* NGSPICE file created from schematic.ext - technology: sky130A

.subckt schematic N_1
X0 N_1 N_2.t1 0.t2 sky130_fd_pr__res_xhigh_po_1p41 l=6.89
X1 N_2.t0 0.t1 0.t0 sky130_fd_pr__res_xhigh_po_1p41 l=6.89
R0 N_2.t0 N_2.t1 45.4805
R1 0.n204 0.n203 1302.81
R2 0.n291 0.n12 1141.44
R3 0.n382 0.n295 1141.44
R4 0.n289 0.n205 1141.44
R5 0.n312 0.n296 1141.44
R6 0.n57 0.n36 1141.44
R7 0.n201 0.n32 1141.44
R8 0.n135 0.n29 1141.44
R9 0.n125 0.n38 1141.44
R10 0.n295 0.n294 585
R11 0.n378 0.n377 585
R12 0.n376 0.n313 585
R13 0.n380 0.n313 585
R14 0.n375 0.n374 585
R15 0.n373 0.n372 585
R16 0.n371 0.n370 585
R17 0.n369 0.n368 585
R18 0.n367 0.n366 585
R19 0.n365 0.n364 585
R20 0.n363 0.n362 585
R21 0.n361 0.n360 585
R22 0.n359 0.n358 585
R23 0.n357 0.n356 585
R24 0.n355 0.n354 585
R25 0.n353 0.n352 585
R26 0.n351 0.n350 585
R27 0.n349 0.n348 585
R28 0.n347 0.n346 585
R29 0.n345 0.n344 585
R30 0.n343 0.n342 585
R31 0.n341 0.n340 585
R32 0.n339 0.n338 585
R33 0.n337 0.n336 585
R34 0.n335 0.n334 585
R35 0.n333 0.n332 585
R36 0.n331 0.n330 585
R37 0.n329 0.n328 585
R38 0.n327 0.n326 585
R39 0.n325 0.n324 585
R40 0.n323 0.n322 585
R41 0.n321 0.n320 585
R42 0.n319 0.n318 585
R43 0.n317 0.n316 585
R44 0.n315 0.n312 585
R45 0.n380 0.n312 585
R46 0.n314 0.n296 585
R47 0.n381 0.n296 585
R48 0.n6 0.n4 585
R49 0.n8 0.n6 585
R50 0 0.n387 585
R51 0.n387 0.t2 585
R52 0.n5 0.n3 585
R53 0.n7 0.n5 585
R54 0.n289 0.n288 585
R55 0.n290 0.n289 585
R56 0.n287 0.n205 585
R57 0.n286 0.n285 585
R58 0.n283 0.n206 585
R59 0.n281 0.n280 585
R60 0.n279 0.n207 585
R61 0.n278 0.n277 585
R62 0.n275 0.n208 585
R63 0.n273 0.n272 585
R64 0.n271 0.n209 585
R65 0.n270 0.n269 585
R66 0.n267 0.n210 585
R67 0.n265 0.n264 585
R68 0.n263 0.n211 585
R69 0.n262 0.n261 585
R70 0.n259 0.n212 585
R71 0.n257 0.n256 585
R72 0.n255 0.n213 585
R73 0.n254 0.n253 585
R74 0.n251 0.n214 585
R75 0.n249 0.n248 585
R76 0.n247 0.n215 585
R77 0.n246 0.n245 585
R78 0.n243 0.n216 585
R79 0.n241 0.n240 585
R80 0.n239 0.n217 585
R81 0.n238 0.n237 585
R82 0.n235 0.n218 585
R83 0.n233 0.n232 585
R84 0.n231 0.n219 585
R85 0.n230 0.n229 585
R86 0.n227 0.n220 585
R87 0.n225 0.n224 585
R88 0.n223 0.n222 585
R89 0.n12 0.n11 585
R90 0.n292 0.n291 585
R91 0.n291 0.n290 585
R92 0.n293 0.n9 585
R93 0.n9 0.n7 585
R94 0.n386 0.n385 585
R95 0.t2 0.n386 585
R96 0.n384 0.n10 585
R97 0.n10 0.n8 585
R98 0.n383 0.n382 585
R99 0.n382 0.n381 585
R100 0.n123 0.n38 585
R101 0.n122 0.n121 585
R102 0.n40 0.n39 585
R103 0.n117 0.n116 585
R104 0.n115 0.n56 585
R105 0.n114 0.n113 585
R106 0.n112 0.n111 585
R107 0.n110 0.n109 585
R108 0.n108 0.n107 585
R109 0.n106 0.n105 585
R110 0.n104 0.n103 585
R111 0.n102 0.n101 585
R112 0.n100 0.n99 585
R113 0.n98 0.n97 585
R114 0.n96 0.n95 585
R115 0.n94 0.n93 585
R116 0.n92 0.n91 585
R117 0.n90 0.n89 585
R118 0.n88 0.n87 585
R119 0.n86 0.n85 585
R120 0.n84 0.n83 585
R121 0.n82 0.n81 585
R122 0.n80 0.n79 585
R123 0.n78 0.n77 585
R124 0.n76 0.n75 585
R125 0.n74 0.n73 585
R126 0.n72 0.n71 585
R127 0.n70 0.n69 585
R128 0.n68 0.n67 585
R129 0.n66 0.n65 585
R130 0.n64 0.n63 585
R131 0.n62 0.n61 585
R132 0.n60 0.n59 585
R133 0.n58 0.n57 585
R134 0.n36 0.n35 585
R135 0.n37 0.n36 585
R136 0.n129 0.n128 585
R137 0.n128 0.n127 585
R138 0.n130 0.n34 585
R139 0.n34 0.t0 585
R140 0.n132 0.n131 585
R141 0.n133 0.n132 585
R142 0.n33 0.n32 585
R143 0.n32 0.n13 585
R144 0.n201 0.n200 585
R145 0.n199 0.n31 585
R146 0.n198 0.n30 585
R147 0.n203 0.n30 585
R148 0.n197 0.n196 585
R149 0.n195 0.n194 585
R150 0.n193 0.n192 585
R151 0.n191 0.n190 585
R152 0.n189 0.n188 585
R153 0.n187 0.n186 585
R154 0.n185 0.n184 585
R155 0.n183 0.n182 585
R156 0.n181 0.n180 585
R157 0.n179 0.n178 585
R158 0.n177 0.n176 585
R159 0.n175 0.n174 585
R160 0.n173 0.n172 585
R161 0.n171 0.n170 585
R162 0.n169 0.n168 585
R163 0.n167 0.n166 585
R164 0.n165 0.n164 585
R165 0.n163 0.n162 585
R166 0.n161 0.n160 585
R167 0.n159 0.n158 585
R168 0.n157 0.n156 585
R169 0.n155 0.n154 585
R170 0.n153 0.n152 585
R171 0.n151 0.n150 585
R172 0.n149 0.n148 585
R173 0.n147 0.n146 585
R174 0.n145 0.n144 585
R175 0.n143 0.n142 585
R176 0.n141 0.n140 585
R177 0.n139 0.n138 585
R178 0.n137 0.n29 585
R179 0.n203 0.n29 585
R180 0.n136 0.n135 585
R181 0.n135 0.n13 585
R182 0.n134 0.n2 585
R183 0.n134 0.n133 585
R184 0 0.n1 585
R185 0.t0 0.n1 585
R186 0.n126 0.n0 585
R187 0.n127 0.n126 585
R188 0.n125 0.n124 585
R189 0.n125 0.n37 585
R190 0.n291 0.n9 394
R191 0.n386 0.n9 394
R192 0.n386 0.n10 394
R193 0.n382 0.n10 394
R194 0.n225 0.n222 394
R195 0.n229 0.n227 394
R196 0.n233 0.n219 394
R197 0.n237 0.n235 394
R198 0.n241 0.n217 394
R199 0.n245 0.n243 394
R200 0.n249 0.n215 394
R201 0.n253 0.n251 394
R202 0.n257 0.n213 394
R203 0.n261 0.n259 394
R204 0.n265 0.n211 394
R205 0.n269 0.n267 394
R206 0.n273 0.n209 394
R207 0.n277 0.n275 394
R208 0.n281 0.n207 394
R209 0.n285 0.n283 394
R210 0.n289 0.n5 394
R211 0.n387 0.n5 394
R212 0.n387 0.n6 394
R213 0.n296 0.n6 394
R214 0.n378 0.n313 394
R215 0.n374 0.n313 394
R216 0.n372 0.n371 394
R217 0.n368 0.n367 394
R218 0.n364 0.n363 394
R219 0.n360 0.n359 394
R220 0.n356 0.n355 394
R221 0.n352 0.n351 394
R222 0.n348 0.n347 394
R223 0.n344 0.n343 394
R224 0.n340 0.n339 394
R225 0.n336 0.n335 394
R226 0.n332 0.n331 394
R227 0.n328 0.n327 394
R228 0.n324 0.n323 394
R229 0.n320 0.n319 394
R230 0.n316 0.n312 394
R231 0.n128 0.n36 394
R232 0.n128 0.n34 394
R233 0.n132 0.n34 394
R234 0.n132 0.n32 394
R235 0.n31 0.n30 394
R236 0.n196 0.n30 394
R237 0.n194 0.n193 394
R238 0.n190 0.n189 394
R239 0.n186 0.n185 394
R240 0.n182 0.n181 394
R241 0.n178 0.n177 394
R242 0.n174 0.n173 394
R243 0.n170 0.n169 394
R244 0.n166 0.n165 394
R245 0.n162 0.n161 394
R246 0.n158 0.n157 394
R247 0.n154 0.n153 394
R248 0.n150 0.n149 394
R249 0.n146 0.n145 394
R250 0.n142 0.n141 394
R251 0.n138 0.n29 394
R252 0.n126 0.n125 394
R253 0.n126 0.n1 394
R254 0.n134 0.n1 394
R255 0.n135 0.n134 394
R256 0.n61 0.n60 394
R257 0.n65 0.n64 394
R258 0.n69 0.n68 394
R259 0.n73 0.n72 394
R260 0.n77 0.n76 394
R261 0.n81 0.n80 394
R262 0.n85 0.n84 394
R263 0.n89 0.n88 394
R264 0.n93 0.n92 394
R265 0.n97 0.n96 394
R266 0.n101 0.n100 394
R267 0.n105 0.n104 394
R268 0.n109 0.n108 394
R269 0.n113 0.n112 394
R270 0.n117 0.n56 394
R271 0.n121 0.n40 394
R272 0.n380 0.n379 218.815
R273 0.n380 0.n297 218.815
R274 0.n380 0.n298 218.815
R275 0.n380 0.n299 218.815
R276 0.n380 0.n300 218.815
R277 0.n380 0.n301 218.815
R278 0.n380 0.n302 218.815
R279 0.n380 0.n303 218.815
R280 0.n380 0.n304 218.815
R281 0.n380 0.n305 218.815
R282 0.n380 0.n306 218.815
R283 0.n380 0.n307 218.815
R284 0.n380 0.n308 218.815
R285 0.n380 0.n309 218.815
R286 0.n380 0.n310 218.815
R287 0.n380 0.n311 218.815
R288 0.n284 0.n204 218.815
R289 0.n282 0.n204 218.815
R290 0.n276 0.n204 218.815
R291 0.n274 0.n204 218.815
R292 0.n268 0.n204 218.815
R293 0.n266 0.n204 218.815
R294 0.n260 0.n204 218.815
R295 0.n258 0.n204 218.815
R296 0.n252 0.n204 218.815
R297 0.n250 0.n204 218.815
R298 0.n244 0.n204 218.815
R299 0.n242 0.n204 218.815
R300 0.n236 0.n204 218.815
R301 0.n234 0.n204 218.815
R302 0.n228 0.n204 218.815
R303 0.n226 0.n204 218.815
R304 0.n221 0.n204 218.815
R305 0.n120 0.n119 218.815
R306 0.n119 0.n118 218.815
R307 0.n119 0.n55 218.815
R308 0.n119 0.n54 218.815
R309 0.n119 0.n53 218.815
R310 0.n119 0.n52 218.815
R311 0.n119 0.n51 218.815
R312 0.n119 0.n50 218.815
R313 0.n119 0.n49 218.815
R314 0.n119 0.n48 218.815
R315 0.n119 0.n47 218.815
R316 0.n119 0.n46 218.815
R317 0.n119 0.n45 218.815
R318 0.n119 0.n44 218.815
R319 0.n119 0.n43 218.815
R320 0.n119 0.n42 218.815
R321 0.n119 0.n41 218.815
R322 0.n203 0.n202 218.815
R323 0.n203 0.n14 218.815
R324 0.n203 0.n15 218.815
R325 0.n203 0.n16 218.815
R326 0.n203 0.n17 218.815
R327 0.n203 0.n18 218.815
R328 0.n203 0.n19 218.815
R329 0.n203 0.n20 218.815
R330 0.n203 0.n21 218.815
R331 0.n203 0.n22 218.815
R332 0.n203 0.n23 218.815
R333 0.n203 0.n24 218.815
R334 0.n203 0.n25 218.815
R335 0.n203 0.n26 218.815
R336 0.n203 0.n27 218.815
R337 0.n203 0.n28 218.815
R338 0.n222 0.n221 147.374
R339 0.n227 0.n226 147.374
R340 0.n228 0.n219 147.374
R341 0.n235 0.n234 147.374
R342 0.n236 0.n217 147.374
R343 0.n243 0.n242 147.374
R344 0.n244 0.n215 147.374
R345 0.n251 0.n250 147.374
R346 0.n252 0.n213 147.374
R347 0.n259 0.n258 147.374
R348 0.n260 0.n211 147.374
R349 0.n267 0.n266 147.374
R350 0.n268 0.n209 147.374
R351 0.n275 0.n274 147.374
R352 0.n276 0.n207 147.374
R353 0.n283 0.n282 147.374
R354 0.n284 0.n205 147.374
R355 0.n379 0.n295 147.374
R356 0.n374 0.n297 147.374
R357 0.n371 0.n298 147.374
R358 0.n367 0.n299 147.374
R359 0.n363 0.n300 147.374
R360 0.n359 0.n301 147.374
R361 0.n355 0.n302 147.374
R362 0.n351 0.n303 147.374
R363 0.n347 0.n304 147.374
R364 0.n343 0.n305 147.374
R365 0.n339 0.n306 147.374
R366 0.n335 0.n307 147.374
R367 0.n331 0.n308 147.374
R368 0.n327 0.n309 147.374
R369 0.n323 0.n310 147.374
R370 0.n319 0.n311 147.374
R371 0.n379 0.n378 147.374
R372 0.n372 0.n297 147.374
R373 0.n368 0.n298 147.374
R374 0.n364 0.n299 147.374
R375 0.n360 0.n300 147.374
R376 0.n356 0.n301 147.374
R377 0.n352 0.n302 147.374
R378 0.n348 0.n303 147.374
R379 0.n344 0.n304 147.374
R380 0.n340 0.n305 147.374
R381 0.n336 0.n306 147.374
R382 0.n332 0.n307 147.374
R383 0.n328 0.n308 147.374
R384 0.n324 0.n309 147.374
R385 0.n320 0.n310 147.374
R386 0.n316 0.n311 147.374
R387 0.n285 0.n284 147.374
R388 0.n282 0.n281 147.374
R389 0.n277 0.n276 147.374
R390 0.n274 0.n273 147.374
R391 0.n269 0.n268 147.374
R392 0.n266 0.n265 147.374
R393 0.n261 0.n260 147.374
R394 0.n258 0.n257 147.374
R395 0.n253 0.n252 147.374
R396 0.n250 0.n249 147.374
R397 0.n245 0.n244 147.374
R398 0.n242 0.n241 147.374
R399 0.n237 0.n236 147.374
R400 0.n234 0.n233 147.374
R401 0.n229 0.n228 147.374
R402 0.n226 0.n225 147.374
R403 0.n221 0.n12 147.374
R404 0.n202 0.n201 147.374
R405 0.n196 0.n14 147.374
R406 0.n193 0.n15 147.374
R407 0.n189 0.n16 147.374
R408 0.n185 0.n17 147.374
R409 0.n181 0.n18 147.374
R410 0.n177 0.n19 147.374
R411 0.n173 0.n20 147.374
R412 0.n169 0.n21 147.374
R413 0.n165 0.n22 147.374
R414 0.n161 0.n23 147.374
R415 0.n157 0.n24 147.374
R416 0.n153 0.n25 147.374
R417 0.n149 0.n26 147.374
R418 0.n145 0.n27 147.374
R419 0.n141 0.n28 147.374
R420 0.n57 0.n41 147.374
R421 0.n61 0.n42 147.374
R422 0.n65 0.n43 147.374
R423 0.n69 0.n44 147.374
R424 0.n73 0.n45 147.374
R425 0.n77 0.n46 147.374
R426 0.n81 0.n47 147.374
R427 0.n85 0.n48 147.374
R428 0.n89 0.n49 147.374
R429 0.n93 0.n50 147.374
R430 0.n97 0.n51 147.374
R431 0.n101 0.n52 147.374
R432 0.n105 0.n53 147.374
R433 0.n109 0.n54 147.374
R434 0.n113 0.n55 147.374
R435 0.n118 0.n117 147.374
R436 0.n121 0.n120 147.374
R437 0.n120 0.n38 147.374
R438 0.n118 0.n40 147.374
R439 0.n56 0.n55 147.374
R440 0.n112 0.n54 147.374
R441 0.n108 0.n53 147.374
R442 0.n104 0.n52 147.374
R443 0.n100 0.n51 147.374
R444 0.n96 0.n50 147.374
R445 0.n92 0.n49 147.374
R446 0.n88 0.n48 147.374
R447 0.n84 0.n47 147.374
R448 0.n80 0.n46 147.374
R449 0.n76 0.n45 147.374
R450 0.n72 0.n44 147.374
R451 0.n68 0.n43 147.374
R452 0.n64 0.n42 147.374
R453 0.n60 0.n41 147.374
R454 0.n202 0.n31 147.374
R455 0.n194 0.n14 147.374
R456 0.n190 0.n15 147.374
R457 0.n186 0.n16 147.374
R458 0.n182 0.n17 147.374
R459 0.n178 0.n18 147.374
R460 0.n174 0.n19 147.374
R461 0.n170 0.n20 147.374
R462 0.n166 0.n21 147.374
R463 0.n162 0.n22 147.374
R464 0.n158 0.n23 147.374
R465 0.n154 0.n24 147.374
R466 0.n150 0.n25 147.374
R467 0.n146 0.n26 147.374
R468 0.n142 0.n27 147.374
R469 0.n138 0.n28 147.374
R470 0.n119 0.n37 141.82
R471 0.n203 0.n13 141.82
R472 0.n290 0.n204 141.82
R473 0.n381 0.n380 141.82
R474 0.n127 0.n37 81.7268
R475 0.n127 0.t0 81.7268
R476 0.n133 0.t0 81.7268
R477 0.n133 0.n13 81.7268
R478 0.n290 0.n7 81.7268
R479 0.t2 0.n7 81.7268
R480 0.t2 0.n8 81.7268
R481 0.n381 0.n8 81.7268
R482 0.n292 0.n11 74.1652
R483 0.n383 0.n294 74.1652
R484 0.n288 0.n287 74.1652
R485 0.n315 0.n314 74.1652
R486 0.n58 0.n35 74.1652
R487 0.n124 0.n123 74.1652
R488 0.n200 0.n33 74.1652
R489 0.n137 0.n136 74.1652
R490 0.n293 0.n292 25.6005
R491 0.n385 0.n293 25.6005
R492 0.n385 0.n384 25.6005
R493 0.n384 0.n383 25.6005
R494 0.n223 0.n11 25.6005
R495 0.n224 0.n223 25.6005
R496 0.n224 0.n220 25.6005
R497 0.n230 0.n220 25.6005
R498 0.n231 0.n230 25.6005
R499 0.n232 0.n231 25.6005
R500 0.n232 0.n218 25.6005
R501 0.n238 0.n218 25.6005
R502 0.n239 0.n238 25.6005
R503 0.n240 0.n239 25.6005
R504 0.n240 0.n216 25.6005
R505 0.n246 0.n216 25.6005
R506 0.n247 0.n246 25.6005
R507 0.n248 0.n247 25.6005
R508 0.n248 0.n214 25.6005
R509 0.n254 0.n214 25.6005
R510 0.n255 0.n254 25.6005
R511 0.n256 0.n255 25.6005
R512 0.n256 0.n212 25.6005
R513 0.n262 0.n212 25.6005
R514 0.n263 0.n262 25.6005
R515 0.n264 0.n263 25.6005
R516 0.n264 0.n210 25.6005
R517 0.n270 0.n210 25.6005
R518 0.n271 0.n270 25.6005
R519 0.n272 0.n271 25.6005
R520 0.n272 0.n208 25.6005
R521 0.n278 0.n208 25.6005
R522 0.n279 0.n278 25.6005
R523 0.n280 0.n279 25.6005
R524 0.n280 0.n206 25.6005
R525 0.n286 0.n206 25.6005
R526 0.n287 0.n286 25.6005
R527 0.n288 0.n3 25.6005
R528 0 0.n3 25.6005
R529 0 0.n4 25.6005
R530 0.n314 0.n4 25.6005
R531 0.n377 0.n294 25.6005
R532 0.n377 0.n376 25.6005
R533 0.n376 0.n375 25.6005
R534 0.n375 0.n373 25.6005
R535 0.n373 0.n370 25.6005
R536 0.n370 0.n369 25.6005
R537 0.n369 0.n366 25.6005
R538 0.n366 0.n365 25.6005
R539 0.n365 0.n362 25.6005
R540 0.n362 0.n361 25.6005
R541 0.n361 0.n358 25.6005
R542 0.n358 0.n357 25.6005
R543 0.n357 0.n354 25.6005
R544 0.n354 0.n353 25.6005
R545 0.n353 0.n350 25.6005
R546 0.n350 0.n349 25.6005
R547 0.n349 0.n346 25.6005
R548 0.n346 0.n345 25.6005
R549 0.n345 0.n342 25.6005
R550 0.n342 0.n341 25.6005
R551 0.n341 0.n338 25.6005
R552 0.n338 0.n337 25.6005
R553 0.n337 0.n334 25.6005
R554 0.n334 0.n333 25.6005
R555 0.n333 0.n330 25.6005
R556 0.n330 0.n329 25.6005
R557 0.n329 0.n326 25.6005
R558 0.n326 0.n325 25.6005
R559 0.n325 0.n322 25.6005
R560 0.n322 0.n321 25.6005
R561 0.n321 0.n318 25.6005
R562 0.n318 0.n317 25.6005
R563 0.n317 0.n315 25.6005
R564 0.n59 0.n58 25.6005
R565 0.n62 0.n59 25.6005
R566 0.n63 0.n62 25.6005
R567 0.n66 0.n63 25.6005
R568 0.n67 0.n66 25.6005
R569 0.n70 0.n67 25.6005
R570 0.n71 0.n70 25.6005
R571 0.n74 0.n71 25.6005
R572 0.n75 0.n74 25.6005
R573 0.n78 0.n75 25.6005
R574 0.n79 0.n78 25.6005
R575 0.n82 0.n79 25.6005
R576 0.n83 0.n82 25.6005
R577 0.n86 0.n83 25.6005
R578 0.n87 0.n86 25.6005
R579 0.n90 0.n87 25.6005
R580 0.n91 0.n90 25.6005
R581 0.n94 0.n91 25.6005
R582 0.n95 0.n94 25.6005
R583 0.n98 0.n95 25.6005
R584 0.n99 0.n98 25.6005
R585 0.n102 0.n99 25.6005
R586 0.n103 0.n102 25.6005
R587 0.n106 0.n103 25.6005
R588 0.n107 0.n106 25.6005
R589 0.n110 0.n107 25.6005
R590 0.n111 0.n110 25.6005
R591 0.n114 0.n111 25.6005
R592 0.n115 0.n114 25.6005
R593 0.n116 0.n115 25.6005
R594 0.n116 0.n39 25.6005
R595 0.n122 0.n39 25.6005
R596 0.n123 0.n122 25.6005
R597 0.n129 0.n35 25.6005
R598 0.n130 0.n129 25.6005
R599 0.n131 0.n130 25.6005
R600 0.n131 0.n33 25.6005
R601 0.n200 0.n199 25.6005
R602 0.n199 0.n198 25.6005
R603 0.n198 0.n197 25.6005
R604 0.n197 0.n195 25.6005
R605 0.n195 0.n192 25.6005
R606 0.n192 0.n191 25.6005
R607 0.n191 0.n188 25.6005
R608 0.n188 0.n187 25.6005
R609 0.n187 0.n184 25.6005
R610 0.n184 0.n183 25.6005
R611 0.n183 0.n180 25.6005
R612 0.n180 0.n179 25.6005
R613 0.n179 0.n176 25.6005
R614 0.n176 0.n175 25.6005
R615 0.n175 0.n172 25.6005
R616 0.n172 0.n171 25.6005
R617 0.n171 0.n168 25.6005
R618 0.n168 0.n167 25.6005
R619 0.n167 0.n164 25.6005
R620 0.n164 0.n163 25.6005
R621 0.n163 0.n160 25.6005
R622 0.n160 0.n159 25.6005
R623 0.n159 0.n156 25.6005
R624 0.n156 0.n155 25.6005
R625 0.n155 0.n152 25.6005
R626 0.n152 0.n151 25.6005
R627 0.n151 0.n148 25.6005
R628 0.n148 0.n147 25.6005
R629 0.n147 0.n144 25.6005
R630 0.n144 0.n143 25.6005
R631 0.n143 0.n140 25.6005
R632 0.n140 0.n139 25.6005
R633 0.n139 0.n137 25.6005
R634 0.n124 0.n0 25.6005
R635 0 0.n0 25.6005
R636 0 0.n2 25.6005
R637 0.n136 0.n2 25.6005
R638 0.n388 0 24.0111
R639 0 0.n388 23.3876
R640 0.n388 0.t1 15.1002
C0 N_1 0 2.34066f
.ends

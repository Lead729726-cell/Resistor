.subckt schematic N_1
XR1_P0 N_1 N_2 0 sky130_fd_pr__res_xhigh_po_1p41 l=6.885
XR2_P0 N_2 0 0 sky130_fd_pr__res_xhigh_po_1p41 l=6.885
.ends schematic

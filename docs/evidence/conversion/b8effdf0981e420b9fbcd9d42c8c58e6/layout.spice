* NGSPICE file created from schematic.ext - technology: sky130A

.subckt schematic N_1
X0 N_1 N_2 0 sky130_fd_pr__res_xhigh_po_1p41 l=6.89
X1 N_2 0 0 sky130_fd_pr__res_xhigh_po_1p41 l=6.89
.ends

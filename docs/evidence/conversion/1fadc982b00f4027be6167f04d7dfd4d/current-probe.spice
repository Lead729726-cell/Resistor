.subckt schematic
RR1 register_cf_node_eaac70311f533dbd N_2 10000
Vregister_cf_eaac70311f533dbd N_1 register_cf_node_eaac70311f533dbd 0
RR2 register_cf_node_08c2727c53dd9cbc 0 10000
Vregister_cf_08c2727c53dd9cbc N_2 register_cf_node_08c2727c53dd9cbc 0
VV1 register_cf_node_f4715a27313a7f7f 0 1.8
Vregister_cf_f4715a27313a7f7f N_1 register_cf_node_f4715a27313a7f7f 0
.ends schematic

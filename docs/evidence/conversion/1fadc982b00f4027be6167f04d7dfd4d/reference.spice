.subckt schematic
RR1 N_1 N_2 10000
RR2 N_2 0 10000
VV1 N_1 0 1.8
.ends schematic

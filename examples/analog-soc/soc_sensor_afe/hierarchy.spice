.subckt SOC_OTA_FIRST INP INN BIAS OUT VPWR VGND
XN_INN0 MIR INN TAIL VGND sky130_fd_pr__nfet_01v8 w=5 l=1 nf=1 m=1
XN_INN1 MIR INN TAIL VGND sky130_fd_pr__nfet_01v8 w=5 l=1 nf=1 m=1
XN_INP0 OUT INP TAIL VGND sky130_fd_pr__nfet_01v8 w=5 l=1 nf=1 m=1
XN_INP1 OUT INP TAIL VGND sky130_fd_pr__nfet_01v8 w=5 l=1 nf=1 m=1
XN_TAIL TAIL BIAS VGND VGND sky130_fd_pr__nfet_01v8 w=2 l=1 nf=1 m=1
XP_DIODE MIR MIR VPWR VPWR sky130_fd_pr__pfet_01v8_hvt w=20 l=1 nf=1 m=1
XP_MIRROR OUT MIR VPWR VPWR sky130_fd_pr__pfet_01v8_hvt w=20 l=1 nf=1 m=1
.ends SOC_OTA_FIRST
.subckt SOC_OTA INP INN BIAS OUT VPWR VGND
CC_MILLER PRE COMP 5e-12
XFIRST INP INN BIAS PRE VPWR VGND SOC_OTA_FIRST
XN_SECOND OUT BIAS VGND VGND sky130_fd_pr__nfet_01v8 w=2 l=1 nf=1 m=1
XP_SECOND OUT PRE VPWR VPWR sky130_fd_pr__pfet_01v8_hvt w=40 l=1 nf=1 m=1
RR_ZERO COMP OUT 5000
.ends SOC_OTA
.subckt SOC_BIAS BIAS VCM VPWR VGND
CC_VCM VCM_RAW VGND 2e-11
XN_DIODE BIAS BIAS VGND VGND sky130_fd_pr__nfet_01v8 w=2 l=1 nf=1 m=1
RR_BIAS VPWR BIAS 30000
RR_VCM_BOTTOM VCM_RAW VGND 100000
RR_VCM_TOP VPWR VCM_RAW 100000
XVCM_BUFFER VCM_RAW VCM BIAS VCM VPWR VGND SOC_OTA
.ends SOC_BIAS
.subckt SOC_GAIN2 VIN VCM BIAS OUT VPWR VGND
XAMP VIN FB BIAS OUT VPWR VGND SOC_OTA
RR_FEEDBACK OUT FB 10000
RR_GROUND FB VCM 10000
.ends SOC_GAIN2
.subckt SOC_GAIN8 VIN VCM BIAS OUT VPWR VGND
XAMP VIN FB BIAS OUT VPWR VGND SOC_OTA
RR_FEEDBACK OUT FB 70000
RR_GROUND FB VCM 10000
.ends SOC_GAIN8
.subckt INV A Y VPWR VGND
XMN Y A VGND VGND sky130_fd_pr__nfet_01v8 w=0.65 l=0.15 nf=1 m=1
XMP Y A VPWR VPWR sky130_fd_pr__pfet_01v8_hvt w=0.65 l=0.15 nf=1 m=1
.ends INV
.subckt SOC_PGA VIN GAIN VCM BIAS OUT VPWR VGND
XGAIN2 VIN VCM BIAS V2 VPWR VGND SOC_GAIN2
XGAIN8 VIN VCM BIAS V8 VPWR VGND SOC_GAIN8
XGAIN_INVERTER GAIN GAINB VPWR VGND INV
XN_HIGH V8 GAIN SELECTED VGND sky130_fd_pr__nfet_01v8 w=20 l=0.15 nf=1 m=1
XN_LOW V2 GAINB SELECTED VGND sky130_fd_pr__nfet_01v8 w=20 l=0.15 nf=1 m=1
XOUTPUT_BUFFER SELECTED OUT BIAS OUT VPWR VGND SOC_OTA
XP_HIGH V8 GAINB SELECTED VPWR sky130_fd_pr__pfet_01v8_hvt w=20 l=0.15 nf=1 m=1
XP_LOW V2 GAIN SELECTED VPWR sky130_fd_pr__pfet_01v8_hvt w=20 l=0.15 nf=1 m=1
.ends SOC_PGA
.subckt SOC_FILTER2 VIN BIAS OUT VPWR VGND
XBUFFER0 FILTER0 MID BIAS MID VPWR VGND SOC_OTA
XBUFFER1 FILTER1 OUT BIAS OUT VPWR VGND SOC_OTA
CC_POLE0 FILTER0 VGND 2e-11
CC_POLE1 FILTER1 VGND 2e-11
RR_POLE0 VIN FILTER0 40000
RR_POLE1 MID FILTER1 40000
.ends SOC_FILTER2
.subckt PREAMP INP INN BIAS OUT VPWR VGND
XN_INN MIR INN TAIL VGND sky130_fd_pr__nfet_01v8 w=10 l=1 nf=1 m=1
XN_INP OUT INP TAIL VGND sky130_fd_pr__nfet_01v8 w=10 l=1 nf=1 m=1
XN_TAIL TAIL BIAS VGND VGND sky130_fd_pr__nfet_01v8 w=2 l=1 nf=1 m=1
XP_DIODE MIR MIR VPWR VPWR sky130_fd_pr__pfet_01v8_hvt w=20 l=1 nf=1 m=1
XP_MIRROR OUT MIR VPWR VPWR sky130_fd_pr__pfet_01v8_hvt w=20 l=1 nf=1 m=1
.ends PREAMP
.subckt SOC_COMPARATOR INP INN BIAS OUT VPWR VGND
XN_OUT OUT PRE VGND VGND sky130_fd_pr__nfet_01v8 w=4 l=0.15 nf=1 m=1
XPREAMP INP INN BIAS PRE VPWR VGND PREAMP
XP_OUT OUT PRE VPWR VPWR sky130_fd_pr__pfet_01v8_hvt w=8 l=0.15 nf=1 m=1
.ends SOC_COMPARATOR
.subckt MUX2 A B S Y VPWR VGND
XIS S SB VPWR VGND INV
XMNA Y SB A VGND sky130_fd_pr__nfet_01v8 w=0.65 l=0.15 nf=1 m=1
XMNB Y S B VGND sky130_fd_pr__nfet_01v8 w=0.65 l=0.15 nf=1 m=1
XMPA Y S A VPWR sky130_fd_pr__pfet_01v8_hvt w=0.65 l=0.15 nf=1 m=1
XMPB Y SB B VPWR sky130_fd_pr__pfet_01v8_hvt w=0.65 l=0.15 nf=1 m=1
.ends MUX2
.subckt DFF D CLK Q VPWR VGND
XICLK CLK CLKB VPWR VGND INV
XM1 M MB VPWR VGND INV
XM2 MB MF VPWR VGND INV
XMNIN M CLKB D VGND sky130_fd_pr__nfet_01v8 w=0.65 l=0.15 nf=1 m=1
XMNMF M CLK MF VGND sky130_fd_pr__nfet_01v8 w=0.65 l=0.15 nf=1 m=1
XMNOUT T CLK MF VGND sky130_fd_pr__nfet_01v8 w=0.65 l=0.15 nf=1 m=1
XMNSF T CLKB Q VGND sky130_fd_pr__nfet_01v8 w=0.65 l=0.15 nf=1 m=1
XMPIN M CLK D VPWR sky130_fd_pr__pfet_01v8_hvt w=0.65 l=0.15 nf=1 m=1
XMPMF M CLKB MF VPWR sky130_fd_pr__pfet_01v8_hvt w=0.65 l=0.15 nf=1 m=1
XMPOUT T CLKB MF VPWR sky130_fd_pr__pfet_01v8_hvt w=0.65 l=0.15 nf=1 m=1
XMPSF T CLK Q VPWR sky130_fd_pr__pfet_01v8_hvt w=0.65 l=0.15 nf=1 m=1
XS1 T TB VPWR VGND INV
XS2 TB Q VPWR VGND INV
.ends DFF
.subckt soc_sensor_afe VIN GAIN CLK RESET OUT DATA VCM BIAS VPWR VGND
XBIAS_SOURCE BIAS VCM VPWR VGND SOC_BIAS
XCOMPARATOR OUT VCM BIAS CMP VPWR VGND SOC_COMPARATOR
XFILTER AMPLIFIED BIAS OUT VPWR VGND SOC_FILTER2
XPGA VIN GAIN VCM BIAS AMPLIFIED VPWR VGND SOC_PGA
XRESET_MUX CMP VGND RESET D VPWR VGND MUX2
XSAMPLE D CLK DATA VPWR VGND DFF
.ends soc_sensor_afe

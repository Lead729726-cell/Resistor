* NGSPICE file created from soc_sensor_afe.ext - technology: sky130A

.subckt soc_sensor_afe VPWR DATA CLK BIAS RESET VCM VGND GAIN OUT VIN
X0 AMPLIFIED.t1 FILTER__FILTER0.t0 VGND.t110 sky130_fd_pr__res_xhigh_po_1p41 l=28.04
X1 VPWR FILTER__BUFFER0__FIRST__MIR.t0 FILTER__BUFFER0__FIRST__MIR.t1 VPWR sky130_fd_pr__pfet_01v8_hvt ad=5.8 pd=40.58 as=5.8 ps=40.58 w=20 l=1
X2 PGA__OUTPUT_BUFFER__COMP.t2 AMPLIFIED.t2 VGND.t111 sky130_fd_pr__res_xhigh_po_1p41 l=3.36
X3 FILTER__FILTER1.t1 VGND.t11 sky130_fd_pr__cap_mim_m3_1 l=28.68 w=28.68
X4 VGND.t65 COMPARATOR__PRE.t2 CMP.t3 VGND.t64 sky130_fd_pr__nfet_01v8 ad=1.16 pd=8.58 as=1.16 ps=8.58 w=4 l=0.15
X5 FILTER__BUFFER1__FIRST__TAIL.t3 FILTER__FILTER1.t2 FILTER__BUFFER1__PRE.t1 VGND.t128 sky130_fd_pr__nfet_01v8 ad=1.45 pd=10.58 as=1.45 ps=10.58 w=5 l=1
X6 FILTER__FILTER1.t3 VGND.t10 sky130_fd_pr__cap_mim_m3_1 l=28.68 w=28.68
X7 FILTER__BUFFER1__COMP.t0 OUT.t1 VGND.t101 sky130_fd_pr__res_xhigh_po_1p41 l=3.36
X8 PGA__OUTPUT_BUFFER__PRE.t3 PGA__OUTPUT_BUFFER__COMP.t3 sky130_fd_pr__cap_mim_m3_1 l=28.68 w=28.68
X9 VPWR SAMPLE__MB.t2 SAMPLE__MF.t2 VPWR sky130_fd_pr__pfet_01v8_hvt ad=0.1885 pd=1.88 as=0.1885 ps=1.88 w=0.65 l=0.15
X10 VPWR COMPARATOR__PRE.t3 CMP.t2 VPWR sky130_fd_pr__pfet_01v8_hvt ad=2.32 pd=16.58 as=2.32 ps=16.58 w=8 l=0.15
X11 VGND.t131 BIAS.t3 PGA__GAIN8__AMP__FIRST__TAIL.t0 VGND.t130 sky130_fd_pr__nfet_01v8 ad=0.58 pd=4.58 as=0.58 ps=4.58 w=2 l=1
X12 FILTER__BUFFER0__PRE.t3 FILTER__BUFFER0__COMP.t2 sky130_fd_pr__cap_mim_m3_1 l=28.68 w=28.68
X13 FILTER__BUFFER1__FIRST__TAIL.t2 FILTER__FILTER1.t4 FILTER__BUFFER1__PRE.t2 VGND.t97 sky130_fd_pr__nfet_01v8 ad=1.45 pd=10.58 as=1.45 ps=10.58 w=5 l=1
X14 VPWR PGA__OUTPUT_BUFFER__FIRST__MIR.t0 PGA__OUTPUT_BUFFER__FIRST__MIR.t1 VPWR sky130_fd_pr__pfet_01v8_hvt ad=5.8 pd=40.58 as=5.8 ps=40.58 w=20 l=1
X15 BIAS_SOURCE__VCM_RAW.t2 VGND.t102 sky130_fd_pr__cap_mim_m3_1 l=28.68 w=28.68
X16 PGA__GAIN8__AMP__PRE.t3 PGA__GAIN8__AMP__COMP.t2 sky130_fd_pr__cap_mim_m3_1 l=28.68 w=28.68
X17 FILTER__FILTER1.t5 VGND.t90 sky130_fd_pr__cap_mim_m3_1 l=28.68 w=28.68
X18 PGA__GAIN2__FB.t0 VCM.t1 VGND.t19 sky130_fd_pr__res_xhigh_po_1p41 l=6.89
X19 FILTER__FILTER1.t6 VGND.t66 sky130_fd_pr__cap_mim_m3_1 l=28.68 w=28.68
X20 FILTER__FILTER0.t1 VGND.t38 sky130_fd_pr__cap_mim_m3_1 l=28.68 w=28.68
X21 BIAS_SOURCE__VCM_RAW.t0 BIAS_SOURCE_R_VCM_BOTTOM_R0_N0.t1 VGND.t50 sky130_fd_pr__res_xhigh_po_1p41 l=23.34
X22 PGA__SELECTED.t2 GAIN.t0 PGA__V2.t5 VPWR sky130_fd_pr__pfet_01v8_hvt ad=5.8 pd=40.58 as=5.8 ps=40.58 w=20 l=0.15
X23 VPWR GAIN.t1 PGA__GAINB.t0 VPWR sky130_fd_pr__pfet_01v8_hvt ad=0.1885 pd=1.88 as=0.1885 ps=1.88 w=0.65 l=0.15
X24 VGND.t45 BIAS.t4 PGA__OUTPUT_BUFFER__FIRST__TAIL.t0 VGND.t44 sky130_fd_pr__nfet_01v8 ad=0.58 pd=4.58 as=0.58 ps=4.58 w=2 l=1
X25 PGA__SELECTED.t0 PGA__GAINB.t2 PGA__V8.t2 VPWR sky130_fd_pr__pfet_01v8_hvt ad=5.8 pd=40.58 as=5.8 ps=40.58 w=20 l=0.15
X26 FILTER__FILTER0.t2 VGND.t37 sky130_fd_pr__cap_mim_m3_1 l=28.68 w=28.68
X27 BIAS_SOURCE__VCM_RAW.t3 VGND.t103 sky130_fd_pr__cap_mim_m3_1 l=28.68 w=28.68
X28 VGND.t74 RESET.t0 D.t2 VGND.t73 sky130_fd_pr__nfet_01v8 ad=0.1885 pd=1.88 as=0.1885 ps=1.88 w=0.65 l=0.15
X29 VPWR FILTER__BUFFER1__PRE.t3 OUT.t2 VPWR sky130_fd_pr__pfet_01v8_hvt ad=11.6 pd=80.58 as=11.6 ps=80.58 w=40 l=1
X30 PGA__GAIN2__AMP__FIRST__TAIL.t4 VIN.t0 PGA__GAIN2__AMP__PRE.t0 VGND.t122 sky130_fd_pr__nfet_01v8 ad=1.45 pd=10.58 as=1.45 ps=10.58 w=5 l=1
X31 VPWR PGA__GAIN2__AMP__FIRST__MIR.t0 PGA__GAIN2__AMP__FIRST__MIR.t1 VPWR sky130_fd_pr__pfet_01v8_hvt ad=5.8 pd=40.58 as=5.8 ps=40.58 w=20 l=1
X32 BIAS_SOURCE__VCM_RAW.t4 VGND.t115 sky130_fd_pr__cap_mim_m3_1 l=28.68 w=28.68
X33 DATA.t1 CLK.t0 SAMPLE__T.t0 VPWR sky130_fd_pr__pfet_01v8_hvt ad=0.1885 pd=1.88 as=0.1885 ps=1.88 w=0.65 l=0.15
X34 PGA__SELECTED.t1 PGA__GAINB.t3 PGA__V2.t3 VGND.t85 sky130_fd_pr__nfet_01v8 ad=5.8 pd=40.58 as=5.8 ps=40.58 w=20 l=0.15
X35 BIAS_SOURCE_R_VCM_BOTTOM_R0_N0.t0 BIAS_SOURCE_R_VCM_BOTTOM_R0_N1.t0 VGND.t15 sky130_fd_pr__res_xhigh_po_1p41 l=23.34
X36 VPWR BIAS_SOURCE__VCM_BUFFER__FIRST__MIR.t4 BIAS_SOURCE__VCM_BUFFER__PRE.t2 VPWR sky130_fd_pr__pfet_01v8_hvt ad=5.8 pd=40.58 as=5.8 ps=40.58 w=20 l=1
X37 BIAS_SOURCE__VCM_RAW.t5 VGND.t116 sky130_fd_pr__cap_mim_m3_1 l=28.68 w=28.68
X38 SAMPLE__MF.t4 SAMPLE__CLKB.t2 SAMPLE__M.t2 VPWR sky130_fd_pr__pfet_01v8_hvt ad=0.1885 pd=1.88 as=0.1885 ps=1.88 w=0.65 l=0.15
X39 PGA__OUTPUT_BUFFER__FIRST__TAIL.t4 AMPLIFIED.t4 PGA__OUTPUT_BUFFER__FIRST__MIR.t2 VGND.t21 sky130_fd_pr__nfet_01v8 ad=1.45 pd=10.58 as=1.45 ps=10.58 w=5 l=1
X40 VPWR FILTER__BUFFER0__PRE.t4 FILTER__MID.t1 VPWR sky130_fd_pr__pfet_01v8_hvt ad=11.6 pd=80.58 as=11.6 ps=80.58 w=40 l=1
X41 PGA__SELECTED.t3 GAIN.t2 PGA__V8.t5 VGND.t104 sky130_fd_pr__nfet_01v8 ad=5.8 pd=40.58 as=5.8 ps=40.58 w=20 l=0.15
X42 FILTER__FILTER0.t3 VGND.t36 sky130_fd_pr__cap_mim_m3_1 l=28.68 w=28.68
X43 VPWR FILTER__BUFFER1__FIRST__MIR.t4 FILTER__BUFFER1__PRE.t0 VPWR sky130_fd_pr__pfet_01v8_hvt ad=5.8 pd=40.58 as=5.8 ps=40.58 w=20 l=1
X44 VPWR BIAS_SOURCE__VCM_BUFFER__FIRST__MIR.t2 BIAS_SOURCE__VCM_BUFFER__FIRST__MIR.t3 VPWR sky130_fd_pr__pfet_01v8_hvt ad=5.8 pd=40.58 as=5.8 ps=40.58 w=20 l=1
X45 PGA__GAIN2__AMP__PRE.t3 PGA__GAIN2__AMP__COMP.t3 sky130_fd_pr__cap_mim_m3_1 l=28.68 w=28.68
X46 D.t1 CLK.t1 SAMPLE__M.t1 VPWR sky130_fd_pr__pfet_01v8_hvt ad=0.1885 pd=1.88 as=0.1885 ps=1.88 w=0.65 l=0.15
X47 BIAS_SOURCE__VCM_BUFFER__FIRST__TAIL.t4 BIAS_SOURCE__VCM_RAW.t6 BIAS_SOURCE__VCM_BUFFER__PRE.t0 VGND.t113 sky130_fd_pr__nfet_01v8 ad=1.45 pd=10.58 as=1.45 ps=10.58 w=5 l=1
X48 FILTER__BUFFER0__FIRST__TAIL.t2 FILTER__FILTER0.t4 FILTER__BUFFER0__PRE.t2 VGND.t35 sky130_fd_pr__nfet_01v8 ad=1.45 pd=10.58 as=1.45 ps=10.58 w=5 l=1
X49 FILTER__FILTER1.t7 VGND.t78 sky130_fd_pr__cap_mim_m3_1 l=28.68 w=28.68
X50 VPWR RESET.t1 RESET_MUX__SB.t0 VPWR sky130_fd_pr__pfet_01v8_hvt ad=0.1885 pd=1.88 as=0.1885 ps=1.88 w=0.65 l=0.15
X51 VGND.t72 BIAS.t5 COMPARATOR__PREAMP__TAIL.t0 VGND.t71 sky130_fd_pr__nfet_01v8 ad=0.58 pd=4.58 as=0.58 ps=4.58 w=2 l=1
X52 PGA__GAIN8__AMP__PRE.t4 PGA__GAIN8__AMP__COMP.t1 sky130_fd_pr__cap_mim_m3_1 l=28.68 w=28.68
X53 SAMPLE__MF.t5 SAMPLE__CLKB.t3 SAMPLE__T.t3 VPWR sky130_fd_pr__pfet_01v8_hvt ad=0.1885 pd=1.88 as=0.1885 ps=1.88 w=0.65 l=0.15
X54 PGA__OUTPUT_BUFFER__FIRST__TAIL.t3 AMPLIFIED.t5 PGA__OUTPUT_BUFFER__FIRST__MIR.t3 VGND.t20 sky130_fd_pr__nfet_01v8 ad=1.45 pd=10.58 as=1.45 ps=10.58 w=5 l=1
X55 FILTER__FILTER0.t5 VGND.t34 sky130_fd_pr__cap_mim_m3_1 l=28.68 w=28.68
X56 PGA__GAIN2__AMP__FIRST__TAIL.t3 VIN.t1 PGA__GAIN2__AMP__PRE.t1 VGND.t112 sky130_fd_pr__nfet_01v8 ad=1.45 pd=10.58 as=1.45 ps=10.58 w=5 l=1
X57 VGND.t23 BIAS.t6 AMPLIFIED.t0 VGND.t22 sky130_fd_pr__nfet_01v8 ad=0.58 pd=4.58 as=0.58 ps=4.58 w=2 l=1
X58 FILTER__FILTER1.t8 VGND.t24 sky130_fd_pr__cap_mim_m3_1 l=28.68 w=28.68
X59 VPWR SAMPLE__TB.t2 DATA.t2 VPWR sky130_fd_pr__pfet_01v8_hvt ad=0.1885 pd=1.88 as=0.1885 ps=1.88 w=0.65 l=0.15
X60 VPWR SAMPLE__M.t4 SAMPLE__MB.t0 VPWR sky130_fd_pr__pfet_01v8_hvt ad=0.1885 pd=1.88 as=0.1885 ps=1.88 w=0.65 l=0.15
X61 BIAS_SOURCE_R_VCM_BOTTOM_R0_N1.t1 VGND.t109 VGND.t108 sky130_fd_pr__res_xhigh_po_1p41 l=23.34
X62 FILTER__FILTER1.t9 VGND.t92 sky130_fd_pr__cap_mim_m3_1 l=28.68 w=28.68
X63 BIAS_SOURCE__VCM_BUFFER__FIRST__TAIL.t2 VCM.t5 BIAS_SOURCE__VCM_BUFFER__FIRST__MIR.t0 VGND.t5 sky130_fd_pr__nfet_01v8 ad=1.45 pd=10.58 as=1.45 ps=10.58 w=5 l=1
X64 VPWR SAMPLE__T.t4 SAMPLE__TB.t0 VPWR sky130_fd_pr__pfet_01v8_hvt ad=0.1885 pd=1.88 as=0.1885 ps=1.88 w=0.65 l=0.15
X65 PGA__GAIN8__AMP__FIRST__TAIL.t4 VIN.t2 PGA__GAIN8__AMP__PRE.t2 VGND.t133 sky130_fd_pr__nfet_01v8 ad=1.45 pd=10.58 as=1.45 ps=10.58 w=5 l=1
X66 FILTER__BUFFER0__FIRST__TAIL.t1 FILTER__FILTER0.t6 FILTER__BUFFER0__PRE.t1 VGND.t33 sky130_fd_pr__nfet_01v8 ad=1.45 pd=10.58 as=1.45 ps=10.58 w=5 l=1
X67 VGND.t99 BIAS.t7 BIAS_SOURCE__VCM_BUFFER__FIRST__TAIL.t0 VGND.t98 sky130_fd_pr__nfet_01v8 ad=0.58 pd=4.58 as=0.58 ps=4.58 w=2 l=1
X68 BIAS_SOURCE__VCM_RAW.t7 VGND.t114 sky130_fd_pr__cap_mim_m3_1 l=28.68 w=28.68
X69 VPWR COMPARATOR__PREAMP__MIR.t1 COMPARATOR__PREAMP__MIR.t2 VPWR sky130_fd_pr__pfet_01v8_hvt ad=5.8 pd=40.58 as=5.8 ps=40.58 w=20 l=1
X70 VPWR FILTER__BUFFER1__FIRST__MIR.t2 FILTER__BUFFER1__FIRST__MIR.t3 VPWR sky130_fd_pr__pfet_01v8_hvt ad=5.8 pd=40.58 as=5.8 ps=40.58 w=20 l=1
X71 FILTER__FILTER0.t7 VGND.t32 sky130_fd_pr__cap_mim_m3_1 l=28.68 w=28.68
X72 COMPARATOR__PREAMP__TAIL.t2 OUT.t3 COMPARATOR__PRE.t1 VGND.t124 sky130_fd_pr__nfet_01v8 ad=2.9 pd=20.58 as=2.9 ps=20.58 w=10 l=1
X73 FILTER__FILTER1.t10 VGND.t56 sky130_fd_pr__cap_mim_m3_1 l=28.68 w=28.68
X74 PGA__GAIN2__AMP__PRE.t4 PGA__GAIN2__AMP__COMP.t2 sky130_fd_pr__cap_mim_m3_1 l=28.68 w=28.68
X75 CMP.t1 RESET_MUX__SB.t2 D.t4 VGND.t79 sky130_fd_pr__nfet_01v8 ad=0.1885 pd=1.88 as=0.1885 ps=1.88 w=0.65 l=0.15
X76 PGA__OUTPUT_BUFFER__FIRST__TAIL.t2 PGA__SELECTED.t4 PGA__OUTPUT_BUFFER__PRE.t2 VGND.t88 sky130_fd_pr__nfet_01v8 ad=1.45 pd=10.58 as=1.45 ps=10.58 w=5 l=1
X77 VGND.t2 BIAS.t8 VCM.t0 VGND.t1 sky130_fd_pr__nfet_01v8 ad=0.58 pd=4.58 as=0.58 ps=4.58 w=2 l=1
X78 PGA__GAIN8__AMP__FIRST__TAIL.t2 PGA__GAIN8__FB.t2 PGA__GAIN8__AMP__FIRST__MIR.t3 VGND.t121 sky130_fd_pr__nfet_01v8 ad=1.45 pd=10.58 as=1.45 ps=10.58 w=5 l=1
X79 VGND.t84 RESET_MUX__SB.t3 D.t5 VPWR sky130_fd_pr__pfet_01v8_hvt ad=0.1885 pd=1.88 as=0.1885 ps=1.88 w=0.65 l=0.15
X80 VPWR COMPARATOR__PREAMP__MIR.t3 COMPARATOR__PRE.t0 VPWR sky130_fd_pr__pfet_01v8_hvt ad=5.8 pd=40.58 as=5.8 ps=40.58 w=20 l=1
X81 FILTER__BUFFER1__PRE.t4 FILTER__BUFFER1__COMP.t3 sky130_fd_pr__cap_mim_m3_1 l=28.68 w=28.68
X82 BIAS_SOURCE_R_VCM_TOP_R0_N1.t0 BIAS_SOURCE__VCM_RAW.t1 VGND.t96 sky130_fd_pr__res_xhigh_po_1p41 l=23.34
X83 FILTER__FILTER1.t11 VGND.t9 sky130_fd_pr__cap_mim_m3_1 l=28.68 w=28.68
X84 BIAS_SOURCE__VCM_BUFFER__PRE.t3 BIAS_SOURCE__VCM_BUFFER__COMP.t3 sky130_fd_pr__cap_mim_m3_1 l=28.68 w=28.68
X85 PGA__GAIN8__AMP__FIRST__TAIL.t1 VIN.t3 PGA__GAIN8__AMP__PRE.t0 VGND.t54 sky130_fd_pr__nfet_01v8 ad=1.45 pd=10.58 as=1.45 ps=10.58 w=5 l=1
X86 BIAS_SOURCE__VCM_BUFFER__COMP.t0 VCM.t2 VGND.t95 sky130_fd_pr__res_xhigh_po_1p41 l=3.36
X87 FILTER__FILTER0.t8 VGND.t31 sky130_fd_pr__cap_mim_m3_1 l=28.68 w=28.68
X88 CMP.t0 RESET.t2 D.t3 VPWR sky130_fd_pr__pfet_01v8_hvt ad=0.1885 pd=1.88 as=0.1885 ps=1.88 w=0.65 l=0.15
X89 BIAS_SOURCE__VCM_RAW.t8 VGND.t51 sky130_fd_pr__cap_mim_m3_1 l=28.68 w=28.68
X90 FILTER__FILTER1.t12 VGND.t132 sky130_fd_pr__cap_mim_m3_1 l=28.68 w=28.68
X91 VGND.t7 CLK.t2 SAMPLE__CLKB.t1 VGND.t6 sky130_fd_pr__nfet_01v8 ad=0.1885 pd=1.88 as=0.1885 ps=1.88 w=0.65 l=0.15
X92 PGA__OUTPUT_BUFFER__FIRST__TAIL.t1 PGA__SELECTED.t5 PGA__OUTPUT_BUFFER__PRE.t1 VGND.t67 sky130_fd_pr__nfet_01v8 ad=1.45 pd=10.58 as=1.45 ps=10.58 w=5 l=1
X93 BIAS_SOURCE__VCM_BUFFER__FIRST__TAIL.t1 VCM.t6 BIAS_SOURCE__VCM_BUFFER__FIRST__MIR.t1 VGND.t63 sky130_fd_pr__nfet_01v8 ad=1.45 pd=10.58 as=1.45 ps=10.58 w=5 l=1
X94 PGA__GAIN2__AMP__FIRST__TAIL.t1 PGA__GAIN2__FB.t2 PGA__GAIN2__AMP__FIRST__MIR.t3 VGND.t87 sky130_fd_pr__nfet_01v8 ad=1.45 pd=10.58 as=1.45 ps=10.58 w=5 l=1
X95 PGA__V2.t4 PGA__GAIN2__FB.t1 VGND.t94 sky130_fd_pr__res_xhigh_po_1p41 l=6.89
X96 FILTER__FILTER0.t9 VGND.t30 sky130_fd_pr__cap_mim_m3_1 l=28.68 w=28.68
X97 VGND.t118 BIAS.t9 FILTER__BUFFER1__FIRST__TAIL.t4 VGND.t117 sky130_fd_pr__nfet_01v8 ad=0.58 pd=4.58 as=0.58 ps=4.58 w=2 l=1
X98 FILTER__FILTER1.t13 VGND.t52 sky130_fd_pr__cap_mim_m3_1 l=28.68 w=28.68
X99 PGA__GAIN8__AMP__COMP.t3 PGA__V8.t4 VGND.t93 sky130_fd_pr__res_xhigh_po_1p41 l=3.36
X100 PGA__OUTPUT_BUFFER__PRE.t4 PGA__OUTPUT_BUFFER__COMP.t1 sky130_fd_pr__cap_mim_m3_1 l=28.68 w=28.68
X101 PGA__GAIN2__AMP__COMP.t0 PGA__V2.t1 VGND.t16 sky130_fd_pr__res_xhigh_po_1p41 l=3.36
X102 FILTER__BUFFER0__PRE.t5 FILTER__BUFFER0__COMP.t1 sky130_fd_pr__cap_mim_m3_1 l=28.68 w=28.68
X103 BIAS_SOURCE__VCM_RAW.t9 VGND.t100 sky130_fd_pr__cap_mim_m3_1 l=28.68 w=28.68
X104 FILTER__FILTER0.t10 VGND.t29 sky130_fd_pr__cap_mim_m3_1 l=28.68 w=28.68
X105 FILTER__BUFFER1__FIRST__TAIL.t1 OUT.t4 FILTER__BUFFER1__FIRST__MIR.t1 VGND.t80 sky130_fd_pr__nfet_01v8 ad=1.45 pd=10.58 as=1.45 ps=10.58 w=5 l=1
X106 FILTER__BUFFER1__PRE.t5 FILTER__BUFFER1__COMP.t2 sky130_fd_pr__cap_mim_m3_1 l=28.68 w=28.68
X107 VPWR BIAS_SOURCE_R_VCM_TOP_R0_N0.t0 VGND.t18 sky130_fd_pr__res_xhigh_po_1p41 l=23.34
X108 VGND.t60 BIAS.t10 PGA__V2.t0 VGND.t59 sky130_fd_pr__nfet_01v8 ad=0.58 pd=4.58 as=0.58 ps=4.58 w=2 l=1
X109 VGND.t13 SAMPLE__TB.t3 DATA.t0 VGND.t12 sky130_fd_pr__nfet_01v8 ad=0.1885 pd=1.88 as=0.1885 ps=1.88 w=0.65 l=0.15
X110 BIAS_SOURCE__VCM_BUFFER__FIRST__TAIL.t3 BIAS_SOURCE__VCM_RAW.t10 BIAS_SOURCE__VCM_BUFFER__PRE.t1 VGND.t77 sky130_fd_pr__nfet_01v8 ad=1.45 pd=10.58 as=1.45 ps=10.58 w=5 l=1
X111 BIAS_SOURCE__VCM_BUFFER__PRE.t4 BIAS_SOURCE__VCM_BUFFER__COMP.t2 sky130_fd_pr__cap_mim_m3_1 l=28.68 w=28.68
X112 PGA__GAIN8__FB.t1 VCM.t3 VGND.t106 sky130_fd_pr__res_xhigh_po_1p41 l=6.89
X113 FILTER__BUFFER1__FIRST__TAIL.t0 OUT.t5 FILTER__BUFFER1__FIRST__MIR.t0 VGND.t53 sky130_fd_pr__nfet_01v8 ad=1.45 pd=10.58 as=1.45 ps=10.58 w=5 l=1
X114 VGND.t126 GAIN.t3 PGA__GAINB.t1 VGND.t125 sky130_fd_pr__nfet_01v8 ad=0.1885 pd=1.88 as=0.1885 ps=1.88 w=0.65 l=0.15
X115 COMPARATOR__PREAMP__TAIL.t1 VCM.t7 COMPARATOR__PREAMP__MIR.t0 VGND.t49 sky130_fd_pr__nfet_01v8 ad=2.9 pd=20.58 as=2.9 ps=20.58 w=10 l=1
X116 BIAS_SOURCE_R_VCM_TOP_R0_N0.t1 BIAS_SOURCE_R_VCM_TOP_R0_N1.t1 VGND.t107 sky130_fd_pr__res_xhigh_po_1p41 l=23.34
X117 VGND.t62 BIAS.t11 PGA__GAIN2__AMP__FIRST__TAIL.t0 VGND.t61 sky130_fd_pr__nfet_01v8 ad=0.58 pd=4.58 as=0.58 ps=4.58 w=2 l=1
X118 BIAS_SOURCE__VCM_RAW.t11 VGND.t8 sky130_fd_pr__cap_mim_m3_1 l=28.68 w=28.68
X119 VGND.t48 BIAS.t12 OUT.t0 VGND.t47 sky130_fd_pr__nfet_01v8 ad=0.58 pd=4.58 as=0.58 ps=4.58 w=2 l=1
X120 PGA__GAIN8__AMP__FIRST__TAIL.t3 PGA__GAIN8__FB.t3 PGA__GAIN8__AMP__FIRST__MIR.t2 VGND.t127 sky130_fd_pr__nfet_01v8 ad=1.45 pd=10.58 as=1.45 ps=10.58 w=5 l=1
X121 FILTER__FILTER0.t11 VGND.t28 sky130_fd_pr__cap_mim_m3_1 l=28.68 w=28.68
X122 BIAS_SOURCE__VCM_RAW.t12 VGND.t134 sky130_fd_pr__cap_mim_m3_1 l=28.68 w=28.68
X123 VPWR BIAS.t2 VGND.t55 sky130_fd_pr__res_xhigh_po_1p41 l=20.99
X124 FILTER__BUFFER0__COMP.t3 FILTER__MID.t3 VGND.t17 sky130_fd_pr__res_xhigh_po_1p41 l=3.36
X125 FILTER__FILTER0.t12 VGND.t27 sky130_fd_pr__cap_mim_m3_1 l=28.68 w=28.68
X126 PGA__GAIN2__AMP__PRE.t5 PGA__GAIN2__AMP__COMP.t1 sky130_fd_pr__cap_mim_m3_1 l=28.68 w=28.68
X127 SAMPLE__MF.t0 CLK.t3 SAMPLE__T.t1 VGND.t0 sky130_fd_pr__nfet_01v8 ad=0.1885 pd=1.88 as=0.1885 ps=1.88 w=0.65 l=0.15
X128 VGND.t76 BIAS.t0 BIAS.t1 VGND.t75 sky130_fd_pr__nfet_01v8 ad=0.58 pd=4.58 as=0.58 ps=4.58 w=2 l=1
X129 VPWR PGA__OUTPUT_BUFFER__PRE.t5 AMPLIFIED.t3 VPWR sky130_fd_pr__pfet_01v8_hvt ad=11.6 pd=80.58 as=11.6 ps=80.58 w=40 l=1
X130 VPWR FILTER__BUFFER0__FIRST__MIR.t4 FILTER__BUFFER0__PRE.t0 VPWR sky130_fd_pr__pfet_01v8_hvt ad=5.8 pd=40.58 as=5.8 ps=40.58 w=20 l=1
X131 SAMPLE__MF.t1 CLK.t4 SAMPLE__M.t0 VGND.t3 sky130_fd_pr__nfet_01v8 ad=0.1885 pd=1.88 as=0.1885 ps=1.88 w=0.65 l=0.15
X132 FILTER__BUFFER0__PRE.t6 FILTER__BUFFER0__COMP.t0 sky130_fd_pr__cap_mim_m3_1 l=28.68 w=28.68
X133 FILTER__FILTER0.t13 VGND.t26 sky130_fd_pr__cap_mim_m3_1 l=28.68 w=28.68
X134 PGA__V8.t3 PGA_GAIN8_R_FEEDBACK_R0_N0.t0 VGND.t68 sky130_fd_pr__res_xhigh_po_1p41 l=24.51
X135 PGA__OUTPUT_BUFFER__PRE.t6 PGA__OUTPUT_BUFFER__COMP.t0 sky130_fd_pr__cap_mim_m3_1 l=28.68 w=28.68
X136 PGA__GAIN8__AMP__PRE.t5 PGA__GAIN8__AMP__COMP.t0 sky130_fd_pr__cap_mim_m3_1 l=28.68 w=28.68
X137 BIAS_SOURCE__VCM_RAW.t13 VGND.t86 sky130_fd_pr__cap_mim_m3_1 l=28.68 w=28.68
X138 FILTER__BUFFER1__PRE.t6 FILTER__BUFFER1__COMP.t1 sky130_fd_pr__cap_mim_m3_1 l=28.68 w=28.68
X139 DATA.t3 SAMPLE__CLKB.t4 SAMPLE__T.t2 VGND.t83 sky130_fd_pr__nfet_01v8 ad=0.1885 pd=1.88 as=0.1885 ps=1.88 w=0.65 l=0.15
X140 VPWR PGA__GAIN8__AMP__FIRST__MIR.t4 PGA__GAIN8__AMP__PRE.t1 VPWR sky130_fd_pr__pfet_01v8_hvt ad=5.8 pd=40.58 as=5.8 ps=40.58 w=20 l=1
X141 D.t0 SAMPLE__CLKB.t5 SAMPLE__M.t3 VGND.t4 sky130_fd_pr__nfet_01v8 ad=0.1885 pd=1.88 as=0.1885 ps=1.88 w=0.65 l=0.15
X142 VGND.t70 RESET.t3 RESET_MUX__SB.t1 VGND.t69 sky130_fd_pr__nfet_01v8 ad=0.1885 pd=1.88 as=0.1885 ps=1.88 w=0.65 l=0.15
X143 VPWR PGA__GAIN2__AMP__FIRST__MIR.t4 PGA__GAIN2__AMP__PRE.t2 VPWR sky130_fd_pr__pfet_01v8_hvt ad=5.8 pd=40.58 as=5.8 ps=40.58 w=20 l=1
X144 VPWR PGA__OUTPUT_BUFFER__FIRST__MIR.t4 PGA__OUTPUT_BUFFER__PRE.t0 VPWR sky130_fd_pr__pfet_01v8_hvt ad=5.8 pd=40.58 as=5.8 ps=40.58 w=20 l=1
X145 FILTER__BUFFER0__FIRST__TAIL.t4 FILTER__MID.t4 FILTER__BUFFER0__FIRST__MIR.t3 VGND.t123 sky130_fd_pr__nfet_01v8 ad=1.45 pd=10.58 as=1.45 ps=10.58 w=5 l=1
X146 FILTER__FILTER0.t14 VGND.t25 sky130_fd_pr__cap_mim_m3_1 l=28.68 w=28.68
X147 PGA__GAIN2__AMP__FIRST__TAIL.t2 PGA__GAIN2__FB.t3 PGA__GAIN2__AMP__FIRST__MIR.t2 VGND.t41 sky130_fd_pr__nfet_01v8 ad=1.45 pd=10.58 as=1.45 ps=10.58 w=5 l=1
X148 VPWR PGA__GAIN8__AMP__FIRST__MIR.t0 PGA__GAIN8__AMP__FIRST__MIR.t1 VPWR sky130_fd_pr__pfet_01v8_hvt ad=5.8 pd=40.58 as=5.8 ps=40.58 w=20 l=1
X149 FILTER__FILTER1.t14 VGND.t89 sky130_fd_pr__cap_mim_m3_1 l=28.68 w=28.68
X150 BIAS_SOURCE__VCM_BUFFER__PRE.t5 BIAS_SOURCE__VCM_BUFFER__COMP.t1 sky130_fd_pr__cap_mim_m3_1 l=28.68 w=28.68
X151 VGND.t136 BIAS.t13 FILTER__BUFFER0__FIRST__TAIL.t0 VGND.t135 sky130_fd_pr__nfet_01v8 ad=0.58 pd=4.58 as=0.58 ps=4.58 w=2 l=1
X152 VGND.t58 SAMPLE__MB.t3 SAMPLE__MF.t3 VGND.t57 sky130_fd_pr__nfet_01v8 ad=0.1885 pd=1.88 as=0.1885 ps=1.88 w=0.65 l=0.15
X153 VPWR PGA__GAIN8__AMP__PRE.t6 PGA__V8.t1 VPWR sky130_fd_pr__pfet_01v8_hvt ad=11.6 pd=80.58 as=11.6 ps=80.58 w=40 l=1
X154 VPWR PGA__GAIN2__AMP__PRE.t6 PGA__V2.t2 VPWR sky130_fd_pr__pfet_01v8_hvt ad=11.6 pd=80.58 as=11.6 ps=80.58 w=40 l=1
X155 PGA_GAIN8_R_FEEDBACK_R0_N0.t1 PGA__GAIN8__FB.t0 VGND.t105 sky130_fd_pr__res_xhigh_po_1p41 l=24.51
X156 VPWR CLK.t5 SAMPLE__CLKB.t0 VPWR sky130_fd_pr__pfet_01v8_hvt ad=0.1885 pd=1.88 as=0.1885 ps=1.88 w=0.65 l=0.15
X157 FILTER__BUFFER0__FIRST__TAIL.t3 FILTER__MID.t5 FILTER__BUFFER0__FIRST__MIR.t2 VGND.t91 sky130_fd_pr__nfet_01v8 ad=1.45 pd=10.58 as=1.45 ps=10.58 w=5 l=1
X158 VGND.t82 SAMPLE__M.t5 SAMPLE__MB.t1 VGND.t81 sky130_fd_pr__nfet_01v8 ad=0.1885 pd=1.88 as=0.1885 ps=1.88 w=0.65 l=0.15
X159 FILTER__MID.t2 FILTER__FILTER1.t0 VGND.t14 sky130_fd_pr__res_xhigh_po_1p41 l=28.04
X160 VGND.t40 SAMPLE__T.t5 SAMPLE__TB.t1 VGND.t39 sky130_fd_pr__nfet_01v8 ad=0.1885 pd=1.88 as=0.1885 ps=1.88 w=0.65 l=0.15
X161 VGND.t43 BIAS.t14 PGA__V8.t0 VGND.t42 sky130_fd_pr__nfet_01v8 ad=0.58 pd=4.58 as=0.58 ps=4.58 w=2 l=1
X162 VPWR BIAS_SOURCE__VCM_BUFFER__PRE.t6 VCM.t4 VPWR sky130_fd_pr__pfet_01v8_hvt ad=11.6 pd=80.58 as=11.6 ps=80.58 w=40 l=1
X163 VGND.t120 BIAS.t15 FILTER__MID.t0 VGND.t119 sky130_fd_pr__nfet_01v8 ad=0.58 pd=4.58 as=0.58 ps=4.58 w=2 l=1
X164 BIAS_SOURCE__VCM_RAW.t14 VGND.t46 sky130_fd_pr__cap_mim_m3_1 l=28.68 w=28.68
X165 BIAS_SOURCE__VCM_RAW.t15 VGND.t129 sky130_fd_pr__cap_mim_m3_1 l=28.68 w=28.68
C0 COMPARATOR__PREAMP__MIR VPWR 9.60926f
C1 PGA__GAIN2__AMP__FIRST__MIR GAIN 0.34705f
C2 PGA__OUTPUT_BUFFER__FIRST__TAIL RESET 0
C3 PGA__GAIN8__AMP__FIRST__MIR VCM 0.34705f
C4 PGA__V2 PGA__GAIN8__AMP__PRE 9.71949f
C5 PGA__V8 VPWR 11.1496f
C6 SAMPLE__MB SAMPLE__TB 0.30782f
C7 PGA__GAIN8__FB PGA__V8 0.33233f
C8 SAMPLE__MF VPWR 4.66523f
C9 FILTER__BUFFER1__FIRST__TAIL VPWR 0.38392f
C10 PGA__GAIN8__AMP__PRE DATA 10.2597f
C11 VCM GAIN 0.4889f
C12 BIAS OUT 1.40512f
C13 SAMPLE__TB DATA 0.53803f
C14 VPWR RESET 7.15709f
C15 SAMPLE__CLKB SAMPLE__T 1.18208f
C16 PGA__OUTPUT_BUFFER__FIRST__MIR RESET 0.34711f
C17 PGA__GAIN8__FB RESET 0.27744f
C18 FILTER__BUFFER1__FIRST__MIR FILTER__BUFFER1__FIRST__TAIL 3.80949f
C19 PGA__GAIN2__FB GAIN 0.27731f
C20 SAMPLE__CLKB CLK 0.75324f
C21 D DATA 0
C22 FILTER__BUFFER1__FIRST__MIR RESET 0.34773f
C23 PGA__SELECTED BIAS 0.40325f
C24 PGA__GAINB VCM 0.26705f
C25 BIAS_SOURCE__VCM_BUFFER__PRE VCM 2.24338f
C26 PGA__GAIN8__AMP__FIRST__TAIL PGA__V8 0
C27 FILTER__FILTER1 BIAS 0.00406f
C28 BIAS_SOURCE__VCM_RAW VPWR 0.00759f
C29 PGA__GAIN8__AMP__FIRST__TAIL RESET 0.33656f
C30 PGA__GAIN2__AMP__FIRST__TAIL GAIN 0.33656f
C31 COMPARATOR__PRE OUT 0.71083f
C32 PGA__OUTPUT_BUFFER__PRE AMPLIFIED 1.91965f
C33 FILTER__BUFFER0__PRE RESET 0.00137f
C34 AMPLIFIED CLK 0.42693f
C35 PGA__OUTPUT_BUFFER__PRE PGA__OUTPUT_BUFFER__FIRST__TAIL 3.80101f
C36 COMPARATOR__PREAMP__MIR BIAS 0.49202f
C37 PGA__GAIN2__AMP__FIRST__MIR OUT 0.34705f
C38 PGA__OUTPUT_BUFFER__FIRST__TAIL CLK 0
C39 PGA__GAIN8__AMP__FIRST__MIR VIN 0.65494f
C40 PGA__GAIN2__AMP__PRE VPWR 8.55588f
C41 PGA__OUTPUT_BUFFER__PRE VPWR 7.73096f
C42 PGA__V8 BIAS 0.40806f
C43 PGA__OUTPUT_BUFFER__PRE PGA__OUTPUT_BUFFER__FIRST__MIR 1.20555f
C44 SAMPLE__T VPWR 6.4005f
C45 FILTER__BUFFER1__FIRST__TAIL BIAS 0.41051f
C46 VCM OUT 0.15841p
C47 VPWR CLK 8.30348f
C48 VIN GAIN 55.9197f
C49 BIAS RESET 0.15989p
C50 PGA__OUTPUT_BUFFER__FIRST__MIR CLK 0.34711f
C51 PGA__GAIN8__FB CLK 0.27744f
C52 PGA__GAIN2__FB OUT 0.27731f
C53 BIAS_SOURCE__VCM_BUFFER__FIRST__TAIL VPWR 0.38418f
C54 SAMPLE__CLKB DATA 2.32579f
C55 FILTER__BUFFER1__FIRST__MIR CLK 0.34773f
C56 COMPARATOR__PREAMP__MIR COMPARATOR__PRE 1.12737f
C57 FILTER__FILTER0 OUT 13.3471f
C58 PGA__SELECTED VCM 0.40325f
C59 BIAS_SOURCE__VCM_BUFFER__PRE VIN 0.63773f
C60 FILTER__FILTER1 VCM 0.00745f
C61 BIAS_SOURCE__VCM_RAW BIAS 1.42796f
C62 COMPARATOR__PREAMP__TAIL VPWR 0.38716f
C63 PGA__GAIN8__AMP__FIRST__TAIL CLK 0.33656f
C64 PGA__GAIN2__AMP__FIRST__TAIL OUT 0.33656f
C65 BIAS_SOURCE__VCM_BUFFER__FIRST__MIR VPWR 11.1799f
C66 COMPARATOR__PRE RESET 0.04266f
C67 FILTER__BUFFER0__PRE CLK 0
C68 AMPLIFIED DATA 4.85151f
C69 FILTER__MID OUT 0.43528f
C70 COMPARATOR__PREAMP__MIR VCM 0.89221f
C71 PGA__GAIN2__AMP__FIRST__MIR RESET 0.34705f
C72 PGA__OUTPUT_BUFFER__FIRST__TAIL DATA 0
C73 FILTER__MID FILTER__FILTER1 0.0591f
C74 PGA__GAIN8__AMP__FIRST__MIR GAIN 0.3737f
C75 PGA__GAIN2__AMP__PRE BIAS 0.58255f
C76 FILTER__BUFFER0__FIRST__TAIL OUT 0.33656f
C77 PGA__OUTPUT_BUFFER__PRE BIAS 0.1845f
C78 PGA__V8 VCM 0.17739f
C79 PGA__V2 VPWR 12.4362f
C80 SAMPLE__MB VPWR 4.29409f
C81 FILTER__BUFFER1__FIRST__TAIL VCM 0.35013f
C82 FILTER__BUFFER0__FIRST__MIR VPWR 10.8721f
C83 PGA__V2 PGA__GAIN8__FB 1.93568f
C84 BIAS CLK 0.00706f
C85 VPWR DATA 8.3127f
C86 VCM RESET 0.00353f
C87 VIN OUT 0.00176f
C88 PGA__OUTPUT_BUFFER__FIRST__MIR DATA 2.54728f
C89 PGA__GAIN8__FB DATA 0.28849f
C90 PGA__GAIN2__FB RESET 0.27731f
C91 BIAS_SOURCE__VCM_BUFFER__FIRST__TAIL BIAS 0.39692f
C92 FILTER__BUFFER1__FIRST__MIR DATA 0.34773f
C93 D SAMPLE__CLKB 2.82835f
C94 FILTER__FILTER0 RESET 0.00255f
C95 PGA__GAINB GAIN 0.57836f
C96 BIAS_SOURCE__VCM_BUFFER__PRE GAIN 0.56684f
C97 CMP RESET 2.94566f
C98 PGA__V2 PGA__GAIN8__AMP__FIRST__TAIL 3.14785f
C99 BIAS_SOURCE__VCM_RAW VCM 1.43804f
C100 COMPARATOR__PREAMP__TAIL BIAS 0.15314f
C101 PGA__GAIN8__AMP__FIRST__TAIL DATA 0.33656f
C102 PGA__GAIN2__AMP__FIRST__TAIL RESET 0.33656f
C103 BIAS_SOURCE__VCM_BUFFER__FIRST__MIR BIAS 0.34676f
C104 COMPARATOR__PRE CLK 0
C105 FILTER__BUFFER0__PRE FILTER__BUFFER0__FIRST__MIR 1.2019f
C106 FILTER__BUFFER0__PRE DATA 0
C107 PGA__GAIN2__AMP__PRE PGA__GAIN2__AMP__FIRST__MIR 1.2704f
C108 FILTER__BUFFER1__PRE OUT 11.6405f
C109 FILTER__MID RESET 0.41778f
C110 COMPARATOR__PRE COMPARATOR__PREAMP__TAIL 2.61897f
C111 PGA__GAIN2__AMP__FIRST__MIR CLK 0.34705f
C112 PGA__GAIN8__AMP__FIRST__MIR OUT 0.34705f
C113 FILTER__BUFFER1__PRE FILTER__FILTER1 2.21868f
C114 PGA__GAIN2__AMP__PRE VCM 0.83065f
C115 FILTER__BUFFER0__FIRST__TAIL RESET 0.33656f
C116 PGA__GAIN2__AMP__PRE PGA__GAIN2__FB 0.64792f
C117 PGA__OUTPUT_BUFFER__PRE VCM 0.00287f
C118 PGA__GAIN8__AMP__PRE VPWR 8.56169f
C119 PGA__V2 BIAS 0.80278f
C120 SAMPLE__TB VPWR 4.31328f
C121 PGA__GAIN8__AMP__PRE PGA__GAIN8__FB 0.49673f
C122 FILTER__BUFFER0__FIRST__MIR BIAS 0.34743f
C123 GAIN OUT 69.0707f
C124 BIAS DATA 0.0031f
C125 VCM CLK 0.00155f
C126 VIN RESET 0
C127 D VPWR 4.4298f
C128 PGA__GAIN2__FB CLK 0.27731f
C129 BIAS_SOURCE__VCM_BUFFER__FIRST__TAIL VCM 3.39612f
C130 FILTER__FILTER0 CLK 0.00175f
C131 PGA__SELECTED GAIN 3.33209f
C132 PGA__GAIN2__AMP__PRE PGA__GAIN2__AMP__FIRST__TAIL 3.76993f
C133 PGA__GAINB OUT 0.27594f
C134 BIAS_SOURCE__VCM_BUFFER__PRE OUT 0.5666f
C135 CMP CLK 0
C136 RESET_MUX__SB RESET 0.6658f
C137 PGA__GAIN8__AMP__PRE PGA__GAIN8__AMP__FIRST__TAIL 0.95347f
C138 BIAS_SOURCE__VCM_RAW VIN 1.55494f
C139 PGA__GAINB PGA__SELECTED 5.46047f
C140 COMPARATOR__PREAMP__TAIL VCM 1.61331f
C141 PGA__GAIN2__AMP__FIRST__TAIL CLK 0.33656f
C142 BIAS_SOURCE__VCM_BUFFER__FIRST__MIR VCM 0.9869f
C143 COMPARATOR__PREAMP__TAIL CMP 0.00507f
C144 FILTER__BUFFER1__PRE FILTER__BUFFER1__FIRST__TAIL 0.96148f
C145 FILTER__BUFFER1__PRE RESET 0.00137f
C146 FILTER__MID CLK 0.41778f
C147 PGA__GAIN2__AMP__FIRST__MIR DATA 0.34705f
C148 PGA__GAIN8__AMP__FIRST__MIR RESET 0.34705f
C149 PGA__GAIN2__AMP__PRE VIN 0.98855f
C150 FILTER__BUFFER0__FIRST__TAIL CLK 0.33656f
C151 PGA__V8 GAIN 12.2625f
C152 PGA__GAIN8__AMP__PRE BIAS 0.58266f
C153 PGA__V2 VCM 0.62911f
C154 FILTER__BUFFER0__FIRST__MIR VCM 0.3474f
C155 PGA__GAIN2__FB PGA__V2 2.50572f
C156 VIN CLK 0
C157 GAIN RESET 0
C158 VCM DATA 0
C159 SAMPLE__CLKB VPWR 2.51028f
C160 PGA__V8 PGA__GAINB 0.38336f
C161 FILTER__FILTER0 FILTER__BUFFER0__FIRST__MIR 0.65494f
C162 PGA__GAIN2__FB DATA 0.28835f
C163 BIAS_SOURCE__VCM_BUFFER__FIRST__TAIL VIN 0.36763f
C164 FILTER__FILTER0 DATA 0
C165 PGA__SELECTED OUT 0.41213f
C166 PGA__GAINB RESET 0.26705f
C167 BIAS_SOURCE__VCM_BUFFER__PRE RESET 0.56692f
C168 RESET_MUX__SB CLK 0.00564f
C169 CMP DATA 0
C170 FILTER__FILTER1 OUT 13.5123f
C171 PGA__GAIN2__AMP__FIRST__TAIL PGA__V2 0.00479f
C172 BIAS_SOURCE__VCM_RAW GAIN 1.42739f
C173 PGA__GAIN2__AMP__FIRST__TAIL DATA 0.33656f
C174 PGA__OUTPUT_BUFFER__FIRST__TAIL AMPLIFIED 2.96677f
C175 BIAS_SOURCE__VCM_BUFFER__FIRST__MIR VIN 0.39083f
C176 BIAS_SOURCE__VCM_BUFFER__PRE BIAS_SOURCE__VCM_RAW 2.20124f
C177 AMPLIFIED VPWR 8.3533f
C178 PGA__OUTPUT_BUFFER__FIRST__MIR AMPLIFIED 2.85354f
C179 FILTER__BUFFER0__FIRST__MIR FILTER__MID 2.86735f
C180 FILTER__BUFFER1__PRE CLK 0
C181 FILTER__MID DATA 3.28961f
C182 COMPARATOR__PREAMP__MIR OUT 0.25537f
C183 PGA__OUTPUT_BUFFER__FIRST__TAIL VPWR 0.38413f
C184 PGA__OUTPUT_BUFFER__FIRST__MIR PGA__OUTPUT_BUFFER__FIRST__TAIL 1.25978f
C185 PGA__GAIN8__AMP__FIRST__MIR CLK 0.34705f
C186 FILTER__BUFFER0__FIRST__MIR FILTER__BUFFER0__FIRST__TAIL 3.74236f
C187 PGA__GAIN2__AMP__PRE GAIN 0.56641f
C188 SAMPLE__M SAMPLE__MF 3.93527f
C189 FILTER__BUFFER0__FIRST__TAIL DATA 3.14785f
C190 PGA__V8 OUT 0.12744f
C191 PGA__V2 VIN 0.31719f
C192 PGA__GAIN8__AMP__PRE VCM 0.56645f
C193 FILTER__BUFFER1__FIRST__TAIL OUT 3.28774f
C194 PGA__OUTPUT_BUFFER__FIRST__MIR VPWR 10.6975f
C195 PGA__GAIN2__FB PGA__GAIN8__AMP__PRE 0.31406f
C196 PGA__GAIN8__FB VPWR 0.48726f
C197 PGA__V8 PGA__SELECTED 7.13314f
C198 PGA__OUTPUT_BUFFER__PRE PGA__GAINB 0.15926f
C199 OUT RESET 0.00116f
C200 GAIN CLK 0
C201 FILTER__BUFFER1__FIRST__MIR VPWR 10.9038f
C202 BIAS_SOURCE__VCM_BUFFER__FIRST__TAIL GAIN 0.32321f
C203 PGA__SELECTED RESET 0.40325f
C204 PGA__GAINB CLK 0.26705f
C205 FILTER__FILTER1 FILTER__BUFFER1__FIRST__TAIL 2.99627f
C206 BIAS_SOURCE__VCM_BUFFER__PRE CLK 0.56705f
C207 FILTER__FILTER1 RESET 0.00255f
C208 CMP D 1.02333f
C209 PGA__GAIN8__AMP__FIRST__TAIL VPWR 0.38418f
C210 BIAS_SOURCE__VCM_BUFFER__PRE BIAS_SOURCE__VCM_BUFFER__FIRST__TAIL 3.85559f
C211 BIAS_SOURCE__VCM_RAW OUT 1.42761f
C212 PGA__GAIN8__AMP__FIRST__TAIL PGA__GAIN8__FB 4.2023f
C213 BIAS_SOURCE__VCM_BUFFER__FIRST__MIR GAIN 0.3464f
C214 BIAS_SOURCE__VCM_BUFFER__PRE BIAS_SOURCE__VCM_BUFFER__FIRST__MIR 1.30077f
C215 FILTER__BUFFER0__PRE VPWR 7.82342f
C216 AMPLIFIED BIAS 0.81017f
C217 FILTER__BUFFER1__PRE DATA 0
C218 COMPARATOR__PREAMP__MIR RESET 0
C219 PGA__V2 PGA__GAIN8__AMP__FIRST__MIR 0.3474f
C220 PGA__OUTPUT_BUFFER__FIRST__TAIL BIAS 0.06171f
C221 PGA__GAIN8__AMP__FIRST__MIR DATA 0.34705f
C222 PGA__GAIN2__AMP__PRE OUT 0.56621f
C223 SAMPLE__M SAMPLE__T 0.28874f
C224 PGA__OUTPUT_BUFFER__PRE OUT 1.71954f
C225 PGA__V8 RESET 0
C226 PGA__V2 GAIN 0.89485f
C227 PGA__GAIN8__AMP__PRE VIN 0.5088f
C228 SAMPLE__M CLK 1.35336f
C229 VPWR BIAS 3.69244f
C230 FILTER__BUFFER1__FIRST__TAIL RESET 0.35013f
C231 PGA__OUTPUT_BUFFER__FIRST__MIR BIAS 0.34714f
C232 PGA__GAIN8__FB BIAS 0.27744f
C233 OUT CLK 0
C234 GAIN DATA 0
C235 PGA__OUTPUT_BUFFER__PRE PGA__SELECTED 0.64639f
C236 PGA__V2 PGA__GAINB 1.9419f
C237 FILTER__BUFFER1__FIRST__MIR BIAS 0.34776f
C238 BIAS_SOURCE__VCM_BUFFER__FIRST__TAIL OUT 0.32321f
C239 PGA__SELECTED CLK 0.40325f
C240 PGA__GAINB DATA 2.66557f
C241 BIAS_SOURCE__VCM_BUFFER__PRE DATA 2.84869f
C242 FILTER__FILTER1 CLK 0.00175f
C243 RESET_MUX__SB D 1.13125f
C244 PGA__GAIN8__AMP__FIRST__TAIL BIAS 0.39693f
C245 BIAS_SOURCE__VCM_RAW RESET 1.42848f
C246 COMPARATOR__PREAMP__TAIL OUT 1.60041f
C247 BIAS_SOURCE__VCM_BUFFER__FIRST__MIR OUT 0.3464f
C248 COMPARATOR__PRE VPWR 7.18748f
C249 AMPLIFIED VCM 0.42664f
C250 FILTER__BUFFER0__PRE BIAS 0.17458f
C251 AMPLIFIED FILTER__FILTER0 0.0591f
C252 PGA__GAIN2__AMP__FIRST__MIR VPWR 10.983f
C253 COMPARATOR__PREAMP__MIR CLK 0
C254 PGA__GAIN8__AMP__PRE PGA__GAIN8__AMP__FIRST__MIR 1.26991f
C255 PGA__OUTPUT_BUFFER__FIRST__TAIL VCM 0.00221f
C256 PGA__V8 PGA__OUTPUT_BUFFER__PRE 0.00507f
C257 PGA__GAIN2__AMP__PRE RESET 0.56615f
C258 SAMPLE__M SAMPLE__MB 1.16568f
C259 SAMPLE__MF SAMPLE__T 3.6895f
C260 PGA__V8 CLK 0
C261 PGA__OUTPUT_BUFFER__PRE RESET 0
C262 PGA__V2 OUT 0.41897f
C263 PGA__GAIN8__AMP__PRE GAIN 0.57565f
C264 SAMPLE__MF CLK 5.32593f
C265 SAMPLE__M DATA 0.13738f
C266 VPWR VCM 10.2395f
C267 FILTER__BUFFER1__FIRST__TAIL CLK 0.35013f
C268 COMPARATOR__PREAMP__MIR COMPARATOR__PREAMP__TAIL 2.47381f
C269 FILTER__BUFFER0__FIRST__MIR OUT 0.3474f
C270 PGA__OUTPUT_BUFFER__FIRST__MIR VCM 0.34711f
C271 PGA__GAIN8__FB VCM 0.34878f
C272 PGA__GAIN2__FB VPWR 0.46676f
C273 RESET CLK 0.1629p
C274 OUT DATA 0
C275 PGA__V2 PGA__SELECTED 7.09093f
C276 FILTER__BUFFER1__FIRST__MIR VCM 0.34773f
C277 FILTER__FILTER0 VPWR 0.00594f
C278 BIAS_SOURCE__VCM_BUFFER__FIRST__TAIL RESET 0.33654f
C279 CMP VPWR 5.17449f
C280 PGA__SELECTED DATA 0.65123f
C281 FILTER__FILTER1 DATA 0
C282 RESET_MUX__SB SAMPLE__CLKB 0.30306f
C283 PGA__GAIN8__AMP__FIRST__TAIL VCM 0.33656f
C284 PGA__GAIN2__AMP__FIRST__TAIL VPWR 0.38401f
C285 BIAS_SOURCE__VCM_RAW CLK 1.43005f
C286 COMPARATOR__PREAMP__TAIL RESET 0
C287 PGA__GAIN2__FB PGA__GAIN8__AMP__FIRST__TAIL 0
C288 BIAS_SOURCE__VCM_RAW BIAS_SOURCE__VCM_BUFFER__FIRST__TAIL 3.94956f
C289 BIAS_SOURCE__VCM_BUFFER__FIRST__MIR RESET 0.34673f
C290 COMPARATOR__PRE BIAS 0.13883f
C291 FILTER__BUFFER0__PRE VCM 0.00622f
C292 BIAS_SOURCE__VCM_RAW BIAS_SOURCE__VCM_BUFFER__FIRST__MIR 0.85726f
C293 FILTER__MID VPWR 8.40516f
C294 FILTER__BUFFER0__PRE FILTER__FILTER0 2.21868f
C295 PGA__GAIN2__AMP__FIRST__MIR BIAS 0.34708f
C296 COMPARATOR__PREAMP__MIR DATA 0
C297 PGA__V2 PGA__V8 0.15686f
C298 FILTER__BUFFER0__FIRST__TAIL VPWR 0.38392f
C299 PGA__GAIN2__AMP__PRE CLK 0.56654f
C300 SAMPLE__MF SAMPLE__MB 0.86206f
C301 PGA__OUTPUT_BUFFER__PRE CLK 0
C302 PGA__V2 RESET 0.41947f
C303 PGA__GAIN8__AMP__PRE OUT 0.56656f
C304 SAMPLE__T CLK 1.05725f
C305 VPWR VIN 1.07243f
C306 SAMPLE__MF DATA 0.12855f
C307 BIAS VCM 0.15982p
C308 FILTER__BUFFER1__FIRST__TAIL DATA 3.16142f
C309 FILTER__BUFFER0__FIRST__MIR RESET 0.3474f
C310 D SAMPLE__M 1.01193f
C311 PGA__GAIN8__FB VIN 0.16514f
C312 PGA__GAIN2__FB BIAS 0.27731f
C313 RESET DATA 0.00176f
C314 FILTER__FILTER0 BIAS 0.00406f
C315 BIAS_SOURCE__VCM_BUFFER__FIRST__TAIL CLK 0.33654f
C316 RESET_MUX__SB VPWR 2.04482f
C317 CMP BIAS 0.3092f
C318 FILTER__BUFFER0__PRE FILTER__MID 1.91739f
C319 PGA__GAIN8__AMP__FIRST__TAIL VIN 2.99627f
C320 PGA__GAIN2__AMP__FIRST__TAIL BIAS 0.39693f
C321 BIAS_SOURCE__VCM_RAW DATA 31.2851f
C322 COMPARATOR__PREAMP__TAIL CLK 0
C323 BIAS_SOURCE__VCM_BUFFER__FIRST__MIR CLK 0.34673f
C324 COMPARATOR__PRE VCM 0.0777f
C325 BIAS_SOURCE__VCM_BUFFER__FIRST__MIR BIAS_SOURCE__VCM_BUFFER__FIRST__TAIL 3.71499f
C326 FILTER__BUFFER0__PRE FILTER__BUFFER0__FIRST__TAIL 0.96148f
C327 COMPARATOR__PRE CMP 1.20731f
C328 FILTER__BUFFER1__PRE VPWR 7.82342f
C329 FILTER__MID BIAS 0.80098f
C330 FILTER__BUFFER1__PRE FILTER__BUFFER1__FIRST__MIR 1.2019f
C331 PGA__GAIN2__AMP__FIRST__MIR VCM 0.34705f
C332 PGA__GAIN2__AMP__PRE PGA__V2 7.90166f
C333 PGA__GAIN2__AMP__FIRST__MIR PGA__GAIN2__FB 2.88116f
C334 PGA__GAIN8__AMP__FIRST__MIR VPWR 11.1684f
C335 PGA__GAIN8__AMP__FIRST__MIR PGA__GAIN8__FB 2.89497f
C336 PGA__GAIN8__AMP__PRE PGA__V8 1.74766f
C337 FILTER__BUFFER0__FIRST__TAIL BIAS 0.39693f
C338 PGA__GAIN2__AMP__PRE DATA 10.2596f
C339 PGA__GAINB PGA__OUTPUT_BUFFER__FIRST__TAIL 0
C340 SAMPLE__T SAMPLE__MB 0.0681f
C341 PGA__OUTPUT_BUFFER__PRE DATA 0
C342 PGA__GAIN8__AMP__PRE RESET 0.56627f
C343 PGA__V2 CLK 0.41947f
C344 SAMPLE__T DATA 1.40865f
C345 BIAS VIN 0.54551f
C346 VPWR GAIN 4.75376f
C347 SAMPLE__MB CLK 0.29396f
C348 SAMPLE__CLKB SAMPLE__M 3.51344f
C349 D SAMPLE__MF 0.00538f
C350 FILTER__BUFFER0__FIRST__MIR CLK 0.3474f
C351 PGA__GAIN2__AMP__FIRST__MIR PGA__GAIN2__AMP__FIRST__TAIL 3.77815f
C352 PGA__GAIN8__FB GAIN 0.27756f
C353 PGA__GAIN2__FB VCM 0.36775f
C354 CLK DATA 0.17072p
C355 D RESET 1.56871f
C356 PGA__GAIN8__AMP__FIRST__MIR PGA__GAIN8__AMP__FIRST__TAIL 3.81393f
C357 FILTER__FILTER0 VCM 0.00745f
C358 PGA__GAINB VPWR 2.63542f
C359 BIAS_SOURCE__VCM_BUFFER__FIRST__TAIL DATA 0.34207f
C360 BIAS_SOURCE__VCM_BUFFER__PRE VPWR 8.7245f
C361 PGA__GAIN8__FB PGA__GAINB 0.33596f
C362 PGA__GAIN8__AMP__FIRST__TAIL GAIN 0.34544f
C363 PGA__GAIN2__AMP__FIRST__TAIL VCM 0.33657f
C364 COMPARATOR__PREAMP__TAIL DATA 0
C365 PGA__GAIN2__AMP__FIRST__TAIL PGA__GAIN2__FB 4.08048f
C366 BIAS_SOURCE__VCM_BUFFER__FIRST__MIR DATA 0.3633f
C367 AMPLIFIED OUT 0.45548f
C368 COMPARATOR__PRE RESET_MUX__SB 0.28675f
C369 FILTER__BUFFER1__PRE BIAS 0.17458f
C370 FILTER__MID VCM 0.4175f
C371 PGA__SELECTED AMPLIFIED 1.09585f
C372 FILTER__FILTER0 FILTER__MID 0.16514f
C373 PGA__GAIN2__AMP__FIRST__MIR VIN 0.88826f
C374 PGA__OUTPUT_BUFFER__FIRST__TAIL OUT 2.82218f
C375 PGA__GAIN8__AMP__FIRST__MIR BIAS 0.34708f
C376 FILTER__BUFFER0__FIRST__TAIL VCM 0.33656f
C377 PGA__SELECTED PGA__OUTPUT_BUFFER__FIRST__TAIL 2.96633f
C378 SAMPLE__T SAMPLE__TB 0.73431f
C379 SAMPLE__M VPWR 5.73009f
C380 PGA__GAIN8__AMP__PRE CLK 0.56666f
C381 PGA__V2 DATA 3.21952f
C382 FILTER__FILTER0 FILTER__BUFFER0__FIRST__TAIL 2.99627f
C383 VCM VIN 0.47442f
C384 VPWR OUT 10.1959f
C385 BIAS GAIN 0.63091f
C386 SAMPLE__MB DATA 0.01409f
C387 SAMPLE__CLKB SAMPLE__MF 4.76996f
C388 FILTER__BUFFER0__FIRST__MIR DATA 0.3474f
C389 PGA__OUTPUT_BUFFER__FIRST__MIR OUT 0.34711f
C390 PGA__GAIN8__FB OUT 0.27744f
C391 PGA__GAIN2__FB VIN 0.32422f
C392 D CLK 3.16452f
C393 FILTER__BUFFER1__FIRST__MIR OUT 0.97409f
C394 PGA__SELECTED VPWR 8.27714f
C395 PGA__GAINB BIAS 0.26705f
C396 PGA__SELECTED PGA__OUTPUT_BUFFER__FIRST__MIR 0.89787f
C397 BIAS_SOURCE__VCM_BUFFER__PRE BIAS 0.58331f
C398 FILTER__FILTER1 VPWR 0.00594f
C399 PGA__GAIN8__AMP__FIRST__TAIL OUT 0.33656f
C400 FILTER__FILTER1 FILTER__BUFFER1__FIRST__MIR 0.65494f
C401 PGA__GAIN2__AMP__FIRST__TAIL VIN 3.07498f
C402 CMP RESET_MUX__SB 3.89055f
C403 FILTER__BUFFER0__FIRST__TAIL FILTER__MID 3.95873f
C404 FILTER__BUFFER0__PRE OUT 9.71971f
C405 AMPLIFIED RESET 0.42693f
C406 FILTER__BUFFER1__PRE VCM 0.00622f
C407 DATA VGND 0.22702p
C408 CLK VGND 0.22834p
C409 RESET VGND 0.22087p
C410 OUT VGND 0.19536p
C411 GAIN VGND 95.70565f
C412 VIN VGND 77.68741f
C413 VCM VGND 0.17389p
C414 BIAS VGND 0.12258p
C415 VPWR VGND 0.66367p
C416 SAMPLE__TB VGND 10.55043f $ **FLOATING
C417 SAMPLE__MB VGND 9.68975f $ **FLOATING
C418 SAMPLE__T VGND 15.61548f $ **FLOATING
C419 SAMPLE__MF VGND 9.79284f $ **FLOATING
C420 SAMPLE__M VGND 13.82244f $ **FLOATING
C421 SAMPLE__CLKB VGND 12.69395f $ **FLOATING
C422 D VGND 11.83238f $ **FLOATING
C423 RESET_MUX__SB VGND 10.59436f $ **FLOATING
C424 CMP VGND 8.40101f $ **FLOATING
C425 COMPARATOR__PREAMP__TAIL VGND 9.32313f $ **FLOATING
C426 COMPARATOR__PRE VGND 12.60893f $ **FLOATING
C427 COMPARATOR__PREAMP__MIR VGND 9.21552f $ **FLOATING
C428 FILTER__BUFFER1__FIRST__TAIL VGND 16.90947f $ **FLOATING
C429 FILTER__BUFFER1__FIRST__MIR VGND 15.39802f $ **FLOATING
C430 FILTER__FILTER1 VGND 0.95887p $ **FLOATING
C431 FILTER__BUFFER1__PRE VGND 0.14116p $ **FLOATING
C432 FILTER__MID VGND 30.49895f $ **FLOATING
C433 FILTER__BUFFER0__FIRST__TAIL VGND 16.43243f $ **FLOATING
C434 FILTER__BUFFER0__FIRST__MIR VGND 14.64448f $ **FLOATING
C435 FILTER__FILTER0 VGND 0.95877p $ **FLOATING
C436 FILTER__BUFFER0__PRE VGND 0.14025p $ **FLOATING
C437 AMPLIFIED VGND 29.05402f $ **FLOATING
C438 PGA__OUTPUT_BUFFER__FIRST__TAIL VGND 13.03752f $ **FLOATING
C439 PGA__OUTPUT_BUFFER__FIRST__MIR VGND 14.08284f $ **FLOATING
C440 PGA__SELECTED VGND 24.80173f $ **FLOATING
C441 PGA__GAINB VGND 9.04298f $ **FLOATING
C442 PGA__OUTPUT_BUFFER__PRE VGND 0.13858p $ **FLOATING
C443 PGA__V8 VGND 27.06641f $ **FLOATING
C444 PGA__GAIN8__FB VGND 32.62727f $ **FLOATING
C445 PGA__GAIN8__AMP__FIRST__TAIL VGND 17.30884f $ **FLOATING
C446 PGA__GAIN8__AMP__FIRST__MIR VGND 15.356f $ **FLOATING
C447 PGA__GAIN8__AMP__PRE VGND 0.14358p $ **FLOATING
C448 PGA__V2 VGND 32.38059f $ **FLOATING
C449 PGA__GAIN2__FB VGND 25.52617f $ **FLOATING
C450 PGA__GAIN2__AMP__FIRST__TAIL VGND 16.85382f $ **FLOATING
C451 PGA__GAIN2__AMP__FIRST__MIR VGND 14.98181f $ **FLOATING
C452 PGA__GAIN2__AMP__PRE VGND 0.14463p $ **FLOATING
C453 BIAS_SOURCE__VCM_BUFFER__FIRST__TAIL VGND 17.42097f $ **FLOATING
C454 BIAS_SOURCE__VCM_BUFFER__FIRST__MIR VGND 16.24247f $ **FLOATING
C455 BIAS_SOURCE__VCM_RAW VGND 0.97432p $ **FLOATING
C456 BIAS_SOURCE__VCM_BUFFER__PRE VGND 0.14609p $ **FLOATING
C457 BIAS_SOURCE__VCM_BUFFER__COMP.t2 VGND 74.33311f $ **FLOATING
C458 BIAS_SOURCE__VCM_BUFFER__COMP.t3 VGND 73.9547f $ **FLOATING
C459 BIAS_SOURCE__VCM_BUFFER__COMP.n0 VGND 1.97169f $ **FLOATING
C460 BIAS_SOURCE__VCM_BUFFER__COMP.t1 VGND 73.9547f $ **FLOATING
C461 BIAS_SOURCE__VCM_BUFFER__COMP.n1 VGND 1.90891f $ **FLOATING
C462 BIAS_SOURCE__VCM_BUFFER__COMP.t0 VGND 0.77699f $ **FLOATING
C463 PGA__GAIN8__AMP__FIRST__MIR.n0 VGND 0.03491f $ **FLOATING
C464 PGA__GAIN8__AMP__FIRST__MIR.t1 VGND 0.04183f $ **FLOATING
C465 PGA__GAIN8__AMP__FIRST__MIR.t4 VGND 2.12781f $ **FLOATING
C466 PGA__GAIN8__AMP__FIRST__MIR.t0 VGND 2.12781f $ **FLOATING
C467 PGA__GAIN8__AMP__FIRST__MIR.n1 VGND 2.46973f $ **FLOATING
C468 PGA__GAIN8__AMP__FIRST__MIR.n2 VGND 0.02466f $ **FLOATING
C469 PGA__GAIN8__AMP__FIRST__MIR.t3 VGND 0.03011f $ **FLOATING
C470 PGA__GAIN8__AMP__FIRST__MIR.n3 VGND 0.02466f $ **FLOATING
C471 PGA__GAIN8__AMP__FIRST__MIR.n4 VGND 1.22985f $ **FLOATING
C472 PGA__GAIN8__AMP__FIRST__MIR.n5 VGND 0.02466f $ **FLOATING
C473 PGA__GAIN8__AMP__FIRST__MIR.t2 VGND 0.03011f $ **FLOATING
C474 PGA__GAIN8__AMP__FIRST__MIR.n6 VGND 0.02466f $ **FLOATING
C475 PGA__GAIN8__AMP__FIRST__MIR.n7 VGND 1.18259f $ **FLOATING
C476 PGA__GAIN8__AMP__FIRST__MIR.n8 VGND 2.63648f $ **FLOATING
C477 PGA__GAIN8__AMP__FIRST__MIR.n9 VGND 1.42616f $ **FLOATING
C478 PGA__GAIN8__AMP__FIRST__MIR.n10 VGND 2.48131f $ **FLOATING
C479 PGA__GAIN8__AMP__FIRST__MIR.n11 VGND 0.03437f $ **FLOATING
C480 PGA__GAIN8__FB.t2 VGND 0.29147f $ **FLOATING
C481 PGA__GAIN8__FB.t0 VGND 1.06477f $ **FLOATING
C482 PGA__GAIN8__FB.t1 VGND 0.56254f $ **FLOATING
C483 PGA__GAIN8__FB.n0 VGND 3.51885f $ **FLOATING
C484 PGA__GAIN8__FB.t3 VGND 0.29147f $ **FLOATING
C485 PGA__GAIN8__FB.n1 VGND 3.21053f $ **FLOATING
C486 COMPARATOR__PREAMP__MIR.n0 VGND 0.01545f $ **FLOATING
C487 COMPARATOR__PREAMP__MIR.t3 VGND 1.93105f $ **FLOATING
C488 COMPARATOR__PREAMP__MIR.t1 VGND 1.93105f $ **FLOATING
C489 COMPARATOR__PREAMP__MIR.n1 VGND 1.6019f $ **FLOATING
C490 COMPARATOR__PREAMP__MIR.n2 VGND 0.03119f $ **FLOATING
C491 COMPARATOR__PREAMP__MIR.t2 VGND 0.03796f $ **FLOATING
C492 COMPARATOR__PREAMP__MIR.n3 VGND 0.03169f $ **FLOATING
C493 COMPARATOR__PREAMP__MIR.n4 VGND 2.032f $ **FLOATING
C494 COMPARATOR__PREAMP__MIR.n5 VGND 1.64082f $ **FLOATING
C495 COMPARATOR__PREAMP__MIR.n6 VGND 0.92377f $ **FLOATING
C496 COMPARATOR__PREAMP__MIR.t0 VGND 0.08474f $ **FLOATING
C497 COMPARATOR__PREAMP__MIR.n7 VGND 0.28907f $ **FLOATING
C498 COMPARATOR__PREAMP__MIR.n8 VGND 0.05101f $ **FLOATING
C499 SAMPLE__TB.n0 VGND 0.00492f $ **FLOATING
C500 SAMPLE__TB.t3 VGND 0.02031f $ **FLOATING
C501 SAMPLE__TB.t2 VGND 0.02111f $ **FLOATING
C502 SAMPLE__TB.n1 VGND 1.70409f $ **FLOATING
C503 SAMPLE__TB.n2 VGND 0.00562f $ **FLOATING
C504 SAMPLE__TB.t1 VGND 0.01366f $ **FLOATING
C505 SAMPLE__TB.n3 VGND 0.00562f $ **FLOATING
C506 SAMPLE__TB.n4 VGND 0.3857f $ **FLOATING
C507 SAMPLE__TB.n5 VGND 1.30312f $ **FLOATING
C508 SAMPLE__TB.n6 VGND 0.41236f $ **FLOATING
C509 SAMPLE__TB.t0 VGND 0.01506f $ **FLOATING
C510 SAMPLE__TB.n7 VGND 0.00492f $ **FLOATING
C511 COMPARATOR__PREAMP__TAIL.n0 VGND 0.01315f $ **FLOATING
C512 COMPARATOR__PREAMP__TAIL.t0 VGND 0.02142f $ **FLOATING
C513 COMPARATOR__PREAMP__TAIL.n1 VGND 0.03817f $ **FLOATING
C514 COMPARATOR__PREAMP__TAIL.t2 VGND 0.06729f $ **FLOATING
C515 COMPARATOR__PREAMP__TAIL.n2 VGND 0.22953f $ **FLOATING
C516 COMPARATOR__PREAMP__TAIL.n3 VGND 0.0146f $ **FLOATING
C517 COMPARATOR__PREAMP__TAIL.n4 VGND 0.71367f $ **FLOATING
C518 COMPARATOR__PREAMP__TAIL.n5 VGND 0.01227f $ **FLOATING
C519 COMPARATOR__PREAMP__TAIL.t1 VGND 0.06729f $ **FLOATING
C520 COMPARATOR__PREAMP__TAIL.n6 VGND 0.22953f $ **FLOATING
C521 COMPARATOR__PREAMP__TAIL.n7 VGND 0.04051f $ **FLOATING
C522 COMPARATOR__PREAMP__TAIL.n8 VGND 0.68223f $ **FLOATING
C523 COMPARATOR__PREAMP__TAIL.n9 VGND 2.34923f $ **FLOATING
C524 COMPARATOR__PREAMP__TAIL.n10 VGND 0.58676f $ **FLOATING
C525 COMPARATOR__PREAMP__TAIL.n11 VGND 0.01268f $ **FLOATING
C526 RESET_MUX__SB.n0 VGND 0.00603f $ **FLOATING
C527 RESET_MUX__SB.t3 VGND 0.02588f $ **FLOATING
C528 RESET_MUX__SB.t2 VGND 0.02491f $ **FLOATING
C529 RESET_MUX__SB.n1 VGND 2.6581f $ **FLOATING
C530 RESET_MUX__SB.n2 VGND 0.00689f $ **FLOATING
C531 RESET_MUX__SB.t1 VGND 0.01675f $ **FLOATING
C532 RESET_MUX__SB.n3 VGND 0.00689f $ **FLOATING
C533 RESET_MUX__SB.n4 VGND 0.47298f $ **FLOATING
C534 RESET_MUX__SB.n5 VGND 1.59676f $ **FLOATING
C535 RESET_MUX__SB.n6 VGND 0.50567f $ **FLOATING
C536 RESET_MUX__SB.t0 VGND 0.01846f $ **FLOATING
C537 RESET_MUX__SB.n7 VGND 0.00603f $ **FLOATING
C538 FILTER__BUFFER0__FIRST__TAIL.n0 VGND 0.02059f $ **FLOATING
C539 FILTER__BUFFER0__FIRST__TAIL.t0 VGND 0.03354f $ **FLOATING
C540 FILTER__BUFFER0__FIRST__TAIL.n1 VGND 0.02782f $ **FLOATING
C541 FILTER__BUFFER0__FIRST__TAIL.t1 VGND 0.03397f $ **FLOATING
C542 FILTER__BUFFER0__FIRST__TAIL.n2 VGND 0.02782f $ **FLOATING
C543 FILTER__BUFFER0__FIRST__TAIL.n3 VGND 1.29506f $ **FLOATING
C544 FILTER__BUFFER0__FIRST__TAIL.n4 VGND 0.02782f $ **FLOATING
C545 FILTER__BUFFER0__FIRST__TAIL.t3 VGND 0.03397f $ **FLOATING
C546 FILTER__BUFFER0__FIRST__TAIL.n5 VGND 0.02782f $ **FLOATING
C547 FILTER__BUFFER0__FIRST__TAIL.n6 VGND 1.24278f $ **FLOATING
C548 FILTER__BUFFER0__FIRST__TAIL.n7 VGND 2.55225f $ **FLOATING
C549 FILTER__BUFFER0__FIRST__TAIL.n8 VGND 0.02782f $ **FLOATING
C550 FILTER__BUFFER0__FIRST__TAIL.t4 VGND 0.03397f $ **FLOATING
C551 FILTER__BUFFER0__FIRST__TAIL.n9 VGND 0.02782f $ **FLOATING
C552 FILTER__BUFFER0__FIRST__TAIL.n10 VGND 1.24278f $ **FLOATING
C553 FILTER__BUFFER0__FIRST__TAIL.n11 VGND 1.41053f $ **FLOATING
C554 FILTER__BUFFER0__FIRST__TAIL.n12 VGND 0.02782f $ **FLOATING
C555 FILTER__BUFFER0__FIRST__TAIL.t2 VGND 0.03397f $ **FLOATING
C556 FILTER__BUFFER0__FIRST__TAIL.n13 VGND 0.02782f $ **FLOATING
C557 FILTER__BUFFER0__FIRST__TAIL.n14 VGND 1.24278f $ **FLOATING
C558 FILTER__BUFFER0__FIRST__TAIL.n15 VGND 3.21324f $ **FLOATING
C559 FILTER__BUFFER0__FIRST__TAIL.n16 VGND 1.13332f $ **FLOATING
C560 FILTER__BUFFER0__FIRST__TAIL.n17 VGND 0.01985f $ **FLOATING
C561 BIAS_SOURCE__VCM_BUFFER__FIRST__TAIL.n0 VGND 0.02126f $ **FLOATING
C562 BIAS_SOURCE__VCM_BUFFER__FIRST__TAIL.t0 VGND 0.03464f $ **FLOATING
C563 BIAS_SOURCE__VCM_BUFFER__FIRST__TAIL.n1 VGND 0.02873f $ **FLOATING
C564 BIAS_SOURCE__VCM_BUFFER__FIRST__TAIL.t4 VGND 0.03508f $ **FLOATING
C565 BIAS_SOURCE__VCM_BUFFER__FIRST__TAIL.n2 VGND 0.02873f $ **FLOATING
C566 BIAS_SOURCE__VCM_BUFFER__FIRST__TAIL.n3 VGND 1.40113f $ **FLOATING
C567 BIAS_SOURCE__VCM_BUFFER__FIRST__TAIL.n4 VGND 0.02873f $ **FLOATING
C568 BIAS_SOURCE__VCM_BUFFER__FIRST__TAIL.t1 VGND 0.03508f $ **FLOATING
C569 BIAS_SOURCE__VCM_BUFFER__FIRST__TAIL.n5 VGND 0.02873f $ **FLOATING
C570 BIAS_SOURCE__VCM_BUFFER__FIRST__TAIL.n6 VGND 1.34641f $ **FLOATING
C571 BIAS_SOURCE__VCM_BUFFER__FIRST__TAIL.n7 VGND 2.76847f $ **FLOATING
C572 BIAS_SOURCE__VCM_BUFFER__FIRST__TAIL.n8 VGND 0.02873f $ **FLOATING
C573 BIAS_SOURCE__VCM_BUFFER__FIRST__TAIL.t2 VGND 0.03508f $ **FLOATING
C574 BIAS_SOURCE__VCM_BUFFER__FIRST__TAIL.n9 VGND 0.02873f $ **FLOATING
C575 BIAS_SOURCE__VCM_BUFFER__FIRST__TAIL.n10 VGND 1.34641f $ **FLOATING
C576 BIAS_SOURCE__VCM_BUFFER__FIRST__TAIL.n11 VGND 1.5234f $ **FLOATING
C577 BIAS_SOURCE__VCM_BUFFER__FIRST__TAIL.n12 VGND 0.02873f $ **FLOATING
C578 BIAS_SOURCE__VCM_BUFFER__FIRST__TAIL.t3 VGND 0.03508f $ **FLOATING
C579 BIAS_SOURCE__VCM_BUFFER__FIRST__TAIL.n13 VGND 0.02873f $ **FLOATING
C580 BIAS_SOURCE__VCM_BUFFER__FIRST__TAIL.n14 VGND 1.34641f $ **FLOATING
C581 BIAS_SOURCE__VCM_BUFFER__FIRST__TAIL.n15 VGND 3.45122f $ **FLOATING
C582 BIAS_SOURCE__VCM_BUFFER__FIRST__TAIL.n16 VGND 1.23398f $ **FLOATING
C583 BIAS_SOURCE__VCM_BUFFER__FIRST__TAIL.n17 VGND 0.0205f $ **FLOATING
C584 PGA__GAIN2__AMP__COMP.t2 VGND 74.77779f $ **FLOATING
C585 PGA__GAIN2__AMP__COMP.t1 VGND 74.39429f $ **FLOATING
C586 PGA__GAIN2__AMP__COMP.n0 VGND 2.03515f $ **FLOATING
C587 PGA__GAIN2__AMP__COMP.t3 VGND 74.39429f $ **FLOATING
C588 PGA__GAIN2__AMP__COMP.n1 VGND 1.98464f $ **FLOATING
C589 PGA__GAIN2__AMP__COMP.t0 VGND 0.81378f $ **FLOATING
C590 FILTER__BUFFER1__FIRST__MIR.n0 VGND 0.0209f $ **FLOATING
C591 FILTER__BUFFER1__FIRST__MIR.t4 VGND 1.80348f $ **FLOATING
C592 FILTER__BUFFER1__FIRST__MIR.t2 VGND 1.80348f $ **FLOATING
C593 FILTER__BUFFER1__FIRST__MIR.n1 VGND 1.96386f $ **FLOATING
C594 FILTER__BUFFER1__FIRST__MIR.n2 VGND 0.02913f $ **FLOATING
C595 FILTER__BUFFER1__FIRST__MIR.t3 VGND 0.03545f $ **FLOATING
C596 FILTER__BUFFER1__FIRST__MIR.n3 VGND 0.02959f $ **FLOATING
C597 FILTER__BUFFER1__FIRST__MIR.n4 VGND 2.05724f $ **FLOATING
C598 FILTER__BUFFER1__FIRST__MIR.n5 VGND 1.16031f $ **FLOATING
C599 FILTER__BUFFER1__FIRST__MIR.n6 VGND 0.0209f $ **FLOATING
C600 FILTER__BUFFER1__FIRST__MIR.t0 VGND 0.02552f $ **FLOATING
C601 FILTER__BUFFER1__FIRST__MIR.n7 VGND 0.0209f $ **FLOATING
C602 FILTER__BUFFER1__FIRST__MIR.n8 VGND 0.99603f $ **FLOATING
C603 FILTER__BUFFER1__FIRST__MIR.n9 VGND 2.13818f $ **FLOATING
C604 FILTER__BUFFER1__FIRST__MIR.n10 VGND 0.95649f $ **FLOATING
C605 FILTER__BUFFER1__FIRST__MIR.t1 VGND 0.02552f $ **FLOATING
C606 FILTER__BUFFER1__FIRST__MIR.n11 VGND 0.0209f $ **FLOATING
C607 FILTER__MID.n0 VGND 0.01301f $ **FLOATING
C608 FILTER__MID.t0 VGND 0.0212f $ **FLOATING
C609 FILTER__MID.t2 VGND 0.72586f $ **FLOATING
C610 FILTER__MID.t3 VGND 0.99989f $ **FLOATING
C611 FILTER__MID.n1 VGND 4.27327f $ **FLOATING
C612 FILTER__MID.t5 VGND 0.46647f $ **FLOATING
C613 FILTER__MID.t4 VGND 0.46647f $ **FLOATING
C614 FILTER__MID.n2 VGND 2.63861f $ **FLOATING
C615 FILTER__MID.n3 VGND 0.26814f $ **FLOATING
C616 FILTER__MID.t1 VGND 0.26637f $ **FLOATING
C617 FILTER__MID.n4 VGND 1.15976f $ **FLOATING
C618 FILTER__MID.n5 VGND 0.10433f $ **FLOATING
C619 FILTER__MID.n6 VGND 1.29602f $ **FLOATING
C620 FILTER__MID.n7 VGND 1.45198f $ **FLOATING
C621 FILTER__MID.n8 VGND 2.93712f $ **FLOATING
C622 FILTER__MID.n9 VGND 0.64288f $ **FLOATING
C623 FILTER__MID.n10 VGND 0.01255f $ **FLOATING
C624 SAMPLE__M.n0 VGND 0.00945f $ **FLOATING
C625 SAMPLE__M.t5 VGND 0.03417f $ **FLOATING
C626 SAMPLE__M.t4 VGND 0.03551f $ **FLOATING
C627 SAMPLE__M.n1 VGND 3.82653f $ **FLOATING
C628 SAMPLE__M.n2 VGND 0.00827f $ **FLOATING
C629 SAMPLE__M.t2 VGND 0.02533f $ **FLOATING
C630 SAMPLE__M.n3 VGND 0.00827f $ **FLOATING
C631 SAMPLE__M.n4 VGND 0.68025f $ **FLOATING
C632 SAMPLE__M.n5 VGND 2.16659f $ **FLOATING
C633 SAMPLE__M.n6 VGND 0.00945f $ **FLOATING
C634 SAMPLE__M.t3 VGND 0.02297f $ **FLOATING
C635 SAMPLE__M.n7 VGND 0.00945f $ **FLOATING
C636 SAMPLE__M.n8 VGND 0.72563f $ **FLOATING
C637 SAMPLE__M.n9 VGND 0.00827f $ **FLOATING
C638 SAMPLE__M.t1 VGND 0.02533f $ **FLOATING
C639 SAMPLE__M.n10 VGND 0.00827f $ **FLOATING
C640 SAMPLE__M.n11 VGND 0.68025f $ **FLOATING
C641 SAMPLE__M.n12 VGND 2.16885f $ **FLOATING
C642 SAMPLE__M.n13 VGND 1.20895f $ **FLOATING
C643 SAMPLE__M.n14 VGND 0.68025f $ **FLOATING
C644 SAMPLE__M.t0 VGND 0.02297f $ **FLOATING
C645 SAMPLE__M.n15 VGND 0.00945f $ **FLOATING
C646 SAMPLE__CLKB.n0 VGND 0.01074f $ **FLOATING
C647 SAMPLE__CLKB.t4 VGND 0.04438f $ **FLOATING
C648 SAMPLE__CLKB.t3 VGND 0.04611f $ **FLOATING
C649 SAMPLE__CLKB.n1 VGND 3.88329f $ **FLOATING
C650 SAMPLE__CLKB.t2 VGND 0.04611f $ **FLOATING
C651 SAMPLE__CLKB.n2 VGND 2.79223f $ **FLOATING
C652 SAMPLE__CLKB.t5 VGND 0.04438f $ **FLOATING
C653 SAMPLE__CLKB.n3 VGND 2.63202f $ **FLOATING
C654 SAMPLE__CLKB.n4 VGND 0.01227f $ **FLOATING
C655 SAMPLE__CLKB.t1 VGND 0.02983f $ **FLOATING
C656 SAMPLE__CLKB.n5 VGND 0.01227f $ **FLOATING
C657 SAMPLE__CLKB.n6 VGND 0.84265f $ **FLOATING
C658 SAMPLE__CLKB.n7 VGND 2.84475f $ **FLOATING
C659 SAMPLE__CLKB.n8 VGND 0.90089f $ **FLOATING
C660 SAMPLE__CLKB.t0 VGND 0.03289f $ **FLOATING
C661 SAMPLE__CLKB.n9 VGND 0.01074f $ **FLOATING
C662 BIAS_SOURCE__VCM_BUFFER__PRE.n0 VGND 0.00912f $ **FLOATING
C663 BIAS_SOURCE__VCM_BUFFER__PRE.t5 VGND 39.1995f $ **FLOATING
C664 BIAS_SOURCE__VCM_BUFFER__PRE.t3 VGND 39.1995f $ **FLOATING
C665 BIAS_SOURCE__VCM_BUFFER__PRE.n1 VGND 1.09532f $ **FLOATING
C666 BIAS_SOURCE__VCM_BUFFER__PRE.t4 VGND 39.1995f $ **FLOATING
C667 BIAS_SOURCE__VCM_BUFFER__PRE.n2 VGND 0.73581f $ **FLOATING
C668 BIAS_SOURCE__VCM_BUFFER__PRE.t6 VGND 1.50383f $ **FLOATING
C669 BIAS_SOURCE__VCM_BUFFER__PRE.n3 VGND 0.6535f $ **FLOATING
C670 BIAS_SOURCE__VCM_BUFFER__PRE.n4 VGND 0.01272f $ **FLOATING
C671 BIAS_SOURCE__VCM_BUFFER__PRE.t2 VGND 0.01548f $ **FLOATING
C672 BIAS_SOURCE__VCM_BUFFER__PRE.n5 VGND 0.01292f $ **FLOATING
C673 BIAS_SOURCE__VCM_BUFFER__PRE.n6 VGND 0.89809f $ **FLOATING
C674 BIAS_SOURCE__VCM_BUFFER__PRE.n7 VGND 0.65827f $ **FLOATING
C675 BIAS_SOURCE__VCM_BUFFER__PRE.n8 VGND 0.00912f $ **FLOATING
C676 BIAS_SOURCE__VCM_BUFFER__PRE.t1 VGND 0.01114f $ **FLOATING
C677 BIAS_SOURCE__VCM_BUFFER__PRE.n9 VGND 0.00912f $ **FLOATING
C678 BIAS_SOURCE__VCM_BUFFER__PRE.n10 VGND 0.41756f $ **FLOATING
C679 BIAS_SOURCE__VCM_BUFFER__PRE.n11 VGND 1.18508f $ **FLOATING
C680 BIAS_SOURCE__VCM_BUFFER__PRE.n12 VGND 0.48349f $ **FLOATING
C681 BIAS_SOURCE__VCM_BUFFER__PRE.t0 VGND 0.01114f $ **FLOATING
C682 BIAS_SOURCE__VCM_BUFFER__PRE.n13 VGND 0.00912f $ **FLOATING
C683 BIAS_SOURCE__VCM_BUFFER__FIRST__MIR.n0 VGND 0.02053f $ **FLOATING
C684 BIAS_SOURCE__VCM_BUFFER__FIRST__MIR.t4 VGND 1.77119f $ **FLOATING
C685 BIAS_SOURCE__VCM_BUFFER__FIRST__MIR.t2 VGND 1.77119f $ **FLOATING
C686 BIAS_SOURCE__VCM_BUFFER__FIRST__MIR.n1 VGND 2.05581f $ **FLOATING
C687 BIAS_SOURCE__VCM_BUFFER__FIRST__MIR.n2 VGND 0.02861f $ **FLOATING
C688 BIAS_SOURCE__VCM_BUFFER__FIRST__MIR.t3 VGND 0.03482f $ **FLOATING
C689 BIAS_SOURCE__VCM_BUFFER__FIRST__MIR.n3 VGND 0.02906f $ **FLOATING
C690 BIAS_SOURCE__VCM_BUFFER__FIRST__MIR.n4 VGND 2.06544f $ **FLOATING
C691 BIAS_SOURCE__VCM_BUFFER__FIRST__MIR.n5 VGND 1.18714f $ **FLOATING
C692 BIAS_SOURCE__VCM_BUFFER__FIRST__MIR.n6 VGND 0.02053f $ **FLOATING
C693 BIAS_SOURCE__VCM_BUFFER__FIRST__MIR.t1 VGND 0.02506f $ **FLOATING
C694 BIAS_SOURCE__VCM_BUFFER__FIRST__MIR.n7 VGND 0.02053f $ **FLOATING
C695 BIAS_SOURCE__VCM_BUFFER__FIRST__MIR.n8 VGND 1.02373f $ **FLOATING
C696 BIAS_SOURCE__VCM_BUFFER__FIRST__MIR.n9 VGND 2.19461f $ **FLOATING
C697 BIAS_SOURCE__VCM_BUFFER__FIRST__MIR.n10 VGND 0.98439f $ **FLOATING
C698 BIAS_SOURCE__VCM_BUFFER__FIRST__MIR.t0 VGND 0.02506f $ **FLOATING
C699 BIAS_SOURCE__VCM_BUFFER__FIRST__MIR.n11 VGND 0.02053f $ **FLOATING
C700 DATA.n0 VGND 0.01407f $ **FLOATING
C701 DATA.n1 VGND 0.01407f $ **FLOATING
C702 DATA.t3 VGND 0.03421f $ **FLOATING
C703 DATA.n2 VGND 0.01407f $ **FLOATING
C704 DATA.n3 VGND 1.29546f $ **FLOATING
C705 DATA.n4 VGND 0.12533p $ **FLOATING
C706 DATA.n5 VGND 0.01232f $ **FLOATING
C707 DATA.t1 VGND 0.03772f $ **FLOATING
C708 DATA.n6 VGND 0.01232f $ **FLOATING
C709 DATA.n7 VGND 1.29546f $ **FLOATING
C710 DATA.n8 VGND 3.93081f $ **FLOATING
C711 DATA.n9 VGND 0.01232f $ **FLOATING
C712 DATA.t2 VGND 0.03772f $ **FLOATING
C713 DATA.n10 VGND 0.01232f $ **FLOATING
C714 DATA.n11 VGND 1.29546f $ **FLOATING
C715 DATA.n12 VGND 5.66454f $ **FLOATING
C716 DATA.n13 VGND 1.36708f $ **FLOATING
C717 DATA.t0 VGND 0.03421f $ **FLOATING
C718 DATA.n14 VGND 0.01407f $ **FLOATING
C719 SAMPLE__T.n0 VGND 0.00601f $ **FLOATING
C720 SAMPLE__T.t5 VGND 0.02484f $ **FLOATING
C721 SAMPLE__T.t4 VGND 0.02581f $ **FLOATING
C722 SAMPLE__T.n1 VGND 2.91768f $ **FLOATING
C723 SAMPLE__T.n2 VGND 0.00687f $ **FLOATING
C724 SAMPLE__T.t1 VGND 0.0167f $ **FLOATING
C725 SAMPLE__T.n3 VGND 0.00687f $ **FLOATING
C726 SAMPLE__T.n4 VGND 0.574f $ **FLOATING
C727 SAMPLE__T.n5 VGND 0.00601f $ **FLOATING
C728 SAMPLE__T.t3 VGND 0.01841f $ **FLOATING
C729 SAMPLE__T.n6 VGND 0.00601f $ **FLOATING
C730 SAMPLE__T.n7 VGND 0.54028f $ **FLOATING
C731 SAMPLE__T.n8 VGND 1.67667f $ **FLOATING
C732 SAMPLE__T.n9 VGND 0.00687f $ **FLOATING
C733 SAMPLE__T.t2 VGND 0.0167f $ **FLOATING
C734 SAMPLE__T.n10 VGND 0.00687f $ **FLOATING
C735 SAMPLE__T.n11 VGND 0.54028f $ **FLOATING
C736 SAMPLE__T.n12 VGND 0.92922f $ **FLOATING
C737 SAMPLE__T.n13 VGND 1.6254f $ **FLOATING
C738 SAMPLE__T.n14 VGND 0.54028f $ **FLOATING
C739 SAMPLE__T.t0 VGND 0.01841f $ **FLOATING
C740 SAMPLE__T.n15 VGND 0.00601f $ **FLOATING
C741 CLK.t5 VGND 0.07016f $ **FLOATING
C742 CLK.n0 VGND 0.16364p $ **FLOATING
C743 CLK.t2 VGND 0.06752f $ **FLOATING
C744 CLK.n1 VGND 3.95002f $ **FLOATING
C745 CLK.t1 VGND 0.07016f $ **FLOATING
C746 CLK.n2 VGND 3.94662f $ **FLOATING
C747 CLK.t4 VGND 0.06752f $ **FLOATING
C748 CLK.n3 VGND 3.95335f $ **FLOATING
C749 CLK.t3 VGND 0.06752f $ **FLOATING
C750 CLK.n4 VGND 8.54171f $ **FLOATING
C751 CLK.t0 VGND 0.07016f $ **FLOATING
C752 PGA__GAIN2__AMP__FIRST__MIR.n0 VGND 0.03507f $ **FLOATING
C753 PGA__GAIN2__AMP__FIRST__MIR.t1 VGND 0.04201f $ **FLOATING
C754 PGA__GAIN2__AMP__FIRST__MIR.t4 VGND 2.13725f $ **FLOATING
C755 PGA__GAIN2__AMP__FIRST__MIR.t0 VGND 2.13725f $ **FLOATING
C756 PGA__GAIN2__AMP__FIRST__MIR.n1 VGND 2.40425f $ **FLOATING
C757 PGA__GAIN2__AMP__FIRST__MIR.n2 VGND 0.02477f $ **FLOATING
C758 PGA__GAIN2__AMP__FIRST__MIR.t2 VGND 0.03024f $ **FLOATING
C759 PGA__GAIN2__AMP__FIRST__MIR.n3 VGND 0.02477f $ **FLOATING
C760 PGA__GAIN2__AMP__FIRST__MIR.n4 VGND 1.20783f $ **FLOATING
C761 PGA__GAIN2__AMP__FIRST__MIR.n5 VGND 0.02477f $ **FLOATING
C762 PGA__GAIN2__AMP__FIRST__MIR.t3 VGND 0.03024f $ **FLOATING
C763 PGA__GAIN2__AMP__FIRST__MIR.n6 VGND 0.02477f $ **FLOATING
C764 PGA__GAIN2__AMP__FIRST__MIR.n7 VGND 1.16066f $ **FLOATING
C765 PGA__GAIN2__AMP__FIRST__MIR.n8 VGND 2.59106f $ **FLOATING
C766 PGA__GAIN2__AMP__FIRST__MIR.n9 VGND 1.40379f $ **FLOATING
C767 PGA__GAIN2__AMP__FIRST__MIR.n10 VGND 2.46514f $ **FLOATING
C768 PGA__GAIN2__AMP__FIRST__MIR.n11 VGND 0.03453f $ **FLOATING
C769 PGA__GAIN2__AMP__FIRST__TAIL.n0 VGND 0.02159f $ **FLOATING
C770 PGA__GAIN2__AMP__FIRST__TAIL.t0 VGND 0.03518f $ **FLOATING
C771 PGA__GAIN2__AMP__FIRST__TAIL.n1 VGND 0.02917f $ **FLOATING
C772 PGA__GAIN2__AMP__FIRST__TAIL.t3 VGND 0.03562f $ **FLOATING
C773 PGA__GAIN2__AMP__FIRST__TAIL.n2 VGND 0.02917f $ **FLOATING
C774 PGA__GAIN2__AMP__FIRST__TAIL.n3 VGND 1.39034f $ **FLOATING
C775 PGA__GAIN2__AMP__FIRST__TAIL.n4 VGND 0.02917f $ **FLOATING
C776 PGA__GAIN2__AMP__FIRST__TAIL.t2 VGND 0.03562f $ **FLOATING
C777 PGA__GAIN2__AMP__FIRST__TAIL.n5 VGND 0.02917f $ **FLOATING
C778 PGA__GAIN2__AMP__FIRST__TAIL.n6 VGND 1.33514f $ **FLOATING
C779 PGA__GAIN2__AMP__FIRST__TAIL.n7 VGND 2.74372f $ **FLOATING
C780 PGA__GAIN2__AMP__FIRST__TAIL.n8 VGND 0.02917f $ **FLOATING
C781 PGA__GAIN2__AMP__FIRST__TAIL.t1 VGND 0.03562f $ **FLOATING
C782 PGA__GAIN2__AMP__FIRST__TAIL.n9 VGND 0.02917f $ **FLOATING
C783 PGA__GAIN2__AMP__FIRST__TAIL.n10 VGND 1.33514f $ **FLOATING
C784 PGA__GAIN2__AMP__FIRST__TAIL.n11 VGND 1.51298f $ **FLOATING
C785 PGA__GAIN2__AMP__FIRST__TAIL.n12 VGND 0.02917f $ **FLOATING
C786 PGA__GAIN2__AMP__FIRST__TAIL.t4 VGND 0.03562f $ **FLOATING
C787 PGA__GAIN2__AMP__FIRST__TAIL.n13 VGND 0.02917f $ **FLOATING
C788 PGA__GAIN2__AMP__FIRST__TAIL.n14 VGND 1.33514f $ **FLOATING
C789 PGA__GAIN2__AMP__FIRST__TAIL.n15 VGND 3.4369f $ **FLOATING
C790 PGA__GAIN2__AMP__FIRST__TAIL.n16 VGND 1.22067f $ **FLOATING
C791 PGA__GAIN2__AMP__FIRST__TAIL.n17 VGND 0.02081f $ **FLOATING
C792 PGA__GAIN2__AMP__PRE.n0 VGND 0.00941f $ **FLOATING
C793 PGA__GAIN2__AMP__PRE.t3 VGND 40.4121f $ **FLOATING
C794 PGA__GAIN2__AMP__PRE.t5 VGND 40.4121f $ **FLOATING
C795 PGA__GAIN2__AMP__PRE.n1 VGND 1.11423f $ **FLOATING
C796 PGA__GAIN2__AMP__PRE.t4 VGND 40.4121f $ **FLOATING
C797 PGA__GAIN2__AMP__PRE.n2 VGND 0.75065f $ **FLOATING
C798 PGA__GAIN2__AMP__PRE.t6 VGND 1.55035f $ **FLOATING
C799 PGA__GAIN2__AMP__PRE.n3 VGND 0.65784f $ **FLOATING
C800 PGA__GAIN2__AMP__PRE.n4 VGND 0.01311f $ **FLOATING
C801 PGA__GAIN2__AMP__PRE.t2 VGND 0.01595f $ **FLOATING
C802 PGA__GAIN2__AMP__PRE.n5 VGND 0.01332f $ **FLOATING
C803 PGA__GAIN2__AMP__PRE.n6 VGND 0.91557f $ **FLOATING
C804 PGA__GAIN2__AMP__PRE.n7 VGND 0.66771f $ **FLOATING
C805 PGA__GAIN2__AMP__PRE.n8 VGND 0.00941f $ **FLOATING
C806 PGA__GAIN2__AMP__PRE.t1 VGND 0.01148f $ **FLOATING
C807 PGA__GAIN2__AMP__PRE.n9 VGND 0.00941f $ **FLOATING
C808 PGA__GAIN2__AMP__PRE.n10 VGND 0.48807f $ **FLOATING
C809 PGA__GAIN2__AMP__PRE.n11 VGND 1.19997f $ **FLOATING
C810 PGA__GAIN2__AMP__PRE.n12 VGND 0.42017f $ **FLOATING
C811 PGA__GAIN2__AMP__PRE.t0 VGND 0.01148f $ **FLOATING
C812 PGA__GAIN2__AMP__PRE.n13 VGND 0.00941f $ **FLOATING
C813 VIN.t2 VGND 0.74869f $ **FLOATING
C814 VIN.t3 VGND 0.74869f $ **FLOATING
C815 VIN.n0 VGND 8.37959f $ **FLOATING
C816 VIN.t0 VGND 0.74869f $ **FLOATING
C817 VIN.n1 VGND 6.87097f $ **FLOATING
C818 VIN.n2 VGND 21.7133f $ **FLOATING
C819 VIN.t1 VGND 0.74869f $ **FLOATING
C820 D.n0 VGND 0.00779f $ **FLOATING
C821 D.n1 VGND 0.00682f $ **FLOATING
C822 D.t1 VGND 0.02089f $ **FLOATING
C823 D.n2 VGND 0.00682f $ **FLOATING
C824 D.n3 VGND 0.62468f $ **FLOATING
C825 D.n4 VGND 0.00779f $ **FLOATING
C826 D.t4 VGND 0.01894f $ **FLOATING
C827 D.n5 VGND 0.00779f $ **FLOATING
C828 D.n6 VGND 0.62468f $ **FLOATING
C829 D.n7 VGND 0.00682f $ **FLOATING
C830 D.t3 VGND 0.02089f $ **FLOATING
C831 D.n8 VGND 0.00682f $ **FLOATING
C832 D.n9 VGND 0.58683f $ **FLOATING
C833 D.n10 VGND 1.84512f $ **FLOATING
C834 D.n11 VGND 0.00779f $ **FLOATING
C835 D.t2 VGND 0.01894f $ **FLOATING
C836 D.n12 VGND 0.00779f $ **FLOATING
C837 D.n13 VGND 0.58683f $ **FLOATING
C838 D.n14 VGND 1.02544f $ **FLOATING
C839 D.n15 VGND 0.00682f $ **FLOATING
C840 D.t5 VGND 0.02089f $ **FLOATING
C841 D.n16 VGND 0.00682f $ **FLOATING
C842 D.n17 VGND 0.58683f $ **FLOATING
C843 D.n18 VGND 1.44203f $ **FLOATING
C844 D.n19 VGND 2.2617f $ **FLOATING
C845 D.n20 VGND 0.58683f $ **FLOATING
C846 D.t0 VGND 0.01894f $ **FLOATING
C847 D.n21 VGND 0.00779f $ **FLOATING
C848 RESET.t1 VGND 0.07008f $ **FLOATING
C849 RESET.n0 VGND 0.16081p $ **FLOATING
C850 RESET.t3 VGND 0.06744f $ **FLOATING
C851 RESET.n1 VGND 3.85462f $ **FLOATING
C852 RESET.t2 VGND 0.07008f $ **FLOATING
C853 RESET.n2 VGND 6.81785f $ **FLOATING
C854 RESET.t0 VGND 0.06744f $ **FLOATING
C855 PGA__V8.n0 VGND 0.02164f $ **FLOATING
C856 PGA__V8.t0 VGND 0.03527f $ **FLOATING
C857 PGA__V8.n1 VGND 0.04077f $ **FLOATING
C858 PGA__V8.t2 VGND 0.04962f $ **FLOATING
C859 PGA__V8.n2 VGND 0.04142f $ **FLOATING
C860 PGA__V8.n3 VGND 2.63686f $ **FLOATING
C861 PGA__V8.n4 VGND 0.03808f $ **FLOATING
C862 PGA__V8.t5 VGND 0.03734f $ **FLOATING
C863 PGA__V8.n5 VGND 0.03948f $ **FLOATING
C864 PGA__V8.n6 VGND 2.61009f $ **FLOATING
C865 PGA__V8.n7 VGND 3.2154f $ **FLOATING
C866 PGA__V8.t3 VGND 0.9221f $ **FLOATING
C867 PGA__V8.n8 VGND 2.75253f $ **FLOATING
C868 PGA__V8.t4 VGND 1.35707f $ **FLOATING
C869 PGA__V8.n9 VGND 5.53229f $ **FLOATING
C870 PGA__V8.n10 VGND 0.44602f $ **FLOATING
C871 PGA__V8.t1 VGND 0.44307f $ **FLOATING
C872 PGA__V8.n11 VGND 1.92911f $ **FLOATING
C873 PGA__V8.n12 VGND 0.17354f $ **FLOATING
C874 PGA__V8.n13 VGND 1.88885f $ **FLOATING
C875 PGA__V8.n14 VGND 5.47585f $ **FLOATING
C876 PGA__V8.n15 VGND 0.75082f $ **FLOATING
C877 PGA__V8.n16 VGND 0.02087f $ **FLOATING
C878 PGA__OUTPUT_BUFFER__FIRST__TAIL.n0 VGND 0.02236f $ **FLOATING
C879 PGA__OUTPUT_BUFFER__FIRST__TAIL.t0 VGND 0.03643f $ **FLOATING
C880 PGA__OUTPUT_BUFFER__FIRST__TAIL.n1 VGND 0.03021f $ **FLOATING
C881 PGA__OUTPUT_BUFFER__FIRST__TAIL.t1 VGND 0.03689f $ **FLOATING
C882 PGA__OUTPUT_BUFFER__FIRST__TAIL.n2 VGND 0.03021f $ **FLOATING
C883 PGA__OUTPUT_BUFFER__FIRST__TAIL.n3 VGND 1.17287f $ **FLOATING
C884 PGA__OUTPUT_BUFFER__FIRST__TAIL.n4 VGND 0.03021f $ **FLOATING
C885 PGA__OUTPUT_BUFFER__FIRST__TAIL.t3 VGND 0.03689f $ **FLOATING
C886 PGA__OUTPUT_BUFFER__FIRST__TAIL.n5 VGND 0.03021f $ **FLOATING
C887 PGA__OUTPUT_BUFFER__FIRST__TAIL.n6 VGND 1.11942f $ **FLOATING
C888 PGA__OUTPUT_BUFFER__FIRST__TAIL.n7 VGND 2.28085f $ **FLOATING
C889 PGA__OUTPUT_BUFFER__FIRST__TAIL.n8 VGND 0.03021f $ **FLOATING
C890 PGA__OUTPUT_BUFFER__FIRST__TAIL.t4 VGND 0.03689f $ **FLOATING
C891 PGA__OUTPUT_BUFFER__FIRST__TAIL.n9 VGND 0.03021f $ **FLOATING
C892 PGA__OUTPUT_BUFFER__FIRST__TAIL.n10 VGND 1.11942f $ **FLOATING
C893 PGA__OUTPUT_BUFFER__FIRST__TAIL.n11 VGND 1.28472f $ **FLOATING
C894 PGA__OUTPUT_BUFFER__FIRST__TAIL.n12 VGND 0.03021f $ **FLOATING
C895 PGA__OUTPUT_BUFFER__FIRST__TAIL.t2 VGND 0.03689f $ **FLOATING
C896 PGA__OUTPUT_BUFFER__FIRST__TAIL.n13 VGND 0.03021f $ **FLOATING
C897 PGA__OUTPUT_BUFFER__FIRST__TAIL.n14 VGND 1.11942f $ **FLOATING
C898 PGA__OUTPUT_BUFFER__FIRST__TAIL.n15 VGND 2.99823f $ **FLOATING
C899 PGA__OUTPUT_BUFFER__FIRST__TAIL.n16 VGND 0.99766f $ **FLOATING
C900 PGA__OUTPUT_BUFFER__FIRST__TAIL.n17 VGND 0.02155f $ **FLOATING
C901 PGA__GAINB.n0 VGND 0.0089f $ **FLOATING
C902 PGA__GAINB.t2 VGND 0.39231f $ **FLOATING
C903 PGA__GAINB.t3 VGND 0.39064f $ **FLOATING
C904 PGA__GAINB.n1 VGND 3.91966f $ **FLOATING
C905 PGA__GAINB.n2 VGND 0.01017f $ **FLOATING
C906 PGA__GAINB.t1 VGND 0.02473f $ **FLOATING
C907 PGA__GAINB.n3 VGND 0.01017f $ **FLOATING
C908 PGA__GAINB.n4 VGND 0.97074f $ **FLOATING
C909 PGA__GAINB.n5 VGND 2.9487f $ **FLOATING
C910 PGA__GAINB.n6 VGND 1.02292f $ **FLOATING
C911 PGA__GAINB.t0 VGND 0.02727f $ **FLOATING
C912 PGA__GAINB.n7 VGND 0.0089f $ **FLOATING
C913 PGA__SELECTED.n0 VGND 0.05556f $ **FLOATING
C914 PGA__SELECTED.t0 VGND 0.06656f $ **FLOATING
C915 PGA__SELECTED.t4 VGND 1.04093f $ **FLOATING
C916 PGA__SELECTED.t5 VGND 1.04093f $ **FLOATING
C917 PGA__SELECTED.n1 VGND 5.89831f $ **FLOATING
C918 PGA__SELECTED.n2 VGND 0.05108f $ **FLOATING
C919 PGA__SELECTED.t1 VGND 0.0501f $ **FLOATING
C920 PGA__SELECTED.n3 VGND 0.05297f $ **FLOATING
C921 PGA__SELECTED.n4 VGND 3.99153f $ **FLOATING
C922 PGA__SELECTED.n5 VGND 0.0547f $ **FLOATING
C923 PGA__SELECTED.t2 VGND 0.06656f $ **FLOATING
C924 PGA__SELECTED.n6 VGND 0.05556f $ **FLOATING
C925 PGA__SELECTED.n7 VGND 3.90148f $ **FLOATING
C926 PGA__SELECTED.n8 VGND 3.72998f $ **FLOATING
C927 PGA__SELECTED.n9 VGND 0.05108f $ **FLOATING
C928 PGA__SELECTED.t3 VGND 0.0501f $ **FLOATING
C929 PGA__SELECTED.n10 VGND 0.05297f $ **FLOATING
C930 PGA__SELECTED.n11 VGND 3.92565f $ **FLOATING
C931 PGA__SELECTED.n12 VGND 2.03434f $ **FLOATING
C932 PGA__SELECTED.n13 VGND 2.0946f $ **FLOATING
C933 PGA__SELECTED.n14 VGND 3.90148f $ **FLOATING
C934 PGA__SELECTED.n15 VGND 0.0547f $ **FLOATING
C935 PGA__V2.n0 VGND 0.02649f $ **FLOATING
C936 PGA__V2.t0 VGND 0.04317f $ **FLOATING
C937 PGA__V2.n1 VGND 0.0499f $ **FLOATING
C938 PGA__V2.t5 VGND 0.06073f $ **FLOATING
C939 PGA__V2.n2 VGND 0.05069f $ **FLOATING
C940 PGA__V2.n3 VGND 3.58011f $ **FLOATING
C941 PGA__V2.n4 VGND 0.0466f $ **FLOATING
C942 PGA__V2.t3 VGND 0.0457f $ **FLOATING
C943 PGA__V2.n5 VGND 0.04833f $ **FLOATING
C944 PGA__V2.n6 VGND 3.54247f $ **FLOATING
C945 PGA__V2.n7 VGND 11.6962f $ **FLOATING
C946 PGA__V2.t4 VGND 1.72086f $ **FLOATING
C947 PGA__V2.n8 VGND 11.1042f $ **FLOATING
C948 PGA__V2.t1 VGND 1.99782f $ **FLOATING
C949 PGA__V2.n9 VGND 7.1613f $ **FLOATING
C950 PGA__V2.n10 VGND 0.5459f $ **FLOATING
C951 PGA__V2.t2 VGND 0.54229f $ **FLOATING
C952 PGA__V2.n11 VGND 2.36109f $ **FLOATING
C953 PGA__V2.n12 VGND 0.2124f $ **FLOATING
C954 PGA__V2.n13 VGND 2.66755f $ **FLOATING
C955 PGA__V2.n14 VGND 7.44978f $ **FLOATING
C956 PGA__V2.n15 VGND 1.26957f $ **FLOATING
C957 PGA__V2.n16 VGND 0.02554f $ **FLOATING
C958 GAIN.t1 VGND 0.06947f $ **FLOATING
C959 GAIN.n0 VGND 67.9465f $ **FLOATING
C960 GAIN.t3 VGND 0.06685f $ **FLOATING
C961 GAIN.n1 VGND 3.45483f $ **FLOATING
C962 GAIN.t0 VGND 0.71286f $ **FLOATING
C963 GAIN.n2 VGND 4.50348f $ **FLOATING
C964 GAIN.t2 VGND 0.70983f $ **FLOATING
C965 VCM.t7 VGND 2.50117f $ **FLOATING
C966 VCM.t3 VGND 2.74249f $ **FLOATING
C967 VCM.n0 VGND 0.11219p $ **FLOATING
C968 VCM.t1 VGND 2.74249f $ **FLOATING
C969 VCM.n1 VGND 25.3016f $ **FLOATING
C970 VCM.t2 VGND 2.65999f $ **FLOATING
C971 VCM.n2 VGND 20.4602f $ **FLOATING
C972 VCM.n3 VGND 0.03975f $ **FLOATING
C973 VCM.t0 VGND 0.06478f $ **FLOATING
C974 VCM.n4 VGND 0.03833f $ **FLOATING
C975 VCM.n5 VGND 1.55356f $ **FLOATING
C976 VCM.n6 VGND 8.53548f $ **FLOATING
C977 VCM.n7 VGND 0.81924f $ **FLOATING
C978 VCM.t4 VGND 0.81381f $ **FLOATING
C979 VCM.n8 VGND 3.5433f $ **FLOATING
C980 VCM.n9 VGND 0.31876f $ **FLOATING
C981 VCM.n10 VGND 3.54903f $ **FLOATING
C982 VCM.n11 VGND 3.99807f $ **FLOATING
C983 VCM.t5 VGND 1.42518f $ **FLOATING
C984 VCM.n12 VGND 4.49238f $ **FLOATING
C985 VCM.n13 VGND 30.7329f $ **FLOATING
C986 VCM.t6 VGND 1.42518f $ **FLOATING
C987 PGA__GAIN2__FB.t3 VGND 0.46126f $ **FLOATING
C988 PGA__GAIN2__FB.t1 VGND 1.08176f $ **FLOATING
C989 PGA__GAIN2__FB.t0 VGND 0.87207f $ **FLOATING
C990 PGA__GAIN2__FB.n0 VGND 5.5345f $ **FLOATING
C991 PGA__GAIN2__FB.t2 VGND 0.46126f $ **FLOATING
C992 PGA__GAIN2__FB.n1 VGND 5.02938f $ **FLOATING
C993 PGA__GAIN8__AMP__COMP.t3 VGND 0.80452f $ **FLOATING
C994 PGA__GAIN8__AMP__COMP.t0 VGND 73.92661f $ **FLOATING
C995 PGA__GAIN8__AMP__COMP.t1 VGND 73.54739f $ **FLOATING
C996 PGA__GAIN8__AMP__COMP.n0 VGND 2.01198f $ **FLOATING
C997 PGA__GAIN8__AMP__COMP.n1 VGND 1.87528f $ **FLOATING
C998 PGA__GAIN8__AMP__COMP.t2 VGND 52.7063f $ **FLOATING
C999 PGA__GAIN8__AMP__COMP.n2 VGND 27.4132f $ **FLOATING
C1000 PGA__GAIN8__AMP__PRE.n0 VGND 0.00933f $ **FLOATING
C1001 PGA__GAIN8__AMP__PRE.t3 VGND 40.0874f $ **FLOATING
C1002 PGA__GAIN8__AMP__PRE.t4 VGND 40.0874f $ **FLOATING
C1003 PGA__GAIN8__AMP__PRE.n1 VGND 1.10527f $ **FLOATING
C1004 PGA__GAIN8__AMP__PRE.t5 VGND 40.0874f $ **FLOATING
C1005 PGA__GAIN8__AMP__PRE.n2 VGND 0.74461f $ **FLOATING
C1006 PGA__GAIN8__AMP__PRE.t6 VGND 1.53789f $ **FLOATING
C1007 PGA__GAIN8__AMP__PRE.n3 VGND 0.65255f $ **FLOATING
C1008 PGA__GAIN8__AMP__PRE.n4 VGND 0.01301f $ **FLOATING
C1009 PGA__GAIN8__AMP__PRE.t1 VGND 0.01583f $ **FLOATING
C1010 PGA__GAIN8__AMP__PRE.n5 VGND 0.01321f $ **FLOATING
C1011 PGA__GAIN8__AMP__PRE.n6 VGND 0.90822f $ **FLOATING
C1012 PGA__GAIN8__AMP__PRE.n7 VGND 0.66234f $ **FLOATING
C1013 PGA__GAIN8__AMP__PRE.n8 VGND 0.00933f $ **FLOATING
C1014 PGA__GAIN8__AMP__PRE.t2 VGND 0.01139f $ **FLOATING
C1015 PGA__GAIN8__AMP__PRE.n9 VGND 0.00933f $ **FLOATING
C1016 PGA__GAIN8__AMP__PRE.n10 VGND 0.4168f $ **FLOATING
C1017 PGA__GAIN8__AMP__PRE.n11 VGND 1.19033f $ **FLOATING
C1018 PGA__GAIN8__AMP__PRE.n12 VGND 0.48415f $ **FLOATING
C1019 PGA__GAIN8__AMP__PRE.t0 VGND 0.01139f $ **FLOATING
C1020 PGA__GAIN8__AMP__PRE.n13 VGND 0.00933f $ **FLOATING
C1021 BIAS_SOURCE__VCM_RAW.t10 VGND 0.00956f $ **FLOATING
C1022 BIAS_SOURCE__VCM_RAW.t1 VGND 0.02342f $ **FLOATING
C1023 BIAS_SOURCE__VCM_RAW.t0 VGND 0.01441f $ **FLOATING
C1024 BIAS_SOURCE__VCM_RAW.n0 VGND 0.06055f $ **FLOATING
C1025 BIAS_SOURCE__VCM_RAW.t15 VGND 1.54844f $ **FLOATING
C1026 BIAS_SOURCE__VCM_RAW.n1 VGND 0.0331f $ **FLOATING
C1027 BIAS_SOURCE__VCM_RAW.t12 VGND 1.54844f $ **FLOATING
C1028 BIAS_SOURCE__VCM_RAW.n2 VGND 0.0321f $ **FLOATING
C1029 BIAS_SOURCE__VCM_RAW.t5 VGND 1.54844f $ **FLOATING
C1030 BIAS_SOURCE__VCM_RAW.n3 VGND 0.0321f $ **FLOATING
C1031 BIAS_SOURCE__VCM_RAW.t9 VGND 1.54844f $ **FLOATING
C1032 BIAS_SOURCE__VCM_RAW.n4 VGND 0.0321f $ **FLOATING
C1033 BIAS_SOURCE__VCM_RAW.t2 VGND 1.54844f $ **FLOATING
C1034 BIAS_SOURCE__VCM_RAW.n5 VGND 0.0321f $ **FLOATING
C1035 BIAS_SOURCE__VCM_RAW.t13 VGND 1.54844f $ **FLOATING
C1036 BIAS_SOURCE__VCM_RAW.n6 VGND 0.0321f $ **FLOATING
C1037 BIAS_SOURCE__VCM_RAW.t3 VGND 1.54844f $ **FLOATING
C1038 BIAS_SOURCE__VCM_RAW.n7 VGND 0.0321f $ **FLOATING
C1039 BIAS_SOURCE__VCM_RAW.t8 VGND 1.54844f $ **FLOATING
C1040 BIAS_SOURCE__VCM_RAW.n8 VGND 0.0321f $ **FLOATING
C1041 BIAS_SOURCE__VCM_RAW.t14 VGND 1.54844f $ **FLOATING
C1042 BIAS_SOURCE__VCM_RAW.n9 VGND 0.0321f $ **FLOATING
C1043 BIAS_SOURCE__VCM_RAW.t7 VGND 1.54844f $ **FLOATING
C1044 BIAS_SOURCE__VCM_RAW.n10 VGND 0.0321f $ **FLOATING
C1045 BIAS_SOURCE__VCM_RAW.t11 VGND 1.54844f $ **FLOATING
C1046 BIAS_SOURCE__VCM_RAW.n11 VGND 0.0321f $ **FLOATING
C1047 BIAS_SOURCE__VCM_RAW.t4 VGND 1.54844f $ **FLOATING
C1048 BIAS_SOURCE__VCM_RAW.n12 VGND 0.02803f $ **FLOATING
C1049 BIAS_SOURCE__VCM_RAW.t6 VGND 0.00956f $ **FLOATING
C1050 BIAS_SOURCE__VCM_RAW.n13 VGND 0.05809f $ **FLOATING
C1051 PGA__OUTPUT_BUFFER__FIRST__MIR.n0 VGND 0.03294f $ **FLOATING
C1052 PGA__OUTPUT_BUFFER__FIRST__MIR.t1 VGND 0.03946f $ **FLOATING
C1053 PGA__OUTPUT_BUFFER__FIRST__MIR.t4 VGND 2.00744f $ **FLOATING
C1054 PGA__OUTPUT_BUFFER__FIRST__MIR.t0 VGND 2.00744f $ **FLOATING
C1055 PGA__OUTPUT_BUFFER__FIRST__MIR.n1 VGND 2.1132f $ **FLOATING
C1056 PGA__OUTPUT_BUFFER__FIRST__MIR.n2 VGND 0.02326f $ **FLOATING
C1057 PGA__OUTPUT_BUFFER__FIRST__MIR.t3 VGND 0.0284f $ **FLOATING
C1058 PGA__OUTPUT_BUFFER__FIRST__MIR.n3 VGND 0.02326f $ **FLOATING
C1059 PGA__OUTPUT_BUFFER__FIRST__MIR.n4 VGND 1.0829f $ **FLOATING
C1060 PGA__OUTPUT_BUFFER__FIRST__MIR.n5 VGND 0.02326f $ **FLOATING
C1061 PGA__OUTPUT_BUFFER__FIRST__MIR.t2 VGND 0.0284f $ **FLOATING
C1062 PGA__OUTPUT_BUFFER__FIRST__MIR.n6 VGND 0.02326f $ **FLOATING
C1063 PGA__OUTPUT_BUFFER__FIRST__MIR.n7 VGND 1.03919f $ **FLOATING
C1064 PGA__OUTPUT_BUFFER__FIRST__MIR.n8 VGND 2.32625f $ **FLOATING
C1065 PGA__OUTPUT_BUFFER__FIRST__MIR.n9 VGND 1.26451f $ **FLOATING
C1066 PGA__OUTPUT_BUFFER__FIRST__MIR.n10 VGND 2.26443f $ **FLOATING
C1067 PGA__OUTPUT_BUFFER__FIRST__MIR.n11 VGND 0.03243f $ **FLOATING
C1068 FILTER__BUFFER0__COMP.t3 VGND 0.63708f $ **FLOATING
C1069 FILTER__BUFFER0__COMP.t0 VGND 72.466f $ **FLOATING
C1070 FILTER__BUFFER0__COMP.n0 VGND 1.63672f $ **FLOATING
C1071 FILTER__BUFFER0__COMP.t1 VGND 72.83311f $ **FLOATING
C1072 FILTER__BUFFER0__COMP.n1 VGND 1.65527f $ **FLOATING
C1073 FILTER__BUFFER0__COMP.t2 VGND 52.1899f $ **FLOATING
C1074 FILTER__BUFFER0__COMP.n2 VGND 68.1878f $ **FLOATING
C1075 FILTER__BUFFER0__PRE.n0 VGND 0.01299f $ **FLOATING
C1076 FILTER__BUFFER0__PRE.t0 VGND 0.01556f $ **FLOATING
C1077 FILTER__BUFFER0__PRE.t6 VGND 39.4027f $ **FLOATING
C1078 FILTER__BUFFER0__PRE.t3 VGND 39.4027f $ **FLOATING
C1079 FILTER__BUFFER0__PRE.n1 VGND 0.99901f $ **FLOATING
C1080 FILTER__BUFFER0__PRE.t5 VGND 39.4027f $ **FLOATING
C1081 FILTER__BUFFER0__PRE.n2 VGND 0.68717f $ **FLOATING
C1082 FILTER__BUFFER0__PRE.t4 VGND 1.51163f $ **FLOATING
C1083 FILTER__BUFFER0__PRE.n3 VGND 0.52858f $ **FLOATING
C1084 FILTER__BUFFER0__PRE.n4 VGND 0.00917f $ **FLOATING
C1085 FILTER__BUFFER0__PRE.t1 VGND 0.0112f $ **FLOATING
C1086 FILTER__BUFFER0__PRE.n5 VGND 0.00917f $ **FLOATING
C1087 FILTER__BUFFER0__PRE.n6 VGND 0.40532f $ **FLOATING
C1088 FILTER__BUFFER0__PRE.n7 VGND 0.00917f $ **FLOATING
C1089 FILTER__BUFFER0__PRE.t2 VGND 0.0112f $ **FLOATING
C1090 FILTER__BUFFER0__PRE.n8 VGND 0.00917f $ **FLOATING
C1091 FILTER__BUFFER0__PRE.n9 VGND 0.33981f $ **FLOATING
C1092 FILTER__BUFFER0__PRE.n10 VGND 1.0207f $ **FLOATING
C1093 FILTER__BUFFER0__PRE.n11 VGND 0.57604f $ **FLOATING
C1094 FILTER__BUFFER0__PRE.n12 VGND 0.82283f $ **FLOATING
C1095 FILTER__BUFFER0__PRE.n13 VGND 0.01278f $ **FLOATING
C1096 PGA__GAIN8__AMP__FIRST__TAIL.n0 VGND 0.02012f $ **FLOATING
C1097 PGA__GAIN8__AMP__FIRST__TAIL.t0 VGND 0.03278f $ **FLOATING
C1098 PGA__GAIN8__AMP__FIRST__TAIL.n1 VGND 0.02719f $ **FLOATING
C1099 PGA__GAIN8__AMP__FIRST__TAIL.t1 VGND 0.0332f $ **FLOATING
C1100 PGA__GAIN8__AMP__FIRST__TAIL.n2 VGND 0.02719f $ **FLOATING
C1101 PGA__GAIN8__AMP__FIRST__TAIL.n3 VGND 1.3259f $ **FLOATING
C1102 PGA__GAIN8__AMP__FIRST__TAIL.n4 VGND 0.02719f $ **FLOATING
C1103 PGA__GAIN8__AMP__FIRST__TAIL.t2 VGND 0.0332f $ **FLOATING
C1104 PGA__GAIN8__AMP__FIRST__TAIL.n5 VGND 0.02719f $ **FLOATING
C1105 PGA__GAIN8__AMP__FIRST__TAIL.n6 VGND 1.27412f $ **FLOATING
C1106 PGA__GAIN8__AMP__FIRST__TAIL.n7 VGND 2.61983f $ **FLOATING
C1107 PGA__GAIN8__AMP__FIRST__TAIL.n8 VGND 0.02719f $ **FLOATING
C1108 PGA__GAIN8__AMP__FIRST__TAIL.t3 VGND 0.0332f $ **FLOATING
C1109 PGA__GAIN8__AMP__FIRST__TAIL.n9 VGND 0.02719f $ **FLOATING
C1110 PGA__GAIN8__AMP__FIRST__TAIL.n10 VGND 1.27412f $ **FLOATING
C1111 PGA__GAIN8__AMP__FIRST__TAIL.n11 VGND 1.44161f $ **FLOATING
C1112 PGA__GAIN8__AMP__FIRST__TAIL.n12 VGND 0.02719f $ **FLOATING
C1113 PGA__GAIN8__AMP__FIRST__TAIL.t4 VGND 0.0332f $ **FLOATING
C1114 PGA__GAIN8__AMP__FIRST__TAIL.n13 VGND 0.02719f $ **FLOATING
C1115 PGA__GAIN8__AMP__FIRST__TAIL.n14 VGND 1.27412f $ **FLOATING
C1116 PGA__GAIN8__AMP__FIRST__TAIL.n15 VGND 3.26592f $ **FLOATING
C1117 PGA__GAIN8__AMP__FIRST__TAIL.n16 VGND 1.16773f $ **FLOATING
C1118 PGA__GAIN8__AMP__FIRST__TAIL.n17 VGND 0.0194f $ **FLOATING
C1119 BIAS.t5 VGND 0.69224f $ **FLOATING
C1120 BIAS.n0 VGND 0.03491f $ **FLOATING
C1121 BIAS.t1 VGND 0.059f $ **FLOATING
C1122 BIAS.n1 VGND 0.03621f $ **FLOATING
C1123 BIAS.n2 VGND 1.4682f $ **FLOATING
C1124 BIAS.n3 VGND 1.74215f $ **FLOATING
C1125 BIAS.t0 VGND 0.69224f $ **FLOATING
C1126 BIAS.n4 VGND 2.54429f $ **FLOATING
C1127 BIAS.t2 VGND 2.85214f $ **FLOATING
C1128 BIAS.n5 VGND 30.7282f $ **FLOATING
C1129 BIAS.t7 VGND 0.69224f $ **FLOATING
C1130 BIAS.n6 VGND 29.9453f $ **FLOATING
C1131 BIAS.t8 VGND 0.69224f $ **FLOATING
C1132 BIAS.n7 VGND 11.5033f $ **FLOATING
C1133 BIAS.t11 VGND 0.69224f $ **FLOATING
C1134 BIAS.n8 VGND 11.5033f $ **FLOATING
C1135 BIAS.t10 VGND 0.69224f $ **FLOATING
C1136 BIAS.n9 VGND 12.3171f $ **FLOATING
C1137 BIAS.t3 VGND 0.69224f $ **FLOATING
C1138 BIAS.n10 VGND 12.3171f $ **FLOATING
C1139 BIAS.t14 VGND 0.69224f $ **FLOATING
C1140 BIAS.n11 VGND 14.8879f $ **FLOATING
C1141 BIAS.t4 VGND 0.69224f $ **FLOATING
C1142 BIAS.n12 VGND 14.8879f $ **FLOATING
C1143 BIAS.t6 VGND 0.69224f $ **FLOATING
C1144 BIAS.n13 VGND 33.7118f $ **FLOATING
C1145 BIAS.t13 VGND 0.69224f $ **FLOATING
C1146 BIAS.n14 VGND 33.7118f $ **FLOATING
C1147 BIAS.t15 VGND 0.69224f $ **FLOATING
C1148 BIAS.n15 VGND 33.7118f $ **FLOATING
C1149 BIAS.t9 VGND 0.69224f $ **FLOATING
C1150 BIAS.n16 VGND 33.7118f $ **FLOATING
C1151 BIAS.t12 VGND 0.69224f $ **FLOATING
C1152 BIAS.n17 VGND 17.2143f $ **FLOATING
C1153 SAMPLE__MF.n0 VGND 0.01605f $ **FLOATING
C1154 SAMPLE__MF.n1 VGND 0.01605f $ **FLOATING
C1155 SAMPLE__MF.t3 VGND 0.03903f $ **FLOATING
C1156 SAMPLE__MF.n2 VGND 0.01605f $ **FLOATING
C1157 SAMPLE__MF.n3 VGND 1.28697f $ **FLOATING
C1158 SAMPLE__MF.n4 VGND 0.01405f $ **FLOATING
C1159 SAMPLE__MF.t2 VGND 0.04303f $ **FLOATING
C1160 SAMPLE__MF.n5 VGND 0.01405f $ **FLOATING
C1161 SAMPLE__MF.n6 VGND 1.20901f $ **FLOATING
C1162 SAMPLE__MF.n7 VGND 5.14645f $ **FLOATING
C1163 SAMPLE__MF.n8 VGND 0.01405f $ **FLOATING
C1164 SAMPLE__MF.t5 VGND 0.04303f $ **FLOATING
C1165 SAMPLE__MF.n9 VGND 0.01405f $ **FLOATING
C1166 SAMPLE__MF.n10 VGND 1.20901f $ **FLOATING
C1167 SAMPLE__MF.n11 VGND 3.45774f $ **FLOATING
C1168 SAMPLE__MF.n12 VGND 0.01605f $ **FLOATING
C1169 SAMPLE__MF.t1 VGND 0.03903f $ **FLOATING
C1170 SAMPLE__MF.n13 VGND 0.01605f $ **FLOATING
C1171 SAMPLE__MF.n14 VGND 1.28697f $ **FLOATING
C1172 SAMPLE__MF.n15 VGND 0.01405f $ **FLOATING
C1173 SAMPLE__MF.t4 VGND 0.04303f $ **FLOATING
C1174 SAMPLE__MF.n16 VGND 0.01405f $ **FLOATING
C1175 SAMPLE__MF.n17 VGND 1.20901f $ **FLOATING
C1176 SAMPLE__MF.n18 VGND 3.80136f $ **FLOATING
C1177 SAMPLE__MF.n19 VGND 2.11264f $ **FLOATING
C1178 SAMPLE__MF.n20 VGND 1.20901f $ **FLOATING
C1179 SAMPLE__MF.t0 VGND 0.03903f $ **FLOATING
C1180 SAMPLE__MF.n21 VGND 0.01605f $ **FLOATING
C1181 SAMPLE__MB.n0 VGND 0.00492f $ **FLOATING
C1182 SAMPLE__MB.t3 VGND 0.02031f $ **FLOATING
C1183 SAMPLE__MB.t2 VGND 0.02111f $ **FLOATING
C1184 SAMPLE__MB.n1 VGND 1.70409f $ **FLOATING
C1185 SAMPLE__MB.n2 VGND 0.00562f $ **FLOATING
C1186 SAMPLE__MB.t1 VGND 0.01366f $ **FLOATING
C1187 SAMPLE__MB.n3 VGND 0.00562f $ **FLOATING
C1188 SAMPLE__MB.n4 VGND 0.3857f $ **FLOATING
C1189 SAMPLE__MB.n5 VGND 1.30312f $ **FLOATING
C1190 SAMPLE__MB.n6 VGND 0.41236f $ **FLOATING
C1191 SAMPLE__MB.t0 VGND 0.01506f $ **FLOATING
C1192 SAMPLE__MB.n7 VGND 0.00492f $ **FLOATING
C1193 PGA__OUTPUT_BUFFER__PRE.n0 VGND 0.01255f $ **FLOATING
C1194 PGA__OUTPUT_BUFFER__PRE.t0 VGND 0.01504f $ **FLOATING
C1195 PGA__OUTPUT_BUFFER__PRE.t3 VGND 38.0914f $ **FLOATING
C1196 PGA__OUTPUT_BUFFER__PRE.t4 VGND 38.0914f $ **FLOATING
C1197 PGA__OUTPUT_BUFFER__PRE.n1 VGND 0.95614f $ **FLOATING
C1198 PGA__OUTPUT_BUFFER__PRE.t6 VGND 38.0914f $ **FLOATING
C1199 PGA__OUTPUT_BUFFER__PRE.n2 VGND 0.65972f $ **FLOATING
C1200 PGA__OUTPUT_BUFFER__PRE.t5 VGND 1.46132f $ **FLOATING
C1201 PGA__OUTPUT_BUFFER__PRE.n3 VGND 0.4947f $ **FLOATING
C1202 PGA__OUTPUT_BUFFER__PRE.n4 VGND 0.00887f $ **FLOATING
C1203 PGA__OUTPUT_BUFFER__PRE.t1 VGND 0.01082f $ **FLOATING
C1204 PGA__OUTPUT_BUFFER__PRE.n5 VGND 0.00887f $ **FLOATING
C1205 PGA__OUTPUT_BUFFER__PRE.n6 VGND 0.38213f $ **FLOATING
C1206 PGA__OUTPUT_BUFFER__PRE.n7 VGND 0.00887f $ **FLOATING
C1207 PGA__OUTPUT_BUFFER__PRE.t2 VGND 0.01082f $ **FLOATING
C1208 PGA__OUTPUT_BUFFER__PRE.n8 VGND 0.00887f $ **FLOATING
C1209 PGA__OUTPUT_BUFFER__PRE.n9 VGND 0.31892f $ **FLOATING
C1210 PGA__OUTPUT_BUFFER__PRE.n10 VGND 0.966f $ **FLOATING
C1211 PGA__OUTPUT_BUFFER__PRE.n11 VGND 0.54645f $ **FLOATING
C1212 PGA__OUTPUT_BUFFER__PRE.n12 VGND 0.78587f $ **FLOATING
C1213 PGA__OUTPUT_BUFFER__PRE.n13 VGND 0.01236f $ **FLOATING
C1214 OUT.t3 VGND 2.31441f $ **FLOATING
C1215 OUT.t1 VGND 2.40961f $ **FLOATING
C1216 OUT.n0 VGND 11.3387f $ **FLOATING
C1217 OUT.n1 VGND 0.03679f $ **FLOATING
C1218 OUT.t0 VGND 0.05994f $ **FLOATING
C1219 OUT.n2 VGND 0.03547f $ **FLOATING
C1220 OUT.n3 VGND 1.38363f $ **FLOATING
C1221 OUT.n4 VGND 7.8399f $ **FLOATING
C1222 OUT.n5 VGND 0.75806f $ **FLOATING
C1223 OUT.t2 VGND 0.75304f $ **FLOATING
C1224 OUT.n6 VGND 3.27873f $ **FLOATING
C1225 OUT.n7 VGND 0.29496f $ **FLOATING
C1226 OUT.n8 VGND 3.2301f $ **FLOATING
C1227 OUT.n9 VGND 3.64129f $ **FLOATING
C1228 OUT.t4 VGND 1.31876f $ **FLOATING
C1229 OUT.n10 VGND 4.07867f $ **FLOATING
C1230 OUT.n11 VGND 0.12593p $ **FLOATING
C1231 OUT.t5 VGND 1.31876f $ **FLOATING
C1232 FILTER__BUFFER1__COMP.t3 VGND 72.83311f $ **FLOATING
C1233 FILTER__BUFFER1__COMP.t1 VGND 72.466f $ **FLOATING
C1234 FILTER__BUFFER1__COMP.n0 VGND 1.76115f $ **FLOATING
C1235 FILTER__BUFFER1__COMP.t2 VGND 72.466f $ **FLOATING
C1236 FILTER__BUFFER1__COMP.n1 VGND 1.63672f $ **FLOATING
C1237 FILTER__BUFFER1__COMP.t0 VGND 0.63707f $ **FLOATING
C1238 FILTER__BUFFER1__FIRST__TAIL.n0 VGND 0.02681f $ **FLOATING
C1239 FILTER__BUFFER1__FIRST__TAIL.n1 VGND 0.01984f $ **FLOATING
C1240 FILTER__BUFFER1__FIRST__TAIL.t4 VGND 0.03233f $ **FLOATING
C1241 FILTER__BUFFER1__FIRST__TAIL.n2 VGND 0.01913f $ **FLOATING
C1242 FILTER__BUFFER1__FIRST__TAIL.n3 VGND 1.09225f $ **FLOATING
C1243 FILTER__BUFFER1__FIRST__TAIL.n4 VGND 0.02681f $ **FLOATING
C1244 FILTER__BUFFER1__FIRST__TAIL.t3 VGND 0.03274f $ **FLOATING
C1245 FILTER__BUFFER1__FIRST__TAIL.n5 VGND 0.02681f $ **FLOATING
C1246 FILTER__BUFFER1__FIRST__TAIL.n6 VGND 1.19775f $ **FLOATING
C1247 FILTER__BUFFER1__FIRST__TAIL.n7 VGND 3.09682f $ **FLOATING
C1248 FILTER__BUFFER1__FIRST__TAIL.n8 VGND 0.02681f $ **FLOATING
C1249 FILTER__BUFFER1__FIRST__TAIL.t1 VGND 0.03274f $ **FLOATING
C1250 FILTER__BUFFER1__FIRST__TAIL.n9 VGND 0.02681f $ **FLOATING
C1251 FILTER__BUFFER1__FIRST__TAIL.n10 VGND 1.19775f $ **FLOATING
C1252 FILTER__BUFFER1__FIRST__TAIL.n11 VGND 1.35942f $ **FLOATING
C1253 FILTER__BUFFER1__FIRST__TAIL.n12 VGND 0.02681f $ **FLOATING
C1254 FILTER__BUFFER1__FIRST__TAIL.t2 VGND 0.03274f $ **FLOATING
C1255 FILTER__BUFFER1__FIRST__TAIL.n13 VGND 0.02681f $ **FLOATING
C1256 FILTER__BUFFER1__FIRST__TAIL.n14 VGND 1.24814f $ **FLOATING
C1257 FILTER__BUFFER1__FIRST__TAIL.n15 VGND 2.45978f $ **FLOATING
C1258 FILTER__BUFFER1__FIRST__TAIL.n16 VGND 1.19775f $ **FLOATING
C1259 FILTER__BUFFER1__FIRST__TAIL.t0 VGND 0.03274f $ **FLOATING
C1260 FILTER__BUFFER1__FIRST__TAIL.n17 VGND 0.02681f $ **FLOATING
C1261 FILTER__BUFFER1__PRE.n0 VGND 0.01309f $ **FLOATING
C1262 FILTER__BUFFER1__PRE.t0 VGND 0.01568f $ **FLOATING
C1263 FILTER__BUFFER1__PRE.t5 VGND 39.7127f $ **FLOATING
C1264 FILTER__BUFFER1__PRE.t6 VGND 39.7127f $ **FLOATING
C1265 FILTER__BUFFER1__PRE.n1 VGND 1.00687f $ **FLOATING
C1266 FILTER__BUFFER1__PRE.t4 VGND 39.7127f $ **FLOATING
C1267 FILTER__BUFFER1__PRE.n2 VGND 0.69257f $ **FLOATING
C1268 FILTER__BUFFER1__PRE.t3 VGND 1.52352f $ **FLOATING
C1269 FILTER__BUFFER1__PRE.n3 VGND 0.53274f $ **FLOATING
C1270 FILTER__BUFFER1__PRE.n4 VGND 0.00924f $ **FLOATING
C1271 FILTER__BUFFER1__PRE.t2 VGND 0.01129f $ **FLOATING
C1272 FILTER__BUFFER1__PRE.n5 VGND 0.00924f $ **FLOATING
C1273 FILTER__BUFFER1__PRE.n6 VGND 0.40851f $ **FLOATING
C1274 FILTER__BUFFER1__PRE.n7 VGND 0.00924f $ **FLOATING
C1275 FILTER__BUFFER1__PRE.t1 VGND 0.01129f $ **FLOATING
C1276 FILTER__BUFFER1__PRE.n8 VGND 0.00924f $ **FLOATING
C1277 FILTER__BUFFER1__PRE.n9 VGND 0.34248f $ **FLOATING
C1278 FILTER__BUFFER1__PRE.n10 VGND 1.02873f $ **FLOATING
C1279 FILTER__BUFFER1__PRE.n11 VGND 0.58057f $ **FLOATING
C1280 FILTER__BUFFER1__PRE.n12 VGND 0.82931f $ **FLOATING
C1281 FILTER__BUFFER1__PRE.n13 VGND 0.01288f $ **FLOATING
C1282 CMP.n0 VGND 0.01048f $ **FLOATING
C1283 CMP.n1 VGND 0.02159f $ **FLOATING
C1284 CMP.t2 VGND 0.11243f $ **FLOATING
C1285 CMP.n2 VGND 0.34848f $ **FLOATING
C1286 CMP.n3 VGND 0.07238f $ **FLOATING
C1287 CMP.n4 VGND 1.39278f $ **FLOATING
C1288 CMP.n5 VGND 0.02558f $ **FLOATING
C1289 CMP.t3 VGND 0.05622f $ **FLOATING
C1290 CMP.n6 VGND 0.17593f $ **FLOATING
C1291 CMP.n7 VGND 0.00791f $ **FLOATING
C1292 CMP.n8 VGND 1.08694f $ **FLOATING
C1293 CMP.n9 VGND 3.38587f $ **FLOATING
C1294 CMP.n10 VGND 0.01197f $ **FLOATING
C1295 CMP.t1 VGND 0.02911f $ **FLOATING
C1296 CMP.n11 VGND 0.01197f $ **FLOATING
C1297 CMP.n12 VGND 0.86186f $ **FLOATING
C1298 CMP.n13 VGND 3.38587f $ **FLOATING
C1299 CMP.n14 VGND 0.91937f $ **FLOATING
C1300 CMP.t0 VGND 0.03209f $ **FLOATING
C1301 CMP.n15 VGND 0.01048f $ **FLOATING
C1302 COMPARATOR__PRE.n0 VGND 0.03467f $ **FLOATING
C1303 COMPARATOR__PRE.t0 VGND 0.04154f $ **FLOATING
C1304 COMPARATOR__PRE.t2 VGND 0.07423f $ **FLOATING
C1305 COMPARATOR__PRE.t3 VGND 0.13244f $ **FLOATING
C1306 COMPARATOR__PRE.n1 VGND 2.43122f $ **FLOATING
C1307 COMPARATOR__PRE.n2 VGND 0.01691f $ **FLOATING
C1308 COMPARATOR__PRE.t1 VGND 0.09274f $ **FLOATING
C1309 COMPARATOR__PRE.n3 VGND 0.31633f $ **FLOATING
C1310 COMPARATOR__PRE.n4 VGND 0.05583f $ **FLOATING
C1311 COMPARATOR__PRE.n5 VGND 1.09005f $ **FLOATING
C1312 COMPARATOR__PRE.n6 VGND 2.73999f $ **FLOATING
C1313 COMPARATOR__PRE.n7 VGND 2.17069f $ **FLOATING
C1314 COMPARATOR__PRE.n8 VGND 0.03414f $ **FLOATING
C1315 FILTER__FILTER1.t2 VGND 0.0048f $ **FLOATING
C1316 FILTER__FILTER1.t0 VGND 0.01552f $ **FLOATING
C1317 FILTER__FILTER1.t1 VGND 0.77786f $ **FLOATING
C1318 FILTER__FILTER1.n0 VGND 0.02265f $ **FLOATING
C1319 FILTER__FILTER1.t10 VGND 0.77786f $ **FLOATING
C1320 FILTER__FILTER1.n1 VGND 0.01515f $ **FLOATING
C1321 FILTER__FILTER1.t7 VGND 0.77786f $ **FLOATING
C1322 FILTER__FILTER1.n2 VGND 0.01515f $ **FLOATING
C1323 FILTER__FILTER1.t3 VGND 0.77786f $ **FLOATING
C1324 FILTER__FILTER1.n3 VGND 0.01515f $ **FLOATING
C1325 FILTER__FILTER1.t5 VGND 0.77786f $ **FLOATING
C1326 FILTER__FILTER1.n4 VGND 0.01515f $ **FLOATING
C1327 FILTER__FILTER1.t14 VGND 0.77786f $ **FLOATING
C1328 FILTER__FILTER1.n5 VGND 0.01515f $ **FLOATING
C1329 FILTER__FILTER1.t8 VGND 0.77786f $ **FLOATING
C1330 FILTER__FILTER1.n6 VGND 0.01515f $ **FLOATING
C1331 FILTER__FILTER1.t6 VGND 0.77786f $ **FLOATING
C1332 FILTER__FILTER1.n7 VGND 0.01515f $ **FLOATING
C1333 FILTER__FILTER1.t11 VGND 0.77786f $ **FLOATING
C1334 FILTER__FILTER1.n8 VGND 0.01515f $ **FLOATING
C1335 FILTER__FILTER1.t12 VGND 0.77786f $ **FLOATING
C1336 FILTER__FILTER1.n9 VGND 0.01515f $ **FLOATING
C1337 FILTER__FILTER1.t9 VGND 0.77786f $ **FLOATING
C1338 FILTER__FILTER1.n10 VGND 0.01515f $ **FLOATING
C1339 FILTER__FILTER1.t13 VGND 0.77786f $ **FLOATING
C1340 FILTER__FILTER1.n11 VGND 0.0131f $ **FLOATING
C1341 FILTER__FILTER1.t4 VGND 0.0048f $ **FLOATING
C1342 FILTER__FILTER1.n12 VGND 0.02476f $ **FLOATING
C1343 PGA__OUTPUT_BUFFER__COMP.t2 VGND 0.66644f $ **FLOATING
C1344 PGA__OUTPUT_BUFFER__COMP.t3 VGND 74.014f $ **FLOATING
C1345 PGA__OUTPUT_BUFFER__COMP.n0 VGND 1.69964f $ **FLOATING
C1346 PGA__OUTPUT_BUFFER__COMP.t1 VGND 74.014f $ **FLOATING
C1347 PGA__OUTPUT_BUFFER__COMP.n1 VGND 1.76024f $ **FLOATING
C1348 PGA__OUTPUT_BUFFER__COMP.t0 VGND 53.2764f $ **FLOATING
C1349 PGA__OUTPUT_BUFFER__COMP.n2 VGND 0.11222p $ **FLOATING
C1350 FILTER__BUFFER0__FIRST__MIR.n0 VGND 0.03523f $ **FLOATING
C1351 FILTER__BUFFER0__FIRST__MIR.t1 VGND 0.0422f $ **FLOATING
C1352 FILTER__BUFFER0__FIRST__MIR.t4 VGND 2.147f $ **FLOATING
C1353 FILTER__BUFFER0__FIRST__MIR.t0 VGND 2.147f $ **FLOATING
C1354 FILTER__BUFFER0__FIRST__MIR.n1 VGND 2.33792f $ **FLOATING
C1355 FILTER__BUFFER0__FIRST__MIR.n2 VGND 0.02488f $ **FLOATING
C1356 FILTER__BUFFER0__FIRST__MIR.t2 VGND 0.03038f $ **FLOATING
C1357 FILTER__BUFFER0__FIRST__MIR.n3 VGND 0.02488f $ **FLOATING
C1358 FILTER__BUFFER0__FIRST__MIR.n4 VGND 1.18575f $ **FLOATING
C1359 FILTER__BUFFER0__FIRST__MIR.n5 VGND 0.02488f $ **FLOATING
C1360 FILTER__BUFFER0__FIRST__MIR.t3 VGND 0.03038f $ **FLOATING
C1361 FILTER__BUFFER0__FIRST__MIR.n6 VGND 0.02488f $ **FLOATING
C1362 FILTER__BUFFER0__FIRST__MIR.n7 VGND 1.13868f $ **FLOATING
C1363 FILTER__BUFFER0__FIRST__MIR.n8 VGND 2.54545f $ **FLOATING
C1364 FILTER__BUFFER0__FIRST__MIR.n9 VGND 1.38132f $ **FLOATING
C1365 FILTER__BUFFER0__FIRST__MIR.n10 VGND 2.4491f $ **FLOATING
C1366 FILTER__BUFFER0__FIRST__MIR.n11 VGND 0.03468f $ **FLOATING
C1367 FILTER__FILTER0.t4 VGND 0.00475f $ **FLOATING
C1368 FILTER__FILTER0.t0 VGND 0.01536f $ **FLOATING
C1369 FILTER__FILTER0.t3 VGND 0.76954f $ **FLOATING
C1370 FILTER__FILTER0.n0 VGND 0.02241f $ **FLOATING
C1371 FILTER__FILTER0.t9 VGND 0.76954f $ **FLOATING
C1372 FILTER__FILTER0.n1 VGND 0.01499f $ **FLOATING
C1373 FILTER__FILTER0.t7 VGND 0.76954f $ **FLOATING
C1374 FILTER__FILTER0.n2 VGND 0.01499f $ **FLOATING
C1375 FILTER__FILTER0.t11 VGND 0.76954f $ **FLOATING
C1376 FILTER__FILTER0.n3 VGND 0.01499f $ **FLOATING
C1377 FILTER__FILTER0.t13 VGND 0.76954f $ **FLOATING
C1378 FILTER__FILTER0.n4 VGND 0.01499f $ **FLOATING
C1379 FILTER__FILTER0.t1 VGND 0.76954f $ **FLOATING
C1380 FILTER__FILTER0.n5 VGND 0.01499f $ **FLOATING
C1381 FILTER__FILTER0.t14 VGND 0.76954f $ **FLOATING
C1382 FILTER__FILTER0.n6 VGND 0.01499f $ **FLOATING
C1383 FILTER__FILTER0.t5 VGND 0.76954f $ **FLOATING
C1384 FILTER__FILTER0.n7 VGND 0.01499f $ **FLOATING
C1385 FILTER__FILTER0.t10 VGND 0.76954f $ **FLOATING
C1386 FILTER__FILTER0.n8 VGND 0.01499f $ **FLOATING
C1387 FILTER__FILTER0.t2 VGND 0.76954f $ **FLOATING
C1388 FILTER__FILTER0.n9 VGND 0.01499f $ **FLOATING
C1389 FILTER__FILTER0.t8 VGND 0.76954f $ **FLOATING
C1390 FILTER__FILTER0.n10 VGND 0.01499f $ **FLOATING
C1391 FILTER__FILTER0.t12 VGND 0.76954f $ **FLOATING
C1392 FILTER__FILTER0.n11 VGND 0.01296f $ **FLOATING
C1393 FILTER__FILTER0.t6 VGND 0.00475f $ **FLOATING
C1394 FILTER__FILTER0.n12 VGND 0.02449f $ **FLOATING
C1395 AMPLIFIED.n0 VGND 0.01361f $ **FLOATING
C1396 AMPLIFIED.t0 VGND 0.02217f $ **FLOATING
C1397 AMPLIFIED.t1 VGND 0.74015f $ **FLOATING
C1398 AMPLIFIED.t2 VGND 1.02611f $ **FLOATING
C1399 AMPLIFIED.n1 VGND 4.42359f $ **FLOATING
C1400 AMPLIFIED.t5 VGND 0.48777f $ **FLOATING
C1401 AMPLIFIED.t4 VGND 0.48777f $ **FLOATING
C1402 AMPLIFIED.n2 VGND 2.70406f $ **FLOATING
C1403 AMPLIFIED.n3 VGND 0.28038f $ **FLOATING
C1404 AMPLIFIED.t3 VGND 0.27852f $ **FLOATING
C1405 AMPLIFIED.n4 VGND 1.21269f $ **FLOATING
C1406 AMPLIFIED.n5 VGND 0.10909f $ **FLOATING
C1407 AMPLIFIED.n6 VGND 1.33502f $ **FLOATING
C1408 AMPLIFIED.n7 VGND 1.49692f $ **FLOATING
C1409 AMPLIFIED.n8 VGND 3.04984f $ **FLOATING
C1410 AMPLIFIED.n9 VGND 0.65207f $ **FLOATING
C1411 AMPLIFIED.n10 VGND 0.01312f $ **FLOATING
rmesh_equiv_0 amplified amplified.n0 19.837
rmesh_equiv_1 amplified amplified.n10 4.2590000000000003
rmesh_equiv_10 amplified.n1 amplified.t1 26.082799999999999
rmesh_equiv_100 bias_source__vcm_buffer__first__mir.n6 bias_source__vcm_buffer__first__mir.t1 174.857
rmesh_equiv_1000 pga__output_buffer__first__mir.n6 pga__output_buffer__first__mir.n7 5.2415200000000004
rmesh_equiv_1001 pga__output_buffer__first__mir.n6 pga__output_buffer__first__mir.t2 174.857
rmesh_equiv_1002 pga__output_buffer__first__mir.n7 pga__output_buffer__first__mir.n8 19.887899999999998
rmesh_equiv_1003 pga__output_buffer__first__mir.n8 pga__output_buffer__first__mir.n9 1.83996
rmesh_equiv_1004 pga__output_buffer__first__tail pga__output_buffer__first__tail.n0 19.837
rmesh_equiv_1005 pga__output_buffer__first__tail pga__output_buffer__first__tail.n1 15.6333
rmesh_equiv_1006 pga__output_buffer__first__tail pga__output_buffer__first__tail.n12 15.6333
rmesh_equiv_1007 pga__output_buffer__first__tail pga__output_buffer__first__tail.n13 15.6333
rmesh_equiv_1008 pga__output_buffer__first__tail pga__output_buffer__first__tail.n17 4.2590000000000003
rmesh_equiv_1009 pga__output_buffer__first__tail pga__output_buffer__first__tail.n2 15.6333
rmesh_equiv_101 bias_source__vcm_buffer__first__mir.n7 bias_source__vcm_buffer__first__mir.n8 5.2415200000000004
rmesh_equiv_1010 pga__output_buffer__first__tail pga__output_buffer__first__tail.n4 15.6333
rmesh_equiv_1011 pga__output_buffer__first__tail pga__output_buffer__first__tail.n5 15.6333
rmesh_equiv_1012 pga__output_buffer__first__tail pga__output_buffer__first__tail.n8 15.6333
rmesh_equiv_1013 pga__output_buffer__first__tail pga__output_buffer__first__tail.n9 15.6333
rmesh_equiv_1014 pga__output_buffer__first__tail.n0 pga__output_buffer__first__tail.n16 14.189499999999999
rmesh_equiv_1015 pga__output_buffer__first__tail.n0 pga__output_buffer__first__tail.t0 174.91200000000001
rmesh_equiv_1016 pga__output_buffer__first__tail.n1 pga__output_buffer__first__tail.n3 5.2415200000000004
rmesh_equiv_1017 pga__output_buffer__first__tail.n1 pga__output_buffer__first__tail.t1 174.857
rmesh_equiv_1018 pga__output_buffer__first__tail.n10 pga__output_buffer__first__tail.n11 16.9712
rmesh_equiv_1019 pga__output_buffer__first__tail.n10 pga__output_buffer__first__tail.n8 5.2415200000000004
rmesh_equiv_102 bias_source__vcm_buffer__first__mir.n7 bias_source__vcm_buffer__first__mir.t1 174.857
rmesh_equiv_1020 pga__output_buffer__first__tail.n10 pga__output_buffer__first__tail.n9 5.2415200000000004
rmesh_equiv_1021 pga__output_buffer__first__tail.n11 pga__output_buffer__first__tail.n15 0.91112499999999996
rmesh_equiv_1022 pga__output_buffer__first__tail.n11 pga__output_buffer__first__tail.n7 0.91112499999999996
rmesh_equiv_1023 pga__output_buffer__first__tail.n12 pga__output_buffer__first__tail.n14 5.2415200000000004
rmesh_equiv_1024 pga__output_buffer__first__tail.n12 pga__output_buffer__first__tail.t2 174.857
rmesh_equiv_1025 pga__output_buffer__first__tail.n13 pga__output_buffer__first__tail.n14 5.2415200000000004
rmesh_equiv_1026 pga__output_buffer__first__tail.n13 pga__output_buffer__first__tail.t2 174.857
rmesh_equiv_1027 pga__output_buffer__first__tail.n14 pga__output_buffer__first__tail.n15 16.9712
rmesh_equiv_1028 pga__output_buffer__first__tail.n15 pga__output_buffer__first__tail.n16 19.470400000000001
rmesh_equiv_1029 pga__output_buffer__first__tail.n16 pga__output_buffer__first__tail.n17 3.0467200000000001
rmesh_equiv_103 bias_source__vcm_buffer__first__mir.n8 bias_source__vcm_buffer__first__mir.n9 22.048500000000001
rmesh_equiv_1030 pga__output_buffer__first__tail.n17 pga__output_buffer__first__tail.t0 181.41
rmesh_equiv_1031 pga__output_buffer__first__tail.n2 pga__output_buffer__first__tail.n3 5.2415200000000004
rmesh_equiv_1032 pga__output_buffer__first__tail.n2 pga__output_buffer__first__tail.t1 174.857
rmesh_equiv_1033 pga__output_buffer__first__tail.n3 pga__output_buffer__first__tail.n7 17.881799999999998
rmesh_equiv_1034 pga__output_buffer__first__tail.n4 pga__output_buffer__first__tail.n6 5.2415200000000004
rmesh_equiv_1035 pga__output_buffer__first__tail.n4 pga__output_buffer__first__tail.t3 174.857
rmesh_equiv_1036 pga__output_buffer__first__tail.n5 pga__output_buffer__first__tail.n6 5.2415200000000004
rmesh_equiv_1037 pga__output_buffer__first__tail.n5 pga__output_buffer__first__tail.t3 174.857
rmesh_equiv_1038 pga__output_buffer__first__tail.n6 pga__output_buffer__first__tail.n7 16.9712
rmesh_equiv_1039 pga__output_buffer__first__tail.n8 pga__output_buffer__first__tail.t4 174.857
rmesh_equiv_104 bias_source__vcm_buffer__first__tail bias_source__vcm_buffer__first__tail.n0 19.837
rmesh_equiv_1040 pga__output_buffer__first__tail.n9 pga__output_buffer__first__tail.t4 174.857
rmesh_equiv_1041 pga__output_buffer__pre pga__output_buffer__pre.n0 22.8553
rmesh_equiv_1042 pga__output_buffer__pre pga__output_buffer__pre.n1 2.8857728963292746
rmesh_equiv_1043 pga__output_buffer__pre pga__output_buffer__pre.n13 4.8770699999999998
rmesh_equiv_1044 pga__output_buffer__pre pga__output_buffer__pre.n2 4.3646000000000003
rmesh_equiv_1045 pga__output_buffer__pre pga__output_buffer__pre.n3 26.3826
rmesh_equiv_1046 pga__output_buffer__pre pga__output_buffer__pre.n4 15.6333
rmesh_equiv_1047 pga__output_buffer__pre pga__output_buffer__pre.n5 15.6333
rmesh_equiv_1048 pga__output_buffer__pre pga__output_buffer__pre.n7 15.6333
rmesh_equiv_1049 pga__output_buffer__pre pga__output_buffer__pre.n8 15.6333
rmesh_equiv_105 bias_source__vcm_buffer__first__tail bias_source__vcm_buffer__first__tail.n1 15.6333
rmesh_equiv_1050 pga__output_buffer__pre pga__output_buffer__pre.t3 0.00141837
rmesh_equiv_1051 pga__output_buffer__pre pga__output_buffer__pre.t4 0.00141837
rmesh_equiv_1052 pga__output_buffer__pre pga__output_buffer__pre.t5 1054.8499999999999
rmesh_equiv_1053 pga__output_buffer__pre pga__output_buffer__pre.t6 0.00141837
rmesh_equiv_1054 pga__output_buffer__pre.n0 pga__output_buffer__pre.n12 11.4361
rmesh_equiv_1055 pga__output_buffer__pre.n0 pga__output_buffer__pre.t0 381.113
rmesh_equiv_1056 pga__output_buffer__pre.n1 pga__output_buffer__pre.n2 4.1529499999999997
rmesh_equiv_1057 pga__output_buffer__pre.n10 pga__output_buffer__pre.n11 1.8528899999999999
rmesh_equiv_1058 pga__output_buffer__pre.n10 pga__output_buffer__pre.n6 19.309899999999999
rmesh_equiv_1059 pga__output_buffer__pre.n10 pga__output_buffer__pre.n9 16.554500000000001
rmesh_equiv_106 bias_source__vcm_buffer__first__tail bias_source__vcm_buffer__first__tail.n12 15.6333
rmesh_equiv_1060 pga__output_buffer__pre.n11 pga__output_buffer__pre.n12 16.554500000000001
rmesh_equiv_1061 pga__output_buffer__pre.n11 pga__output_buffer__pre.n3 2.2512099999999999
rmesh_equiv_1062 pga__output_buffer__pre.n12 pga__output_buffer__pre.n13 2.4407800000000002
rmesh_equiv_1063 pga__output_buffer__pre.n13 pga__output_buffer__pre.t0 387.11000000000001
rmesh_equiv_1064 pga__output_buffer__pre.n2 pga__output_buffer__pre.n3 3.1113099999999996
rmesh_equiv_1065 pga__output_buffer__pre.n4 pga__output_buffer__pre.n6 5.2415200000000004
rmesh_equiv_1066 pga__output_buffer__pre.n4 pga__output_buffer__pre.t1 174.857
rmesh_equiv_1067 pga__output_buffer__pre.n5 pga__output_buffer__pre.n6 5.2415200000000004
rmesh_equiv_1068 pga__output_buffer__pre.n5 pga__output_buffer__pre.t1 174.857
rmesh_equiv_1069 pga__output_buffer__pre.n7 pga__output_buffer__pre.n9 5.2415200000000004
rmesh_equiv_107 bias_source__vcm_buffer__first__tail bias_source__vcm_buffer__first__tail.n13 15.6333
rmesh_equiv_1070 pga__output_buffer__pre.n7 pga__output_buffer__pre.t2 174.857
rmesh_equiv_1071 pga__output_buffer__pre.n8 pga__output_buffer__pre.n9 5.2415200000000004
rmesh_equiv_1072 pga__output_buffer__pre.n8 pga__output_buffer__pre.t2 174.857
rmesh_equiv_1073 pga__selected pga__selected.n0 22.8553
rmesh_equiv_1074 pga__selected pga__selected.n1 18.984538042952209
rmesh_equiv_1075 pga__selected pga__selected.n10 20.370899999999999
rmesh_equiv_1076 pga__selected pga__selected.n15 4.8770699999999998
rmesh_equiv_1077 pga__selected pga__selected.n2 4.39276
rmesh_equiv_1078 pga__selected pga__selected.n3 20.370899999999999
rmesh_equiv_1079 pga__selected pga__selected.n5 4.8770699999999998
rmesh_equiv_108 bias_source__vcm_buffer__first__tail bias_source__vcm_buffer__first__tail.n17 4.2590000000000003
rmesh_equiv_1080 pga__selected pga__selected.n6 22.8553
rmesh_equiv_1081 pga__selected pga__selected.n9 4.39276
rmesh_equiv_1082 pga__selected pga__selected.t4 212.21199999999999
rmesh_equiv_1083 pga__selected pga__selected.t5 212.21199999999999
rmesh_equiv_1084 pga__selected.n0 pga__selected.n14 11.4361
rmesh_equiv_1085 pga__selected.n0 pga__selected.t0 381.113
rmesh_equiv_1086 pga__selected.n1 pga__selected.n13 0.99043700000000001
rmesh_equiv_1087 pga__selected.n10 pga__selected.n11 13.4665
rmesh_equiv_1088 pga__selected.n10 pga__selected.t3 172.06
rmesh_equiv_1089 pga__selected.n11 pga__selected.n12 21.0337
rmesh_equiv_109 bias_source__vcm_buffer__first__tail bias_source__vcm_buffer__first__tail.n2 15.6333
rmesh_equiv_1090 pga__selected.n11 pga__selected.n9 2.90421
rmesh_equiv_1091 pga__selected.n12 pga__selected.n13 0.81771300000000002
rmesh_equiv_1092 pga__selected.n12 pga__selected.n8 0.81771300000000002
rmesh_equiv_1093 pga__selected.n13 pga__selected.n14 21.0337
rmesh_equiv_1094 pga__selected.n14 pga__selected.n15 2.4407800000000002
rmesh_equiv_1095 pga__selected.n15 pga__selected.t0 387.11000000000001
rmesh_equiv_1096 pga__selected.n2 pga__selected.n4 2.90421
rmesh_equiv_1097 pga__selected.n2 pga__selected.t1 178.41800000000001
rmesh_equiv_1098 pga__selected.n3 pga__selected.n4 13.4665
rmesh_equiv_1099 pga__selected.n3 pga__selected.t1 172.06
rmesh_equiv_11 amplified.n1 amplified.t2 32.260399999999997
rmesh_equiv_110 bias_source__vcm_buffer__first__tail bias_source__vcm_buffer__first__tail.n4 15.6333
rmesh_equiv_1100 pga__selected.n4 pga__selected.n8 21.850899999999999
rmesh_equiv_1101 pga__selected.n5 pga__selected.n7 2.4407800000000002
rmesh_equiv_1102 pga__selected.n5 pga__selected.t2 387.11000000000001
rmesh_equiv_1103 pga__selected.n6 pga__selected.n7 11.4361
rmesh_equiv_1104 pga__selected.n6 pga__selected.t2 381.113
rmesh_equiv_1105 pga__selected.n7 pga__selected.n8 21.0337
rmesh_equiv_1106 pga__selected.n9 pga__selected.t3 178.41800000000001
rmesh_equiv_1107 pga__v2 pga__v2.n0 19.837
rmesh_equiv_1108 pga__v2 pga__v2.n1 4.8770699999999998
rmesh_equiv_1109 pga__v2 pga__v2.n10 33.9895
rmesh_equiv_111 bias_source__vcm_buffer__first__tail bias_source__vcm_buffer__first__tail.n5 15.6333
rmesh_equiv_1110 pga__v2 pga__v2.n12 6.9688099999999995
rmesh_equiv_1111 pga__v2 pga__v2.n16 4.2590000000000003
rmesh_equiv_1112 pga__v2 pga__v2.n2 22.8553
rmesh_equiv_1113 pga__v2 pga__v2.n4 4.39276
rmesh_equiv_1114 pga__v2 pga__v2.n5 20.370899999999999
rmesh_equiv_1115 pga__v2.n0 pga__v2.n15 14.189499999999999
rmesh_equiv_1116 pga__v2.n0 pga__v2.t0 174.91200000000001
rmesh_equiv_1117 pga__v2.n1 pga__v2.n3 2.4407800000000002
rmesh_equiv_1118 pga__v2.n1 pga__v2.t5 387.11000000000001
rmesh_equiv_1119 pga__v2.n10 pga__v2.n11 13.2728
rmesh_equiv_112 bias_source__vcm_buffer__first__tail bias_source__vcm_buffer__first__tail.n8 15.6333
rmesh_equiv_1120 pga__v2.n10 pga__v2.n13 0.51338700000000004
rmesh_equiv_1121 pga__v2.n11 pga__v2.n12 13.200100000000001
rmesh_equiv_1122 pga__v2.n11 pga__v2.t2 0.71462499999999995
rmesh_equiv_1123 pga__v2.n12 pga__v2.n13 0.27270899999999998
rmesh_equiv_1124 pga__v2.n13 pga__v2.n14 21.221599999999999
rmesh_equiv_1125 pga__v2.n14 pga__v2.n15 20.304500000000001
rmesh_equiv_1126 pga__v2.n14 pga__v2.n9 13.727399999999999
rmesh_equiv_1127 pga__v2.n15 pga__v2.n16 3.0467200000000001
rmesh_equiv_1128 pga__v2.n16 pga__v2.t0 181.41
rmesh_equiv_1129 pga__v2.n2 pga__v2.n3 11.4361
rmesh_equiv_113 bias_source__vcm_buffer__first__tail bias_source__vcm_buffer__first__tail.n9 15.6333
rmesh_equiv_1130 pga__v2.n2 pga__v2.t5 381.113
rmesh_equiv_1131 pga__v2.n3 pga__v2.n7 21.434200000000001
rmesh_equiv_1132 pga__v2.n4 pga__v2.n6 2.90421
rmesh_equiv_1133 pga__v2.n4 pga__v2.t3 178.41800000000001
rmesh_equiv_1134 pga__v2.n5 pga__v2.n6 13.4665
rmesh_equiv_1135 pga__v2.n5 pga__v2.t3 172.06
rmesh_equiv_1136 pga__v2.n6 pga__v2.n7 20.617000000000001
rmesh_equiv_1137 pga__v2.n7 pga__v2.n8 27.134799999999998
rmesh_equiv_1138 pga__v2.n8 pga__v2.n9 1.57735
rmesh_equiv_1139 pga__v2.n8 pga__v2.t4 29.113099999999999
rmesh_equiv_114 bias_source__vcm_buffer__first__tail.n0 bias_source__vcm_buffer__first__tail.n16 14.189499999999999
rmesh_equiv_1140 pga__v2.n9 pga__v2.t1 32.260399999999997
rmesh_equiv_1141 pga__v8 pga__v8.n0 19.837
rmesh_equiv_1142 pga__v8 pga__v8.n1 4.8770699999999998
rmesh_equiv_1143 pga__v8 pga__v8.n10 33.9895
rmesh_equiv_1144 pga__v8 pga__v8.n12 6.9688099999999995
rmesh_equiv_1145 pga__v8 pga__v8.n16 4.2590000000000003
rmesh_equiv_1146 pga__v8 pga__v8.n2 22.8553
rmesh_equiv_1147 pga__v8 pga__v8.n4 4.39276
rmesh_equiv_1148 pga__v8 pga__v8.n5 20.370899999999999
rmesh_equiv_1149 pga__v8.n0 pga__v8.n15 14.189499999999999
rmesh_equiv_115 bias_source__vcm_buffer__first__tail.n0 bias_source__vcm_buffer__first__tail.t0 174.91200000000001
rmesh_equiv_1150 pga__v8.n0 pga__v8.t0 174.91200000000001
rmesh_equiv_1151 pga__v8.n1 pga__v8.n3 2.4407800000000002
rmesh_equiv_1152 pga__v8.n1 pga__v8.t2 387.11000000000001
rmesh_equiv_1153 pga__v8.n10 pga__v8.n11 13.2728
rmesh_equiv_1154 pga__v8.n10 pga__v8.n13 0.51338700000000004
rmesh_equiv_1155 pga__v8.n11 pga__v8.n12 13.200100000000001
rmesh_equiv_1156 pga__v8.n11 pga__v8.t1 0.71462499999999995
rmesh_equiv_1157 pga__v8.n12 pga__v8.n13 0.27270899999999998
rmesh_equiv_1158 pga__v8.n13 pga__v8.n14 17.471599999999999
rmesh_equiv_1159 pga__v8.n14 pga__v8.n15 16.554500000000001
rmesh_equiv_116 bias_source__vcm_buffer__first__tail.n1 bias_source__vcm_buffer__first__tail.n3 5.2415200000000004
rmesh_equiv_1160 pga__v8.n14 pga__v8.n9 13.727399999999999
rmesh_equiv_1161 pga__v8.n15 pga__v8.n16 3.0467200000000001
rmesh_equiv_1162 pga__v8.n16 pga__v8.t0 181.41
rmesh_equiv_1163 pga__v8.n2 pga__v8.n3 11.4361
rmesh_equiv_1164 pga__v8.n2 pga__v8.t2 381.113
rmesh_equiv_1165 pga__v8.n3 pga__v8.n7 17.684200000000001
rmesh_equiv_1166 pga__v8.n4 pga__v8.n6 2.90421
rmesh_equiv_1167 pga__v8.n4 pga__v8.t5 178.41800000000001
rmesh_equiv_1168 pga__v8.n5 pga__v8.n6 13.4665
rmesh_equiv_1169 pga__v8.n5 pga__v8.t5 172.06
rmesh_equiv_117 bias_source__vcm_buffer__first__tail.n1 bias_source__vcm_buffer__first__tail.t4 174.857
rmesh_equiv_1170 pga__v8.n6 pga__v8.n7 16.867000000000001
rmesh_equiv_1171 pga__v8.n7 pga__v8.n8 5.1188000000000002
rmesh_equiv_1172 pga__v8.n8 pga__v8.n9 1.57735
rmesh_equiv_1173 pga__v8.n8 pga__v8.t3 22.304099999999998
rmesh_equiv_1174 pga__v8.n9 pga__v8.t4 28.510400000000001
rmesh_equiv_1175 pga_gain8_r_feedback_r0_n0.t0 pga_gain8_r_feedback_r0_n0.t1 51.980899999999998
rmesh_equiv_1176 reset reset.n0 34.037695883737968
rmesh_equiv_1177 reset reset.n1 38.297600000000003
rmesh_equiv_1178 reset reset.n2 19.346959739937567
rmesh_equiv_1179 reset reset.t0 315.88
rmesh_equiv_118 bias_source__vcm_buffer__first__tail.n10 bias_source__vcm_buffer__first__tail.n11 20.7212
rmesh_equiv_1180 reset reset.t1 330.34100000000001
rmesh_equiv_1181 reset reset.t2 330.34100000000001
rmesh_equiv_1182 reset reset.t3 315.88
rmesh_equiv_1183 reset.n0 reset.n1 0.81771300000000002
rmesh_equiv_1184 reset.n1 reset.n2 1.6402100000000002
rmesh_equiv_1185 reset_mux__sb reset_mux__sb.n0 12.8005
rmesh_equiv_1186 reset_mux__sb reset_mux__sb.n1 18.701831069822845
rmesh_equiv_1187 reset_mux__sb reset_mux__sb.n2 12.8005
rmesh_equiv_1188 reset_mux__sb reset_mux__sb.n3 12.8005
rmesh_equiv_1189 reset_mux__sb reset_mux__sb.n7 12.8005
rmesh_equiv_119 bias_source__vcm_buffer__first__tail.n10 bias_source__vcm_buffer__first__tail.n8 5.2415200000000004
rmesh_equiv_1190 reset_mux__sb reset_mux__sb.t2 315.88
rmesh_equiv_1191 reset_mux__sb reset_mux__sb.t3 330.34100000000001
rmesh_equiv_1192 reset_mux__sb.n0 reset_mux__sb.n6 10.151300000000001
rmesh_equiv_1193 reset_mux__sb.n0 reset_mux__sb.t0 700.48400000000004
rmesh_equiv_1194 reset_mux__sb.n1 reset_mux__sb.n5 1.1660999999999999
rmesh_equiv_1195 reset_mux__sb.n2 reset_mux__sb.n4 10.151300000000001
rmesh_equiv_1196 reset_mux__sb.n2 reset_mux__sb.t1 255.34500000000003
rmesh_equiv_1197 reset_mux__sb.n3 reset_mux__sb.n4 10.151300000000001
rmesh_equiv_1198 reset_mux__sb.n3 reset_mux__sb.t1 255.34500000000003
rmesh_equiv_1199 reset_mux__sb.n4 reset_mux__sb.n5 16.867000000000001
rmesh_equiv_12 amplified.n10 amplified.n9 3.0467200000000001
rmesh_equiv_120 bias_source__vcm_buffer__first__tail.n10 bias_source__vcm_buffer__first__tail.n9 5.2415200000000004
rmesh_equiv_1200 reset_mux__sb.n5 reset_mux__sb.n6 17.684200000000001
rmesh_equiv_1201 reset_mux__sb.n6 reset_mux__sb.n7 10.151300000000001
rmesh_equiv_1202 reset_mux__sb.n7 reset_mux__sb.t0 700.48400000000004
rmesh_equiv_1203 sample__clkb sample__clkb.n0 12.8005
rmesh_equiv_1204 sample__clkb sample__clkb.n1 18.30518227520886
rmesh_equiv_1205 sample__clkb sample__clkb.n2 36.198700000000002
rmesh_equiv_1206 sample__clkb sample__clkb.n3 36.214300000000001
rmesh_equiv_1207 sample__clkb sample__clkb.n4 12.8005
rmesh_equiv_1208 sample__clkb sample__clkb.n5 12.8005
rmesh_equiv_1209 sample__clkb sample__clkb.n9 12.8005
rmesh_equiv_121 bias_source__vcm_buffer__first__tail.n11 bias_source__vcm_buffer__first__tail.n15 0.91112499999999996
rmesh_equiv_1210 sample__clkb sample__clkb.t2 330.34100000000001
rmesh_equiv_1211 sample__clkb sample__clkb.t3 330.34100000000001
rmesh_equiv_1212 sample__clkb sample__clkb.t4 315.88
rmesh_equiv_1213 sample__clkb sample__clkb.t5 315.88
rmesh_equiv_1214 sample__clkb.n0 sample__clkb.n8 10.151300000000001
rmesh_equiv_1215 sample__clkb.n0 sample__clkb.t0 700.48400000000004
rmesh_equiv_1216 sample__clkb.n1 sample__clkb.n2 1.6466799999999999
rmesh_equiv_1217 sample__clkb.n2 sample__clkb.n3 2.4756399999999998
rmesh_equiv_1218 sample__clkb.n3 sample__clkb.n7 1.1660999999999999
rmesh_equiv_1219 sample__clkb.n4 sample__clkb.n6 10.151300000000001
rmesh_equiv_122 bias_source__vcm_buffer__first__tail.n11 bias_source__vcm_buffer__first__tail.n7 0.91112499999999996
rmesh_equiv_1220 sample__clkb.n4 sample__clkb.t1 255.34500000000003
rmesh_equiv_1221 sample__clkb.n5 sample__clkb.n6 10.151300000000001
rmesh_equiv_1222 sample__clkb.n5 sample__clkb.t1 255.34500000000003
rmesh_equiv_1223 sample__clkb.n6 sample__clkb.n7 16.867000000000001
rmesh_equiv_1224 sample__clkb.n7 sample__clkb.n8 17.684200000000001
rmesh_equiv_1225 sample__clkb.n8 sample__clkb.n9 10.151300000000001
rmesh_equiv_1226 sample__clkb.n9 sample__clkb.t0 700.48400000000004
rmesh_equiv_1227 sample__m sample__m.n0 12.8005
rmesh_equiv_1228 sample__m sample__m.n1 18.513533352596085
rmesh_equiv_1229 sample__m sample__m.n10 12.8005
rmesh_equiv_123 bias_source__vcm_buffer__first__tail.n12 bias_source__vcm_buffer__first__tail.n14 5.2415200000000004
rmesh_equiv_1230 sample__m sample__m.n15 12.8005
rmesh_equiv_1231 sample__m sample__m.n2 12.8005
rmesh_equiv_1232 sample__m sample__m.n3 12.8005
rmesh_equiv_1233 sample__m sample__m.n6 12.8005
rmesh_equiv_1234 sample__m sample__m.n7 12.8005
rmesh_equiv_1235 sample__m sample__m.n9 12.8005
rmesh_equiv_1236 sample__m sample__m.t4 330.34100000000001
rmesh_equiv_1237 sample__m sample__m.t5 315.88
rmesh_equiv_1238 sample__m.n0 sample__m.n14 10.151300000000001
rmesh_equiv_1239 sample__m.n0 sample__m.t0 255.34500000000003
rmesh_equiv_124 bias_source__vcm_buffer__first__tail.n12 bias_source__vcm_buffer__first__tail.t3 174.857
rmesh_equiv_1240 sample__m.n1 sample__m.n5 4.4948800000000002
rmesh_equiv_1241 sample__m.n10 sample__m.n11 10.151300000000001
rmesh_equiv_1242 sample__m.n10 sample__m.t1 700.48400000000004
rmesh_equiv_1243 sample__m.n11 sample__m.n12 17.2837
rmesh_equiv_1244 sample__m.n11 sample__m.n9 10.151300000000001
rmesh_equiv_1245 sample__m.n12 sample__m.n13 0.81771300000000002
rmesh_equiv_1246 sample__m.n12 sample__m.n8 18.100899999999999
rmesh_equiv_1247 sample__m.n13 sample__m.n14 17.2837
rmesh_equiv_1248 sample__m.n13 sample__m.n5 0.81771300000000002
rmesh_equiv_1249 sample__m.n14 sample__m.n15 10.151300000000001
rmesh_equiv_125 bias_source__vcm_buffer__first__tail.n13 bias_source__vcm_buffer__first__tail.n14 5.2415200000000004
rmesh_equiv_1250 sample__m.n15 sample__m.t0 255.34500000000003
rmesh_equiv_1251 sample__m.n2 sample__m.n4 10.151300000000001
rmesh_equiv_1252 sample__m.n2 sample__m.t2 700.48400000000004
rmesh_equiv_1253 sample__m.n3 sample__m.n4 10.151300000000001
rmesh_equiv_1254 sample__m.n3 sample__m.t2 700.48400000000004
rmesh_equiv_1255 sample__m.n4 sample__m.n5 17.2837
rmesh_equiv_1256 sample__m.n6 sample__m.n8 10.151300000000001
rmesh_equiv_1257 sample__m.n6 sample__m.t3 255.34500000000003
rmesh_equiv_1258 sample__m.n7 sample__m.n8 10.151300000000001
rmesh_equiv_1259 sample__m.n7 sample__m.t3 255.34500000000003
rmesh_equiv_126 bias_source__vcm_buffer__first__tail.n13 bias_source__vcm_buffer__first__tail.t3 174.857
rmesh_equiv_1260 sample__m.n9 sample__m.t1 700.48400000000004
rmesh_equiv_1261 sample__mb sample__mb.n0 12.8005
rmesh_equiv_1262 sample__mb sample__mb.n1 18.30518227520886
rmesh_equiv_1263 sample__mb sample__mb.n2 12.8005
rmesh_equiv_1264 sample__mb sample__mb.n3 12.8005
rmesh_equiv_1265 sample__mb sample__mb.n7 12.8005
rmesh_equiv_1266 sample__mb sample__mb.t2 330.34100000000001
rmesh_equiv_1267 sample__mb sample__mb.t3 315.88
rmesh_equiv_1268 sample__mb.n0 sample__mb.n6 10.151300000000001
rmesh_equiv_1269 sample__mb.n0 sample__mb.t0 700.48400000000004
rmesh_equiv_127 bias_source__vcm_buffer__first__tail.n14 bias_source__vcm_buffer__first__tail.n15 20.7212
rmesh_equiv_1270 sample__mb.n1 sample__mb.n5 1.17256
rmesh_equiv_1271 sample__mb.n2 sample__mb.n4 10.151300000000001
rmesh_equiv_1272 sample__mb.n2 sample__mb.t1 255.34500000000003
rmesh_equiv_1273 sample__mb.n3 sample__mb.n4 10.151300000000001
rmesh_equiv_1274 sample__mb.n3 sample__mb.t1 255.34500000000003
rmesh_equiv_1275 sample__mb.n4 sample__mb.n5 16.867000000000001
rmesh_equiv_1276 sample__mb.n5 sample__mb.n6 17.684200000000001
rmesh_equiv_1277 sample__mb.n6 sample__mb.n7 10.151300000000001
rmesh_equiv_1278 sample__mb.n7 sample__mb.t0 700.48400000000004
rmesh_equiv_1279 sample__mf sample__mf.n0 12.8005
rmesh_equiv_128 bias_source__vcm_buffer__first__tail.n15 bias_source__vcm_buffer__first__tail.n16 23.220400000000001
rmesh_equiv_1280 sample__mf sample__mf.n1 12.8005
rmesh_equiv_1281 sample__mf sample__mf.n12 12.8005
rmesh_equiv_1282 sample__mf sample__mf.n13 12.8005
rmesh_equiv_1283 sample__mf sample__mf.n15 12.8005
rmesh_equiv_1284 sample__mf sample__mf.n16 12.8005
rmesh_equiv_1285 sample__mf sample__mf.n2 12.8005
rmesh_equiv_1286 sample__mf sample__mf.n21 12.8005
rmesh_equiv_1287 sample__mf sample__mf.n4 12.8005
rmesh_equiv_1288 sample__mf sample__mf.n5 12.8005
rmesh_equiv_1289 sample__mf sample__mf.n8 12.8005
rmesh_equiv_129 bias_source__vcm_buffer__first__tail.n16 bias_source__vcm_buffer__first__tail.n17 3.0467200000000001
rmesh_equiv_1290 sample__mf sample__mf.n9 12.8005
rmesh_equiv_1291 sample__mf.n0 sample__mf.n20 10.151300000000001
rmesh_equiv_1292 sample__mf.n0 sample__mf.t0 255.34500000000003
rmesh_equiv_1293 sample__mf.n1 sample__mf.n3 10.151300000000001
rmesh_equiv_1294 sample__mf.n1 sample__mf.t3 255.34500000000003
rmesh_equiv_1295 sample__mf.n10 sample__mf.n11 17.700399999999998
rmesh_equiv_1296 sample__mf.n10 sample__mf.n8 10.151300000000001
rmesh_equiv_1297 sample__mf.n10 sample__mf.n9 10.151300000000001
rmesh_equiv_1298 sample__mf.n11 sample__mf.n19 0.81771300000000002
rmesh_equiv_1299 sample__mf.n11 sample__mf.n7 3.8580199999999998
rmesh_equiv_13 amplified.n10 amplified.t0 181.41
rmesh_equiv_130 bias_source__vcm_buffer__first__tail.n17 bias_source__vcm_buffer__first__tail.t0 181.41
rmesh_equiv_1300 sample__mf.n12 sample__mf.n14 10.151300000000001
rmesh_equiv_1301 sample__mf.n12 sample__mf.t1 255.34500000000003
rmesh_equiv_1302 sample__mf.n13 sample__mf.n14 10.151300000000001
rmesh_equiv_1303 sample__mf.n13 sample__mf.t1 255.34500000000003
rmesh_equiv_1304 sample__mf.n14 sample__mf.n18 18.517600000000002
rmesh_equiv_1305 sample__mf.n15 sample__mf.n17 10.151300000000001
rmesh_equiv_1306 sample__mf.n15 sample__mf.t4 700.48400000000004
rmesh_equiv_1307 sample__mf.n16 sample__mf.n17 10.151300000000001
rmesh_equiv_1308 sample__mf.n16 sample__mf.t4 700.48400000000004
rmesh_equiv_1309 sample__mf.n17 sample__mf.n18 17.700399999999998
rmesh_equiv_131 bias_source__vcm_buffer__first__tail.n2 bias_source__vcm_buffer__first__tail.n3 5.2415200000000004
rmesh_equiv_1310 sample__mf.n18 sample__mf.n19 0.81771300000000002
rmesh_equiv_1311 sample__mf.n19 sample__mf.n20 17.700399999999998
rmesh_equiv_1312 sample__mf.n2 sample__mf.n3 10.151300000000001
rmesh_equiv_1313 sample__mf.n2 sample__mf.t3 255.34500000000003
rmesh_equiv_1314 sample__mf.n20 sample__mf.n21 10.151300000000001
rmesh_equiv_1315 sample__mf.n21 sample__mf.t0 255.34500000000003
rmesh_equiv_1316 sample__mf.n3 sample__mf.n7 18.517600000000002
rmesh_equiv_1317 sample__mf.n4 sample__mf.n6 10.151300000000001
rmesh_equiv_1318 sample__mf.n4 sample__mf.t2 700.48400000000004
rmesh_equiv_1319 sample__mf.n5 sample__mf.n6 10.151300000000001
rmesh_equiv_132 bias_source__vcm_buffer__first__tail.n2 bias_source__vcm_buffer__first__tail.t4 174.857
rmesh_equiv_1320 sample__mf.n5 sample__mf.t2 700.48400000000004
rmesh_equiv_1321 sample__mf.n6 sample__mf.n7 17.700399999999998
rmesh_equiv_1322 sample__mf.n8 sample__mf.t5 700.48400000000004
rmesh_equiv_1323 sample__mf.n9 sample__mf.t5 700.48400000000004
rmesh_equiv_1324 sample__t sample__t.n0 12.8005
rmesh_equiv_1325 sample__t sample__t.n1 18.930260438372009
rmesh_equiv_1326 sample__t sample__t.n10 12.8005
rmesh_equiv_1327 sample__t sample__t.n15 12.8005
rmesh_equiv_1328 sample__t sample__t.n2 12.8005
rmesh_equiv_1329 sample__t sample__t.n3 12.8005
rmesh_equiv_133 bias_source__vcm_buffer__first__tail.n3 bias_source__vcm_buffer__first__tail.n7 21.631799999999998
rmesh_equiv_1330 sample__t sample__t.n5 12.8005
rmesh_equiv_1331 sample__t sample__t.n6 12.8005
rmesh_equiv_1332 sample__t sample__t.n9 12.8005
rmesh_equiv_1333 sample__t sample__t.t4 330.34100000000001
rmesh_equiv_1334 sample__t sample__t.t5 315.88
rmesh_equiv_1335 sample__t.n0 sample__t.n14 10.151300000000001
rmesh_equiv_1336 sample__t.n0 sample__t.t0 700.48400000000004
rmesh_equiv_1337 sample__t.n1 sample__t.n13 4.4948800000000002
rmesh_equiv_1338 sample__t.n10 sample__t.n11 10.151300000000001
rmesh_equiv_1339 sample__t.n10 sample__t.t2 255.34500000000003
rmesh_equiv_134 bias_source__vcm_buffer__first__tail.n4 bias_source__vcm_buffer__first__tail.n6 5.2415200000000004
rmesh_equiv_1340 sample__t.n11 sample__t.n12 18.117000000000001
rmesh_equiv_1341 sample__t.n11 sample__t.n9 10.151300000000001
rmesh_equiv_1342 sample__t.n12 sample__t.n13 0.81771300000000002
rmesh_equiv_1343 sample__t.n12 sample__t.n8 0.81771300000000002
rmesh_equiv_1344 sample__t.n13 sample__t.n14 18.117000000000001
rmesh_equiv_1345 sample__t.n14 sample__t.n15 10.151300000000001
rmesh_equiv_1346 sample__t.n15 sample__t.t0 700.48400000000004
rmesh_equiv_1347 sample__t.n2 sample__t.n4 10.151300000000001
rmesh_equiv_1348 sample__t.n2 sample__t.t1 255.34500000000003
rmesh_equiv_1349 sample__t.n3 sample__t.n4 10.151300000000001
rmesh_equiv_135 bias_source__vcm_buffer__first__tail.n4 bias_source__vcm_buffer__first__tail.t1 174.857
rmesh_equiv_1350 sample__t.n3 sample__t.t1 255.34500000000003
rmesh_equiv_1351 sample__t.n4 sample__t.n8 18.934200000000001
rmesh_equiv_1352 sample__t.n5 sample__t.n7 10.151300000000001
rmesh_equiv_1353 sample__t.n5 sample__t.t3 700.48400000000004
rmesh_equiv_1354 sample__t.n6 sample__t.n7 10.151300000000001
rmesh_equiv_1355 sample__t.n6 sample__t.t3 700.48400000000004
rmesh_equiv_1356 sample__t.n7 sample__t.n8 18.117000000000001
rmesh_equiv_1357 sample__t.n9 sample__t.t2 255.34500000000003
rmesh_equiv_1358 sample__tb sample__tb.n0 12.8005
rmesh_equiv_1359 sample__tb sample__tb.n1 18.30518227520886
rmesh_equiv_136 bias_source__vcm_buffer__first__tail.n5 bias_source__vcm_buffer__first__tail.n6 5.2415200000000004
rmesh_equiv_1360 sample__tb sample__tb.n2 12.8005
rmesh_equiv_1361 sample__tb sample__tb.n3 12.8005
rmesh_equiv_1362 sample__tb sample__tb.n7 12.8005
rmesh_equiv_1363 sample__tb sample__tb.t2 330.34100000000001
rmesh_equiv_1364 sample__tb sample__tb.t3 315.88
rmesh_equiv_1365 sample__tb.n0 sample__tb.n6 10.151300000000001
rmesh_equiv_1366 sample__tb.n0 sample__tb.t0 700.48400000000004
rmesh_equiv_1367 sample__tb.n1 sample__tb.n5 1.17256
rmesh_equiv_1368 sample__tb.n2 sample__tb.n4 10.151300000000001
rmesh_equiv_1369 sample__tb.n2 sample__tb.t1 255.34500000000003
rmesh_equiv_137 bias_source__vcm_buffer__first__tail.n5 bias_source__vcm_buffer__first__tail.t1 174.857
rmesh_equiv_1370 sample__tb.n3 sample__tb.n4 10.151300000000001
rmesh_equiv_1371 sample__tb.n3 sample__tb.t1 255.34500000000003
rmesh_equiv_1372 sample__tb.n4 sample__tb.n5 16.867000000000001
rmesh_equiv_1373 sample__tb.n5 sample__tb.n6 17.684200000000001
rmesh_equiv_1374 sample__tb.n6 sample__tb.n7 10.151300000000001
rmesh_equiv_1375 sample__tb.n7 sample__tb.t0 700.48400000000004
rmesh_equiv_1376 vcm vcm.n0 209.167
rmesh_equiv_1377 vcm vcm.n12 33.724600000000002
rmesh_equiv_1378 vcm vcm.n13 21.480391122493913
rmesh_equiv_1379 vcm vcm.n3 19.837
rmesh_equiv_138 bias_source__vcm_buffer__first__tail.n6 bias_source__vcm_buffer__first__tail.n7 20.7212
rmesh_equiv_1380 vcm vcm.n4 4.2590000000000003
rmesh_equiv_1381 vcm vcm.n7 33.9895
rmesh_equiv_1382 vcm vcm.n9 6.9688099999999995
rmesh_equiv_1383 vcm vcm.t5 212.21199999999999
rmesh_equiv_1384 vcm vcm.t6 212.21199999999999
rmesh_equiv_1385 vcm vcm.t7 332.71199999999999
rmesh_equiv_1386 vcm.n0 vcm.n1 23.662700000000001
rmesh_equiv_1387 vcm.n0 vcm.t3 30.3733
rmesh_equiv_1388 vcm.n1 vcm.n2 22.727399999999999
rmesh_equiv_1389 vcm.n1 vcm.t1 30.3733
rmesh_equiv_139 bias_source__vcm_buffer__first__tail.n8 bias_source__vcm_buffer__first__tail.t2 174.857
rmesh_equiv_1390 vcm.n10 vcm.n11 17.804500000000001
rmesh_equiv_1391 vcm.n10 vcm.n7 0.51338700000000004
rmesh_equiv_1392 vcm.n10 vcm.n9 0.27270899999999998
rmesh_equiv_1393 vcm.n11 vcm.n12 4.2281500000000003
rmesh_equiv_1394 vcm.n11 vcm.n6 0.91758700000000015
rmesh_equiv_1395 vcm.n12 vcm.n13 0.91112499999999996
rmesh_equiv_1396 vcm.n2 vcm.n6 13.727399999999999
rmesh_equiv_1397 vcm.n2 vcm.t2 29.760400000000001
rmesh_equiv_1398 vcm.n3 vcm.n5 14.189499999999999
rmesh_equiv_1399 vcm.n3 vcm.t0 174.91200000000001
rmesh_equiv_14 amplified.n2 amplified.n7 4.2281500000000003
rmesh_equiv_140 bias_source__vcm_buffer__first__tail.n9 bias_source__vcm_buffer__first__tail.t2 174.857
rmesh_equiv_1400 vcm.n4 vcm.n5 3.0467200000000001
rmesh_equiv_1401 vcm.n4 vcm.t0 181.41
rmesh_equiv_1402 vcm.n5 vcm.n6 17.804500000000001
rmesh_equiv_1403 vcm.n7 vcm.n8 13.2728
rmesh_equiv_1404 vcm.n8 vcm.n9 13.200100000000001
rmesh_equiv_1405 vcm.n8 vcm.t4 0.71462499999999995
rmesh_equiv_1406 vgnd vgnd.n10041 213.86055095397336
rmesh_equiv_1407 vgnd vgnd.n1006 134.60601006654991
rmesh_equiv_1408 vgnd vgnd.n1008 9774.2521338301085
rmesh_equiv_1409 vgnd vgnd.n1010 9774.2425539249925
rmesh_equiv_141 bias_source__vcm_buffer__pre bias_source__vcm_buffer__pre.n0 15.6333
rmesh_equiv_1410 vgnd vgnd.n1012 134.60600126553072
rmesh_equiv_1411 vgnd vgnd.n10417 207.29274111744894
rmesh_equiv_1412 vgnd vgnd.n10426 15.939159281910895
rmesh_equiv_1413 vgnd vgnd.n10434 170.07307472723139
rmesh_equiv_1414 vgnd vgnd.n10941 646.87948297150558
rmesh_equiv_1415 vgnd vgnd.n10945 8035.0091933166832
rmesh_equiv_1416 vgnd vgnd.n11029 2424.2850663563163
rmesh_equiv_1417 vgnd vgnd.n11136 3.7461420512578103
rmesh_equiv_1418 vgnd vgnd.n11403 3.1779244197078329
rmesh_equiv_1419 vgnd vgnd.n11452 204.98780332237669
rmesh_equiv_142 bias_source__vcm_buffer__pre bias_source__vcm_buffer__pre.n1 3.4389368698468692
rmesh_equiv_1420 vgnd vgnd.n11511 244.12207082854019
rmesh_equiv_1421 vgnd vgnd.n11515 3347.2765931704275
rmesh_equiv_1422 vgnd vgnd.n11517 9676.5824806788205
rmesh_equiv_1423 vgnd vgnd.n11519 51.356746910853694
rmesh_equiv_1424 vgnd vgnd.n11526 389.26217785228874
rmesh_equiv_1425 vgnd vgnd.n11534 2079.3263311990486
rmesh_equiv_1426 vgnd vgnd.n11536 86.903019952042996
rmesh_equiv_1427 vgnd vgnd.n1518 19733.954912862115
rmesh_equiv_1428 vgnd vgnd.n1519 314.81879625147172
rmesh_equiv_1429 vgnd vgnd.n1547 213.62241642488382
rmesh_equiv_143 bias_source__vcm_buffer__pre bias_source__vcm_buffer__pre.n13 15.6333
rmesh_equiv_1430 vgnd vgnd.n1559 14684.703893909062
rmesh_equiv_1431 vgnd vgnd.n1563 1906.2618614348219
rmesh_equiv_1432 vgnd vgnd.n1606 169.26347762818747
rmesh_equiv_1433 vgnd vgnd.n1608 8076.9525291074597
rmesh_equiv_1434 vgnd vgnd.n1610 164.35716309672193
rmesh_equiv_1435 vgnd vgnd.n173 1459.0530552088569
rmesh_equiv_1436 vgnd vgnd.n175 1430.9892192128932
rmesh_equiv_1437 vgnd vgnd.n176 339.30719477055214
rmesh_equiv_1438 vgnd vgnd.n22 2908.3150568646811
rmesh_equiv_1439 vgnd vgnd.n23 1907.834355500348
rmesh_equiv_144 bias_source__vcm_buffer__pre bias_source__vcm_buffer__pre.n2 5.3798000000000004
rmesh_equiv_1440 vgnd vgnd.n2370 33816.772200176696
rmesh_equiv_1441 vgnd vgnd.n2371 316.93799437174511
rmesh_equiv_1442 vgnd vgnd.n2407 14684.703893909062
rmesh_equiv_1443 vgnd vgnd.n2411 1906.2618614348219
rmesh_equiv_1444 vgnd vgnd.n242 131.31149194675746
rmesh_equiv_1445 vgnd vgnd.n2454 169.26347762818747
rmesh_equiv_1446 vgnd vgnd.n2456 8076.9525291074597
rmesh_equiv_1447 vgnd vgnd.n2458 164.35716309672193
rmesh_equiv_1448 vgnd vgnd.n26 197.41992145422682
rmesh_equiv_1449 vgnd vgnd.n277 278.57322038320825
rmesh_equiv_145 bias_source__vcm_buffer__pre bias_source__vcm_buffer__pre.n3 30.1326
rmesh_equiv_1450 vgnd vgnd.n283 4.9760142806342964
rmesh_equiv_1451 vgnd vgnd.n2839 278.67456116500961
rmesh_equiv_1452 vgnd vgnd.n2886 35530.829426265518
rmesh_equiv_1453 vgnd vgnd.n2887 316.94538993059996
rmesh_equiv_1454 vgnd vgnd.n29 1065.7493794015286
rmesh_equiv_1455 vgnd vgnd.n2923 14684.703893909062
rmesh_equiv_1456 vgnd vgnd.n2927 1906.2618614348219
rmesh_equiv_1457 vgnd vgnd.n2970 169.26347762818747
rmesh_equiv_1458 vgnd vgnd.n2972 8076.9525291074597
rmesh_equiv_1459 vgnd vgnd.n2974 164.35716309672193
rmesh_equiv_146 bias_source__vcm_buffer__pre bias_source__vcm_buffer__pre.n4 4.8770699999999998
rmesh_equiv_1460 vgnd vgnd.n30 421.8600387188348
rmesh_equiv_1461 vgnd vgnd.n31 1742.8126006528196
rmesh_equiv_1462 vgnd vgnd.n3227 33816.622941411653
rmesh_equiv_1463 vgnd vgnd.n3228 316.93799369511623
rmesh_equiv_1464 vgnd vgnd.n324 20304.048540522701
rmesh_equiv_1465 vgnd vgnd.n325 314.82680880405633
rmesh_equiv_1466 vgnd vgnd.n3268 14684.703893909062
rmesh_equiv_1467 vgnd vgnd.n3272 1906.2618614348219
rmesh_equiv_1468 vgnd vgnd.n3315 169.26347762818747
rmesh_equiv_1469 vgnd vgnd.n3317 8076.9525291074597
rmesh_equiv_147 bias_source__vcm_buffer__pre bias_source__vcm_buffer__pre.n5 22.8553
rmesh_equiv_1470 vgnd vgnd.n3319 164.35716309672193
rmesh_equiv_1471 vgnd vgnd.n353 213.62306238105853
rmesh_equiv_1472 vgnd vgnd.n361 14684.703893909062
rmesh_equiv_1473 vgnd vgnd.n365 1906.2618614348219
rmesh_equiv_1474 vgnd vgnd.n408 169.26347762818747
rmesh_equiv_1475 vgnd vgnd.n410 8076.9525291074597
rmesh_equiv_1476 vgnd vgnd.n412 164.35716309672193
rmesh_equiv_1477 vgnd vgnd.n4569 208.43438575267277
rmesh_equiv_1478 vgnd vgnd.n4670 29512.326792669679
rmesh_equiv_1479 vgnd vgnd.n4673 345.36635474766439
rmesh_equiv_148 bias_source__vcm_buffer__pre bias_source__vcm_buffer__pre.n8 15.6333
rmesh_equiv_1480 vgnd vgnd.n5943 2090.7860675619322
rmesh_equiv_1481 vgnd vgnd.n5945 2095.0305113814084
rmesh_equiv_1482 vgnd vgnd.n5949 385.87392940900855
rmesh_equiv_1483 vgnd vgnd.n5955 1240.8254005857843
rmesh_equiv_1484 vgnd vgnd.n6533 20.164077804070953
rmesh_equiv_1485 vgnd vgnd.n6543 6.4502395693364507
rmesh_equiv_1486 vgnd vgnd.n6662 213.60332417402969
rmesh_equiv_1487 vgnd vgnd.n6830 239.75925887643913
rmesh_equiv_1488 vgnd vgnd.n7038 213.59627162730828
rmesh_equiv_1489 vgnd vgnd.n7206 239.84734639518604
rmesh_equiv_149 bias_source__vcm_buffer__pre bias_source__vcm_buffer__pre.n9 15.6333
rmesh_equiv_1490 vgnd vgnd.n7633 213.5916705463485
rmesh_equiv_1491 vgnd vgnd.n7801 239.75926693216658
rmesh_equiv_1492 vgnd vgnd.n7831 3.9482497831217862
rmesh_equiv_1493 vgnd vgnd.n7937 206.19434979617751
rmesh_equiv_1494 vgnd vgnd.n8583 6040.7128853575805
rmesh_equiv_1495 vgnd vgnd.n8626 1398.5884735621482
rmesh_equiv_1496 vgnd vgnd.n8716 4650.3001926314373
rmesh_equiv_1497 vgnd vgnd.n8717 156.64432966597016
rmesh_equiv_1498 vgnd vgnd.n8726 1510.5172795918224
rmesh_equiv_1499 vgnd vgnd.n8728 128.33289401808275
rmesh_equiv_15 amplified.n3 amplified.n4 13.2728
rmesh_equiv_150 bias_source__vcm_buffer__pre bias_source__vcm_buffer__pre.t3 0.00141837
rmesh_equiv_1500 vgnd vgnd.n8846 676.4897744867053
rmesh_equiv_1501 vgnd vgnd.n919 20284.194053482115
rmesh_equiv_1502 vgnd vgnd.n920 328.83405728514259
rmesh_equiv_1503 vgnd vgnd.n9530 239.74222897049316
rmesh_equiv_1504 vgnd vgnd.n961 28958.67519877767
rmesh_equiv_1505 vgnd vgnd.n9787 13.978588982378715
rmesh_equiv_1506 vgnd vgnd.n9797 16.39782103321464
rmesh_equiv_1507 vgnd vgnd.t0 243.26382689255698
rmesh_equiv_1508 vgnd vgnd.t1 120.80808035801245
rmesh_equiv_1509 vgnd vgnd.t101 127.10136542435849
rmesh_equiv_151 bias_source__vcm_buffer__pre bias_source__vcm_buffer__pre.t4 0.00141837
rmesh_equiv_1510 vgnd vgnd.t104 143.60098220702923
rmesh_equiv_1511 vgnd vgnd.t105 128.28736110665773
rmesh_equiv_1512 vgnd vgnd.t106 194.07411760084557
rmesh_equiv_1513 vgnd vgnd.t107 285.0911216908525
rmesh_equiv_1514 vgnd vgnd.t108 120.619938379652
rmesh_equiv_1515 vgnd vgnd.t109 67.885245380250566
rmesh_equiv_1516 vgnd vgnd.t110 120.75284422096814
rmesh_equiv_1517 vgnd vgnd.t111 193.07183417934439
rmesh_equiv_1518 vgnd vgnd.t112 124.95345642415812
rmesh_equiv_1519 vgnd vgnd.t113 125.1376570016087
rmesh_equiv_152 bias_source__vcm_buffer__pre bias_source__vcm_buffer__pre.t5 0.00141837
rmesh_equiv_1520 vgnd vgnd.t118 106.54633903245674
rmesh_equiv_1521 vgnd vgnd.t119 120.45492047856963
rmesh_equiv_1522 vgnd vgnd.t12 369.95887665750251
rmesh_equiv_1523 vgnd vgnd.t120 98.147335977270473
rmesh_equiv_1524 vgnd vgnd.t121 189.46738598089294
rmesh_equiv_1525 vgnd vgnd.t122 189.46738757076585
rmesh_equiv_1526 vgnd vgnd.t123 125.08575951906461
rmesh_equiv_1527 vgnd vgnd.t124 384.53356951432613
rmesh_equiv_1528 vgnd vgnd.t125 363.09120444099955
rmesh_equiv_1529 vgnd vgnd.t126 137.12770097376509
rmesh_equiv_153 bias_source__vcm_buffer__pre bias_source__vcm_buffer__pre.t6 1054.8499999999999
rmesh_equiv_1530 vgnd vgnd.t127 119.76713717314095
rmesh_equiv_1531 vgnd vgnd.t128 125.6848800992589
rmesh_equiv_1532 vgnd vgnd.t129 30.034575358338113
rmesh_equiv_1533 vgnd vgnd.t13 150.46201119396656
rmesh_equiv_1534 vgnd vgnd.t131 102.82615202036376
rmesh_equiv_1535 vgnd vgnd.t132 253.28702761698264
rmesh_equiv_1536 vgnd vgnd.t133 189.46738757076585
rmesh_equiv_1537 vgnd vgnd.t136 98.225053141964835
rmesh_equiv_1538 vgnd vgnd.t14 195.88029039900829
rmesh_equiv_1539 vgnd vgnd.t15 120.6780514986076
rmesh_equiv_154 bias_source__vcm_buffer__pre.n0 bias_source__vcm_buffer__pre.n12 5.2415200000000004
rmesh_equiv_1540 vgnd vgnd.t16 121.04557300735976
rmesh_equiv_1541 vgnd vgnd.t17 127.29066204725275
rmesh_equiv_1542 vgnd vgnd.t18 124.59234660762752
rmesh_equiv_1543 vgnd vgnd.t19 119.8041833680368
rmesh_equiv_1544 vgnd vgnd.t2 97.343858782286333
rmesh_equiv_1545 vgnd vgnd.t20 119.38592037424451
rmesh_equiv_1546 vgnd vgnd.t21 189.45957101881135
rmesh_equiv_1547 vgnd vgnd.t22 120.77358863992072
rmesh_equiv_1548 vgnd vgnd.t23 95.661826633241716
rmesh_equiv_1549 vgnd vgnd.t27 24.42100465085058
rmesh_equiv_155 bias_source__vcm_buffer__pre.n0 bias_source__vcm_buffer__pre.t0 174.857
rmesh_equiv_1550 vgnd vgnd.t3 243.26382689255698
rmesh_equiv_1551 vgnd vgnd.t33 118.98457135933451
rmesh_equiv_1552 vgnd vgnd.t35 191.38769769010577
rmesh_equiv_1553 vgnd vgnd.t39 243.26382689255698
rmesh_equiv_1554 vgnd vgnd.t4 363.09120444099955
rmesh_equiv_1555 vgnd vgnd.t40 152.34410726597935
rmesh_equiv_1556 vgnd vgnd.t41 189.46738598089294
rmesh_equiv_1557 vgnd vgnd.t42 120.81178586742027
rmesh_equiv_1558 vgnd vgnd.t43 106.54633903245674
rmesh_equiv_1559 vgnd vgnd.t45 95.191531773897267
rmesh_equiv_156 bias_source__vcm_buffer__pre.n1 bias_source__vcm_buffer__pre.n2 4.1529499999999997
rmesh_equiv_1560 vgnd vgnd.t47 180.91743025760073
rmesh_equiv_1561 vgnd vgnd.t48 104.440970916099
rmesh_equiv_1562 vgnd vgnd.t49 126.92180822916431
rmesh_equiv_1563 vgnd vgnd.t5 119.76713717314095
rmesh_equiv_1564 vgnd vgnd.t50 127.02518214534913
rmesh_equiv_1565 vgnd vgnd.t52 41.27401472525537
rmesh_equiv_1566 vgnd vgnd.t53 119.37602669312304
rmesh_equiv_1567 vgnd vgnd.t54 124.8335694622789
rmesh_equiv_1568 vgnd vgnd.t55 121.40569939154058
rmesh_equiv_1569 vgnd vgnd.t57 243.26382689255698
rmesh_equiv_157 bias_source__vcm_buffer__pre.n10 bias_source__vcm_buffer__pre.n11 20.304500000000001
rmesh_equiv_1570 vgnd vgnd.t58 156.54602604433489
rmesh_equiv_1571 vgnd vgnd.t59 181.73881279544685
rmesh_equiv_1572 vgnd vgnd.t6 363.09120444099955
rmesh_equiv_1573 vgnd vgnd.t60 94.459531488887805
rmesh_equiv_1574 vgnd vgnd.t62 94.33690157093659
rmesh_equiv_1575 vgnd vgnd.t63 189.46738598089294
rmesh_equiv_1576 vgnd vgnd.t65 29.70170610011747
rmesh_equiv_1577 vgnd vgnd.t67 120.12903338690555
rmesh_equiv_1578 vgnd vgnd.t68 122.02893503204599
rmesh_equiv_1579 vgnd vgnd.t69 363.09120444099955
rmesh_equiv_158 bias_source__vcm_buffer__pre.n10 bias_source__vcm_buffer__pre.n8 5.2415200000000004
rmesh_equiv_1580 vgnd vgnd.t7 150.29726362184346
rmesh_equiv_1581 vgnd vgnd.t70 163.9395384333875
rmesh_equiv_1582 vgnd vgnd.t72 101.73220099152208
rmesh_equiv_1583 vgnd vgnd.t73 243.26382689255698
rmesh_equiv_1584 vgnd vgnd.t74 154.1057254167597
rmesh_equiv_1585 vgnd vgnd.t75 119.54983759611412
rmesh_equiv_1586 vgnd vgnd.t76 93.514390882430561
rmesh_equiv_1587 vgnd vgnd.t77 189.46738757076585
rmesh_equiv_1588 vgnd vgnd.t79 363.09120444099955
rmesh_equiv_1589 vgnd vgnd.t80 189.45936750060696
rmesh_equiv_159 bias_source__vcm_buffer__pre.n10 bias_source__vcm_buffer__pre.n9 5.2415200000000004
rmesh_equiv_1590 vgnd vgnd.t81 243.26382689255698
rmesh_equiv_1591 vgnd vgnd.t82 163.9395384333875
rmesh_equiv_1592 vgnd vgnd.t83 243.26382689255698
rmesh_equiv_1593 vgnd vgnd.t84 407.79708314172484
rmesh_equiv_1594 vgnd vgnd.t87 119.76713717314095
rmesh_equiv_1595 vgnd vgnd.t88 125.66711064302592
rmesh_equiv_1596 vgnd vgnd.t91 119.03814430457248
rmesh_equiv_1597 vgnd vgnd.t92 94.812074888613125
rmesh_equiv_1598 vgnd vgnd.t93 127.29080397794152
rmesh_equiv_1599 vgnd vgnd.t94 119.97087361911777
rmesh_equiv_16 amplified.n3 amplified.n6 0.51338700000000004
rmesh_equiv_160 bias_source__vcm_buffer__pre.n11 bias_source__vcm_buffer__pre.n12 23.059899999999999
rmesh_equiv_1600 vgnd vgnd.t95 121.03066825415667
rmesh_equiv_1601 vgnd vgnd.t96 197.45317223861403
rmesh_equiv_1602 vgnd vgnd.t97 118.99513357328478
rmesh_equiv_1603 vgnd vgnd.t99 98.222896613906087
rmesh_equiv_1604 vgnd.n10041 vgnd.n10417 22790045762.390274
rmesh_equiv_1605 vgnd.n10041 vgnd.n919 149038.96322038461
rmesh_equiv_1606 vgnd.n10041 vgnd.n920 148164.30112135899
rmesh_equiv_1607 vgnd.n10041 vgnd.n9530 47403312612762.438
rmesh_equiv_1608 vgnd.n10041 vgnd.t110 54028221869.223915
rmesh_equiv_1609 vgnd.n10041 vgnd.t111 5626726006891.916
rmesh_equiv_161 bias_source__vcm_buffer__pre.n11 bias_source__vcm_buffer__pre.n7 1.8528899999999999
rmesh_equiv_1610 vgnd.n10041 vgnd.t119 119900.19129603218
rmesh_equiv_1611 vgnd.n10041 vgnd.t123 581.05847577025304
rmesh_equiv_1612 vgnd.n10041 vgnd.t17 335666283.61831629
rmesh_equiv_1613 vgnd.n10041 vgnd.t33 7521632.0737513248
rmesh_equiv_1614 vgnd.n10041 vgnd.t35 75.640412989564453
rmesh_equiv_1615 vgnd.n10041 vgnd.t91 66393.743561106778
rmesh_equiv_1616 vgnd.n1006 vgnd.n1008 416.21012156690659
rmesh_equiv_1617 vgnd.n1006 vgnd.n1010 19098.346857963636
rmesh_equiv_1618 vgnd.n1006 vgnd.n1012 40878.247892056141
rmesh_equiv_1619 vgnd.n1006 vgnd.n920 1388.8903594784931
rmesh_equiv_162 bias_source__vcm_buffer__pre.n12 bias_source__vcm_buffer__pre.n13 5.2415200000000004
rmesh_equiv_1620 vgnd.n1006 vgnd.n961 2625.3483834719659
rmesh_equiv_1621 vgnd.n1006 vgnd.n966 1699.7406610798271
rmesh_equiv_1622 vgnd.n1006 vgnd.n991 147.20724290839783
rmesh_equiv_1623 vgnd.n1006 vgnd.n999 5101.4906680790427
rmesh_equiv_1624 vgnd.n1008 vgnd.n1010 3431.2494397202108
rmesh_equiv_1625 vgnd.n1008 vgnd.n1012 19098.341242429011
rmesh_equiv_1626 vgnd.n1008 vgnd.n920 1434.7407310711239
rmesh_equiv_1627 vgnd.n1008 vgnd.n961 593.27867788332583
rmesh_equiv_1628 vgnd.n1008 vgnd.n966 3344.4138251336885
rmesh_equiv_1629 vgnd.n1008 vgnd.n991 1699.7406610798271
rmesh_equiv_163 bias_source__vcm_buffer__pre.n13 bias_source__vcm_buffer__pre.t0 174.857
rmesh_equiv_1630 vgnd.n1008 vgnd.n999 5433.5478966051924
rmesh_equiv_1631 vgnd.n1010 vgnd.n1012 494.88045945199929
rmesh_equiv_1632 vgnd.n1010 vgnd.n920 1434.7414947667066
rmesh_equiv_1633 vgnd.n1010 vgnd.n961 597.18345533019624
rmesh_equiv_1634 vgnd.n1010 vgnd.n967 3958.0480375294428
rmesh_equiv_1635 vgnd.n1010 vgnd.n997 930.57463345244435
rmesh_equiv_1636 vgnd.n1010 vgnd.n999 5876.7972130830558
rmesh_equiv_1637 vgnd.n1012 vgnd.n920 1388.8924419087207
rmesh_equiv_1638 vgnd.n1012 vgnd.n961 3942.5300991046693
rmesh_equiv_1639 vgnd.n1012 vgnd.n967 18843.567151013071
rmesh_equiv_164 bias_source__vcm_buffer__pre.n2 bias_source__vcm_buffer__pre.n3 3.1113099999999996
rmesh_equiv_1640 vgnd.n1012 vgnd.n997 80.593074724705744
rmesh_equiv_1641 vgnd.n1012 vgnd.n999 27978.392851123463
rmesh_equiv_1642 vgnd.n10417 vgnd.n353 59621099045.693283
rmesh_equiv_1643 vgnd.n10417 vgnd.n919 1803227814.0869458
rmesh_equiv_1644 vgnd.n10417 vgnd.n920 31750758401.220284
rmesh_equiv_1645 vgnd.n10417 vgnd.t119 932072.52133733663
rmesh_equiv_1646 vgnd.n10417 vgnd.t14 77.080990959709197
rmesh_equiv_1647 vgnd.n10417 vgnd.t17 582.37478715757061
rmesh_equiv_1648 vgnd.n10417 vgnd.t35 2441979225.63696
rmesh_equiv_1649 vgnd.n10417 vgnd.t53 52177072.476991057
rmesh_equiv_165 bias_source__vcm_buffer__pre.n3 bias_source__vcm_buffer__pre.n7 2.2512099999999999
rmesh_equiv_1650 vgnd.n10417 vgnd.t80 6388468471.472126
rmesh_equiv_1651 vgnd.n10417 vgnd.t97 456635.72423600999
rmesh_equiv_1652 vgnd.n10426 vgnd.n10430 56.989100467959091
rmesh_equiv_1653 vgnd.n10426 vgnd.n9797 161.90815438159115
rmesh_equiv_1654 vgnd.n10426 vgnd.t10 84.872928223621642
rmesh_equiv_1655 vgnd.n10426 vgnd.t11 6.18492
rmesh_equiv_1656 vgnd.n10426 vgnd.t120 4561.561422754553
rmesh_equiv_1657 vgnd.n10426 vgnd.t136 6328.8936054022761
rmesh_equiv_1658 vgnd.n10426 vgnd.t27 241.12714629306663
rmesh_equiv_1659 vgnd.n10426 vgnd.t56 13.830343078503665
rmesh_equiv_166 bias_source__vcm_buffer__pre.n4 bias_source__vcm_buffer__pre.n6 2.4407800000000002
rmesh_equiv_1660 vgnd.n10426 vgnd.t78 31.770195664826705
rmesh_equiv_1661 vgnd.n10430 vgnd.n10434 56.989100467959091
rmesh_equiv_1662 vgnd.n10430 vgnd.t10 13.830343078503665
rmesh_equiv_1663 vgnd.n10430 vgnd.t24 31.770195664826705
rmesh_equiv_1664 vgnd.n10430 vgnd.t56 84.872928223621642
rmesh_equiv_1665 vgnd.n10430 vgnd.t66 84.872928223621642
rmesh_equiv_1666 vgnd.n10430 vgnd.t78 31.770195664826705
rmesh_equiv_1667 vgnd.n10430 vgnd.t89 13.830343078503665
rmesh_equiv_1668 vgnd.n10430 vgnd.t90 6.18492
rmesh_equiv_1669 vgnd.n10434 vgnd.n283 96.780650561748217
rmesh_equiv_167 bias_source__vcm_buffer__pre.n4 bias_source__vcm_buffer__pre.t2 387.11000000000001
rmesh_equiv_1670 vgnd.n10434 vgnd.t132 13.807781249531724
rmesh_equiv_1671 vgnd.n10434 vgnd.t24 31.770195664826705
rmesh_equiv_1672 vgnd.n10434 vgnd.t52 79.953012089647672
rmesh_equiv_1673 vgnd.n10434 vgnd.t66 13.830343078503665
rmesh_equiv_1674 vgnd.n10434 vgnd.t89 84.872928223621642
rmesh_equiv_1675 vgnd.n10434 vgnd.t9 6.18492
rmesh_equiv_1676 vgnd.n10434 vgnd.t92 31.454787168227089
rmesh_equiv_1677 vgnd.n10941 vgnd.n10945 87586.489475156079
rmesh_equiv_1678 vgnd.n10941 vgnd.n173 6300.6542133362591
rmesh_equiv_1679 vgnd.n10941 vgnd.n175 466.36259556494889
rmesh_equiv_168 bias_source__vcm_buffer__pre.n5 bias_source__vcm_buffer__pre.n6 11.4361
rmesh_equiv_1680 vgnd.n10941 vgnd.n176 3928.0237111635038
rmesh_equiv_1681 vgnd.n10941 vgnd.n242 744.27779566963738
rmesh_equiv_1682 vgnd.n10941 vgnd.n277 20191629.16477298
rmesh_equiv_1683 vgnd.n10941 vgnd.t101 16312.959225244587
rmesh_equiv_1684 vgnd.n10941 vgnd.t124 5832.2179467782989
rmesh_equiv_1685 vgnd.n10945 vgnd.n173 336.75803669810995
rmesh_equiv_1686 vgnd.n10945 vgnd.n175 1251.321479240165
rmesh_equiv_1687 vgnd.n10945 vgnd.n176 15214.4071357912
rmesh_equiv_1688 vgnd.n10945 vgnd.n242 27859.091422263173
rmesh_equiv_1689 vgnd.n10945 vgnd.n277 123263866.89268814
rmesh_equiv_169 bias_source__vcm_buffer__pre.n5 bias_source__vcm_buffer__pre.t2 381.113
rmesh_equiv_1690 vgnd.n10945 vgnd.n31 1309725.0004344333
rmesh_equiv_1691 vgnd.n10945 vgnd.t101 99585.745070759644
rmesh_equiv_1692 vgnd.n10945 vgnd.t124 392.86009494243797
rmesh_equiv_1693 vgnd.n10945 vgnd.t49 20145.569855728834
rmesh_equiv_1694 vgnd.n11029 vgnd.n11032 36870.206915880037
rmesh_equiv_1695 vgnd.n11029 vgnd.n11037 11173.245309151118
rmesh_equiv_1696 vgnd.n11029 vgnd.n11498 14366.402634930102
rmesh_equiv_1697 vgnd.n11029 vgnd.n11502 8745.4253067387654
rmesh_equiv_1698 vgnd.n11029 vgnd.n11507 22049.879582249647
rmesh_equiv_1699 vgnd.n11029 vgnd.n11509 765.53251583084466
rmesh_equiv_17 amplified.n4 amplified.n5 13.200100000000001
rmesh_equiv_170 bias_source__vcm_buffer__pre.n6 bias_source__vcm_buffer__pre.n7 20.304500000000001
rmesh_equiv_1700 vgnd.n11029 vgnd.n11511 376.96929454884679
rmesh_equiv_1701 vgnd.n11029 vgnd.n11515 675.30260888780015
rmesh_equiv_1702 vgnd.n11029 vgnd.n11517 22499.855453217071
rmesh_equiv_1703 vgnd.n11029 vgnd.n11519 98034.100930047382
rmesh_equiv_1704 vgnd.n11029 vgnd.n11526 6485.0408608297357
rmesh_equiv_1705 vgnd.n11029 vgnd.t71 8909.6924593396452
rmesh_equiv_1706 vgnd.n11032 vgnd.n11037 16857.861329605537
rmesh_equiv_1707 vgnd.n11032 vgnd.n11483 4722.8111619899537
rmesh_equiv_1708 vgnd.n11032 vgnd.n11498 5188.2654481749705
rmesh_equiv_1709 vgnd.n11032 vgnd.n11502 773.54943618508287
rmesh_equiv_171 bias_source__vcm_buffer__pre.n8 bias_source__vcm_buffer__pre.t1 174.857
rmesh_equiv_1710 vgnd.n11032 vgnd.n11507 357.95467880612762
rmesh_equiv_1711 vgnd.n11032 vgnd.n11509 1524.7383058356354
rmesh_equiv_1712 vgnd.n11032 vgnd.n11511 34447.386852490345
rmesh_equiv_1713 vgnd.n11032 vgnd.n11515 7181.8664804807859
rmesh_equiv_1714 vgnd.n11032 vgnd.n11517 10678.102486853031
rmesh_equiv_1715 vgnd.n11032 vgnd.n11519 22644.642795916465
rmesh_equiv_1716 vgnd.n11032 vgnd.t71 979.49592683769617
rmesh_equiv_1717 vgnd.n11037 vgnd.n11483 1293.3480619752336
rmesh_equiv_1718 vgnd.n11037 vgnd.n11498 423.84777783973362
rmesh_equiv_1719 vgnd.n11037 vgnd.n11502 545.56825289647372
rmesh_equiv_172 bias_source__vcm_buffer__pre.n9 bias_source__vcm_buffer__pre.t1 174.857
rmesh_equiv_1720 vgnd.n11037 vgnd.n11507 7270.5544276860801
rmesh_equiv_1721 vgnd.n11037 vgnd.n11509 16589.717019932497
rmesh_equiv_1722 vgnd.n11037 vgnd.n11511 1167.3973084086754
rmesh_equiv_1723 vgnd.n11037 vgnd.t71 8421.2869173765612
rmesh_equiv_1724 vgnd.n11046 vgnd.n11049 10106.074406578287
rmesh_equiv_1725 vgnd.n11046 vgnd.n11053 10959.425451900523
rmesh_equiv_1726 vgnd.n11046 vgnd.n11059 3703.1451533213421
rmesh_equiv_1727 vgnd.n11046 vgnd.n11461 14091.476051326914
rmesh_equiv_1728 vgnd.n11046 vgnd.n11465 16845.580223576348
rmesh_equiv_1729 vgnd.n11046 vgnd.n11466 1651.2503926888369
rmesh_equiv_173 bias_source__vcm_raw bias_source__vcm_raw.n1 5.2670000000000003
rmesh_equiv_1730 vgnd.n11046 vgnd.n11469 356.27623528476619
rmesh_equiv_1731 vgnd.n11046 vgnd.n11483 596990.46128745389
rmesh_equiv_1732 vgnd.n11046 vgnd.n11536 386.98409666164901
rmesh_equiv_1733 vgnd.n11046 vgnd.n31 81302.571470284645
rmesh_equiv_1734 vgnd.n11049 vgnd.n11053 108901.38967258605
rmesh_equiv_1735 vgnd.n11049 vgnd.n11059 427.98967516634639
rmesh_equiv_1736 vgnd.n11049 vgnd.n11063 3759.8454058512039
rmesh_equiv_1737 vgnd.n11049 vgnd.n11064 1286.9971594202066
rmesh_equiv_1738 vgnd.n11049 vgnd.n11461 140023.88457885329
rmesh_equiv_1739 vgnd.n11049 vgnd.n11465 5402.3425492111528
rmesh_equiv_174 bias_source__vcm_raw bias_source__vcm_raw.n10 5.2670000000000003
rmesh_equiv_1740 vgnd.n11049 vgnd.n11466 544.6163975505807
rmesh_equiv_1741 vgnd.n11049 vgnd.n11469 9204.2950966623284
rmesh_equiv_1742 vgnd.n11049 vgnd.n11483 2007751.9242618366
rmesh_equiv_1743 vgnd.n11049 vgnd.n11536 1203.0784512516957
rmesh_equiv_1744 vgnd.n11049 vgnd.n31 273430.48993592017
rmesh_equiv_1745 vgnd.n11053 vgnd.n11063 9405.2905002070729
rmesh_equiv_1746 vgnd.n11053 vgnd.n11460 394.00000000000006
rmesh_equiv_1747 vgnd.n11053 vgnd.n11461 652.23438410485801
rmesh_equiv_1748 vgnd.n11053 vgnd.n11465 924.39422461960862
rmesh_equiv_1749 vgnd.n11053 vgnd.n11466 4122.1342960501452
rmesh_equiv_175 bias_source__vcm_raw bias_source__vcm_raw.n11 5.2670000000000003
rmesh_equiv_1750 vgnd.n11053 vgnd.n11469 1168.4131363060469
rmesh_equiv_1751 vgnd.n11053 vgnd.t64 1002.1666615073635
rmesh_equiv_1752 vgnd.n11059 vgnd.n11063 4834.3566663940337
rmesh_equiv_1753 vgnd.n11059 vgnd.n11064 111.46129983666417
rmesh_equiv_1754 vgnd.n11059 vgnd.n11465 7177.9153549251514
rmesh_equiv_1755 vgnd.n11059 vgnd.n11466 4953.837310939427
rmesh_equiv_1756 vgnd.n11059 vgnd.n11469 427.2596178214726
rmesh_equiv_1757 vgnd.n11059 vgnd.n11483 236637.89375789737
rmesh_equiv_1758 vgnd.n11059 vgnd.n11536 387.50423488086483
rmesh_equiv_1759 vgnd.n11059 vgnd.n31 32227.09660777188
rmesh_equiv_176 bias_source__vcm_raw bias_source__vcm_raw.n12 5.2670000000000003
rmesh_equiv_1760 vgnd.n11063 vgnd.n11064 372.51192942726937
rmesh_equiv_1761 vgnd.n11063 vgnd.n11452 4767.2197327612421
rmesh_equiv_1762 vgnd.n11063 vgnd.n11454 3707.6307041025889
rmesh_equiv_1763 vgnd.n11063 vgnd.n11458 2913.7764665932355
rmesh_equiv_1764 vgnd.n11063 vgnd.n11460 27976.919306164025
rmesh_equiv_1765 vgnd.n11063 vgnd.n11465 938.43491086663073
rmesh_equiv_1766 vgnd.n11063 vgnd.n11466 5779.2060076952203
rmesh_equiv_1767 vgnd.n11063 vgnd.t64 750.02349956157047
rmesh_equiv_1768 vgnd.n11064 vgnd.n11452 111.4404797148738
rmesh_equiv_1769 vgnd.n11064 vgnd.n11454 1283.4372649595321
rmesh_equiv_177 bias_source__vcm_raw bias_source__vcm_raw.n13 18.567278598032573
rmesh_equiv_1770 vgnd.n11064 vgnd.n11458 2802.7303776634262
rmesh_equiv_1771 vgnd.n11064 vgnd.n11460 48622.954449345532
rmesh_equiv_1772 vgnd.n11064 vgnd.n11465 3066.8922240739039
rmesh_equiv_1773 vgnd.n11064 vgnd.n11466 3862.709264397643
rmesh_equiv_1774 vgnd.n11064 vgnd.t64 5180.9461847087432
rmesh_equiv_1775 vgnd.n11136 vgnd.n11403 25.56023786733061
rmesh_equiv_1776 vgnd.n11136 vgnd.t13 1152.9752911643748
rmesh_equiv_1777 vgnd.n11136 vgnd.t40 1050.9864577431479
rmesh_equiv_1778 vgnd.n11136 vgnd.t58 883.43472200912038
rmesh_equiv_1779 vgnd.n11136 vgnd.t7 3218.8265353245642
rmesh_equiv_178 bias_source__vcm_raw bias_source__vcm_raw.n2 5.2670000000000003
rmesh_equiv_1780 vgnd.n11136 vgnd.t74 7181.2494667601568
rmesh_equiv_1781 vgnd.n11136 vgnd.t82 700.79750179094594
rmesh_equiv_1782 vgnd.n11136 vgnd.t84 13882.677713466039
rmesh_equiv_1783 vgnd.n11403 vgnd.n283 48.527558766506289
rmesh_equiv_1784 vgnd.n11403 vgnd.t48 19595.277926970139
rmesh_equiv_1785 vgnd.n11403 vgnd.t65 194.45088220935435
rmesh_equiv_1786 vgnd.n11403 vgnd.t7 1801.1684204296741
rmesh_equiv_1787 vgnd.n11403 vgnd.t70 700.79750179094594
rmesh_equiv_1788 vgnd.n11403 vgnd.t72 1266.1557474562821
rmesh_equiv_1789 vgnd.n11403 vgnd.t74 1120.7245023682574
rmesh_equiv_179 bias_source__vcm_raw bias_source__vcm_raw.n3 5.2670000000000003
rmesh_equiv_1790 vgnd.n11403 vgnd.t84 3487.969627210512
rmesh_equiv_1791 vgnd.n11452 vgnd.n11454 490.82146097356735
rmesh_equiv_1792 vgnd.n11452 vgnd.n11458 4103.452969453575
rmesh_equiv_1793 vgnd.n11452 vgnd.n11460 113799.7118399467
rmesh_equiv_1794 vgnd.n11452 vgnd.n20 2907.182741116751
rmesh_equiv_1795 vgnd.n11452 vgnd.n22 456.68709884853035
rmesh_equiv_1796 vgnd.n11452 vgnd.n23 4648.152907491889
rmesh_equiv_1797 vgnd.n11452 vgnd.n29 873.73093821757845
rmesh_equiv_1798 vgnd.n11452 vgnd.n30 12801.615350890532
rmesh_equiv_1799 vgnd.n11452 vgnd.t64 12125.758081861317
rmesh_equiv_18 amplified.n4 amplified.t3 0.71462499999999995
rmesh_equiv_180 bias_source__vcm_raw bias_source__vcm_raw.n4 5.2670000000000003
rmesh_equiv_1800 vgnd.n11454 vgnd.n11458 734.13245049930845
rmesh_equiv_1801 vgnd.n11454 vgnd.n11460 35222.762825824939
rmesh_equiv_1802 vgnd.n11454 vgnd.n11461 51669.81955029181
rmesh_equiv_1803 vgnd.n11454 vgnd.n11534 59385.913039037696
rmesh_equiv_1804 vgnd.n11454 vgnd.n20 804.98025257912957
rmesh_equiv_1805 vgnd.n11454 vgnd.n22 1318.7213675213677
rmesh_equiv_1806 vgnd.n11454 vgnd.n26 25391.128824674644
rmesh_equiv_1807 vgnd.n11454 vgnd.t64 9430.6189970372761
rmesh_equiv_1808 vgnd.n11458 vgnd.n11460 857.52565601319282
rmesh_equiv_1809 vgnd.n11458 vgnd.n11461 2630.3319870673336
rmesh_equiv_181 bias_source__vcm_raw bias_source__vcm_raw.n5 5.2670000000000003
rmesh_equiv_1810 vgnd.n11458 vgnd.n11534 7290.9968660935474
rmesh_equiv_1811 vgnd.n11458 vgnd.n20 283.6151301520573
rmesh_equiv_1812 vgnd.n11458 vgnd.n26 2327.3453635249139
rmesh_equiv_1813 vgnd.n11458 vgnd.t64 207.58750823345463
rmesh_equiv_1814 vgnd.n11460 vgnd.n11461 467.49924574416889
rmesh_equiv_1815 vgnd.n11460 vgnd.n11534 11584.37604232969
rmesh_equiv_1816 vgnd.n11460 vgnd.n20 7228.417690051625
rmesh_equiv_1817 vgnd.n11460 vgnd.n26 2750.4912927718901
rmesh_equiv_1818 vgnd.n11460 vgnd.t64 988.24911233058674
rmesh_equiv_1819 vgnd.n11461 vgnd.n11465 4837.8877557227088
rmesh_equiv_182 bias_source__vcm_raw bias_source__vcm_raw.n6 5.2670000000000003
rmesh_equiv_1820 vgnd.n11461 vgnd.n11466 5300.182657209536
rmesh_equiv_1821 vgnd.n11461 vgnd.n11469 110.70451417601892
rmesh_equiv_1822 vgnd.n11461 vgnd.n11534 10230.665750993165
rmesh_equiv_1823 vgnd.n11461 vgnd.n20 6383.7296912033053
rmesh_equiv_1824 vgnd.n11461 vgnd.n26 79.403051027488701
rmesh_equiv_1825 vgnd.n11465 vgnd.n11466 120.54481094527527
rmesh_equiv_1826 vgnd.n11465 vgnd.n11469 3223.8308174140816
rmesh_equiv_1827 vgnd.n11465 vgnd.t64 213.5694245415385
rmesh_equiv_1828 vgnd.n11466 vgnd.n11469 1177.2255441815655
rmesh_equiv_1829 vgnd.n11469 vgnd.n11483 330763.18805574731
rmesh_equiv_183 bias_source__vcm_raw bias_source__vcm_raw.n7 5.2670000000000003
rmesh_equiv_1830 vgnd.n11469 vgnd.n11536 683.58109234131871
rmesh_equiv_1831 vgnd.n11469 vgnd.n31 45045.77456505291
rmesh_equiv_1832 vgnd.n11483 vgnd.n11498 418.81095235442848
rmesh_equiv_1833 vgnd.n11483 vgnd.n11502 564.64279412857195
rmesh_equiv_1834 vgnd.n11483 vgnd.n11507 772.78642150706173
rmesh_equiv_1835 vgnd.n11483 vgnd.n11536 12244.49274888453
rmesh_equiv_1836 vgnd.n11483 vgnd.n31 17962.34739974832
rmesh_equiv_1837 vgnd.n11498 vgnd.n11502 1688.7542589498369
rmesh_equiv_1838 vgnd.n11498 vgnd.n11507 578.08879387674335
rmesh_equiv_1839 vgnd.n11498 vgnd.n11509 21330.826247294695
rmesh_equiv_184 bias_source__vcm_raw bias_source__vcm_raw.n8 5.2670000000000003
rmesh_equiv_1840 vgnd.n11498 vgnd.n11511 110.69741612476514
rmesh_equiv_1841 vgnd.n11498 vgnd.t71 10827.973002634515
rmesh_equiv_1842 vgnd.n11502 vgnd.n11507 1242.4574872579303
rmesh_equiv_1843 vgnd.n11502 vgnd.n11509 12984.958894523295
rmesh_equiv_1844 vgnd.n11502 vgnd.n11511 2190.3633693131251
rmesh_equiv_1845 vgnd.n11502 vgnd.t71 192.0378029286808
rmesh_equiv_1846 vgnd.n11507 vgnd.n11509 1360.2943953347958
rmesh_equiv_1847 vgnd.n11507 vgnd.n11515 1660.4328877655012
rmesh_equiv_1848 vgnd.n11507 vgnd.n11517 756.39626287053704
rmesh_equiv_1849 vgnd.n11507 vgnd.n11519 175.54023166265264
rmesh_equiv_185 bias_source__vcm_raw bias_source__vcm_raw.n9 5.2670000000000003
rmesh_equiv_1850 vgnd.n11509 vgnd.n11511 2032.233396872499
rmesh_equiv_1851 vgnd.n11509 vgnd.n11515 262.70246824174558
rmesh_equiv_1852 vgnd.n11509 vgnd.n11517 6617.8115058109506
rmesh_equiv_1853 vgnd.n11509 vgnd.n11519 14034.139288726758
rmesh_equiv_1854 vgnd.n11509 vgnd.t71 57.955579571446137
rmesh_equiv_1855 vgnd.n11511 vgnd.n11515 1803.4281700240495
rmesh_equiv_1856 vgnd.n11511 vgnd.n11517 23582.568770369326
rmesh_equiv_1857 vgnd.n11511 vgnd.n11519 105218.46212865131
rmesh_equiv_1858 vgnd.n11511 vgnd.n11526 2285.9076179467384
rmesh_equiv_1859 vgnd.n11511 vgnd.t71 3427.697533530898
rmesh_equiv_186 bias_source__vcm_raw bias_source__vcm_raw.t10 212.21199999999999
rmesh_equiv_1860 vgnd.n11515 vgnd.n11517 627.0095784982999
rmesh_equiv_1861 vgnd.n11515 vgnd.n11519 5719.3005474907086
rmesh_equiv_1862 vgnd.n11515 vgnd.n11526 367.05457163549693
rmesh_equiv_1863 vgnd.n11517 vgnd.n11519 803.60933813001338
rmesh_equiv_1864 vgnd.n11517 vgnd.n11526 1135.9697952690883
rmesh_equiv_1865 vgnd.n11519 vgnd.n11526 878.51314191516508
rmesh_equiv_1866 vgnd.n11526 vgnd.n11534 2266241.3689493109
rmesh_equiv_1867 vgnd.n11526 vgnd.n23 4765.59386291999
rmesh_equiv_1868 vgnd.n11526 vgnd.n26 1661251.3019131303
rmesh_equiv_1869 vgnd.n11526 vgnd.n29 331089.77652937692
rmesh_equiv_187 bias_source__vcm_raw bias_source__vcm_raw.t11 0.00141837
rmesh_equiv_1870 vgnd.n11526 vgnd.n30 44697.648801013624
rmesh_equiv_1871 vgnd.n11526 vgnd.n31 10249.751311058715
rmesh_equiv_1872 vgnd.n11534 vgnd.n11536 779.74432942899966
rmesh_equiv_1873 vgnd.n11534 vgnd.n20 1545.547408760199
rmesh_equiv_1874 vgnd.n11534 vgnd.n22 167199.53694989509
rmesh_equiv_1875 vgnd.n11534 vgnd.n23 797.58904197458162
rmesh_equiv_1876 vgnd.n11534 vgnd.n26 391.16356023259539
rmesh_equiv_1877 vgnd.n11534 vgnd.n29 295265.52012087195
rmesh_equiv_1878 vgnd.n11534 vgnd.n30 10037.863468999571
rmesh_equiv_1879 vgnd.n11534 vgnd.n31 12728714.69075371
rmesh_equiv_188 bias_source__vcm_raw bias_source__vcm_raw.t12 0.00141837
rmesh_equiv_1880 vgnd.n11536 vgnd.n20 84.333799999999997
rmesh_equiv_1881 vgnd.n11536 vgnd.n22 779.74432942899966
rmesh_equiv_1882 vgnd.n11536 vgnd.n23 11.238341723875559
rmesh_equiv_1883 vgnd.n11536 vgnd.n31 1667.5454825302882
rmesh_equiv_1884 vgnd.n11536 vgnd.t0 651.94729176104249
rmesh_equiv_1885 vgnd.n11536 vgnd.t12 7825.8245925990186
rmesh_equiv_1886 vgnd.n11536 vgnd.t3 651.94729176104249
rmesh_equiv_1887 vgnd.n11536 vgnd.t39 651.94729176104249
rmesh_equiv_1888 vgnd.n11536 vgnd.t4 17074.104095630344
rmesh_equiv_1889 vgnd.n11536 vgnd.t57 651.94729176104249
rmesh_equiv_189 bias_source__vcm_raw bias_source__vcm_raw.t13 0.00141837
rmesh_equiv_1890 vgnd.n11536 vgnd.t6 17074.104095630344
rmesh_equiv_1891 vgnd.n11536 vgnd.t64 17.6065
rmesh_equiv_1892 vgnd.n11536 vgnd.t69 17074.104095630344
rmesh_equiv_1893 vgnd.n11536 vgnd.t73 651.94729176104249
rmesh_equiv_1894 vgnd.n11536 vgnd.t79 17074.104095630344
rmesh_equiv_1895 vgnd.n11536 vgnd.t81 651.94729176104249
rmesh_equiv_1896 vgnd.n11536 vgnd.t83 651.94729176104249
rmesh_equiv_1897 vgnd.n1518 vgnd.n1519 207541.31937169004
rmesh_equiv_1898 vgnd.n1518 vgnd.n1547 1136538.1839637177
rmesh_equiv_1899 vgnd.n1518 vgnd.n1559 5407.105392814633
rmesh_equiv_19 amplified.n5 amplified.n6 0.27270899999999998
rmesh_equiv_190 bias_source__vcm_raw bias_source__vcm_raw.t14 0.00141837
rmesh_equiv_1900 vgnd.n1518 vgnd.n1565 1861.1415946970819
rmesh_equiv_1901 vgnd.n1518 vgnd.n1598 12305.085349681374
rmesh_equiv_1902 vgnd.n1518 vgnd.n1600 526.22552770447749
rmesh_equiv_1903 vgnd.n1518 vgnd.n1610 680.81051771011187
rmesh_equiv_1904 vgnd.n1518 vgnd.n9530 19719173.704739027
rmesh_equiv_1905 vgnd.n1518 vgnd.t22 9486.6951279932673
rmesh_equiv_1906 vgnd.n1518 vgnd.t44 884.1291348700031
rmesh_equiv_1907 vgnd.n1518 vgnd.t88 14913.295788439395
rmesh_equiv_1908 vgnd.n1519 vgnd.n1547 1129868.2022795
rmesh_equiv_1909 vgnd.n1519 vgnd.n1559 8518.8704474047481
rmesh_equiv_191 bias_source__vcm_raw bias_source__vcm_raw.t15 0.00141837
rmesh_equiv_1910 vgnd.n1519 vgnd.n1563 1105.8560684540639
rmesh_equiv_1911 vgnd.n1519 vgnd.n1606 2895.8018898371597
rmesh_equiv_1912 vgnd.n1519 vgnd.n1608 369.59779367798893
rmesh_equiv_1913 vgnd.n1519 vgnd.n1610 1540.0362363369115
rmesh_equiv_1914 vgnd.n1519 vgnd.n9530 347056028.9250524
rmesh_equiv_1915 vgnd.n1519 vgnd.t22 166965.14712240366
rmesh_equiv_1916 vgnd.n1519 vgnd.t88 14825.774391302253
rmesh_equiv_1917 vgnd.n1547 vgnd.n8846 166095256787.72879
rmesh_equiv_1918 vgnd.n1547 vgnd.n9530 1900548912.5841174
rmesh_equiv_1919 vgnd.n1547 vgnd.t104 220302221.89836472
rmesh_equiv_192 bias_source__vcm_raw bias_source__vcm_raw.t2 0.00141837
rmesh_equiv_1920 vgnd.n1547 vgnd.t20 8702.2851504615446
rmesh_equiv_1921 vgnd.n1547 vgnd.t21 76.159813064286055
rmesh_equiv_1922 vgnd.n1547 vgnd.t22 914334.86917312315
rmesh_equiv_1923 vgnd.n1547 vgnd.t67 989532.31490029069
rmesh_equiv_1924 vgnd.n1547 vgnd.t88 576.81706584442247
rmesh_equiv_1925 vgnd.n1559 vgnd.n1563 25511.409503124058
rmesh_equiv_1926 vgnd.n1559 vgnd.n1565 14722.075518278534
rmesh_equiv_1927 vgnd.n1559 vgnd.n1598 743.94079028835688
rmesh_equiv_1928 vgnd.n1559 vgnd.n1600 7559.8315777736861
rmesh_equiv_1929 vgnd.n1559 vgnd.n1606 35149.541188472424
rmesh_equiv_193 bias_source__vcm_raw bias_source__vcm_raw.t3 0.00141837
rmesh_equiv_1930 vgnd.n1559 vgnd.n1608 697.55506021508097
rmesh_equiv_1931 vgnd.n1559 vgnd.n1610 352.8780814232282
rmesh_equiv_1932 vgnd.n1559 vgnd.t44 3987.4343783077097
rmesh_equiv_1933 vgnd.n1563 vgnd.n1565 11825.13468727295
rmesh_equiv_1934 vgnd.n1563 vgnd.n1598 7328.6908875007684
rmesh_equiv_1935 vgnd.n1563 vgnd.n1600 6656.4879854530382
rmesh_equiv_1936 vgnd.n1563 vgnd.n1606 472.41796020972009
rmesh_equiv_1937 vgnd.n1563 vgnd.n1608 641.99811307556843
rmesh_equiv_1938 vgnd.n1563 vgnd.n1610 15821.414558644625
rmesh_equiv_1939 vgnd.n1565 vgnd.n1598 1481.5396722393079
rmesh_equiv_194 bias_source__vcm_raw bias_source__vcm_raw.t4 0.00141837
rmesh_equiv_1940 vgnd.n1565 vgnd.n1600 349.98269739429838
rmesh_equiv_1941 vgnd.n1565 vgnd.n1606 6656.4879854530382
rmesh_equiv_1942 vgnd.n1565 vgnd.n1608 7328.6908875007684
rmesh_equiv_1943 vgnd.n1565 vgnd.n1610 4040.4316579407378
rmesh_equiv_1944 vgnd.n1565 vgnd.t44 608.40282688822072
rmesh_equiv_1945 vgnd.n1598 vgnd.n1600 1586.8066286580693
rmesh_equiv_1946 vgnd.n1598 vgnd.n1606 4125.3942666929725
rmesh_equiv_1947 vgnd.n1598 vgnd.n1608 263.01346535148565
rmesh_equiv_1948 vgnd.n1598 vgnd.n1610 2445.7040838288308
rmesh_equiv_1949 vgnd.n1598 vgnd.t44 57.720611180958343
rmesh_equiv_195 bias_source__vcm_raw bias_source__vcm_raw.t5 0.00141837
rmesh_equiv_1950 vgnd.n1600 vgnd.n1606 51.600789359185825
rmesh_equiv_1951 vgnd.n1600 vgnd.n1608 4125.3942666929725
rmesh_equiv_1952 vgnd.n1600 vgnd.n1610 1118.8989765236236
rmesh_equiv_1953 vgnd.n1600 vgnd.t44 1922.4930724746139
rmesh_equiv_1954 vgnd.n1606 vgnd.n1608 1703.5636641986459
rmesh_equiv_1955 vgnd.n1606 vgnd.n1610 233783.07302186851
rmesh_equiv_1956 vgnd.n1608 vgnd.n1610 1215.9640626449034
rmesh_equiv_1957 vgnd.n1610 vgnd.t44 1277.3195072841893
rmesh_equiv_1958 vgnd.n173 vgnd.n175 325.34835822672733
rmesh_equiv_1959 vgnd.n173 vgnd.n176 4626.712853654084
rmesh_equiv_196 bias_source__vcm_raw bias_source__vcm_raw.t6 212.21199999999999
rmesh_equiv_1960 vgnd.n173 vgnd.n242 1117.7204424337228
rmesh_equiv_1961 vgnd.n173 vgnd.n277 5273409.3915080884
rmesh_equiv_1962 vgnd.n173 vgnd.n31 259637.84494785187
rmesh_equiv_1963 vgnd.n173 vgnd.t101 4260.4245392826133
rmesh_equiv_1964 vgnd.n173 vgnd.t124 484.66430302803167
rmesh_equiv_1965 vgnd.n173 vgnd.t49 3993.6264031402607
rmesh_equiv_1966 vgnd.n175 vgnd.n176 5924.9699095592487
rmesh_equiv_1967 vgnd.n175 vgnd.n242 302.19480860296534
rmesh_equiv_1968 vgnd.n175 vgnd.n277 1335875.8719222511
rmesh_equiv_1969 vgnd.n175 vgnd.t101 1079.2635131530137
rmesh_equiv_197 bias_source__vcm_raw bias_source__vcm_raw.t7 0.00141837
rmesh_equiv_1970 vgnd.n175 vgnd.t124 23.856330461114439
rmesh_equiv_1971 vgnd.n176 vgnd.n242 31165.38415388139
rmesh_equiv_1972 vgnd.n176 vgnd.n31 650871.85268604441
rmesh_equiv_1973 vgnd.n176 vgnd.t124 380.30652762209542
rmesh_equiv_1974 vgnd.n176 vgnd.t49 10011.402676947504
rmesh_equiv_1975 vgnd.n1791 vgnd.n8583 10186.744570591349
rmesh_equiv_1976 vgnd.n1791 vgnd.n8589 16261.388653193309
rmesh_equiv_1977 vgnd.n1791 vgnd.n8636 17181.03661143349
rmesh_equiv_1978 vgnd.n1791 vgnd.n8670 2188.361284353382
rmesh_equiv_1979 vgnd.n1791 vgnd.n8775 51247.600795736646
rmesh_equiv_198 bias_source__vcm_raw bias_source__vcm_raw.t8 0.00141837
rmesh_equiv_1980 vgnd.n1791 vgnd.n8794 307.56238387920638
rmesh_equiv_1981 vgnd.n1791 vgnd.n8796 428.95251280780155
rmesh_equiv_1982 vgnd.n1791 vgnd.n8846 33336.104609128815
rmesh_equiv_1983 vgnd.n1791 vgnd.t85 76927.762728391826
rmesh_equiv_1984 vgnd.n20 vgnd.n22 1958.0000000000005
rmesh_equiv_1985 vgnd.n20 vgnd.n26 1508.8695198394278
rmesh_equiv_1986 vgnd.n22 vgnd.n23 1062.860476976309
rmesh_equiv_1987 vgnd.n22 vgnd.n29 1191.9239402486937
rmesh_equiv_1988 vgnd.n22 vgnd.n30 181626.07761903253
rmesh_equiv_1989 vgnd.n23 vgnd.n26 1557.5855938903476
rmesh_equiv_199 bias_source__vcm_raw bias_source__vcm_raw.t9 0.00141837
rmesh_equiv_1990 vgnd.n23 vgnd.n29 466.87923367670669
rmesh_equiv_1991 vgnd.n23 vgnd.n30 235.41256111584806
rmesh_equiv_1992 vgnd.n23 vgnd.n31 26766.736078619426
rmesh_equiv_1993 vgnd.n2370 vgnd.n2371 229745.27393611975
rmesh_equiv_1994 vgnd.n2370 vgnd.n2407 5407.105392814633
rmesh_equiv_1995 vgnd.n2370 vgnd.n2413 1861.1415946970819
rmesh_equiv_1996 vgnd.n2370 vgnd.n2446 12305.085349681374
rmesh_equiv_1997 vgnd.n2370 vgnd.n2448 526.22552770447749
rmesh_equiv_1998 vgnd.n2370 vgnd.n2458 680.81051771011187
rmesh_equiv_1999 vgnd.n2370 vgnd.n7801 11043.188900552921
rmesh_equiv_2 amplified amplified.n2 18.337124227710543
rmesh_equiv_20 amplified.n6 amplified.n7 20.304500000000001
rmesh_equiv_200 bias_source__vcm_raw.n0 bias_source__vcm_raw.n1 4.4643300000000004
rmesh_equiv_2000 vgnd.n2370 vgnd.n7937 1813077616.1398926
rmesh_equiv_2001 vgnd.n2370 vgnd.t130 884.1291348700031
rmesh_equiv_2002 vgnd.n2370 vgnd.t42 9538.7413994787457
rmesh_equiv_2003 vgnd.n2370 vgnd.t93 26704159.862880595
rmesh_equiv_2004 vgnd.n2371 vgnd.n2407 8518.8704474047481
rmesh_equiv_2005 vgnd.n2371 vgnd.n2411 1105.8560684540639
rmesh_equiv_2006 vgnd.n2371 vgnd.n2454 2895.8018898371597
rmesh_equiv_2007 vgnd.n2371 vgnd.n2456 369.59779367798893
rmesh_equiv_2008 vgnd.n2371 vgnd.n2458 1540.0362363369115
rmesh_equiv_2009 vgnd.n2371 vgnd.n7801 10978.379950094703
rmesh_equiv_201 bias_source__vcm_raw.n0 bias_source__vcm_raw.t0 25.840499999999999
rmesh_equiv_2010 vgnd.n2371 vgnd.n7937 35131117350.532684
rmesh_equiv_2011 vgnd.n2371 vgnd.t42 184827.52227393669
rmesh_equiv_2012 vgnd.n2371 vgnd.t93 517433432.26948631
rmesh_equiv_2013 vgnd.n2407 vgnd.n2411 25511.409503124058
rmesh_equiv_2014 vgnd.n2407 vgnd.n2413 14722.075518278534
rmesh_equiv_2015 vgnd.n2407 vgnd.n2446 743.94079028835688
rmesh_equiv_2016 vgnd.n2407 vgnd.n2448 7559.8315777736861
rmesh_equiv_2017 vgnd.n2407 vgnd.n2454 35149.541188472424
rmesh_equiv_2018 vgnd.n2407 vgnd.n2456 697.55506021508097
rmesh_equiv_2019 vgnd.n2407 vgnd.n2458 352.8780814232282
rmesh_equiv_202 bias_source__vcm_raw.n0 bias_source__vcm_raw.t1 35.954099999999997
rmesh_equiv_2020 vgnd.n2407 vgnd.t130 3987.4343783077097
rmesh_equiv_2021 vgnd.n2411 vgnd.n2413 11825.13468727295
rmesh_equiv_2022 vgnd.n2411 vgnd.n2446 7328.6908875007684
rmesh_equiv_2023 vgnd.n2411 vgnd.n2448 6656.4879854530382
rmesh_equiv_2024 vgnd.n2411 vgnd.n2454 472.41796020972009
rmesh_equiv_2025 vgnd.n2411 vgnd.n2456 641.99811307556843
rmesh_equiv_2026 vgnd.n2411 vgnd.n2458 15821.414558644625
rmesh_equiv_2027 vgnd.n2413 vgnd.n2446 1481.5396722393079
rmesh_equiv_2028 vgnd.n2413 vgnd.n2448 349.98269739429838
rmesh_equiv_2029 vgnd.n2413 vgnd.n2454 6656.4879854530382
rmesh_equiv_203 bias_source__vcm_raw.n1 bias_source__vcm_raw.n2 4.1529499999999997
rmesh_equiv_2030 vgnd.n2413 vgnd.n2456 7328.6908875007684
rmesh_equiv_2031 vgnd.n2413 vgnd.n2458 4040.4316579407378
rmesh_equiv_2032 vgnd.n2413 vgnd.t130 608.40282688822072
rmesh_equiv_2033 vgnd.n242 vgnd.n277 3522899.4188228087
rmesh_equiv_2034 vgnd.n242 vgnd.t101 2846.1752196874036
rmesh_equiv_2035 vgnd.n242 vgnd.t124 46273.476472133538
rmesh_equiv_2036 vgnd.n2446 vgnd.n2448 1586.8066286580693
rmesh_equiv_2037 vgnd.n2446 vgnd.n2454 4125.3942666929725
rmesh_equiv_2038 vgnd.n2446 vgnd.n2456 263.01346535148565
rmesh_equiv_2039 vgnd.n2446 vgnd.n2458 2445.7040838288308
rmesh_equiv_204 bias_source__vcm_raw.n10 bias_source__vcm_raw.n11 4.1529499999999997
rmesh_equiv_2040 vgnd.n2446 vgnd.t130 57.720611180958343
rmesh_equiv_2041 vgnd.n2448 vgnd.n2454 51.600789359185825
rmesh_equiv_2042 vgnd.n2448 vgnd.n2456 4125.3942666929725
rmesh_equiv_2043 vgnd.n2448 vgnd.n2458 1118.8989765236236
rmesh_equiv_2044 vgnd.n2448 vgnd.t130 1922.4930724746139
rmesh_equiv_2045 vgnd.n2454 vgnd.n2456 1703.5636641986459
rmesh_equiv_2046 vgnd.n2454 vgnd.n2458 233783.07302186851
rmesh_equiv_2047 vgnd.n2456 vgnd.n2458 1215.9640626449034
rmesh_equiv_2048 vgnd.n2458 vgnd.t130 1277.3195072841893
rmesh_equiv_2049 vgnd.n26 vgnd.n29 216442.18326941476
rmesh_equiv_205 bias_source__vcm_raw.n10 bias_source__vcm_raw.n9 4.1529499999999997
rmesh_equiv_2050 vgnd.n26 vgnd.n30 4842.441775030592
rmesh_equiv_2051 vgnd.n26 vgnd.n31 9330689.1937547866
rmesh_equiv_2052 vgnd.n277 vgnd.n324 153319.44437726118
rmesh_equiv_2053 vgnd.n277 vgnd.n325 2698411.1159677994
rmesh_equiv_2054 vgnd.n277 vgnd.n353 14777044.294669205
rmesh_equiv_2055 vgnd.n277 vgnd.t101 10607.939281464838
rmesh_equiv_2056 vgnd.n277 vgnd.t128 193899.71718918314
rmesh_equiv_2057 vgnd.n277 vgnd.t47 79.251568349865551
rmesh_equiv_2058 vgnd.n283 vgnd.t118 743.8664051013684
rmesh_equiv_2059 vgnd.n283 vgnd.t132 144.13382806736607
rmesh_equiv_206 bias_source__vcm_raw.n11 bias_source__vcm_raw.n12 4.1529499999999997
rmesh_equiv_2060 vgnd.n283 vgnd.t48 908.63052454972944
rmesh_equiv_2061 vgnd.n283 vgnd.t52 23.487115775450871
rmesh_equiv_2062 vgnd.n283 vgnd.t65 4334.7876999133123
rmesh_equiv_2063 vgnd.n283 vgnd.t72 10248.988980870685
rmesh_equiv_2064 vgnd.n283 vgnd.t92 53.953127522071853
rmesh_equiv_2065 vgnd.n2839 vgnd.n2886 154160.99033347151
rmesh_equiv_2066 vgnd.n2839 vgnd.n2887 2987102.0380308134
rmesh_equiv_2067 vgnd.n2839 vgnd.n7206 143581.33034054449
rmesh_equiv_2068 vgnd.n2839 vgnd.n7633 782653268316.44653
rmesh_equiv_2069 vgnd.n2839 vgnd.t16 10603.377817580238
rmesh_equiv_207 bias_source__vcm_raw.n12 bias_source__vcm_raw.n13 2.8816000000000002
rmesh_equiv_2070 vgnd.n2839 vgnd.t19 1096902.1871954857
rmesh_equiv_2071 vgnd.n2839 vgnd.t54 10269729537.325268
rmesh_equiv_2072 vgnd.n2839 vgnd.t59 79.251833029514273
rmesh_equiv_2073 vgnd.n2839 vgnd.t94 106944325.51368558
rmesh_equiv_2074 vgnd.n2886 vgnd.n2887 229752.29953256232
rmesh_equiv_2075 vgnd.n2886 vgnd.n2923 5407.105392814633
rmesh_equiv_2076 vgnd.n2886 vgnd.n2929 1861.1415946970819
rmesh_equiv_2077 vgnd.n2886 vgnd.n2962 12305.085349681374
rmesh_equiv_2078 vgnd.n2886 vgnd.n2964 526.22552770447749
rmesh_equiv_2079 vgnd.n2886 vgnd.n2974 680.81051771011187
rmesh_equiv_208 bias_source__vcm_raw.n2 bias_source__vcm_raw.n3 4.1529499999999997
rmesh_equiv_2080 vgnd.n2886 vgnd.n7206 11043.526600594909
rmesh_equiv_2081 vgnd.n2886 vgnd.t59 10018.138723095937
rmesh_equiv_2082 vgnd.n2886 vgnd.t61 884.1291348700031
rmesh_equiv_2083 vgnd.n2887 vgnd.n2923 8518.8704474047481
rmesh_equiv_2084 vgnd.n2887 vgnd.n2927 1105.8560684540639
rmesh_equiv_2085 vgnd.n2887 vgnd.n2970 2895.8018898371597
rmesh_equiv_2086 vgnd.n2887 vgnd.n2972 369.59779367798893
rmesh_equiv_2087 vgnd.n2887 vgnd.n2974 1540.0362363369115
rmesh_equiv_2088 vgnd.n2887 vgnd.n7206 10978.397173953683
rmesh_equiv_2089 vgnd.n2887 vgnd.t59 194116.56951802745
rmesh_equiv_209 bias_source__vcm_raw.n3 bias_source__vcm_raw.n4 4.1529499999999997
rmesh_equiv_2090 vgnd.n29 vgnd.n30 1552.2856465888074
rmesh_equiv_2091 vgnd.n29 vgnd.n31 1859619.7917001774
rmesh_equiv_2092 vgnd.n2923 vgnd.n2927 25511.409503124058
rmesh_equiv_2093 vgnd.n2923 vgnd.n2929 14722.075518278534
rmesh_equiv_2094 vgnd.n2923 vgnd.n2962 743.94079028835688
rmesh_equiv_2095 vgnd.n2923 vgnd.n2964 7559.8315777736861
rmesh_equiv_2096 vgnd.n2923 vgnd.n2970 35149.541188472424
rmesh_equiv_2097 vgnd.n2923 vgnd.n2972 697.55506021508097
rmesh_equiv_2098 vgnd.n2923 vgnd.n2974 352.8780814232282
rmesh_equiv_2099 vgnd.n2923 vgnd.t61 3987.4343783077097
rmesh_equiv_21 amplified.n7 amplified.n8 0.91758700000000015
rmesh_equiv_210 bias_source__vcm_raw.n4 bias_source__vcm_raw.n5 4.1529499999999997
rmesh_equiv_2100 vgnd.n2927 vgnd.n2929 11825.13468727295
rmesh_equiv_2101 vgnd.n2927 vgnd.n2962 7328.6908875007684
rmesh_equiv_2102 vgnd.n2927 vgnd.n2964 6656.4879854530382
rmesh_equiv_2103 vgnd.n2927 vgnd.n2970 472.41796020972009
rmesh_equiv_2104 vgnd.n2927 vgnd.n2972 641.99811307556843
rmesh_equiv_2105 vgnd.n2927 vgnd.n2974 15821.414558644625
rmesh_equiv_2106 vgnd.n2929 vgnd.n2962 1481.5396722393079
rmesh_equiv_2107 vgnd.n2929 vgnd.n2964 349.98269739429838
rmesh_equiv_2108 vgnd.n2929 vgnd.n2970 6656.4879854530382
rmesh_equiv_2109 vgnd.n2929 vgnd.n2972 7328.6908875007684
rmesh_equiv_211 bias_source__vcm_raw.n5 bias_source__vcm_raw.n6 4.1529499999999997
rmesh_equiv_2110 vgnd.n2929 vgnd.n2974 4040.4316579407378
rmesh_equiv_2111 vgnd.n2929 vgnd.t61 608.40282688822072
rmesh_equiv_2112 vgnd.n2962 vgnd.n2964 1586.8066286580693
rmesh_equiv_2113 vgnd.n2962 vgnd.n2970 4125.3942666929725
rmesh_equiv_2114 vgnd.n2962 vgnd.n2972 263.01346535148565
rmesh_equiv_2115 vgnd.n2962 vgnd.n2974 2445.7040838288308
rmesh_equiv_2116 vgnd.n2962 vgnd.t61 57.720611180958343
rmesh_equiv_2117 vgnd.n2964 vgnd.n2970 51.600789359185825
rmesh_equiv_2118 vgnd.n2964 vgnd.n2972 4125.3942666929725
rmesh_equiv_2119 vgnd.n2964 vgnd.n2974 1118.8989765236236
rmesh_equiv_212 bias_source__vcm_raw.n6 bias_source__vcm_raw.n7 4.1529499999999997
rmesh_equiv_2120 vgnd.n2964 vgnd.t61 1922.4930724746139
rmesh_equiv_2121 vgnd.n2970 vgnd.n2972 1703.5636641986459
rmesh_equiv_2122 vgnd.n2970 vgnd.n2974 233783.07302186851
rmesh_equiv_2123 vgnd.n2972 vgnd.n2974 1215.9640626449034
rmesh_equiv_2124 vgnd.n2974 vgnd.t61 1277.3195072841893
rmesh_equiv_2125 vgnd.n30 vgnd.n31 251051.64292336139
rmesh_equiv_2126 vgnd.n31 vgnd.t124 75306.793293115144
rmesh_equiv_2127 vgnd.n31 vgnd.t49 564.07518576335258
rmesh_equiv_2128 vgnd.n3227 vgnd.n3228 229745.27393607757
rmesh_equiv_2129 vgnd.n3227 vgnd.n3268 5407.105392814633
rmesh_equiv_213 bias_source__vcm_raw.n7 bias_source__vcm_raw.n8 4.1529499999999997
rmesh_equiv_2130 vgnd.n3227 vgnd.n3274 1861.1415946970819
rmesh_equiv_2131 vgnd.n3227 vgnd.n3307 12305.085349681374
rmesh_equiv_2132 vgnd.n3227 vgnd.n3309 526.22552770447749
rmesh_equiv_2133 vgnd.n3227 vgnd.n3319 680.81051771011187
rmesh_equiv_2134 vgnd.n3227 vgnd.n6830 11043.188900550895
rmesh_equiv_2135 vgnd.n3227 vgnd.n7038 207095228264.54144
rmesh_equiv_2136 vgnd.n3227 vgnd.t1 9538.7413967399316
rmesh_equiv_2137 vgnd.n3227 vgnd.t112 2717438320.1930947
rmesh_equiv_2138 vgnd.n3227 vgnd.t95 26669849.264178019
rmesh_equiv_2139 vgnd.n3227 vgnd.t98 884.1291348700031
rmesh_equiv_214 bias_source__vcm_raw.n8 bias_source__vcm_raw.n9 4.1529499999999997
rmesh_equiv_2140 vgnd.n3228 vgnd.n3268 8518.8704474047481
rmesh_equiv_2141 vgnd.n3228 vgnd.n3272 1105.8560684540639
rmesh_equiv_2142 vgnd.n3228 vgnd.n3315 2895.8018898371597
rmesh_equiv_2143 vgnd.n3228 vgnd.n3317 369.59779367798893
rmesh_equiv_2144 vgnd.n3228 vgnd.n3319 1540.0362363369115
rmesh_equiv_2145 vgnd.n3228 vgnd.n6830 10978.379950094601
rmesh_equiv_2146 vgnd.n3228 vgnd.n7038 4012782851727.4014
rmesh_equiv_2147 vgnd.n3228 vgnd.t1 184827.52222086809
rmesh_equiv_2148 vgnd.n3228 vgnd.t112 52654471970.58773
rmesh_equiv_2149 vgnd.n3228 vgnd.t95 516768612.59565806
rmesh_equiv_215 bias_source_r_vcm_bottom_r0_n0.t0 bias_source_r_vcm_bottom_r0_n0.t1 62.627400000000002
rmesh_equiv_2150 vgnd.n324 vgnd.n325 207547.70044163943
rmesh_equiv_2151 vgnd.n324 vgnd.n353 1136573.1279916056
rmesh_equiv_2152 vgnd.n324 vgnd.n361 5407.105392814633
rmesh_equiv_2153 vgnd.n324 vgnd.n367 1861.1415946970819
rmesh_equiv_2154 vgnd.n324 vgnd.n400 12305.085349681374
rmesh_equiv_2155 vgnd.n324 vgnd.n402 526.22552770447749
rmesh_equiv_2156 vgnd.n324 vgnd.n412 680.81051771011187
rmesh_equiv_2157 vgnd.n324 vgnd.t117 884.1291348700031
rmesh_equiv_2158 vgnd.n324 vgnd.t128 14913.754312958223
rmesh_equiv_2159 vgnd.n324 vgnd.t47 9963.4509313728922
rmesh_equiv_216 bias_source_r_vcm_bottom_r0_n1.t0 bias_source_r_vcm_bottom_r0_n1.t1 52.8142
rmesh_equiv_2160 vgnd.n325 vgnd.n353 1129870.1644511432
rmesh_equiv_2161 vgnd.n325 vgnd.n361 8518.8704474047481
rmesh_equiv_2162 vgnd.n325 vgnd.n365 1105.8560684540639
rmesh_equiv_2163 vgnd.n325 vgnd.n408 2895.8018898371597
rmesh_equiv_2164 vgnd.n325 vgnd.n410 369.59779367798893
rmesh_equiv_2165 vgnd.n325 vgnd.n412 1540.0362363369115
rmesh_equiv_2166 vgnd.n325 vgnd.t128 14825.800138300036
rmesh_equiv_2167 vgnd.n325 vgnd.t47 175356.01473001242
rmesh_equiv_2168 vgnd.n3268 vgnd.n3272 25511.409503124058
rmesh_equiv_2169 vgnd.n3268 vgnd.n3274 14722.075518278534
rmesh_equiv_217 bias_source_r_vcm_top_r0_n0.t0 bias_source_r_vcm_top_r0_n0.t1 51.980899999999998
rmesh_equiv_2170 vgnd.n3268 vgnd.n3307 743.94079028835688
rmesh_equiv_2171 vgnd.n3268 vgnd.n3309 7559.8315777736861
rmesh_equiv_2172 vgnd.n3268 vgnd.n3315 35149.541188472424
rmesh_equiv_2173 vgnd.n3268 vgnd.n3317 697.55506021508097
rmesh_equiv_2174 vgnd.n3268 vgnd.n3319 352.8780814232282
rmesh_equiv_2175 vgnd.n3268 vgnd.t98 3987.4343783077097
rmesh_equiv_2176 vgnd.n3272 vgnd.n3274 11825.13468727295
rmesh_equiv_2177 vgnd.n3272 vgnd.n3307 7328.6908875007684
rmesh_equiv_2178 vgnd.n3272 vgnd.n3309 6656.4879854530382
rmesh_equiv_2179 vgnd.n3272 vgnd.n3315 472.41796020972009
rmesh_equiv_218 bias_source_r_vcm_top_r0_n1.t0 bias_source_r_vcm_top_r0_n1.t1 61.794099999999993
rmesh_equiv_2180 vgnd.n3272 vgnd.n3317 641.99811307556843
rmesh_equiv_2181 vgnd.n3272 vgnd.n3319 15821.414558644625
rmesh_equiv_2182 vgnd.n3274 vgnd.n3307 1481.5396722393079
rmesh_equiv_2183 vgnd.n3274 vgnd.n3309 349.98269739429838
rmesh_equiv_2184 vgnd.n3274 vgnd.n3315 6656.4879854530382
rmesh_equiv_2185 vgnd.n3274 vgnd.n3317 7328.6908875007684
rmesh_equiv_2186 vgnd.n3274 vgnd.n3319 4040.4316579407378
rmesh_equiv_2187 vgnd.n3274 vgnd.t98 608.40282688822072
rmesh_equiv_2188 vgnd.n3307 vgnd.n3309 1586.8066286580693
rmesh_equiv_2189 vgnd.n3307 vgnd.n3315 4125.3942666929725
rmesh_equiv_219 clk clk.n0 34.428166571090372
rmesh_equiv_2190 vgnd.n3307 vgnd.n3317 263.01346535148565
rmesh_equiv_2191 vgnd.n3307 vgnd.n3319 2445.7040838288308
rmesh_equiv_2192 vgnd.n3307 vgnd.t98 57.720611180958343
rmesh_equiv_2193 vgnd.n3309 vgnd.n3315 51.600789359185825
rmesh_equiv_2194 vgnd.n3309 vgnd.n3317 4125.3942666929725
rmesh_equiv_2195 vgnd.n3309 vgnd.n3319 1118.8989765236236
rmesh_equiv_2196 vgnd.n3309 vgnd.t98 1922.4930724746139
rmesh_equiv_2197 vgnd.n3315 vgnd.n3317 1703.5636641986459
rmesh_equiv_2198 vgnd.n3315 vgnd.n3319 233783.07302186851
rmesh_equiv_2199 vgnd.n3317 vgnd.n3319 1215.9640626449034
rmesh_equiv_22 amplified.n8 amplified.n9 20.304500000000001
rmesh_equiv_220 clk clk.n1 38.714300000000001
rmesh_equiv_2200 vgnd.n3319 vgnd.t98 1277.3195072841893
rmesh_equiv_2201 vgnd.n353 vgnd.t128 576.8170729612724
rmesh_equiv_2202 vgnd.n353 vgnd.t14 7688456885.0050449
rmesh_equiv_2203 vgnd.n353 vgnd.t47 960284.95497532666
rmesh_equiv_2204 vgnd.n353 vgnd.t53 8702.2826600134667
rmesh_equiv_2205 vgnd.n353 vgnd.t80 76.159813062728134
rmesh_equiv_2206 vgnd.n353 vgnd.t97 985866.51363591186
rmesh_equiv_2207 vgnd.n361 vgnd.n365 25511.409503124058
rmesh_equiv_2208 vgnd.n361 vgnd.n367 14722.075518278534
rmesh_equiv_2209 vgnd.n361 vgnd.n400 743.94079028835688
rmesh_equiv_221 clk clk.n2 38.698700000000002
rmesh_equiv_2210 vgnd.n361 vgnd.n402 7559.8315777736861
rmesh_equiv_2211 vgnd.n361 vgnd.n408 35149.541188472424
rmesh_equiv_2212 vgnd.n361 vgnd.n410 697.55506021508097
rmesh_equiv_2213 vgnd.n361 vgnd.n412 352.8780814232282
rmesh_equiv_2214 vgnd.n361 vgnd.t117 3987.4343783077097
rmesh_equiv_2215 vgnd.n365 vgnd.n367 11825.13468727295
rmesh_equiv_2216 vgnd.n365 vgnd.n400 7328.6908875007684
rmesh_equiv_2217 vgnd.n365 vgnd.n402 6656.4879854530382
rmesh_equiv_2218 vgnd.n365 vgnd.n408 472.41796020972009
rmesh_equiv_2219 vgnd.n365 vgnd.n410 641.99811307556843
rmesh_equiv_222 clk clk.n3 38.714300000000001
rmesh_equiv_2220 vgnd.n365 vgnd.n412 15821.414558644625
rmesh_equiv_2221 vgnd.n367 vgnd.n400 1481.5396722393079
rmesh_equiv_2222 vgnd.n367 vgnd.n402 349.98269739429838
rmesh_equiv_2223 vgnd.n367 vgnd.n408 6656.4879854530382
rmesh_equiv_2224 vgnd.n367 vgnd.n410 7328.6908875007684
rmesh_equiv_2225 vgnd.n367 vgnd.n412 4040.4316579407378
rmesh_equiv_2226 vgnd.n367 vgnd.t117 608.40282688822072
rmesh_equiv_2227 vgnd.n400 vgnd.n402 1586.8066286580693
rmesh_equiv_2228 vgnd.n400 vgnd.n408 4125.3942666929725
rmesh_equiv_2229 vgnd.n400 vgnd.n410 263.01346535148565
rmesh_equiv_223 clk clk.n4 19.953094958322954
rmesh_equiv_2230 vgnd.n400 vgnd.n412 2445.7040838288308
rmesh_equiv_2231 vgnd.n400 vgnd.t117 57.720611180958343
rmesh_equiv_2232 vgnd.n402 vgnd.n408 51.600789359185825
rmesh_equiv_2233 vgnd.n402 vgnd.n410 4125.3942666929725
rmesh_equiv_2234 vgnd.n402 vgnd.n412 1118.8989765236236
rmesh_equiv_2235 vgnd.n402 vgnd.t117 1922.4930724746139
rmesh_equiv_2236 vgnd.n408 vgnd.n410 1703.5636641986459
rmesh_equiv_2237 vgnd.n408 vgnd.n412 233783.07302186851
rmesh_equiv_2238 vgnd.n410 vgnd.n412 1215.9640626449034
rmesh_equiv_2239 vgnd.n412 vgnd.t117 1277.3195072841893
rmesh_equiv_224 clk clk.t0 330.34100000000001
rmesh_equiv_2240 vgnd.n4569 vgnd.n4670 746378.6956563167
rmesh_equiv_2241 vgnd.n4569 vgnd.n4673 746378.6956563167
rmesh_equiv_2242 vgnd.n4569 vgnd.n5955 27619.325654654323
rmesh_equiv_2243 vgnd.n4569 vgnd.n6662 2510918584498.8545
rmesh_equiv_2244 vgnd.n4569 vgnd.t107 9655.8466898486913
rmesh_equiv_2245 vgnd.n4569 vgnd.t108 5527763.4986834023
rmesh_equiv_2246 vgnd.n4569 vgnd.t113 32947482361.526062
rmesh_equiv_2247 vgnd.n4569 vgnd.t15 57356.715467764989
rmesh_equiv_2248 vgnd.n4569 vgnd.t50 589.18758653588225
rmesh_equiv_2249 vgnd.n4569 vgnd.t96 77.877304787219686
rmesh_equiv_225 clk clk.t1 330.34100000000001
rmesh_equiv_2250 vgnd.n4670 vgnd.n4673 28093.218968260451
rmesh_equiv_2251 vgnd.n4670 vgnd.n5943 4001.7919961119474
rmesh_equiv_2252 vgnd.n4670 vgnd.n5945 2020.2930039264036
rmesh_equiv_2253 vgnd.n4670 vgnd.n5949 671.27191274478537
rmesh_equiv_2254 vgnd.n4670 vgnd.n5955 385.40696376031758
rmesh_equiv_2255 vgnd.n4670 vgnd.t107 612.01324693621962
rmesh_equiv_2256 vgnd.n4670 vgnd.t96 95489.58035452172
rmesh_equiv_2257 vgnd.n4673 vgnd.n5943 17518.862863513223
rmesh_equiv_2258 vgnd.n4673 vgnd.n5945 17554.719194636975
rmesh_equiv_2259 vgnd.n4673 vgnd.n5949 565.57812987805619
rmesh_equiv_226 clk clk.t2 315.88
rmesh_equiv_2260 vgnd.n4673 vgnd.n5955 32831.666484777081
rmesh_equiv_2261 vgnd.n4673 vgnd.t107 612.01324693621962
rmesh_equiv_2262 vgnd.n4673 vgnd.t18 54072.811724875959
rmesh_equiv_2263 vgnd.n4673 vgnd.t55 5260250.1534080924
rmesh_equiv_2264 vgnd.n4673 vgnd.t75 494547000.95207477
rmesh_equiv_2265 vgnd.n4673 vgnd.t96 95489.58035452172
rmesh_equiv_2266 vgnd.n5943 vgnd.n5945 300.38901000588476
rmesh_equiv_2267 vgnd.n5943 vgnd.n5949 303.70214914021255
rmesh_equiv_2268 vgnd.n5943 vgnd.n5955 3560.2042816996477
rmesh_equiv_2269 vgnd.n5943 vgnd.t18 4569.5356701847668
rmesh_equiv_227 clk clk.t3 315.88
rmesh_equiv_2270 vgnd.n5943 vgnd.t55 444528.40426337789
rmesh_equiv_2271 vgnd.n5943 vgnd.t75 41792725.204148613
rmesh_equiv_2272 vgnd.n5945 vgnd.n5949 304.04966978980701
rmesh_equiv_2273 vgnd.n5945 vgnd.n5955 172.90150716397031
rmesh_equiv_2274 vgnd.n5945 vgnd.t18 4579.2537264006623
rmesh_equiv_2275 vgnd.n5945 vgnd.t55 445473.78522415698
rmesh_equiv_2276 vgnd.n5945 vgnd.t75 41881606.018801041
rmesh_equiv_2277 vgnd.n5949 vgnd.n5955 3626.8503868168286
rmesh_equiv_2278 vgnd.n5949 vgnd.t107 49.79872071603419
rmesh_equiv_2279 vgnd.n5949 vgnd.t18 985.2729340562579
rmesh_equiv_228 clk clk.t4 315.88
rmesh_equiv_2280 vgnd.n5949 vgnd.t55 95848.207947617368
rmesh_equiv_2281 vgnd.n5949 vgnd.t75 9011252.7740555834
rmesh_equiv_2282 vgnd.n5955 vgnd.t107 308.37104113937062
rmesh_equiv_2283 vgnd.n5955 vgnd.t96 3533.538446081579
rmesh_equiv_2284 vgnd.n6533 vgnd.n6537 56.989100467959091
rmesh_equiv_2285 vgnd.n6533 vgnd.t100 31.770195664826705
rmesh_equiv_2286 vgnd.n6533 vgnd.t102 84.872928223621642
rmesh_equiv_2287 vgnd.n6533 vgnd.t109 163.96727461867872
rmesh_equiv_2288 vgnd.n6533 vgnd.t116 13.830343078503665
rmesh_equiv_2289 vgnd.n6533 vgnd.t129 13.450790868555375
rmesh_equiv_229 clk clk.t5 330.34100000000001
rmesh_equiv_2290 vgnd.n6533 vgnd.t134 6.18492
rmesh_equiv_2291 vgnd.n6533 vgnd.t76 55415.963565737358
rmesh_equiv_2292 vgnd.n6537 vgnd.n6543 281.64253569957697
rmesh_equiv_2293 vgnd.n6537 vgnd.t100 31.770195664826705
rmesh_equiv_2294 vgnd.n6537 vgnd.t102 13.830343078503665
rmesh_equiv_2295 vgnd.n6537 vgnd.t103 13.742131494558031
rmesh_equiv_2296 vgnd.n6537 vgnd.t114 157.00964558554901
rmesh_equiv_2297 vgnd.n6537 vgnd.t116 84.872928223621642
rmesh_equiv_2298 vgnd.n6537 vgnd.t46 68.350138223621641
rmesh_equiv_2299 vgnd.n6537 vgnd.t51 30.566135236305303
rmesh_equiv_23 bias bias.n0 4.2590000000000003
rmesh_equiv_230 clk.n0 clk.n1 0.81771300000000002
rmesh_equiv_2300 vgnd.n6537 vgnd.t8 419.44558732925452
rmesh_equiv_2301 vgnd.n6537 vgnd.t86 6.18492
rmesh_equiv_2302 vgnd.n6543 vgnd.n7831 1971.0998472883705
rmesh_equiv_2303 vgnd.n6543 vgnd.t103 419.44558732925447
rmesh_equiv_2304 vgnd.n6543 vgnd.t114 30.56613523630531
rmesh_equiv_2305 vgnd.n6543 vgnd.t115 6.18492
rmesh_equiv_2306 vgnd.n6543 vgnd.t131 795924.0133068976
rmesh_equiv_2307 vgnd.n6543 vgnd.t2 2285.0308985262077
rmesh_equiv_2308 vgnd.n6543 vgnd.t46 68.35013822362167
rmesh_equiv_2309 vgnd.n6543 vgnd.t51 157.00964558554901
rmesh_equiv_231 clk.n1 clk.n2 1.6402100000000002
rmesh_equiv_2310 vgnd.n6543 vgnd.t60 24906.340094188901
rmesh_equiv_2311 vgnd.n6543 vgnd.t62 20392.022152895232
rmesh_equiv_2312 vgnd.n6543 vgnd.t8 13.742131494558031
rmesh_equiv_2313 vgnd.n6543 vgnd.t99 1875.4612699552847
rmesh_equiv_2314 vgnd.n6662 vgnd.n6830 9943882.2238041423
rmesh_equiv_2315 vgnd.n6662 vgnd.t108 4131848.3627875932
rmesh_equiv_2316 vgnd.n6662 vgnd.t113 576.10436971536978
rmesh_equiv_2317 vgnd.n6662 vgnd.t15 402231043.10074985
rmesh_equiv_2318 vgnd.n6662 vgnd.t5 8702.333096819526
rmesh_equiv_2319 vgnd.n6662 vgnd.t50 39209986071.819145
rmesh_equiv_232 clk.n2 clk.n3 0.81771300000000002
rmesh_equiv_2320 vgnd.n6662 vgnd.t63 76.159814791478425
rmesh_equiv_2321 vgnd.n6662 vgnd.t77 1065498.273054624
rmesh_equiv_2322 vgnd.n6830 vgnd.n7038 192882831882.9599
rmesh_equiv_2323 vgnd.n6830 vgnd.t1 8884.1228676316932
rmesh_equiv_2324 vgnd.n6830 vgnd.t112 2530947733.8443408
rmesh_equiv_2325 vgnd.n6830 vgnd.t5 8702.3329028754615
rmesh_equiv_2326 vgnd.n6830 vgnd.t63 1065498.247168221
rmesh_equiv_2327 vgnd.n6830 vgnd.t77 76.159813094157826
rmesh_equiv_2328 vgnd.n6830 vgnd.t95 24839568.227015037
rmesh_equiv_2329 vgnd.n7038 vgnd.n7206 9943882.2238041423
rmesh_equiv_233 clk.n3 clk.n4 1.6466799999999999
rmesh_equiv_2330 vgnd.n7038 vgnd.t1 106464523.97670583
rmesh_equiv_2331 vgnd.n7038 vgnd.t112 581.04473916990639
rmesh_equiv_2332 vgnd.n7038 vgnd.t122 1065498.273054624
rmesh_equiv_2333 vgnd.n7038 vgnd.t41 76.159814791478425
rmesh_equiv_2334 vgnd.n7038 vgnd.t87 8702.333096819526
rmesh_equiv_2335 vgnd.n7038 vgnd.t95 66520.615779693704
rmesh_equiv_2336 vgnd.n7206 vgnd.t122 76.159813094157826
rmesh_equiv_2337 vgnd.n7206 vgnd.t41 1065498.247168221
rmesh_equiv_2338 vgnd.n7206 vgnd.t59 9330.6204266510085
rmesh_equiv_2339 vgnd.n7206 vgnd.t87 8702.3329028754615
rmesh_equiv_234 cmp cmp.n0 12.8005
rmesh_equiv_2340 vgnd.n7633 vgnd.n7801 9943882.2238041423
rmesh_equiv_2341 vgnd.n7633 vgnd.t121 76.159814791478425
rmesh_equiv_2342 vgnd.n7633 vgnd.t127 8702.333096819526
rmesh_equiv_2343 vgnd.n7633 vgnd.t133 1065498.273054624
rmesh_equiv_2344 vgnd.n7633 vgnd.t16 632311080.46620822
rmesh_equiv_2345 vgnd.n7633 vgnd.t19 6579394.1971130911
rmesh_equiv_2346 vgnd.n7633 vgnd.t54 581.05479125093245
rmesh_equiv_2347 vgnd.n7633 vgnd.t94 67485.140149052386
rmesh_equiv_2348 vgnd.n7801 vgnd.n7937 1688650906.9052544
rmesh_equiv_2349 vgnd.n7801 vgnd.t121 1065498.247168221
rmesh_equiv_235 cmp cmp.n1 17.948799999999999
rmesh_equiv_2350 vgnd.n7801 vgnd.t127 8702.3329028754615
rmesh_equiv_2351 vgnd.n7801 vgnd.t133 76.159813094157826
rmesh_equiv_2352 vgnd.n7801 vgnd.t42 8884.1228701825476
rmesh_equiv_2353 vgnd.n7801 vgnd.t93 24871524.180306718
rmesh_equiv_2354 vgnd.n7831 vgnd.n9787 862.17033175012909
rmesh_equiv_2355 vgnd.n7831 vgnd.t126 5372.0097857599694
rmesh_equiv_2356 vgnd.n7831 vgnd.t131 999.39170282517091
rmesh_equiv_2357 vgnd.n7831 vgnd.t2 135897.00785865023
rmesh_equiv_2358 vgnd.n7831 vgnd.t23 28658.175154659039
rmesh_equiv_2359 vgnd.n7831 vgnd.t43 743.8664051013684
rmesh_equiv_236 cmp cmp.n10 12.8005
rmesh_equiv_2360 vgnd.n7831 vgnd.t45 23384.079392286727
rmesh_equiv_2361 vgnd.n7831 vgnd.t60 11161.815793618081
rmesh_equiv_2362 vgnd.n7831 vgnd.t62 14846.184551820075
rmesh_equiv_2363 vgnd.n7831 vgnd.t99 195846.48241333419
rmesh_equiv_2364 vgnd.n7937 vgnd.n8846 46587303.101101212
rmesh_equiv_2365 vgnd.n7937 vgnd.t105 743269.60206768173
rmesh_equiv_2366 vgnd.n7937 vgnd.t106 77.839320747293911
rmesh_equiv_2367 vgnd.n7937 vgnd.t42 932075.77476667636
rmesh_equiv_2368 vgnd.n7937 vgnd.t68 7546.3562543020471
rmesh_equiv_2369 vgnd.n7937 vgnd.t93 582.37478715802411
rmesh_equiv_237 cmp cmp.n11 12.8005
rmesh_equiv_2370 vgnd.n8583 vgnd.n8584 1142.20316642526
rmesh_equiv_2371 vgnd.n8583 vgnd.n8589 14593.80960102248
rmesh_equiv_2372 vgnd.n8583 vgnd.n8636 1133.0785891714766
rmesh_equiv_2373 vgnd.n8583 vgnd.n8670 11823.481037162488
rmesh_equiv_2374 vgnd.n8583 vgnd.n8689 15084.36970873378
rmesh_equiv_2375 vgnd.n8583 vgnd.n8773 143.36882398324786
rmesh_equiv_2376 vgnd.n8583 vgnd.n8775 1153.7986734254587
rmesh_equiv_2377 vgnd.n8583 vgnd.n8794 2735.6044441073468
rmesh_equiv_2378 vgnd.n8583 vgnd.n8796 140.22857979681734
rmesh_equiv_2379 vgnd.n8583 vgnd.t125 17074.104095630344
rmesh_equiv_238 cmp cmp.n15 12.8005
rmesh_equiv_2380 vgnd.n8583 vgnd.t85 147.16626613522038
rmesh_equiv_2381 vgnd.n8584 vgnd.n8592 602615.77374135552
rmesh_equiv_2382 vgnd.n8584 vgnd.n8636 7833.3730155085741
rmesh_equiv_2383 vgnd.n8584 vgnd.n8670 1639.6147153308605
rmesh_equiv_2384 vgnd.n8584 vgnd.n8689 339.7449006856059
rmesh_equiv_2385 vgnd.n8584 vgnd.n8691 3938.6928096651664
rmesh_equiv_2386 vgnd.n8584 vgnd.n8694 26371.393360112092
rmesh_equiv_2387 vgnd.n8584 vgnd.n8772 5927.2352012638303
rmesh_equiv_2388 vgnd.n8584 vgnd.n8773 795.55595459372967
rmesh_equiv_2389 vgnd.n8584 vgnd.n8775 11862.972124824017
rmesh_equiv_239 cmp cmp.n3 20.2395
rmesh_equiv_2390 vgnd.n8584 vgnd.t85 9545.0796971054569
rmesh_equiv_2391 vgnd.n8589 vgnd.n8591 8274.4230615166289
rmesh_equiv_2392 vgnd.n8589 vgnd.n8636 146284.4275181095
rmesh_equiv_2393 vgnd.n8589 vgnd.n8691 67942.275157165161
rmesh_equiv_2394 vgnd.n8589 vgnd.n8766 4928.682896190594
rmesh_equiv_2395 vgnd.n8589 vgnd.n8768 78.782101190708943
rmesh_equiv_2396 vgnd.n8589 vgnd.n8772 1753.4382458963576
rmesh_equiv_2397 vgnd.n8589 vgnd.n8773 2091.7503993240857
rmesh_equiv_2398 vgnd.n8589 vgnd.n8775 329.32809971408449
rmesh_equiv_2399 vgnd.n8589 vgnd.n8794 344.51079404713039
rmesh_equiv_24 bias bias.n1 19.837
rmesh_equiv_240 cmp cmp.n5 31.751799999999999
rmesh_equiv_2400 vgnd.n8589 vgnd.n8796 10219.980130290614
rmesh_equiv_2401 vgnd.n8589 vgnd.t85 3793.6452389569158
rmesh_equiv_2402 vgnd.n8591 vgnd.n8592 32592.353730941712
rmesh_equiv_2403 vgnd.n8591 vgnd.n8598 11186.003991199468
rmesh_equiv_2404 vgnd.n8591 vgnd.n8599 16363684.360128619
rmesh_equiv_2405 vgnd.n8591 vgnd.n8691 96281.294145493826
rmesh_equiv_2406 vgnd.n8591 vgnd.n8694 39839.10712426823
rmesh_equiv_2407 vgnd.n8591 vgnd.n8696 49413.781869106118
rmesh_equiv_2408 vgnd.n8591 vgnd.n8699 716100.00249824394
rmesh_equiv_2409 vgnd.n8591 vgnd.n8758 6662.9740996152623
rmesh_equiv_241 cmp cmp.n7 5.4168500000000002
rmesh_equiv_2410 vgnd.n8591 vgnd.n8760 1167.7590376831508
rmesh_equiv_2411 vgnd.n8591 vgnd.n8764 689.11334669978271
rmesh_equiv_2412 vgnd.n8591 vgnd.n8766 701.52531416009685
rmesh_equiv_2413 vgnd.n8591 vgnd.n8768 445.25067593605985
rmesh_equiv_2414 vgnd.n8591 vgnd.n8772 6676.0853252257457
rmesh_equiv_2415 vgnd.n8591 vgnd.n8773 52254.923613578292
rmesh_equiv_2416 vgnd.n8591 vgnd.n8775 35193.914365384349
rmesh_equiv_2417 vgnd.n8592 vgnd.n8599 595417.93014849478
rmesh_equiv_2418 vgnd.n8592 vgnd.n8689 2577.3600982344997
rmesh_equiv_2419 vgnd.n8592 vgnd.n8691 387.88811649951509
rmesh_equiv_242 cmp.n0 cmp.n14 10.151300000000001
rmesh_equiv_2420 vgnd.n8592 vgnd.n8694 523.20747879982196
rmesh_equiv_2421 vgnd.n8592 vgnd.n8696 3891.6477503759243
rmesh_equiv_2422 vgnd.n8592 vgnd.n8699 26056.404650882978
rmesh_equiv_2423 vgnd.n8592 vgnd.n8764 2358.3347459914521
rmesh_equiv_2424 vgnd.n8592 vgnd.n8766 509.50806303293899
rmesh_equiv_2425 vgnd.n8592 vgnd.n8772 267327.30379678239
rmesh_equiv_2426 vgnd.n8592 vgnd.n8773 894746.77065658127
rmesh_equiv_2427 vgnd.n8598 vgnd.n8599 32592.353730941712
rmesh_equiv_2428 vgnd.n8598 vgnd.n8605 11186.003991199468
rmesh_equiv_2429 vgnd.n8598 vgnd.n8606 16363684.360128619
rmesh_equiv_243 cmp.n0 cmp.t0 700.48400000000004
rmesh_equiv_2430 vgnd.n8598 vgnd.n8696 97176.573822877501
rmesh_equiv_2431 vgnd.n8598 vgnd.n8699 39839.10712426823
rmesh_equiv_2432 vgnd.n8598 vgnd.n8701 49413.781869106118
rmesh_equiv_2433 vgnd.n8598 vgnd.n8704 716100.00249824394
rmesh_equiv_2434 vgnd.n8598 vgnd.n8750 6662.9740996152623
rmesh_equiv_2435 vgnd.n8598 vgnd.n8752 1167.7590376831508
rmesh_equiv_2436 vgnd.n8598 vgnd.n8756 689.11334669978271
rmesh_equiv_2437 vgnd.n8598 vgnd.n8758 702.17507448404922
rmesh_equiv_2438 vgnd.n8598 vgnd.n8760 441.63996879204274
rmesh_equiv_2439 vgnd.n8598 vgnd.n8764 6987.764894317459
rmesh_equiv_244 cmp.n1 cmp.n2 48.279000000000003
rmesh_equiv_2440 vgnd.n8598 vgnd.n8768 14382.807569962499
rmesh_equiv_2441 vgnd.n8599 vgnd.n8606 595417.93014849478
rmesh_equiv_2442 vgnd.n8599 vgnd.n8694 2577.2510853172244
rmesh_equiv_2443 vgnd.n8599 vgnd.n8696 387.88719673862806
rmesh_equiv_2444 vgnd.n8599 vgnd.n8699 523.2072288632952
rmesh_equiv_2445 vgnd.n8599 vgnd.n8701 3891.6477503759243
rmesh_equiv_2446 vgnd.n8599 vgnd.n8704 26056.404650882978
rmesh_equiv_2447 vgnd.n8599 vgnd.n8756 2358.3347459914521
rmesh_equiv_2448 vgnd.n8599 vgnd.n8758 509.50806303293899
rmesh_equiv_2449 vgnd.n8599 vgnd.n8764 235335.27362947303
rmesh_equiv_245 cmp.n1 cmp.n4 2.38164
rmesh_equiv_2450 vgnd.n8599 vgnd.n8766 1982310.7094409894
rmesh_equiv_2451 vgnd.n8605 vgnd.n8606 32592.353730941712
rmesh_equiv_2452 vgnd.n8605 vgnd.n8612 11186.003991199468
rmesh_equiv_2453 vgnd.n8605 vgnd.n8613 16363684.360128619
rmesh_equiv_2454 vgnd.n8605 vgnd.n8701 97176.573822877501
rmesh_equiv_2455 vgnd.n8605 vgnd.n8704 39839.10712426823
rmesh_equiv_2456 vgnd.n8605 vgnd.n8706 49413.781869106118
rmesh_equiv_2457 vgnd.n8605 vgnd.n8709 716100.00249824394
rmesh_equiv_2458 vgnd.n8605 vgnd.n8742 6662.9740996152623
rmesh_equiv_2459 vgnd.n8605 vgnd.n8744 1167.7590376831508
rmesh_equiv_246 cmp.n10 cmp.n12 10.151300000000001
rmesh_equiv_2460 vgnd.n8605 vgnd.n8748 689.11334669978271
rmesh_equiv_2461 vgnd.n8605 vgnd.n8750 702.17507448404922
rmesh_equiv_2462 vgnd.n8605 vgnd.n8752 441.63996879204274
rmesh_equiv_2463 vgnd.n8605 vgnd.n8756 6987.764894317459
rmesh_equiv_2464 vgnd.n8605 vgnd.n8760 14382.807569962499
rmesh_equiv_2465 vgnd.n8606 vgnd.n8613 595417.93014849478
rmesh_equiv_2466 vgnd.n8606 vgnd.n8699 2577.2510853172244
rmesh_equiv_2467 vgnd.n8606 vgnd.n8701 387.88719673862806
rmesh_equiv_2468 vgnd.n8606 vgnd.n8704 523.2072288632952
rmesh_equiv_2469 vgnd.n8606 vgnd.n8706 3891.6477503759243
rmesh_equiv_247 cmp.n10 cmp.t1 255.34500000000003
rmesh_equiv_2470 vgnd.n8606 vgnd.n8709 26056.404650882978
rmesh_equiv_2471 vgnd.n8606 vgnd.n8748 2358.3347459914521
rmesh_equiv_2472 vgnd.n8606 vgnd.n8750 509.50806303293899
rmesh_equiv_2473 vgnd.n8606 vgnd.n8756 235335.27362947303
rmesh_equiv_2474 vgnd.n8606 vgnd.n8758 1982310.7094409894
rmesh_equiv_2475 vgnd.n8612 vgnd.n8613 32592.353730941712
rmesh_equiv_2476 vgnd.n8612 vgnd.n8619 11186.003991199468
rmesh_equiv_2477 vgnd.n8612 vgnd.n8620 16363684.360128619
rmesh_equiv_2478 vgnd.n8612 vgnd.n8706 97176.573822877501
rmesh_equiv_2479 vgnd.n8612 vgnd.n8709 39839.10712426823
rmesh_equiv_248 cmp.n11 cmp.n12 10.151300000000001
rmesh_equiv_2480 vgnd.n8612 vgnd.n8711 49413.781869106118
rmesh_equiv_2481 vgnd.n8612 vgnd.n8714 716100.00249824394
rmesh_equiv_2482 vgnd.n8612 vgnd.n8734 6662.9740996152623
rmesh_equiv_2483 vgnd.n8612 vgnd.n8736 1167.7590376831508
rmesh_equiv_2484 vgnd.n8612 vgnd.n8740 689.11334669978271
rmesh_equiv_2485 vgnd.n8612 vgnd.n8742 702.17507448404922
rmesh_equiv_2486 vgnd.n8612 vgnd.n8744 441.63996879204274
rmesh_equiv_2487 vgnd.n8612 vgnd.n8748 6987.764894317459
rmesh_equiv_2488 vgnd.n8612 vgnd.n8752 14382.807569962499
rmesh_equiv_2489 vgnd.n8613 vgnd.n8620 595417.93014849478
rmesh_equiv_249 cmp.n11 cmp.t1 255.34500000000003
rmesh_equiv_2490 vgnd.n8613 vgnd.n8704 2577.2510853172244
rmesh_equiv_2491 vgnd.n8613 vgnd.n8706 387.88719673862806
rmesh_equiv_2492 vgnd.n8613 vgnd.n8709 523.2072288632952
rmesh_equiv_2493 vgnd.n8613 vgnd.n8711 3891.6477503759243
rmesh_equiv_2494 vgnd.n8613 vgnd.n8714 26056.404650882978
rmesh_equiv_2495 vgnd.n8613 vgnd.n8740 2358.3347459914521
rmesh_equiv_2496 vgnd.n8613 vgnd.n8742 509.50806303293899
rmesh_equiv_2497 vgnd.n8613 vgnd.n8748 235335.27362947303
rmesh_equiv_2498 vgnd.n8613 vgnd.n8750 1982310.7094409894
rmesh_equiv_2499 vgnd.n8619 vgnd.n8620 32598.82528380286
rmesh_equiv_25 bias bias.n10 34.662100000000002
rmesh_equiv_250 cmp.n12 cmp.n13 17.2837
rmesh_equiv_2500 vgnd.n8619 vgnd.n8626 11186.003991199468
rmesh_equiv_2501 vgnd.n8619 vgnd.n8711 97176.573822877501
rmesh_equiv_2502 vgnd.n8619 vgnd.n8714 42205.198707743999
rmesh_equiv_2503 vgnd.n8619 vgnd.n8716 49770.538390312511
rmesh_equiv_2504 vgnd.n8619 vgnd.n8717 329665.38760109764
rmesh_equiv_2505 vgnd.n8619 vgnd.n8726 6662.9740996152623
rmesh_equiv_2506 vgnd.n8619 vgnd.n8728 1167.7590376831508
rmesh_equiv_2507 vgnd.n8619 vgnd.n8732 689.12066502397079
rmesh_equiv_2508 vgnd.n8619 vgnd.n8734 702.17597653773373
rmesh_equiv_2509 vgnd.n8619 vgnd.n8736 441.63996879204274
rmesh_equiv_251 cmp.n13 cmp.n14 18.100899999999999
rmesh_equiv_2510 vgnd.n8619 vgnd.n8740 6987.764894317459
rmesh_equiv_2511 vgnd.n8619 vgnd.n8744 14382.807569962499
rmesh_equiv_2512 vgnd.n8620 vgnd.n8709 2577.2510853172244
rmesh_equiv_2513 vgnd.n8620 vgnd.n8711 387.88719673862806
rmesh_equiv_2514 vgnd.n8620 vgnd.n8714 534.01261883630059
rmesh_equiv_2515 vgnd.n8620 vgnd.n8716 3952.9771194827845
rmesh_equiv_2516 vgnd.n8620 vgnd.n8717 11995.384316096894
rmesh_equiv_2517 vgnd.n8620 vgnd.n8732 2360.6926699504966
rmesh_equiv_2518 vgnd.n8620 vgnd.n8734 509.52111612624299
rmesh_equiv_2519 vgnd.n8620 vgnd.n8740 235335.27362947303
rmesh_equiv_252 cmp.n13 cmp.n9 2.7511700000000001
rmesh_equiv_2520 vgnd.n8620 vgnd.n8742 1982310.7094409894
rmesh_equiv_2521 vgnd.n8626 vgnd.n8716 26492.312027385164
rmesh_equiv_2522 vgnd.n8626 vgnd.n8717 16513.626729120784
rmesh_equiv_2523 vgnd.n8626 vgnd.n8726 535.05792841335824
rmesh_equiv_2524 vgnd.n8626 vgnd.n8728 484.51360358723832
rmesh_equiv_2525 vgnd.n8626 vgnd.n8732 6987.764894317459
rmesh_equiv_2526 vgnd.n8626 vgnd.n8736 14382.807569962499
rmesh_equiv_2527 vgnd.n8626 vgnd.n8846 1957.4531120986996
rmesh_equiv_2528 vgnd.n8636 vgnd.n8670 289.18881813537564
rmesh_equiv_2529 vgnd.n8636 vgnd.n8689 2977.0270461945961
rmesh_equiv_253 cmp.n14 cmp.n15 10.151300000000001
rmesh_equiv_2530 vgnd.n8636 vgnd.n8775 461013.88411307597
rmesh_equiv_2531 vgnd.n8636 vgnd.n8794 9362.5447594764773
rmesh_equiv_2532 vgnd.n8636 vgnd.n8796 663.68621555980155
rmesh_equiv_2533 vgnd.n8636 vgnd.n8846 162989.84620460836
rmesh_equiv_2534 vgnd.n8636 vgnd.t85 10757.003167522462
rmesh_equiv_2535 vgnd.n8670 vgnd.n8689 321.2453969694007
rmesh_equiv_2536 vgnd.n8670 vgnd.n8794 814.82361507233338
rmesh_equiv_2537 vgnd.n8670 vgnd.n8796 525.22783636942017
rmesh_equiv_2538 vgnd.n8670 vgnd.n8846 7336.027299227906
rmesh_equiv_2539 vgnd.n8670 vgnd.t85 3446.7883661155456
rmesh_equiv_254 cmp.n15 cmp.t0 700.48400000000004
rmesh_equiv_2540 vgnd.n8689 vgnd.n8691 732.6577405175924
rmesh_equiv_2541 vgnd.n8689 vgnd.n8694 112.78924306812361
rmesh_equiv_2542 vgnd.n8689 vgnd.n8772 2596.0868314970885
rmesh_equiv_2543 vgnd.n8689 vgnd.n8773 2178.3549267263197
rmesh_equiv_2544 vgnd.n8689 vgnd.t85 4397.4046102692464
rmesh_equiv_2545 vgnd.n8691 vgnd.n8694 1094.2592094045083
rmesh_equiv_2546 vgnd.n8691 vgnd.n8766 1282.4032128488718
rmesh_equiv_2547 vgnd.n8691 vgnd.n8768 40795.980748351285
rmesh_equiv_2548 vgnd.n8691 vgnd.n8772 739.14230198940299
rmesh_equiv_2549 vgnd.n8691 vgnd.n8773 5769.4243445388165
rmesh_equiv_255 cmp.n2 cmp.n3 54.441600000000001
rmesh_equiv_2550 vgnd.n8691 vgnd.n8775 288981.43059564254
rmesh_equiv_2551 vgnd.n8694 vgnd.n8696 731.31238029489532
rmesh_equiv_2552 vgnd.n8694 vgnd.n8699 112.78447249515146
rmesh_equiv_2553 vgnd.n8694 vgnd.n8764 1683.3077345932547
rmesh_equiv_2554 vgnd.n8694 vgnd.n8766 4826.143487552763
rmesh_equiv_2555 vgnd.n8694 vgnd.n8772 11698.65408692227
rmesh_equiv_2556 vgnd.n8694 vgnd.n8773 39155.495217425312
rmesh_equiv_2557 vgnd.n8696 vgnd.n8699 1094.0919677418831
rmesh_equiv_2558 vgnd.n8696 vgnd.n8758 1282.6674541758782
rmesh_equiv_2559 vgnd.n8696 vgnd.n8760 37385.342303313126
rmesh_equiv_256 cmp.n2 cmp.t2 3.5711299999999997
rmesh_equiv_2560 vgnd.n8696 vgnd.n8764 699.34499977162341
rmesh_equiv_2561 vgnd.n8696 vgnd.n8766 12956.370008908152
rmesh_equiv_2562 vgnd.n8696 vgnd.n8768 118098.94927850571
rmesh_equiv_2563 vgnd.n8699 vgnd.n8701 731.31238029489532
rmesh_equiv_2564 vgnd.n8699 vgnd.n8704 112.78447249515146
rmesh_equiv_2565 vgnd.n8699 vgnd.n8756 1683.3077345932547
rmesh_equiv_2566 vgnd.n8699 vgnd.n8758 4826.143487552763
rmesh_equiv_2567 vgnd.n8699 vgnd.n8764 10298.633628292861
rmesh_equiv_2568 vgnd.n8699 vgnd.n8766 86748.966353921453
rmesh_equiv_2569 vgnd.n8701 vgnd.n8704 1094.0919677418831
rmesh_equiv_257 cmp.n3 cmp.n4 0.71089000000000002
rmesh_equiv_2570 vgnd.n8701 vgnd.n8750 1282.6674541758782
rmesh_equiv_2571 vgnd.n8701 vgnd.n8752 37385.342303313126
rmesh_equiv_2572 vgnd.n8701 vgnd.n8756 699.34499977162341
rmesh_equiv_2573 vgnd.n8701 vgnd.n8758 12956.370008908152
rmesh_equiv_2574 vgnd.n8701 vgnd.n8760 118098.94927850571
rmesh_equiv_2575 vgnd.n8704 vgnd.n8706 731.31238029489532
rmesh_equiv_2576 vgnd.n8704 vgnd.n8709 112.78447249515146
rmesh_equiv_2577 vgnd.n8704 vgnd.n8748 1683.3077345932547
rmesh_equiv_2578 vgnd.n8704 vgnd.n8750 4826.143487552763
rmesh_equiv_2579 vgnd.n8704 vgnd.n8756 10298.633628292861
rmesh_equiv_258 cmp.n4 cmp.n9 18.100899999999999
rmesh_equiv_2580 vgnd.n8704 vgnd.n8758 86748.966353921453
rmesh_equiv_2581 vgnd.n8706 vgnd.n8709 1094.0919677418831
rmesh_equiv_2582 vgnd.n8706 vgnd.n8742 1282.6674541758782
rmesh_equiv_2583 vgnd.n8706 vgnd.n8744 37385.342303313126
rmesh_equiv_2584 vgnd.n8706 vgnd.n8748 699.34499977162341
rmesh_equiv_2585 vgnd.n8706 vgnd.n8750 12956.370008908152
rmesh_equiv_2586 vgnd.n8706 vgnd.n8752 118098.94927850571
rmesh_equiv_2587 vgnd.n8709 vgnd.n8711 731.31238029489532
rmesh_equiv_2588 vgnd.n8709 vgnd.n8714 112.78447249515146
rmesh_equiv_2589 vgnd.n8709 vgnd.n8740 1683.3077345932547
rmesh_equiv_259 cmp.n5 cmp.n6 37.418900000000001
rmesh_equiv_2590 vgnd.n8709 vgnd.n8742 4826.143487552763
rmesh_equiv_2591 vgnd.n8709 vgnd.n8748 10298.633628292861
rmesh_equiv_2592 vgnd.n8709 vgnd.n8750 86748.966353921453
rmesh_equiv_2593 vgnd.n8711 vgnd.n8714 1094.0919677418831
rmesh_equiv_2594 vgnd.n8711 vgnd.n8734 1282.6674541758782
rmesh_equiv_2595 vgnd.n8711 vgnd.n8736 37385.342303313126
rmesh_equiv_2596 vgnd.n8711 vgnd.n8740 699.34499977162341
rmesh_equiv_2597 vgnd.n8711 vgnd.n8742 12956.370008908152
rmesh_equiv_2598 vgnd.n8711 vgnd.n8744 118098.94927850571
rmesh_equiv_2599 vgnd.n8714 vgnd.n8716 2240.2923183309731
rmesh_equiv_26 bias bias.n11 34.662100000000002
rmesh_equiv_260 cmp.n5 cmp.n8 2.60127
rmesh_equiv_2600 vgnd.n8714 vgnd.n8717 51.921710251063189
rmesh_equiv_2601 vgnd.n8714 vgnd.n8732 2015.2316693331989
rmesh_equiv_2602 vgnd.n8714 vgnd.n8734 5112.7738442755171
rmesh_equiv_2603 vgnd.n8714 vgnd.n8740 10298.633628292861
rmesh_equiv_2604 vgnd.n8714 vgnd.n8742 86748.966353921453
rmesh_equiv_2605 vgnd.n8716 vgnd.n8717 386.16772684111373
rmesh_equiv_2606 vgnd.n8716 vgnd.n8726 654.3658723134148
rmesh_equiv_2607 vgnd.n8716 vgnd.n8728 35130.185259149293
rmesh_equiv_2608 vgnd.n8716 vgnd.n8732 704.31324338991897
rmesh_equiv_2609 vgnd.n8716 vgnd.n8734 13160.552414287631
rmesh_equiv_261 cmp.n6 cmp.n7 31.473199999999995
rmesh_equiv_2610 vgnd.n8716 vgnd.n8736 118098.94927850571
rmesh_equiv_2611 vgnd.n8716 vgnd.n8846 14424.424802891659
rmesh_equiv_2612 vgnd.n8717 vgnd.n8726 1385.2897135042506
rmesh_equiv_2613 vgnd.n8717 vgnd.n8728 205470.39947498398
rmesh_equiv_2614 vgnd.n8717 vgnd.n8732 4741.1018502840889
rmesh_equiv_2615 vgnd.n8717 vgnd.n8734 39935.94681928552
rmesh_equiv_2616 vgnd.n8717 vgnd.n8846 6253.2143888877454
rmesh_equiv_2617 vgnd.n8726 vgnd.n8728 1362.3084101469001
rmesh_equiv_2618 vgnd.n8726 vgnd.n8732 153.06121073592419
rmesh_equiv_2619 vgnd.n8726 vgnd.n8736 8567.1589598757546
rmesh_equiv_262 cmp.n6 cmp.t3 4.3505000000000003
rmesh_equiv_2620 vgnd.n8726 vgnd.n8846 368.21325606793533
rmesh_equiv_2621 vgnd.n8728 vgnd.n8732 1882.1531099845897
rmesh_equiv_2622 vgnd.n8728 vgnd.n8736 110.6999450030161
rmesh_equiv_2623 vgnd.n8728 vgnd.n8846 24543.643589658444
rmesh_equiv_2624 vgnd.n8732 vgnd.n8734 155.7555424617091
rmesh_equiv_2625 vgnd.n8732 vgnd.n8736 3609.0812621729187
rmesh_equiv_2626 vgnd.n8734 vgnd.n8736 1403.1048880495202
rmesh_equiv_2627 vgnd.n8734 vgnd.n8740 153.06121073592419
rmesh_equiv_2628 vgnd.n8734 vgnd.n8744 8567.1589598757546
rmesh_equiv_2629 vgnd.n8736 vgnd.n8740 1882.1531099845897
rmesh_equiv_263 cmp.n7 cmp.n8 1.7058199999999999
rmesh_equiv_2630 vgnd.n8736 vgnd.n8744 110.6999450030161
rmesh_equiv_2631 vgnd.n8740 vgnd.n8742 155.75245633687121
rmesh_equiv_2632 vgnd.n8740 vgnd.n8744 3609.0812621729187
rmesh_equiv_2633 vgnd.n8742 vgnd.n8744 1403.1048880495202
rmesh_equiv_2634 vgnd.n8742 vgnd.n8748 153.06121073592419
rmesh_equiv_2635 vgnd.n8742 vgnd.n8752 8567.1589598757546
rmesh_equiv_2636 vgnd.n8744 vgnd.n8748 1882.1531099845897
rmesh_equiv_2637 vgnd.n8744 vgnd.n8752 110.6999450030161
rmesh_equiv_2638 vgnd.n8748 vgnd.n8750 155.75245633687121
rmesh_equiv_2639 vgnd.n8748 vgnd.n8752 3609.0812621729187
rmesh_equiv_264 cmp.n8 cmp.n9 17.2837
rmesh_equiv_2640 vgnd.n8750 vgnd.n8752 1403.1048880495202
rmesh_equiv_2641 vgnd.n8750 vgnd.n8756 153.06121073592419
rmesh_equiv_2642 vgnd.n8750 vgnd.n8760 8567.1589598757546
rmesh_equiv_2643 vgnd.n8752 vgnd.n8756 1882.1531099845897
rmesh_equiv_2644 vgnd.n8752 vgnd.n8760 110.6999450030161
rmesh_equiv_2645 vgnd.n8756 vgnd.n8758 155.75245633687121
rmesh_equiv_2646 vgnd.n8756 vgnd.n8760 3609.0812621729187
rmesh_equiv_2647 vgnd.n8758 vgnd.n8760 1403.1048880495202
rmesh_equiv_2648 vgnd.n8758 vgnd.n8764 153.06121073592419
rmesh_equiv_2649 vgnd.n8758 vgnd.n8768 8567.1589598757546
rmesh_equiv_265 comparator__pre comparator__pre.n0 22.8553
rmesh_equiv_2650 vgnd.n8760 vgnd.n8764 1882.1531099845897
rmesh_equiv_2651 vgnd.n8760 vgnd.n8768 110.6999450030161
rmesh_equiv_2652 vgnd.n8764 vgnd.n8766 155.75245633687121
rmesh_equiv_2653 vgnd.n8764 vgnd.n8768 3609.0812621729187
rmesh_equiv_2654 vgnd.n8766 vgnd.n8768 1466.5370218193091
rmesh_equiv_2655 vgnd.n8766 vgnd.n8772 152.79888533405975
rmesh_equiv_2656 vgnd.n8766 vgnd.n8773 31125.789235241613
rmesh_equiv_2657 vgnd.n8766 vgnd.n8775 20963.352066128544
rmesh_equiv_2658 vgnd.n8768 vgnd.n8772 2113.5432852289291
rmesh_equiv_2659 vgnd.n8768 vgnd.n8773 12359.964795379721
rmesh_equiv_266 comparator__pre comparator__pre.n1 17.834954327507095
rmesh_equiv_2660 vgnd.n8768 vgnd.n8775 8324.4891100506156
rmesh_equiv_2661 vgnd.n8772 vgnd.n8773 69.581425480396931
rmesh_equiv_2662 vgnd.n8772 vgnd.n8775 4576.6111207564072
rmesh_equiv_2663 vgnd.n8773 vgnd.n8775 791.5626634893747
rmesh_equiv_2664 vgnd.n8775 vgnd.n8794 1661.1968733081851
rmesh_equiv_2665 vgnd.n8775 vgnd.n8796 32208.163338783706
rmesh_equiv_2666 vgnd.n8775 vgnd.t85 8713.2283526111623
rmesh_equiv_2667 vgnd.n8794 vgnd.n8796 517.42386783439383
rmesh_equiv_2668 vgnd.n8794 vgnd.n8846 6743.4792654357816
rmesh_equiv_2669 vgnd.n8794 vgnd.t85 3301.0803657714659
rmesh_equiv_267 comparator__pre comparator__pre.n2 6.3200399999999997
rmesh_equiv_2670 vgnd.n8796 vgnd.n8846 16896.41167664824
rmesh_equiv_2671 vgnd.n8796 vgnd.t85 48347.667183853104
rmesh_equiv_2672 vgnd.n8846 vgnd.t104 1394.5183995873251
rmesh_equiv_2673 vgnd.n8846 vgnd.t105 567.68552680751225
rmesh_equiv_2674 vgnd.n8846 vgnd.t106 5984759.8209554562
rmesh_equiv_2675 vgnd.n8846 vgnd.t20 145357338.09361538
rmesh_equiv_2676 vgnd.n8846 vgnd.t21 17797295390.953037
rmesh_equiv_2677 vgnd.n8846 vgnd.t67 1272117.2385182534
rmesh_equiv_2678 vgnd.n8846 vgnd.t68 55816.659020097431
rmesh_equiv_2679 vgnd.n919 vgnd.n920 207638.90353340283
rmesh_equiv_268 comparator__pre comparator__pre.n4 33.130400000000002
rmesh_equiv_2680 vgnd.n919 vgnd.n966 3089.5106052605806
rmesh_equiv_2681 vgnd.n919 vgnd.n967 2159.7068474784082
rmesh_equiv_2682 vgnd.n919 vgnd.n991 415.83578873619371
rmesh_equiv_2683 vgnd.n919 vgnd.n997 606.36410617550803
rmesh_equiv_2684 vgnd.n919 vgnd.t119 9486.9208299770635
rmesh_equiv_2685 vgnd.n919 vgnd.t135 1138.1512126211551
rmesh_equiv_2686 vgnd.n919 vgnd.t17 26559085.7158622
rmesh_equiv_2687 vgnd.n919 vgnd.t35 15969.693777239625
rmesh_equiv_2688 vgnd.n920 vgnd.n961 682.52794976222447
rmesh_equiv_2689 vgnd.n920 vgnd.t119 167043.19270753121
rmesh_equiv_269 comparator__pre comparator__pre.n8 4.8770699999999998
rmesh_equiv_2690 vgnd.n920 vgnd.t17 467645356.47351187
rmesh_equiv_2691 vgnd.n920 vgnd.t35 15875.972742295618
rmesh_equiv_2692 vgnd.n9530 vgnd.t110 8032.7089717879826
rmesh_equiv_2693 vgnd.n9530 vgnd.t111 78.538542158971097
rmesh_equiv_2694 vgnd.n9530 vgnd.t123 622011329172.03467
rmesh_equiv_2695 vgnd.n9530 vgnd.t22 10192.937034252471
rmesh_equiv_2696 vgnd.n9530 vgnd.t33 47586594.720902815
rmesh_equiv_2697 vgnd.n9530 vgnd.t88 24938403.736612696
rmesh_equiv_2698 vgnd.n9530 vgnd.t91 5437412342.0491037
rmesh_equiv_2699 vgnd.n961 vgnd.n966 5433.5478966051924
rmesh_equiv_27 bias bias.n12 34.662100000000002
rmesh_equiv_270 comparator__pre comparator__pre.t2 854.11400000000003
rmesh_equiv_2700 vgnd.n961 vgnd.n967 5931.3179513294845
rmesh_equiv_2701 vgnd.n961 vgnd.n991 5101.4906680790446
rmesh_equiv_2702 vgnd.n961 vgnd.n997 2792.9659607559197
rmesh_equiv_2703 vgnd.n961 vgnd.n999 113.36272579287773
rmesh_equiv_2704 vgnd.n966 vgnd.n967 4149.6368277223
rmesh_equiv_2705 vgnd.n966 vgnd.n991 381.95135323058116
rmesh_equiv_2706 vgnd.n966 vgnd.n997 8160.2478367387157
rmesh_equiv_2707 vgnd.n966 vgnd.n999 1722.5027529956442
rmesh_equiv_2708 vgnd.n966 vgnd.t135 654.59981436461771
rmesh_equiv_2709 vgnd.n967 vgnd.n991 3271.315645816062
rmesh_equiv_271 comparator__pre comparator__pre.t3 1511.24
rmesh_equiv_2710 vgnd.n967 vgnd.n997 354.21944489613583
rmesh_equiv_2711 vgnd.n967 vgnd.n999 1782.2212843886318
rmesh_equiv_2712 vgnd.n967 vgnd.t135 641.02162793965863
rmesh_equiv_2713 vgnd.n9787 vgnd.n9791 56.989100467959091
rmesh_equiv_2714 vgnd.n9787 vgnd.t126 25501.24549652822
rmesh_equiv_2715 vgnd.n9787 vgnd.t23 4378.508584920789
rmesh_equiv_2716 vgnd.n9787 vgnd.t28 84.872928223621642
rmesh_equiv_2717 vgnd.n9787 vgnd.t30 13.830343078503665
rmesh_equiv_2718 vgnd.n9787 vgnd.t32 31.770195664826705
rmesh_equiv_2719 vgnd.n9787 vgnd.t36 6.18492
rmesh_equiv_272 comparator__pre.n0 comparator__pre.n7 11.4361
rmesh_equiv_2720 vgnd.n9787 vgnd.t45 5908.8487612993104
rmesh_equiv_2721 vgnd.n9791 vgnd.n9797 281.64253569957697
rmesh_equiv_2722 vgnd.n9791 vgnd.t25 30.566135236305303
rmesh_equiv_2723 vgnd.n9791 vgnd.t26 6.18492
rmesh_equiv_2724 vgnd.n9791 vgnd.t28 13.830343078503665
rmesh_equiv_2725 vgnd.n9791 vgnd.t29 157.00964558554901
rmesh_equiv_2726 vgnd.n9791 vgnd.t30 84.872928223621642
rmesh_equiv_2727 vgnd.n9791 vgnd.t32 31.770195664826705
rmesh_equiv_2728 vgnd.n9791 vgnd.t34 68.350138223621641
rmesh_equiv_2729 vgnd.n9791 vgnd.t37 419.44558732925452
rmesh_equiv_273 comparator__pre.n0 comparator__pre.t0 381.113
rmesh_equiv_2730 vgnd.n9791 vgnd.t38 13.742131494558031
rmesh_equiv_2731 vgnd.n9797 vgnd.t120 5381.7581936697388
rmesh_equiv_2732 vgnd.n9797 vgnd.t136 4391.3284845145972
rmesh_equiv_2733 vgnd.n9797 vgnd.t25 157.00964558554901
rmesh_equiv_2734 vgnd.n9797 vgnd.t27 14.370721804348698
rmesh_equiv_2735 vgnd.n9797 vgnd.t29 30.56613523630531
rmesh_equiv_2736 vgnd.n9797 vgnd.t31 6.18492
rmesh_equiv_2737 vgnd.n9797 vgnd.t34 68.35013822362167
rmesh_equiv_2738 vgnd.n9797 vgnd.t37 13.742131494558031
rmesh_equiv_2739 vgnd.n9797 vgnd.t38 419.44558732925447
rmesh_equiv_274 comparator__pre.n1 comparator__pre.n6 2.1513399999999998
rmesh_equiv_2740 vgnd.n991 vgnd.n997 665.36004769155772
rmesh_equiv_2741 vgnd.n991 vgnd.n999 4050.4529308801148
rmesh_equiv_2742 vgnd.n991 vgnd.t135 1790.7520578221206
rmesh_equiv_2743 vgnd.n997 vgnd.n999 2217.543439288896
rmesh_equiv_2744 vgnd.n997 vgnd.t135 2611.241745746237
rmesh_equiv_2745 vgnd.n999 vgnd.t135 58.210600000000007
rmesh_equiv_2746 vgnd.t1 vgnd.t112 1396993.9318247072
rmesh_equiv_2747 vgnd.t1 vgnd.t95 13710.566053285393
rmesh_equiv_2748 vgnd.t10 vgnd.t56 126.39985341235558
rmesh_equiv_2749 vgnd.t10 vgnd.t78 47.314828873764434
rmesh_equiv_275 comparator__pre.n2 comparator__pre.n3 13.389300000000002
rmesh_equiv_2750 vgnd.t100 vgnd.t102 47.314828873764434
rmesh_equiv_2751 vgnd.t100 vgnd.t116 47.314828873764434
rmesh_equiv_2752 vgnd.t102 vgnd.t116 126.39985341235558
rmesh_equiv_2753 vgnd.t103 vgnd.t114 233.8318778639217
rmesh_equiv_2754 vgnd.t103 vgnd.t46 101.79273453859115
rmesh_equiv_2755 vgnd.t103 vgnd.t51 45.521641518855134
rmesh_equiv_2756 vgnd.t103 vgnd.t8 624.67340131339233
rmesh_equiv_2757 vgnd.t104 vgnd.t20 192796.26143797938
rmesh_equiv_2758 vgnd.t104 vgnd.t21 23605633.262720302
rmesh_equiv_2759 vgnd.t104 vgnd.t67 1687.2863173868091
rmesh_equiv_276 comparator__pre.n2 comparator__pre.n5 0.75515399999999999
rmesh_equiv_2760 vgnd.t105 vgnd.t106 95482.883843668256
rmesh_equiv_2761 vgnd.t105 vgnd.t68 890.51787025711405
rmesh_equiv_2762 vgnd.t106 vgnd.t68 969.43000987527159
rmesh_equiv_2763 vgnd.t107 vgnd.t96 1235.3417290005495
rmesh_equiv_2764 vgnd.t108 vgnd.t113 54216.812083779711
rmesh_equiv_2765 vgnd.t108 vgnd.t15 885.50783439019551
rmesh_equiv_2766 vgnd.t108 vgnd.t50 86320.413226359364
rmesh_equiv_2767 vgnd.t109 vgnd.t129 244.23073118879626
rmesh_equiv_2768 vgnd.t109 vgnd.t76 186565.74930908097
rmesh_equiv_2769 vgnd.t110 vgnd.t111 953.47455665334246
rmesh_equiv_277 comparator__pre.n3 comparator__pre.n4 14.121399999999998
rmesh_equiv_2770 vgnd.t110 vgnd.t123 708941300.62610304
rmesh_equiv_2771 vgnd.t110 vgnd.t33 54237.11879767615
rmesh_equiv_2772 vgnd.t110 vgnd.t91 6197324.706197693
rmesh_equiv_2773 vgnd.t111 vgnd.t123 73832125426.006989
rmesh_equiv_2774 vgnd.t111 vgnd.t33 5648481.4106312282
rmesh_equiv_2775 vgnd.t111 vgnd.t91 645415430.88205397
rmesh_equiv_2776 vgnd.t112 vgnd.t95 872.86255659967583
rmesh_equiv_2777 vgnd.t113 vgnd.t15 5277948.9863329055
rmesh_equiv_2778 vgnd.t113 vgnd.t50 514501080.39037979
rmesh_equiv_2779 vgnd.t114 vgnd.t46 38.103729436882219
rmesh_equiv_278 comparator__pre.n3 comparator__pre.t1 1.7404999999999999
rmesh_equiv_2780 vgnd.t114 vgnd.t51 87.529494597348673
rmesh_equiv_2781 vgnd.t114 vgnd.t8 45.521641518855134
rmesh_equiv_2782 vgnd.t119 vgnd.t17 13728.156694462188
rmesh_equiv_2783 vgnd.t119 vgnd.t35 12847.44134994221
rmesh_equiv_2784 vgnd.t120 vgnd.t136 210369.73182624567
rmesh_equiv_2785 vgnd.t120 vgnd.t27 8014.963793735019
rmesh_equiv_2786 vgnd.t121 vgnd.t127 932.46485147809494
rmesh_equiv_2787 vgnd.t121 vgnd.t133 114169.34721760527
rmesh_equiv_2788 vgnd.t122 vgnd.t41 114169.34721760527
rmesh_equiv_2789 vgnd.t122 vgnd.t87 932.46485335110981
rmesh_equiv_279 comparator__pre.n4 comparator__pre.n5 1.13588
rmesh_equiv_2790 vgnd.t123 vgnd.t33 98696.485664536885
rmesh_equiv_2791 vgnd.t123 vgnd.t91 871.19777933056594
rmesh_equiv_2792 vgnd.t124 vgnd.t49 1158.3334397634344
rmesh_equiv_2793 vgnd.t126 vgnd.t23 847650.5548711794
rmesh_equiv_2794 vgnd.t126 vgnd.t45 691653.52521760657
rmesh_equiv_2795 vgnd.t127 vgnd.t133 932.46485335110981
rmesh_equiv_2796 vgnd.t128 vgnd.t47 12600.556476501481
rmesh_equiv_2797 vgnd.t129 vgnd.t76 82542.576454155074
rmesh_equiv_2798 vgnd.t13 vgnd.t40 234243.59478196889
rmesh_equiv_2799 vgnd.t13 vgnd.t58 492190.32110995927
rmesh_equiv_28 bias bias.n13 34.662100000000002
rmesh_equiv_280 comparator__pre.n5 comparator__pre.n6 19.3293
rmesh_equiv_2800 vgnd.t131 vgnd.t2 54874790.863616586
rmesh_equiv_2801 vgnd.t131 vgnd.t60 4507106.6463073511
rmesh_equiv_2802 vgnd.t131 vgnd.t62 5994843.3393850103
rmesh_equiv_2803 vgnd.t131 vgnd.t99 79082203.009097353
rmesh_equiv_2804 vgnd.t132 vgnd.t52 119.07270338759285
rmesh_equiv_2805 vgnd.t132 vgnd.t92 46.845096197284121
rmesh_equiv_2806 vgnd.t136 vgnd.t27 6539.9331488325242
rmesh_equiv_2807 vgnd.t14 vgnd.t53 6728510.1842500679
rmesh_equiv_2808 vgnd.t14 vgnd.t80 823826886.62757063
rmesh_equiv_2809 vgnd.t14 vgnd.t97 58885.598121076895
rmesh_equiv_281 comparator__pre.n6 comparator__pre.n7 16.554500000000001
rmesh_equiv_2810 vgnd.t15 vgnd.t50 895.67062369137705
rmesh_equiv_2811 vgnd.t16 vgnd.t19 886.19499237929608
rmesh_equiv_2812 vgnd.t16 vgnd.t54 8296986.7279929621
rmesh_equiv_2813 vgnd.t16 vgnd.t94 86401.072802965777
rmesh_equiv_2814 vgnd.t17 vgnd.t35 35967022.615435109
rmesh_equiv_2815 vgnd.t18 vgnd.t55 894.46066231289842
rmesh_equiv_2816 vgnd.t18 vgnd.t75 84093.498429889674
rmesh_equiv_2817 vgnd.t19 vgnd.t54 86332.737189157269
rmesh_equiv_2818 vgnd.t19 vgnd.t94 899.03013656670942
rmesh_equiv_2819 vgnd.t2 vgnd.t60 1717161.664928599
rmesh_equiv_282 comparator__pre.n7 comparator__pre.n8 2.4407800000000002
rmesh_equiv_2820 vgnd.t2 vgnd.t62 1405923.0934334025
rmesh_equiv_2821 vgnd.t2 vgnd.t99 227038.35338315408
rmesh_equiv_2822 vgnd.t20 vgnd.t21 932.45973662572828
rmesh_equiv_2823 vgnd.t20 vgnd.t67 865.98368931957407
rmesh_equiv_2824 vgnd.t21 vgnd.t67 106029.51130435379
rmesh_equiv_2825 vgnd.t22 vgnd.t88 11997.613935070503
rmesh_equiv_2826 vgnd.t23 vgnd.t45 196407.61984927853
rmesh_equiv_2827 vgnd.t24 vgnd.t66 47.314828873764434
rmesh_equiv_2828 vgnd.t24 vgnd.t89 47.314828873764434
rmesh_equiv_2829 vgnd.t25 vgnd.t29 87.529494597348673
rmesh_equiv_283 comparator__pre.n8 comparator__pre.t0 387.11000000000001
rmesh_equiv_2830 vgnd.t25 vgnd.t34 38.103729436882219
rmesh_equiv_2831 vgnd.t25 vgnd.t37 233.8318778639217
rmesh_equiv_2832 vgnd.t25 vgnd.t38 45.521641518855134
rmesh_equiv_2833 vgnd.t28 vgnd.t30 126.39985341235558
rmesh_equiv_2834 vgnd.t28 vgnd.t32 47.314828873764434
rmesh_equiv_2835 vgnd.t29 vgnd.t34 38.103729436882219
rmesh_equiv_2836 vgnd.t29 vgnd.t37 45.521641518855134
rmesh_equiv_2837 vgnd.t29 vgnd.t38 233.8318778639217
rmesh_equiv_2838 vgnd.t30 vgnd.t32 47.314828873764434
rmesh_equiv_2839 vgnd.t33 vgnd.t91 862.77124563562199
rmesh_equiv_284 comparator__preamp__mir comparator__preamp__mir.n0 6.3200399999999997
rmesh_equiv_2840 vgnd.t34 vgnd.t37 101.79273453859115
rmesh_equiv_2841 vgnd.t34 vgnd.t38 101.79273453859115
rmesh_equiv_2842 vgnd.t37 vgnd.t38 624.67340131339233
rmesh_equiv_2843 vgnd.t40 vgnd.t58 448652.60000187752
rmesh_equiv_2844 vgnd.t41 vgnd.t87 932.46485147809494
rmesh_equiv_2845 vgnd.t42 vgnd.t93 13728.204613037997
rmesh_equiv_2846 vgnd.t46 vgnd.t51 38.103729436882219
rmesh_equiv_2847 vgnd.t46 vgnd.t8 101.79273453859115
rmesh_equiv_2848 vgnd.t48 vgnd.t65 1750373.8472177074
rmesh_equiv_2849 vgnd.t48 vgnd.t72 4138510.0065909266
rmesh_equiv_285 comparator__preamp__mir comparator__preamp__mir.n1 15.571552633952864
rmesh_equiv_2850 vgnd.t5 vgnd.t63 932.46485147809494
rmesh_equiv_2851 vgnd.t5 vgnd.t77 932.46485335110981
rmesh_equiv_2852 vgnd.t51 vgnd.t8 233.8318778639217
rmesh_equiv_2853 vgnd.t52 vgnd.t92 44.572081630038923
rmesh_equiv_2854 vgnd.t53 vgnd.t80 932.45946977138885
rmesh_equiv_2855 vgnd.t53 vgnd.t97 862.77558377775631
rmesh_equiv_2856 vgnd.t54 vgnd.t94 885.51874140904908
rmesh_equiv_2857 vgnd.t55 vgnd.t75 860.95582790850301
rmesh_equiv_2858 vgnd.t56 vgnd.t78 47.314828873764434
rmesh_equiv_2859 vgnd.t60 vgnd.t62 187592.79092705846
rmesh_equiv_286 comparator__preamp__mir comparator__preamp__mir.n2 4.8770699999999998
rmesh_equiv_2860 vgnd.t60 vgnd.t99 2474668.7002931242
rmesh_equiv_2861 vgnd.t62 vgnd.t99 2026130.6465187101
rmesh_equiv_2862 vgnd.t63 vgnd.t77 114169.34721760527
rmesh_equiv_2863 vgnd.t65 vgnd.t72 113101.01929207722
rmesh_equiv_2864 vgnd.t66 vgnd.t89 126.39985341235558
rmesh_equiv_2865 vgnd.t7 vgnd.t74 506045.3594325906
rmesh_equiv_2866 vgnd.t7 vgnd.t84 978278.87276658078
rmesh_equiv_2867 vgnd.t74 vgnd.t84 979958.79989425954
rmesh_equiv_2868 vgnd.t80 vgnd.t97 105636.71653580687
rmesh_equiv_2869 vin vin.n0 16.89811560809753
rmesh_equiv_287 comparator__preamp__mir comparator__preamp__mir.n3 22.8553
rmesh_equiv_2870 vin vin.n1 32.474600000000002
rmesh_equiv_2871 vin vin.n2 23.102013844699059
rmesh_equiv_2872 vin vin.t0 212.21199999999999
rmesh_equiv_2873 vin vin.t1 212.21199999999999
rmesh_equiv_2874 vin vin.t2 212.21199999999999
rmesh_equiv_2875 vin vin.t3 212.21199999999999
rmesh_equiv_2876 vin.n0 vin.n1 20.895499999999998
rmesh_equiv_2877 vin.n1 vin.n2 2.7558699999999998
rmesh_equiv_288 comparator__preamp__mir comparator__preamp__mir.n8 33.130400000000002
rmesh_equiv_289 comparator__preamp__mir comparator__preamp__mir.t1 572.84699999999998
rmesh_equiv_29 bias bias.n14 34.662100000000002
rmesh_equiv_290 comparator__preamp__mir comparator__preamp__mir.t3 572.84699999999998
rmesh_equiv_291 comparator__preamp__mir.n0 comparator__preamp__mir.n6 0.75515399999999999
rmesh_equiv_292 comparator__preamp__mir.n0 comparator__preamp__mir.n7 13.389300000000002
rmesh_equiv_293 comparator__preamp__mir.n1 comparator__preamp__mir.n5 0.39353700000000003
rmesh_equiv_294 comparator__preamp__mir.n2 comparator__preamp__mir.n4 2.4407800000000002
rmesh_equiv_295 comparator__preamp__mir.n2 comparator__preamp__mir.t2 387.11000000000001
rmesh_equiv_296 comparator__preamp__mir.n3 comparator__preamp__mir.n4 11.4361
rmesh_equiv_297 comparator__preamp__mir.n3 comparator__preamp__mir.t2 381.113
rmesh_equiv_298 comparator__preamp__mir.n4 comparator__preamp__mir.n5 17.387899999999998
rmesh_equiv_299 comparator__preamp__mir.n5 comparator__preamp__mir.n6 18.305
rmesh_equiv_3 amplified amplified.n3 33.9895
rmesh_equiv_30 bias bias.n15 34.662100000000002
rmesh_equiv_300 comparator__preamp__mir.n6 comparator__preamp__mir.n8 1.13588
rmesh_equiv_301 comparator__preamp__mir.n7 comparator__preamp__mir.n8 14.121399999999998
rmesh_equiv_302 comparator__preamp__mir.n7 comparator__preamp__mir.t0 1.7404999999999999
rmesh_equiv_303 comparator__preamp__tail comparator__preamp__tail.n0 19.837
rmesh_equiv_304 comparator__preamp__tail comparator__preamp__tail.n1 7.0733300000000003
rmesh_equiv_305 comparator__preamp__tail comparator__preamp__tail.n11 4.2590000000000003
rmesh_equiv_306 comparator__preamp__tail comparator__preamp__tail.n3 26.391300000000001
rmesh_equiv_307 comparator__preamp__tail comparator__preamp__tail.n5 6.3200399999999997
rmesh_equiv_308 comparator__preamp__tail comparator__preamp__tail.n7 33.130400000000002
rmesh_equiv_309 comparator__preamp__tail.n0 comparator__preamp__tail.n10 14.189499999999999
rmesh_equiv_31 bias bias.n16 34.662100000000002
rmesh_equiv_310 comparator__preamp__tail.n0 comparator__preamp__tail.t0 174.91200000000001
rmesh_equiv_311 comparator__preamp__tail.n1 comparator__preamp__tail.n2 14.985300000000001
rmesh_equiv_312 comparator__preamp__tail.n1 comparator__preamp__tail.n4 0.24337299999999998
rmesh_equiv_313 comparator__preamp__tail.n10 comparator__preamp__tail.n11 3.0467200000000001
rmesh_equiv_314 comparator__preamp__tail.n10 comparator__preamp__tail.n9 19.470400000000001
rmesh_equiv_315 comparator__preamp__tail.n11 comparator__preamp__tail.t0 181.41
rmesh_equiv_316 comparator__preamp__tail.n2 comparator__preamp__tail.n3 11.248699999999999
rmesh_equiv_317 comparator__preamp__tail.n2 comparator__preamp__tail.t2 1.7404999999999999
rmesh_equiv_318 comparator__preamp__tail.n3 comparator__preamp__tail.n4 3.1501399999999999
rmesh_equiv_319 comparator__preamp__tail.n4 comparator__preamp__tail.n9 17.881799999999998
rmesh_equiv_32 bias bias.n17 20.917496187879877
rmesh_equiv_320 comparator__preamp__tail.n5 comparator__preamp__tail.n6 13.389300000000002
rmesh_equiv_321 comparator__preamp__tail.n5 comparator__preamp__tail.n8 0.75515399999999999
rmesh_equiv_322 comparator__preamp__tail.n6 comparator__preamp__tail.n7 14.121399999999998
rmesh_equiv_323 comparator__preamp__tail.n6 comparator__preamp__tail.t1 1.7404999999999999
rmesh_equiv_324 comparator__preamp__tail.n7 comparator__preamp__tail.n8 1.13588
rmesh_equiv_325 comparator__preamp__tail.n8 comparator__preamp__tail.n9 16.9712
rmesh_equiv_326 d d.n0 12.8005
rmesh_equiv_327 d d.n1 12.8005
rmesh_equiv_328 d d.n11 12.8005
rmesh_equiv_329 d d.n12 12.8005
rmesh_equiv_33 bias bias.n3 0.25606299999999999
rmesh_equiv_330 d d.n15 12.8005
rmesh_equiv_331 d d.n16 12.8005
rmesh_equiv_332 d d.n2 12.8005
rmesh_equiv_333 d d.n21 12.8005
rmesh_equiv_334 d d.n4 12.8005
rmesh_equiv_335 d d.n5 12.8005
rmesh_equiv_336 d d.n7 12.8005
rmesh_equiv_337 d d.n8 12.8005
rmesh_equiv_338 d.n0 d.n20 10.151300000000001
rmesh_equiv_339 d.n0 d.t0 255.34500000000003
rmesh_equiv_34 bias bias.n4 34.662100000000002
rmesh_equiv_340 d.n1 d.n3 10.151300000000001
rmesh_equiv_341 d.n1 d.t1 700.48400000000004
rmesh_equiv_342 d.n10 d.n14 0.81771300000000002
rmesh_equiv_343 d.n10 d.n6 18.517600000000002
rmesh_equiv_344 d.n10 d.n9 17.700399999999998
rmesh_equiv_345 d.n11 d.n13 10.151300000000001
rmesh_equiv_346 d.n11 d.t2 255.34500000000003
rmesh_equiv_347 d.n12 d.n13 10.151300000000001
rmesh_equiv_348 d.n12 d.t2 255.34500000000003
rmesh_equiv_349 d.n13 d.n14 17.700399999999998
rmesh_equiv_35 bias bias.n6 34.662100000000002
rmesh_equiv_350 d.n14 d.n18 0.81771300000000002
rmesh_equiv_351 d.n15 d.n17 10.151300000000001
rmesh_equiv_352 d.n15 d.t5 700.48400000000004
rmesh_equiv_353 d.n16 d.n17 10.151300000000001
rmesh_equiv_354 d.n16 d.t5 700.48400000000004
rmesh_equiv_355 d.n17 d.n18 17.700399999999998
rmesh_equiv_356 d.n18 d.n19 2.7576399999999999
rmesh_equiv_357 d.n19 d.n20 17.700399999999998
rmesh_equiv_358 d.n19 d.n3 18.517600000000002
rmesh_equiv_359 d.n2 d.n3 10.151300000000001
rmesh_equiv_36 bias bias.n7 34.662100000000002
rmesh_equiv_360 d.n2 d.t1 700.48400000000004
rmesh_equiv_361 d.n20 d.n21 10.151300000000001
rmesh_equiv_362 d.n21 d.t0 255.34500000000003
rmesh_equiv_363 d.n4 d.n6 10.151300000000001
rmesh_equiv_364 d.n4 d.t4 255.34500000000003
rmesh_equiv_365 d.n5 d.n6 10.151300000000001
rmesh_equiv_366 d.n5 d.t4 255.34500000000003
rmesh_equiv_367 d.n7 d.n9 10.151300000000001
rmesh_equiv_368 d.n7 d.t3 700.48400000000004
rmesh_equiv_369 d.n8 d.n9 10.151300000000001
rmesh_equiv_37 bias bias.n8 34.662100000000002
rmesh_equiv_370 d.n8 d.t3 700.48400000000004
rmesh_equiv_371 data data.n0 12.8005
rmesh_equiv_372 data data.n1 12.8005
rmesh_equiv_373 data data.n10 12.8005
rmesh_equiv_374 data data.n14 12.8005
rmesh_equiv_375 data data.n2 12.8005
rmesh_equiv_376 data data.n4 318.53399999999999
rmesh_equiv_377 data data.n5 12.8005
rmesh_equiv_378 data data.n6 12.8005
rmesh_equiv_379 data data.n9 12.8005
rmesh_equiv_38 bias bias.n9 34.662100000000002
rmesh_equiv_380 data.n0 data.n13 10.151300000000001
rmesh_equiv_381 data.n0 data.t0 255.34500000000003
rmesh_equiv_382 data.n1 data.n3 10.151300000000001
rmesh_equiv_383 data.n1 data.t3 255.34500000000003
rmesh_equiv_384 data.n10 data.n11 10.151300000000001
rmesh_equiv_385 data.n10 data.t2 700.48400000000004
rmesh_equiv_386 data.n11 data.n12 19.7837
rmesh_equiv_387 data.n11 data.n9 10.151300000000001
rmesh_equiv_388 data.n12 data.n13 20.600899999999999
rmesh_equiv_389 data.n12 data.n8 5.5159500000000001
rmesh_equiv_39 bias bias.t0 139.911
rmesh_equiv_390 data.n13 data.n14 10.151300000000001
rmesh_equiv_391 data.n14 data.t0 255.34500000000003
rmesh_equiv_392 data.n2 data.n3 10.151300000000001
rmesh_equiv_393 data.n2 data.t3 255.34500000000003
rmesh_equiv_394 data.n3 data.n4 19.7837
rmesh_equiv_395 data.n4 data.n8 0.81771300000000002
rmesh_equiv_396 data.n5 data.n7 10.151300000000001
rmesh_equiv_397 data.n5 data.t1 700.48400000000004
rmesh_equiv_398 data.n6 data.n7 10.151300000000001
rmesh_equiv_399 data.n6 data.t1 700.48400000000004
rmesh_equiv_4 amplified amplified.n5 6.9688099999999995
rmesh_equiv_40 bias bias.t10 139.911
rmesh_equiv_400 data.n7 data.n8 19.7837
rmesh_equiv_401 data.n9 data.t2 700.48400000000004
rmesh_equiv_402 filter__buffer0__comp.n0 filter__buffer0__comp.n1 4.1529499999999997
rmesh_equiv_403 filter__buffer0__comp.n0 filter__buffer0__comp.t0 4.7185199999999998
rmesh_equiv_404 filter__buffer0__comp.n0 filter__buffer0__comp.t3 26.609300000000001
rmesh_equiv_405 filter__buffer0__comp.n1 filter__buffer0__comp.n2 4.7105199999999998
rmesh_equiv_406 filter__buffer0__comp.n1 filter__buffer0__comp.t1 8.8709699999999998
rmesh_equiv_407 filter__buffer0__comp.n2 filter__buffer0__comp.t2 0.025939499999999997
rmesh_equiv_408 filter__buffer0__first__mir filter__buffer0__first__mir.n0 22.8553
rmesh_equiv_409 filter__buffer0__first__mir filter__buffer0__first__mir.n1 17.030169965890344
rmesh_equiv_41 bias bias.t11 139.911
rmesh_equiv_410 filter__buffer0__first__mir filter__buffer0__first__mir.n11 4.8770699999999998
rmesh_equiv_411 filter__buffer0__first__mir filter__buffer0__first__mir.n2 15.6333
rmesh_equiv_412 filter__buffer0__first__mir filter__buffer0__first__mir.n3 15.6333
rmesh_equiv_413 filter__buffer0__first__mir filter__buffer0__first__mir.n5 15.6333
rmesh_equiv_414 filter__buffer0__first__mir filter__buffer0__first__mir.n6 15.6333
rmesh_equiv_415 filter__buffer0__first__mir filter__buffer0__first__mir.t0 572.84699999999998
rmesh_equiv_416 filter__buffer0__first__mir filter__buffer0__first__mir.t4 572.84699999999998
rmesh_equiv_417 filter__buffer0__first__mir.n0 filter__buffer0__first__mir.n10 11.4361
rmesh_equiv_418 filter__buffer0__first__mir.n0 filter__buffer0__first__mir.t1 381.113
rmesh_equiv_419 filter__buffer0__first__mir.n1 filter__buffer0__first__mir.n9 0.39353700000000003
rmesh_equiv_42 bias bias.t12 139.911
rmesh_equiv_420 filter__buffer0__first__mir.n10 filter__buffer0__first__mir.n11 2.4407800000000002
rmesh_equiv_421 filter__buffer0__first__mir.n10 filter__buffer0__first__mir.n9 20.304500000000001
rmesh_equiv_422 filter__buffer0__first__mir.n11 filter__buffer0__first__mir.t1 387.11000000000001
rmesh_equiv_423 filter__buffer0__first__mir.n2 filter__buffer0__first__mir.n4 5.2415200000000004
rmesh_equiv_424 filter__buffer0__first__mir.n2 filter__buffer0__first__mir.t2 174.857
rmesh_equiv_425 filter__buffer0__first__mir.n3 filter__buffer0__first__mir.n4 5.2415200000000004
rmesh_equiv_426 filter__buffer0__first__mir.n3 filter__buffer0__first__mir.t2 174.857
rmesh_equiv_427 filter__buffer0__first__mir.n4 filter__buffer0__first__mir.n8 21.215199999999999
rmesh_equiv_428 filter__buffer0__first__mir.n5 filter__buffer0__first__mir.n7 5.2415200000000004
rmesh_equiv_429 filter__buffer0__first__mir.n5 filter__buffer0__first__mir.t3 174.857
rmesh_equiv_43 bias bias.t13 139.911
rmesh_equiv_430 filter__buffer0__first__mir.n6 filter__buffer0__first__mir.n7 5.2415200000000004
rmesh_equiv_431 filter__buffer0__first__mir.n6 filter__buffer0__first__mir.t3 174.857
rmesh_equiv_432 filter__buffer0__first__mir.n7 filter__buffer0__first__mir.n8 20.304500000000001
rmesh_equiv_433 filter__buffer0__first__mir.n8 filter__buffer0__first__mir.n9 1.83996
rmesh_equiv_434 filter__buffer0__first__tail filter__buffer0__first__tail.n0 19.837
rmesh_equiv_435 filter__buffer0__first__tail filter__buffer0__first__tail.n1 15.6333
rmesh_equiv_436 filter__buffer0__first__tail filter__buffer0__first__tail.n12 15.6333
rmesh_equiv_437 filter__buffer0__first__tail filter__buffer0__first__tail.n13 15.6333
rmesh_equiv_438 filter__buffer0__first__tail filter__buffer0__first__tail.n17 4.2590000000000003
rmesh_equiv_439 filter__buffer0__first__tail filter__buffer0__first__tail.n2 15.6333
rmesh_equiv_44 bias bias.t14 139.911
rmesh_equiv_440 filter__buffer0__first__tail filter__buffer0__first__tail.n4 15.6333
rmesh_equiv_441 filter__buffer0__first__tail filter__buffer0__first__tail.n5 15.6333
rmesh_equiv_442 filter__buffer0__first__tail filter__buffer0__first__tail.n8 15.6333
rmesh_equiv_443 filter__buffer0__first__tail filter__buffer0__first__tail.n9 15.6333
rmesh_equiv_444 filter__buffer0__first__tail.n0 filter__buffer0__first__tail.n16 14.189499999999999
rmesh_equiv_445 filter__buffer0__first__tail.n0 filter__buffer0__first__tail.t0 174.91200000000001
rmesh_equiv_446 filter__buffer0__first__tail.n1 filter__buffer0__first__tail.n3 5.2415200000000004
rmesh_equiv_447 filter__buffer0__first__tail.n1 filter__buffer0__first__tail.t1 174.857
rmesh_equiv_448 filter__buffer0__first__tail.n10 filter__buffer0__first__tail.n11 19.887899999999998
rmesh_equiv_449 filter__buffer0__first__tail.n10 filter__buffer0__first__tail.n8 5.2415200000000004
rmesh_equiv_45 bias bias.t15 139.911
rmesh_equiv_450 filter__buffer0__first__tail.n10 filter__buffer0__first__tail.n9 5.2415200000000004
rmesh_equiv_451 filter__buffer0__first__tail.n11 filter__buffer0__first__tail.n15 0.91112499999999996
rmesh_equiv_452 filter__buffer0__first__tail.n11 filter__buffer0__first__tail.n7 0.91112499999999996
rmesh_equiv_453 filter__buffer0__first__tail.n12 filter__buffer0__first__tail.n14 5.2415200000000004
rmesh_equiv_454 filter__buffer0__first__tail.n12 filter__buffer0__first__tail.t2 174.857
rmesh_equiv_455 filter__buffer0__first__tail.n13 filter__buffer0__first__tail.n14 5.2415200000000004
rmesh_equiv_456 filter__buffer0__first__tail.n13 filter__buffer0__first__tail.t2 174.857
rmesh_equiv_457 filter__buffer0__first__tail.n14 filter__buffer0__first__tail.n15 19.887899999999998
rmesh_equiv_458 filter__buffer0__first__tail.n15 filter__buffer0__first__tail.n16 22.3871
rmesh_equiv_459 filter__buffer0__first__tail.n16 filter__buffer0__first__tail.n17 3.0467200000000001
rmesh_equiv_46 bias bias.t3 139.911
rmesh_equiv_460 filter__buffer0__first__tail.n17 filter__buffer0__first__tail.t0 181.41
rmesh_equiv_461 filter__buffer0__first__tail.n2 filter__buffer0__first__tail.n3 5.2415200000000004
rmesh_equiv_462 filter__buffer0__first__tail.n2 filter__buffer0__first__tail.t1 174.857
rmesh_equiv_463 filter__buffer0__first__tail.n3 filter__buffer0__first__tail.n7 20.798500000000001
rmesh_equiv_464 filter__buffer0__first__tail.n4 filter__buffer0__first__tail.n6 5.2415200000000004
rmesh_equiv_465 filter__buffer0__first__tail.n4 filter__buffer0__first__tail.t3 174.857
rmesh_equiv_466 filter__buffer0__first__tail.n5 filter__buffer0__first__tail.n6 5.2415200000000004
rmesh_equiv_467 filter__buffer0__first__tail.n5 filter__buffer0__first__tail.t3 174.857
rmesh_equiv_468 filter__buffer0__first__tail.n6 filter__buffer0__first__tail.n7 19.887899999999998
rmesh_equiv_469 filter__buffer0__first__tail.n8 filter__buffer0__first__tail.t4 174.857
rmesh_equiv_47 bias bias.t4 139.911
rmesh_equiv_470 filter__buffer0__first__tail.n9 filter__buffer0__first__tail.t4 174.857
rmesh_equiv_471 filter__buffer0__pre filter__buffer0__pre.n0 22.8553
rmesh_equiv_472 filter__buffer0__pre filter__buffer0__pre.n1 2.9479326624577999
rmesh_equiv_473 filter__buffer0__pre filter__buffer0__pre.n13 4.8770699999999998
rmesh_equiv_474 filter__buffer0__pre filter__buffer0__pre.n2 4.4774000000000003
rmesh_equiv_475 filter__buffer0__pre filter__buffer0__pre.n3 26.799300000000002
rmesh_equiv_476 filter__buffer0__pre filter__buffer0__pre.n4 15.6333
rmesh_equiv_477 filter__buffer0__pre filter__buffer0__pre.n5 15.6333
rmesh_equiv_478 filter__buffer0__pre filter__buffer0__pre.n7 15.6333
rmesh_equiv_479 filter__buffer0__pre filter__buffer0__pre.n8 15.6333
rmesh_equiv_48 bias bias.t5 139.911
rmesh_equiv_480 filter__buffer0__pre filter__buffer0__pre.t3 0.00141837
rmesh_equiv_481 filter__buffer0__pre filter__buffer0__pre.t4 1054.8499999999999
rmesh_equiv_482 filter__buffer0__pre filter__buffer0__pre.t5 0.00141837
rmesh_equiv_483 filter__buffer0__pre filter__buffer0__pre.t6 0.00141837
rmesh_equiv_484 filter__buffer0__pre.n0 filter__buffer0__pre.n12 11.4361
rmesh_equiv_485 filter__buffer0__pre.n0 filter__buffer0__pre.t0 381.113
rmesh_equiv_486 filter__buffer0__pre.n1 filter__buffer0__pre.n2 4.1529499999999997
rmesh_equiv_487 filter__buffer0__pre.n10 filter__buffer0__pre.n11 1.8528899999999999
rmesh_equiv_488 filter__buffer0__pre.n10 filter__buffer0__pre.n6 19.726600000000001
rmesh_equiv_489 filter__buffer0__pre.n10 filter__buffer0__pre.n9 16.9712
rmesh_equiv_49 bias bias.t6 139.911
rmesh_equiv_490 filter__buffer0__pre.n11 filter__buffer0__pre.n12 16.9712
rmesh_equiv_491 filter__buffer0__pre.n11 filter__buffer0__pre.n3 2.2512099999999999
rmesh_equiv_492 filter__buffer0__pre.n12 filter__buffer0__pre.n13 2.4407800000000002
rmesh_equiv_493 filter__buffer0__pre.n13 filter__buffer0__pre.t0 387.11000000000001
rmesh_equiv_494 filter__buffer0__pre.n2 filter__buffer0__pre.n3 3.1113099999999996
rmesh_equiv_495 filter__buffer0__pre.n4 filter__buffer0__pre.n6 5.2415200000000004
rmesh_equiv_496 filter__buffer0__pre.n4 filter__buffer0__pre.t1 174.857
rmesh_equiv_497 filter__buffer0__pre.n5 filter__buffer0__pre.n6 5.2415200000000004
rmesh_equiv_498 filter__buffer0__pre.n5 filter__buffer0__pre.t1 174.857
rmesh_equiv_499 filter__buffer0__pre.n7 filter__buffer0__pre.n9 5.2415200000000004
rmesh_equiv_5 amplified amplified.t4 212.21199999999999
rmesh_equiv_50 bias bias.t7 139.911
rmesh_equiv_500 filter__buffer0__pre.n7 filter__buffer0__pre.t2 174.857
rmesh_equiv_501 filter__buffer0__pre.n8 filter__buffer0__pre.n9 5.2415200000000004
rmesh_equiv_502 filter__buffer0__pre.n8 filter__buffer0__pre.t2 174.857
rmesh_equiv_503 filter__buffer1__comp.n0 filter__buffer1__comp.n1 4.1529499999999997
rmesh_equiv_504 filter__buffer1__comp.n0 filter__buffer1__comp.t1 4.7185199999999998
rmesh_equiv_505 filter__buffer1__comp.n0 filter__buffer1__comp.t3 8.8709699999999998
rmesh_equiv_506 filter__buffer1__comp.n1 filter__buffer1__comp.t0 26.609300000000001
rmesh_equiv_507 filter__buffer1__comp.n1 filter__buffer1__comp.t2 4.7185199999999998
rmesh_equiv_508 filter__buffer1__first__mir filter__buffer1__first__mir.n0 15.6333
rmesh_equiv_509 filter__buffer1__first__mir filter__buffer1__first__mir.n1 17.030169965890344
rmesh_equiv_51 bias bias.t8 139.911
rmesh_equiv_510 filter__buffer1__first__mir filter__buffer1__first__mir.n11 15.6333
rmesh_equiv_511 filter__buffer1__first__mir filter__buffer1__first__mir.n2 4.8770699999999998
rmesh_equiv_512 filter__buffer1__first__mir filter__buffer1__first__mir.n3 22.8553
rmesh_equiv_513 filter__buffer1__first__mir filter__buffer1__first__mir.n6 15.6333
rmesh_equiv_514 filter__buffer1__first__mir filter__buffer1__first__mir.n7 15.6333
rmesh_equiv_515 filter__buffer1__first__mir filter__buffer1__first__mir.t2 572.84699999999998
rmesh_equiv_516 filter__buffer1__first__mir filter__buffer1__first__mir.t4 572.84699999999998
rmesh_equiv_517 filter__buffer1__first__mir.n0 filter__buffer1__first__mir.n10 5.2415200000000004
rmesh_equiv_518 filter__buffer1__first__mir.n0 filter__buffer1__first__mir.t1 174.857
rmesh_equiv_519 filter__buffer1__first__mir.n1 filter__buffer1__first__mir.n5 0.39353700000000003
rmesh_equiv_52 bias bias.t9 139.911
rmesh_equiv_520 filter__buffer1__first__mir.n10 filter__buffer1__first__mir.n11 5.2415200000000004
rmesh_equiv_521 filter__buffer1__first__mir.n10 filter__buffer1__first__mir.n9 20.304500000000001
rmesh_equiv_522 filter__buffer1__first__mir.n11 filter__buffer1__first__mir.t1 174.857
rmesh_equiv_523 filter__buffer1__first__mir.n2 filter__buffer1__first__mir.n4 2.4407800000000002
rmesh_equiv_524 filter__buffer1__first__mir.n2 filter__buffer1__first__mir.t3 387.11000000000001
rmesh_equiv_525 filter__buffer1__first__mir.n3 filter__buffer1__first__mir.n4 11.4361
rmesh_equiv_526 filter__buffer1__first__mir.n3 filter__buffer1__first__mir.t3 381.113
rmesh_equiv_527 filter__buffer1__first__mir.n4 filter__buffer1__first__mir.n5 20.304500000000001
rmesh_equiv_528 filter__buffer1__first__mir.n5 filter__buffer1__first__mir.n9 1.83996
rmesh_equiv_529 filter__buffer1__first__mir.n6 filter__buffer1__first__mir.n8 5.2415200000000004
rmesh_equiv_53 bias.n0 bias.n2 3.0467200000000001
rmesh_equiv_530 filter__buffer1__first__mir.n6 filter__buffer1__first__mir.t0 174.857
rmesh_equiv_531 filter__buffer1__first__mir.n7 filter__buffer1__first__mir.n8 5.2415200000000004
rmesh_equiv_532 filter__buffer1__first__mir.n7 filter__buffer1__first__mir.t0 174.857
rmesh_equiv_533 filter__buffer1__first__mir.n8 filter__buffer1__first__mir.n9 21.215199999999999
rmesh_equiv_534 filter__buffer1__first__tail filter__buffer1__first__tail.n0 15.6333
rmesh_equiv_535 filter__buffer1__first__tail filter__buffer1__first__tail.n1 19.837
rmesh_equiv_536 filter__buffer1__first__tail filter__buffer1__first__tail.n12 15.6333
rmesh_equiv_537 filter__buffer1__first__tail filter__buffer1__first__tail.n13 15.6333
rmesh_equiv_538 filter__buffer1__first__tail filter__buffer1__first__tail.n17 15.6333
rmesh_equiv_539 filter__buffer1__first__tail filter__buffer1__first__tail.n2 4.2590000000000003
rmesh_equiv_54 bias.n0 bias.t1 181.41
rmesh_equiv_540 filter__buffer1__first__tail filter__buffer1__first__tail.n4 15.6333
rmesh_equiv_541 filter__buffer1__first__tail filter__buffer1__first__tail.n5 15.6333
rmesh_equiv_542 filter__buffer1__first__tail filter__buffer1__first__tail.n8 15.6333
rmesh_equiv_543 filter__buffer1__first__tail filter__buffer1__first__tail.n9 15.6333
rmesh_equiv_544 filter__buffer1__first__tail.n0 filter__buffer1__first__tail.n16 5.2415200000000004
rmesh_equiv_545 filter__buffer1__first__tail.n0 filter__buffer1__first__tail.t0 174.857
rmesh_equiv_546 filter__buffer1__first__tail.n1 filter__buffer1__first__tail.n3 14.189499999999999
rmesh_equiv_547 filter__buffer1__first__tail.n1 filter__buffer1__first__tail.t4 174.91200000000001
rmesh_equiv_548 filter__buffer1__first__tail.n10 filter__buffer1__first__tail.n11 19.887899999999998
rmesh_equiv_549 filter__buffer1__first__tail.n10 filter__buffer1__first__tail.n8 5.2415200000000004
rmesh_equiv_55 bias.n1 bias.n2 14.189499999999999
rmesh_equiv_550 filter__buffer1__first__tail.n10 filter__buffer1__first__tail.n9 5.2415200000000004
rmesh_equiv_551 filter__buffer1__first__tail.n11 filter__buffer1__first__tail.n15 0.91112499999999996
rmesh_equiv_552 filter__buffer1__first__tail.n11 filter__buffer1__first__tail.n7 0.91112499999999996
rmesh_equiv_553 filter__buffer1__first__tail.n12 filter__buffer1__first__tail.n14 5.2415200000000004
rmesh_equiv_554 filter__buffer1__first__tail.n12 filter__buffer1__first__tail.t2 174.857
rmesh_equiv_555 filter__buffer1__first__tail.n13 filter__buffer1__first__tail.n14 5.2415200000000004
rmesh_equiv_556 filter__buffer1__first__tail.n13 filter__buffer1__first__tail.t2 174.857
rmesh_equiv_557 filter__buffer1__first__tail.n14 filter__buffer1__first__tail.n15 20.798500000000001
rmesh_equiv_558 filter__buffer1__first__tail.n15 filter__buffer1__first__tail.n16 19.887899999999998
rmesh_equiv_559 filter__buffer1__first__tail.n16 filter__buffer1__first__tail.n17 5.2415200000000004
rmesh_equiv_56 bias.n1 bias.t1 174.91200000000001
rmesh_equiv_560 filter__buffer1__first__tail.n17 filter__buffer1__first__tail.t0 174.857
rmesh_equiv_561 filter__buffer1__first__tail.n2 filter__buffer1__first__tail.n3 3.0467200000000001
rmesh_equiv_562 filter__buffer1__first__tail.n2 filter__buffer1__first__tail.t4 181.41
rmesh_equiv_563 filter__buffer1__first__tail.n3 filter__buffer1__first__tail.n7 22.3871
rmesh_equiv_564 filter__buffer1__first__tail.n4 filter__buffer1__first__tail.n6 5.2415200000000004
rmesh_equiv_565 filter__buffer1__first__tail.n4 filter__buffer1__first__tail.t3 174.857
rmesh_equiv_566 filter__buffer1__first__tail.n5 filter__buffer1__first__tail.n6 5.2415200000000004
rmesh_equiv_567 filter__buffer1__first__tail.n5 filter__buffer1__first__tail.t3 174.857
rmesh_equiv_568 filter__buffer1__first__tail.n6 filter__buffer1__first__tail.n7 19.887899999999998
rmesh_equiv_569 filter__buffer1__first__tail.n8 filter__buffer1__first__tail.t1 174.857
rmesh_equiv_57 bias.n10 bias.n11 1.84643
rmesh_equiv_570 filter__buffer1__first__tail.n9 filter__buffer1__first__tail.t1 174.857
rmesh_equiv_571 filter__buffer1__pre filter__buffer1__pre.n0 22.8553
rmesh_equiv_572 filter__buffer1__pre filter__buffer1__pre.n1 2.9479326624577999
rmesh_equiv_573 filter__buffer1__pre filter__buffer1__pre.n13 4.8770699999999998
rmesh_equiv_574 filter__buffer1__pre filter__buffer1__pre.n2 4.4774000000000003
rmesh_equiv_575 filter__buffer1__pre filter__buffer1__pre.n3 26.799300000000002
rmesh_equiv_576 filter__buffer1__pre filter__buffer1__pre.n4 15.6333
rmesh_equiv_577 filter__buffer1__pre filter__buffer1__pre.n5 15.6333
rmesh_equiv_578 filter__buffer1__pre filter__buffer1__pre.n7 15.6333
rmesh_equiv_579 filter__buffer1__pre filter__buffer1__pre.n8 15.6333
rmesh_equiv_58 bias.n10 bias.n9 21.805
rmesh_equiv_580 filter__buffer1__pre filter__buffer1__pre.t3 1054.8499999999999
rmesh_equiv_581 filter__buffer1__pre filter__buffer1__pre.t4 0.00141837
rmesh_equiv_582 filter__buffer1__pre filter__buffer1__pre.t5 0.00141837
rmesh_equiv_583 filter__buffer1__pre filter__buffer1__pre.t6 0.00141837
rmesh_equiv_584 filter__buffer1__pre.n0 filter__buffer1__pre.n12 11.4361
rmesh_equiv_585 filter__buffer1__pre.n0 filter__buffer1__pre.t0 381.113
rmesh_equiv_586 filter__buffer1__pre.n1 filter__buffer1__pre.n2 4.1529499999999997
rmesh_equiv_587 filter__buffer1__pre.n10 filter__buffer1__pre.n11 1.8528899999999999
rmesh_equiv_588 filter__buffer1__pre.n10 filter__buffer1__pre.n6 19.726600000000001
rmesh_equiv_589 filter__buffer1__pre.n10 filter__buffer1__pre.n9 16.9712
rmesh_equiv_59 bias.n11 bias.n12 27.714099999999998
rmesh_equiv_590 filter__buffer1__pre.n11 filter__buffer1__pre.n12 16.9712
rmesh_equiv_591 filter__buffer1__pre.n11 filter__buffer1__pre.n3 2.2512099999999999
rmesh_equiv_592 filter__buffer1__pre.n12 filter__buffer1__pre.n13 2.4407800000000002
rmesh_equiv_593 filter__buffer1__pre.n13 filter__buffer1__pre.t0 387.11000000000001
rmesh_equiv_594 filter__buffer1__pre.n2 filter__buffer1__pre.n3 3.1113099999999996
rmesh_equiv_595 filter__buffer1__pre.n4 filter__buffer1__pre.n6 5.2415200000000004
rmesh_equiv_596 filter__buffer1__pre.n4 filter__buffer1__pre.t2 174.857
rmesh_equiv_597 filter__buffer1__pre.n5 filter__buffer1__pre.n6 5.2415200000000004
rmesh_equiv_598 filter__buffer1__pre.n5 filter__buffer1__pre.t2 174.857
rmesh_equiv_599 filter__buffer1__pre.n7 filter__buffer1__pre.n9 5.2415200000000004
rmesh_equiv_6 amplified amplified.t5 212.21199999999999
rmesh_equiv_60 bias.n12 bias.n13 1.84643
rmesh_equiv_600 filter__buffer1__pre.n7 filter__buffer1__pre.t1 174.857
rmesh_equiv_601 filter__buffer1__pre.n8 filter__buffer1__pre.n9 5.2415200000000004
rmesh_equiv_602 filter__buffer1__pre.n8 filter__buffer1__pre.t1 174.857
rmesh_equiv_603 filter__filter0 filter__filter0.n0 4.3646000000000003
rmesh_equiv_604 filter__filter0 filter__filter0.n1 4.3646000000000003
rmesh_equiv_605 filter__filter0 filter__filter0.n10 4.3646000000000003
rmesh_equiv_606 filter__filter0 filter__filter0.n11 4.3646000000000003
rmesh_equiv_607 filter__filter0 filter__filter0.n12 16.89811560809753
rmesh_equiv_608 filter__filter0 filter__filter0.n2 4.3646000000000003
rmesh_equiv_609 filter__filter0 filter__filter0.n3 4.3646000000000003
rmesh_equiv_61 bias.n13 bias.n14 70.981099999999998
rmesh_equiv_610 filter__filter0 filter__filter0.n4 4.3646000000000003
rmesh_equiv_611 filter__filter0 filter__filter0.n5 4.3646000000000003
rmesh_equiv_612 filter__filter0 filter__filter0.n6 4.3646000000000003
rmesh_equiv_613 filter__filter0 filter__filter0.n7 4.3646000000000003
rmesh_equiv_614 filter__filter0 filter__filter0.n8 4.3646000000000003
rmesh_equiv_615 filter__filter0 filter__filter0.n9 4.3646000000000003
rmesh_equiv_616 filter__filter0 filter__filter0.t1 0.00141837
rmesh_equiv_617 filter__filter0 filter__filter0.t10 0.00141837
rmesh_equiv_618 filter__filter0 filter__filter0.t11 0.00141837
rmesh_equiv_619 filter__filter0 filter__filter0.t12 0.00141837
rmesh_equiv_62 bias.n14 bias.n15 1.84643
rmesh_equiv_620 filter__filter0 filter__filter0.t13 0.00141837
rmesh_equiv_621 filter__filter0 filter__filter0.t14 0.00141837
rmesh_equiv_622 filter__filter0 filter__filter0.t2 0.00141837
rmesh_equiv_623 filter__filter0 filter__filter0.t3 0.00141837
rmesh_equiv_624 filter__filter0 filter__filter0.t4 212.21199999999999
rmesh_equiv_625 filter__filter0 filter__filter0.t5 0.00141837
rmesh_equiv_626 filter__filter0 filter__filter0.t6 212.21199999999999
rmesh_equiv_627 filter__filter0 filter__filter0.t7 0.00141837
rmesh_equiv_628 filter__filter0 filter__filter0.t8 0.00141837
rmesh_equiv_629 filter__filter0 filter__filter0.t9 0.00141837
rmesh_equiv_63 bias.n15 bias.n16 70.981099999999998
rmesh_equiv_630 filter__filter0.n0 filter__filter0.n1 4.1529499999999997
rmesh_equiv_631 filter__filter0.n0 filter__filter0.t0 25.293099999999999
rmesh_equiv_632 filter__filter0.n1 filter__filter0.n2 4.1529499999999997
rmesh_equiv_633 filter__filter0.n10 filter__filter0.n11 4.1529499999999997
rmesh_equiv_634 filter__filter0.n10 filter__filter0.n9 4.1529499999999997
rmesh_equiv_635 filter__filter0.n11 filter__filter0.n12 2.8816000000000002
rmesh_equiv_636 filter__filter0.n2 filter__filter0.n3 4.1529499999999997
rmesh_equiv_637 filter__filter0.n3 filter__filter0.n4 4.1529499999999997
rmesh_equiv_638 filter__filter0.n4 filter__filter0.n5 4.1529499999999997
rmesh_equiv_639 filter__filter0.n5 filter__filter0.n6 4.1529499999999997
rmesh_equiv_64 bias.n16 bias.n17 1.84643
rmesh_equiv_640 filter__filter0.n6 filter__filter0.n7 4.1529499999999997
rmesh_equiv_641 filter__filter0.n7 filter__filter0.n8 4.1529499999999997
rmesh_equiv_642 filter__filter0.n8 filter__filter0.n9 4.1529499999999997
rmesh_equiv_643 filter__filter1 filter__filter1.n0 4.3646000000000003
rmesh_equiv_644 filter__filter1 filter__filter1.n1 4.3646000000000003
rmesh_equiv_645 filter__filter1 filter__filter1.n10 4.3646000000000003
rmesh_equiv_646 filter__filter1 filter__filter1.n11 4.3646000000000003
rmesh_equiv_647 filter__filter1 filter__filter1.n12 16.89811560809753
rmesh_equiv_648 filter__filter1 filter__filter1.n2 4.3646000000000003
rmesh_equiv_649 filter__filter1 filter__filter1.n3 4.3646000000000003
rmesh_equiv_65 bias.n2 bias.n3 18.2212
rmesh_equiv_650 filter__filter1 filter__filter1.n4 4.3646000000000003
rmesh_equiv_651 filter__filter1 filter__filter1.n5 4.3646000000000003
rmesh_equiv_652 filter__filter1 filter__filter1.n6 4.3646000000000003
rmesh_equiv_653 filter__filter1 filter__filter1.n7 4.3646000000000003
rmesh_equiv_654 filter__filter1 filter__filter1.n8 4.3646000000000003
rmesh_equiv_655 filter__filter1 filter__filter1.n9 4.3646000000000003
rmesh_equiv_656 filter__filter1 filter__filter1.t1 0.00141837
rmesh_equiv_657 filter__filter1 filter__filter1.t10 0.00141837
rmesh_equiv_658 filter__filter1 filter__filter1.t11 0.00141837
rmesh_equiv_659 filter__filter1 filter__filter1.t12 0.00141837
rmesh_equiv_66 bias.n3 bias.n4 0.39353700000000003
rmesh_equiv_660 filter__filter1 filter__filter1.t13 0.00141837
rmesh_equiv_661 filter__filter1 filter__filter1.t14 0.00141837
rmesh_equiv_662 filter__filter1 filter__filter1.t2 212.21199999999999
rmesh_equiv_663 filter__filter1 filter__filter1.t3 0.00141837
rmesh_equiv_664 filter__filter1 filter__filter1.t4 212.21199999999999
rmesh_equiv_665 filter__filter1 filter__filter1.t5 0.00141837
rmesh_equiv_666 filter__filter1 filter__filter1.t6 0.00141837
rmesh_equiv_667 filter__filter1 filter__filter1.t7 0.00141837
rmesh_equiv_668 filter__filter1 filter__filter1.t8 0.00141837
rmesh_equiv_669 filter__filter1 filter__filter1.t9 0.00141837
rmesh_equiv_67 bias.n4 bias.n5 0.79479999999999995
rmesh_equiv_670 filter__filter1.n0 filter__filter1.n1 4.1529499999999997
rmesh_equiv_671 filter__filter1.n0 filter__filter1.t0 25.293099999999999
rmesh_equiv_672 filter__filter1.n1 filter__filter1.n2 4.1529499999999997
rmesh_equiv_673 filter__filter1.n10 filter__filter1.n11 4.1529499999999997
rmesh_equiv_674 filter__filter1.n10 filter__filter1.n9 4.1529499999999997
rmesh_equiv_675 filter__filter1.n11 filter__filter1.n12 2.8816000000000002
rmesh_equiv_676 filter__filter1.n2 filter__filter1.n3 4.1529499999999997
rmesh_equiv_677 filter__filter1.n3 filter__filter1.n4 4.1529499999999997
rmesh_equiv_678 filter__filter1.n4 filter__filter1.n5 4.1529499999999997
rmesh_equiv_679 filter__filter1.n5 filter__filter1.n6 4.1529499999999997
rmesh_equiv_68 bias.n5 bias.n6 62.323700000000002
rmesh_equiv_680 filter__filter1.n6 filter__filter1.n7 4.1529499999999997
rmesh_equiv_681 filter__filter1.n7 filter__filter1.n8 4.1529499999999997
rmesh_equiv_682 filter__filter1.n8 filter__filter1.n9 4.1529499999999997
rmesh_equiv_683 filter__mid filter__mid.n0 19.837
rmesh_equiv_684 filter__mid filter__mid.n10 4.2590000000000003
rmesh_equiv_685 filter__mid filter__mid.n2 18.54550596914542
rmesh_equiv_686 filter__mid filter__mid.n3 33.9895
rmesh_equiv_687 filter__mid filter__mid.n5 6.9688099999999995
rmesh_equiv_688 filter__mid filter__mid.t4 212.21199999999999
rmesh_equiv_689 filter__mid filter__mid.t5 212.21199999999999
rmesh_equiv_69 bias.n5 bias.t2 33.237900000000003
rmesh_equiv_690 filter__mid.n0 filter__mid.n9 14.189499999999999
rmesh_equiv_691 filter__mid.n0 filter__mid.t0 174.91200000000001
rmesh_equiv_692 filter__mid.n1 filter__mid.n8 13.727399999999999
rmesh_equiv_693 filter__mid.n1 filter__mid.t2 26.499399999999998
rmesh_equiv_694 filter__mid.n1 filter__mid.t3 32.677100000000003
rmesh_equiv_695 filter__mid.n10 filter__mid.n9 3.0467200000000001
rmesh_equiv_696 filter__mid.n10 filter__mid.t0 181.41
rmesh_equiv_697 filter__mid.n2 filter__mid.n7 4.2281500000000003
rmesh_equiv_698 filter__mid.n3 filter__mid.n4 13.2728
rmesh_equiv_699 filter__mid.n3 filter__mid.n6 0.51338700000000004
rmesh_equiv_7 amplified.n0 amplified.n9 14.189499999999999
rmesh_equiv_70 bias.n6 bias.n7 1.84643
rmesh_equiv_700 filter__mid.n4 filter__mid.n5 13.200100000000001
rmesh_equiv_701 filter__mid.n4 filter__mid.t1 0.71462499999999995
rmesh_equiv_702 filter__mid.n5 filter__mid.n6 0.27270899999999998
rmesh_equiv_703 filter__mid.n6 filter__mid.n7 20.7212
rmesh_equiv_704 filter__mid.n7 filter__mid.n8 0.91758700000000015
rmesh_equiv_705 filter__mid.n8 filter__mid.n9 20.7212
rmesh_equiv_706 gain gain.n0 28.482537567341804
rmesh_equiv_707 gain gain.n1 36.631
rmesh_equiv_708 gain gain.n2 16.83362535489006
rmesh_equiv_709 gain gain.t0 3439.2399999999998
rmesh_equiv_71 bias.n7 bias.n8 19.9344
rmesh_equiv_710 gain gain.t1 330.34100000000001
rmesh_equiv_711 gain gain.t2 3424.7800000000002
rmesh_equiv_712 gain gain.t3 315.88
rmesh_equiv_713 gain.n0 gain.n1 0.81771300000000002
rmesh_equiv_714 gain.n1 gain.n2 1.6402100000000002
rmesh_equiv_715 out out.n0 33.479799999999997
rmesh_equiv_716 out out.n1 19.837
rmesh_equiv_717 out out.n10 33.307899999999997
rmesh_equiv_718 out out.n11 29.766074724270659
rmesh_equiv_719 out out.n2 4.2590000000000003
rmesh_equiv_72 bias.n8 bias.n9 1.84643
rmesh_equiv_720 out out.n5 33.9895
rmesh_equiv_721 out out.n7 6.9688099999999995
rmesh_equiv_722 out out.t3 332.71199999999999
rmesh_equiv_723 out out.t4 212.21199999999999
rmesh_equiv_724 out out.t5 212.21199999999999
rmesh_equiv_725 out.n0 out.n4 13.727399999999999
rmesh_equiv_726 out.n0 out.t1 29.343800000000005
rmesh_equiv_727 out.n1 out.n3 14.189499999999999
rmesh_equiv_728 out.n1 out.t0 174.91200000000001
rmesh_equiv_729 out.n10 out.n11 0.91112499999999996
rmesh_equiv_73 bias_source__vcm_buffer__comp.n0 bias_source__vcm_buffer__comp.n1 4.1529499999999997
rmesh_equiv_730 out.n10 out.n9 4.2281500000000003
rmesh_equiv_731 out.n2 out.n3 3.0467200000000001
rmesh_equiv_732 out.n2 out.t0 181.41
rmesh_equiv_733 out.n3 out.n4 17.387899999999998
rmesh_equiv_734 out.n4 out.n9 0.91758700000000015
rmesh_equiv_735 out.n5 out.n6 13.2728
rmesh_equiv_736 out.n5 out.n8 0.51338700000000004
rmesh_equiv_737 out.n6 out.n7 13.200100000000001
rmesh_equiv_738 out.n6 out.t2 0.71462499999999995
rmesh_equiv_739 out.n7 out.n8 0.27270899999999998
rmesh_equiv_74 bias_source__vcm_buffer__comp.n0 bias_source__vcm_buffer__comp.t2 9.7733699999999999
rmesh_equiv_740 out.n8 out.n9 17.387899999999998
rmesh_equiv_741 pga__gain2__amp__comp.n0 pga__gain2__amp__comp.n1 4.1529499999999997
rmesh_equiv_742 pga__gain2__amp__comp.n0 pga__gain2__amp__comp.t1 5.8465199999999999
rmesh_equiv_743 pga__gain2__amp__comp.n0 pga__gain2__amp__comp.t2 9.9989699999999999
rmesh_equiv_744 pga__gain2__amp__comp.n1 pga__gain2__amp__comp.t0 30.7759
rmesh_equiv_745 pga__gain2__amp__comp.n1 pga__gain2__amp__comp.t3 5.8465199999999999
rmesh_equiv_746 pga__gain2__amp__first__mir pga__gain2__amp__first__mir.n0 22.8553
rmesh_equiv_747 pga__gain2__amp__first__mir pga__gain2__amp__first__mir.n1 17.23853345464827
rmesh_equiv_748 pga__gain2__amp__first__mir pga__gain2__amp__first__mir.n11 4.8770699999999998
rmesh_equiv_749 pga__gain2__amp__first__mir pga__gain2__amp__first__mir.n2 15.6333
rmesh_equiv_75 bias_source__vcm_buffer__comp.n0 bias_source__vcm_buffer__comp.t3 5.6209199999999999
rmesh_equiv_750 pga__gain2__amp__first__mir pga__gain2__amp__first__mir.n3 15.6333
rmesh_equiv_751 pga__gain2__amp__first__mir pga__gain2__amp__first__mir.n5 15.6333
rmesh_equiv_752 pga__gain2__amp__first__mir pga__gain2__amp__first__mir.n6 15.6333
rmesh_equiv_753 pga__gain2__amp__first__mir pga__gain2__amp__first__mir.t0 572.84699999999998
rmesh_equiv_754 pga__gain2__amp__first__mir pga__gain2__amp__first__mir.t4 572.84699999999998
rmesh_equiv_755 pga__gain2__amp__first__mir.n0 pga__gain2__amp__first__mir.n10 11.4361
rmesh_equiv_756 pga__gain2__amp__first__mir.n0 pga__gain2__amp__first__mir.t1 381.113
rmesh_equiv_757 pga__gain2__amp__first__mir.n1 pga__gain2__amp__first__mir.n9 0.39353700000000003
rmesh_equiv_758 pga__gain2__amp__first__mir.n10 pga__gain2__amp__first__mir.n11 2.4407800000000002
rmesh_equiv_759 pga__gain2__amp__first__mir.n10 pga__gain2__amp__first__mir.n9 20.7212
rmesh_equiv_76 bias_source__vcm_buffer__comp.n1 bias_source__vcm_buffer__comp.t0 29.942599999999999
rmesh_equiv_760 pga__gain2__amp__first__mir.n11 pga__gain2__amp__first__mir.t1 387.11000000000001
rmesh_equiv_761 pga__gain2__amp__first__mir.n2 pga__gain2__amp__first__mir.n4 5.2415200000000004
rmesh_equiv_762 pga__gain2__amp__first__mir.n2 pga__gain2__amp__first__mir.t2 174.857
rmesh_equiv_763 pga__gain2__amp__first__mir.n3 pga__gain2__amp__first__mir.n4 5.2415200000000004
rmesh_equiv_764 pga__gain2__amp__first__mir.n3 pga__gain2__amp__first__mir.t2 174.857
rmesh_equiv_765 pga__gain2__amp__first__mir.n4 pga__gain2__amp__first__mir.n8 21.631799999999998
rmesh_equiv_766 pga__gain2__amp__first__mir.n5 pga__gain2__amp__first__mir.n7 5.2415200000000004
rmesh_equiv_767 pga__gain2__amp__first__mir.n5 pga__gain2__amp__first__mir.t3 174.857
rmesh_equiv_768 pga__gain2__amp__first__mir.n6 pga__gain2__amp__first__mir.n7 5.2415200000000004
rmesh_equiv_769 pga__gain2__amp__first__mir.n6 pga__gain2__amp__first__mir.t3 174.857
rmesh_equiv_77 bias_source__vcm_buffer__comp.n1 bias_source__vcm_buffer__comp.t1 5.6209199999999999
rmesh_equiv_770 pga__gain2__amp__first__mir.n7 pga__gain2__amp__first__mir.n8 20.7212
rmesh_equiv_771 pga__gain2__amp__first__mir.n8 pga__gain2__amp__first__mir.n9 1.83996
rmesh_equiv_772 pga__gain2__amp__first__tail pga__gain2__amp__first__tail.n0 19.837
rmesh_equiv_773 pga__gain2__amp__first__tail pga__gain2__amp__first__tail.n1 15.6333
rmesh_equiv_774 pga__gain2__amp__first__tail pga__gain2__amp__first__tail.n12 15.6333
rmesh_equiv_775 pga__gain2__amp__first__tail pga__gain2__amp__first__tail.n13 15.6333
rmesh_equiv_776 pga__gain2__amp__first__tail pga__gain2__amp__first__tail.n17 4.2590000000000003
rmesh_equiv_777 pga__gain2__amp__first__tail pga__gain2__amp__first__tail.n2 15.6333
rmesh_equiv_778 pga__gain2__amp__first__tail pga__gain2__amp__first__tail.n4 15.6333
rmesh_equiv_779 pga__gain2__amp__first__tail pga__gain2__amp__first__tail.n5 15.6333
rmesh_equiv_78 bias_source__vcm_buffer__first__mir bias_source__vcm_buffer__first__mir.n0 15.6333
rmesh_equiv_780 pga__gain2__amp__first__tail pga__gain2__amp__first__tail.n8 15.6333
rmesh_equiv_781 pga__gain2__amp__first__tail pga__gain2__amp__first__tail.n9 15.6333
rmesh_equiv_782 pga__gain2__amp__first__tail.n0 pga__gain2__amp__first__tail.n16 14.189499999999999
rmesh_equiv_783 pga__gain2__amp__first__tail.n0 pga__gain2__amp__first__tail.t0 174.91200000000001
rmesh_equiv_784 pga__gain2__amp__first__tail.n1 pga__gain2__amp__first__tail.n3 5.2415200000000004
rmesh_equiv_785 pga__gain2__amp__first__tail.n1 pga__gain2__amp__first__tail.t3 174.857
rmesh_equiv_786 pga__gain2__amp__first__tail.n10 pga__gain2__amp__first__tail.n11 20.304500000000001
rmesh_equiv_787 pga__gain2__amp__first__tail.n10 pga__gain2__amp__first__tail.n8 5.2415200000000004
rmesh_equiv_788 pga__gain2__amp__first__tail.n10 pga__gain2__amp__first__tail.n9 5.2415200000000004
rmesh_equiv_789 pga__gain2__amp__first__tail.n11 pga__gain2__amp__first__tail.n15 0.91112499999999996
rmesh_equiv_79 bias_source__vcm_buffer__first__mir bias_source__vcm_buffer__first__mir.n1 17.446920367221157
rmesh_equiv_790 pga__gain2__amp__first__tail.n11 pga__gain2__amp__first__tail.n7 0.91112499999999996
rmesh_equiv_791 pga__gain2__amp__first__tail.n12 pga__gain2__amp__first__tail.n14 5.2415200000000004
rmesh_equiv_792 pga__gain2__amp__first__tail.n12 pga__gain2__amp__first__tail.t4 174.857
rmesh_equiv_793 pga__gain2__amp__first__tail.n13 pga__gain2__amp__first__tail.n14 5.2415200000000004
rmesh_equiv_794 pga__gain2__amp__first__tail.n13 pga__gain2__amp__first__tail.t4 174.857
rmesh_equiv_795 pga__gain2__amp__first__tail.n14 pga__gain2__amp__first__tail.n15 20.304500000000001
rmesh_equiv_796 pga__gain2__amp__first__tail.n15 pga__gain2__amp__first__tail.n16 22.803799999999999
rmesh_equiv_797 pga__gain2__amp__first__tail.n16 pga__gain2__amp__first__tail.n17 3.0467200000000001
rmesh_equiv_798 pga__gain2__amp__first__tail.n17 pga__gain2__amp__first__tail.t0 181.41
rmesh_equiv_799 pga__gain2__amp__first__tail.n2 pga__gain2__amp__first__tail.n3 5.2415200000000004
rmesh_equiv_8 amplified.n0 amplified.t0 174.91200000000001
rmesh_equiv_80 bias_source__vcm_buffer__first__mir bias_source__vcm_buffer__first__mir.n11 15.6333
rmesh_equiv_800 pga__gain2__amp__first__tail.n2 pga__gain2__amp__first__tail.t3 174.857
rmesh_equiv_801 pga__gain2__amp__first__tail.n3 pga__gain2__amp__first__tail.n7 21.215199999999999
rmesh_equiv_802 pga__gain2__amp__first__tail.n4 pga__gain2__amp__first__tail.n6 5.2415200000000004
rmesh_equiv_803 pga__gain2__amp__first__tail.n4 pga__gain2__amp__first__tail.t2 174.857
rmesh_equiv_804 pga__gain2__amp__first__tail.n5 pga__gain2__amp__first__tail.n6 5.2415200000000004
rmesh_equiv_805 pga__gain2__amp__first__tail.n5 pga__gain2__amp__first__tail.t2 174.857
rmesh_equiv_806 pga__gain2__amp__first__tail.n6 pga__gain2__amp__first__tail.n7 20.304500000000001
rmesh_equiv_807 pga__gain2__amp__first__tail.n8 pga__gain2__amp__first__tail.t1 174.857
rmesh_equiv_808 pga__gain2__amp__first__tail.n9 pga__gain2__amp__first__tail.t1 174.857
rmesh_equiv_809 pga__gain2__amp__pre pga__gain2__amp__pre.n0 15.6333
rmesh_equiv_81 bias_source__vcm_buffer__first__mir bias_source__vcm_buffer__first__mir.n2 4.8770699999999998
rmesh_equiv_810 pga__gain2__amp__pre pga__gain2__amp__pre.n1 3.3780963507178385
rmesh_equiv_811 pga__gain2__amp__pre pga__gain2__amp__pre.n13 15.6333
rmesh_equiv_812 pga__gain2__amp__pre pga__gain2__amp__pre.n2 5.2670000000000003
rmesh_equiv_813 pga__gain2__amp__pre pga__gain2__amp__pre.n3 29.715900000000001
rmesh_equiv_814 pga__gain2__amp__pre pga__gain2__amp__pre.n4 4.8770699999999998
rmesh_equiv_815 pga__gain2__amp__pre pga__gain2__amp__pre.n5 22.8553
rmesh_equiv_816 pga__gain2__amp__pre pga__gain2__amp__pre.n8 15.6333
rmesh_equiv_817 pga__gain2__amp__pre pga__gain2__amp__pre.n9 15.6333
rmesh_equiv_818 pga__gain2__amp__pre pga__gain2__amp__pre.t3 0.00141837
rmesh_equiv_819 pga__gain2__amp__pre pga__gain2__amp__pre.t4 0.00141837
rmesh_equiv_82 bias_source__vcm_buffer__first__mir bias_source__vcm_buffer__first__mir.n3 22.8553
rmesh_equiv_820 pga__gain2__amp__pre pga__gain2__amp__pre.t5 0.00141837
rmesh_equiv_821 pga__gain2__amp__pre pga__gain2__amp__pre.t6 1054.8499999999999
rmesh_equiv_822 pga__gain2__amp__pre.n0 pga__gain2__amp__pre.n12 5.2415200000000004
rmesh_equiv_823 pga__gain2__amp__pre.n0 pga__gain2__amp__pre.t0 174.857
rmesh_equiv_824 pga__gain2__amp__pre.n1 pga__gain2__amp__pre.n2 4.1529499999999997
rmesh_equiv_825 pga__gain2__amp__pre.n10 pga__gain2__amp__pre.n11 22.6432
rmesh_equiv_826 pga__gain2__amp__pre.n10 pga__gain2__amp__pre.n8 5.2415200000000004
rmesh_equiv_827 pga__gain2__amp__pre.n10 pga__gain2__amp__pre.n9 5.2415200000000004
rmesh_equiv_828 pga__gain2__amp__pre.n11 pga__gain2__amp__pre.n12 19.887899999999998
rmesh_equiv_829 pga__gain2__amp__pre.n11 pga__gain2__amp__pre.n7 1.8528899999999999
rmesh_equiv_83 bias_source__vcm_buffer__first__mir bias_source__vcm_buffer__first__mir.n6 15.6333
rmesh_equiv_830 pga__gain2__amp__pre.n12 pga__gain2__amp__pre.n13 5.2415200000000004
rmesh_equiv_831 pga__gain2__amp__pre.n13 pga__gain2__amp__pre.t0 174.857
rmesh_equiv_832 pga__gain2__amp__pre.n2 pga__gain2__amp__pre.n3 3.1113099999999996
rmesh_equiv_833 pga__gain2__amp__pre.n3 pga__gain2__amp__pre.n7 2.2512099999999999
rmesh_equiv_834 pga__gain2__amp__pre.n4 pga__gain2__amp__pre.n6 2.4407800000000002
rmesh_equiv_835 pga__gain2__amp__pre.n4 pga__gain2__amp__pre.t2 387.11000000000001
rmesh_equiv_836 pga__gain2__amp__pre.n5 pga__gain2__amp__pre.n6 11.4361
rmesh_equiv_837 pga__gain2__amp__pre.n5 pga__gain2__amp__pre.t2 381.113
rmesh_equiv_838 pga__gain2__amp__pre.n6 pga__gain2__amp__pre.n7 19.887899999999998
rmesh_equiv_839 pga__gain2__amp__pre.n8 pga__gain2__amp__pre.t1 174.857
rmesh_equiv_84 bias_source__vcm_buffer__first__mir bias_source__vcm_buffer__first__mir.n7 15.6333
rmesh_equiv_840 pga__gain2__amp__pre.n9 pga__gain2__amp__pre.t1 174.857
rmesh_equiv_841 pga__gain2__fb pga__gain2__fb.n1 18.753861394840492
rmesh_equiv_842 pga__gain2__fb pga__gain2__fb.t2 212.21199999999999
rmesh_equiv_843 pga__gain2__fb pga__gain2__fb.t3 212.21199999999999
rmesh_equiv_844 pga__gain2__fb.n0 pga__gain2__fb.n1 19.548999999999999
rmesh_equiv_845 pga__gain2__fb.n0 pga__gain2__fb.t0 29.946400000000001
rmesh_equiv_846 pga__gain2__fb.n0 pga__gain2__fb.t1 34.912199999999999
rmesh_equiv_847 pga__gain8__amp__comp.n0 pga__gain8__amp__comp.n1 4.1529499999999997
rmesh_equiv_848 pga__gain8__amp__comp.n0 pga__gain8__amp__comp.t0 9.9989699999999999
rmesh_equiv_849 pga__gain8__amp__comp.n0 pga__gain8__amp__comp.t1 5.8465199999999999
rmesh_equiv_85 bias_source__vcm_buffer__first__mir bias_source__vcm_buffer__first__mir.t2 572.84699999999998
rmesh_equiv_850 pga__gain8__amp__comp.n1 pga__gain8__amp__comp.n2 5.8385199999999999
rmesh_equiv_851 pga__gain8__amp__comp.n1 pga__gain8__amp__comp.t3 30.7759
rmesh_equiv_852 pga__gain8__amp__comp.n2 pga__gain8__amp__comp.t2 0.025939499999999997
rmesh_equiv_853 pga__gain8__amp__first__mir pga__gain8__amp__first__mir.n0 22.8553
rmesh_equiv_854 pga__gain8__amp__first__mir pga__gain8__amp__first__mir.n1 17.446920367221157
rmesh_equiv_855 pga__gain8__amp__first__mir pga__gain8__amp__first__mir.n11 4.8770699999999998
rmesh_equiv_856 pga__gain8__amp__first__mir pga__gain8__amp__first__mir.n2 15.6333
rmesh_equiv_857 pga__gain8__amp__first__mir pga__gain8__amp__first__mir.n3 15.6333
rmesh_equiv_858 pga__gain8__amp__first__mir pga__gain8__amp__first__mir.n5 15.6333
rmesh_equiv_859 pga__gain8__amp__first__mir pga__gain8__amp__first__mir.n6 15.6333
rmesh_equiv_86 bias_source__vcm_buffer__first__mir bias_source__vcm_buffer__first__mir.t4 572.84699999999998
rmesh_equiv_860 pga__gain8__amp__first__mir pga__gain8__amp__first__mir.t0 572.84699999999998
rmesh_equiv_861 pga__gain8__amp__first__mir pga__gain8__amp__first__mir.t4 572.84699999999998
rmesh_equiv_862 pga__gain8__amp__first__mir.n0 pga__gain8__amp__first__mir.n10 11.4361
rmesh_equiv_863 pga__gain8__amp__first__mir.n0 pga__gain8__amp__first__mir.t1 381.113
rmesh_equiv_864 pga__gain8__amp__first__mir.n1 pga__gain8__amp__first__mir.n9 0.39353700000000003
rmesh_equiv_865 pga__gain8__amp__first__mir.n10 pga__gain8__amp__first__mir.n11 2.4407800000000002
rmesh_equiv_866 pga__gain8__amp__first__mir.n10 pga__gain8__amp__first__mir.n9 21.137899999999998
rmesh_equiv_867 pga__gain8__amp__first__mir.n11 pga__gain8__amp__first__mir.t1 387.11000000000001
rmesh_equiv_868 pga__gain8__amp__first__mir.n2 pga__gain8__amp__first__mir.n4 5.2415200000000004
rmesh_equiv_869 pga__gain8__amp__first__mir.n2 pga__gain8__amp__first__mir.t3 174.857
rmesh_equiv_87 bias_source__vcm_buffer__first__mir.n0 bias_source__vcm_buffer__first__mir.n10 5.2415200000000004
rmesh_equiv_870 pga__gain8__amp__first__mir.n3 pga__gain8__amp__first__mir.n4 5.2415200000000004
rmesh_equiv_871 pga__gain8__amp__first__mir.n3 pga__gain8__amp__first__mir.t3 174.857
rmesh_equiv_872 pga__gain8__amp__first__mir.n4 pga__gain8__amp__first__mir.n8 22.048500000000001
rmesh_equiv_873 pga__gain8__amp__first__mir.n5 pga__gain8__amp__first__mir.n7 5.2415200000000004
rmesh_equiv_874 pga__gain8__amp__first__mir.n5 pga__gain8__amp__first__mir.t2 174.857
rmesh_equiv_875 pga__gain8__amp__first__mir.n6 pga__gain8__amp__first__mir.n7 5.2415200000000004
rmesh_equiv_876 pga__gain8__amp__first__mir.n6 pga__gain8__amp__first__mir.t2 174.857
rmesh_equiv_877 pga__gain8__amp__first__mir.n7 pga__gain8__amp__first__mir.n8 21.137899999999998
rmesh_equiv_878 pga__gain8__amp__first__mir.n8 pga__gain8__amp__first__mir.n9 1.83996
rmesh_equiv_879 pga__gain8__amp__first__tail pga__gain8__amp__first__tail.n0 19.837
rmesh_equiv_88 bias_source__vcm_buffer__first__mir.n0 bias_source__vcm_buffer__first__mir.t0 174.857
rmesh_equiv_880 pga__gain8__amp__first__tail pga__gain8__amp__first__tail.n1 15.6333
rmesh_equiv_881 pga__gain8__amp__first__tail pga__gain8__amp__first__tail.n12 15.6333
rmesh_equiv_882 pga__gain8__amp__first__tail pga__gain8__amp__first__tail.n13 15.6333
rmesh_equiv_883 pga__gain8__amp__first__tail pga__gain8__amp__first__tail.n17 4.2590000000000003
rmesh_equiv_884 pga__gain8__amp__first__tail pga__gain8__amp__first__tail.n2 15.6333
rmesh_equiv_885 pga__gain8__amp__first__tail pga__gain8__amp__first__tail.n4 15.6333
rmesh_equiv_886 pga__gain8__amp__first__tail pga__gain8__amp__first__tail.n5 15.6333
rmesh_equiv_887 pga__gain8__amp__first__tail pga__gain8__amp__first__tail.n8 15.6333
rmesh_equiv_888 pga__gain8__amp__first__tail pga__gain8__amp__first__tail.n9 15.6333
rmesh_equiv_889 pga__gain8__amp__first__tail.n0 pga__gain8__amp__first__tail.n16 14.189499999999999
rmesh_equiv_89 bias_source__vcm_buffer__first__mir.n1 bias_source__vcm_buffer__first__mir.n5 0.39353700000000003
rmesh_equiv_890 pga__gain8__amp__first__tail.n0 pga__gain8__amp__first__tail.t0 174.91200000000001
rmesh_equiv_891 pga__gain8__amp__first__tail.n1 pga__gain8__amp__first__tail.n3 5.2415200000000004
rmesh_equiv_892 pga__gain8__amp__first__tail.n1 pga__gain8__amp__first__tail.t1 174.857
rmesh_equiv_893 pga__gain8__amp__first__tail.n10 pga__gain8__amp__first__tail.n11 20.7212
rmesh_equiv_894 pga__gain8__amp__first__tail.n10 pga__gain8__amp__first__tail.n8 5.2415200000000004
rmesh_equiv_895 pga__gain8__amp__first__tail.n10 pga__gain8__amp__first__tail.n9 5.2415200000000004
rmesh_equiv_896 pga__gain8__amp__first__tail.n11 pga__gain8__amp__first__tail.n15 0.91112499999999996
rmesh_equiv_897 pga__gain8__amp__first__tail.n11 pga__gain8__amp__first__tail.n7 0.91112499999999996
rmesh_equiv_898 pga__gain8__amp__first__tail.n12 pga__gain8__amp__first__tail.n14 5.2415200000000004
rmesh_equiv_899 pga__gain8__amp__first__tail.n12 pga__gain8__amp__first__tail.t4 174.857
rmesh_equiv_9 amplified.n1 amplified.n8 13.727399999999999
rmesh_equiv_90 bias_source__vcm_buffer__first__mir.n10 bias_source__vcm_buffer__first__mir.n11 5.2415200000000004
rmesh_equiv_900 pga__gain8__amp__first__tail.n13 pga__gain8__amp__first__tail.n14 5.2415200000000004
rmesh_equiv_901 pga__gain8__amp__first__tail.n13 pga__gain8__amp__first__tail.t4 174.857
rmesh_equiv_902 pga__gain8__amp__first__tail.n14 pga__gain8__amp__first__tail.n15 20.7212
rmesh_equiv_903 pga__gain8__amp__first__tail.n15 pga__gain8__amp__first__tail.n16 23.220400000000001
rmesh_equiv_904 pga__gain8__amp__first__tail.n16 pga__gain8__amp__first__tail.n17 3.0467200000000001
rmesh_equiv_905 pga__gain8__amp__first__tail.n17 pga__gain8__amp__first__tail.t0 181.41
rmesh_equiv_906 pga__gain8__amp__first__tail.n2 pga__gain8__amp__first__tail.n3 5.2415200000000004
rmesh_equiv_907 pga__gain8__amp__first__tail.n2 pga__gain8__amp__first__tail.t1 174.857
rmesh_equiv_908 pga__gain8__amp__first__tail.n3 pga__gain8__amp__first__tail.n7 21.631799999999998
rmesh_equiv_909 pga__gain8__amp__first__tail.n4 pga__gain8__amp__first__tail.n6 5.2415200000000004
rmesh_equiv_91 bias_source__vcm_buffer__first__mir.n10 bias_source__vcm_buffer__first__mir.n9 21.137899999999998
rmesh_equiv_910 pga__gain8__amp__first__tail.n4 pga__gain8__amp__first__tail.t2 174.857
rmesh_equiv_911 pga__gain8__amp__first__tail.n5 pga__gain8__amp__first__tail.n6 5.2415200000000004
rmesh_equiv_912 pga__gain8__amp__first__tail.n5 pga__gain8__amp__first__tail.t2 174.857
rmesh_equiv_913 pga__gain8__amp__first__tail.n6 pga__gain8__amp__first__tail.n7 20.7212
rmesh_equiv_914 pga__gain8__amp__first__tail.n8 pga__gain8__amp__first__tail.t3 174.857
rmesh_equiv_915 pga__gain8__amp__first__tail.n9 pga__gain8__amp__first__tail.t3 174.857
rmesh_equiv_916 pga__gain8__amp__pre pga__gain8__amp__pre.n0 15.6333
rmesh_equiv_917 pga__gain8__amp__pre pga__gain8__amp__pre.n1 3.3780963507178385
rmesh_equiv_918 pga__gain8__amp__pre pga__gain8__amp__pre.n13 15.6333
rmesh_equiv_919 pga__gain8__amp__pre pga__gain8__amp__pre.n2 5.2670000000000003
rmesh_equiv_92 bias_source__vcm_buffer__first__mir.n11 bias_source__vcm_buffer__first__mir.t0 174.857
rmesh_equiv_920 pga__gain8__amp__pre pga__gain8__amp__pre.n3 29.715900000000001
rmesh_equiv_921 pga__gain8__amp__pre pga__gain8__amp__pre.n4 4.8770699999999998
rmesh_equiv_922 pga__gain8__amp__pre pga__gain8__amp__pre.n5 22.8553
rmesh_equiv_923 pga__gain8__amp__pre pga__gain8__amp__pre.n8 15.6333
rmesh_equiv_924 pga__gain8__amp__pre pga__gain8__amp__pre.n9 15.6333
rmesh_equiv_925 pga__gain8__amp__pre pga__gain8__amp__pre.t3 0.00141837
rmesh_equiv_926 pga__gain8__amp__pre pga__gain8__amp__pre.t4 0.00141837
rmesh_equiv_927 pga__gain8__amp__pre pga__gain8__amp__pre.t5 0.00141837
rmesh_equiv_928 pga__gain8__amp__pre pga__gain8__amp__pre.t6 1054.8499999999999
rmesh_equiv_929 pga__gain8__amp__pre.n0 pga__gain8__amp__pre.n12 5.2415200000000004
rmesh_equiv_93 bias_source__vcm_buffer__first__mir.n2 bias_source__vcm_buffer__first__mir.n4 2.4407800000000002
rmesh_equiv_930 pga__gain8__amp__pre.n0 pga__gain8__amp__pre.t0 174.857
rmesh_equiv_931 pga__gain8__amp__pre.n1 pga__gain8__amp__pre.n2 4.1529499999999997
rmesh_equiv_932 pga__gain8__amp__pre.n10 pga__gain8__amp__pre.n11 19.887899999999998
rmesh_equiv_933 pga__gain8__amp__pre.n10 pga__gain8__amp__pre.n8 5.2415200000000004
rmesh_equiv_934 pga__gain8__amp__pre.n10 pga__gain8__amp__pre.n9 5.2415200000000004
rmesh_equiv_935 pga__gain8__amp__pre.n11 pga__gain8__amp__pre.n12 22.6432
rmesh_equiv_936 pga__gain8__amp__pre.n11 pga__gain8__amp__pre.n7 1.8528899999999999
rmesh_equiv_937 pga__gain8__amp__pre.n12 pga__gain8__amp__pre.n13 5.2415200000000004
rmesh_equiv_938 pga__gain8__amp__pre.n13 pga__gain8__amp__pre.t0 174.857
rmesh_equiv_939 pga__gain8__amp__pre.n2 pga__gain8__amp__pre.n3 3.1113099999999996
rmesh_equiv_94 bias_source__vcm_buffer__first__mir.n2 bias_source__vcm_buffer__first__mir.t3 387.11000000000001
rmesh_equiv_940 pga__gain8__amp__pre.n3 pga__gain8__amp__pre.n7 2.2512099999999999
rmesh_equiv_941 pga__gain8__amp__pre.n4 pga__gain8__amp__pre.n6 2.4407800000000002
rmesh_equiv_942 pga__gain8__amp__pre.n4 pga__gain8__amp__pre.t1 387.11000000000001
rmesh_equiv_943 pga__gain8__amp__pre.n5 pga__gain8__amp__pre.n6 11.4361
rmesh_equiv_944 pga__gain8__amp__pre.n5 pga__gain8__amp__pre.t1 381.113
rmesh_equiv_945 pga__gain8__amp__pre.n6 pga__gain8__amp__pre.n7 19.887899999999998
rmesh_equiv_946 pga__gain8__amp__pre.n8 pga__gain8__amp__pre.t2 174.857
rmesh_equiv_947 pga__gain8__amp__pre.n9 pga__gain8__amp__pre.t2 174.857
rmesh_equiv_948 pga__gain8__fb pga__gain8__fb.n1 18.962217352537181
rmesh_equiv_949 pga__gain8__fb pga__gain8__fb.t2 212.21199999999999
rmesh_equiv_95 bias_source__vcm_buffer__first__mir.n3 bias_source__vcm_buffer__first__mir.n4 11.4361
rmesh_equiv_950 pga__gain8__fb pga__gain8__fb.t3 212.21199999999999
rmesh_equiv_951 pga__gain8__fb.n0 pga__gain8__fb.n1 19.548999999999999
rmesh_equiv_952 pga__gain8__fb.n0 pga__gain8__fb.t0 29.509899999999998
rmesh_equiv_953 pga__gain8__fb.n0 pga__gain8__fb.t1 30.363099999999996
rmesh_equiv_954 pga__gainb pga__gainb.n0 12.8005
rmesh_equiv_955 pga__gainb pga__gainb.n1 18.68879036773745
rmesh_equiv_956 pga__gainb pga__gainb.n2 12.8005
rmesh_equiv_957 pga__gainb pga__gainb.n3 12.8005
rmesh_equiv_958 pga__gainb pga__gainb.n7 12.8005
rmesh_equiv_959 pga__gainb pga__gainb.t2 3439.2399999999998
rmesh_equiv_96 bias_source__vcm_buffer__first__mir.n3 bias_source__vcm_buffer__first__mir.t3 381.113
rmesh_equiv_960 pga__gainb pga__gainb.t3 3424.7800000000002
rmesh_equiv_961 pga__gainb.n0 pga__gainb.n6 10.151300000000001
rmesh_equiv_962 pga__gainb.n0 pga__gainb.t0 700.48400000000004
rmesh_equiv_963 pga__gainb.n1 pga__gainb.n5 1.1660999999999999
rmesh_equiv_964 pga__gainb.n2 pga__gainb.n4 10.151300000000001
rmesh_equiv_965 pga__gainb.n2 pga__gainb.t1 255.34500000000003
rmesh_equiv_966 pga__gainb.n3 pga__gainb.n4 10.151300000000001
rmesh_equiv_967 pga__gainb.n3 pga__gainb.t1 255.34500000000003
rmesh_equiv_968 pga__gainb.n4 pga__gainb.n5 20.200399999999998
rmesh_equiv_969 pga__gainb.n5 pga__gainb.n6 21.017600000000002
rmesh_equiv_97 bias_source__vcm_buffer__first__mir.n4 bias_source__vcm_buffer__first__mir.n5 21.137899999999998
rmesh_equiv_970 pga__gainb.n6 pga__gainb.n7 10.151300000000001
rmesh_equiv_971 pga__gainb.n7 pga__gainb.t0 700.48400000000004
rmesh_equiv_972 pga__output_buffer__comp.n0 pga__output_buffer__comp.n1 4.1529499999999997
rmesh_equiv_973 pga__output_buffer__comp.n0 pga__output_buffer__comp.t2 27.0259
rmesh_equiv_974 pga__output_buffer__comp.n0 pga__output_buffer__comp.t3 4.8313199999999998
rmesh_equiv_975 pga__output_buffer__comp.n1 pga__output_buffer__comp.n2 8.9757599999999993
rmesh_equiv_976 pga__output_buffer__comp.n1 pga__output_buffer__comp.t1 4.8313199999999998
rmesh_equiv_977 pga__output_buffer__comp.n2 pga__output_buffer__comp.t0 0.025939499999999997
rmesh_equiv_978 pga__output_buffer__first__mir pga__output_buffer__first__mir.n0 22.8553
rmesh_equiv_979 pga__output_buffer__first__mir pga__output_buffer__first__mir.n1 16.821806896295538
rmesh_equiv_98 bias_source__vcm_buffer__first__mir.n5 bias_source__vcm_buffer__first__mir.n9 1.83996
rmesh_equiv_980 pga__output_buffer__first__mir pga__output_buffer__first__mir.n11 4.8770699999999998
rmesh_equiv_981 pga__output_buffer__first__mir pga__output_buffer__first__mir.n2 15.6333
rmesh_equiv_982 pga__output_buffer__first__mir pga__output_buffer__first__mir.n3 15.6333
rmesh_equiv_983 pga__output_buffer__first__mir pga__output_buffer__first__mir.n5 15.6333
rmesh_equiv_984 pga__output_buffer__first__mir pga__output_buffer__first__mir.n6 15.6333
rmesh_equiv_985 pga__output_buffer__first__mir pga__output_buffer__first__mir.t0 572.84699999999998
rmesh_equiv_986 pga__output_buffer__first__mir pga__output_buffer__first__mir.t4 572.84699999999998
rmesh_equiv_987 pga__output_buffer__first__mir.n0 pga__output_buffer__first__mir.n10 11.4361
rmesh_equiv_988 pga__output_buffer__first__mir.n0 pga__output_buffer__first__mir.t1 381.113
rmesh_equiv_989 pga__output_buffer__first__mir.n1 pga__output_buffer__first__mir.n9 0.39353700000000003
rmesh_equiv_99 bias_source__vcm_buffer__first__mir.n6 bias_source__vcm_buffer__first__mir.n8 5.2415200000000004
rmesh_equiv_990 pga__output_buffer__first__mir.n10 pga__output_buffer__first__mir.n11 2.4407800000000002
rmesh_equiv_991 pga__output_buffer__first__mir.n10 pga__output_buffer__first__mir.n9 19.887899999999998
rmesh_equiv_992 pga__output_buffer__first__mir.n11 pga__output_buffer__first__mir.t1 387.11000000000001
rmesh_equiv_993 pga__output_buffer__first__mir.n2 pga__output_buffer__first__mir.n4 5.2415200000000004
rmesh_equiv_994 pga__output_buffer__first__mir.n2 pga__output_buffer__first__mir.t3 174.857
rmesh_equiv_995 pga__output_buffer__first__mir.n3 pga__output_buffer__first__mir.n4 5.2415200000000004
rmesh_equiv_996 pga__output_buffer__first__mir.n3 pga__output_buffer__first__mir.t3 174.857
rmesh_equiv_997 pga__output_buffer__first__mir.n4 pga__output_buffer__first__mir.n8 20.798500000000001
rmesh_equiv_998 pga__output_buffer__first__mir.n5 pga__output_buffer__first__mir.n7 5.2415200000000004
rmesh_equiv_999 pga__output_buffer__first__mir.n5 pga__output_buffer__first__mir.t2 174.857
.ends

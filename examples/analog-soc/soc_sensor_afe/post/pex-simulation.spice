* NGSPICE file created from soc_sensor_afe.ext - technology: sky130A

.subckt soc_sensor_afe VPWR VGND DATA CLK RESET BIAS OUT VCM GAIN VIN
X0 VPWR PGA__AMP__FIRST__MIR.t1 PGA__AMP__FIRST__MIR.t2 VPWR sky130_fd_pr__pfet_01v8_hvt ad=5.8 pd=40.58 as=5.8 ps=40.58 w=20 l=1
X1 VGND.t33 RESET.t0 RESET_MUX__SB.t0 VGND.t32 sky130_fd_pr__nfet_01v8 ad=0.1885 pd=1.88 as=0.1885 ps=1.88 w=0.65 l=0.15
X2 AMPLIFIED.t1 FILTER__FILTER0.t0 VGND.t47 sky130_fd_pr__res_xhigh_po_1p41 l=28.04
X3 BIAS_SOURCE__VCM_BUFFER__FIRST__TAIL.t0 VCM.t4 BIAS_SOURCE__VCM_BUFFER__FIRST__MIR.t2 VGND.t88 sky130_fd_pr__nfet_01v8 ad=2.9 pd=20.58 as=2.9 ps=20.58 w=10 l=1
X4 FILTER__FILTER1.t1 VGND.t44 sky130_fd_pr__cap_mim_m3_1 l=28.68 w=28.68
X5 FILTER__BUFFER0__PRE.t2 FILTER__BUFFER0__COMP.t2 sky130_fd_pr__cap_mim_m3_1 l=28.68 w=28.68
X6 VGND.t64 SAMPLE__MB.t2 SAMPLE__MF.t1 VGND.t63 sky130_fd_pr__nfet_01v8 ad=0.1885 pd=1.88 as=0.1885 ps=1.88 w=0.65 l=0.15
X7 BIAS_SOURCE__VCM_RAW.t2 VGND.t53 sky130_fd_pr__cap_mim_m3_1 l=28.68 w=28.68
X8 PGA__AMP__FIRST__TAIL.t0 PGA__FB.t3 PGA__AMP__FIRST__MIR.t0 VGND.t9 sky130_fd_pr__nfet_01v8 ad=2.9 pd=20.58 as=2.9 ps=20.58 w=10 l=1
X9 FILTER__FILTER0.t1 VGND.t77 sky130_fd_pr__cap_mim_m3_1 l=28.68 w=28.68
X10 VGND.t27 SAMPLE__M.t4 SAMPLE__MB.t0 VGND.t26 sky130_fd_pr__nfet_01v8 ad=0.1885 pd=1.88 as=0.1885 ps=1.88 w=0.65 l=0.15
X11 VGND.t55 BIAS.t3 COMPARATOR__PREAMP__TAIL.t0 VGND.t54 sky130_fd_pr__nfet_01v8 ad=0.58 pd=4.58 as=0.58 ps=4.58 w=2 l=1
X12 VGND.t94 BIAS.t4 BIAS_SOURCE__VCM_BUFFER__FIRST__TAIL.t2 VGND.t93 sky130_fd_pr__nfet_01v8 ad=0.58 pd=4.58 as=0.58 ps=4.58 w=2 l=1
X13 PGA__LOW.t0 GAIN.t0 AMPLIFIED.t0 VPWR sky130_fd_pr__pfet_01v8_hvt ad=5.8 pd=40.58 as=5.8 ps=40.58 w=20 l=0.15
X14 PGA__AMP__PRE.t2 PGA__AMP__COMP.t2 sky130_fd_pr__cap_mim_m3_1 l=28.68 w=28.68
X15 FILTER__FILTER1.t2 VGND.t98 sky130_fd_pr__cap_mim_m3_1 l=28.68 w=28.68
X16 BIAS_SOURCE__VCM_RAW.t0 BIAS_SOURCE_R_VCM_BOTTOM_R0_N0.t0 VGND.t5 sky130_fd_pr__res_xhigh_po_1p41 l=23.34
X17 FILTER__FILTER1.t3 VGND.t106 sky130_fd_pr__cap_mim_m3_1 l=28.68 w=28.68
X18 VGND.t81 SAMPLE__T.t4 SAMPLE__TB.t0 VGND.t80 sky130_fd_pr__nfet_01v8 ad=0.1885 pd=1.88 as=0.1885 ps=1.88 w=0.65 l=0.15
X19 VPWR BIAS_SOURCE__VCM_BUFFER__PRE.t2 VCM.t3 VPWR sky130_fd_pr__pfet_01v8_hvt ad=11.6 pd=80.58 as=11.6 ps=80.58 w=40 l=1
X20 FILTER__BUFFER1__PRE.t2 FILTER__BUFFER1__COMP.t3 sky130_fd_pr__cap_mim_m3_1 l=28.68 w=28.68
X21 BIAS_SOURCE__VCM_RAW.t3 VGND.t78 sky130_fd_pr__cap_mim_m3_1 l=28.68 w=28.68
X22 BIAS_SOURCE__VCM_RAW.t4 VGND.t18 sky130_fd_pr__cap_mim_m3_1 l=28.68 w=28.68
X23 BIAS_SOURCE_R_VCM_BOTTOM_R0_N0.t1 BIAS_SOURCE_R_VCM_BOTTOM_R0_N1.t0 VGND.t14 sky130_fd_pr__res_xhigh_po_1p41 l=23.34
X24 PGA__AMP__COMP.t3 AMPLIFIED.t6 VGND.t84 sky130_fd_pr__res_xhigh_po_1p41 l=3.36
X25 FILTER__FILTER0.t2 VGND.t23 sky130_fd_pr__cap_mim_m3_1 l=28.68 w=28.68
X26 BIAS_SOURCE__VCM_RAW.t5 VGND.t57 sky130_fd_pr__cap_mim_m3_1 l=28.68 w=28.68
X27 AMPLIFIED.t5 PGA_R_HIGH_R0_N0.t0 VGND.t83 sky130_fd_pr__res_xhigh_po_1p41 l=24.51
X28 FILTER__BUFFER0__FIRST__TAIL.t1 FILTER__FILTER0.t3 FILTER__BUFFER0__PRE.t0 VGND.t76 sky130_fd_pr__nfet_01v8 ad=2.9 pd=20.58 as=2.9 ps=20.58 w=10 l=1
X29 BIAS_SOURCE__VCM_BUFFER__COMP.t3 VCM.t2 VGND.t89 sky130_fd_pr__res_xhigh_po_1p41 l=3.36
X30 VGND.t31 RESET.t1 D.t3 VGND.t30 sky130_fd_pr__nfet_01v8 ad=0.1885 pd=1.88 as=0.1885 ps=1.88 w=0.65 l=0.15
X31 FILTER__FILTER1.t4 VGND.t68 sky130_fd_pr__cap_mim_m3_1 l=28.68 w=28.68
X32 SAMPLE__MF.t0 SAMPLE__CLKB.t2 SAMPLE__T.t1 VPWR sky130_fd_pr__pfet_01v8_hvt ad=0.1885 pd=1.88 as=0.1885 ps=1.88 w=0.65 l=0.15
X33 VGND.t7 GAIN.t1 PGA__GAINB.t0 VGND.t6 sky130_fd_pr__nfet_01v8 ad=0.1885 pd=1.88 as=0.1885 ps=1.88 w=0.65 l=0.15
X34 D.t0 SAMPLE__CLKB.t3 SAMPLE__M.t0 VGND.t1 sky130_fd_pr__nfet_01v8 ad=0.1885 pd=1.88 as=0.1885 ps=1.88 w=0.65 l=0.15
X35 FILTER__FILTER0.t4 VGND.t0 sky130_fd_pr__cap_mim_m3_1 l=28.68 w=28.68
X36 PGA__AMP__PRE.t3 PGA__AMP__COMP.t1 sky130_fd_pr__cap_mim_m3_1 l=28.68 w=28.68
X37 COMPARATOR__PREAMP__TAIL.t1 OUT.t3 COMPARATOR__PRE.t1 VGND.t79 sky130_fd_pr__nfet_01v8 ad=2.9 pd=20.58 as=2.9 ps=20.58 w=10 l=1
X38 BIAS_SOURCE__VCM_BUFFER__PRE.t3 BIAS_SOURCE__VCM_BUFFER__COMP.t2 sky130_fd_pr__cap_mim_m3_1 l=28.68 w=28.68
X39 FILTER__FILTER1.t5 VGND.t74 sky130_fd_pr__cap_mim_m3_1 l=28.68 w=28.68
X40 DATA.t3 CLK.t0 SAMPLE__T.t0 VPWR sky130_fd_pr__pfet_01v8_hvt ad=0.1885 pd=1.88 as=0.1885 ps=1.88 w=0.65 l=0.15
X41 FILTER__FILTER1.t6 VGND.t60 sky130_fd_pr__cap_mim_m3_1 l=28.68 w=28.68
X42 SAMPLE__MF.t3 SAMPLE__CLKB.t4 SAMPLE__M.t2 VPWR sky130_fd_pr__pfet_01v8_hvt ad=0.1885 pd=1.88 as=0.1885 ps=1.88 w=0.65 l=0.15
X43 FILTER__BUFFER1__FIRST__TAIL.t2 OUT.t4 FILTER__BUFFER1__FIRST__MIR.t2 VGND.t24 sky130_fd_pr__nfet_01v8 ad=2.9 pd=20.58 as=2.9 ps=20.58 w=10 l=1
X44 BIAS_SOURCE_R_VCM_BOTTOM_R0_N1.t1 VGND.t52 VGND.t51 sky130_fd_pr__res_xhigh_po_1p41 l=23.34
X45 VPWR BIAS_SOURCE__VCM_BUFFER__FIRST__MIR.t0 BIAS_SOURCE__VCM_BUFFER__FIRST__MIR.t1 VPWR sky130_fd_pr__pfet_01v8_hvt ad=5.8 pd=40.58 as=5.8 ps=40.58 w=20 l=1
X46 D.t5 CLK.t1 SAMPLE__M.t1 VPWR sky130_fd_pr__pfet_01v8_hvt ad=0.1885 pd=1.88 as=0.1885 ps=1.88 w=0.65 l=0.15
X47 VPWR FILTER__BUFFER0__PRE.t3 FILTER__MID.t1 VPWR sky130_fd_pr__pfet_01v8_hvt ad=11.6 pd=80.58 as=11.6 ps=80.58 w=40 l=1
X48 VGND.t72 BIAS.t5 AMPLIFIED.t4 VGND.t71 sky130_fd_pr__nfet_01v8 ad=0.58 pd=4.58 as=0.58 ps=4.58 w=2 l=1
X49 VPWR RESET.t2 RESET_MUX__SB.t1 VPWR sky130_fd_pr__pfet_01v8_hvt ad=0.1885 pd=1.88 as=0.1885 ps=1.88 w=0.65 l=0.15
X50 BIAS_SOURCE__VCM_RAW.t6 VGND.t91 sky130_fd_pr__cap_mim_m3_1 l=28.68 w=28.68
X51 VPWR FILTER__BUFFER1__FIRST__MIR.t3 FILTER__BUFFER1__PRE.t1 VPWR sky130_fd_pr__pfet_01v8_hvt ad=5.8 pd=40.58 as=5.8 ps=40.58 w=20 l=1
X52 VPWR SAMPLE__T.t5 SAMPLE__TB.t1 VPWR sky130_fd_pr__pfet_01v8_hvt ad=0.1885 pd=1.88 as=0.1885 ps=1.88 w=0.65 l=0.15
X53 FILTER__FILTER0.t5 VGND.t56 sky130_fd_pr__cap_mim_m3_1 l=28.68 w=28.68
X54 PGA__LOW.t2 PGA__GAINB.t2 AMPLIFIED.t2 VGND.t48 sky130_fd_pr__nfet_01v8 ad=5.8 pd=40.58 as=5.8 ps=40.58 w=20 l=0.15
X55 VPWR SAMPLE__TB.t2 DATA.t1 VPWR sky130_fd_pr__pfet_01v8_hvt ad=0.1885 pd=1.88 as=0.1885 ps=1.88 w=0.65 l=0.15
X56 VPWR SAMPLE__MB.t3 SAMPLE__MF.t2 VPWR sky130_fd_pr__pfet_01v8_hvt ad=0.1885 pd=1.88 as=0.1885 ps=1.88 w=0.65 l=0.15
X57 VPWR BIAS_SOURCE__VCM_BUFFER__FIRST__MIR.t3 BIAS_SOURCE__VCM_BUFFER__PRE.t1 VPWR sky130_fd_pr__pfet_01v8_hvt ad=5.8 pd=40.58 as=5.8 ps=40.58 w=20 l=1
X58 VPWR FILTER__BUFFER1__PRE.t3 OUT.t2 VPWR sky130_fd_pr__pfet_01v8_hvt ad=11.6 pd=80.58 as=11.6 ps=80.58 w=40 l=1
X59 VGND.t108 BIAS.t6 FILTER__BUFFER1__FIRST__TAIL.t0 VGND.t107 sky130_fd_pr__nfet_01v8 ad=0.58 pd=4.58 as=0.58 ps=4.58 w=2 l=1
X60 VPWR SAMPLE__M.t5 SAMPLE__MB.t1 VPWR sky130_fd_pr__pfet_01v8_hvt ad=0.1885 pd=1.88 as=0.1885 ps=1.88 w=0.65 l=0.15
X61 BIAS_SOURCE_R_VCM_TOP_R0_N1.t1 BIAS_SOURCE__VCM_RAW.t1 VGND.t90 sky130_fd_pr__res_xhigh_po_1p41 l=23.34
X62 PGA__AMP__PRE.t4 PGA__AMP__COMP.t0 sky130_fd_pr__cap_mim_m3_1 l=28.68 w=28.68
X63 FILTER__FILTER0.t6 VGND.t61 sky130_fd_pr__cap_mim_m3_1 l=28.68 w=28.68
X64 FILTER__FILTER1.t7 VGND.t38 sky130_fd_pr__cap_mim_m3_1 l=28.68 w=28.68
X65 VGND.t13 BIAS.t7 VCM.t1 VGND.t12 sky130_fd_pr__nfet_01v8 ad=0.58 pd=4.58 as=0.58 ps=4.58 w=2 l=1
X66 FILTER__BUFFER0__PRE.t4 FILTER__BUFFER0__COMP.t1 sky130_fd_pr__cap_mim_m3_1 l=28.68 w=28.68
X67 BIAS_SOURCE__VCM_RAW.t7 VGND.t62 sky130_fd_pr__cap_mim_m3_1 l=28.68 w=28.68
X68 VGND.t42 BIAS.t8 PGA__AMP__FIRST__TAIL.t1 VGND.t41 sky130_fd_pr__nfet_01v8 ad=0.58 pd=4.58 as=0.58 ps=4.58 w=2 l=1
X69 CMP.t0 RESET_MUX__SB.t2 D.t2 VGND.t29 sky130_fd_pr__nfet_01v8 ad=0.1885 pd=1.88 as=0.1885 ps=1.88 w=0.65 l=0.15
X70 VPWR COMPARATOR__PREAMP__MIR.t1 COMPARATOR__PREAMP__MIR.t2 VPWR sky130_fd_pr__pfet_01v8_hvt ad=5.8 pd=40.58 as=5.8 ps=40.58 w=20 l=1
X71 FILTER__BUFFER0__FIRST__TAIL.t2 FILTER__MID.t4 FILTER__BUFFER0__FIRST__MIR.t2 VGND.t45 sky130_fd_pr__nfet_01v8 ad=2.9 pd=20.58 as=2.9 ps=20.58 w=10 l=1
X72 FILTER__FILTER0.t7 VGND.t104 sky130_fd_pr__cap_mim_m3_1 l=28.68 w=28.68
X73 VGND.t28 RESET_MUX__SB.t3 D.t1 VPWR sky130_fd_pr__pfet_01v8_hvt ad=0.1885 pd=1.88 as=0.1885 ps=1.88 w=0.65 l=0.15
X74 VGND.t103 BIAS.t9 OUT.t1 VGND.t102 sky130_fd_pr__nfet_01v8 ad=0.58 pd=4.58 as=0.58 ps=4.58 w=2 l=1
X75 PGA__FB.t0 VCM.t0 VGND.t4 sky130_fd_pr__res_xhigh_po_1p41 l=6.89
X76 FILTER__FILTER0.t8 VGND.t25 sky130_fd_pr__cap_mim_m3_1 l=28.68 w=28.68
X77 VPWR GAIN.t2 PGA__GAINB.t1 VPWR sky130_fd_pr__pfet_01v8_hvt ad=0.1885 pd=1.88 as=0.1885 ps=1.88 w=0.65 l=0.15
X78 FILTER__BUFFER1__PRE.t4 FILTER__BUFFER1__COMP.t2 sky130_fd_pr__cap_mim_m3_1 l=28.68 w=28.68
X79 VPWR COMPARATOR__PREAMP__MIR.t3 COMPARATOR__PRE.t0 VPWR sky130_fd_pr__pfet_01v8_hvt ad=5.8 pd=40.58 as=5.8 ps=40.58 w=20 l=1
X80 FILTER__BUFFER1__FIRST__TAIL.t1 FILTER__FILTER1.t8 FILTER__BUFFER1__PRE.t0 VGND.t59 sky130_fd_pr__nfet_01v8 ad=2.9 pd=20.58 as=2.9 ps=20.58 w=10 l=1
X81 FILTER__FILTER1.t9 VGND.t35 sky130_fd_pr__cap_mim_m3_1 l=28.68 w=28.68
X82 FILTER__FILTER0.t9 VGND.t34 sky130_fd_pr__cap_mim_m3_1 l=28.68 w=28.68
X83 BIAS_SOURCE__VCM_RAW.t8 VGND.t67 sky130_fd_pr__cap_mim_m3_1 l=28.68 w=28.68
X84 BIAS_SOURCE__VCM_BUFFER__PRE.t4 BIAS_SOURCE__VCM_BUFFER__COMP.t1 sky130_fd_pr__cap_mim_m3_1 l=28.68 w=28.68
X85 BIAS_SOURCE__VCM_BUFFER__FIRST__TAIL.t1 BIAS_SOURCE__VCM_RAW.t9 BIAS_SOURCE__VCM_BUFFER__PRE.t0 VGND.t92 sky130_fd_pr__nfet_01v8 ad=2.9 pd=20.58 as=2.9 ps=20.58 w=10 l=1
X86 FILTER__FILTER0.t10 VGND.t8 sky130_fd_pr__cap_mim_m3_1 l=28.68 w=28.68
X87 VPWR BIAS_SOURCE_R_VCM_TOP_R0_N0.t1 VGND.t97 sky130_fd_pr__res_xhigh_po_1p41 l=23.34
X88 VGND.t66 CLK.t2 SAMPLE__CLKB.t0 VGND.t65 sky130_fd_pr__nfet_01v8 ad=0.1885 pd=1.88 as=0.1885 ps=1.88 w=0.65 l=0.15
X89 FILTER__FILTER1.t10 VGND.t43 sky130_fd_pr__cap_mim_m3_1 l=28.68 w=28.68
X90 FILTER__FILTER0.t11 VGND.t49 sky130_fd_pr__cap_mim_m3_1 l=28.68 w=28.68
X91 PGA__AMP__FIRST__TAIL.t2 VIN.t0 PGA__AMP__PRE.t1 VGND.t69 sky130_fd_pr__nfet_01v8 ad=2.9 pd=20.58 as=2.9 ps=20.58 w=10 l=1
X92 VPWR CLK.t3 SAMPLE__CLKB.t1 VPWR sky130_fd_pr__pfet_01v8_hvt ad=0.1885 pd=1.88 as=0.1885 ps=1.88 w=0.65 l=0.15
X93 BIAS_SOURCE_R_VCM_TOP_R0_N0.t0 BIAS_SOURCE_R_VCM_TOP_R0_N1.t0 VGND.t86 sky130_fd_pr__res_xhigh_po_1p41 l=23.34
X94 BIAS_SOURCE__VCM_RAW.t10 VGND.t22 sky130_fd_pr__cap_mim_m3_1 l=28.68 w=28.68
X95 VGND.t11 SAMPLE__TB.t3 DATA.t0 VGND.t10 sky130_fd_pr__nfet_01v8 ad=0.1885 pd=1.88 as=0.1885 ps=1.88 w=0.65 l=0.15
X96 BIAS_SOURCE__VCM_RAW.t11 VGND.t2 sky130_fd_pr__cap_mim_m3_1 l=28.68 w=28.68
X97 VPWR BIAS.t2 VGND.t82 sky130_fd_pr__res_xhigh_po_1p41 l=20.99
X98 VPWR FILTER__BUFFER0__FIRST__MIR.t0 FILTER__BUFFER0__FIRST__MIR.t1 VPWR sky130_fd_pr__pfet_01v8_hvt ad=5.8 pd=40.58 as=5.8 ps=40.58 w=20 l=1
X99 VGND.t37 BIAS.t0 BIAS.t1 VGND.t36 sky130_fd_pr__nfet_01v8 ad=0.58 pd=4.58 as=0.58 ps=4.58 w=2 l=1
X100 VPWR PGA__AMP__FIRST__MIR.t3 PGA__AMP__PRE.t0 VPWR sky130_fd_pr__pfet_01v8_hvt ad=5.8 pd=40.58 as=5.8 ps=40.58 w=20 l=1
X101 PGA_R_HIGH_R0_N0.t1 PGA__FB.t2 VGND.t85 sky130_fd_pr__res_xhigh_po_1p41 l=24.51
X102 PGA__LOW.t1 PGA__FB.t1 VGND.t19 sky130_fd_pr__res_xhigh_po_1p41 l=8.06
X103 FILTER__FILTER1.t11 VGND.t46 sky130_fd_pr__cap_mim_m3_1 l=28.68 w=28.68
X104 VPWR PGA__AMP__PRE.t5 AMPLIFIED.t3 VPWR sky130_fd_pr__pfet_01v8_hvt ad=11.6 pd=80.58 as=11.6 ps=80.58 w=40 l=1
X105 BIAS_SOURCE__VCM_RAW.t12 VGND.t17 sky130_fd_pr__cap_mim_m3_1 l=28.68 w=28.68
X106 COMPARATOR__PREAMP__TAIL.t2 VCM.t5 COMPARATOR__PREAMP__MIR.t0 VGND.t87 sky130_fd_pr__nfet_01v8 ad=2.9 pd=20.58 as=2.9 ps=20.58 w=10 l=1
X107 CMP.t1 RESET.t3 D.t4 VPWR sky130_fd_pr__pfet_01v8_hvt ad=0.1885 pd=1.88 as=0.1885 ps=1.88 w=0.65 l=0.15
X108 VGND.t96 BIAS.t10 FILTER__MID.t0 VGND.t95 sky130_fd_pr__nfet_01v8 ad=0.58 pd=4.58 as=0.58 ps=4.58 w=2 l=1
X109 FILTER__FILTER0.t12 VGND.t105 sky130_fd_pr__cap_mim_m3_1 l=28.68 w=28.68
X110 FILTER__BUFFER1__COMP.t0 OUT.t0 VGND.t3 sky130_fd_pr__res_xhigh_po_1p41 l=3.36
X111 FILTER__MID.t2 FILTER__FILTER1.t0 VGND.t20 sky130_fd_pr__res_xhigh_po_1p41 l=28.04
X112 VPWR COMPARATOR__PRE.t2 CMP.t3 VPWR sky130_fd_pr__pfet_01v8_hvt ad=2.32 pd=16.58 as=2.32 ps=16.58 w=8 l=0.15
X113 VPWR FILTER__BUFFER0__FIRST__MIR.t3 FILTER__BUFFER0__PRE.t1 VPWR sky130_fd_pr__pfet_01v8_hvt ad=5.8 pd=40.58 as=5.8 ps=40.58 w=20 l=1
X114 VPWR FILTER__BUFFER1__FIRST__MIR.t0 FILTER__BUFFER1__FIRST__MIR.t1 VPWR sky130_fd_pr__pfet_01v8_hvt ad=5.8 pd=40.58 as=5.8 ps=40.58 w=20 l=1
X115 BIAS_SOURCE__VCM_BUFFER__PRE.t5 BIAS_SOURCE__VCM_BUFFER__COMP.t0 sky130_fd_pr__cap_mim_m3_1 l=28.68 w=28.68
X116 FILTER__FILTER1.t12 VGND.t73 sky130_fd_pr__cap_mim_m3_1 l=28.68 w=28.68
X117 FILTER__FILTER0.t13 VGND.t21 sky130_fd_pr__cap_mim_m3_1 l=28.68 w=28.68
X118 FILTER__BUFFER0__PRE.t5 FILTER__BUFFER0__COMP.t0 sky130_fd_pr__cap_mim_m3_1 l=28.68 w=28.68
X119 FILTER__BUFFER1__PRE.t5 FILTER__BUFFER1__COMP.t1 sky130_fd_pr__cap_mim_m3_1 l=28.68 w=28.68
X120 VGND.t16 BIAS.t11 FILTER__BUFFER0__FIRST__TAIL.t0 VGND.t15 sky130_fd_pr__nfet_01v8 ad=0.58 pd=4.58 as=0.58 ps=4.58 w=2 l=1
X121 SAMPLE__MF.t4 CLK.t4 SAMPLE__T.t3 VGND.t99 sky130_fd_pr__nfet_01v8 ad=0.1885 pd=1.88 as=0.1885 ps=1.88 w=0.65 l=0.15
X122 FILTER__BUFFER0__COMP.t3 FILTER__MID.t3 VGND.t75 sky130_fd_pr__res_xhigh_po_1p41 l=3.36
X123 FILTER__FILTER1.t13 VGND.t101 sky130_fd_pr__cap_mim_m3_1 l=28.68 w=28.68
X124 DATA.t2 SAMPLE__CLKB.t5 SAMPLE__T.t2 VGND.t70 sky130_fd_pr__nfet_01v8 ad=0.1885 pd=1.88 as=0.1885 ps=1.88 w=0.65 l=0.15
X125 SAMPLE__MF.t5 CLK.t5 SAMPLE__M.t3 VGND.t100 sky130_fd_pr__nfet_01v8 ad=0.1885 pd=1.88 as=0.1885 ps=1.88 w=0.65 l=0.15
X126 VGND.t40 COMPARATOR__PRE.t3 CMP.t2 VGND.t39 sky130_fd_pr__nfet_01v8 ad=1.16 pd=8.58 as=1.16 ps=8.58 w=4 l=0.15
X127 BIAS_SOURCE__VCM_RAW.t13 VGND.t50 sky130_fd_pr__cap_mim_m3_1 l=28.68 w=28.68
X128 BIAS_SOURCE__VCM_RAW.t14 VGND.t58 sky130_fd_pr__cap_mim_m3_1 l=28.68 w=28.68
C0 FILTER__BUFFER0__FIRST__MIR FILTER__MID 0.61594f
C1 PGA__GAINB PGA__LOW 3.63106f
C2 FILTER__BUFFER1__PRE CLK 0
C3 FILTER__MID DATA 4.63627f
C4 PGA__AMP__FIRST__MIR RESET 0
C5 COMPARATOR__PREAMP__MIR OUT 0.25537f
C6 PGA__AMP__PRE BIAS 0.51351f
C7 FILTER__BUFFER0__FIRST__MIR FILTER__BUFFER0__FIRST__TAIL 1.02145f
C8 PGA__AMP__PRE AMPLIFIED 1.74766f
C9 FILTER__BUFFER0__FIRST__TAIL DATA 2.04513f
C10 SAMPLE__M SAMPLE__MF 3.93527f
C11 FILTER__BUFFER1__FIRST__TAIL OUT 1.69122f
C12 BIAS_SOURCE__VCM_BUFFER__FIRST__TAIL BIAS 0.26353f
C13 OUT RESET 0
C14 GAIN CLK 0
C15 FILTER__BUFFER1__FIRST__MIR VPWR 9.24693f
C16 PGA__FB VPWR 0.56739f
C17 BIAS_SOURCE__VCM_BUFFER__PRE GAIN 0.49714f
C18 FILTER__FILTER1 FILTER__BUFFER1__FIRST__TAIL 1.43774f
C19 BIAS_SOURCE__VCM_RAW VCM 1.3642f
C20 CMP D 1.02333f
C21 FILTER__FILTER1 RESET 0.00248f
C22 PGA__AMP__FIRST__TAIL RESET 0.2037f
C23 BIAS_SOURCE__VCM_BUFFER__FIRST__MIR BIAS 0.27705f
C24 PGA__LOW VPWR 4.09562f
C25 PGA__GAINB BIAS 0.20357f
C26 AMPLIFIED PGA__GAINB 0.56181f
C27 PGA__FB PGA__LOW 0.49499f
C28 FILTER__BUFFER1__PRE DATA 0
C29 PGA__AMP__FIRST__MIR CLK 0
C30 COMPARATOR__PREAMP__MIR RESET 0
C31 PGA__AMP__PRE VCM 0.77087f
C32 SAMPLE__M SAMPLE__T 0.28874f
C33 SAMPLE__M CLK 1.35336f
C34 VPWR BIAS 2.86834f
C35 FILTER__BUFFER1__FIRST__TAIL RESET 0.21062f
C36 BIAS_SOURCE__VCM_BUFFER__FIRST__TAIL VCM 1.74486f
C37 OUT CLK 0
C38 GAIN DATA 0
C39 FILTER__BUFFER1__FIRST__MIR BIAS 0
C40 PGA__FB BIAS 0.27938f
C41 AMPLIFIED VPWR 11.1289f
C42 BIAS_SOURCE__VCM_BUFFER__PRE OUT 0.49689f
C43 BIAS_SOURCE__VCM_RAW VIN 1.47744f
C44 PGA__FB AMPLIFIED 0.41128f
C45 FILTER__FILTER1 CLK 0.0017f
C46 RESET_MUX__SB D 1.13125f
C47 PGA__AMP__FIRST__TAIL CLK 0.2037f
C48 BIAS_SOURCE__VCM_BUFFER__FIRST__MIR VCM 0.85613f
C49 COMPARATOR__PREAMP__TAIL OUT 1.60041f
C50 PGA__GAINB VCM 0.20357f
C51 PGA__LOW BIAS 0.1986f
C52 COMPARATOR__PRE VPWR 7.18748f
C53 AMPLIFIED PGA__LOW 6.89301f
C54 COMPARATOR__PREAMP__MIR CLK 0
C55 PGA__AMP__PRE VIN 0.39659f
C56 SAMPLE__MF SAMPLE__T 3.6895f
C57 SAMPLE__M SAMPLE__MB 1.16568f
C58 SAMPLE__MF CLK 5.32593f
C59 VPWR VCM 9.45841f
C60 SAMPLE__M DATA 0.13738f
C61 FILTER__BUFFER1__FIRST__TAIL CLK 0.21062f
C62 FILTER__BUFFER0__FIRST__MIR OUT 0.00176f
C63 COMPARATOR__PREAMP__MIR COMPARATOR__PREAMP__TAIL 2.47381f
C64 BIAS_SOURCE__VCM_BUFFER__FIRST__TAIL VIN 0.22312f
C65 RESET CLK 0.13477p
C66 OUT DATA 0
C67 FILTER__BUFFER1__FIRST__MIR VCM 0
C68 FILTER__BUFFER0__PRE VPWR 7.81736f
C69 AMPLIFIED BIAS 0.40817f
C70 PGA__FB VCM 0.35062f
C71 BIAS_SOURCE__VCM_BUFFER__PRE RESET 0.49688f
C72 CMP VPWR 5.17449f
C73 BIAS_SOURCE__VCM_RAW GAIN 1.35877f
C74 FILTER__FILTER1 DATA 0
C75 RESET_MUX__SB SAMPLE__CLKB 0.30306f
C76 PGA__AMP__FIRST__TAIL DATA 0.2037f
C77 BIAS_SOURCE__VCM_BUFFER__FIRST__MIR VIN 0.31223f
C78 COMPARATOR__PREAMP__TAIL RESET 0
C79 PGA__LOW VCM 0.1986f
C80 COMPARATOR__PRE BIAS 0.13883f
C81 PGA__LOW FILTER__FILTER0 0
C82 FILTER__MID VPWR 8.42998f
C83 COMPARATOR__PREAMP__MIR DATA 0
C84 PGA__AMP__PRE GAIN 0.49737f
C85 FILTER__BUFFER0__FIRST__TAIL VPWR 0.49587f
C86 SAMPLE__MF SAMPLE__MB 0.86206f
C87 SAMPLE__T CLK 1.05725f
C88 VPWR VIN 0.60916f
C89 SAMPLE__MF DATA 0.12855f
C90 BIAS VCM 0.13141p
C91 D SAMPLE__M 1.01193f
C92 FILTER__BUFFER1__FIRST__TAIL DATA 2.05205f
C93 FILTER__BUFFER0__FIRST__MIR RESET 0
C94 BIAS_SOURCE__VCM_BUFFER__FIRST__TAIL GAIN 0.19647f
C95 RESET DATA 0.00176f
C96 FILTER__FILTER0 BIAS 0.00396f
C97 AMPLIFIED VCM 0.17759f
C98 FILTER__BUFFER0__PRE BIAS 0.17438f
C99 PGA__FB VIN 0.00507f
C100 BIAS_SOURCE__VCM_BUFFER__PRE CLK 0.49701f
C101 RESET_MUX__SB VPWR 2.04482f
C102 CMP BIAS 0.3092f
C103 BIAS_SOURCE__VCM_RAW OUT 1.35899f
C104 AMPLIFIED FILTER__FILTER0 0.0747f
C105 BIAS_SOURCE__VCM_BUFFER__FIRST__MIR GAIN 0.27669f
C106 COMPARATOR__PREAMP__TAIL CLK 0
C107 PGA__GAINB GAIN 0.57369f
C108 COMPARATOR__PRE VCM 0.0777f
C109 PGA__AMP__PRE PGA__AMP__FIRST__MIR 0.89329f
C110 COMPARATOR__PRE CMP 1.20731f
C111 FILTER__MID BIAS 0.73244f
C112 FILTER__BUFFER1__PRE VPWR 7.81736f
C113 FILTER__BUFFER1__PRE FILTER__BUFFER1__FIRST__MIR 2.13401f
C114 PGA__AMP__PRE OUT 0.49717f
C115 FILTER__BUFFER0__FIRST__TAIL BIAS 0.26408f
C116 SAMPLE__T SAMPLE__MB 0.0681f
C117 VPWR GAIN 4.34523f
C118 PGA__AMP__PRE PGA__AMP__FIRST__TAIL 2.59954f
C119 SAMPLE__MB CLK 0.29396f
C120 BIAS VIN 0.38941f
C121 SAMPLE__T DATA 1.40865f
C122 D SAMPLE__MF 0.00538f
C123 SAMPLE__CLKB SAMPLE__M 3.51344f
C124 FILTER__BUFFER0__FIRST__MIR CLK 0
C125 BIAS_SOURCE__VCM_BUFFER__FIRST__TAIL OUT 0.19647f
C126 CLK DATA 0.1426p
C127 D RESET 1.56871f
C128 FILTER__FILTER0 VCM 0.00725f
C129 FILTER__BUFFER0__PRE VCM 0.00577f
C130 PGA__FB GAIN 0.2794f
C131 BIAS_SOURCE__VCM_BUFFER__PRE DATA 2.40106f
C132 BIAS_SOURCE__VCM_RAW RESET 1.35987f
C133 FILTER__BUFFER0__PRE FILTER__FILTER0 0.65035f
C134 BIAS_SOURCE__VCM_BUFFER__FIRST__MIR OUT 0.27669f
C135 COMPARATOR__PREAMP__TAIL DATA 0
C136 PGA__GAINB OUT 0.20357f
C137 PGA__LOW GAIN 1.76188f
C138 COMPARATOR__PRE RESET_MUX__SB 0.28675f
C139 FILTER__MID VCM 0.34892f
C140 FILTER__BUFFER1__PRE BIAS 0.17438f
C141 PGA__AMP__FIRST__MIR VPWR 9.24693f
C142 FILTER__FILTER0 FILTER__MID 0.00507f
C143 FILTER__BUFFER0__PRE FILTER__MID 1.58756f
C144 PGA__AMP__FIRST__MIR PGA__FB 0.61594f
C145 PGA__AMP__PRE RESET 0.49711f
C146 FILTER__BUFFER0__FIRST__TAIL VCM 0.2037f
C147 SAMPLE__T SAMPLE__TB 0.73431f
C148 SAMPLE__M VPWR 5.73009f
C149 FILTER__FILTER0 FILTER__BUFFER0__FIRST__TAIL 1.43774f
C150 FILTER__BUFFER0__PRE FILTER__BUFFER0__FIRST__TAIL 0.76397f
C151 VCM VIN 0.31742f
C152 SAMPLE__MB DATA 0.01409f
C153 BIAS GAIN 0.49271f
C154 VPWR OUT 9.41602f
C155 SAMPLE__CLKB SAMPLE__MF 4.76996f
C156 BIAS_SOURCE__VCM_BUFFER__FIRST__TAIL RESET 0.20315f
C157 D CLK 3.16452f
C158 FILTER__BUFFER1__FIRST__MIR OUT 0.61771f
C159 PGA__FB OUT 0.27929f
C160 AMPLIFIED GAIN 12.2985f
C161 BIAS_SOURCE__VCM_RAW CLK 1.36143f
C162 PGA__AMP__FIRST__TAIL VPWR 0.5071f
C163 BIAS_SOURCE__VCM_BUFFER__PRE BIAS_SOURCE__VCM_RAW 0.64147f
C164 FILTER__FILTER1 FILTER__BUFFER1__FIRST__MIR 0.22775f
C165 BIAS_SOURCE__VCM_BUFFER__FIRST__MIR RESET 0.27701f
C166 PGA__AMP__FIRST__TAIL PGA__FB 3.27701f
C167 CMP RESET_MUX__SB 3.89055f
C168 PGA__GAINB RESET 0.20357f
C169 PGA__LOW OUT 0.1986f
C170 FILTER__BUFFER0__FIRST__TAIL FILTER__MID 3.21618f
C171 FILTER__BUFFER1__PRE VCM 0.00577f
C172 PGA__AMP__FIRST__MIR BIAS 0
C173 COMPARATOR__PREAMP__MIR VPWR 9.60926f
C174 PGA__AMP__PRE CLK 0.4975f
C175 SAMPLE__MB SAMPLE__TB 0.30782f
C176 SAMPLE__MF VPWR 4.66523f
C177 FILTER__BUFFER1__FIRST__TAIL VPWR 0.57895f
C178 SAMPLE__TB DATA 0.53803f
C179 BIAS OUT 1.11762f
C180 VPWR RESET 6.37104f
C181 VCM GAIN 0.34982f
C182 SAMPLE__CLKB SAMPLE__T 1.18208f
C183 FILTER__BUFFER1__FIRST__MIR FILTER__BUFFER1__FIRST__TAIL 1.02145f
C184 BIAS_SOURCE__VCM_BUFFER__FIRST__TAIL CLK 0.20315f
C185 D DATA 0
C186 SAMPLE__CLKB CLK 0.75324f
C187 FILTER__BUFFER1__FIRST__MIR RESET 0
C188 FILTER__FILTER0 GAIN 0
C189 BIAS_SOURCE__VCM_BUFFER__PRE BIAS_SOURCE__VCM_BUFFER__FIRST__TAIL 2.61198f
C190 PGA__FB RESET 0.27929f
C191 AMPLIFIED OUT 0.14268f
C192 FILTER__FILTER1 BIAS 0.00396f
C193 PGA__AMP__FIRST__TAIL BIAS 0.26408f
C194 BIAS_SOURCE__VCM_RAW DATA 29.7634f
C195 BIAS_SOURCE__VCM_BUFFER__FIRST__MIR CLK 0.27701f
C196 PGA__AMP__FIRST__TAIL AMPLIFIED 0
C197 PGA__GAINB CLK 0.20357f
C198 PGA__LOW RESET 0.1986f
C199 BIAS_SOURCE__VCM_BUFFER__PRE BIAS_SOURCE__VCM_BUFFER__FIRST__MIR 2.23287f
C200 COMPARATOR__PRE OUT 0.71083f
C201 PGA__AMP__FIRST__MIR VCM 0
C202 COMPARATOR__PREAMP__MIR BIAS 0.49202f
C203 PGA__AMP__PRE DATA 9.22157f
C204 SAMPLE__T VPWR 6.4005f
C205 FILTER__BUFFER1__FIRST__TAIL BIAS 0.27099f
C206 VCM OUT 0.13014p
C207 VPWR CLK 7.51769f
C208 VIN GAIN 41.0656f
C209 BIAS RESET 0.13176p
C210 BIAS_SOURCE__VCM_BUFFER__FIRST__TAIL DATA 0.20867f
C211 BIAS_SOURCE__VCM_BUFFER__PRE VPWR 8.72841f
C212 SAMPLE__CLKB DATA 2.32579f
C213 FILTER__BUFFER1__FIRST__MIR CLK 0
C214 FILTER__FILTER0 OUT 13.3467f
C215 FILTER__BUFFER0__PRE OUT 8.74852f
C216 COMPARATOR__PREAMP__MIR COMPARATOR__PRE 1.12737f
C217 AMPLIFIED RESET 0
C218 PGA__FB CLK 0.27929f
C219 FILTER__FILTER1 VCM 0.00725f
C220 PGA__AMP__FIRST__TAIL VCM 0.20371f
C221 COMPARATOR__PREAMP__TAIL VPWR 0.38716f
C222 BIAS_SOURCE__VCM_BUFFER__FIRST__MIR DATA 1.50818f
C223 PGA__GAINB DATA 0.20357f
C224 PGA__LOW CLK 0.1986f
C225 COMPARATOR__PRE RESET 0.04266f
C226 FILTER__MID OUT 0.3667f
C227 PGA__AMP__FIRST__MIR VIN 0.22775f
C228 COMPARATOR__PREAMP__MIR VCM 0.89221f
C229 FILTER__MID FILTER__FILTER1 0.0591f
C230 FILTER__BUFFER0__FIRST__TAIL OUT 0.2037f
C231 SAMPLE__MB VPWR 4.29409f
C232 FILTER__BUFFER1__FIRST__TAIL VCM 0.21062f
C233 FILTER__BUFFER0__FIRST__MIR VPWR 9.24693f
C234 VIN OUT 0
C235 VCM RESET 0.00265f
C236 VPWR DATA 7.46979f
C237 BIAS CLK 0.00529f
C238 BIAS_SOURCE__VCM_BUFFER__PRE BIAS 0.51327f
C239 D SAMPLE__CLKB 2.82835f
C240 FILTER__FILTER0 RESET 0.00248f
C241 FILTER__BUFFER0__PRE RESET 0.00126f
C242 AMPLIFIED CLK 0
C243 PGA__FB DATA 0.80937f
C244 CMP RESET 2.94566f
C245 BIAS_SOURCE__VCM_RAW BIAS_SOURCE__VCM_BUFFER__FIRST__TAIL 1.91661f
C246 PGA__AMP__FIRST__TAIL VIN 1.43774f
C247 COMPARATOR__PREAMP__TAIL BIAS 0.15314f
C248 PGA__LOW DATA 2.15258f
C249 COMPARATOR__PRE CLK 0
C250 BIAS_SOURCE__VCM_RAW BIAS_SOURCE__VCM_BUFFER__FIRST__MIR 0.33822f
C251 FILTER__BUFFER1__PRE OUT 10.3386f
C252 FILTER__MID RESET 0.3492f
C253 COMPARATOR__PRE COMPARATOR__PREAMP__TAIL 2.61897f
C254 PGA__AMP__FIRST__MIR GAIN 1.23987f
C255 FILTER__BUFFER1__PRE FILTER__FILTER1 0.65035f
C256 FILTER__BUFFER0__FIRST__TAIL RESET 0.2037f
C257 SAMPLE__TB VPWR 4.31328f
C258 FILTER__BUFFER0__FIRST__MIR BIAS 0
C259 VCM CLK 0.00116f
C260 VIN RESET 0
C261 BIAS DATA 0.00232f
C262 GAIN OUT 54.7626f
C263 D VPWR 4.4298f
C264 BIAS_SOURCE__VCM_BUFFER__PRE VCM 1.88439f
C265 FILTER__FILTER0 CLK 0.0017f
C266 FILTER__BUFFER0__PRE CLK 0
C267 BIAS_SOURCE__VCM_RAW VPWR 0.00358f
C268 CMP CLK 0
C269 RESET_MUX__SB RESET 0.6658f
C270 PGA__AMP__FIRST__TAIL GAIN 0.21258f
C271 BIAS_SOURCE__VCM_BUFFER__FIRST__MIR BIAS_SOURCE__VCM_BUFFER__FIRST__TAIL 1.18521f
C272 COMPARATOR__PREAMP__TAIL VCM 1.61331f
C273 COMPARATOR__PREAMP__TAIL CMP 0.00507f
C274 FILTER__BUFFER1__PRE FILTER__BUFFER1__FIRST__TAIL 0.76397f
C275 FILTER__BUFFER1__PRE RESET 0.00126f
C276 FILTER__MID CLK 0.3492f
C277 PGA__AMP__FIRST__MIR OUT 0.00176f
C278 PGA__AMP__PRE VPWR 8.67915f
C279 PGA__AMP__FIRST__MIR PGA__AMP__FIRST__TAIL 1.02145f
C280 PGA__AMP__PRE PGA__FB 1.71277f
C281 FILTER__BUFFER0__FIRST__TAIL CLK 0.2037f
C282 FILTER__BUFFER0__FIRST__MIR VCM 0
C283 BIAS_SOURCE__VCM_BUFFER__FIRST__TAIL VPWR 0.44878f
C284 VIN CLK 0
C285 VCM DATA 0
C286 GAIN RESET 0
C287 SAMPLE__CLKB VPWR 2.51028f
C288 FILTER__FILTER0 FILTER__BUFFER0__FIRST__MIR 0.22775f
C289 BIAS_SOURCE__VCM_BUFFER__PRE VIN 0.55914f
C290 FILTER__BUFFER0__PRE FILTER__BUFFER0__FIRST__MIR 2.13401f
C291 FILTER__FILTER0 DATA 0
C292 FILTER__BUFFER0__PRE DATA 0
C293 BIAS_SOURCE__VCM_RAW BIAS 1.35935f
C294 CMP DATA 0
C295 RESET_MUX__SB CLK 0.00564f
C296 FILTER__FILTER1 OUT 13.3517f
C297 PGA__AMP__FIRST__TAIL OUT 0.2037f
C298 BIAS_SOURCE__VCM_BUFFER__FIRST__MIR VPWR 10.6074f
C299 PGA__GAINB VPWR 2.19408f
C300 PGA__FB PGA__GAINB 0.34778f
C301 DATA VGND 0.19005p
C302 CLK VGND 0.19173p
C303 RESET VGND 0.18424p
C304 OUT VGND 0.15829p
C305 GAIN VGND 74.99429f
C306 VIN VGND 77.3943f
C307 VCM VGND 0.14585p
C308 BIAS VGND 96.27497f
C309 VPWR VGND 0.51076p
C310 SAMPLE__TB VGND 10.55043f $ **FLOATING
C311 SAMPLE__MB VGND 9.68975f $ **FLOATING
C312 SAMPLE__T VGND 15.61548f $ **FLOATING
C313 SAMPLE__MF VGND 9.79284f $ **FLOATING
C314 SAMPLE__M VGND 13.82244f $ **FLOATING
C315 SAMPLE__CLKB VGND 12.69395f $ **FLOATING
C316 D VGND 11.83238f $ **FLOATING
C317 RESET_MUX__SB VGND 10.59436f $ **FLOATING
C318 CMP VGND 8.40101f $ **FLOATING
C319 COMPARATOR__PREAMP__TAIL VGND 9.32313f $ **FLOATING
C320 COMPARATOR__PRE VGND 12.60893f $ **FLOATING
C321 COMPARATOR__PREAMP__MIR VGND 9.21552f $ **FLOATING
C322 FILTER__BUFFER1__FIRST__TAIL VGND 12.45686f $ **FLOATING
C323 FILTER__BUFFER1__FIRST__MIR VGND 9.15088f $ **FLOATING
C324 FILTER__FILTER1 VGND 0.95321p $ **FLOATING
C325 FILTER__BUFFER1__PRE VGND 0.13805p $ **FLOATING
C326 FILTER__MID VGND 26.47577f $ **FLOATING
C327 FILTER__BUFFER0__FIRST__TAIL VGND 11.63277f $ **FLOATING
C328 FILTER__BUFFER0__FIRST__MIR VGND 9.15088f $ **FLOATING
C329 FILTER__FILTER0 VGND 0.95315p $ **FLOATING
C330 PGA__LOW VGND 11.78958f $ **FLOATING
C331 PGA__GAINB VGND 7.7677f $ **FLOATING
C332 FILTER__BUFFER0__PRE VGND 0.13727p $ **FLOATING
C333 AMPLIFIED VGND 29.29117f $ **FLOATING
C334 PGA__FB VGND 33.48023f $ **FLOATING
C335 PGA__AMP__FIRST__TAIL VGND 11.9415f $ **FLOATING
C336 PGA__AMP__FIRST__MIR VGND 8.89154f $ **FLOATING
C337 PGA__AMP__PRE VGND 0.13917p $ **FLOATING
C338 BIAS_SOURCE__VCM_BUFFER__FIRST__TAIL VGND 13.61742f $ **FLOATING
C339 BIAS_SOURCE__VCM_BUFFER__FIRST__MIR VGND 10.55598f $ **FLOATING
C340 BIAS_SOURCE__VCM_RAW VGND 0.96841p $ **FLOATING
C341 BIAS_SOURCE__VCM_BUFFER__PRE VGND 0.14202p $ **FLOATING
C342 VIN.t0 VGND 1.28578f $ **FLOATING
C343 FILTER__BUFFER0__FIRST__MIR.n0 VGND 0.03061f $ **FLOATING
C344 FILTER__BUFFER0__FIRST__MIR.t1 VGND 0.03667f $ **FLOATING
C345 FILTER__BUFFER0__FIRST__MIR.t3 VGND 1.86566f $ **FLOATING
C346 FILTER__BUFFER0__FIRST__MIR.t0 VGND 1.86566f $ **FLOATING
C347 FILTER__BUFFER0__FIRST__MIR.n1 VGND 1.40436f $ **FLOATING
C348 FILTER__BUFFER0__FIRST__MIR.n2 VGND 0.01493f $ **FLOATING
C349 FILTER__BUFFER0__FIRST__MIR.t2 VGND 0.08187f $ **FLOATING
C350 FILTER__BUFFER0__FIRST__MIR.n3 VGND 0.27928f $ **FLOATING
C351 FILTER__BUFFER0__FIRST__MIR.n4 VGND 0.04929f $ **FLOATING
C352 FILTER__BUFFER0__FIRST__MIR.n5 VGND 0.84491f $ **FLOATING
C353 FILTER__BUFFER0__FIRST__MIR.n6 VGND 1.48445f $ **FLOATING
C354 FILTER__BUFFER0__FIRST__MIR.n7 VGND 1.91643f $ **FLOATING
C355 FILTER__BUFFER0__FIRST__MIR.n8 VGND 0.03014f $ **FLOATING
C356 COMPARATOR__PREAMP__MIR.n0 VGND 0.01545f $ **FLOATING
C357 COMPARATOR__PREAMP__MIR.t3 VGND 1.93105f $ **FLOATING
C358 COMPARATOR__PREAMP__MIR.t1 VGND 1.93105f $ **FLOATING
C359 COMPARATOR__PREAMP__MIR.n1 VGND 1.6019f $ **FLOATING
C360 COMPARATOR__PREAMP__MIR.n2 VGND 0.03119f $ **FLOATING
C361 COMPARATOR__PREAMP__MIR.t2 VGND 0.03796f $ **FLOATING
C362 COMPARATOR__PREAMP__MIR.n3 VGND 0.03169f $ **FLOATING
C363 COMPARATOR__PREAMP__MIR.n4 VGND 2.032f $ **FLOATING
C364 COMPARATOR__PREAMP__MIR.n5 VGND 1.64082f $ **FLOATING
C365 COMPARATOR__PREAMP__MIR.n6 VGND 0.92377f $ **FLOATING
C366 COMPARATOR__PREAMP__MIR.t0 VGND 0.08474f $ **FLOATING
C367 COMPARATOR__PREAMP__MIR.n7 VGND 0.28907f $ **FLOATING
C368 COMPARATOR__PREAMP__MIR.n8 VGND 0.05101f $ **FLOATING
C369 CMP.n0 VGND 0.01197f $ **FLOATING
C370 CMP.n1 VGND 0.01048f $ **FLOATING
C371 CMP.t1 VGND 0.03209f $ **FLOATING
C372 CMP.n2 VGND 0.01048f $ **FLOATING
C373 CMP.n3 VGND 0.91937f $ **FLOATING
C374 CMP.n4 VGND 0.02159f $ **FLOATING
C375 CMP.t3 VGND 0.11243f $ **FLOATING
C376 CMP.n5 VGND 0.34848f $ **FLOATING
C377 CMP.n6 VGND 0.07238f $ **FLOATING
C378 CMP.n7 VGND 1.39278f $ **FLOATING
C379 CMP.n8 VGND 0.02558f $ **FLOATING
C380 CMP.t2 VGND 0.05622f $ **FLOATING
C381 CMP.n9 VGND 0.17593f $ **FLOATING
C382 CMP.n10 VGND 0.00791f $ **FLOATING
C383 CMP.n11 VGND 1.08694f $ **FLOATING
C384 CMP.n12 VGND 3.38587f $ **FLOATING
C385 CMP.n13 VGND 3.38587f $ **FLOATING
C386 CMP.n14 VGND 0.86186f $ **FLOATING
C387 CMP.t0 VGND 0.02911f $ **FLOATING
C388 CMP.n15 VGND 0.01197f $ **FLOATING
C389 FILTER__MID.n0 VGND 0.0128f $ **FLOATING
C390 FILTER__MID.t0 VGND 0.02085f $ **FLOATING
C391 FILTER__MID.t2 VGND 0.69609f $ **FLOATING
C392 FILTER__MID.t3 VGND 0.96502f $ **FLOATING
C393 FILTER__MID.n1 VGND 4.16023f $ **FLOATING
C394 FILTER__MID.t4 VGND 0.80506f $ **FLOATING
C395 FILTER__MID.n2 VGND 0.26369f $ **FLOATING
C396 FILTER__MID.t1 VGND 0.26194f $ **FLOATING
C397 FILTER__MID.n3 VGND 1.14049f $ **FLOATING
C398 FILTER__MID.n4 VGND 0.1026f $ **FLOATING
C399 FILTER__MID.n5 VGND 1.25554f $ **FLOATING
C400 FILTER__MID.n6 VGND 2.43149f $ **FLOATING
C401 FILTER__MID.n7 VGND 2.86826f $ **FLOATING
C402 FILTER__MID.n8 VGND 0.61325f $ **FLOATING
C403 FILTER__MID.n9 VGND 0.01234f $ **FLOATING
C404 FILTER__BUFFER1__FIRST__TAIL.n0 VGND 0.00465f $ **FLOATING
C405 FILTER__BUFFER1__FIRST__TAIL.t0 VGND 0.00757f $ **FLOATING
C406 FILTER__BUFFER1__FIRST__TAIL.n1 VGND 0.01349f $ **FLOATING
C407 FILTER__BUFFER1__FIRST__TAIL.t1 VGND 0.02378f $ **FLOATING
C408 FILTER__BUFFER1__FIRST__TAIL.n2 VGND 0.08112f $ **FLOATING
C409 FILTER__BUFFER1__FIRST__TAIL.n3 VGND 0.00516f $ **FLOATING
C410 FILTER__BUFFER1__FIRST__TAIL.n4 VGND 0.30076f $ **FLOATING
C411 FILTER__BUFFER1__FIRST__TAIL.n5 VGND 0.00434f $ **FLOATING
C412 FILTER__BUFFER1__FIRST__TAIL.t2 VGND 0.02378f $ **FLOATING
C413 FILTER__BUFFER1__FIRST__TAIL.n6 VGND 0.08112f $ **FLOATING
C414 FILTER__BUFFER1__FIRST__TAIL.n7 VGND 0.01432f $ **FLOATING
C415 FILTER__BUFFER1__FIRST__TAIL.n8 VGND 0.28896f $ **FLOATING
C416 FILTER__BUFFER1__FIRST__TAIL.n9 VGND 0.98301f $ **FLOATING
C417 FILTER__BUFFER1__FIRST__TAIL.n10 VGND 0.25581f $ **FLOATING
C418 FILTER__BUFFER1__FIRST__TAIL.n11 VGND 0.00448f $ **FLOATING
C419 FILTER__BUFFER1__FIRST__MIR.n0 VGND 0.03061f $ **FLOATING
C420 FILTER__BUFFER1__FIRST__MIR.t1 VGND 0.03667f $ **FLOATING
C421 FILTER__BUFFER1__FIRST__MIR.t3 VGND 1.86566f $ **FLOATING
C422 FILTER__BUFFER1__FIRST__MIR.t0 VGND 1.86566f $ **FLOATING
C423 FILTER__BUFFER1__FIRST__MIR.n1 VGND 1.40436f $ **FLOATING
C424 FILTER__BUFFER1__FIRST__MIR.n2 VGND 0.01493f $ **FLOATING
C425 FILTER__BUFFER1__FIRST__MIR.t2 VGND 0.08187f $ **FLOATING
C426 FILTER__BUFFER1__FIRST__MIR.n3 VGND 0.27928f $ **FLOATING
C427 FILTER__BUFFER1__FIRST__MIR.n4 VGND 0.04929f $ **FLOATING
C428 FILTER__BUFFER1__FIRST__MIR.n5 VGND 0.84491f $ **FLOATING
C429 FILTER__BUFFER1__FIRST__MIR.n6 VGND 1.48445f $ **FLOATING
C430 FILTER__BUFFER1__FIRST__MIR.n7 VGND 1.91643f $ **FLOATING
C431 FILTER__BUFFER1__FIRST__MIR.n8 VGND 0.03014f $ **FLOATING
C432 DATA.n0 VGND 0.01327f $ **FLOATING
C433 DATA.n1 VGND 0.01327f $ **FLOATING
C434 DATA.t2 VGND 0.03227f $ **FLOATING
C435 DATA.n2 VGND 0.01327f $ **FLOATING
C436 DATA.n3 VGND 1.22185f $ **FLOATING
C437 DATA.n4 VGND 98.6123f $ **FLOATING
C438 DATA.n5 VGND 0.01162f $ **FLOATING
C439 DATA.t3 VGND 0.03558f $ **FLOATING
C440 DATA.n6 VGND 0.01162f $ **FLOATING
C441 DATA.n7 VGND 1.22185f $ **FLOATING
C442 DATA.n8 VGND 3.70746f $ **FLOATING
C443 DATA.n9 VGND 0.01162f $ **FLOATING
C444 DATA.t1 VGND 0.03558f $ **FLOATING
C445 DATA.n10 VGND 0.01162f $ **FLOATING
C446 DATA.n11 VGND 1.22185f $ **FLOATING
C447 DATA.n12 VGND 5.34267f $ **FLOATING
C448 DATA.n13 VGND 1.2894f $ **FLOATING
C449 DATA.t0 VGND 0.03227f $ **FLOATING
C450 DATA.n14 VGND 0.01327f $ **FLOATING
C451 CLK.t3 VGND 0.06972f $ **FLOATING
C452 CLK.n0 VGND 0.13521p $ **FLOATING
C453 CLK.t2 VGND 0.06709f $ **FLOATING
C454 CLK.n1 VGND 3.92516f $ **FLOATING
C455 CLK.t1 VGND 0.06972f $ **FLOATING
C456 CLK.n2 VGND 3.92178f $ **FLOATING
C457 CLK.t5 VGND 0.06709f $ **FLOATING
C458 CLK.n3 VGND 3.92846f $ **FLOATING
C459 CLK.t4 VGND 0.06709f $ **FLOATING
C460 CLK.n4 VGND 8.48793f $ **FLOATING
C461 CLK.t0 VGND 0.06972f $ **FLOATING
C462 COMPARATOR__PRE.n0 VGND 0.03467f $ **FLOATING
C463 COMPARATOR__PRE.t0 VGND 0.04154f $ **FLOATING
C464 COMPARATOR__PRE.t3 VGND 0.07423f $ **FLOATING
C465 COMPARATOR__PRE.t2 VGND 0.13244f $ **FLOATING
C466 COMPARATOR__PRE.n1 VGND 2.43122f $ **FLOATING
C467 COMPARATOR__PRE.n2 VGND 0.01691f $ **FLOATING
C468 COMPARATOR__PRE.t1 VGND 0.09274f $ **FLOATING
C469 COMPARATOR__PRE.n3 VGND 0.31633f $ **FLOATING
C470 COMPARATOR__PRE.n4 VGND 0.05583f $ **FLOATING
C471 COMPARATOR__PRE.n5 VGND 1.09005f $ **FLOATING
C472 COMPARATOR__PRE.n6 VGND 2.73999f $ **FLOATING
C473 COMPARATOR__PRE.n7 VGND 2.17069f $ **FLOATING
C474 COMPARATOR__PRE.n8 VGND 0.03414f $ **FLOATING
C475 OUT.t3 VGND 2.25416f $ **FLOATING
C476 OUT.t0 VGND 2.34689f $ **FLOATING
C477 OUT.n0 VGND 11.0435f $ **FLOATING
C478 OUT.n1 VGND 0.03583f $ **FLOATING
C479 OUT.t1 VGND 0.05838f $ **FLOATING
C480 OUT.n2 VGND 0.03454f $ **FLOATING
C481 OUT.n3 VGND 1.34761f $ **FLOATING
C482 OUT.n4 VGND 7.6358f $ **FLOATING
C483 OUT.n5 VGND 0.73833f $ **FLOATING
C484 OUT.t2 VGND 0.73344f $ **FLOATING
C485 OUT.n6 VGND 3.19337f $ **FLOATING
C486 OUT.n7 VGND 0.28728f $ **FLOATING
C487 OUT.n8 VGND 3.14601f $ **FLOATING
C488 OUT.n9 VGND 3.14943f $ **FLOATING
C489 OUT.n10 VGND 0.10125p $ **FLOATING
C490 OUT.t4 VGND 2.25416f $ **FLOATING
C491 PGA__GAINB.n0 VGND 0.00775f $ **FLOATING
C492 PGA__GAINB.t2 VGND 0.29777f $ **FLOATING
C493 PGA__GAINB.n1 VGND 0.00679f $ **FLOATING
C494 PGA__GAINB.t1 VGND 0.02079f $ **FLOATING
C495 PGA__GAINB.n2 VGND 0.00679f $ **FLOATING
C496 PGA__GAINB.n3 VGND 0.80616f $ **FLOATING
C497 PGA__GAINB.n4 VGND 3.44555f $ **FLOATING
C498 PGA__GAINB.n5 VGND 0.76609f $ **FLOATING
C499 PGA__GAINB.t0 VGND 0.01885f $ **FLOATING
C500 PGA__GAINB.n6 VGND 0.00775f $ **FLOATING
C501 SAMPLE__CLKB.n0 VGND 0.01227f $ **FLOATING
C502 SAMPLE__CLKB.t5 VGND 0.04438f $ **FLOATING
C503 SAMPLE__CLKB.t2 VGND 0.04611f $ **FLOATING
C504 SAMPLE__CLKB.n1 VGND 3.88329f $ **FLOATING
C505 SAMPLE__CLKB.t4 VGND 0.04611f $ **FLOATING
C506 SAMPLE__CLKB.n2 VGND 2.79223f $ **FLOATING
C507 SAMPLE__CLKB.t3 VGND 0.04438f $ **FLOATING
C508 SAMPLE__CLKB.n3 VGND 2.63202f $ **FLOATING
C509 SAMPLE__CLKB.n4 VGND 0.01074f $ **FLOATING
C510 SAMPLE__CLKB.t1 VGND 0.03289f $ **FLOATING
C511 SAMPLE__CLKB.n5 VGND 0.01074f $ **FLOATING
C512 SAMPLE__CLKB.n6 VGND 0.90089f $ **FLOATING
C513 SAMPLE__CLKB.n7 VGND 2.84475f $ **FLOATING
C514 SAMPLE__CLKB.n8 VGND 0.84265f $ **FLOATING
C515 SAMPLE__CLKB.t0 VGND 0.02983f $ **FLOATING
C516 SAMPLE__CLKB.n9 VGND 0.01227f $ **FLOATING
C517 D.n0 VGND 0.00779f $ **FLOATING
C518 D.n1 VGND 0.00682f $ **FLOATING
C519 D.t5 VGND 0.02089f $ **FLOATING
C520 D.n2 VGND 0.00682f $ **FLOATING
C521 D.n3 VGND 0.62468f $ **FLOATING
C522 D.n4 VGND 0.00779f $ **FLOATING
C523 D.t2 VGND 0.01894f $ **FLOATING
C524 D.n5 VGND 0.00779f $ **FLOATING
C525 D.n6 VGND 0.62468f $ **FLOATING
C526 D.n7 VGND 0.00682f $ **FLOATING
C527 D.t4 VGND 0.02089f $ **FLOATING
C528 D.n8 VGND 0.00682f $ **FLOATING
C529 D.n9 VGND 0.58683f $ **FLOATING
C530 D.n10 VGND 1.84512f $ **FLOATING
C531 D.n11 VGND 0.00779f $ **FLOATING
C532 D.t3 VGND 0.01894f $ **FLOATING
C533 D.n12 VGND 0.00779f $ **FLOATING
C534 D.n13 VGND 0.58683f $ **FLOATING
C535 D.n14 VGND 1.02544f $ **FLOATING
C536 D.n15 VGND 0.00682f $ **FLOATING
C537 D.t1 VGND 0.02089f $ **FLOATING
C538 D.n16 VGND 0.00682f $ **FLOATING
C539 D.n17 VGND 0.58683f $ **FLOATING
C540 D.n18 VGND 1.44203f $ **FLOATING
C541 D.n19 VGND 2.2617f $ **FLOATING
C542 D.n20 VGND 0.58683f $ **FLOATING
C543 D.t0 VGND 0.01894f $ **FLOATING
C544 D.n21 VGND 0.00779f $ **FLOATING
C545 BIAS_SOURCE__VCM_BUFFER__COMP.t3 VGND 0.77699f $ **FLOATING
C546 BIAS_SOURCE__VCM_BUFFER__COMP.t1 VGND 73.9547f $ **FLOATING
C547 BIAS_SOURCE__VCM_BUFFER__COMP.n0 VGND 1.90891f $ **FLOATING
C548 BIAS_SOURCE__VCM_BUFFER__COMP.t0 VGND 74.33311f $ **FLOATING
C549 BIAS_SOURCE__VCM_BUFFER__COMP.n1 VGND 1.88094f $ **FLOATING
C550 BIAS_SOURCE__VCM_BUFFER__COMP.t2 VGND 53.0479f $ **FLOATING
C551 BIAS_SOURCE__VCM_BUFFER__COMP.n2 VGND 69.5892f $ **FLOATING
C552 FILTER__BUFFER0__FIRST__TAIL.n0 VGND 0.01151f $ **FLOATING
C553 FILTER__BUFFER0__FIRST__TAIL.t0 VGND 0.01875f $ **FLOATING
C554 FILTER__BUFFER0__FIRST__TAIL.n1 VGND 0.0334f $ **FLOATING
C555 FILTER__BUFFER0__FIRST__TAIL.t1 VGND 0.05889f $ **FLOATING
C556 FILTER__BUFFER0__FIRST__TAIL.n2 VGND 0.20087f $ **FLOATING
C557 FILTER__BUFFER0__FIRST__TAIL.n3 VGND 0.01278f $ **FLOATING
C558 FILTER__BUFFER0__FIRST__TAIL.n4 VGND 0.74473f $ **FLOATING
C559 FILTER__BUFFER0__FIRST__TAIL.n5 VGND 0.01073f $ **FLOATING
C560 FILTER__BUFFER0__FIRST__TAIL.t2 VGND 0.05889f $ **FLOATING
C561 FILTER__BUFFER0__FIRST__TAIL.n6 VGND 0.20087f $ **FLOATING
C562 FILTER__BUFFER0__FIRST__TAIL.n7 VGND 0.03545f $ **FLOATING
C563 FILTER__BUFFER0__FIRST__TAIL.n8 VGND 0.71551f $ **FLOATING
C564 FILTER__BUFFER0__FIRST__TAIL.n9 VGND 2.43412f $ **FLOATING
C565 FILTER__BUFFER0__FIRST__TAIL.n10 VGND 0.63344f $ **FLOATING
C566 FILTER__BUFFER0__FIRST__TAIL.n11 VGND 0.01109f $ **FLOATING
C567 FILTER__BUFFER1__COMP.t2 VGND 72.83311f $ **FLOATING
C568 FILTER__BUFFER1__COMP.t3 VGND 72.466f $ **FLOATING
C569 FILTER__BUFFER1__COMP.n0 VGND 1.76115f $ **FLOATING
C570 FILTER__BUFFER1__COMP.t1 VGND 72.466f $ **FLOATING
C571 FILTER__BUFFER1__COMP.n1 VGND 1.63672f $ **FLOATING
C572 FILTER__BUFFER1__COMP.t0 VGND 0.63707f $ **FLOATING
C573 FILTER__BUFFER1__PRE.n0 VGND 0.00636f $ **FLOATING
C574 FILTER__BUFFER1__PRE.t5 VGND 39.6067f $ **FLOATING
C575 FILTER__BUFFER1__PRE.t2 VGND 39.6067f $ **FLOATING
C576 FILTER__BUFFER1__PRE.n1 VGND 1.00418f $ **FLOATING
C577 FILTER__BUFFER1__PRE.t4 VGND 39.6067f $ **FLOATING
C578 FILTER__BUFFER1__PRE.n2 VGND 0.69072f $ **FLOATING
C579 FILTER__BUFFER1__PRE.t3 VGND 1.51945f $ **FLOATING
C580 FILTER__BUFFER1__PRE.n3 VGND 0.53132f $ **FLOATING
C581 FILTER__BUFFER1__PRE.n4 VGND 0.01285f $ **FLOATING
C582 FILTER__BUFFER1__PRE.t1 VGND 0.01564f $ **FLOATING
C583 FILTER__BUFFER1__PRE.n5 VGND 0.01305f $ **FLOATING
C584 FILTER__BUFFER1__PRE.n6 VGND 0.82709f $ **FLOATING
C585 FILTER__BUFFER1__PRE.n7 VGND 1.06119f $ **FLOATING
C586 FILTER__BUFFER1__PRE.n8 VGND 0.42042f $ **FLOATING
C587 FILTER__BUFFER1__PRE.t0 VGND 0.03491f $ **FLOATING
C588 FILTER__BUFFER1__PRE.n9 VGND 0.11908f $ **FLOATING
C589 FILTER__BUFFER1__PRE.n10 VGND 0.02101f $ **FLOATING
C590 BIAS_SOURCE__VCM_BUFFER__PRE.n0 VGND 0.00622f $ **FLOATING
C591 BIAS_SOURCE__VCM_BUFFER__PRE.t4 VGND 38.7122f $ **FLOATING
C592 BIAS_SOURCE__VCM_BUFFER__PRE.t3 VGND 38.7122f $ **FLOATING
C593 BIAS_SOURCE__VCM_BUFFER__PRE.n1 VGND 1.08171f $ **FLOATING
C594 BIAS_SOURCE__VCM_BUFFER__PRE.t5 VGND 38.7122f $ **FLOATING
C595 BIAS_SOURCE__VCM_BUFFER__PRE.n2 VGND 0.72666f $ **FLOATING
C596 BIAS_SOURCE__VCM_BUFFER__PRE.t2 VGND 1.48514f $ **FLOATING
C597 BIAS_SOURCE__VCM_BUFFER__PRE.n3 VGND 0.64538f $ **FLOATING
C598 BIAS_SOURCE__VCM_BUFFER__PRE.n4 VGND 0.01256f $ **FLOATING
C599 BIAS_SOURCE__VCM_BUFFER__PRE.t1 VGND 0.01528f $ **FLOATING
C600 BIAS_SOURCE__VCM_BUFFER__PRE.n5 VGND 0.01276f $ **FLOATING
C601 BIAS_SOURCE__VCM_BUFFER__PRE.n6 VGND 0.88693f $ **FLOATING
C602 BIAS_SOURCE__VCM_BUFFER__PRE.n7 VGND 1.20477f $ **FLOATING
C603 BIAS_SOURCE__VCM_BUFFER__PRE.n8 VGND 0.49017f $ **FLOATING
C604 BIAS_SOURCE__VCM_BUFFER__PRE.t0 VGND 0.03412f $ **FLOATING
C605 BIAS_SOURCE__VCM_BUFFER__PRE.n9 VGND 0.11639f $ **FLOATING
C606 BIAS_SOURCE__VCM_BUFFER__PRE.n10 VGND 0.02054f $ **FLOATING
C607 SAMPLE__TB.n0 VGND 0.00562f $ **FLOATING
C608 SAMPLE__TB.t3 VGND 0.02031f $ **FLOATING
C609 SAMPLE__TB.t2 VGND 0.02111f $ **FLOATING
C610 SAMPLE__TB.n1 VGND 1.70409f $ **FLOATING
C611 SAMPLE__TB.n2 VGND 0.00492f $ **FLOATING
C612 SAMPLE__TB.t1 VGND 0.01506f $ **FLOATING
C613 SAMPLE__TB.n3 VGND 0.00492f $ **FLOATING
C614 SAMPLE__TB.n4 VGND 0.41236f $ **FLOATING
C615 SAMPLE__TB.n5 VGND 1.30312f $ **FLOATING
C616 SAMPLE__TB.n6 VGND 0.3857f $ **FLOATING
C617 SAMPLE__TB.t0 VGND 0.01366f $ **FLOATING
C618 SAMPLE__TB.n7 VGND 0.00562f $ **FLOATING
C619 SAMPLE__T.n0 VGND 0.00601f $ **FLOATING
C620 SAMPLE__T.t4 VGND 0.02484f $ **FLOATING
C621 SAMPLE__T.t5 VGND 0.02581f $ **FLOATING
C622 SAMPLE__T.n1 VGND 2.91768f $ **FLOATING
C623 SAMPLE__T.n2 VGND 0.00687f $ **FLOATING
C624 SAMPLE__T.t3 VGND 0.0167f $ **FLOATING
C625 SAMPLE__T.n3 VGND 0.00687f $ **FLOATING
C626 SAMPLE__T.n4 VGND 0.574f $ **FLOATING
C627 SAMPLE__T.n5 VGND 0.00601f $ **FLOATING
C628 SAMPLE__T.t1 VGND 0.01841f $ **FLOATING
C629 SAMPLE__T.n6 VGND 0.00601f $ **FLOATING
C630 SAMPLE__T.n7 VGND 0.54028f $ **FLOATING
C631 SAMPLE__T.n8 VGND 1.67667f $ **FLOATING
C632 SAMPLE__T.n9 VGND 0.00687f $ **FLOATING
C633 SAMPLE__T.t2 VGND 0.0167f $ **FLOATING
C634 SAMPLE__T.n10 VGND 0.00687f $ **FLOATING
C635 SAMPLE__T.n11 VGND 0.54028f $ **FLOATING
C636 SAMPLE__T.n12 VGND 0.92922f $ **FLOATING
C637 SAMPLE__T.n13 VGND 1.6254f $ **FLOATING
C638 SAMPLE__T.n14 VGND 0.54028f $ **FLOATING
C639 SAMPLE__T.t0 VGND 0.01841f $ **FLOATING
C640 SAMPLE__T.n15 VGND 0.00601f $ **FLOATING
C641 PGA__AMP__COMP.t3 VGND 0.79167f $ **FLOATING
C642 PGA__AMP__COMP.t1 VGND 73.8326f $ **FLOATING
C643 PGA__AMP__COMP.n0 VGND 1.93753f $ **FLOATING
C644 PGA__AMP__COMP.t0 VGND 73.8326f $ **FLOATING
C645 PGA__AMP__COMP.n1 VGND 1.94199f $ **FLOATING
C646 PGA__AMP__COMP.t2 VGND 52.9354f $ **FLOATING
C647 PGA__AMP__COMP.n2 VGND 0.11179p $ **FLOATING
C648 PGA__AMP__PRE.n0 VGND 0.01301f $ **FLOATING
C649 PGA__AMP__PRE.t0 VGND 0.01559f $ **FLOATING
C650 PGA__AMP__PRE.t3 VGND 39.4856f $ **FLOATING
C651 PGA__AMP__PRE.t4 VGND 39.4856f $ **FLOATING
C652 PGA__AMP__PRE.n1 VGND 1.08868f $ **FLOATING
C653 PGA__AMP__PRE.t2 VGND 39.4856f $ **FLOATING
C654 PGA__AMP__PRE.n2 VGND 0.73344f $ **FLOATING
C655 PGA__AMP__PRE.t5 VGND 1.51481f $ **FLOATING
C656 PGA__AMP__PRE.n3 VGND 0.64276f $ **FLOATING
C657 PGA__AMP__PRE.n4 VGND 0.00634f $ **FLOATING
C658 PGA__AMP__PRE.t1 VGND 0.0348f $ **FLOATING
C659 PGA__AMP__PRE.n5 VGND 0.11872f $ **FLOATING
C660 PGA__AMP__PRE.n6 VGND 0.02095f $ **FLOATING
C661 PGA__AMP__PRE.n7 VGND 0.48983f $ **FLOATING
C662 PGA__AMP__PRE.n8 VGND 1.20757f $ **FLOATING
C663 PGA__AMP__PRE.n9 VGND 0.89458f $ **FLOATING
C664 PGA__AMP__PRE.n10 VGND 0.01281f $ **FLOATING
C665 PGA__LOW.n0 VGND 0.0542f $ **FLOATING
C666 PGA__LOW.t0 VGND 0.06494f $ **FLOATING
C667 PGA__LOW.t1 VGND 2.05013f $ **FLOATING
C668 PGA__LOW.n1 VGND 0.04983f $ **FLOATING
C669 PGA__LOW.t2 VGND 0.04887f $ **FLOATING
C670 PGA__LOW.n2 VGND 0.05168f $ **FLOATING
C671 PGA__LOW.n3 VGND 3.74642f $ **FLOATING
C672 PGA__LOW.n4 VGND 6.8692f $ **FLOATING
C673 PGA__LOW.n5 VGND 3.78619f $ **FLOATING
C674 PGA__LOW.n6 VGND 0.05336f $ **FLOATING
C675 GAIN.t2 VGND 0.06803f $ **FLOATING
C676 GAIN.n0 VGND 53.3539f $ **FLOATING
C677 GAIN.t1 VGND 0.06546f $ **FLOATING
C678 GAIN.n1 VGND 5.51357f $ **FLOATING
C679 GAIN.t0 VGND 0.69809f $ **FLOATING
C680 COMPARATOR__PREAMP__TAIL.n0 VGND 0.01315f $ **FLOATING
C681 COMPARATOR__PREAMP__TAIL.t0 VGND 0.02142f $ **FLOATING
C682 COMPARATOR__PREAMP__TAIL.n1 VGND 0.03817f $ **FLOATING
C683 COMPARATOR__PREAMP__TAIL.t1 VGND 0.06729f $ **FLOATING
C684 COMPARATOR__PREAMP__TAIL.n2 VGND 0.22953f $ **FLOATING
C685 COMPARATOR__PREAMP__TAIL.n3 VGND 0.0146f $ **FLOATING
C686 COMPARATOR__PREAMP__TAIL.n4 VGND 0.71367f $ **FLOATING
C687 COMPARATOR__PREAMP__TAIL.n5 VGND 0.01227f $ **FLOATING
C688 COMPARATOR__PREAMP__TAIL.t2 VGND 0.06729f $ **FLOATING
C689 COMPARATOR__PREAMP__TAIL.n6 VGND 0.22953f $ **FLOATING
C690 COMPARATOR__PREAMP__TAIL.n7 VGND 0.04051f $ **FLOATING
C691 COMPARATOR__PREAMP__TAIL.n8 VGND 0.68223f $ **FLOATING
C692 COMPARATOR__PREAMP__TAIL.n9 VGND 2.34923f $ **FLOATING
C693 COMPARATOR__PREAMP__TAIL.n10 VGND 0.58676f $ **FLOATING
C694 COMPARATOR__PREAMP__TAIL.n11 VGND 0.01268f $ **FLOATING
C695 BIAS.t3 VGND 0.70117f $ **FLOATING
C696 BIAS.n0 VGND 0.03536f $ **FLOATING
C697 BIAS.t1 VGND 0.05976f $ **FLOATING
C698 BIAS.n1 VGND 0.03668f $ **FLOATING
C699 BIAS.n2 VGND 1.48712f $ **FLOATING
C700 BIAS.n3 VGND 1.76461f $ **FLOATING
C701 BIAS.t0 VGND 0.70117f $ **FLOATING
C702 BIAS.n4 VGND 2.57708f $ **FLOATING
C703 BIAS.t2 VGND 2.88891f $ **FLOATING
C704 BIAS.n5 VGND 30.3113f $ **FLOATING
C705 BIAS.t4 VGND 0.70117f $ **FLOATING
C706 BIAS.n6 VGND 29.5183f $ **FLOATING
C707 BIAS.t7 VGND 0.70117f $ **FLOATING
C708 BIAS.n7 VGND 10.8386f $ **FLOATING
C709 BIAS.t8 VGND 0.70117f $ **FLOATING
C710 BIAS.n8 VGND 10.8386f $ **FLOATING
C711 BIAS.t5 VGND 0.70117f $ **FLOATING
C712 BIAS.n9 VGND 36.4432f $ **FLOATING
C713 BIAS.t11 VGND 0.70117f $ **FLOATING
C714 BIAS.n10 VGND 36.4432f $ **FLOATING
C715 BIAS.t10 VGND 0.70117f $ **FLOATING
C716 BIAS.n11 VGND 33.3334f $ **FLOATING
C717 BIAS.t6 VGND 0.70117f $ **FLOATING
C718 BIAS.n12 VGND 33.3334f $ **FLOATING
C719 BIAS.t9 VGND 0.70117f $ **FLOATING
C720 BIAS.n13 VGND 17.4362f $ **FLOATING
C721 SAMPLE__M.n0 VGND 0.00945f $ **FLOATING
C722 SAMPLE__M.t4 VGND 0.03417f $ **FLOATING
C723 SAMPLE__M.t5 VGND 0.03551f $ **FLOATING
C724 SAMPLE__M.n1 VGND 3.82653f $ **FLOATING
C725 SAMPLE__M.n2 VGND 0.00827f $ **FLOATING
C726 SAMPLE__M.t2 VGND 0.02533f $ **FLOATING
C727 SAMPLE__M.n3 VGND 0.00827f $ **FLOATING
C728 SAMPLE__M.n4 VGND 0.68025f $ **FLOATING
C729 SAMPLE__M.n5 VGND 2.16659f $ **FLOATING
C730 SAMPLE__M.n6 VGND 0.00945f $ **FLOATING
C731 SAMPLE__M.t3 VGND 0.02297f $ **FLOATING
C732 SAMPLE__M.n7 VGND 0.00945f $ **FLOATING
C733 SAMPLE__M.n8 VGND 0.68025f $ **FLOATING
C734 SAMPLE__M.n9 VGND 1.20894f $ **FLOATING
C735 SAMPLE__M.n10 VGND 0.00827f $ **FLOATING
C736 SAMPLE__M.t1 VGND 0.02533f $ **FLOATING
C737 SAMPLE__M.n11 VGND 0.00827f $ **FLOATING
C738 SAMPLE__M.n12 VGND 0.68025f $ **FLOATING
C739 SAMPLE__M.n13 VGND 2.16885f $ **FLOATING
C740 SAMPLE__M.n14 VGND 0.72563f $ **FLOATING
C741 SAMPLE__M.t0 VGND 0.02297f $ **FLOATING
C742 SAMPLE__M.n15 VGND 0.00945f $ **FLOATING
C743 PGA__AMP__FIRST__TAIL.n0 VGND 0.01194f $ **FLOATING
C744 PGA__AMP__FIRST__TAIL.n1 VGND 0.0128f $ **FLOATING
C745 PGA__AMP__FIRST__TAIL.t1 VGND 0.02085f $ **FLOATING
C746 PGA__AMP__FIRST__TAIL.n2 VGND 0.01234f $ **FLOATING
C747 PGA__AMP__FIRST__TAIL.n3 VGND 0.72358f $ **FLOATING
C748 PGA__AMP__FIRST__TAIL.n4 VGND 0.03715f $ **FLOATING
C749 PGA__AMP__FIRST__TAIL.t2 VGND 0.06549f $ **FLOATING
C750 PGA__AMP__FIRST__TAIL.n5 VGND 0.22339f $ **FLOATING
C751 PGA__AMP__FIRST__TAIL.n6 VGND 0.01421f $ **FLOATING
C752 PGA__AMP__FIRST__TAIL.n7 VGND 0.84738f $ **FLOATING
C753 PGA__AMP__FIRST__TAIL.n8 VGND 2.76684f $ **FLOATING
C754 PGA__AMP__FIRST__TAIL.n9 VGND 0.81466f $ **FLOATING
C755 PGA__AMP__FIRST__TAIL.t0 VGND 0.06549f $ **FLOATING
C756 PGA__AMP__FIRST__TAIL.n10 VGND 0.22338f $ **FLOATING
C757 PGA__AMP__FIRST__TAIL.n11 VGND 0.03942f $ **FLOATING
C758 PGA__FB.t3 VGND 0.42861f $ **FLOATING
C759 PGA__FB.t1 VGND 0.56138f $ **FLOATING
C760 PGA__FB.t2 VGND 0.60984f $ **FLOATING
C761 PGA__FB.n0 VGND 1.62893f $ **FLOATING
C762 PGA__FB.t0 VGND 0.45213f $ **FLOATING
C763 PGA__FB.n1 VGND 3.49668f $ **FLOATING
C764 BIAS_SOURCE__VCM_RAW.t9 VGND 0.01338f $ **FLOATING
C765 BIAS_SOURCE__VCM_RAW.t1 VGND 0.01868f $ **FLOATING
C766 BIAS_SOURCE__VCM_RAW.t0 VGND 0.0115f $ **FLOATING
C767 BIAS_SOURCE__VCM_RAW.n0 VGND 0.0483f $ **FLOATING
C768 BIAS_SOURCE__VCM_RAW.t14 VGND 1.23523f $ **FLOATING
C769 BIAS_SOURCE__VCM_RAW.n1 VGND 0.0264f $ **FLOATING
C770 BIAS_SOURCE__VCM_RAW.t11 VGND 1.23523f $ **FLOATING
C771 BIAS_SOURCE__VCM_RAW.n2 VGND 0.02561f $ **FLOATING
C772 BIAS_SOURCE__VCM_RAW.t5 VGND 1.23523f $ **FLOATING
C773 BIAS_SOURCE__VCM_RAW.n3 VGND 0.02561f $ **FLOATING
C774 BIAS_SOURCE__VCM_RAW.t8 VGND 1.23523f $ **FLOATING
C775 BIAS_SOURCE__VCM_RAW.n4 VGND 0.02561f $ **FLOATING
C776 BIAS_SOURCE__VCM_RAW.t2 VGND 1.23523f $ **FLOATING
C777 BIAS_SOURCE__VCM_RAW.n5 VGND 0.02561f $ **FLOATING
C778 BIAS_SOURCE__VCM_RAW.t12 VGND 1.23523f $ **FLOATING
C779 BIAS_SOURCE__VCM_RAW.n6 VGND 0.02561f $ **FLOATING
C780 BIAS_SOURCE__VCM_RAW.t3 VGND 1.23523f $ **FLOATING
C781 BIAS_SOURCE__VCM_RAW.n7 VGND 0.02561f $ **FLOATING
C782 BIAS_SOURCE__VCM_RAW.t7 VGND 1.23523f $ **FLOATING
C783 BIAS_SOURCE__VCM_RAW.n8 VGND 0.02561f $ **FLOATING
C784 BIAS_SOURCE__VCM_RAW.t13 VGND 1.23523f $ **FLOATING
C785 BIAS_SOURCE__VCM_RAW.n9 VGND 0.02561f $ **FLOATING
C786 BIAS_SOURCE__VCM_RAW.t6 VGND 1.23523f $ **FLOATING
C787 BIAS_SOURCE__VCM_RAW.n10 VGND 0.02561f $ **FLOATING
C788 BIAS_SOURCE__VCM_RAW.t10 VGND 1.23523f $ **FLOATING
C789 BIAS_SOURCE__VCM_RAW.n11 VGND 0.02561f $ **FLOATING
C790 BIAS_SOURCE__VCM_RAW.t4 VGND 1.23523f $ **FLOATING
C791 BIAS_SOURCE__VCM_RAW.n12 VGND 0.04052f $ **FLOATING
C792 SAMPLE__MF.n0 VGND 0.01405f $ **FLOATING
C793 SAMPLE__MF.n1 VGND 0.01605f $ **FLOATING
C794 SAMPLE__MF.t1 VGND 0.03903f $ **FLOATING
C795 SAMPLE__MF.n2 VGND 0.01605f $ **FLOATING
C796 SAMPLE__MF.n3 VGND 1.28697f $ **FLOATING
C797 SAMPLE__MF.n4 VGND 0.01405f $ **FLOATING
C798 SAMPLE__MF.t2 VGND 0.04303f $ **FLOATING
C799 SAMPLE__MF.n5 VGND 0.01405f $ **FLOATING
C800 SAMPLE__MF.n6 VGND 1.20901f $ **FLOATING
C801 SAMPLE__MF.n7 VGND 5.14645f $ **FLOATING
C802 SAMPLE__MF.n8 VGND 0.01605f $ **FLOATING
C803 SAMPLE__MF.t5 VGND 0.03903f $ **FLOATING
C804 SAMPLE__MF.n9 VGND 0.01605f $ **FLOATING
C805 SAMPLE__MF.n10 VGND 1.28697f $ **FLOATING
C806 SAMPLE__MF.n11 VGND 0.01405f $ **FLOATING
C807 SAMPLE__MF.t3 VGND 0.04303f $ **FLOATING
C808 SAMPLE__MF.n12 VGND 0.01405f $ **FLOATING
C809 SAMPLE__MF.n13 VGND 1.20901f $ **FLOATING
C810 SAMPLE__MF.n14 VGND 3.80136f $ **FLOATING
C811 SAMPLE__MF.n15 VGND 0.01605f $ **FLOATING
C812 SAMPLE__MF.t4 VGND 0.03903f $ **FLOATING
C813 SAMPLE__MF.n16 VGND 0.01605f $ **FLOATING
C814 SAMPLE__MF.n17 VGND 1.20901f $ **FLOATING
C815 SAMPLE__MF.n18 VGND 2.11264f $ **FLOATING
C816 SAMPLE__MF.n19 VGND 3.45774f $ **FLOATING
C817 SAMPLE__MF.n20 VGND 1.20901f $ **FLOATING
C818 SAMPLE__MF.t0 VGND 0.04303f $ **FLOATING
C819 SAMPLE__MF.n21 VGND 0.01405f $ **FLOATING
C820 SAMPLE__MB.n0 VGND 0.00562f $ **FLOATING
C821 SAMPLE__MB.t2 VGND 0.02031f $ **FLOATING
C822 SAMPLE__MB.t3 VGND 0.02111f $ **FLOATING
C823 SAMPLE__MB.n1 VGND 1.70409f $ **FLOATING
C824 SAMPLE__MB.n2 VGND 0.00492f $ **FLOATING
C825 SAMPLE__MB.t1 VGND 0.01506f $ **FLOATING
C826 SAMPLE__MB.n3 VGND 0.00492f $ **FLOATING
C827 SAMPLE__MB.n4 VGND 0.41236f $ **FLOATING
C828 SAMPLE__MB.n5 VGND 1.30312f $ **FLOATING
C829 SAMPLE__MB.n6 VGND 0.3857f $ **FLOATING
C830 SAMPLE__MB.t0 VGND 0.01366f $ **FLOATING
C831 SAMPLE__MB.n7 VGND 0.00562f $ **FLOATING
C832 FILTER__BUFFER0__COMP.t3 VGND 0.63708f $ **FLOATING
C833 FILTER__BUFFER0__COMP.t0 VGND 72.466f $ **FLOATING
C834 FILTER__BUFFER0__COMP.n0 VGND 1.63672f $ **FLOATING
C835 FILTER__BUFFER0__COMP.t1 VGND 72.466f $ **FLOATING
C836 FILTER__BUFFER0__COMP.n1 VGND 1.70455f $ **FLOATING
C837 FILTER__BUFFER0__COMP.t2 VGND 52.1899f $ **FLOATING
C838 FILTER__BUFFER0__COMP.n2 VGND 0.10989p $ **FLOATING
C839 FILTER__BUFFER0__PRE.n0 VGND 0.00632f $ **FLOATING
C840 FILTER__BUFFER0__PRE.t5 VGND 39.3449f $ **FLOATING
C841 FILTER__BUFFER0__PRE.t4 VGND 39.3449f $ **FLOATING
C842 FILTER__BUFFER0__PRE.n1 VGND 0.99755f $ **FLOATING
C843 FILTER__BUFFER0__PRE.t2 VGND 39.3449f $ **FLOATING
C844 FILTER__BUFFER0__PRE.n2 VGND 0.68616f $ **FLOATING
C845 FILTER__BUFFER0__PRE.t3 VGND 1.50941f $ **FLOATING
C846 FILTER__BUFFER0__PRE.n3 VGND 0.5278f $ **FLOATING
C847 FILTER__BUFFER0__PRE.n4 VGND 0.01277f $ **FLOATING
C848 FILTER__BUFFER0__PRE.t1 VGND 0.01553f $ **FLOATING
C849 FILTER__BUFFER0__PRE.n5 VGND 0.01297f $ **FLOATING
C850 FILTER__BUFFER0__PRE.n6 VGND 0.82163f $ **FLOATING
C851 FILTER__BUFFER0__PRE.n7 VGND 1.05418f $ **FLOATING
C852 FILTER__BUFFER0__PRE.n8 VGND 0.41764f $ **FLOATING
C853 FILTER__BUFFER0__PRE.t0 VGND 0.03468f $ **FLOATING
C854 FILTER__BUFFER0__PRE.n9 VGND 0.11829f $ **FLOATING
C855 FILTER__BUFFER0__PRE.n10 VGND 0.02088f $ **FLOATING
C856 FILTER__FILTER1.t8 VGND 0.00605f $ **FLOATING
C857 FILTER__FILTER1.t0 VGND 0.01113f $ **FLOATING
C858 FILTER__FILTER1.t7 VGND 0.55795f $ **FLOATING
C859 FILTER__FILTER1.n0 VGND 0.01625f $ **FLOATING
C860 FILTER__FILTER1.t6 VGND 0.55795f $ **FLOATING
C861 FILTER__FILTER1.n1 VGND 0.01087f $ **FLOATING
C862 FILTER__FILTER1.t10 VGND 0.55795f $ **FLOATING
C863 FILTER__FILTER1.n2 VGND 0.01087f $ **FLOATING
C864 FILTER__FILTER1.t3 VGND 0.55795f $ **FLOATING
C865 FILTER__FILTER1.n3 VGND 0.01087f $ **FLOATING
C866 FILTER__FILTER1.t12 VGND 0.55795f $ **FLOATING
C867 FILTER__FILTER1.n4 VGND 0.01087f $ **FLOATING
C868 FILTER__FILTER1.t13 VGND 0.55795f $ **FLOATING
C869 FILTER__FILTER1.n5 VGND 0.01087f $ **FLOATING
C870 FILTER__FILTER1.t9 VGND 0.55795f $ **FLOATING
C871 FILTER__FILTER1.n6 VGND 0.01087f $ **FLOATING
C872 FILTER__FILTER1.t1 VGND 0.55795f $ **FLOATING
C873 FILTER__FILTER1.n7 VGND 0.01087f $ **FLOATING
C874 FILTER__FILTER1.t11 VGND 0.55795f $ **FLOATING
C875 FILTER__FILTER1.n8 VGND 0.01087f $ **FLOATING
C876 FILTER__FILTER1.t4 VGND 0.55795f $ **FLOATING
C877 FILTER__FILTER1.n9 VGND 0.01087f $ **FLOATING
C878 FILTER__FILTER1.t5 VGND 0.55795f $ **FLOATING
C879 FILTER__FILTER1.n10 VGND 0.01087f $ **FLOATING
C880 FILTER__FILTER1.t2 VGND 0.55795f $ **FLOATING
C881 FILTER__FILTER1.n11 VGND 0.01603f $ **FLOATING
C882 BIAS_SOURCE__VCM_BUFFER__FIRST__TAIL.n0 VGND 0.00516f $ **FLOATING
C883 BIAS_SOURCE__VCM_BUFFER__FIRST__TAIL.n1 VGND 0.00553f $ **FLOATING
C884 BIAS_SOURCE__VCM_BUFFER__FIRST__TAIL.t2 VGND 0.00901f $ **FLOATING
C885 BIAS_SOURCE__VCM_BUFFER__FIRST__TAIL.n2 VGND 0.00533f $ **FLOATING
C886 BIAS_SOURCE__VCM_BUFFER__FIRST__TAIL.n3 VGND 0.32093f $ **FLOATING
C887 BIAS_SOURCE__VCM_BUFFER__FIRST__TAIL.n4 VGND 0.01605f $ **FLOATING
C888 BIAS_SOURCE__VCM_BUFFER__FIRST__TAIL.t1 VGND 0.0283f $ **FLOATING
C889 BIAS_SOURCE__VCM_BUFFER__FIRST__TAIL.n5 VGND 0.09653f $ **FLOATING
C890 BIAS_SOURCE__VCM_BUFFER__FIRST__TAIL.n6 VGND 0.00614f $ **FLOATING
C891 BIAS_SOURCE__VCM_BUFFER__FIRST__TAIL.n7 VGND 0.37444f $ **FLOATING
C892 BIAS_SOURCE__VCM_BUFFER__FIRST__TAIL.n8 VGND 1.2214f $ **FLOATING
C893 BIAS_SOURCE__VCM_BUFFER__FIRST__TAIL.n9 VGND 0.36021f $ **FLOATING
C894 BIAS_SOURCE__VCM_BUFFER__FIRST__TAIL.t0 VGND 0.0283f $ **FLOATING
C895 BIAS_SOURCE__VCM_BUFFER__FIRST__TAIL.n10 VGND 0.09653f $ **FLOATING
C896 BIAS_SOURCE__VCM_BUFFER__FIRST__TAIL.n11 VGND 0.01703f $ **FLOATING
C897 BIAS_SOURCE__VCM_BUFFER__FIRST__MIR.n0 VGND 0.03047f $ **FLOATING
C898 BIAS_SOURCE__VCM_BUFFER__FIRST__MIR.t1 VGND 0.0365f $ **FLOATING
C899 BIAS_SOURCE__VCM_BUFFER__FIRST__MIR.t3 VGND 1.85679f $ **FLOATING
C900 BIAS_SOURCE__VCM_BUFFER__FIRST__MIR.t0 VGND 1.85679f $ **FLOATING
C901 BIAS_SOURCE__VCM_BUFFER__FIRST__MIR.n1 VGND 1.95461f $ **FLOATING
C902 BIAS_SOURCE__VCM_BUFFER__FIRST__MIR.n2 VGND 0.01485f $ **FLOATING
C903 BIAS_SOURCE__VCM_BUFFER__FIRST__MIR.t2 VGND 0.08149f $ **FLOATING
C904 BIAS_SOURCE__VCM_BUFFER__FIRST__MIR.n3 VGND 0.27795f $ **FLOATING
C905 BIAS_SOURCE__VCM_BUFFER__FIRST__MIR.n4 VGND 0.04905f $ **FLOATING
C906 BIAS_SOURCE__VCM_BUFFER__FIRST__MIR.n5 VGND 1.03086f $ **FLOATING
C907 BIAS_SOURCE__VCM_BUFFER__FIRST__MIR.n6 VGND 1.87711f $ **FLOATING
C908 BIAS_SOURCE__VCM_BUFFER__FIRST__MIR.n7 VGND 2.0945f $ **FLOATING
C909 BIAS_SOURCE__VCM_BUFFER__FIRST__MIR.n8 VGND 0.02999f $ **FLOATING
C910 VCM.t5 VGND 2.47685f $ **FLOATING
C911 VCM.t0 VGND 2.71582f $ **FLOATING
C912 VCM.n0 VGND 97.0714f $ **FLOATING
C913 VCM.t2 VGND 2.63412f $ **FLOATING
C914 VCM.n1 VGND 19.3887f $ **FLOATING
C915 VCM.n2 VGND 0.03937f $ **FLOATING
C916 VCM.t1 VGND 0.06415f $ **FLOATING
C917 VCM.n3 VGND 0.03796f $ **FLOATING
C918 VCM.n4 VGND 1.53845f $ **FLOATING
C919 VCM.n5 VGND 8.45248f $ **FLOATING
C920 VCM.n6 VGND 0.81127f $ **FLOATING
C921 VCM.t3 VGND 0.8059f $ **FLOATING
C922 VCM.n7 VGND 3.50884f $ **FLOATING
C923 VCM.n8 VGND 0.31566f $ **FLOATING
C924 VCM.n9 VGND 3.51452f $ **FLOATING
C925 VCM.n10 VGND 3.5229f $ **FLOATING
C926 VCM.n11 VGND 31.3916f $ **FLOATING
C927 VCM.t4 VGND 2.47685f $ **FLOATING
C928 FILTER__FILTER0.t3 VGND 0.006f $ **FLOATING
C929 FILTER__FILTER0.t0 VGND 0.01105f $ **FLOATING
C930 FILTER__FILTER0.t13 VGND 0.55379f $ **FLOATING
C931 FILTER__FILTER0.n0 VGND 0.01613f $ **FLOATING
C932 FILTER__FILTER0.t2 VGND 0.55379f $ **FLOATING
C933 FILTER__FILTER0.n1 VGND 0.01079f $ **FLOATING
C934 FILTER__FILTER0.t7 VGND 0.55379f $ **FLOATING
C935 FILTER__FILTER0.n2 VGND 0.01079f $ **FLOATING
C936 FILTER__FILTER0.t5 VGND 0.55379f $ **FLOATING
C937 FILTER__FILTER0.n3 VGND 0.01079f $ **FLOATING
C938 FILTER__FILTER0.t8 VGND 0.55379f $ **FLOATING
C939 FILTER__FILTER0.n4 VGND 0.01079f $ **FLOATING
C940 FILTER__FILTER0.t10 VGND 0.55379f $ **FLOATING
C941 FILTER__FILTER0.n5 VGND 0.01079f $ **FLOATING
C942 FILTER__FILTER0.t1 VGND 0.55379f $ **FLOATING
C943 FILTER__FILTER0.n6 VGND 0.01079f $ **FLOATING
C944 FILTER__FILTER0.t12 VGND 0.55379f $ **FLOATING
C945 FILTER__FILTER0.n7 VGND 0.01079f $ **FLOATING
C946 FILTER__FILTER0.t4 VGND 0.55379f $ **FLOATING
C947 FILTER__FILTER0.n8 VGND 0.01079f $ **FLOATING
C948 FILTER__FILTER0.t9 VGND 0.55379f $ **FLOATING
C949 FILTER__FILTER0.n9 VGND 0.01079f $ **FLOATING
C950 FILTER__FILTER0.t11 VGND 0.55379f $ **FLOATING
C951 FILTER__FILTER0.n10 VGND 0.01079f $ **FLOATING
C952 FILTER__FILTER0.t6 VGND 0.55379f $ **FLOATING
C953 FILTER__FILTER0.n11 VGND 0.01591f $ **FLOATING
C954 AMPLIFIED.n0 VGND 0.03871f $ **FLOATING
C955 AMPLIFIED.t0 VGND 0.04638f $ **FLOATING
C956 AMPLIFIED.t1 VGND 0.86598f $ **FLOATING
C957 AMPLIFIED.n1 VGND 0.41692f $ **FLOATING
C958 AMPLIFIED.t3 VGND 0.41416f $ **FLOATING
C959 AMPLIFIED.n2 VGND 1.80324f $ **FLOATING
C960 AMPLIFIED.n3 VGND 0.16222f $ **FLOATING
C961 AMPLIFIED.n4 VGND 1.76561f $ **FLOATING
C962 AMPLIFIED.n5 VGND 0.02023f $ **FLOATING
C963 AMPLIFIED.t4 VGND 0.03297f $ **FLOATING
C964 AMPLIFIED.n6 VGND 0.01951f $ **FLOATING
C965 AMPLIFIED.n7 VGND 0.70183f $ **FLOATING
C966 AMPLIFIED.n8 VGND 5.11857f $ **FLOATING
C967 AMPLIFIED.t6 VGND 1.26852f $ **FLOATING
C968 AMPLIFIED.n9 VGND 5.17133f $ **FLOATING
C969 AMPLIFIED.t5 VGND 0.86194f $ **FLOATING
C970 AMPLIFIED.n10 VGND 2.39727f $ **FLOATING
C971 AMPLIFIED.n11 VGND 0.03559f $ **FLOATING
C972 AMPLIFIED.t2 VGND 0.0349f $ **FLOATING
C973 AMPLIFIED.n12 VGND 0.03691f $ **FLOATING
C974 AMPLIFIED.n13 VGND 2.43979f $ **FLOATING
C975 AMPLIFIED.n14 VGND 1.96589f $ **FLOATING
C976 AMPLIFIED.n15 VGND 2.18129f $ **FLOATING
C977 AMPLIFIED.n16 VGND 2.42295f $ **FLOATING
C978 AMPLIFIED.n17 VGND 0.03811f $ **FLOATING
C979 RESET_MUX__SB.n0 VGND 0.00689f $ **FLOATING
C980 RESET_MUX__SB.t3 VGND 0.02588f $ **FLOATING
C981 RESET_MUX__SB.t2 VGND 0.02491f $ **FLOATING
C982 RESET_MUX__SB.n1 VGND 2.6581f $ **FLOATING
C983 RESET_MUX__SB.n2 VGND 0.00603f $ **FLOATING
C984 RESET_MUX__SB.t1 VGND 0.01846f $ **FLOATING
C985 RESET_MUX__SB.n3 VGND 0.00603f $ **FLOATING
C986 RESET_MUX__SB.n4 VGND 0.50567f $ **FLOATING
C987 RESET_MUX__SB.n5 VGND 1.59676f $ **FLOATING
C988 RESET_MUX__SB.n6 VGND 0.47298f $ **FLOATING
C989 RESET_MUX__SB.t0 VGND 0.01675f $ **FLOATING
C990 RESET_MUX__SB.n7 VGND 0.00689f $ **FLOATING
C991 RESET.t2 VGND 0.0696f $ **FLOATING
C992 RESET.n0 VGND 0.13234p $ **FLOATING
C993 RESET.t0 VGND 0.06697f $ **FLOATING
C994 RESET.n1 VGND 3.82794f $ **FLOATING
C995 RESET.t3 VGND 0.0696f $ **FLOATING
C996 RESET.n2 VGND 6.77067f $ **FLOATING
C997 RESET.t1 VGND 0.06697f $ **FLOATING
C998 PGA__AMP__FIRST__MIR.n0 VGND 0.01215f $ **FLOATING
C999 PGA__AMP__FIRST__MIR.t3 VGND 1.51895f $ **FLOATING
C1000 PGA__AMP__FIRST__MIR.t1 VGND 1.51895f $ **FLOATING
C1001 PGA__AMP__FIRST__MIR.n1 VGND 1.14338f $ **FLOATING
C1002 PGA__AMP__FIRST__MIR.n2 VGND 0.02454f $ **FLOATING
C1003 PGA__AMP__FIRST__MIR.t2 VGND 0.02986f $ **FLOATING
C1004 PGA__AMP__FIRST__MIR.n3 VGND 0.02492f $ **FLOATING
C1005 PGA__AMP__FIRST__MIR.n4 VGND 1.56028f $ **FLOATING
C1006 PGA__AMP__FIRST__MIR.n5 VGND 1.20858f $ **FLOATING
C1007 PGA__AMP__FIRST__MIR.n6 VGND 0.68789f $ **FLOATING
C1008 PGA__AMP__FIRST__MIR.t0 VGND 0.06666f $ **FLOATING
C1009 PGA__AMP__FIRST__MIR.n7 VGND 0.22738f $ **FLOATING
C1010 PGA__AMP__FIRST__MIR.n8 VGND 0.04013f $ **FLOATING
rmesh_equiv_0 amplified amplified.n0 22.8553
rmesh_equiv_1 amplified amplified.n1 33.9895
rmesh_equiv_10 amplified.n1 amplified.n2 13.2728
rmesh_equiv_100 bias_source__vcm_buffer__first__tail bias_source__vcm_buffer__first__tail.n1 19.837
rmesh_equiv_1000 vgnd vgnd.n2462 1906.2618614348219
rmesh_equiv_1001 vgnd vgnd.n2505 169.26347762818747
rmesh_equiv_1002 vgnd vgnd.n2507 8076.9525291074597
rmesh_equiv_1003 vgnd vgnd.n2509 164.35716309672193
rmesh_equiv_1004 vgnd vgnd.n2832 451.64471850897553
rmesh_equiv_1005 vgnd vgnd.n2836 102.80144207586741
rmesh_equiv_1006 vgnd vgnd.n324 20131.587290077056
rmesh_equiv_1007 vgnd vgnd.n325 314.88971566447253
rmesh_equiv_1008 vgnd vgnd.n3484 208.29365704048402
rmesh_equiv_1009 vgnd vgnd.n3585 28804.930282690133
rmesh_equiv_101 bias_source__vcm_buffer__first__tail bias_source__vcm_buffer__first__tail.n11 33.130400000000002
rmesh_equiv_1010 vgnd vgnd.n3588 345.15252243426198
rmesh_equiv_1011 vgnd vgnd.n421 14684.703893909062
rmesh_equiv_1012 vgnd vgnd.n425 1906.2618614348219
rmesh_equiv_1013 vgnd vgnd.n468 169.26347762818747
rmesh_equiv_1014 vgnd vgnd.n470 8076.9525291074597
rmesh_equiv_1015 vgnd vgnd.n472 164.35716309672193
rmesh_equiv_1016 vgnd vgnd.n5074 208.0412297699535
rmesh_equiv_1017 vgnd vgnd.n5293 2042.1952819578328
rmesh_equiv_1018 vgnd vgnd.n5295 2046.3456690316652
rmesh_equiv_1019 vgnd vgnd.n5299 390.94773216765265
rmesh_equiv_102 bias_source__vcm_buffer__first__tail bias_source__vcm_buffer__first__tail.n2 4.2590000000000003
rmesh_equiv_1020 vgnd vgnd.n5305 1212.2625826534827
rmesh_equiv_1021 vgnd vgnd.n5799 204.69373105483575
rmesh_equiv_1022 vgnd vgnd.n5920 5.2936667890588298
rmesh_equiv_1023 vgnd vgnd.n6209 228.73685587803939
rmesh_equiv_1024 vgnd vgnd.n7232 6040.7128853575805
rmesh_equiv_1025 vgnd vgnd.n7479 184.30129224820823
rmesh_equiv_1026 vgnd vgnd.n7481 1386.8716785767972
rmesh_equiv_1027 vgnd vgnd.n7483 192.75059406501836
rmesh_equiv_1028 vgnd vgnd.n7497 500.57021912155739
rmesh_equiv_1029 vgnd vgnd.n7951 277.96701720815685
rmesh_equiv_103 bias_source__vcm_buffer__first__tail bias_source__vcm_buffer__first__tail.n4 7.0733300000000003
rmesh_equiv_1030 vgnd vgnd.n826 7.8575476466424519
rmesh_equiv_1031 vgnd vgnd.n834 237.68186381734853
rmesh_equiv_1032 vgnd vgnd.n8413 204.68837759424193
rmesh_equiv_1033 vgnd vgnd.n8640 204.47713880802056
rmesh_equiv_1034 vgnd vgnd.n880 5.9124908221392936
rmesh_equiv_1035 vgnd vgnd.n8809 2424.2850663563167
rmesh_equiv_1036 vgnd vgnd.n8838 14180.626451959683
rmesh_equiv_1037 vgnd vgnd.n9076 3.6079264520200551
rmesh_equiv_1038 vgnd vgnd.n921 46376.753872898684
rmesh_equiv_1039 vgnd vgnd.n922 314.85610528291107
rmesh_equiv_104 bias_source__vcm_buffer__first__tail bias_source__vcm_buffer__first__tail.n6 26.391300000000001
rmesh_equiv_1040 vgnd vgnd.n9220 3.8291850735171113
rmesh_equiv_1041 vgnd vgnd.n9231 154.74030864859355
rmesh_equiv_1042 vgnd vgnd.n9262 5505.3323606691956
rmesh_equiv_1043 vgnd vgnd.n9291 244.12207082854025
rmesh_equiv_1044 vgnd vgnd.n9295 3347.276593170428
rmesh_equiv_1045 vgnd vgnd.n9297 9676.5824806788187
rmesh_equiv_1046 vgnd vgnd.n9299 51.356746910853694
rmesh_equiv_1047 vgnd vgnd.n9306 386.98448194402653
rmesh_equiv_1048 vgnd vgnd.n9308 558.47396222834993
rmesh_equiv_1049 vgnd vgnd.n9313 154.74030864859355
rmesh_equiv_105 bias_source__vcm_buffer__first__tail.n0 bias_source__vcm_buffer__first__tail.n10 13.389300000000002
rmesh_equiv_1050 vgnd vgnd.n9316 83.191395851024268
rmesh_equiv_1051 vgnd vgnd.t1 363.09120444099955
rmesh_equiv_1052 vgnd vgnd.t10 369.95887665750251
rmesh_equiv_1053 vgnd vgnd.t100 243.26382689255698
rmesh_equiv_1054 vgnd vgnd.t102 121.1513960012169
rmesh_equiv_1055 vgnd vgnd.t103 100.1652625364182
rmesh_equiv_1056 vgnd vgnd.t108 100.99548548480216
rmesh_equiv_1057 vgnd vgnd.t11 138.08002476725417
rmesh_equiv_1058 vgnd vgnd.t12 181.87961372000592
rmesh_equiv_1059 vgnd vgnd.t13 107.00128309769055
rmesh_equiv_106 bias_source__vcm_buffer__first__tail.n0 bias_source__vcm_buffer__first__tail.n9 0.75515399999999999
rmesh_equiv_1060 vgnd vgnd.t14 127.80560764384161
rmesh_equiv_1061 vgnd vgnd.t16 107.00128309769055
rmesh_equiv_1062 vgnd vgnd.t18 45.572440645030525
rmesh_equiv_1063 vgnd vgnd.t19 128.17573205746257
rmesh_equiv_1064 vgnd vgnd.t2 54.698708581992442
rmesh_equiv_1065 vgnd vgnd.t20 121.13176663164076
rmesh_equiv_1066 vgnd vgnd.t21 31.245685343560236
rmesh_equiv_1067 vgnd vgnd.t22 103.31164102710618
rmesh_equiv_1068 vgnd vgnd.t24 196.97056573206123
rmesh_equiv_1069 vgnd vgnd.t26 243.26382689255698
rmesh_equiv_107 bias_source__vcm_buffer__first__tail.n1 bias_source__vcm_buffer__first__tail.n3 14.189499999999999
rmesh_equiv_1070 vgnd vgnd.t27 141.34070578079491
rmesh_equiv_1071 vgnd vgnd.t28 428.31499399294466
rmesh_equiv_1072 vgnd vgnd.t29 363.09120444099955
rmesh_equiv_1073 vgnd vgnd.t3 128.05762296763226
rmesh_equiv_1074 vgnd vgnd.t30 243.26382689255698
rmesh_equiv_1075 vgnd vgnd.t31 158.65443387320187
rmesh_equiv_1076 vgnd vgnd.t32 363.09120444099949
rmesh_equiv_1077 vgnd vgnd.t33 159.62370418325688
rmesh_equiv_1078 vgnd vgnd.t36 120.3219049436149
rmesh_equiv_1079 vgnd vgnd.t37 93.491812915099288
rmesh_equiv_108 bias_source__vcm_buffer__first__tail.n1 bias_source__vcm_buffer__first__tail.t2 174.91200000000001
rmesh_equiv_1080 vgnd vgnd.t38 54.368627345884612
rmesh_equiv_1081 vgnd vgnd.t4 195.34436776888464
rmesh_equiv_1082 vgnd vgnd.t40 31.139005781455246
rmesh_equiv_1083 vgnd vgnd.t42 95.653505333379655
rmesh_equiv_1084 vgnd vgnd.t43 341.06413144487698
rmesh_equiv_1085 vgnd vgnd.t45 120.45793723496919
rmesh_equiv_1086 vgnd vgnd.t47 123.34344153905434
rmesh_equiv_1087 vgnd vgnd.t49 204.99807743979346
rmesh_equiv_1088 vgnd vgnd.t5 198.75878881757254
rmesh_equiv_1089 vgnd vgnd.t50 648.09241717451664
rmesh_equiv_109 bias_source__vcm_buffer__first__tail.n10 bias_source__vcm_buffer__first__tail.n11 14.121399999999998
rmesh_equiv_1090 vgnd vgnd.t51 121.50131373288043
rmesh_equiv_1091 vgnd vgnd.t52 63.574737382050721
rmesh_equiv_1092 vgnd vgnd.t55 103.99769907998501
rmesh_equiv_1093 vgnd vgnd.t57 147.51602831518758
rmesh_equiv_1094 vgnd vgnd.t58 23.519049552884823
rmesh_equiv_1095 vgnd vgnd.t59 125.85452076454909
rmesh_equiv_1096 vgnd vgnd.t6 363.09120444099955
rmesh_equiv_1097 vgnd vgnd.t60 126.4660372621554
rmesh_equiv_1098 vgnd vgnd.t61 76.012960935944122
rmesh_equiv_1099 vgnd vgnd.t63 243.26382689255698
rmesh_equiv_11 amplified.n1 amplified.n4 0.51338700000000004
rmesh_equiv_110 bias_source__vcm_buffer__first__tail.n10 bias_source__vcm_buffer__first__tail.t0 1.7404999999999999
rmesh_equiv_1100 vgnd vgnd.t64 139.5996034652602
rmesh_equiv_1101 vgnd vgnd.t65 363.09120444099949
rmesh_equiv_1102 vgnd vgnd.t66 164.87778573374098
rmesh_equiv_1103 vgnd vgnd.t69 120.09603914001922
rmesh_equiv_1104 vgnd vgnd.t7 141.86071018400168
rmesh_equiv_1105 vgnd vgnd.t70 243.26382689255698
rmesh_equiv_1106 vgnd vgnd.t71 121.48108913753876
rmesh_equiv_1107 vgnd vgnd.t72 95.430106563772156
rmesh_equiv_1108 vgnd vgnd.t75 121.58868909092384
rmesh_equiv_1109 vgnd vgnd.t76 119.64747890476615
rmesh_equiv_111 bias_source__vcm_buffer__first__tail.n11 bias_source__vcm_buffer__first__tail.n9 1.13588
rmesh_equiv_1110 vgnd vgnd.t79 194.82376927210626
rmesh_equiv_1111 vgnd vgnd.t80 243.26382689255698
rmesh_equiv_1112 vgnd vgnd.t81 138.55840591682974
rmesh_equiv_1113 vgnd vgnd.t82 128.62585019773704
rmesh_equiv_1114 vgnd vgnd.t83 128.822036320725
rmesh_equiv_1115 vgnd vgnd.t84 122.04692908677971
rmesh_equiv_1116 vgnd vgnd.t85 122.48195039103007
rmesh_equiv_1117 vgnd vgnd.t86 125.89557685332851
rmesh_equiv_1118 vgnd vgnd.t87 122.3345236932079
rmesh_equiv_1119 vgnd vgnd.t88 197.00859338300148
rmesh_equiv_112 bias_source__vcm_buffer__first__tail.n2 bias_source__vcm_buffer__first__tail.n3 3.0467200000000001
rmesh_equiv_1120 vgnd vgnd.t89 121.977811202436
rmesh_equiv_1121 vgnd vgnd.t9 194.77048597068571
rmesh_equiv_1122 vgnd vgnd.t90 288.31493160620693
rmesh_equiv_1123 vgnd vgnd.t91 240.31163708857935
rmesh_equiv_1124 vgnd vgnd.t92 125.85494359404377
rmesh_equiv_1125 vgnd vgnd.t94 104.91392158641757
rmesh_equiv_1126 vgnd vgnd.t95 181.09282826560971
rmesh_equiv_1127 vgnd vgnd.t96 105.05409137516762
rmesh_equiv_1128 vgnd vgnd.t97 196.47431462604362
rmesh_equiv_1129 vgnd vgnd.t99 243.26382689255698
rmesh_equiv_113 bias_source__vcm_buffer__first__tail.n2 bias_source__vcm_buffer__first__tail.t2 181.41
rmesh_equiv_1130 vgnd.n1018 vgnd.n1022 25511.409503124058
rmesh_equiv_1131 vgnd.n1018 vgnd.n1024 14722.075518278534
rmesh_equiv_1132 vgnd.n1018 vgnd.n1057 743.94079028835688
rmesh_equiv_1133 vgnd.n1018 vgnd.n1059 7559.8315777736861
rmesh_equiv_1134 vgnd.n1018 vgnd.n1065 35149.541188472424
rmesh_equiv_1135 vgnd.n1018 vgnd.n1067 697.55506021508097
rmesh_equiv_1136 vgnd.n1018 vgnd.n1069 352.8780814232282
rmesh_equiv_1137 vgnd.n1018 vgnd.n921 5407.105392814633
rmesh_equiv_1138 vgnd.n1018 vgnd.n922 8518.8704474047481
rmesh_equiv_1139 vgnd.n1018 vgnd.t15 3987.4343783077097
rmesh_equiv_114 bias_source__vcm_buffer__first__tail.n3 bias_source__vcm_buffer__first__tail.n8 23.220400000000001
rmesh_equiv_1140 vgnd.n1022 vgnd.n1024 11825.13468727295
rmesh_equiv_1141 vgnd.n1022 vgnd.n1057 7328.6908875007684
rmesh_equiv_1142 vgnd.n1022 vgnd.n1059 6656.4879854530382
rmesh_equiv_1143 vgnd.n1022 vgnd.n1065 472.41796020972009
rmesh_equiv_1144 vgnd.n1022 vgnd.n1067 641.99811307556843
rmesh_equiv_1145 vgnd.n1022 vgnd.n1069 15821.414558644625
rmesh_equiv_1146 vgnd.n1022 vgnd.n922 1105.8560684540639
rmesh_equiv_1147 vgnd.n1024 vgnd.n1057 1481.5396722393079
rmesh_equiv_1148 vgnd.n1024 vgnd.n1059 349.98269739429838
rmesh_equiv_1149 vgnd.n1024 vgnd.n1065 6656.4879854530382
rmesh_equiv_115 bias_source__vcm_buffer__first__tail.n4 bias_source__vcm_buffer__first__tail.n5 14.985300000000001
rmesh_equiv_1150 vgnd.n1024 vgnd.n1067 7328.6908875007684
rmesh_equiv_1151 vgnd.n1024 vgnd.n1069 4040.4316579407378
rmesh_equiv_1152 vgnd.n1024 vgnd.n921 1861.1415946970819
rmesh_equiv_1153 vgnd.n1024 vgnd.t15 608.40282688822072
rmesh_equiv_1154 vgnd.n1057 vgnd.n1059 1586.8066286580693
rmesh_equiv_1155 vgnd.n1057 vgnd.n1065 4125.3942666929725
rmesh_equiv_1156 vgnd.n1057 vgnd.n1067 263.01346535148565
rmesh_equiv_1157 vgnd.n1057 vgnd.n1069 2445.7040838288308
rmesh_equiv_1158 vgnd.n1057 vgnd.n921 12305.085349681374
rmesh_equiv_1159 vgnd.n1057 vgnd.t15 57.720611180958343
rmesh_equiv_116 bias_source__vcm_buffer__first__tail.n4 bias_source__vcm_buffer__first__tail.n7 0.24337299999999998
rmesh_equiv_1160 vgnd.n1059 vgnd.n1065 51.600789359185825
rmesh_equiv_1161 vgnd.n1059 vgnd.n1067 4125.3942666929725
rmesh_equiv_1162 vgnd.n1059 vgnd.n1069 1118.8989765236236
rmesh_equiv_1163 vgnd.n1059 vgnd.n921 526.22552770447749
rmesh_equiv_1164 vgnd.n1059 vgnd.t15 1922.4930724746139
rmesh_equiv_1165 vgnd.n1065 vgnd.n1067 1703.5636641986459
rmesh_equiv_1166 vgnd.n1065 vgnd.n1069 233783.07302186851
rmesh_equiv_1167 vgnd.n1065 vgnd.n922 2895.8018898371597
rmesh_equiv_1168 vgnd.n1067 vgnd.n1069 1215.9640626449034
rmesh_equiv_1169 vgnd.n1067 vgnd.n922 369.59779367798893
rmesh_equiv_117 bias_source__vcm_buffer__first__tail.n5 bias_source__vcm_buffer__first__tail.n6 11.248699999999999
rmesh_equiv_1170 vgnd.n1069 vgnd.n921 680.81051771011187
rmesh_equiv_1171 vgnd.n1069 vgnd.n922 1540.0362363369115
rmesh_equiv_1172 vgnd.n1069 vgnd.t15 1277.3195072841893
rmesh_equiv_1173 vgnd.n1425 vgnd.n1429 59.059716043503236
rmesh_equiv_1174 vgnd.n1425 vgnd.n880 30.996774535785789
rmesh_equiv_1175 vgnd.n1425 vgnd.t0 13.509636962416895
rmesh_equiv_1176 vgnd.n1425 vgnd.t105 31.424561091416468
rmesh_equiv_1177 vgnd.n1425 vgnd.t34 5.95932
rmesh_equiv_1178 vgnd.n1425 vgnd.t49 13.894792333942394
rmesh_equiv_1179 vgnd.n1425 vgnd.t61 38.039141231474659
rmesh_equiv_118 bias_source__vcm_buffer__first__tail.n5 bias_source__vcm_buffer__first__tail.t1 1.7404999999999999
rmesh_equiv_1180 vgnd.n1425 vgnd.t77 84.748370920037502
rmesh_equiv_1181 vgnd.n1429 vgnd.n1433 59.059716043503236
rmesh_equiv_1182 vgnd.n1429 vgnd.t0 84.748370920037502
rmesh_equiv_1183 vgnd.n1429 vgnd.t104 84.748370920037502
rmesh_equiv_1184 vgnd.n1429 vgnd.t105 31.424561091416468
rmesh_equiv_1185 vgnd.n1429 vgnd.t25 13.509636962416895
rmesh_equiv_1186 vgnd.n1429 vgnd.t56 31.424561091416468
rmesh_equiv_1187 vgnd.n1429 vgnd.t77 13.509636962416895
rmesh_equiv_1188 vgnd.n1429 vgnd.t8 5.95932
rmesh_equiv_1189 vgnd.n1433 vgnd.n5920 1203.399429394306
rmesh_equiv_119 bias_source__vcm_buffer__first__tail.n6 bias_source__vcm_buffer__first__tail.n7 3.1501399999999999
rmesh_equiv_1190 vgnd.n1433 vgnd.t104 13.509636962416895
rmesh_equiv_1191 vgnd.n1433 vgnd.t21 12.570242449070671
rmesh_equiv_1192 vgnd.n1433 vgnd.t23 5.95932
rmesh_equiv_1193 vgnd.n1433 vgnd.t25 84.748370920037502
rmesh_equiv_1194 vgnd.n1433 vgnd.t42 37197.117372864843
rmesh_equiv_1195 vgnd.n1433 vgnd.t56 31.424561091416468
rmesh_equiv_1196 vgnd.n1433 vgnd.t7 3760.1305570672394
rmesh_equiv_1197 vgnd.n1433 vgnd.t72 28197.718422609883
rmesh_equiv_1198 vgnd.n1446 vgnd.n1451 24504.036490676062
rmesh_equiv_1199 vgnd.n1446 vgnd.n1455 11186.003991199468
rmesh_equiv_12 amplified.n10 amplified.n14 4.3961699999999997
rmesh_equiv_120 bias_source__vcm_buffer__first__tail.n7 bias_source__vcm_buffer__first__tail.n8 21.631799999999998
rmesh_equiv_1200 vgnd.n1446 vgnd.n7471 14382.807569962499
rmesh_equiv_1201 vgnd.n1446 vgnd.n7475 6987.764894317459
rmesh_equiv_1202 vgnd.n1446 vgnd.n7479 5944.5572365148973
rmesh_equiv_1203 vgnd.n1446 vgnd.n7481 463.26906196456008
rmesh_equiv_1204 vgnd.n1446 vgnd.n7483 377.10656255605375
rmesh_equiv_1205 vgnd.n1446 vgnd.n7497 2500.229859830732
rmesh_equiv_1206 vgnd.n1451 vgnd.n1455 45924.806807008987
rmesh_equiv_1207 vgnd.n1451 vgnd.n1459 11186.003991199468
rmesh_equiv_1208 vgnd.n1451 vgnd.n7467 1167.7590376831508
rmesh_equiv_1209 vgnd.n1451 vgnd.n7469 6662.9740996152623
rmesh_equiv_121 bias_source__vcm_buffer__first__tail.n8 bias_source__vcm_buffer__first__tail.n9 20.7212
rmesh_equiv_1210 vgnd.n1451 vgnd.n7471 118098.94927850571
rmesh_equiv_1211 vgnd.n1451 vgnd.n7475 688.16510816659832
rmesh_equiv_1212 vgnd.n1451 vgnd.n7479 429.52525360711979
rmesh_equiv_1213 vgnd.n1451 vgnd.n7481 659.37164367467096
rmesh_equiv_1214 vgnd.n1451 vgnd.n7483 28595.87014825286
rmesh_equiv_1215 vgnd.n1451 vgnd.n7497 22286.718482255554
rmesh_equiv_1216 vgnd.n1455 vgnd.n1459 48588.28691143875
rmesh_equiv_1217 vgnd.n1455 vgnd.n1463 11186.003991199468
rmesh_equiv_1218 vgnd.n1455 vgnd.n7459 14382.807569962499
rmesh_equiv_1219 vgnd.n1455 vgnd.n7463 6987.764894317459
rmesh_equiv_122 bias_source__vcm_buffer__pre bias_source__vcm_buffer__pre.n0 6.3200399999999997
rmesh_equiv_1220 vgnd.n1455 vgnd.n7467 37385.342303313126
rmesh_equiv_1221 vgnd.n1455 vgnd.n7469 698.22333417298671
rmesh_equiv_1222 vgnd.n1455 vgnd.n7471 441.63996879204274
rmesh_equiv_1223 vgnd.n1455 vgnd.n7475 688.16510816659832
rmesh_equiv_1224 vgnd.n1455 vgnd.n7479 118098.94927850571
rmesh_equiv_1225 vgnd.n1455 vgnd.n7481 6662.9740996152623
rmesh_equiv_1226 vgnd.n1455 vgnd.n7483 1167.7590376831508
rmesh_equiv_1227 vgnd.n1459 vgnd.n1463 45924.806807008987
rmesh_equiv_1228 vgnd.n1459 vgnd.n1467 11186.003991199468
rmesh_equiv_1229 vgnd.n1459 vgnd.n7455 1167.7590376831508
rmesh_equiv_123 bias_source__vcm_buffer__pre bias_source__vcm_buffer__pre.n1 3.4389368698468692
rmesh_equiv_1230 vgnd.n1459 vgnd.n7457 6662.9740996152623
rmesh_equiv_1231 vgnd.n1459 vgnd.n7459 118098.94927850571
rmesh_equiv_1232 vgnd.n1459 vgnd.n7463 688.16510816659832
rmesh_equiv_1233 vgnd.n1459 vgnd.n7467 441.63996879204274
rmesh_equiv_1234 vgnd.n1459 vgnd.n7469 698.22333417298671
rmesh_equiv_1235 vgnd.n1459 vgnd.n7471 37385.342303313126
rmesh_equiv_1236 vgnd.n1459 vgnd.n7475 6987.764894317459
rmesh_equiv_1237 vgnd.n1459 vgnd.n7479 14382.807569962499
rmesh_equiv_1238 vgnd.n1463 vgnd.n1467 48588.28691143875
rmesh_equiv_1239 vgnd.n1463 vgnd.n1471 11186.003991199468
rmesh_equiv_124 bias_source__vcm_buffer__pre bias_source__vcm_buffer__pre.n10 33.130400000000002
rmesh_equiv_1240 vgnd.n1463 vgnd.n7447 14382.807569962499
rmesh_equiv_1241 vgnd.n1463 vgnd.n7451 6987.764894317459
rmesh_equiv_1242 vgnd.n1463 vgnd.n7455 37385.342303313126
rmesh_equiv_1243 vgnd.n1463 vgnd.n7457 698.22333417298671
rmesh_equiv_1244 vgnd.n1463 vgnd.n7459 441.63996879204274
rmesh_equiv_1245 vgnd.n1463 vgnd.n7463 688.16510816659832
rmesh_equiv_1246 vgnd.n1463 vgnd.n7467 118098.94927850571
rmesh_equiv_1247 vgnd.n1463 vgnd.n7469 6662.9740996152623
rmesh_equiv_1248 vgnd.n1463 vgnd.n7471 1167.7590376831508
rmesh_equiv_1249 vgnd.n1467 vgnd.n1471 45924.806807008987
rmesh_equiv_125 bias_source__vcm_buffer__pre bias_source__vcm_buffer__pre.n2 5.3798000000000004
rmesh_equiv_1250 vgnd.n1467 vgnd.n1475 11186.003991199468
rmesh_equiv_1251 vgnd.n1467 vgnd.n7443 1167.7590376831508
rmesh_equiv_1252 vgnd.n1467 vgnd.n7445 6662.9740996152623
rmesh_equiv_1253 vgnd.n1467 vgnd.n7447 118098.94927850571
rmesh_equiv_1254 vgnd.n1467 vgnd.n7451 688.16510816659832
rmesh_equiv_1255 vgnd.n1467 vgnd.n7455 441.63996879204274
rmesh_equiv_1256 vgnd.n1467 vgnd.n7457 698.22333417298671
rmesh_equiv_1257 vgnd.n1467 vgnd.n7459 37385.342303313126
rmesh_equiv_1258 vgnd.n1467 vgnd.n7463 6987.764894317459
rmesh_equiv_1259 vgnd.n1467 vgnd.n7467 14382.807569962499
rmesh_equiv_126 bias_source__vcm_buffer__pre bias_source__vcm_buffer__pre.n3 30.1326
rmesh_equiv_1260 vgnd.n1471 vgnd.n1475 48588.28691143875
rmesh_equiv_1261 vgnd.n1471 vgnd.n1479 11186.003991199468
rmesh_equiv_1262 vgnd.n1471 vgnd.n7435 14382.807569962499
rmesh_equiv_1263 vgnd.n1471 vgnd.n7439 6987.764894317459
rmesh_equiv_1264 vgnd.n1471 vgnd.n7443 37385.342303313126
rmesh_equiv_1265 vgnd.n1471 vgnd.n7445 698.22333417298671
rmesh_equiv_1266 vgnd.n1471 vgnd.n7447 441.63996879204274
rmesh_equiv_1267 vgnd.n1471 vgnd.n7451 688.16510816659832
rmesh_equiv_1268 vgnd.n1471 vgnd.n7455 118098.94927850571
rmesh_equiv_1269 vgnd.n1471 vgnd.n7457 6662.9740996152623
rmesh_equiv_127 bias_source__vcm_buffer__pre bias_source__vcm_buffer__pre.n4 4.8770699999999998
rmesh_equiv_1270 vgnd.n1471 vgnd.n7459 1167.7590376831508
rmesh_equiv_1271 vgnd.n1475 vgnd.n1479 45924.806807008987
rmesh_equiv_1272 vgnd.n1475 vgnd.n1483 11186.003991199468
rmesh_equiv_1273 vgnd.n1475 vgnd.n7431 1167.7590376831508
rmesh_equiv_1274 vgnd.n1475 vgnd.n7433 6662.9740996152623
rmesh_equiv_1275 vgnd.n1475 vgnd.n7435 118098.94927850571
rmesh_equiv_1276 vgnd.n1475 vgnd.n7439 688.16510816659832
rmesh_equiv_1277 vgnd.n1475 vgnd.n7443 441.63996879204274
rmesh_equiv_1278 vgnd.n1475 vgnd.n7445 698.22333417298671
rmesh_equiv_1279 vgnd.n1475 vgnd.n7447 37385.342303313126
rmesh_equiv_128 bias_source__vcm_buffer__pre bias_source__vcm_buffer__pre.n5 22.8553
rmesh_equiv_1280 vgnd.n1475 vgnd.n7451 6987.764894317459
rmesh_equiv_1281 vgnd.n1475 vgnd.n7455 14382.807569962499
rmesh_equiv_1282 vgnd.n1479 vgnd.n1483 48588.28691143875
rmesh_equiv_1283 vgnd.n1479 vgnd.n1487 11186.003991199468
rmesh_equiv_1284 vgnd.n1479 vgnd.n7423 14382.807569962499
rmesh_equiv_1285 vgnd.n1479 vgnd.n7427 6987.764894317459
rmesh_equiv_1286 vgnd.n1479 vgnd.n7431 37385.342303313126
rmesh_equiv_1287 vgnd.n1479 vgnd.n7433 698.22333417298671
rmesh_equiv_1288 vgnd.n1479 vgnd.n7435 441.63996879204274
rmesh_equiv_1289 vgnd.n1479 vgnd.n7439 688.16510816659832
rmesh_equiv_129 bias_source__vcm_buffer__pre bias_source__vcm_buffer__pre.t2 1054.8499999999999
rmesh_equiv_1290 vgnd.n1479 vgnd.n7443 118098.94927850571
rmesh_equiv_1291 vgnd.n1479 vgnd.n7445 6662.9740996152623
rmesh_equiv_1292 vgnd.n1479 vgnd.n7447 1167.7590376831508
rmesh_equiv_1293 vgnd.n1483 vgnd.n1487 45924.806807008987
rmesh_equiv_1294 vgnd.n1483 vgnd.n1491 11186.003991199468
rmesh_equiv_1295 vgnd.n1483 vgnd.n7419 1167.7590376831508
rmesh_equiv_1296 vgnd.n1483 vgnd.n7421 6662.9740996152623
rmesh_equiv_1297 vgnd.n1483 vgnd.n7423 118098.94927850571
rmesh_equiv_1298 vgnd.n1483 vgnd.n7427 688.16510816659832
rmesh_equiv_1299 vgnd.n1483 vgnd.n7431 441.63996879204274
rmesh_equiv_13 amplified.n10 amplified.n9 1.57735
rmesh_equiv_130 bias_source__vcm_buffer__pre bias_source__vcm_buffer__pre.t3 0.00141837
rmesh_equiv_1300 vgnd.n1483 vgnd.n7433 698.22333417298671
rmesh_equiv_1301 vgnd.n1483 vgnd.n7435 37385.342303313126
rmesh_equiv_1302 vgnd.n1483 vgnd.n7439 6987.764894317459
rmesh_equiv_1303 vgnd.n1483 vgnd.n7443 14382.807569962499
rmesh_equiv_1304 vgnd.n1487 vgnd.n1491 48021.320883642591
rmesh_equiv_1305 vgnd.n1487 vgnd.n7405 19980.829208443676
rmesh_equiv_1306 vgnd.n1487 vgnd.n7407 68011.522972554812
rmesh_equiv_1307 vgnd.n1487 vgnd.n7415 6384.8704938487972
rmesh_equiv_1308 vgnd.n1487 vgnd.n7419 37385.342303313126
rmesh_equiv_1309 vgnd.n1487 vgnd.n7421 696.59413294954948
rmesh_equiv_131 bias_source__vcm_buffer__pre bias_source__vcm_buffer__pre.t4 0.00141837
rmesh_equiv_1310 vgnd.n1487 vgnd.n7423 428.29817328466106
rmesh_equiv_1311 vgnd.n1487 vgnd.n7427 688.16510816659832
rmesh_equiv_1312 vgnd.n1487 vgnd.n7431 118098.94927850571
rmesh_equiv_1313 vgnd.n1487 vgnd.n7433 6662.9740996152623
rmesh_equiv_1314 vgnd.n1487 vgnd.n7435 1167.7590376831508
rmesh_equiv_1315 vgnd.n1487 vgnd.t48 220338.38858270209
rmesh_equiv_1316 vgnd.n1491 vgnd.n7232 73876.512949049109
rmesh_equiv_1317 vgnd.n1491 vgnd.n7389 2261.5435268415804
rmesh_equiv_1318 vgnd.n1491 vgnd.n7391 19067.37577721263
rmesh_equiv_1319 vgnd.n1491 vgnd.n7405 164064.97297221556
rmesh_equiv_132 bias_source__vcm_buffer__pre bias_source__vcm_buffer__pre.t5 0.00141837
rmesh_equiv_1320 vgnd.n1491 vgnd.n7407 558450.73104253574
rmesh_equiv_1321 vgnd.n1491 vgnd.n7415 716.65023425465483
rmesh_equiv_1322 vgnd.n1491 vgnd.n7419 356.27394177121471
rmesh_equiv_1323 vgnd.n1491 vgnd.n7421 698.02451272808287
rmesh_equiv_1324 vgnd.n1491 vgnd.n7423 28297.722198596457
rmesh_equiv_1325 vgnd.n1491 vgnd.n7427 6987.764894317459
rmesh_equiv_1326 vgnd.n1491 vgnd.n7431 14382.807569962499
rmesh_equiv_1327 vgnd.n1491 vgnd.t48 21283.176665169452
rmesh_equiv_1328 vgnd.n1833 vgnd.n2025 22615762934.928524
rmesh_equiv_1329 vgnd.n1833 vgnd.n2026 451937952145.44904
rmesh_equiv_133 bias_source__vcm_buffer__pre.n0 bias_source__vcm_buffer__pre.n8 0.75515399999999999
rmesh_equiv_1330 vgnd.n1833 vgnd.n6209 22777777072.03397
rmesh_equiv_1331 vgnd.n1833 vgnd.n7497 353839938.15519649
rmesh_equiv_1332 vgnd.n1833 vgnd.t19 5802096.7511593066
rmesh_equiv_1333 vgnd.n1833 vgnd.t4 80.595013236565009
rmesh_equiv_1334 vgnd.n1833 vgnd.t71 12062115.766783303
rmesh_equiv_1335 vgnd.n1833 vgnd.t83 615.43825656373735
rmesh_equiv_1336 vgnd.n1833 vgnd.t84 7633.4845418126861
rmesh_equiv_1337 vgnd.n1833 vgnd.t85 59626.009992200197
rmesh_equiv_1338 vgnd.n2025 vgnd.n2026 223224.30711981934
rmesh_equiv_1339 vgnd.n2025 vgnd.n2126 5407.105392814633
rmesh_equiv_134 bias_source__vcm_buffer__pre.n0 bias_source__vcm_buffer__pre.n9 13.389300000000002
rmesh_equiv_1340 vgnd.n2025 vgnd.n2132 1861.1415946970819
rmesh_equiv_1341 vgnd.n2025 vgnd.n2165 12305.085349681374
rmesh_equiv_1342 vgnd.n2025 vgnd.n2167 526.22552770447749
rmesh_equiv_1343 vgnd.n2025 vgnd.n2177 680.81051771011187
rmesh_equiv_1344 vgnd.n2025 vgnd.n6209 11250.556587462936
rmesh_equiv_1345 vgnd.n2025 vgnd.t4 3013410918.7289581
rmesh_equiv_1346 vgnd.n2025 vgnd.t41 884.1291348700031
rmesh_equiv_1347 vgnd.n2025 vgnd.t71 9887.4987323029836
rmesh_equiv_1348 vgnd.n2025 vgnd.t84 27205186.626683429
rmesh_equiv_1349 vgnd.n2026 vgnd.n2126 8518.8704474047481
rmesh_equiv_135 bias_source__vcm_buffer__pre.n1 bias_source__vcm_buffer__pre.n2 4.1529499999999997
rmesh_equiv_1350 vgnd.n2026 vgnd.n2130 1105.8560684540639
rmesh_equiv_1351 vgnd.n2026 vgnd.n2173 2895.8018898371597
rmesh_equiv_1352 vgnd.n2026 vgnd.n2175 369.59779367798893
rmesh_equiv_1353 vgnd.n2026 vgnd.n2177 1540.0362363369115
rmesh_equiv_1354 vgnd.n2026 vgnd.n6209 10964.234845719111
rmesh_equiv_1355 vgnd.n2026 vgnd.t4 60217944603.574593
rmesh_equiv_1356 vgnd.n2026 vgnd.t71 197585.01810329733
rmesh_equiv_1357 vgnd.n2026 vgnd.t84 543649859.04628396
rmesh_equiv_1358 vgnd.n2126 vgnd.n2130 25511.409503124058
rmesh_equiv_1359 vgnd.n2126 vgnd.n2132 14722.075518278534
rmesh_equiv_136 bias_source__vcm_buffer__pre.n10 bias_source__vcm_buffer__pre.n8 1.13588
rmesh_equiv_1360 vgnd.n2126 vgnd.n2165 743.94079028835688
rmesh_equiv_1361 vgnd.n2126 vgnd.n2167 7559.8315777736861
rmesh_equiv_1362 vgnd.n2126 vgnd.n2173 35149.541188472424
rmesh_equiv_1363 vgnd.n2126 vgnd.n2175 697.55506021508097
rmesh_equiv_1364 vgnd.n2126 vgnd.n2177 352.8780814232282
rmesh_equiv_1365 vgnd.n2126 vgnd.t41 3987.4343783077097
rmesh_equiv_1366 vgnd.n2130 vgnd.n2132 11825.13468727295
rmesh_equiv_1367 vgnd.n2130 vgnd.n2165 7328.6908875007684
rmesh_equiv_1368 vgnd.n2130 vgnd.n2167 6656.4879854530382
rmesh_equiv_1369 vgnd.n2130 vgnd.n2173 472.41796020972009
rmesh_equiv_137 bias_source__vcm_buffer__pre.n10 bias_source__vcm_buffer__pre.n9 14.121399999999998
rmesh_equiv_1370 vgnd.n2130 vgnd.n2175 641.99811307556843
rmesh_equiv_1371 vgnd.n2130 vgnd.n2177 15821.414558644625
rmesh_equiv_1372 vgnd.n2132 vgnd.n2165 1481.5396722393079
rmesh_equiv_1373 vgnd.n2132 vgnd.n2167 349.98269739429838
rmesh_equiv_1374 vgnd.n2132 vgnd.n2173 6656.4879854530382
rmesh_equiv_1375 vgnd.n2132 vgnd.n2175 7328.6908875007684
rmesh_equiv_1376 vgnd.n2132 vgnd.n2177 4040.4316579407378
rmesh_equiv_1377 vgnd.n2132 vgnd.t41 608.40282688822072
rmesh_equiv_1378 vgnd.n2165 vgnd.n2167 1586.8066286580693
rmesh_equiv_1379 vgnd.n2165 vgnd.n2173 4125.3942666929725
rmesh_equiv_138 bias_source__vcm_buffer__pre.n2 bias_source__vcm_buffer__pre.n3 3.1113099999999996
rmesh_equiv_1380 vgnd.n2165 vgnd.n2175 263.01346535148565
rmesh_equiv_1381 vgnd.n2165 vgnd.n2177 2445.7040838288308
rmesh_equiv_1382 vgnd.n2165 vgnd.t41 57.720611180958343
rmesh_equiv_1383 vgnd.n2167 vgnd.n2173 51.600789359185825
rmesh_equiv_1384 vgnd.n2167 vgnd.n2175 4125.3942666929725
rmesh_equiv_1385 vgnd.n2167 vgnd.n2177 1118.8989765236236
rmesh_equiv_1386 vgnd.n2167 vgnd.t41 1922.4930724746139
rmesh_equiv_1387 vgnd.n2173 vgnd.n2175 1703.5636641986459
rmesh_equiv_1388 vgnd.n2173 vgnd.n2177 233783.07302186851
rmesh_equiv_1389 vgnd.n2175 vgnd.n2177 1215.9640626449034
rmesh_equiv_139 bias_source__vcm_buffer__pre.n3 bias_source__vcm_buffer__pre.n7 2.2512099999999999
rmesh_equiv_1390 vgnd.n2177 vgnd.t41 1277.3195072841893
rmesh_equiv_1391 vgnd.n2314 vgnd.n2361 153381.18521930894
rmesh_equiv_1392 vgnd.n2314 vgnd.n2362 2796014.0193906794
rmesh_equiv_1393 vgnd.n2314 vgnd.n5799 1778907.1439854838
rmesh_equiv_1394 vgnd.n2314 vgnd.n6209 936430588.98372555
rmesh_equiv_1395 vgnd.n2314 vgnd.t12 82.21118096454974
rmesh_equiv_1396 vgnd.n2314 vgnd.t69 1121275.2903626247
rmesh_equiv_1397 vgnd.n2314 vgnd.t88 231204.33890605983
rmesh_equiv_1398 vgnd.n2314 vgnd.t89 11128.485425524612
rmesh_equiv_1399 vgnd.n2314 vgnd.t9 121707762.55801237
rmesh_equiv_14 amplified.n10 amplified.t5 22.304099999999998
rmesh_equiv_140 bias_source__vcm_buffer__pre.n4 bias_source__vcm_buffer__pre.n6 2.4407800000000002
rmesh_equiv_1400 vgnd.n2361 vgnd.n2362 202631.17410013539
rmesh_equiv_1401 vgnd.n2361 vgnd.n2458 5407.105392814633
rmesh_equiv_1402 vgnd.n2361 vgnd.n2464 1861.1415946970819
rmesh_equiv_1403 vgnd.n2361 vgnd.n2497 12305.085349681374
rmesh_equiv_1404 vgnd.n2361 vgnd.n2499 526.22552770447749
rmesh_equiv_1405 vgnd.n2361 vgnd.n2509 680.81051771011187
rmesh_equiv_1406 vgnd.n2361 vgnd.n5799 128919.96989323062
rmesh_equiv_1407 vgnd.n2361 vgnd.t12 10347.78803346219
rmesh_equiv_1408 vgnd.n2361 vgnd.t88 16755.712355043954
rmesh_equiv_1409 vgnd.n2361 vgnd.t93 884.1291348700031
rmesh_equiv_141 bias_source__vcm_buffer__pre.n4 bias_source__vcm_buffer__pre.t1 387.11000000000001
rmesh_equiv_1410 vgnd.n2362 vgnd.n2458 8518.8704474047481
rmesh_equiv_1411 vgnd.n2362 vgnd.n2462 1105.8560684540639
rmesh_equiv_1412 vgnd.n2362 vgnd.n2505 2895.8018898371597
rmesh_equiv_1413 vgnd.n2362 vgnd.n2507 369.59779367798893
rmesh_equiv_1414 vgnd.n2362 vgnd.n2509 1540.0362363369115
rmesh_equiv_1415 vgnd.n2362 vgnd.n5799 125635.47034379246
rmesh_equiv_1416 vgnd.n2362 vgnd.t12 188631.74365144435
rmesh_equiv_1417 vgnd.n2362 vgnd.t88 16328.826359598595
rmesh_equiv_1418 vgnd.n24 vgnd.n8838 7857.2578680854758
rmesh_equiv_1419 vgnd.n24 vgnd.n9231 220242.93527936481
rmesh_equiv_142 bias_source__vcm_buffer__pre.n5 bias_source__vcm_buffer__pre.n6 11.4361
rmesh_equiv_1420 vgnd.n24 vgnd.n9237 858.22891074865186
rmesh_equiv_1421 vgnd.n24 vgnd.n9238 5582.511579753691
rmesh_equiv_1422 vgnd.n24 vgnd.n9240 3759.8454058512039
rmesh_equiv_1423 vgnd.n24 vgnd.n9241 1286.9971594202066
rmesh_equiv_1424 vgnd.n24 vgnd.n9308 6020.2309147451588
rmesh_equiv_1425 vgnd.n24 vgnd.n9313 435.32586050350346
rmesh_equiv_1426 vgnd.n24 vgnd.n9316 646.31033015336197
rmesh_equiv_1427 vgnd.n2458 vgnd.n2462 25511.409503124058
rmesh_equiv_1428 vgnd.n2458 vgnd.n2464 14722.075518278534
rmesh_equiv_1429 vgnd.n2458 vgnd.n2497 743.94079028835688
rmesh_equiv_143 bias_source__vcm_buffer__pre.n5 bias_source__vcm_buffer__pre.t1 381.113
rmesh_equiv_1430 vgnd.n2458 vgnd.n2499 7559.8315777736861
rmesh_equiv_1431 vgnd.n2458 vgnd.n2505 35149.541188472424
rmesh_equiv_1432 vgnd.n2458 vgnd.n2507 697.55506021508097
rmesh_equiv_1433 vgnd.n2458 vgnd.n2509 352.8780814232282
rmesh_equiv_1434 vgnd.n2458 vgnd.t93 3987.4343783077097
rmesh_equiv_1435 vgnd.n2462 vgnd.n2464 11825.13468727295
rmesh_equiv_1436 vgnd.n2462 vgnd.n2497 7328.6908875007684
rmesh_equiv_1437 vgnd.n2462 vgnd.n2499 6656.4879854530382
rmesh_equiv_1438 vgnd.n2462 vgnd.n2505 472.41796020972009
rmesh_equiv_1439 vgnd.n2462 vgnd.n2507 641.99811307556843
rmesh_equiv_144 bias_source__vcm_buffer__pre.n6 bias_source__vcm_buffer__pre.n7 20.304500000000001
rmesh_equiv_1440 vgnd.n2462 vgnd.n2509 15821.414558644625
rmesh_equiv_1441 vgnd.n2464 vgnd.n2497 1481.5396722393079
rmesh_equiv_1442 vgnd.n2464 vgnd.n2499 349.98269739429838
rmesh_equiv_1443 vgnd.n2464 vgnd.n2505 6656.4879854530382
rmesh_equiv_1444 vgnd.n2464 vgnd.n2507 7328.6908875007684
rmesh_equiv_1445 vgnd.n2464 vgnd.n2509 4040.4316579407378
rmesh_equiv_1446 vgnd.n2464 vgnd.t93 608.40282688822072
rmesh_equiv_1447 vgnd.n2497 vgnd.n2499 1586.8066286580693
rmesh_equiv_1448 vgnd.n2497 vgnd.n2505 4125.3942666929725
rmesh_equiv_1449 vgnd.n2497 vgnd.n2507 263.01346535148565
rmesh_equiv_145 bias_source__vcm_buffer__pre.n7 bias_source__vcm_buffer__pre.n8 23.079299999999996
rmesh_equiv_1450 vgnd.n2497 vgnd.n2509 2445.7040838288308
rmesh_equiv_1451 vgnd.n2497 vgnd.t93 57.720611180958343
rmesh_equiv_1452 vgnd.n2499 vgnd.n2505 51.600789359185825
rmesh_equiv_1453 vgnd.n2499 vgnd.n2507 4125.3942666929725
rmesh_equiv_1454 vgnd.n2499 vgnd.n2509 1118.8989765236236
rmesh_equiv_1455 vgnd.n2499 vgnd.t93 1922.4930724746139
rmesh_equiv_1456 vgnd.n2505 vgnd.n2507 1703.5636641986459
rmesh_equiv_1457 vgnd.n2505 vgnd.n2509 233783.07302186851
rmesh_equiv_1458 vgnd.n2507 vgnd.n2509 1215.9640626449034
rmesh_equiv_1459 vgnd.n2509 vgnd.t93 1277.3195072841893
rmesh_equiv_146 bias_source__vcm_buffer__pre.n9 bias_source__vcm_buffer__pre.t0 1.7404999999999999
rmesh_equiv_1460 vgnd.n2832 vgnd.n2836 59.059716043503236
rmesh_equiv_1461 vgnd.n2832 vgnd.n5920 221.64157617275319
rmesh_equiv_1462 vgnd.n2832 vgnd.t17 31.424561091416468
rmesh_equiv_1463 vgnd.n2832 vgnd.t18 176.75831090537613
rmesh_equiv_1464 vgnd.n2832 vgnd.t22 69.953420930857448
rmesh_equiv_1465 vgnd.n2832 vgnd.t50 13.437419031084769
rmesh_equiv_1466 vgnd.n2832 vgnd.t53 84.748370920037502
rmesh_equiv_1467 vgnd.n2832 vgnd.t62 5.95932
rmesh_equiv_1468 vgnd.n2832 vgnd.t78 13.509636962416895
rmesh_equiv_1469 vgnd.n2832 vgnd.t91 30.399651702676195
rmesh_equiv_147 bias_source__vcm_raw bias_source__vcm_raw.n1 5.2670000000000003
rmesh_equiv_1470 vgnd.n2832 vgnd.t94 86811.788418070122
rmesh_equiv_1471 vgnd.n2836 vgnd.t17 31.424561091416468
rmesh_equiv_1472 vgnd.n2836 vgnd.t2 30.08568518329924
rmesh_equiv_1473 vgnd.n2836 vgnd.t37 277728.91537244257
rmesh_equiv_1474 vgnd.n2836 vgnd.t52 823.43760966494574
rmesh_equiv_1475 vgnd.n2836 vgnd.t53 13.509636962416895
rmesh_equiv_1476 vgnd.n2836 vgnd.t57 13.414474340513955
rmesh_equiv_1477 vgnd.n2836 vgnd.t58 66.263057398355144
rmesh_equiv_1478 vgnd.n2836 vgnd.t67 5.95932
rmesh_equiv_1479 vgnd.n2836 vgnd.t78 84.748370920037502
rmesh_equiv_148 bias_source__vcm_raw bias_source__vcm_raw.n10 5.2670000000000003
rmesh_equiv_1480 vgnd.n324 vgnd.n325 202625.13765930082
rmesh_equiv_1481 vgnd.n324 vgnd.n421 5407.105392814633
rmesh_equiv_1482 vgnd.n324 vgnd.n427 1861.1415946970819
rmesh_equiv_1483 vgnd.n324 vgnd.n460 12305.085349681374
rmesh_equiv_1484 vgnd.n324 vgnd.n462 526.22552770447749
rmesh_equiv_1485 vgnd.n324 vgnd.n472 680.81051771011187
rmesh_equiv_1486 vgnd.n324 vgnd.n8413 128916.12933032557
rmesh_equiv_1487 vgnd.n324 vgnd.n8640 1798580818.0886514
rmesh_equiv_1488 vgnd.n324 vgnd.t102 9838.7198654645144
rmesh_equiv_1489 vgnd.n324 vgnd.t107 884.1291348700031
rmesh_equiv_149 bias_source__vcm_raw bias_source__vcm_raw.n11 5.2670000000000003
rmesh_equiv_1490 vgnd.n324 vgnd.t24 16755.213197563757
rmesh_equiv_1491 vgnd.n324 vgnd.t3 27105884.346989121
rmesh_equiv_1492 vgnd.n325 vgnd.n421 8518.8704474047481
rmesh_equiv_1493 vgnd.n325 vgnd.n425 1105.8560684540639
rmesh_equiv_1494 vgnd.n325 vgnd.n468 2895.8018898371597
rmesh_equiv_1495 vgnd.n325 vgnd.n470 369.59779367798893
rmesh_equiv_1496 vgnd.n325 vgnd.n472 1540.0362363369115
rmesh_equiv_1497 vgnd.n325 vgnd.n8413 125635.27025441962
rmesh_equiv_1498 vgnd.n325 vgnd.n8640 32786662687.425575
rmesh_equiv_1499 vgnd.n325 vgnd.t102 179351.845777974
rmesh_equiv_15 amplified.n11 amplified.n13 2.90421
rmesh_equiv_150 bias_source__vcm_raw bias_source__vcm_raw.n12 4.6231713470107687
rmesh_equiv_1500 vgnd.n325 vgnd.t24 16328.800354007844
rmesh_equiv_1501 vgnd.n325 vgnd.t3 494118183.62075776
rmesh_equiv_1502 vgnd.n3484 vgnd.n3585 737973.04841941537
rmesh_equiv_1503 vgnd.n3484 vgnd.n3588 737973.04841941514
rmesh_equiv_1504 vgnd.n3484 vgnd.n5305 27287.59049420591
rmesh_equiv_1505 vgnd.n3484 vgnd.n5799 22916895835.250435
rmesh_equiv_1506 vgnd.n3484 vgnd.t14 617.33806639112095
rmesh_equiv_1507 vgnd.n3484 vgnd.t5 80.635833552489586
rmesh_equiv_1508 vgnd.n3484 vgnd.t51 58633.325352290405
rmesh_equiv_1509 vgnd.n3484 vgnd.t90 9928.1227314977859
rmesh_equiv_151 bias_source__vcm_raw bias_source__vcm_raw.n2 5.2670000000000003
rmesh_equiv_1510 vgnd.n3484 vgnd.t92 348292664.03522563
rmesh_equiv_1511 vgnd.n3585 vgnd.n3588 27068.668532538741
rmesh_equiv_1512 vgnd.n3585 vgnd.n5293 4001.7919961119474
rmesh_equiv_1513 vgnd.n3585 vgnd.n5295 2020.2930039264036
rmesh_equiv_1514 vgnd.n3585 vgnd.n5299 671.85155594050138
rmesh_equiv_1515 vgnd.n3585 vgnd.n5305 385.28930923732605
rmesh_equiv_1516 vgnd.n3585 vgnd.t5 97928.041498773498
rmesh_equiv_1517 vgnd.n3585 vgnd.t90 613.05941808050579
rmesh_equiv_1518 vgnd.n3588 vgnd.n5074 43415123.838937223
rmesh_equiv_1519 vgnd.n3588 vgnd.n5293 17084.282104842416
rmesh_equiv_152 bias_source__vcm_raw bias_source__vcm_raw.n3 5.2670000000000003
rmesh_equiv_1520 vgnd.n3588 vgnd.n5295 17119.282859959676
rmesh_equiv_1521 vgnd.n3588 vgnd.n5299 567.14363248230609
rmesh_equiv_1522 vgnd.n3588 vgnd.n5305 31999.260898644337
rmesh_equiv_1523 vgnd.n3588 vgnd.t5 97928.041498773484
rmesh_equiv_1524 vgnd.n3588 vgnd.t86 55251.502892943172
rmesh_equiv_1525 vgnd.n3588 vgnd.t90 613.05941808050568
rmesh_equiv_1526 vgnd.n3588 vgnd.t97 5761129.3445384353
rmesh_equiv_1527 vgnd.n421 vgnd.n425 25511.409503124058
rmesh_equiv_1528 vgnd.n421 vgnd.n427 14722.075518278534
rmesh_equiv_1529 vgnd.n421 vgnd.n460 743.94079028835688
rmesh_equiv_153 bias_source__vcm_raw bias_source__vcm_raw.n4 5.2670000000000003
rmesh_equiv_1530 vgnd.n421 vgnd.n462 7559.8315777736861
rmesh_equiv_1531 vgnd.n421 vgnd.n468 35149.541188472424
rmesh_equiv_1532 vgnd.n421 vgnd.n470 697.55506021508097
rmesh_equiv_1533 vgnd.n421 vgnd.n472 352.8780814232282
rmesh_equiv_1534 vgnd.n421 vgnd.t107 3987.4343783077097
rmesh_equiv_1535 vgnd.n425 vgnd.n427 11825.13468727295
rmesh_equiv_1536 vgnd.n425 vgnd.n460 7328.6908875007684
rmesh_equiv_1537 vgnd.n425 vgnd.n462 6656.4879854530382
rmesh_equiv_1538 vgnd.n425 vgnd.n468 472.41796020972009
rmesh_equiv_1539 vgnd.n425 vgnd.n470 641.99811307556843
rmesh_equiv_154 bias_source__vcm_raw bias_source__vcm_raw.n5 5.2670000000000003
rmesh_equiv_1540 vgnd.n425 vgnd.n472 15821.414558644625
rmesh_equiv_1541 vgnd.n427 vgnd.n460 1481.5396722393079
rmesh_equiv_1542 vgnd.n427 vgnd.n462 349.98269739429838
rmesh_equiv_1543 vgnd.n427 vgnd.n468 6656.4879854530382
rmesh_equiv_1544 vgnd.n427 vgnd.n470 7328.6908875007684
rmesh_equiv_1545 vgnd.n427 vgnd.n472 4040.4316579407378
rmesh_equiv_1546 vgnd.n427 vgnd.t107 608.40282688822072
rmesh_equiv_1547 vgnd.n460 vgnd.n462 1586.8066286580693
rmesh_equiv_1548 vgnd.n460 vgnd.n468 4125.3942666929725
rmesh_equiv_1549 vgnd.n460 vgnd.n470 263.01346535148565
rmesh_equiv_155 bias_source__vcm_raw bias_source__vcm_raw.n6 5.2670000000000003
rmesh_equiv_1550 vgnd.n460 vgnd.n472 2445.7040838288308
rmesh_equiv_1551 vgnd.n460 vgnd.t107 57.720611180958343
rmesh_equiv_1552 vgnd.n462 vgnd.n468 51.600789359185825
rmesh_equiv_1553 vgnd.n462 vgnd.n470 4125.3942666929725
rmesh_equiv_1554 vgnd.n462 vgnd.n472 1118.8989765236236
rmesh_equiv_1555 vgnd.n462 vgnd.t107 1922.4930724746139
rmesh_equiv_1556 vgnd.n468 vgnd.n470 1703.5636641986459
rmesh_equiv_1557 vgnd.n468 vgnd.n472 233783.07302186851
rmesh_equiv_1558 vgnd.n470 vgnd.n472 1215.9640626449034
rmesh_equiv_1559 vgnd.n472 vgnd.t107 1277.3195072841893
rmesh_equiv_156 bias_source__vcm_raw bias_source__vcm_raw.n7 5.2670000000000003
rmesh_equiv_1560 vgnd.n5074 vgnd.n5293 3668885.5393152349
rmesh_equiv_1561 vgnd.n5074 vgnd.n5295 3676688.1780282636
rmesh_equiv_1562 vgnd.n5074 vgnd.n5299 822368.22121468082
rmesh_equiv_1563 vgnd.n5074 vgnd.t36 57128.355713634439
rmesh_equiv_1564 vgnd.n5074 vgnd.t82 616.9051755312347
rmesh_equiv_1565 vgnd.n5074 vgnd.t86 7741.850856095537
rmesh_equiv_1566 vgnd.n5074 vgnd.t97 80.627988931054944
rmesh_equiv_1567 vgnd.n5293 vgnd.n5295 298.84983094630542
rmesh_equiv_1568 vgnd.n5293 vgnd.n5299 307.67758171132522
rmesh_equiv_1569 vgnd.n5293 vgnd.n5305 3560.2042816996477
rmesh_equiv_157 bias_source__vcm_raw bias_source__vcm_raw.n8 5.2670000000000003
rmesh_equiv_1570 vgnd.n5293 vgnd.t86 4669.143424337065
rmesh_equiv_1571 vgnd.n5293 vgnd.t97 486856.24439806142
rmesh_equiv_1572 vgnd.n5295 vgnd.n5299 308.02569861840641
rmesh_equiv_1573 vgnd.n5295 vgnd.n5305 172.90150716397031
rmesh_equiv_1574 vgnd.n5295 vgnd.t86 4679.0733169022642
rmesh_equiv_1575 vgnd.n5295 vgnd.t97 487891.64420530898
rmesh_equiv_1576 vgnd.n5299 vgnd.n5305 3626.8503868168286
rmesh_equiv_1577 vgnd.n5299 vgnd.t86 1046.5726257529834
rmesh_equiv_1578 vgnd.n5299 vgnd.t90 51.867174104752145
rmesh_equiv_1579 vgnd.n5299 vgnd.t97 109127.17210786036
rmesh_equiv_158 bias_source__vcm_raw bias_source__vcm_raw.n9 5.2670000000000003
rmesh_equiv_1580 vgnd.n5305 vgnd.t5 3621.0269467719354
rmesh_equiv_1581 vgnd.n5305 vgnd.t90 311.44603749055136
rmesh_equiv_1582 vgnd.n5799 vgnd.t12 120013.11654264139
rmesh_equiv_1583 vgnd.n5799 vgnd.t14 365982064.25838333
rmesh_equiv_1584 vgnd.n5799 vgnd.t51 3809056.3610118027
rmesh_equiv_1585 vgnd.n5799 vgnd.t88 76.949470555401106
rmesh_equiv_1586 vgnd.n5799 vgnd.t92 605.67491220798308
rmesh_equiv_1587 vgnd.n5920 vgnd.t13 721.61260803004654
rmesh_equiv_1588 vgnd.n5920 vgnd.t18 22.36436553038774
rmesh_equiv_1589 vgnd.n5920 vgnd.t21 1726.8308762633969
rmesh_equiv_159 bias_source__vcm_raw bias_source__vcm_raw.t10 0.00141837
rmesh_equiv_1590 vgnd.n5920 vgnd.t22 50.699485714868231
rmesh_equiv_1591 vgnd.n5920 vgnd.t42 4587.5437372116176
rmesh_equiv_1592 vgnd.n5920 vgnd.t50 318.0469492090711
rmesh_equiv_1593 vgnd.n5920 vgnd.t7 49745.103304423268
rmesh_equiv_1594 vgnd.n5920 vgnd.t72 5612.0257344108977
rmesh_equiv_1595 vgnd.n5920 vgnd.t91 117.93130271246353
rmesh_equiv_1596 vgnd.n5920 vgnd.t94 1008.4734941679681
rmesh_equiv_1597 vgnd.n6209 vgnd.t4 3034998303.2070642
rmesh_equiv_1598 vgnd.n6209 vgnd.t69 7752.9549229596614
rmesh_equiv_1599 vgnd.n6209 vgnd.t71 9958.3305048084876
rmesh_equiv_16 amplified.n11 amplified.t2 178.41800000000001
rmesh_equiv_160 bias_source__vcm_raw bias_source__vcm_raw.t11 0.00141837
rmesh_equiv_1600 vgnd.n6209 vgnd.t84 27400078.342200458
rmesh_equiv_1601 vgnd.n6209 vgnd.t89 772709.66325621482
rmesh_equiv_1602 vgnd.n6209 vgnd.t9 77.547523734467319
rmesh_equiv_1603 vgnd.n7232 vgnd.n7389 858.0306467622936
rmesh_equiv_1604 vgnd.n7232 vgnd.n7391 568.62714314176401
rmesh_equiv_1605 vgnd.n7232 vgnd.n7405 780.58104119832217
rmesh_equiv_1606 vgnd.n7232 vgnd.n7407 1506.4888390204376
rmesh_equiv_1607 vgnd.n7232 vgnd.n7415 58.336138384071106
rmesh_equiv_1608 vgnd.n7232 vgnd.n7419 17676.710073685099
rmesh_equiv_1609 vgnd.n7232 vgnd.n7497 16090.599722468602
rmesh_equiv_161 bias_source__vcm_raw bias_source__vcm_raw.t12 0.00141837
rmesh_equiv_1610 vgnd.n7232 vgnd.t48 147.48059118272604
rmesh_equiv_1611 vgnd.n7232 vgnd.t6 17074.104095630344
rmesh_equiv_1612 vgnd.n7389 vgnd.n7391 280.66671578700362
rmesh_equiv_1613 vgnd.n7389 vgnd.n7405 873.77395032155653
rmesh_equiv_1614 vgnd.n7389 vgnd.n7407 5061.6586653792019
rmesh_equiv_1615 vgnd.n7389 vgnd.n7415 4906.677680807582
rmesh_equiv_1616 vgnd.n7389 vgnd.n7419 313.53723383828293
rmesh_equiv_1617 vgnd.n7389 vgnd.n7497 6205.2328762574798
rmesh_equiv_1618 vgnd.n7389 vgnd.t48 2763.3146797830677
rmesh_equiv_1619 vgnd.n7391 vgnd.n7405 2580.5520299253926
rmesh_equiv_162 bias_source__vcm_raw bias_source__vcm_raw.t13 0.00141837
rmesh_equiv_1620 vgnd.n7391 vgnd.n7407 7784.0409630481527
rmesh_equiv_1621 vgnd.n7391 vgnd.n7415 35165.166273113791
rmesh_equiv_1622 vgnd.n7391 vgnd.n7419 4280.7748109050408
rmesh_equiv_1623 vgnd.n7391 vgnd.n7497 32040.688117686514
rmesh_equiv_1624 vgnd.n7391 vgnd.t48 11644.385651640099
rmesh_equiv_1625 vgnd.n7405 vgnd.n7407 253.20721808593689
rmesh_equiv_1626 vgnd.n7405 vgnd.n7415 3483.3445477026212
rmesh_equiv_1627 vgnd.n7405 vgnd.n7421 11901.635973796994
rmesh_equiv_1628 vgnd.n7405 vgnd.n7423 283.33889553578399
rmesh_equiv_1629 vgnd.n7405 vgnd.n7497 7014.8467185900299
rmesh_equiv_163 bias_source__vcm_raw bias_source__vcm_raw.t14 0.00141837
rmesh_equiv_1630 vgnd.n7405 vgnd.t48 3295.6412132481632
rmesh_equiv_1631 vgnd.n7407 vgnd.n7415 10188.160919054093
rmesh_equiv_1632 vgnd.n7407 vgnd.n7421 40511.251059631453
rmesh_equiv_1633 vgnd.n7407 vgnd.n7423 1759.8945237262683
rmesh_equiv_1634 vgnd.n7407 vgnd.n7497 51936.642920855127
rmesh_equiv_1635 vgnd.n7407 vgnd.t48 4380.4253578594416
rmesh_equiv_1636 vgnd.n7415 vgnd.n7419 2329.0892404659035
rmesh_equiv_1637 vgnd.n7415 vgnd.n7421 152.53156851456393
rmesh_equiv_1638 vgnd.n7415 vgnd.n7423 1070.0930142011373
rmesh_equiv_1639 vgnd.n7415 vgnd.t48 17854.123748077043
rmesh_equiv_164 bias_source__vcm_raw bias_source__vcm_raw.t2 0.00141837
rmesh_equiv_1640 vgnd.n7419 vgnd.n7421 1403.1048880495202
rmesh_equiv_1641 vgnd.n7419 vgnd.n7427 1882.1531099845897
rmesh_equiv_1642 vgnd.n7419 vgnd.n7431 110.6999450030161
rmesh_equiv_1643 vgnd.n7419 vgnd.t48 5153.1252464204335
rmesh_equiv_1644 vgnd.n7421 vgnd.n7423 1203.1956267356768
rmesh_equiv_1645 vgnd.n7421 vgnd.n7427 153.06121073592419
rmesh_equiv_1646 vgnd.n7421 vgnd.n7431 8567.1589598757546
rmesh_equiv_1647 vgnd.n7421 vgnd.t48 131245.16828641709
rmesh_equiv_1648 vgnd.n7423 vgnd.n7427 3609.0812621729187
rmesh_equiv_1649 vgnd.n7423 vgnd.n7433 8567.1589598757546
rmesh_equiv_165 bias_source__vcm_raw bias_source__vcm_raw.t3 0.00141837
rmesh_equiv_1650 vgnd.n7423 vgnd.n7435 110.6999450030161
rmesh_equiv_1651 vgnd.n7423 vgnd.t48 5883.1931376532029
rmesh_equiv_1652 vgnd.n7427 vgnd.n7431 3609.0812621729187
rmesh_equiv_1653 vgnd.n7427 vgnd.n7433 153.06121073592419
rmesh_equiv_1654 vgnd.n7427 vgnd.n7435 1882.1531099845897
rmesh_equiv_1655 vgnd.n7431 vgnd.n7433 1403.1048880495202
rmesh_equiv_1656 vgnd.n7431 vgnd.n7439 1882.1531099845897
rmesh_equiv_1657 vgnd.n7431 vgnd.n7443 110.6999450030161
rmesh_equiv_1658 vgnd.n7433 vgnd.n7435 1403.1048880495202
rmesh_equiv_1659 vgnd.n7433 vgnd.n7439 153.06121073592419
rmesh_equiv_166 bias_source__vcm_raw bias_source__vcm_raw.t4 0.00141837
rmesh_equiv_1660 vgnd.n7433 vgnd.n7443 8567.1589598757546
rmesh_equiv_1661 vgnd.n7435 vgnd.n7439 3609.0812621729187
rmesh_equiv_1662 vgnd.n7435 vgnd.n7445 8567.1589598757546
rmesh_equiv_1663 vgnd.n7435 vgnd.n7447 110.6999450030161
rmesh_equiv_1664 vgnd.n7439 vgnd.n7443 3609.0812621729187
rmesh_equiv_1665 vgnd.n7439 vgnd.n7445 153.06121073592419
rmesh_equiv_1666 vgnd.n7439 vgnd.n7447 1882.1531099845897
rmesh_equiv_1667 vgnd.n7443 vgnd.n7445 1403.1048880495202
rmesh_equiv_1668 vgnd.n7443 vgnd.n7451 1882.1531099845897
rmesh_equiv_1669 vgnd.n7443 vgnd.n7455 110.6999450030161
rmesh_equiv_167 bias_source__vcm_raw bias_source__vcm_raw.t5 0.00141837
rmesh_equiv_1670 vgnd.n7445 vgnd.n7447 1403.1048880495202
rmesh_equiv_1671 vgnd.n7445 vgnd.n7451 153.06121073592419
rmesh_equiv_1672 vgnd.n7445 vgnd.n7455 8567.1589598757546
rmesh_equiv_1673 vgnd.n7447 vgnd.n7451 3609.0812621729187
rmesh_equiv_1674 vgnd.n7447 vgnd.n7457 8567.1589598757546
rmesh_equiv_1675 vgnd.n7447 vgnd.n7459 110.6999450030161
rmesh_equiv_1676 vgnd.n7451 vgnd.n7455 3609.0812621729187
rmesh_equiv_1677 vgnd.n7451 vgnd.n7457 153.06121073592419
rmesh_equiv_1678 vgnd.n7451 vgnd.n7459 1882.1531099845897
rmesh_equiv_1679 vgnd.n7455 vgnd.n7457 1403.1048880495202
rmesh_equiv_168 bias_source__vcm_raw bias_source__vcm_raw.t6 0.00141837
rmesh_equiv_1680 vgnd.n7455 vgnd.n7463 1882.1531099845897
rmesh_equiv_1681 vgnd.n7455 vgnd.n7467 110.6999450030161
rmesh_equiv_1682 vgnd.n7457 vgnd.n7459 1403.1048880495202
rmesh_equiv_1683 vgnd.n7457 vgnd.n7463 153.06121073592419
rmesh_equiv_1684 vgnd.n7457 vgnd.n7467 8567.1589598757546
rmesh_equiv_1685 vgnd.n7459 vgnd.n7463 3609.0812621729187
rmesh_equiv_1686 vgnd.n7459 vgnd.n7469 8567.1589598757546
rmesh_equiv_1687 vgnd.n7459 vgnd.n7471 110.6999450030161
rmesh_equiv_1688 vgnd.n7463 vgnd.n7467 3609.0812621729187
rmesh_equiv_1689 vgnd.n7463 vgnd.n7469 153.06121073592419
rmesh_equiv_169 bias_source__vcm_raw bias_source__vcm_raw.t7 0.00141837
rmesh_equiv_1690 vgnd.n7463 vgnd.n7471 1882.1531099845897
rmesh_equiv_1691 vgnd.n7467 vgnd.n7469 1403.1048880495202
rmesh_equiv_1692 vgnd.n7467 vgnd.n7475 1882.1531099845897
rmesh_equiv_1693 vgnd.n7467 vgnd.n7479 110.6999450030161
rmesh_equiv_1694 vgnd.n7469 vgnd.n7471 1403.1048880495202
rmesh_equiv_1695 vgnd.n7469 vgnd.n7475 153.06121073592419
rmesh_equiv_1696 vgnd.n7469 vgnd.n7479 8567.1589598757546
rmesh_equiv_1697 vgnd.n7471 vgnd.n7475 3609.0812621729187
rmesh_equiv_1698 vgnd.n7471 vgnd.n7481 8567.1589598757546
rmesh_equiv_1699 vgnd.n7471 vgnd.n7483 110.6999450030161
rmesh_equiv_17 amplified.n12 amplified.n13 13.4665
rmesh_equiv_170 bias_source__vcm_raw bias_source__vcm_raw.t8 0.00141837
rmesh_equiv_1700 vgnd.n7475 vgnd.n7479 3609.0812621729187
rmesh_equiv_1701 vgnd.n7475 vgnd.n7481 153.06121073592419
rmesh_equiv_1702 vgnd.n7475 vgnd.n7483 1882.1531099845897
rmesh_equiv_1703 vgnd.n7479 vgnd.n7481 755.72794500291241
rmesh_equiv_1704 vgnd.n7479 vgnd.n7483 15870.225404914287
rmesh_equiv_1705 vgnd.n7479 vgnd.n7497 2544.3425992624911
rmesh_equiv_1706 vgnd.n7481 vgnd.n7483 1011.9562057741562
rmesh_equiv_1707 vgnd.n7481 vgnd.n7497 741.79088326613635
rmesh_equiv_1708 vgnd.n7483 vgnd.n7497 3945.4888989291089
rmesh_equiv_1709 vgnd.n7497 vgnd.n7951 1091386626939.1136
rmesh_equiv_171 bias_source__vcm_raw bias_source__vcm_raw.t9 332.71199999999999
rmesh_equiv_1710 vgnd.n7497 vgnd.n921 1642520901026.4016
rmesh_equiv_1711 vgnd.n7497 vgnd.n922 1581898085234.481
rmesh_equiv_1712 vgnd.n7497 vgnd.t19 596.23425648790794
rmesh_equiv_1713 vgnd.n7497 vgnd.t45 968247463.12380791
rmesh_equiv_1714 vgnd.n7497 vgnd.t47 1654.1742100696526
rmesh_equiv_1715 vgnd.n7497 vgnd.t76 9765892.6436162367
rmesh_equiv_1716 vgnd.n7497 vgnd.t83 5578161.4242795603
rmesh_equiv_1717 vgnd.n7497 vgnd.t85 57498.044569784324
rmesh_equiv_1718 vgnd.n7951 vgnd.n8413 8859716525786.0742
rmesh_equiv_1719 vgnd.n7951 vgnd.n921 7478.3221259059865
rmesh_equiv_172 bias_source__vcm_raw.n0 bias_source__vcm_raw.n1 4.4643300000000004
rmesh_equiv_1720 vgnd.n7951 vgnd.n922 136241.22704685424
rmesh_equiv_1721 vgnd.n7951 vgnd.t20 22778272.767359853
rmesh_equiv_1722 vgnd.n7951 vgnd.t45 10376.886196530502
rmesh_equiv_1723 vgnd.n7951 vgnd.t47 6431893155.202281
rmesh_equiv_1724 vgnd.n7951 vgnd.t59 134650621687.44737
rmesh_equiv_1725 vgnd.n7951 vgnd.t75 226100.46810911284
rmesh_equiv_1726 vgnd.n7951 vgnd.t76 1027396.1417858687
rmesh_equiv_1727 vgnd.n7951 vgnd.t95 82.175189347317357
rmesh_equiv_1728 vgnd.n826 vgnd.n830 59.059716043503236
rmesh_equiv_1729 vgnd.n826 vgnd.n9220 70.775522294468132
rmesh_equiv_173 bias_source__vcm_raw.n0 bias_source__vcm_raw.t0 25.840499999999999
rmesh_equiv_1730 vgnd.n826 vgnd.t103 1691.4453068853502
rmesh_equiv_1731 vgnd.n826 vgnd.t108 1377.6622836460194
rmesh_equiv_1732 vgnd.n826 vgnd.t46 84.748370920037502
rmesh_equiv_1733 vgnd.n826 vgnd.t55 30187.474699847764
rmesh_equiv_1734 vgnd.n826 vgnd.t68 31.424561091416468
rmesh_equiv_1735 vgnd.n826 vgnd.t74 13.509636962416895
rmesh_equiv_1736 vgnd.n826 vgnd.t98 5.95932
rmesh_equiv_1737 vgnd.n830 vgnd.n834 59.059716043503236
rmesh_equiv_1738 vgnd.n830 vgnd.t101 31.424561091416468
rmesh_equiv_1739 vgnd.n830 vgnd.t35 13.509636962416895
rmesh_equiv_174 bias_source__vcm_raw.n0 bias_source__vcm_raw.t1 35.954099999999997
rmesh_equiv_1740 vgnd.n830 vgnd.t44 5.95932
rmesh_equiv_1741 vgnd.n830 vgnd.t46 13.509636962416895
rmesh_equiv_1742 vgnd.n830 vgnd.t68 31.424561091416468
rmesh_equiv_1743 vgnd.n830 vgnd.t73 84.748370920037502
rmesh_equiv_1744 vgnd.n830 vgnd.t74 84.748370920037502
rmesh_equiv_1745 vgnd.n834 vgnd.n880 275.9457833442321
rmesh_equiv_1746 vgnd.n834 vgnd.t101 31.424561091416468
rmesh_equiv_1747 vgnd.n834 vgnd.t106 5.95932
rmesh_equiv_1748 vgnd.n834 vgnd.t35 84.748370920037502
rmesh_equiv_1749 vgnd.n834 vgnd.t38 59.522655849854495
rmesh_equiv_175 bias_source__vcm_raw.n1 bias_source__vcm_raw.n2 4.1529499999999997
rmesh_equiv_1750 vgnd.n834 vgnd.t43 13.36569829473409
rmesh_equiv_1751 vgnd.n834 vgnd.t60 29.43594269008172
rmesh_equiv_1752 vgnd.n834 vgnd.t73 13.509636962416895
rmesh_equiv_1753 vgnd.n834 vgnd.t96 108081.46816221283
rmesh_equiv_1754 vgnd.n8413 vgnd.n8640 20859848369.005672
rmesh_equiv_1755 vgnd.n8413 vgnd.t102 114108.96995822273
rmesh_equiv_1756 vgnd.n8413 vgnd.t20 3815006.3944898932
rmesh_equiv_1757 vgnd.n8413 vgnd.t24 76.949469647675045
rmesh_equiv_1758 vgnd.n8413 vgnd.t3 314372660.766433
rmesh_equiv_1759 vgnd.n8413 vgnd.t59 605.67491265920535
rmesh_equiv_176 bias_source__vcm_raw.n10 bias_source__vcm_raw.n11 4.1529499999999997
rmesh_equiv_1760 vgnd.n8413 vgnd.t75 359813245.06017876
rmesh_equiv_1761 vgnd.n8413 vgnd.t95 597716552135.65967
rmesh_equiv_1762 vgnd.n8640 vgnd.n9262 1546904.3624308826
rmesh_equiv_1763 vgnd.n8640 vgnd.n9306 17998110.279683482
rmesh_equiv_1764 vgnd.n8640 vgnd.n9308 41331864.118930437
rmesh_equiv_1765 vgnd.n8640 vgnd.t102 964026.0172969359
rmesh_equiv_1766 vgnd.n8640 vgnd.t24 2711151882.2906933
rmesh_equiv_1767 vgnd.n8640 vgnd.t3 610.08365589446555
rmesh_equiv_1768 vgnd.n8640 vgnd.t79 77.547479976329228
rmesh_equiv_1769 vgnd.n8640 vgnd.t87 7708.5082832034768
rmesh_equiv_177 bias_source__vcm_raw.n10 bias_source__vcm_raw.n9 4.1529499999999997
rmesh_equiv_1770 vgnd.n880 vgnd.t16 721.61260803004654
rmesh_equiv_1771 vgnd.n880 vgnd.t38 63.121322011510195
rmesh_equiv_1772 vgnd.n880 vgnd.t43 395.97135183398541
rmesh_equiv_1773 vgnd.n880 vgnd.t49 44.479152994040142
rmesh_equiv_1774 vgnd.n880 vgnd.t60 146.82554721787363
rmesh_equiv_1775 vgnd.n880 vgnd.t61 16.492799158044928
rmesh_equiv_1776 vgnd.n880 vgnd.t96 880.1855226864908
rmesh_equiv_1777 vgnd.n8809 vgnd.n8812 36870.206915880037
rmesh_equiv_1778 vgnd.n8809 vgnd.n8817 11173.245309151118
rmesh_equiv_1779 vgnd.n8809 vgnd.n9278 14366.402634930102
rmesh_equiv_178 bias_source__vcm_raw.n11 bias_source__vcm_raw.n12 4.1529499999999997
rmesh_equiv_1780 vgnd.n8809 vgnd.n9282 8745.4253067387654
rmesh_equiv_1781 vgnd.n8809 vgnd.n9287 22049.879582249647
rmesh_equiv_1782 vgnd.n8809 vgnd.n9289 765.53251583084466
rmesh_equiv_1783 vgnd.n8809 vgnd.n9291 376.96929454884679
rmesh_equiv_1784 vgnd.n8809 vgnd.n9295 675.30260888780015
rmesh_equiv_1785 vgnd.n8809 vgnd.n9297 22499.855453217071
rmesh_equiv_1786 vgnd.n8809 vgnd.n9299 98034.100930047367
rmesh_equiv_1787 vgnd.n8809 vgnd.n9306 6485.0408608297357
rmesh_equiv_1788 vgnd.n8809 vgnd.t54 8909.6924593396452
rmesh_equiv_1789 vgnd.n8812 vgnd.n8817 11887.627198612352
rmesh_equiv_179 bias_source__vcm_raw.n2 bias_source__vcm_raw.n3 4.1529499999999997
rmesh_equiv_1790 vgnd.n8812 vgnd.n9262 190978.51378432455
rmesh_equiv_1791 vgnd.n8812 vgnd.n9278 3712.8698260184815
rmesh_equiv_1792 vgnd.n8812 vgnd.n9282 740.98681376856837
rmesh_equiv_1793 vgnd.n8812 vgnd.n9287 352.71401990748302
rmesh_equiv_1794 vgnd.n8812 vgnd.n9289 1524.7383058356354
rmesh_equiv_1795 vgnd.n8812 vgnd.n9291 34447.386852490345
rmesh_equiv_1796 vgnd.n8812 vgnd.n9295 7181.8664804807859
rmesh_equiv_1797 vgnd.n8812 vgnd.n9297 10678.102486853031
rmesh_equiv_1798 vgnd.n8812 vgnd.n9299 22644.642795916465
rmesh_equiv_1799 vgnd.n8812 vgnd.t54 979.49592683769617
rmesh_equiv_18 amplified.n12 amplified.t2 172.06
rmesh_equiv_180 bias_source__vcm_raw.n3 bias_source__vcm_raw.n4 4.1529499999999997
rmesh_equiv_1800 vgnd.n8817 vgnd.n9262 52299.717733747493
rmesh_equiv_1801 vgnd.n8817 vgnd.n9278 378.92885511559575
rmesh_equiv_1802 vgnd.n8817 vgnd.n9282 490.10054038181011
rmesh_equiv_1803 vgnd.n8817 vgnd.n9287 3458.8486077322464
rmesh_equiv_1804 vgnd.n8817 vgnd.n9289 16589.717019932497
rmesh_equiv_1805 vgnd.n8817 vgnd.n9291 1167.3973084086754
rmesh_equiv_1806 vgnd.n8817 vgnd.t54 8421.2869173765612
rmesh_equiv_1807 vgnd.n8826 vgnd.n8829 10118.44032171117
rmesh_equiv_1808 vgnd.n8826 vgnd.n8833 10959.425451900523
rmesh_equiv_1809 vgnd.n8826 vgnd.n8839 3717.2689244696558
rmesh_equiv_181 bias_source__vcm_raw.n4 bias_source__vcm_raw.n5 4.1529499999999997
rmesh_equiv_1810 vgnd.n8826 vgnd.n9241 14091.476051326914
rmesh_equiv_1811 vgnd.n8826 vgnd.n9245 16845.580223576348
rmesh_equiv_1812 vgnd.n8826 vgnd.n9246 1651.2503926888369
rmesh_equiv_1813 vgnd.n8826 vgnd.n9249 356.36943409734511
rmesh_equiv_1814 vgnd.n8826 vgnd.n9262 27707.405618405333
rmesh_equiv_1815 vgnd.n8826 vgnd.n9316 389.97657549458319
rmesh_equiv_1816 vgnd.n8829 vgnd.n8833 108901.38967258605
rmesh_equiv_1817 vgnd.n8829 vgnd.n8839 428.045565485662
rmesh_equiv_1818 vgnd.n8829 vgnd.n8843 3759.8454058512039
rmesh_equiv_1819 vgnd.n8829 vgnd.n8844 1286.9971594202066
rmesh_equiv_182 bias_source__vcm_raw.n5 bias_source__vcm_raw.n6 4.1529499999999997
rmesh_equiv_1820 vgnd.n8829 vgnd.n9241 140023.88457885329
rmesh_equiv_1821 vgnd.n8829 vgnd.n9245 5402.3425492111528
rmesh_equiv_1822 vgnd.n8829 vgnd.n9246 544.6163975505807
rmesh_equiv_1823 vgnd.n8829 vgnd.n9249 9222.8233655033328
rmesh_equiv_1824 vgnd.n8829 vgnd.n9262 93183.393293566565
rmesh_equiv_1825 vgnd.n8829 vgnd.n9316 1211.6732608735817
rmesh_equiv_1826 vgnd.n8833 vgnd.n8843 9405.2905002070729
rmesh_equiv_1827 vgnd.n8833 vgnd.n9240 394.00000000000006
rmesh_equiv_1828 vgnd.n8833 vgnd.n9241 652.23438410485801
rmesh_equiv_1829 vgnd.n8833 vgnd.n9245 924.39422461960862
rmesh_equiv_183 bias_source__vcm_raw.n6 bias_source__vcm_raw.n7 4.1529499999999997
rmesh_equiv_1830 vgnd.n8833 vgnd.n9246 4122.1342960501452
rmesh_equiv_1831 vgnd.n8833 vgnd.n9249 1168.4131363060469
rmesh_equiv_1832 vgnd.n8833 vgnd.t39 1002.1666615073635
rmesh_equiv_1833 vgnd.n8838 vgnd.n8843 9822.0689533398327
rmesh_equiv_1834 vgnd.n8838 vgnd.n8844 1526.8359114027714
rmesh_equiv_1835 vgnd.n8838 vgnd.n9231 407.18990435838344
rmesh_equiv_1836 vgnd.n8838 vgnd.n9237 849.99891579284451
rmesh_equiv_1837 vgnd.n8838 vgnd.n9238 4398.6337562588587
rmesh_equiv_1838 vgnd.n8838 vgnd.n9240 234465.51223153798
rmesh_equiv_1839 vgnd.n8838 vgnd.n9308 6020.2309147451588
rmesh_equiv_184 bias_source__vcm_raw.n7 bias_source__vcm_raw.n8 4.1529499999999997
rmesh_equiv_1840 vgnd.n8838 vgnd.n9313 220242.93527936484
rmesh_equiv_1841 vgnd.n8838 vgnd.n9316 646.31033015336197
rmesh_equiv_1842 vgnd.n8838 vgnd.t39 24983.121959552547
rmesh_equiv_1843 vgnd.n8839 vgnd.n8843 4834.3566663940337
rmesh_equiv_1844 vgnd.n8839 vgnd.n8844 111.46129983666417
rmesh_equiv_1845 vgnd.n8839 vgnd.n9245 7177.9153549251514
rmesh_equiv_1846 vgnd.n8839 vgnd.n9246 4953.837310939427
rmesh_equiv_1847 vgnd.n8839 vgnd.n9249 427.59794246473143
rmesh_equiv_1848 vgnd.n8839 vgnd.n9262 10982.792074927518
rmesh_equiv_1849 vgnd.n8839 vgnd.n9316 395.16437631729474
rmesh_equiv_185 bias_source__vcm_raw.n8 bias_source__vcm_raw.n9 4.1529499999999997
rmesh_equiv_1850 vgnd.n8843 vgnd.n8844 362.44217746997469
rmesh_equiv_1851 vgnd.n8843 vgnd.n9231 4991.8971900118067
rmesh_equiv_1852 vgnd.n8843 vgnd.n9237 15957.559348863617
rmesh_equiv_1853 vgnd.n8843 vgnd.n9238 2720.6532459573154
rmesh_equiv_1854 vgnd.n8843 vgnd.n9240 27622.003929353221
rmesh_equiv_1855 vgnd.n8843 vgnd.n9245 938.43491086663073
rmesh_equiv_1856 vgnd.n8843 vgnd.n9246 5779.2060076952203
rmesh_equiv_1857 vgnd.n8843 vgnd.t39 747.60664770374706
rmesh_equiv_1858 vgnd.n8844 vgnd.n9231 144.42030888017487
rmesh_equiv_1859 vgnd.n8844 vgnd.n9237 4218.8909229769679
rmesh_equiv_186 bias_source_r_vcm_bottom_r0_n0.t0 bias_source_r_vcm_bottom_r0_n0.t1 52.8142
rmesh_equiv_1860 vgnd.n8844 vgnd.n9238 2051.6533437665585
rmesh_equiv_1861 vgnd.n8844 vgnd.n9240 42210.481900333252
rmesh_equiv_1862 vgnd.n8844 vgnd.n9245 3066.8922240739039
rmesh_equiv_1863 vgnd.n8844 vgnd.n9246 3862.709264397643
rmesh_equiv_1864 vgnd.n8844 vgnd.t39 4497.674763553835
rmesh_equiv_1865 vgnd.n9076 vgnd.n9220 8.3900741065746072
rmesh_equiv_1866 vgnd.n9076 vgnd.t11 3833.2378957689934
rmesh_equiv_1867 vgnd.n9076 vgnd.t27 2304.0285455018256
rmesh_equiv_1868 vgnd.n9076 vgnd.t28 2700.7622184071024
rmesh_equiv_1869 vgnd.n9076 vgnd.t31 1277.2061954190892
rmesh_equiv_187 bias_source_r_vcm_bottom_r0_n1.t0 bias_source_r_vcm_bottom_r0_n1.t1 52.8142
rmesh_equiv_1870 vgnd.n9076 vgnd.t33 3492.0397836244947
rmesh_equiv_1871 vgnd.n9076 vgnd.t64 2918.4630952100269
rmesh_equiv_1872 vgnd.n9076 vgnd.t66 683.34149263895949
rmesh_equiv_1873 vgnd.n9076 vgnd.t81 3486.0128226011439
rmesh_equiv_1874 vgnd.n921 vgnd.n922 205041.05280596024
rmesh_equiv_1875 vgnd.n921 vgnd.t15 884.1291348700031
rmesh_equiv_1876 vgnd.n921 vgnd.t45 15617.06185934838
rmesh_equiv_1877 vgnd.n921 vgnd.t47 9679905067.3888912
rmesh_equiv_1878 vgnd.n921 vgnd.t76 1546216.1573758381
rmesh_equiv_1879 vgnd.n922 vgnd.t45 15040.661118439275
rmesh_equiv_188 bias_source_r_vcm_top_r0_n0.t0 bias_source_r_vcm_top_r0_n0.t1 61.794099999999993
rmesh_equiv_1880 vgnd.n922 vgnd.t47 9322635274.7080841
rmesh_equiv_1881 vgnd.n922 vgnd.t76 1489147.7954301778
rmesh_equiv_1882 vgnd.n9220 vgnd.t103 6834.6944190463837
rmesh_equiv_1883 vgnd.n9220 vgnd.t108 10517.310325332979
rmesh_equiv_1884 vgnd.n9220 vgnd.t28 9306.5182576050756
rmesh_equiv_1885 vgnd.n9220 vgnd.t31 2283.6515383723854
rmesh_equiv_1886 vgnd.n9220 vgnd.t33 1026.9613395816325
rmesh_equiv_1887 vgnd.n9220 vgnd.t40 142.15907922784191
rmesh_equiv_1888 vgnd.n9220 vgnd.t55 926.22907203950081
rmesh_equiv_1889 vgnd.n9231 vgnd.n9237 3825.3790229742558
rmesh_equiv_189 bias_source_r_vcm_top_r0_n1.t0 bias_source_r_vcm_top_r0_n1.t1 51.980899999999998
rmesh_equiv_1890 vgnd.n9231 vgnd.n9238 3555.9185711998248
rmesh_equiv_1891 vgnd.n9231 vgnd.n9240 119163.05385590972
rmesh_equiv_1892 vgnd.n9231 vgnd.n9308 1502.2308369926943
rmesh_equiv_1893 vgnd.n9231 vgnd.n9313 54435.236105551019
rmesh_equiv_1894 vgnd.n9231 vgnd.n9316 945.51118960656527
rmesh_equiv_1895 vgnd.n9231 vgnd.t39 12697.240968279497
rmesh_equiv_1896 vgnd.n9237 vgnd.n9238 120.73398648559903
rmesh_equiv_1897 vgnd.n9237 vgnd.n9240 5692.8376789331569
rmesh_equiv_1898 vgnd.n9237 vgnd.n9241 3862.709264397643
rmesh_equiv_1899 vgnd.n9237 vgnd.n9313 4953.837310939427
rmesh_equiv_19 amplified.n13 amplified.n14 16.867000000000001
rmesh_equiv_190 clk clk.n0 33.658020588305583
rmesh_equiv_1900 vgnd.n9237 vgnd.n9316 244.94616300307695
rmesh_equiv_1901 vgnd.n9237 vgnd.t39 40589.172534152967
rmesh_equiv_1902 vgnd.n9238 vgnd.n9240 925.06807354458419
rmesh_equiv_1903 vgnd.n9238 vgnd.n9241 3066.8922240739039
rmesh_equiv_1904 vgnd.n9238 vgnd.n9313 7177.9153549251514
rmesh_equiv_1905 vgnd.n9238 vgnd.t39 207.17559934741351
rmesh_equiv_1906 vgnd.n9240 vgnd.n9241 455.88601958099957
rmesh_equiv_1907 vgnd.n9240 vgnd.n9313 4834.3566663940337
rmesh_equiv_1908 vgnd.n9240 vgnd.t39 988.07280052599071
rmesh_equiv_1909 vgnd.n9241 vgnd.n9245 4837.8877557227088
rmesh_equiv_191 clk clk.n1 38.714300000000001
rmesh_equiv_1910 vgnd.n9241 vgnd.n9246 5300.182657209536
rmesh_equiv_1911 vgnd.n9241 vgnd.n9249 110.70451417601892
rmesh_equiv_1912 vgnd.n9241 vgnd.n9313 111.46129983666417
rmesh_equiv_1913 vgnd.n9245 vgnd.n9246 120.54481094527527
rmesh_equiv_1914 vgnd.n9245 vgnd.n9249 3223.8308174140816
rmesh_equiv_1915 vgnd.n9245 vgnd.t39 213.5694245415385
rmesh_equiv_1916 vgnd.n9246 vgnd.n9249 1177.2255441815655
rmesh_equiv_1917 vgnd.n9249 vgnd.n9262 15351.316996478236
rmesh_equiv_1918 vgnd.n9249 vgnd.n9316 700.72408979909073
rmesh_equiv_1919 vgnd.n9262 vgnd.n9278 16935.653468631415
rmesh_equiv_192 clk clk.n2 38.698700000000002
rmesh_equiv_1920 vgnd.n9262 vgnd.n9282 22832.723550239716
rmesh_equiv_1921 vgnd.n9262 vgnd.n9287 31249.524317195042
rmesh_equiv_1922 vgnd.n9262 vgnd.n9306 32178.274051688695
rmesh_equiv_1923 vgnd.n9262 vgnd.n9308 73895.982968134806
rmesh_equiv_1924 vgnd.n9262 vgnd.n9316 568.28902500941251
rmesh_equiv_1925 vgnd.n9262 vgnd.t79 201050.96641831845
rmesh_equiv_1926 vgnd.n9262 vgnd.t87 1852.2522819142573
rmesh_equiv_1927 vgnd.n9278 vgnd.n9282 811.17690747835866
rmesh_equiv_1928 vgnd.n9278 vgnd.n9287 454.97655111439303
rmesh_equiv_1929 vgnd.n9278 vgnd.n9289 21330.826247294695
rmesh_equiv_193 clk clk.n3 38.714300000000001
rmesh_equiv_1930 vgnd.n9278 vgnd.n9291 110.69741612476514
rmesh_equiv_1931 vgnd.n9278 vgnd.t54 10827.973002634515
rmesh_equiv_1932 vgnd.n9282 vgnd.n9287 868.02369503730267
rmesh_equiv_1933 vgnd.n9282 vgnd.n9289 12984.958894523295
rmesh_equiv_1934 vgnd.n9282 vgnd.n9291 2190.3633693131251
rmesh_equiv_1935 vgnd.n9282 vgnd.t54 192.0378029286808
rmesh_equiv_1936 vgnd.n9287 vgnd.n9289 1360.2943953347958
rmesh_equiv_1937 vgnd.n9287 vgnd.n9295 1660.4328877655012
rmesh_equiv_1938 vgnd.n9287 vgnd.n9297 756.39626287053704
rmesh_equiv_1939 vgnd.n9287 vgnd.n9299 175.54023166265264
rmesh_equiv_194 clk clk.n4 19.953094958322954
rmesh_equiv_1940 vgnd.n9289 vgnd.n9291 2032.233396872499
rmesh_equiv_1941 vgnd.n9289 vgnd.n9295 262.70246824174558
rmesh_equiv_1942 vgnd.n9289 vgnd.n9297 6617.8115058109506
rmesh_equiv_1943 vgnd.n9289 vgnd.n9299 14034.139288726758
rmesh_equiv_1944 vgnd.n9289 vgnd.t54 57.955579571446137
rmesh_equiv_1945 vgnd.n9291 vgnd.n9295 1803.4281700240495
rmesh_equiv_1946 vgnd.n9291 vgnd.n9297 23582.568770369326
rmesh_equiv_1947 vgnd.n9291 vgnd.n9299 105218.46212865133
rmesh_equiv_1948 vgnd.n9291 vgnd.n9306 2285.9076179467384
rmesh_equiv_1949 vgnd.n9291 vgnd.t54 3427.697533530898
rmesh_equiv_195 clk clk.t0 330.34100000000001
rmesh_equiv_1950 vgnd.n9295 vgnd.n9297 627.0095784982999
rmesh_equiv_1951 vgnd.n9295 vgnd.n9299 5719.3005474907086
rmesh_equiv_1952 vgnd.n9295 vgnd.n9306 367.05457163549693
rmesh_equiv_1953 vgnd.n9297 vgnd.n9299 803.60933813001327
rmesh_equiv_1954 vgnd.n9297 vgnd.n9306 1135.9697952690883
rmesh_equiv_1955 vgnd.n9299 vgnd.n9306 878.51314191516531
rmesh_equiv_1956 vgnd.n9306 vgnd.n9308 4179.4204914938673
rmesh_equiv_1957 vgnd.n9306 vgnd.t79 2339212.1409157356
rmesh_equiv_1958 vgnd.n9306 vgnd.t87 21550.809245440807
rmesh_equiv_1959 vgnd.n9308 vgnd.n9313 1502.2308369926948
rmesh_equiv_196 clk clk.t1 330.34100000000001
rmesh_equiv_1960 vgnd.n9308 vgnd.n9316 34.828239219561979
rmesh_equiv_1961 vgnd.n9308 vgnd.t79 5371897.2076096125
rmesh_equiv_1962 vgnd.n9308 vgnd.t87 49490.480141741522
rmesh_equiv_1963 vgnd.n9313 vgnd.n9316 945.51118960656538
rmesh_equiv_1964 vgnd.n9316 vgnd.t1 17074.104095630344
rmesh_equiv_1965 vgnd.n9316 vgnd.t10 7825.8245925990204
rmesh_equiv_1966 vgnd.n9316 vgnd.t100 651.94729176104249
rmesh_equiv_1967 vgnd.n9316 vgnd.t26 651.94729176104249
rmesh_equiv_1968 vgnd.n9316 vgnd.t29 17074.104095630344
rmesh_equiv_1969 vgnd.n9316 vgnd.t30 651.94729176104249
rmesh_equiv_197 clk clk.t2 315.88
rmesh_equiv_1970 vgnd.n9316 vgnd.t32 17074.10409563034
rmesh_equiv_1971 vgnd.n9316 vgnd.t39 17.6065
rmesh_equiv_1972 vgnd.n9316 vgnd.t63 651.94729176104249
rmesh_equiv_1973 vgnd.n9316 vgnd.t65 17074.10409563034
rmesh_equiv_1974 vgnd.n9316 vgnd.t70 651.94729176104249
rmesh_equiv_1975 vgnd.n9316 vgnd.t80 651.94729176104249
rmesh_equiv_1976 vgnd.n9316 vgnd.t99 651.94729176104249
rmesh_equiv_1977 vgnd.t0 vgnd.t105 45.093009885334524
rmesh_equiv_1978 vgnd.t0 vgnd.t77 121.61058086208551
rmesh_equiv_1979 vgnd.t101 vgnd.t35 45.093009885334524
rmesh_equiv_198 clk clk.t3 330.34100000000001
rmesh_equiv_1980 vgnd.t101 vgnd.t73 45.093009885334524
rmesh_equiv_1981 vgnd.t102 vgnd.t24 14830.728546817063
rmesh_equiv_1982 vgnd.t102 vgnd.t3 14528.553551520919
rmesh_equiv_1983 vgnd.t103 vgnd.t108 251350.39084313108
rmesh_equiv_1984 vgnd.t103 vgnd.t55 2915162.7309471611
rmesh_equiv_1985 vgnd.t104 vgnd.t25 121.61058086208551
rmesh_equiv_1986 vgnd.t104 vgnd.t56 45.093009885334524
rmesh_equiv_1987 vgnd.t105 vgnd.t77 45.093009885334524
rmesh_equiv_1988 vgnd.t108 vgnd.t55 4485887.6213655621
rmesh_equiv_1989 vgnd.t11 vgnd.t27 262086.42693680635
rmesh_equiv_199 clk clk.t4 315.88
rmesh_equiv_1990 vgnd.t11 vgnd.t64 195099.70728015175
rmesh_equiv_1991 vgnd.t11 vgnd.t81 143512.56046991216
rmesh_equiv_1992 vgnd.t12 vgnd.t88 15598.089739597863
rmesh_equiv_1993 vgnd.t14 vgnd.t51 936.37225569429495
rmesh_equiv_1994 vgnd.t14 vgnd.t92 5562222.2602064926
rmesh_equiv_1995 vgnd.t17 vgnd.t53 45.093009885334524
rmesh_equiv_1996 vgnd.t17 vgnd.t78 45.093009885334524
rmesh_equiv_1997 vgnd.t18 vgnd.t22 40.432646317884355
rmesh_equiv_1998 vgnd.t18 vgnd.t50 253.64122788490738
rmesh_equiv_1999 vgnd.t18 vgnd.t91 94.049763723383094
rmesh_equiv_2 amplified amplified.n11 4.39276
rmesh_equiv_20 amplified.n14 amplified.n15 0.81771300000000002
rmesh_equiv_200 clk clk.t5 315.88
rmesh_equiv_2000 vgnd.t18 vgnd.t94 8759.5955689069506
rmesh_equiv_2001 vgnd.t19 vgnd.t83 91468.002300687425
rmesh_equiv_2002 vgnd.t19 vgnd.t85 942.82522017069596
rmesh_equiv_2003 vgnd.t2 vgnd.t37 147774.31814175154
rmesh_equiv_2004 vgnd.t2 vgnd.t52 438.13562277925132
rmesh_equiv_2005 vgnd.t2 vgnd.t57 43.171775587603726
rmesh_equiv_2006 vgnd.t2 vgnd.t58 35.257323177524917
rmesh_equiv_2007 vgnd.t20 vgnd.t59 57980.747043605224
rmesh_equiv_2008 vgnd.t20 vgnd.t75 925.0774804628943
rmesh_equiv_2009 vgnd.t20 vgnd.t95 1536725.3142339049
rmesh_equiv_201 clk.n0 clk.n1 0.81771300000000002
rmesh_equiv_2010 vgnd.t21 vgnd.t42 53376.40123345115
rmesh_equiv_2011 vgnd.t21 vgnd.t7 5395.6395408906783
rmesh_equiv_2012 vgnd.t21 vgnd.t72 40462.617500867469
rmesh_equiv_2013 vgnd.t22 vgnd.t50 100.38040920831638
rmesh_equiv_2014 vgnd.t22 vgnd.t91 37.220896016094493
rmesh_equiv_2015 vgnd.t22 vgnd.t94 19857.795197023919
rmesh_equiv_2016 vgnd.t24 vgnd.t3 40858975.381817497
rmesh_equiv_2017 vgnd.t25 vgnd.t56 45.093009885334524
rmesh_equiv_2018 vgnd.t27 vgnd.t64 199541.37613394394
rmesh_equiv_2019 vgnd.t27 vgnd.t81 238345.92837033884
rmesh_equiv_202 clk.n1 clk.n2 1.6402100000000002
rmesh_equiv_2020 vgnd.t28 vgnd.t31 1416714.8734812397
rmesh_equiv_2021 vgnd.t28 vgnd.t33 3873473.772671218
rmesh_equiv_2022 vgnd.t31 vgnd.t33 950480.5228934288
rmesh_equiv_2023 vgnd.t35 vgnd.t73 121.61058086208551
rmesh_equiv_2024 vgnd.t36 vgnd.t82 909.95438447516642
rmesh_equiv_2025 vgnd.t37 vgnd.t52 171753.84412578866
rmesh_equiv_2026 vgnd.t37 vgnd.t57 398530.07620060549
rmesh_equiv_2027 vgnd.t37 vgnd.t58 63539.187690508064
rmesh_equiv_2028 vgnd.t38 vgnd.t43 85.412671344262492
rmesh_equiv_2029 vgnd.t38 vgnd.t60 31.670882631730301
rmesh_equiv_203 clk.n2 clk.n3 0.81771300000000002
rmesh_equiv_2030 vgnd.t38 vgnd.t96 24723.136090952059
rmesh_equiv_2031 vgnd.t4 vgnd.t71 1607202.5276874613
rmesh_equiv_2032 vgnd.t4 vgnd.t84 1017.1147324294219
rmesh_equiv_2033 vgnd.t42 vgnd.t7 1537622.8383881222
rmesh_equiv_2034 vgnd.t42 vgnd.t72 173467.90670117622
rmesh_equiv_2035 vgnd.t43 vgnd.t60 42.239420650828414
rmesh_equiv_2036 vgnd.t43 vgnd.t96 155092.65819440119
rmesh_equiv_2037 vgnd.t45 vgnd.t47 5706194.3741000425
rmesh_equiv_2038 vgnd.t45 vgnd.t76 911.47690777307969
rmesh_equiv_2039 vgnd.t46 vgnd.t68 45.093009885334524
rmesh_equiv_204 clk.n3 clk.n4 1.6466799999999999
rmesh_equiv_2040 vgnd.t46 vgnd.t74 121.61058086208551
rmesh_equiv_2041 vgnd.t47 vgnd.t76 57553.55297423833
rmesh_equiv_2042 vgnd.t49 vgnd.t61 54.584672371098044
rmesh_equiv_2043 vgnd.t5 vgnd.t90 1317.4486750395165
rmesh_equiv_2044 vgnd.t50 vgnd.t91 43.622305201072088
rmesh_equiv_2045 vgnd.t50 vgnd.t94 124571.50386004498
rmesh_equiv_2046 vgnd.t51 vgnd.t92 57890.317998324361
rmesh_equiv_2047 vgnd.t52 vgnd.t57 1181.6006010254168
rmesh_equiv_2048 vgnd.t52 vgnd.t58 188.38714277107553
rmesh_equiv_2049 vgnd.t53 vgnd.t78 121.61058086208551
rmesh_equiv_205 cmp cmp.n0 12.8005
rmesh_equiv_2050 vgnd.t57 vgnd.t58 95.08488260517602
rmesh_equiv_2051 vgnd.t59 vgnd.t75 5468468.0935017057
rmesh_equiv_2052 vgnd.t59 vgnd.t95 9084140006.4776134
rmesh_equiv_2053 vgnd.t60 vgnd.t96 57508.11088579653
rmesh_equiv_2054 vgnd.t64 vgnd.t81 177427.04725293306
rmesh_equiv_2055 vgnd.t68 vgnd.t74 45.093009885334524
rmesh_equiv_2056 vgnd.t69 vgnd.t89 925.2370247472511
rmesh_equiv_2057 vgnd.t69 vgnd.t9 1007.6505487829022
rmesh_equiv_2058 vgnd.t7 vgnd.t72 1165613.3297219304
rmesh_equiv_2059 vgnd.t71 vgnd.t84 14509.884609782126
rmesh_equiv_206 cmp cmp.n1 12.8005
rmesh_equiv_2060 vgnd.t75 vgnd.t95 15253.760302725605
rmesh_equiv_2061 vgnd.t79 vgnd.t87 1001.873856988957
rmesh_equiv_2062 vgnd.t83 vgnd.t85 939.98294979442539
rmesh_equiv_2063 vgnd.t86 vgnd.t97 1027.333339265763
rmesh_equiv_2064 vgnd.t89 vgnd.t9 100428.97501237382
rmesh_equiv_2065 vgnd.t91 vgnd.t94 46190.915421762453
rmesh_equiv_2066 vin vin.t0 332.71199999999999
rmesh_equiv_207 cmp cmp.n10 5.4168500000000002
rmesh_equiv_208 cmp cmp.n15 12.8005
rmesh_equiv_209 cmp cmp.n2 12.8005
rmesh_equiv_21 amplified.n15 amplified.n16 16.867000000000001
rmesh_equiv_210 cmp cmp.n4 17.948799999999999
rmesh_equiv_211 cmp cmp.n6 20.2395
rmesh_equiv_212 cmp cmp.n8 31.751799999999999
rmesh_equiv_213 cmp.n0 cmp.n14 10.151300000000001
rmesh_equiv_214 cmp.n0 cmp.t0 255.34500000000003
rmesh_equiv_215 cmp.n1 cmp.n3 10.151300000000001
rmesh_equiv_216 cmp.n1 cmp.t1 700.48400000000004
rmesh_equiv_217 cmp.n10 cmp.n11 1.7058199999999999
rmesh_equiv_218 cmp.n10 cmp.n9 31.473199999999995
rmesh_equiv_219 cmp.n11 cmp.n12 17.2837
rmesh_equiv_22 amplified.n15 amplified.t1 22.564800000000002
rmesh_equiv_220 cmp.n11 cmp.n8 2.60127
rmesh_equiv_221 cmp.n12 cmp.n13 2.7511700000000001
rmesh_equiv_222 cmp.n12 cmp.n7 18.100899999999999
rmesh_equiv_223 cmp.n13 cmp.n14 17.2837
rmesh_equiv_224 cmp.n13 cmp.n3 18.100899999999999
rmesh_equiv_225 cmp.n14 cmp.n15 10.151300000000001
rmesh_equiv_226 cmp.n15 cmp.t0 255.34500000000003
rmesh_equiv_227 cmp.n2 cmp.n3 10.151300000000001
rmesh_equiv_228 cmp.n2 cmp.t1 700.48400000000004
rmesh_equiv_229 cmp.n4 cmp.n5 48.279000000000003
rmesh_equiv_23 amplified.n16 amplified.n17 2.4407800000000002
rmesh_equiv_230 cmp.n4 cmp.n7 2.38164
rmesh_equiv_231 cmp.n5 cmp.n6 54.441600000000001
rmesh_equiv_232 cmp.n5 cmp.t3 3.5711299999999997
rmesh_equiv_233 cmp.n6 cmp.n7 0.71089000000000002
rmesh_equiv_234 cmp.n8 cmp.n9 37.418900000000001
rmesh_equiv_235 cmp.n9 cmp.t2 4.3505000000000003
rmesh_equiv_236 comparator__pre comparator__pre.n0 22.8553
rmesh_equiv_237 comparator__pre comparator__pre.n1 17.834954327507095
rmesh_equiv_238 comparator__pre comparator__pre.n2 6.3200399999999997
rmesh_equiv_239 comparator__pre comparator__pre.n4 33.130400000000002
rmesh_equiv_24 amplified.n17 amplified.t0 387.11000000000001
rmesh_equiv_240 comparator__pre comparator__pre.n8 4.8770699999999998
rmesh_equiv_241 comparator__pre comparator__pre.t2 1511.24
rmesh_equiv_242 comparator__pre comparator__pre.t3 854.11400000000003
rmesh_equiv_243 comparator__pre.n0 comparator__pre.n7 11.4361
rmesh_equiv_244 comparator__pre.n0 comparator__pre.t0 381.113
rmesh_equiv_245 comparator__pre.n1 comparator__pre.n6 2.1513399999999998
rmesh_equiv_246 comparator__pre.n2 comparator__pre.n3 13.389300000000002
rmesh_equiv_247 comparator__pre.n2 comparator__pre.n5 0.75515399999999999
rmesh_equiv_248 comparator__pre.n3 comparator__pre.n4 14.121399999999998
rmesh_equiv_249 comparator__pre.n3 comparator__pre.t1 1.7404999999999999
rmesh_equiv_25 amplified.n2 amplified.n3 13.200100000000001
rmesh_equiv_250 comparator__pre.n4 comparator__pre.n5 1.13588
rmesh_equiv_251 comparator__pre.n5 comparator__pre.n6 19.3293
rmesh_equiv_252 comparator__pre.n6 comparator__pre.n7 16.554500000000001
rmesh_equiv_253 comparator__pre.n7 comparator__pre.n8 2.4407800000000002
rmesh_equiv_254 comparator__pre.n8 comparator__pre.t0 387.11000000000001
rmesh_equiv_255 comparator__preamp__mir comparator__preamp__mir.n0 6.3200399999999997
rmesh_equiv_256 comparator__preamp__mir comparator__preamp__mir.n1 15.571552633952864
rmesh_equiv_257 comparator__preamp__mir comparator__preamp__mir.n2 4.8770699999999998
rmesh_equiv_258 comparator__preamp__mir comparator__preamp__mir.n3 22.8553
rmesh_equiv_259 comparator__preamp__mir comparator__preamp__mir.n8 33.130400000000002
rmesh_equiv_26 amplified.n2 amplified.t3 0.71462499999999995
rmesh_equiv_260 comparator__preamp__mir comparator__preamp__mir.t1 572.84699999999998
rmesh_equiv_261 comparator__preamp__mir comparator__preamp__mir.t3 572.84699999999998
rmesh_equiv_262 comparator__preamp__mir.n0 comparator__preamp__mir.n6 0.75515399999999999
rmesh_equiv_263 comparator__preamp__mir.n0 comparator__preamp__mir.n7 13.389300000000002
rmesh_equiv_264 comparator__preamp__mir.n1 comparator__preamp__mir.n5 0.39353700000000003
rmesh_equiv_265 comparator__preamp__mir.n2 comparator__preamp__mir.n4 2.4407800000000002
rmesh_equiv_266 comparator__preamp__mir.n2 comparator__preamp__mir.t2 387.11000000000001
rmesh_equiv_267 comparator__preamp__mir.n3 comparator__preamp__mir.n4 11.4361
rmesh_equiv_268 comparator__preamp__mir.n3 comparator__preamp__mir.t2 381.113
rmesh_equiv_269 comparator__preamp__mir.n4 comparator__preamp__mir.n5 17.387899999999998
rmesh_equiv_27 amplified.n3 amplified.n4 0.27270899999999998
rmesh_equiv_270 comparator__preamp__mir.n5 comparator__preamp__mir.n6 18.305
rmesh_equiv_271 comparator__preamp__mir.n6 comparator__preamp__mir.n8 1.13588
rmesh_equiv_272 comparator__preamp__mir.n7 comparator__preamp__mir.n8 14.121399999999998
rmesh_equiv_273 comparator__preamp__mir.n7 comparator__preamp__mir.t0 1.7404999999999999
rmesh_equiv_274 comparator__preamp__tail comparator__preamp__tail.n0 19.837
rmesh_equiv_275 comparator__preamp__tail comparator__preamp__tail.n1 7.0733300000000003
rmesh_equiv_276 comparator__preamp__tail comparator__preamp__tail.n11 4.2590000000000003
rmesh_equiv_277 comparator__preamp__tail comparator__preamp__tail.n3 26.391300000000001
rmesh_equiv_278 comparator__preamp__tail comparator__preamp__tail.n5 6.3200399999999997
rmesh_equiv_279 comparator__preamp__tail comparator__preamp__tail.n7 33.130400000000002
rmesh_equiv_28 amplified.n4 amplified.n8 17.471599999999999
rmesh_equiv_280 comparator__preamp__tail.n0 comparator__preamp__tail.n10 14.189499999999999
rmesh_equiv_281 comparator__preamp__tail.n0 comparator__preamp__tail.t0 174.91200000000001
rmesh_equiv_282 comparator__preamp__tail.n1 comparator__preamp__tail.n2 14.985300000000001
rmesh_equiv_283 comparator__preamp__tail.n1 comparator__preamp__tail.n4 0.24337299999999998
rmesh_equiv_284 comparator__preamp__tail.n10 comparator__preamp__tail.n11 3.0467200000000001
rmesh_equiv_285 comparator__preamp__tail.n10 comparator__preamp__tail.n9 19.470400000000001
rmesh_equiv_286 comparator__preamp__tail.n11 comparator__preamp__tail.t0 181.41
rmesh_equiv_287 comparator__preamp__tail.n2 comparator__preamp__tail.n3 11.248699999999999
rmesh_equiv_288 comparator__preamp__tail.n2 comparator__preamp__tail.t1 1.7404999999999999
rmesh_equiv_289 comparator__preamp__tail.n3 comparator__preamp__tail.n4 3.1501399999999999
rmesh_equiv_29 amplified.n5 amplified.n7 14.189499999999999
rmesh_equiv_290 comparator__preamp__tail.n4 comparator__preamp__tail.n9 17.881799999999998
rmesh_equiv_291 comparator__preamp__tail.n5 comparator__preamp__tail.n6 13.389300000000002
rmesh_equiv_292 comparator__preamp__tail.n5 comparator__preamp__tail.n8 0.75515399999999999
rmesh_equiv_293 comparator__preamp__tail.n6 comparator__preamp__tail.n7 14.121399999999998
rmesh_equiv_294 comparator__preamp__tail.n6 comparator__preamp__tail.t2 1.7404999999999999
rmesh_equiv_295 comparator__preamp__tail.n7 comparator__preamp__tail.n8 1.13588
rmesh_equiv_296 comparator__preamp__tail.n8 comparator__preamp__tail.n9 16.9712
rmesh_equiv_297 d d.n0 12.8005
rmesh_equiv_298 d d.n1 12.8005
rmesh_equiv_299 d d.n11 12.8005
rmesh_equiv_3 amplified amplified.n12 20.370899999999999
rmesh_equiv_30 amplified.n5 amplified.t4 174.91200000000001
rmesh_equiv_300 d d.n12 12.8005
rmesh_equiv_301 d d.n15 12.8005
rmesh_equiv_302 d d.n16 12.8005
rmesh_equiv_303 d d.n2 12.8005
rmesh_equiv_304 d d.n21 12.8005
rmesh_equiv_305 d d.n4 12.8005
rmesh_equiv_306 d d.n5 12.8005
rmesh_equiv_307 d d.n7 12.8005
rmesh_equiv_308 d d.n8 12.8005
rmesh_equiv_309 d.n0 d.n20 10.151300000000001
rmesh_equiv_31 amplified.n6 amplified.n7 3.0467200000000001
rmesh_equiv_310 d.n0 d.t0 255.34500000000003
rmesh_equiv_311 d.n1 d.n3 10.151300000000001
rmesh_equiv_312 d.n1 d.t5 700.48400000000004
rmesh_equiv_313 d.n10 d.n14 0.81771300000000002
rmesh_equiv_314 d.n10 d.n6 18.517600000000002
rmesh_equiv_315 d.n10 d.n9 17.700399999999998
rmesh_equiv_316 d.n11 d.n13 10.151300000000001
rmesh_equiv_317 d.n11 d.t3 255.34500000000003
rmesh_equiv_318 d.n12 d.n13 10.151300000000001
rmesh_equiv_319 d.n12 d.t3 255.34500000000003
rmesh_equiv_32 amplified.n6 amplified.t4 181.41
rmesh_equiv_320 d.n13 d.n14 17.700399999999998
rmesh_equiv_321 d.n14 d.n18 0.81771300000000002
rmesh_equiv_322 d.n15 d.n17 10.151300000000001
rmesh_equiv_323 d.n15 d.t1 700.48400000000004
rmesh_equiv_324 d.n16 d.n17 10.151300000000001
rmesh_equiv_325 d.n16 d.t1 700.48400000000004
rmesh_equiv_326 d.n17 d.n18 17.700399999999998
rmesh_equiv_327 d.n18 d.n19 2.7576399999999999
rmesh_equiv_328 d.n19 d.n20 17.700399999999998
rmesh_equiv_329 d.n19 d.n3 18.517600000000002
rmesh_equiv_33 amplified.n7 amplified.n8 16.554500000000001
rmesh_equiv_330 d.n2 d.n3 10.151300000000001
rmesh_equiv_331 d.n2 d.t5 700.48400000000004
rmesh_equiv_332 d.n20 d.n21 10.151300000000001
rmesh_equiv_333 d.n21 d.t0 255.34500000000003
rmesh_equiv_334 d.n4 d.n6 10.151300000000001
rmesh_equiv_335 d.n4 d.t2 255.34500000000003
rmesh_equiv_336 d.n5 d.n6 10.151300000000001
rmesh_equiv_337 d.n5 d.t2 255.34500000000003
rmesh_equiv_338 d.n7 d.n9 10.151300000000001
rmesh_equiv_339 d.n7 d.t4 700.48400000000004
rmesh_equiv_34 amplified.n8 amplified.n9 13.727399999999999
rmesh_equiv_340 d.n8 d.n9 10.151300000000001
rmesh_equiv_341 d.n8 d.t4 700.48400000000004
rmesh_equiv_342 data data.n0 12.8005
rmesh_equiv_343 data data.n1 12.8005
rmesh_equiv_344 data data.n10 12.8005
rmesh_equiv_345 data data.n14 12.8005
rmesh_equiv_346 data data.n2 12.8005
rmesh_equiv_347 data data.n4 264.95400000000001
rmesh_equiv_348 data data.n5 12.8005
rmesh_equiv_349 data data.n6 12.8005
rmesh_equiv_35 amplified.n9 amplified.t6 28.510400000000001
rmesh_equiv_350 data data.n9 12.8005
rmesh_equiv_351 data.n0 data.n13 10.151300000000001
rmesh_equiv_352 data.n0 data.t0 255.34500000000003
rmesh_equiv_353 data.n1 data.n3 10.151300000000001
rmesh_equiv_354 data.n1 data.t2 255.34500000000003
rmesh_equiv_355 data.n10 data.n11 10.151300000000001
rmesh_equiv_356 data.n10 data.t1 700.48400000000004
rmesh_equiv_357 data.n11 data.n12 19.7837
rmesh_equiv_358 data.n11 data.n9 10.151300000000001
rmesh_equiv_359 data.n12 data.n13 20.600899999999999
rmesh_equiv_36 bias bias.n0 4.2590000000000003
rmesh_equiv_360 data.n12 data.n8 5.5159500000000001
rmesh_equiv_361 data.n13 data.n14 10.151300000000001
rmesh_equiv_362 data.n14 data.t0 255.34500000000003
rmesh_equiv_363 data.n2 data.n3 10.151300000000001
rmesh_equiv_364 data.n2 data.t2 255.34500000000003
rmesh_equiv_365 data.n3 data.n4 19.7837
rmesh_equiv_366 data.n4 data.n8 0.81771300000000002
rmesh_equiv_367 data.n5 data.n7 10.151300000000001
rmesh_equiv_368 data.n5 data.t3 700.48400000000004
rmesh_equiv_369 data.n6 data.n7 10.151300000000001
rmesh_equiv_37 bias bias.n1 19.837
rmesh_equiv_370 data.n6 data.t3 700.48400000000004
rmesh_equiv_371 data.n7 data.n8 19.7837
rmesh_equiv_372 data.n9 data.t1 700.48400000000004
rmesh_equiv_373 filter__buffer0__comp.n0 filter__buffer0__comp.n1 4.1529499999999997
rmesh_equiv_374 filter__buffer0__comp.n0 filter__buffer0__comp.t0 4.7185199999999998
rmesh_equiv_375 filter__buffer0__comp.n0 filter__buffer0__comp.t3 26.609300000000001
rmesh_equiv_376 filter__buffer0__comp.n1 filter__buffer0__comp.n2 8.8629599999999993
rmesh_equiv_377 filter__buffer0__comp.n1 filter__buffer0__comp.t1 4.7185199999999998
rmesh_equiv_378 filter__buffer0__comp.n2 filter__buffer0__comp.t2 0.025939499999999997
rmesh_equiv_379 filter__buffer0__first__mir filter__buffer0__first__mir.n0 22.8553
rmesh_equiv_38 bias bias.n10 34.662100000000002
rmesh_equiv_380 filter__buffer0__first__mir filter__buffer0__first__mir.n1 15.154782797543261
rmesh_equiv_381 filter__buffer0__first__mir filter__buffer0__first__mir.n2 6.3200399999999997
rmesh_equiv_382 filter__buffer0__first__mir filter__buffer0__first__mir.n4 33.130400000000002
rmesh_equiv_383 filter__buffer0__first__mir filter__buffer0__first__mir.n8 4.8770699999999998
rmesh_equiv_384 filter__buffer0__first__mir filter__buffer0__first__mir.t0 572.84699999999998
rmesh_equiv_385 filter__buffer0__first__mir filter__buffer0__first__mir.t3 572.84699999999998
rmesh_equiv_386 filter__buffer0__first__mir.n0 filter__buffer0__first__mir.n7 11.4361
rmesh_equiv_387 filter__buffer0__first__mir.n0 filter__buffer0__first__mir.t1 381.113
rmesh_equiv_388 filter__buffer0__first__mir.n1 filter__buffer0__first__mir.n6 0.39353700000000003
rmesh_equiv_389 filter__buffer0__first__mir.n2 filter__buffer0__first__mir.n3 13.389300000000002
rmesh_equiv_39 bias bias.n11 34.662100000000002
rmesh_equiv_390 filter__buffer0__first__mir.n2 filter__buffer0__first__mir.n5 0.75515399999999999
rmesh_equiv_391 filter__buffer0__first__mir.n3 filter__buffer0__first__mir.n4 14.121399999999998
rmesh_equiv_392 filter__buffer0__first__mir.n3 filter__buffer0__first__mir.t2 1.7404999999999999
rmesh_equiv_393 filter__buffer0__first__mir.n4 filter__buffer0__first__mir.n5 1.13588
rmesh_equiv_394 filter__buffer0__first__mir.n5 filter__buffer0__first__mir.n6 17.471599999999999
rmesh_equiv_395 filter__buffer0__first__mir.n6 filter__buffer0__first__mir.n7 16.554500000000001
rmesh_equiv_396 filter__buffer0__first__mir.n7 filter__buffer0__first__mir.n8 2.4407800000000002
rmesh_equiv_397 filter__buffer0__first__mir.n8 filter__buffer0__first__mir.t1 387.11000000000001
rmesh_equiv_398 filter__buffer0__first__tail filter__buffer0__first__tail.n0 19.837
rmesh_equiv_399 filter__buffer0__first__tail filter__buffer0__first__tail.n1 7.0733300000000003
rmesh_equiv_4 amplified amplified.n17 4.8770699999999998
rmesh_equiv_40 bias bias.n12 34.662100000000002
rmesh_equiv_400 filter__buffer0__first__tail filter__buffer0__first__tail.n11 4.2590000000000003
rmesh_equiv_401 filter__buffer0__first__tail filter__buffer0__first__tail.n3 26.391300000000001
rmesh_equiv_402 filter__buffer0__first__tail filter__buffer0__first__tail.n5 6.3200399999999997
rmesh_equiv_403 filter__buffer0__first__tail filter__buffer0__first__tail.n7 33.130400000000002
rmesh_equiv_404 filter__buffer0__first__tail.n0 filter__buffer0__first__tail.n10 14.189499999999999
rmesh_equiv_405 filter__buffer0__first__tail.n0 filter__buffer0__first__tail.t0 174.91200000000001
rmesh_equiv_406 filter__buffer0__first__tail.n1 filter__buffer0__first__tail.n2 14.985300000000001
rmesh_equiv_407 filter__buffer0__first__tail.n1 filter__buffer0__first__tail.n4 0.24337299999999998
rmesh_equiv_408 filter__buffer0__first__tail.n10 filter__buffer0__first__tail.n11 3.0467200000000001
rmesh_equiv_409 filter__buffer0__first__tail.n10 filter__buffer0__first__tail.n9 22.3871
rmesh_equiv_41 bias bias.n13 20.917496187879877
rmesh_equiv_410 filter__buffer0__first__tail.n11 filter__buffer0__first__tail.t0 181.41
rmesh_equiv_411 filter__buffer0__first__tail.n2 filter__buffer0__first__tail.n3 11.248699999999999
rmesh_equiv_412 filter__buffer0__first__tail.n2 filter__buffer0__first__tail.t1 1.7404999999999999
rmesh_equiv_413 filter__buffer0__first__tail.n3 filter__buffer0__first__tail.n4 3.1501399999999999
rmesh_equiv_414 filter__buffer0__first__tail.n4 filter__buffer0__first__tail.n9 20.798500000000001
rmesh_equiv_415 filter__buffer0__first__tail.n5 filter__buffer0__first__tail.n6 13.389300000000002
rmesh_equiv_416 filter__buffer0__first__tail.n5 filter__buffer0__first__tail.n8 0.75515399999999999
rmesh_equiv_417 filter__buffer0__first__tail.n6 filter__buffer0__first__tail.n7 14.121399999999998
rmesh_equiv_418 filter__buffer0__first__tail.n6 filter__buffer0__first__tail.t2 1.7404999999999999
rmesh_equiv_419 filter__buffer0__first__tail.n7 filter__buffer0__first__tail.n8 1.13588
rmesh_equiv_42 bias bias.n3 0.25606299999999999
rmesh_equiv_420 filter__buffer0__first__tail.n8 filter__buffer0__first__tail.n9 19.887899999999998
rmesh_equiv_421 filter__buffer0__pre filter__buffer0__pre.n0 6.3200399999999997
rmesh_equiv_422 filter__buffer0__pre filter__buffer0__pre.n1 2.9479326624577999
rmesh_equiv_423 filter__buffer0__pre filter__buffer0__pre.n10 33.130400000000002
rmesh_equiv_424 filter__buffer0__pre filter__buffer0__pre.n2 4.4774000000000003
rmesh_equiv_425 filter__buffer0__pre filter__buffer0__pre.n3 26.799300000000002
rmesh_equiv_426 filter__buffer0__pre filter__buffer0__pre.n4 4.8770699999999998
rmesh_equiv_427 filter__buffer0__pre filter__buffer0__pre.n5 22.8553
rmesh_equiv_428 filter__buffer0__pre filter__buffer0__pre.t2 0.00141837
rmesh_equiv_429 filter__buffer0__pre filter__buffer0__pre.t3 1054.8499999999999
rmesh_equiv_43 bias bias.n4 34.662100000000002
rmesh_equiv_430 filter__buffer0__pre filter__buffer0__pre.t4 0.00141837
rmesh_equiv_431 filter__buffer0__pre filter__buffer0__pre.t5 0.00141837
rmesh_equiv_432 filter__buffer0__pre.n0 filter__buffer0__pre.n8 0.75515399999999999
rmesh_equiv_433 filter__buffer0__pre.n0 filter__buffer0__pre.n9 13.389300000000002
rmesh_equiv_434 filter__buffer0__pre.n1 filter__buffer0__pre.n2 4.1529499999999997
rmesh_equiv_435 filter__buffer0__pre.n10 filter__buffer0__pre.n8 1.13588
rmesh_equiv_436 filter__buffer0__pre.n10 filter__buffer0__pre.n9 14.121399999999998
rmesh_equiv_437 filter__buffer0__pre.n2 filter__buffer0__pre.n3 3.1113099999999996
rmesh_equiv_438 filter__buffer0__pre.n3 filter__buffer0__pre.n7 2.2512099999999999
rmesh_equiv_439 filter__buffer0__pre.n4 filter__buffer0__pre.n6 2.4407800000000002
rmesh_equiv_44 bias bias.n6 34.662100000000002
rmesh_equiv_440 filter__buffer0__pre.n4 filter__buffer0__pre.t1 387.11000000000001
rmesh_equiv_441 filter__buffer0__pre.n5 filter__buffer0__pre.n6 11.4361
rmesh_equiv_442 filter__buffer0__pre.n5 filter__buffer0__pre.t1 381.113
rmesh_equiv_443 filter__buffer0__pre.n6 filter__buffer0__pre.n7 16.9712
rmesh_equiv_444 filter__buffer0__pre.n7 filter__buffer0__pre.n8 19.745999999999999
rmesh_equiv_445 filter__buffer0__pre.n9 filter__buffer0__pre.t0 1.7404999999999999
rmesh_equiv_446 filter__buffer1__comp.n0 filter__buffer1__comp.n1 4.1529499999999997
rmesh_equiv_447 filter__buffer1__comp.n0 filter__buffer1__comp.t2 8.8709699999999998
rmesh_equiv_448 filter__buffer1__comp.n0 filter__buffer1__comp.t3 4.7185199999999998
rmesh_equiv_449 filter__buffer1__comp.n1 filter__buffer1__comp.t0 26.609300000000001
rmesh_equiv_45 bias bias.n7 34.662100000000002
rmesh_equiv_450 filter__buffer1__comp.n1 filter__buffer1__comp.t1 4.7185199999999998
rmesh_equiv_451 filter__buffer1__first__mir filter__buffer1__first__mir.n0 22.8553
rmesh_equiv_452 filter__buffer1__first__mir filter__buffer1__first__mir.n1 15.154782797543261
rmesh_equiv_453 filter__buffer1__first__mir filter__buffer1__first__mir.n2 6.3200399999999997
rmesh_equiv_454 filter__buffer1__first__mir filter__buffer1__first__mir.n4 33.130400000000002
rmesh_equiv_455 filter__buffer1__first__mir filter__buffer1__first__mir.n8 4.8770699999999998
rmesh_equiv_456 filter__buffer1__first__mir filter__buffer1__first__mir.t0 572.84699999999998
rmesh_equiv_457 filter__buffer1__first__mir filter__buffer1__first__mir.t3 572.84699999999998
rmesh_equiv_458 filter__buffer1__first__mir.n0 filter__buffer1__first__mir.n7 11.4361
rmesh_equiv_459 filter__buffer1__first__mir.n0 filter__buffer1__first__mir.t1 381.113
rmesh_equiv_46 bias bias.n8 34.662100000000002
rmesh_equiv_460 filter__buffer1__first__mir.n1 filter__buffer1__first__mir.n6 0.39353700000000003
rmesh_equiv_461 filter__buffer1__first__mir.n2 filter__buffer1__first__mir.n3 13.389300000000002
rmesh_equiv_462 filter__buffer1__first__mir.n2 filter__buffer1__first__mir.n5 0.75515399999999999
rmesh_equiv_463 filter__buffer1__first__mir.n3 filter__buffer1__first__mir.n4 14.121399999999998
rmesh_equiv_464 filter__buffer1__first__mir.n3 filter__buffer1__first__mir.t2 1.7404999999999999
rmesh_equiv_465 filter__buffer1__first__mir.n4 filter__buffer1__first__mir.n5 1.13588
rmesh_equiv_466 filter__buffer1__first__mir.n5 filter__buffer1__first__mir.n6 17.471599999999999
rmesh_equiv_467 filter__buffer1__first__mir.n6 filter__buffer1__first__mir.n7 16.554500000000001
rmesh_equiv_468 filter__buffer1__first__mir.n7 filter__buffer1__first__mir.n8 2.4407800000000002
rmesh_equiv_469 filter__buffer1__first__mir.n8 filter__buffer1__first__mir.t1 387.11000000000001
rmesh_equiv_47 bias bias.n9 34.662100000000002
rmesh_equiv_470 filter__buffer1__first__tail filter__buffer1__first__tail.n0 19.837
rmesh_equiv_471 filter__buffer1__first__tail filter__buffer1__first__tail.n1 7.0733300000000003
rmesh_equiv_472 filter__buffer1__first__tail filter__buffer1__first__tail.n11 4.2590000000000003
rmesh_equiv_473 filter__buffer1__first__tail filter__buffer1__first__tail.n3 26.391300000000001
rmesh_equiv_474 filter__buffer1__first__tail filter__buffer1__first__tail.n5 6.3200399999999997
rmesh_equiv_475 filter__buffer1__first__tail filter__buffer1__first__tail.n7 33.130400000000002
rmesh_equiv_476 filter__buffer1__first__tail.n0 filter__buffer1__first__tail.n10 14.189499999999999
rmesh_equiv_477 filter__buffer1__first__tail.n0 filter__buffer1__first__tail.t0 174.91200000000001
rmesh_equiv_478 filter__buffer1__first__tail.n1 filter__buffer1__first__tail.n2 14.985300000000001
rmesh_equiv_479 filter__buffer1__first__tail.n1 filter__buffer1__first__tail.n4 0.24337299999999998
rmesh_equiv_48 bias bias.t0 139.911
rmesh_equiv_480 filter__buffer1__first__tail.n10 filter__buffer1__first__tail.n11 3.0467200000000001
rmesh_equiv_481 filter__buffer1__first__tail.n10 filter__buffer1__first__tail.n9 22.3871
rmesh_equiv_482 filter__buffer1__first__tail.n11 filter__buffer1__first__tail.t0 181.41
rmesh_equiv_483 filter__buffer1__first__tail.n2 filter__buffer1__first__tail.n3 11.248699999999999
rmesh_equiv_484 filter__buffer1__first__tail.n2 filter__buffer1__first__tail.t1 1.7404999999999999
rmesh_equiv_485 filter__buffer1__first__tail.n3 filter__buffer1__first__tail.n4 3.1501399999999999
rmesh_equiv_486 filter__buffer1__first__tail.n4 filter__buffer1__first__tail.n9 20.798500000000001
rmesh_equiv_487 filter__buffer1__first__tail.n5 filter__buffer1__first__tail.n6 13.389300000000002
rmesh_equiv_488 filter__buffer1__first__tail.n5 filter__buffer1__first__tail.n8 0.75515399999999999
rmesh_equiv_489 filter__buffer1__first__tail.n6 filter__buffer1__first__tail.n7 14.121399999999998
rmesh_equiv_49 bias bias.t10 139.911
rmesh_equiv_490 filter__buffer1__first__tail.n6 filter__buffer1__first__tail.t2 1.7404999999999999
rmesh_equiv_491 filter__buffer1__first__tail.n7 filter__buffer1__first__tail.n8 1.13588
rmesh_equiv_492 filter__buffer1__first__tail.n8 filter__buffer1__first__tail.n9 19.887899999999998
rmesh_equiv_493 filter__buffer1__pre filter__buffer1__pre.n0 6.3200399999999997
rmesh_equiv_494 filter__buffer1__pre filter__buffer1__pre.n1 2.9479326624577999
rmesh_equiv_495 filter__buffer1__pre filter__buffer1__pre.n10 33.130400000000002
rmesh_equiv_496 filter__buffer1__pre filter__buffer1__pre.n2 4.4774000000000003
rmesh_equiv_497 filter__buffer1__pre filter__buffer1__pre.n3 26.799300000000002
rmesh_equiv_498 filter__buffer1__pre filter__buffer1__pre.n4 4.8770699999999998
rmesh_equiv_499 filter__buffer1__pre filter__buffer1__pre.n5 22.8553
rmesh_equiv_5 amplified amplified.n3 6.9688099999999995
rmesh_equiv_50 bias bias.t11 139.911
rmesh_equiv_500 filter__buffer1__pre filter__buffer1__pre.t2 0.00141837
rmesh_equiv_501 filter__buffer1__pre filter__buffer1__pre.t3 1054.8499999999999
rmesh_equiv_502 filter__buffer1__pre filter__buffer1__pre.t4 0.00141837
rmesh_equiv_503 filter__buffer1__pre filter__buffer1__pre.t5 0.00141837
rmesh_equiv_504 filter__buffer1__pre.n0 filter__buffer1__pre.n8 0.75515399999999999
rmesh_equiv_505 filter__buffer1__pre.n0 filter__buffer1__pre.n9 13.389300000000002
rmesh_equiv_506 filter__buffer1__pre.n1 filter__buffer1__pre.n2 4.1529499999999997
rmesh_equiv_507 filter__buffer1__pre.n10 filter__buffer1__pre.n8 1.13588
rmesh_equiv_508 filter__buffer1__pre.n10 filter__buffer1__pre.n9 14.121399999999998
rmesh_equiv_509 filter__buffer1__pre.n2 filter__buffer1__pre.n3 3.1113099999999996
rmesh_equiv_51 bias bias.t3 139.911
rmesh_equiv_510 filter__buffer1__pre.n3 filter__buffer1__pre.n7 2.2512099999999999
rmesh_equiv_511 filter__buffer1__pre.n4 filter__buffer1__pre.n6 2.4407800000000002
rmesh_equiv_512 filter__buffer1__pre.n4 filter__buffer1__pre.t1 387.11000000000001
rmesh_equiv_513 filter__buffer1__pre.n5 filter__buffer1__pre.n6 11.4361
rmesh_equiv_514 filter__buffer1__pre.n5 filter__buffer1__pre.t1 381.113
rmesh_equiv_515 filter__buffer1__pre.n6 filter__buffer1__pre.n7 16.9712
rmesh_equiv_516 filter__buffer1__pre.n7 filter__buffer1__pre.n8 19.745999999999999
rmesh_equiv_517 filter__buffer1__pre.n9 filter__buffer1__pre.t0 1.7404999999999999
rmesh_equiv_518 filter__filter0 filter__filter0.n0 4.3646000000000003
rmesh_equiv_519 filter__filter0 filter__filter0.n1 4.3646000000000003
rmesh_equiv_52 bias bias.t4 139.911
rmesh_equiv_520 filter__filter0 filter__filter0.n10 4.3646000000000003
rmesh_equiv_521 filter__filter0 filter__filter0.n11 3.874288405577019
rmesh_equiv_522 filter__filter0 filter__filter0.n2 4.3646000000000003
rmesh_equiv_523 filter__filter0 filter__filter0.n3 4.3646000000000003
rmesh_equiv_524 filter__filter0 filter__filter0.n4 4.3646000000000003
rmesh_equiv_525 filter__filter0 filter__filter0.n5 4.3646000000000003
rmesh_equiv_526 filter__filter0 filter__filter0.n6 4.3646000000000003
rmesh_equiv_527 filter__filter0 filter__filter0.n7 4.3646000000000003
rmesh_equiv_528 filter__filter0 filter__filter0.n8 4.3646000000000003
rmesh_equiv_529 filter__filter0 filter__filter0.n9 4.3646000000000003
rmesh_equiv_53 bias bias.t5 139.911
rmesh_equiv_530 filter__filter0 filter__filter0.t1 0.00141837
rmesh_equiv_531 filter__filter0 filter__filter0.t10 0.00141837
rmesh_equiv_532 filter__filter0 filter__filter0.t11 0.00141837
rmesh_equiv_533 filter__filter0 filter__filter0.t12 0.00141837
rmesh_equiv_534 filter__filter0 filter__filter0.t13 0.00141837
rmesh_equiv_535 filter__filter0 filter__filter0.t2 0.00141837
rmesh_equiv_536 filter__filter0 filter__filter0.t3 332.71199999999999
rmesh_equiv_537 filter__filter0 filter__filter0.t4 0.00141837
rmesh_equiv_538 filter__filter0 filter__filter0.t5 0.00141837
rmesh_equiv_539 filter__filter0 filter__filter0.t6 0.00141837
rmesh_equiv_54 bias bias.t6 139.911
rmesh_equiv_540 filter__filter0 filter__filter0.t7 0.00141837
rmesh_equiv_541 filter__filter0 filter__filter0.t8 0.00141837
rmesh_equiv_542 filter__filter0 filter__filter0.t9 0.00141837
rmesh_equiv_543 filter__filter0.n0 filter__filter0.n1 4.1529499999999997
rmesh_equiv_544 filter__filter0.n0 filter__filter0.t0 25.293099999999999
rmesh_equiv_545 filter__filter0.n1 filter__filter0.n2 4.1529499999999997
rmesh_equiv_546 filter__filter0.n10 filter__filter0.n11 4.1529499999999997
rmesh_equiv_547 filter__filter0.n10 filter__filter0.n9 4.1529499999999997
rmesh_equiv_548 filter__filter0.n2 filter__filter0.n3 4.1529499999999997
rmesh_equiv_549 filter__filter0.n3 filter__filter0.n4 4.1529499999999997
rmesh_equiv_55 bias bias.t7 139.911
rmesh_equiv_550 filter__filter0.n4 filter__filter0.n5 4.1529499999999997
rmesh_equiv_551 filter__filter0.n5 filter__filter0.n6 4.1529499999999997
rmesh_equiv_552 filter__filter0.n6 filter__filter0.n7 4.1529499999999997
rmesh_equiv_553 filter__filter0.n7 filter__filter0.n8 4.1529499999999997
rmesh_equiv_554 filter__filter0.n8 filter__filter0.n9 4.1529499999999997
rmesh_equiv_555 filter__filter1 filter__filter1.n0 4.3646000000000003
rmesh_equiv_556 filter__filter1 filter__filter1.n1 4.3646000000000003
rmesh_equiv_557 filter__filter1 filter__filter1.n10 4.3646000000000003
rmesh_equiv_558 filter__filter1 filter__filter1.n11 3.874288405577019
rmesh_equiv_559 filter__filter1 filter__filter1.n2 4.3646000000000003
rmesh_equiv_56 bias bias.t8 139.911
rmesh_equiv_560 filter__filter1 filter__filter1.n3 4.3646000000000003
rmesh_equiv_561 filter__filter1 filter__filter1.n4 4.3646000000000003
rmesh_equiv_562 filter__filter1 filter__filter1.n5 4.3646000000000003
rmesh_equiv_563 filter__filter1 filter__filter1.n6 4.3646000000000003
rmesh_equiv_564 filter__filter1 filter__filter1.n7 4.3646000000000003
rmesh_equiv_565 filter__filter1 filter__filter1.n8 4.3646000000000003
rmesh_equiv_566 filter__filter1 filter__filter1.n9 4.3646000000000003
rmesh_equiv_567 filter__filter1 filter__filter1.t1 0.00141837
rmesh_equiv_568 filter__filter1 filter__filter1.t10 0.00141837
rmesh_equiv_569 filter__filter1 filter__filter1.t11 0.00141837
rmesh_equiv_57 bias bias.t9 139.911
rmesh_equiv_570 filter__filter1 filter__filter1.t12 0.00141837
rmesh_equiv_571 filter__filter1 filter__filter1.t13 0.00141837
rmesh_equiv_572 filter__filter1 filter__filter1.t2 0.00141837
rmesh_equiv_573 filter__filter1 filter__filter1.t3 0.00141837
rmesh_equiv_574 filter__filter1 filter__filter1.t4 0.00141837
rmesh_equiv_575 filter__filter1 filter__filter1.t5 0.00141837
rmesh_equiv_576 filter__filter1 filter__filter1.t6 0.00141837
rmesh_equiv_577 filter__filter1 filter__filter1.t7 0.00141837
rmesh_equiv_578 filter__filter1 filter__filter1.t8 332.71199999999999
rmesh_equiv_579 filter__filter1 filter__filter1.t9 0.00141837
rmesh_equiv_58 bias.n0 bias.n2 3.0467200000000001
rmesh_equiv_580 filter__filter1.n0 filter__filter1.n1 4.1529499999999997
rmesh_equiv_581 filter__filter1.n0 filter__filter1.t0 25.293099999999999
rmesh_equiv_582 filter__filter1.n1 filter__filter1.n2 4.1529499999999997
rmesh_equiv_583 filter__filter1.n10 filter__filter1.n11 4.1529499999999997
rmesh_equiv_584 filter__filter1.n10 filter__filter1.n9 4.1529499999999997
rmesh_equiv_585 filter__filter1.n2 filter__filter1.n3 4.1529499999999997
rmesh_equiv_586 filter__filter1.n3 filter__filter1.n4 4.1529499999999997
rmesh_equiv_587 filter__filter1.n4 filter__filter1.n5 4.1529499999999997
rmesh_equiv_588 filter__filter1.n5 filter__filter1.n6 4.1529499999999997
rmesh_equiv_589 filter__filter1.n6 filter__filter1.n7 4.1529499999999997
rmesh_equiv_59 bias.n0 bias.t1 181.41
rmesh_equiv_590 filter__filter1.n7 filter__filter1.n8 4.1529499999999997
rmesh_equiv_591 filter__filter1.n8 filter__filter1.n9 4.1529499999999997
rmesh_equiv_592 filter__mid filter__mid.n0 19.837
rmesh_equiv_593 filter__mid filter__mid.n2 33.9895
rmesh_equiv_594 filter__mid filter__mid.n4 6.9688099999999995
rmesh_equiv_595 filter__mid filter__mid.n6 38.661799999999999
rmesh_equiv_596 filter__mid filter__mid.n9 4.2590000000000003
rmesh_equiv_597 filter__mid filter__mid.t4 332.71199999999999
rmesh_equiv_598 filter__mid.n0 filter__mid.n8 14.189499999999999
rmesh_equiv_599 filter__mid.n0 filter__mid.t0 174.91200000000001
rmesh_equiv_6 amplified amplified.n5 19.837
rmesh_equiv_60 bias.n1 bias.n2 14.189499999999999
rmesh_equiv_600 filter__mid.n1 filter__mid.n7 13.727399999999999
rmesh_equiv_601 filter__mid.n1 filter__mid.t2 26.082799999999999
rmesh_equiv_602 filter__mid.n1 filter__mid.t3 32.260399999999997
rmesh_equiv_603 filter__mid.n2 filter__mid.n3 13.2728
rmesh_equiv_604 filter__mid.n2 filter__mid.n5 0.51338700000000004
rmesh_equiv_605 filter__mid.n3 filter__mid.n4 13.200100000000001
rmesh_equiv_606 filter__mid.n3 filter__mid.t1 0.71462499999999995
rmesh_equiv_607 filter__mid.n4 filter__mid.n5 0.27270899999999998
rmesh_equiv_608 filter__mid.n5 filter__mid.n6 20.304500000000001
rmesh_equiv_609 filter__mid.n6 filter__mid.n7 0.91758700000000015
rmesh_equiv_61 bias.n1 bias.t1 174.91200000000001
rmesh_equiv_610 filter__mid.n7 filter__mid.n8 20.304500000000001
rmesh_equiv_611 filter__mid.n8 filter__mid.n9 3.0467200000000001
rmesh_equiv_612 filter__mid.n9 filter__mid.t0 181.41
rmesh_equiv_613 gain gain.n0 26.929794993978522
rmesh_equiv_614 gain gain.n1 17.87115002789168
rmesh_equiv_615 gain gain.t0 3439.2399999999998
rmesh_equiv_616 gain gain.t1 315.88
rmesh_equiv_617 gain gain.t2 330.34100000000001
rmesh_equiv_618 gain.n0 gain.n1 0.81771300000000002
rmesh_equiv_619 out out.n0 33.479799999999997
rmesh_equiv_62 bias.n10 bias.n11 1.84643
rmesh_equiv_620 out out.n1 19.837
rmesh_equiv_621 out out.n10 28.40219322878918
rmesh_equiv_622 out out.n2 4.2590000000000003
rmesh_equiv_623 out out.n5 33.9895
rmesh_equiv_624 out out.n7 6.9688099999999995
rmesh_equiv_625 out out.t3 332.71199999999999
rmesh_equiv_626 out out.t4 332.71199999999999
rmesh_equiv_627 out.n0 out.n4 13.727399999999999
rmesh_equiv_628 out.n0 out.t0 29.343800000000005
rmesh_equiv_629 out.n1 out.n3 14.189499999999999
rmesh_equiv_63 bias.n10 bias.n9 76.193399999999997
rmesh_equiv_630 out.n1 out.t1 174.91200000000001
rmesh_equiv_631 out.n10 out.n9 3.3057699999999994
rmesh_equiv_632 out.n2 out.n3 3.0467200000000001
rmesh_equiv_633 out.n2 out.t1 181.41
rmesh_equiv_634 out.n3 out.n4 17.387899999999998
rmesh_equiv_635 out.n4 out.n9 0.91758700000000015
rmesh_equiv_636 out.n5 out.n6 13.2728
rmesh_equiv_637 out.n5 out.n8 0.51338700000000004
rmesh_equiv_638 out.n6 out.n7 13.200100000000001
rmesh_equiv_639 out.n6 out.t2 0.71462499999999995
rmesh_equiv_64 bias.n11 bias.n12 69.136300000000006
rmesh_equiv_640 out.n7 out.n8 0.27270899999999998
rmesh_equiv_641 out.n8 out.n9 17.387899999999998
rmesh_equiv_642 pga__amp__comp.n0 pga__amp__comp.n1 4.1529499999999997
rmesh_equiv_643 pga__amp__comp.n0 pga__amp__comp.t1 5.7337199999999999
rmesh_equiv_644 pga__amp__comp.n0 pga__amp__comp.t3 30.359300000000001
rmesh_equiv_645 pga__amp__comp.n1 pga__amp__comp.n2 9.8781599999999994
rmesh_equiv_646 pga__amp__comp.n1 pga__amp__comp.t0 5.7337199999999999
rmesh_equiv_647 pga__amp__comp.n2 pga__amp__comp.t2 0.025939499999999997
rmesh_equiv_648 pga__amp__first__mir pga__amp__first__mir.n0 6.3200399999999997
rmesh_equiv_649 pga__amp__first__mir pga__amp__first__mir.n1 15.154782797543261
rmesh_equiv_65 bias.n12 bias.n13 1.84643
rmesh_equiv_650 pga__amp__first__mir pga__amp__first__mir.n2 4.8770699999999998
rmesh_equiv_651 pga__amp__first__mir pga__amp__first__mir.n3 22.8553
rmesh_equiv_652 pga__amp__first__mir pga__amp__first__mir.n8 33.130400000000002
rmesh_equiv_653 pga__amp__first__mir pga__amp__first__mir.t1 572.84699999999998
rmesh_equiv_654 pga__amp__first__mir pga__amp__first__mir.t3 572.84699999999998
rmesh_equiv_655 pga__amp__first__mir.n0 pga__amp__first__mir.n6 0.75515399999999999
rmesh_equiv_656 pga__amp__first__mir.n0 pga__amp__first__mir.n7 13.389300000000002
rmesh_equiv_657 pga__amp__first__mir.n1 pga__amp__first__mir.n5 0.39353700000000003
rmesh_equiv_658 pga__amp__first__mir.n2 pga__amp__first__mir.n4 2.4407800000000002
rmesh_equiv_659 pga__amp__first__mir.n2 pga__amp__first__mir.t2 387.11000000000001
rmesh_equiv_66 bias.n2 bias.n3 18.2212
rmesh_equiv_660 pga__amp__first__mir.n3 pga__amp__first__mir.n4 11.4361
rmesh_equiv_661 pga__amp__first__mir.n3 pga__amp__first__mir.t2 381.113
rmesh_equiv_662 pga__amp__first__mir.n4 pga__amp__first__mir.n5 16.554500000000001
rmesh_equiv_663 pga__amp__first__mir.n5 pga__amp__first__mir.n6 17.471599999999999
rmesh_equiv_664 pga__amp__first__mir.n6 pga__amp__first__mir.n8 1.13588
rmesh_equiv_665 pga__amp__first__mir.n7 pga__amp__first__mir.n8 14.121399999999998
rmesh_equiv_666 pga__amp__first__mir.n7 pga__amp__first__mir.t0 1.7404999999999999
rmesh_equiv_667 pga__amp__first__tail pga__amp__first__tail.n0 6.3200399999999997
rmesh_equiv_668 pga__amp__first__tail pga__amp__first__tail.n1 19.837
rmesh_equiv_669 pga__amp__first__tail pga__amp__first__tail.n11 33.130400000000002
rmesh_equiv_67 bias.n3 bias.n4 0.39353700000000003
rmesh_equiv_670 pga__amp__first__tail pga__amp__first__tail.n2 4.2590000000000003
rmesh_equiv_671 pga__amp__first__tail pga__amp__first__tail.n4 7.0733300000000003
rmesh_equiv_672 pga__amp__first__tail pga__amp__first__tail.n6 26.391300000000001
rmesh_equiv_673 pga__amp__first__tail.n0 pga__amp__first__tail.n10 13.389300000000002
rmesh_equiv_674 pga__amp__first__tail.n0 pga__amp__first__tail.n9 0.75515399999999999
rmesh_equiv_675 pga__amp__first__tail.n1 pga__amp__first__tail.n3 14.189499999999999
rmesh_equiv_676 pga__amp__first__tail.n1 pga__amp__first__tail.t1 174.91200000000001
rmesh_equiv_677 pga__amp__first__tail.n10 pga__amp__first__tail.n11 14.121399999999998
rmesh_equiv_678 pga__amp__first__tail.n10 pga__amp__first__tail.t0 1.7404999999999999
rmesh_equiv_679 pga__amp__first__tail.n11 pga__amp__first__tail.n9 1.13588
rmesh_equiv_68 bias.n4 bias.n5 0.79479999999999995
rmesh_equiv_680 pga__amp__first__tail.n2 pga__amp__first__tail.n3 3.0467200000000001
rmesh_equiv_681 pga__amp__first__tail.n2 pga__amp__first__tail.t1 181.41
rmesh_equiv_682 pga__amp__first__tail.n3 pga__amp__first__tail.n8 22.803799999999999
rmesh_equiv_683 pga__amp__first__tail.n4 pga__amp__first__tail.n5 14.985300000000001
rmesh_equiv_684 pga__amp__first__tail.n4 pga__amp__first__tail.n7 0.24337299999999998
rmesh_equiv_685 pga__amp__first__tail.n5 pga__amp__first__tail.n6 11.248699999999999
rmesh_equiv_686 pga__amp__first__tail.n5 pga__amp__first__tail.t2 1.7404999999999999
rmesh_equiv_687 pga__amp__first__tail.n6 pga__amp__first__tail.n7 3.1501399999999999
rmesh_equiv_688 pga__amp__first__tail.n7 pga__amp__first__tail.n8 21.215199999999999
rmesh_equiv_689 pga__amp__first__tail.n8 pga__amp__first__tail.n9 20.304500000000001
rmesh_equiv_69 bias.n5 bias.n6 60.478900000000003
rmesh_equiv_690 pga__amp__pre pga__amp__pre.n0 22.8553
rmesh_equiv_691 pga__amp__pre pga__amp__pre.n1 3.3780963507178385
rmesh_equiv_692 pga__amp__pre pga__amp__pre.n10 4.8770699999999998
rmesh_equiv_693 pga__amp__pre pga__amp__pre.n2 5.2670000000000003
rmesh_equiv_694 pga__amp__pre pga__amp__pre.n3 29.715900000000001
rmesh_equiv_695 pga__amp__pre pga__amp__pre.n4 6.3200399999999997
rmesh_equiv_696 pga__amp__pre pga__amp__pre.n6 33.130400000000002
rmesh_equiv_697 pga__amp__pre pga__amp__pre.t2 0.00141837
rmesh_equiv_698 pga__amp__pre pga__amp__pre.t3 0.00141837
rmesh_equiv_699 pga__amp__pre pga__amp__pre.t4 0.00141837
rmesh_equiv_7 amplified amplified.n6 4.2590000000000003
rmesh_equiv_70 bias.n5 bias.t2 33.237900000000003
rmesh_equiv_700 pga__amp__pre pga__amp__pre.t5 1054.8499999999999
rmesh_equiv_701 pga__amp__pre.n0 pga__amp__pre.n9 11.4361
rmesh_equiv_702 pga__amp__pre.n0 pga__amp__pre.t0 381.113
rmesh_equiv_703 pga__amp__pre.n1 pga__amp__pre.n2 4.1529499999999997
rmesh_equiv_704 pga__amp__pre.n10 pga__amp__pre.n9 2.4407800000000002
rmesh_equiv_705 pga__amp__pre.n10 pga__amp__pre.t0 387.11000000000001
rmesh_equiv_706 pga__amp__pre.n2 pga__amp__pre.n3 3.1113099999999996
rmesh_equiv_707 pga__amp__pre.n3 pga__amp__pre.n8 2.2512099999999999
rmesh_equiv_708 pga__amp__pre.n4 pga__amp__pre.n5 13.389300000000002
rmesh_equiv_709 pga__amp__pre.n4 pga__amp__pre.n7 0.75515399999999999
rmesh_equiv_71 bias.n6 bias.n7 1.84643
rmesh_equiv_710 pga__amp__pre.n5 pga__amp__pre.n6 14.121399999999998
rmesh_equiv_711 pga__amp__pre.n5 pga__amp__pre.t1 1.7404999999999999
rmesh_equiv_712 pga__amp__pre.n6 pga__amp__pre.n7 1.13588
rmesh_equiv_713 pga__amp__pre.n7 pga__amp__pre.n8 22.662600000000001
rmesh_equiv_714 pga__amp__pre.n8 pga__amp__pre.n9 19.887899999999998
rmesh_equiv_715 pga__fb pga__fb.n1 54.399300000000004
rmesh_equiv_716 pga__fb pga__fb.t3 332.71199999999999
rmesh_equiv_717 pga__fb.n0 pga__fb.n1 2.1413500000000001
rmesh_equiv_718 pga__fb.n0 pga__fb.t1 34.416600000000003
rmesh_equiv_719 pga__fb.n0 pga__fb.t2 36.348999999999997
rmesh_equiv_72 bias.n7 bias.n8 18.089600000000001
rmesh_equiv_720 pga__fb.n1 pga__fb.t0 29.529800000000002
rmesh_equiv_721 pga__gainb pga__gainb.n0 12.8005
rmesh_equiv_722 pga__gainb pga__gainb.n1 12.8005
rmesh_equiv_723 pga__gainb pga__gainb.n2 12.8005
rmesh_equiv_724 pga__gainb pga__gainb.n4 37.770499999999998
rmesh_equiv_725 pga__gainb pga__gainb.n6 12.8005
rmesh_equiv_726 pga__gainb pga__gainb.t2 3424.7800000000002
rmesh_equiv_727 pga__gainb.n0 pga__gainb.n5 10.151300000000001
rmesh_equiv_728 pga__gainb.n0 pga__gainb.t0 255.34500000000003
rmesh_equiv_729 pga__gainb.n1 pga__gainb.n3 10.151300000000001
rmesh_equiv_73 bias.n8 bias.n9 1.84643
rmesh_equiv_730 pga__gainb.n1 pga__gainb.t1 700.48400000000004
rmesh_equiv_731 pga__gainb.n2 pga__gainb.n3 10.151300000000001
rmesh_equiv_732 pga__gainb.n2 pga__gainb.t1 700.48400000000004
rmesh_equiv_733 pga__gainb.n3 pga__gainb.n4 21.434200000000001
rmesh_equiv_734 pga__gainb.n4 pga__gainb.n5 20.617000000000001
rmesh_equiv_735 pga__gainb.n5 pga__gainb.n6 10.151300000000001
rmesh_equiv_736 pga__gainb.n6 pga__gainb.t0 255.34500000000003
rmesh_equiv_737 pga__low pga__low.n0 22.8553
rmesh_equiv_738 pga__low pga__low.n1 4.39276
rmesh_equiv_739 pga__low pga__low.n2 20.370899999999999
rmesh_equiv_74 bias_source__vcm_buffer__comp.n0 bias_source__vcm_buffer__comp.n1 4.1529499999999997
rmesh_equiv_740 pga__low pga__low.n6 4.8770699999999998
rmesh_equiv_741 pga__low.n0 pga__low.n5 11.4361
rmesh_equiv_742 pga__low.n0 pga__low.t0 381.113
rmesh_equiv_743 pga__low.n1 pga__low.n3 2.90421
rmesh_equiv_744 pga__low.n1 pga__low.t2 178.41800000000001
rmesh_equiv_745 pga__low.n2 pga__low.n3 13.4665
rmesh_equiv_746 pga__low.n2 pga__low.t2 172.06
rmesh_equiv_747 pga__low.n3 pga__low.n4 20.200399999999998
rmesh_equiv_748 pga__low.n4 pga__low.n5 21.017600000000002
rmesh_equiv_749 pga__low.n4 pga__low.t1 31.300399999999996
rmesh_equiv_75 bias_source__vcm_buffer__comp.n0 bias_source__vcm_buffer__comp.t1 5.6209199999999999
rmesh_equiv_750 pga__low.n5 pga__low.n6 2.4407800000000002
rmesh_equiv_751 pga__low.n6 pga__low.t0 387.11000000000001
rmesh_equiv_752 pga_r_high_r0_n0.t0 pga_r_high_r0_n0.t1 51.980899999999998
rmesh_equiv_753 reset reset.n0 33.25815268536325
rmesh_equiv_754 reset reset.n1 38.297600000000003
rmesh_equiv_755 reset reset.n2 19.346959739937567
rmesh_equiv_756 reset reset.t0 315.88
rmesh_equiv_757 reset reset.t1 315.88
rmesh_equiv_758 reset reset.t2 330.34100000000001
rmesh_equiv_759 reset reset.t3 330.34100000000001
rmesh_equiv_76 bias_source__vcm_buffer__comp.n0 bias_source__vcm_buffer__comp.t3 29.942599999999999
rmesh_equiv_760 reset.n0 reset.n1 0.81771300000000002
rmesh_equiv_761 reset.n1 reset.n2 1.6402100000000002
rmesh_equiv_762 reset_mux__sb reset_mux__sb.n0 12.8005
rmesh_equiv_763 reset_mux__sb reset_mux__sb.n1 18.701831069822845
rmesh_equiv_764 reset_mux__sb reset_mux__sb.n2 12.8005
rmesh_equiv_765 reset_mux__sb reset_mux__sb.n3 12.8005
rmesh_equiv_766 reset_mux__sb reset_mux__sb.n7 12.8005
rmesh_equiv_767 reset_mux__sb reset_mux__sb.t2 315.88
rmesh_equiv_768 reset_mux__sb reset_mux__sb.t3 330.34100000000001
rmesh_equiv_769 reset_mux__sb.n0 reset_mux__sb.n6 10.151300000000001
rmesh_equiv_77 bias_source__vcm_buffer__comp.n1 bias_source__vcm_buffer__comp.n2 5.6129199999999999
rmesh_equiv_770 reset_mux__sb.n0 reset_mux__sb.t0 255.34500000000003
rmesh_equiv_771 reset_mux__sb.n1 reset_mux__sb.n5 1.1660999999999999
rmesh_equiv_772 reset_mux__sb.n2 reset_mux__sb.n4 10.151300000000001
rmesh_equiv_773 reset_mux__sb.n2 reset_mux__sb.t1 700.48400000000004
rmesh_equiv_774 reset_mux__sb.n3 reset_mux__sb.n4 10.151300000000001
rmesh_equiv_775 reset_mux__sb.n3 reset_mux__sb.t1 700.48400000000004
rmesh_equiv_776 reset_mux__sb.n4 reset_mux__sb.n5 17.684200000000001
rmesh_equiv_777 reset_mux__sb.n5 reset_mux__sb.n6 16.867000000000001
rmesh_equiv_778 reset_mux__sb.n6 reset_mux__sb.n7 10.151300000000001
rmesh_equiv_779 reset_mux__sb.n7 reset_mux__sb.t0 255.34500000000003
rmesh_equiv_78 bias_source__vcm_buffer__comp.n1 bias_source__vcm_buffer__comp.t0 9.7733699999999999
rmesh_equiv_780 sample__clkb sample__clkb.n0 12.8005
rmesh_equiv_781 sample__clkb sample__clkb.n1 18.30518227520886
rmesh_equiv_782 sample__clkb sample__clkb.n2 36.198700000000002
rmesh_equiv_783 sample__clkb sample__clkb.n3 36.214300000000001
rmesh_equiv_784 sample__clkb sample__clkb.n4 12.8005
rmesh_equiv_785 sample__clkb sample__clkb.n5 12.8005
rmesh_equiv_786 sample__clkb sample__clkb.n9 12.8005
rmesh_equiv_787 sample__clkb sample__clkb.t2 330.34100000000001
rmesh_equiv_788 sample__clkb sample__clkb.t3 315.88
rmesh_equiv_789 sample__clkb sample__clkb.t4 330.34100000000001
rmesh_equiv_79 bias_source__vcm_buffer__comp.n2 bias_source__vcm_buffer__comp.t2 0.025939499999999997
rmesh_equiv_790 sample__clkb sample__clkb.t5 315.88
rmesh_equiv_791 sample__clkb.n0 sample__clkb.n8 10.151300000000001
rmesh_equiv_792 sample__clkb.n0 sample__clkb.t0 255.34500000000003
rmesh_equiv_793 sample__clkb.n1 sample__clkb.n2 1.6466799999999999
rmesh_equiv_794 sample__clkb.n2 sample__clkb.n3 2.4756399999999998
rmesh_equiv_795 sample__clkb.n3 sample__clkb.n7 1.1660999999999999
rmesh_equiv_796 sample__clkb.n4 sample__clkb.n6 10.151300000000001
rmesh_equiv_797 sample__clkb.n4 sample__clkb.t1 700.48400000000004
rmesh_equiv_798 sample__clkb.n5 sample__clkb.n6 10.151300000000001
rmesh_equiv_799 sample__clkb.n5 sample__clkb.t1 700.48400000000004
rmesh_equiv_8 amplified.n0 amplified.n16 11.4361
rmesh_equiv_80 bias_source__vcm_buffer__first__mir bias_source__vcm_buffer__first__mir.n0 22.8553
rmesh_equiv_800 sample__clkb.n6 sample__clkb.n7 17.684200000000001
rmesh_equiv_801 sample__clkb.n7 sample__clkb.n8 16.867000000000001
rmesh_equiv_802 sample__clkb.n8 sample__clkb.n9 10.151300000000001
rmesh_equiv_803 sample__clkb.n9 sample__clkb.t0 255.34500000000003
rmesh_equiv_804 sample__m sample__m.n0 12.8005
rmesh_equiv_805 sample__m sample__m.n1 18.513533352596085
rmesh_equiv_806 sample__m sample__m.n10 12.8005
rmesh_equiv_807 sample__m sample__m.n11 12.8005
rmesh_equiv_808 sample__m sample__m.n15 12.8005
rmesh_equiv_809 sample__m sample__m.n2 12.8005
rmesh_equiv_81 bias_source__vcm_buffer__first__mir bias_source__vcm_buffer__first__mir.n1 16.821806896295538
rmesh_equiv_810 sample__m sample__m.n3 12.8005
rmesh_equiv_811 sample__m sample__m.n6 12.8005
rmesh_equiv_812 sample__m sample__m.n7 12.8005
rmesh_equiv_813 sample__m sample__m.t4 315.88
rmesh_equiv_814 sample__m sample__m.t5 330.34100000000001
rmesh_equiv_815 sample__m.n0 sample__m.n14 10.151300000000001
rmesh_equiv_816 sample__m.n0 sample__m.t0 255.34500000000003
rmesh_equiv_817 sample__m.n1 sample__m.n5 4.4948800000000002
rmesh_equiv_818 sample__m.n10 sample__m.n12 10.151300000000001
rmesh_equiv_819 sample__m.n10 sample__m.t1 700.48400000000004
rmesh_equiv_82 bias_source__vcm_buffer__first__mir bias_source__vcm_buffer__first__mir.n2 6.3200399999999997
rmesh_equiv_820 sample__m.n11 sample__m.n12 10.151300000000001
rmesh_equiv_821 sample__m.n11 sample__m.t1 700.48400000000004
rmesh_equiv_822 sample__m.n12 sample__m.n13 17.2837
rmesh_equiv_823 sample__m.n13 sample__m.n14 18.100899999999999
rmesh_equiv_824 sample__m.n13 sample__m.n9 0.81771300000000002
rmesh_equiv_825 sample__m.n14 sample__m.n15 10.151300000000001
rmesh_equiv_826 sample__m.n15 sample__m.t0 255.34500000000003
rmesh_equiv_827 sample__m.n2 sample__m.n4 10.151300000000001
rmesh_equiv_828 sample__m.n2 sample__m.t2 700.48400000000004
rmesh_equiv_829 sample__m.n3 sample__m.n4 10.151300000000001
rmesh_equiv_83 bias_source__vcm_buffer__first__mir bias_source__vcm_buffer__first__mir.n4 33.130400000000002
rmesh_equiv_830 sample__m.n3 sample__m.t2 700.48400000000004
rmesh_equiv_831 sample__m.n4 sample__m.n5 17.2837
rmesh_equiv_832 sample__m.n5 sample__m.n9 0.81771300000000002
rmesh_equiv_833 sample__m.n6 sample__m.n8 10.151300000000001
rmesh_equiv_834 sample__m.n6 sample__m.t3 255.34500000000003
rmesh_equiv_835 sample__m.n7 sample__m.n8 10.151300000000001
rmesh_equiv_836 sample__m.n7 sample__m.t3 255.34500000000003
rmesh_equiv_837 sample__m.n8 sample__m.n9 17.2837
rmesh_equiv_838 sample__mb sample__mb.n0 12.8005
rmesh_equiv_839 sample__mb sample__mb.n1 18.30518227520886
rmesh_equiv_84 bias_source__vcm_buffer__first__mir bias_source__vcm_buffer__first__mir.n8 4.8770699999999998
rmesh_equiv_840 sample__mb sample__mb.n2 12.8005
rmesh_equiv_841 sample__mb sample__mb.n3 12.8005
rmesh_equiv_842 sample__mb sample__mb.n7 12.8005
rmesh_equiv_843 sample__mb sample__mb.t2 315.88
rmesh_equiv_844 sample__mb sample__mb.t3 330.34100000000001
rmesh_equiv_845 sample__mb.n0 sample__mb.n6 10.151300000000001
rmesh_equiv_846 sample__mb.n0 sample__mb.t0 255.34500000000003
rmesh_equiv_847 sample__mb.n1 sample__mb.n5 1.17256
rmesh_equiv_848 sample__mb.n2 sample__mb.n4 10.151300000000001
rmesh_equiv_849 sample__mb.n2 sample__mb.t1 700.48400000000004
rmesh_equiv_85 bias_source__vcm_buffer__first__mir bias_source__vcm_buffer__first__mir.t0 572.84699999999998
rmesh_equiv_850 sample__mb.n3 sample__mb.n4 10.151300000000001
rmesh_equiv_851 sample__mb.n3 sample__mb.t1 700.48400000000004
rmesh_equiv_852 sample__mb.n4 sample__mb.n5 17.684200000000001
rmesh_equiv_853 sample__mb.n5 sample__mb.n6 16.867000000000001
rmesh_equiv_854 sample__mb.n6 sample__mb.n7 10.151300000000001
rmesh_equiv_855 sample__mb.n7 sample__mb.t0 255.34500000000003
rmesh_equiv_856 sample__mf sample__mf.n0 12.8005
rmesh_equiv_857 sample__mf sample__mf.n1 12.8005
rmesh_equiv_858 sample__mf sample__mf.n11 12.8005
rmesh_equiv_859 sample__mf sample__mf.n12 12.8005
rmesh_equiv_86 bias_source__vcm_buffer__first__mir bias_source__vcm_buffer__first__mir.t3 572.84699999999998
rmesh_equiv_860 sample__mf sample__mf.n15 12.8005
rmesh_equiv_861 sample__mf sample__mf.n16 12.8005
rmesh_equiv_862 sample__mf sample__mf.n2 12.8005
rmesh_equiv_863 sample__mf sample__mf.n21 12.8005
rmesh_equiv_864 sample__mf sample__mf.n4 12.8005
rmesh_equiv_865 sample__mf sample__mf.n5 12.8005
rmesh_equiv_866 sample__mf sample__mf.n8 12.8005
rmesh_equiv_867 sample__mf sample__mf.n9 12.8005
rmesh_equiv_868 sample__mf.n0 sample__mf.n20 10.151300000000001
rmesh_equiv_869 sample__mf.n0 sample__mf.t0 700.48400000000004
rmesh_equiv_87 bias_source__vcm_buffer__first__mir.n0 bias_source__vcm_buffer__first__mir.n7 11.4361
rmesh_equiv_870 sample__mf.n1 sample__mf.n3 10.151300000000001
rmesh_equiv_871 sample__mf.n1 sample__mf.t1 255.34500000000003
rmesh_equiv_872 sample__mf.n10 sample__mf.n14 18.517600000000002
rmesh_equiv_873 sample__mf.n10 sample__mf.n8 10.151300000000001
rmesh_equiv_874 sample__mf.n10 sample__mf.n9 10.151300000000001
rmesh_equiv_875 sample__mf.n11 sample__mf.n13 10.151300000000001
rmesh_equiv_876 sample__mf.n11 sample__mf.t3 700.48400000000004
rmesh_equiv_877 sample__mf.n12 sample__mf.n13 10.151300000000001
rmesh_equiv_878 sample__mf.n12 sample__mf.t3 700.48400000000004
rmesh_equiv_879 sample__mf.n13 sample__mf.n14 17.700399999999998
rmesh_equiv_88 bias_source__vcm_buffer__first__mir.n0 bias_source__vcm_buffer__first__mir.t1 381.113
rmesh_equiv_880 sample__mf.n14 sample__mf.n18 0.81771300000000002
rmesh_equiv_881 sample__mf.n15 sample__mf.n17 10.151300000000001
rmesh_equiv_882 sample__mf.n15 sample__mf.t4 255.34500000000003
rmesh_equiv_883 sample__mf.n16 sample__mf.n17 10.151300000000001
rmesh_equiv_884 sample__mf.n16 sample__mf.t4 255.34500000000003
rmesh_equiv_885 sample__mf.n17 sample__mf.n18 17.700399999999998
rmesh_equiv_886 sample__mf.n18 sample__mf.n19 0.81771300000000002
rmesh_equiv_887 sample__mf.n19 sample__mf.n20 17.700399999999998
rmesh_equiv_888 sample__mf.n19 sample__mf.n7 3.8580199999999998
rmesh_equiv_889 sample__mf.n2 sample__mf.n3 10.151300000000001
rmesh_equiv_89 bias_source__vcm_buffer__first__mir.n1 bias_source__vcm_buffer__first__mir.n6 0.39353700000000003
rmesh_equiv_890 sample__mf.n2 sample__mf.t1 255.34500000000003
rmesh_equiv_891 sample__mf.n20 sample__mf.n21 10.151300000000001
rmesh_equiv_892 sample__mf.n21 sample__mf.t0 700.48400000000004
rmesh_equiv_893 sample__mf.n3 sample__mf.n7 18.517600000000002
rmesh_equiv_894 sample__mf.n4 sample__mf.n6 10.151300000000001
rmesh_equiv_895 sample__mf.n4 sample__mf.t2 700.48400000000004
rmesh_equiv_896 sample__mf.n5 sample__mf.n6 10.151300000000001
rmesh_equiv_897 sample__mf.n5 sample__mf.t2 700.48400000000004
rmesh_equiv_898 sample__mf.n6 sample__mf.n7 17.700399999999998
rmesh_equiv_899 sample__mf.n8 sample__mf.t5 255.34500000000003
rmesh_equiv_9 amplified.n0 amplified.t0 381.113
rmesh_equiv_90 bias_source__vcm_buffer__first__mir.n2 bias_source__vcm_buffer__first__mir.n3 13.389300000000002
rmesh_equiv_900 sample__mf.n9 sample__mf.t5 255.34500000000003
rmesh_equiv_901 sample__t sample__t.n0 12.8005
rmesh_equiv_902 sample__t sample__t.n1 18.930260438372009
rmesh_equiv_903 sample__t sample__t.n10 12.8005
rmesh_equiv_904 sample__t sample__t.n15 12.8005
rmesh_equiv_905 sample__t sample__t.n2 12.8005
rmesh_equiv_906 sample__t sample__t.n3 12.8005
rmesh_equiv_907 sample__t sample__t.n5 12.8005
rmesh_equiv_908 sample__t sample__t.n6 12.8005
rmesh_equiv_909 sample__t sample__t.n9 12.8005
rmesh_equiv_91 bias_source__vcm_buffer__first__mir.n2 bias_source__vcm_buffer__first__mir.n5 0.75515399999999999
rmesh_equiv_910 sample__t sample__t.t4 315.88
rmesh_equiv_911 sample__t sample__t.t5 330.34100000000001
rmesh_equiv_912 sample__t.n0 sample__t.n14 10.151300000000001
rmesh_equiv_913 sample__t.n0 sample__t.t0 700.48400000000004
rmesh_equiv_914 sample__t.n1 sample__t.n13 4.4948800000000002
rmesh_equiv_915 sample__t.n10 sample__t.n11 10.151300000000001
rmesh_equiv_916 sample__t.n10 sample__t.t2 255.34500000000003
rmesh_equiv_917 sample__t.n11 sample__t.n12 18.117000000000001
rmesh_equiv_918 sample__t.n11 sample__t.n9 10.151300000000001
rmesh_equiv_919 sample__t.n12 sample__t.n13 0.81771300000000002
rmesh_equiv_92 bias_source__vcm_buffer__first__mir.n3 bias_source__vcm_buffer__first__mir.n4 14.121399999999998
rmesh_equiv_920 sample__t.n12 sample__t.n8 0.81771300000000002
rmesh_equiv_921 sample__t.n13 sample__t.n14 18.117000000000001
rmesh_equiv_922 sample__t.n14 sample__t.n15 10.151300000000001
rmesh_equiv_923 sample__t.n15 sample__t.t0 700.48400000000004
rmesh_equiv_924 sample__t.n2 sample__t.n4 10.151300000000001
rmesh_equiv_925 sample__t.n2 sample__t.t3 255.34500000000003
rmesh_equiv_926 sample__t.n3 sample__t.n4 10.151300000000001
rmesh_equiv_927 sample__t.n3 sample__t.t3 255.34500000000003
rmesh_equiv_928 sample__t.n4 sample__t.n8 18.934200000000001
rmesh_equiv_929 sample__t.n5 sample__t.n7 10.151300000000001
rmesh_equiv_93 bias_source__vcm_buffer__first__mir.n3 bias_source__vcm_buffer__first__mir.t2 1.7404999999999999
rmesh_equiv_930 sample__t.n5 sample__t.t1 700.48400000000004
rmesh_equiv_931 sample__t.n6 sample__t.n7 10.151300000000001
rmesh_equiv_932 sample__t.n6 sample__t.t1 700.48400000000004
rmesh_equiv_933 sample__t.n7 sample__t.n8 18.117000000000001
rmesh_equiv_934 sample__t.n9 sample__t.t2 255.34500000000003
rmesh_equiv_935 sample__tb sample__tb.n0 12.8005
rmesh_equiv_936 sample__tb sample__tb.n1 18.30518227520886
rmesh_equiv_937 sample__tb sample__tb.n2 12.8005
rmesh_equiv_938 sample__tb sample__tb.n3 12.8005
rmesh_equiv_939 sample__tb sample__tb.n7 12.8005
rmesh_equiv_94 bias_source__vcm_buffer__first__mir.n4 bias_source__vcm_buffer__first__mir.n5 1.13588
rmesh_equiv_940 sample__tb sample__tb.t2 330.34100000000001
rmesh_equiv_941 sample__tb sample__tb.t3 315.88
rmesh_equiv_942 sample__tb.n0 sample__tb.n6 10.151300000000001
rmesh_equiv_943 sample__tb.n0 sample__tb.t0 255.34500000000003
rmesh_equiv_944 sample__tb.n1 sample__tb.n5 1.17256
rmesh_equiv_945 sample__tb.n2 sample__tb.n4 10.151300000000001
rmesh_equiv_946 sample__tb.n2 sample__tb.t1 700.48400000000004
rmesh_equiv_947 sample__tb.n3 sample__tb.n4 10.151300000000001
rmesh_equiv_948 sample__tb.n3 sample__tb.t1 700.48400000000004
rmesh_equiv_949 sample__tb.n4 sample__tb.n5 17.684200000000001
rmesh_equiv_95 bias_source__vcm_buffer__first__mir.n5 bias_source__vcm_buffer__first__mir.n6 20.805
rmesh_equiv_950 sample__tb.n5 sample__tb.n6 16.867000000000001
rmesh_equiv_951 sample__tb.n6 sample__tb.n7 10.151300000000001
rmesh_equiv_952 sample__tb.n7 sample__tb.t0 255.34500000000003
rmesh_equiv_953 vcm vcm.n0 182.952
rmesh_equiv_954 vcm vcm.n11 21.12493349931048
rmesh_equiv_955 vcm vcm.n2 19.837
rmesh_equiv_956 vcm vcm.n3 4.2590000000000003
rmesh_equiv_957 vcm vcm.n6 33.9895
rmesh_equiv_958 vcm vcm.n8 6.9688099999999995
rmesh_equiv_959 vcm vcm.t4 332.71199999999999
rmesh_equiv_96 bias_source__vcm_buffer__first__mir.n6 bias_source__vcm_buffer__first__mir.n7 19.887899999999998
rmesh_equiv_960 vcm vcm.t5 332.71199999999999
rmesh_equiv_961 vcm.n0 vcm.n1 20.8826
rmesh_equiv_962 vcm.n0 vcm.t0 30.3733
rmesh_equiv_963 vcm.n1 vcm.n5 13.727399999999999
rmesh_equiv_964 vcm.n1 vcm.t2 29.760400000000001
rmesh_equiv_965 vcm.n10 vcm.n11 3.3057699999999994
rmesh_equiv_966 vcm.n10 vcm.n5 0.91758700000000015
rmesh_equiv_967 vcm.n10 vcm.n9 17.804500000000001
rmesh_equiv_968 vcm.n2 vcm.n4 14.189499999999999
rmesh_equiv_969 vcm.n2 vcm.t1 174.91200000000001
rmesh_equiv_97 bias_source__vcm_buffer__first__mir.n7 bias_source__vcm_buffer__first__mir.n8 2.4407800000000002
rmesh_equiv_970 vcm.n3 vcm.n4 3.0467200000000001
rmesh_equiv_971 vcm.n3 vcm.t1 181.41
rmesh_equiv_972 vcm.n4 vcm.n5 17.804500000000001
rmesh_equiv_973 vcm.n6 vcm.n7 13.2728
rmesh_equiv_974 vcm.n6 vcm.n9 0.51338700000000004
rmesh_equiv_975 vcm.n7 vcm.n8 13.200100000000001
rmesh_equiv_976 vcm.n7 vcm.t3 0.71462499999999995
rmesh_equiv_977 vcm.n8 vcm.n9 0.27270899999999998
rmesh_equiv_978 vgnd vgnd.n1018 14684.703893909062
rmesh_equiv_979 vgnd vgnd.n1022 1906.2618614348219
rmesh_equiv_98 bias_source__vcm_buffer__first__mir.n8 bias_source__vcm_buffer__first__mir.t1 387.11000000000001
rmesh_equiv_980 vgnd vgnd.n1065 169.26347762818747
rmesh_equiv_981 vgnd vgnd.n1067 8076.9525291074597
rmesh_equiv_982 vgnd vgnd.n1069 164.35716309672193
rmesh_equiv_983 vgnd vgnd.n1425 142.85971649510182
rmesh_equiv_984 vgnd vgnd.n1433 21.77459323337872
rmesh_equiv_985 vgnd vgnd.n1446 1467.2032776087581
rmesh_equiv_986 vgnd vgnd.n1451 13078.456077043569
rmesh_equiv_987 vgnd vgnd.n1833 206.00702512627146
rmesh_equiv_988 vgnd vgnd.n2025 33750.050891020692
rmesh_equiv_989 vgnd vgnd.n2026 316.94235561197723
rmesh_equiv_99 bias_source__vcm_buffer__first__tail bias_source__vcm_buffer__first__tail.n0 6.3200399999999997
rmesh_equiv_990 vgnd vgnd.n2126 14684.703893909062
rmesh_equiv_991 vgnd vgnd.n2130 1906.2618614348219
rmesh_equiv_992 vgnd vgnd.n2173 169.26347762818747
rmesh_equiv_993 vgnd vgnd.n2175 8076.9525291074597
rmesh_equiv_994 vgnd vgnd.n2177 164.35716309672193
rmesh_equiv_995 vgnd vgnd.n2314 278.25500200634946
rmesh_equiv_996 vgnd vgnd.n2361 20748.614047719642
rmesh_equiv_997 vgnd vgnd.n2362 314.89775088253373
rmesh_equiv_998 vgnd vgnd.n24 14180.626451959683
rmesh_equiv_999 vgnd vgnd.n2458 14684.703893909062
.ends

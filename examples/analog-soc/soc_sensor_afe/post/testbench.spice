Resistor analog SoC soc_sensor_afe
.include "./supported-tt.spice"
.options method=gear maxord=2
.include "./current-probe.spice"
.temp 27.0
VGND VGND 0 0
VDD VPWR VGND 1.8
VIN VIN VGND DC 0.9 AC 1 SIN(0.9 0.025 5000)
VGAIN GAIN VGND PULSE(0 1.8 100u 2n 2n 1 2)
VCLK CLK VGND PULSE(0 1.8 250n 2n 2n 498n 1u)
VRESET RESET VGND PWL(0 1.8 5u 1.8 5.002u 0)
CLOAD OUT VGND 50f
.nodeset v(VCM)=0.9 v(OUT)=0.9
XU VPWR DATA CLK BIAS RESET VCM VGND GAIN OUT VIN soc_sensor_afe
.control
save v(OUT) i(VDD) v(VIN) v(GAIN) v(CLK) v(RESET) v(DATA) v(VCM) v(BIAS) i(v.xu.vregister_cf_364978ad91fabd22) i(v.xu.vregister_cf_2f3a5d093469eef5) i(v.xu.vregister_cf_7175e89028bb7248) i(v.xu.vregister_cf_b03c907f260c2886) i(v.xu.vregister_cf_49c749606463d3e7) i(v.xu.vregister_cf_5339a2ad49f84627) i(v.xu.vregister_cf_d866ad78d458a60d) i(v.xu.vregister_cf_c4c6ca526db8e569) i(v.xu.vregister_cf_42918cdd66f3ae1c) i(v.xu.vregister_cf_05c6904e96e95a07) i(v.xu.vregister_cf_2cd08cc02cc01151) i(v.xu.vregister_cf_3fd3b3ec0fd5efd1) i(v.xu.vregister_cf_ab092755cd55528a) i(v.xu.vregister_cf_348b92bd8ffb1bd7) i(v.xu.vregister_cf_252b3710cc6a1ae8) i(v.xu.vregister_cf_0a2948402ec592a6) i(v.xu.vregister_cf_4ae0e0a672255849) i(v.xu.vregister_cf_47d59203f1a40b37) i(v.xu.vregister_cf_97f755f9997d72fc) i(v.xu.vregister_cf_0a2200bd559594c6) i(v.xu.vregister_cf_fbff23537e98467c) i(v.xu.vregister_cf_19d955342b95dba6) i(v.xu.vregister_cf_180f1a3a25a05eed) i(v.xu.vregister_cf_5a1bed08c3e8147b) i(v.xu.vregister_cf_5e8977893f444654) i(v.xu.vregister_cf_91543fc7b0b915b6) i(v.xu.vregister_cf_f9ce593811f5be84) i(v.xu.vregister_cf_3c863b4c3d76d79a) i(v.xu.vregister_cf_2e6bfea501a74f1b) i(v.xu.vregister_cf_8ae07d91a7ec8891) i(v.xu.vregister_cf_da575a61d8815f68) i(v.xu.vregister_cf_2a969e9e6fe3c2b5) i(v.xu.vregister_cf_58d02d6642816e24) i(v.xu.vregister_cf_df0c7f0461fcbe9d) i(v.xu.vregister_cf_c1a3cc7e8db487d8) i(v.xu.vregister_cf_46aeb6a72436bd2c) i(v.xu.vregister_cf_2f1a58acfd68c6f8) i(v.xu.vregister_cf_5483726bce058902) i(v.xu.vregister_cf_d1ce7a36509983e0) i(v.xu.vregister_cf_663abaf3e8bae0e2) i(v.xu.vregister_cf_50bdcd4754318caf) i(v.xu.vregister_cf_75311aafbce4a3d1) i(v.xu.vregister_cf_9fbc4f8be125a026) i(v.xu.vregister_cf_888c64d54c22e83e) i(v.xu.vregister_cf_6aaad9666b7539ee) i(v.xu.vregister_cf_29e3eda06c59ef82) i(v.xu.vregister_cf_c3a46168b32a2f5b) i(v.xu.vregister_cf_30afca0182d35ed6) i(v.xu.vregister_cf_43fc01830a2a01de) i(v.xu.vregister_cf_27ac3e6956716256) i(v.xu.vregister_cf_2c60808c1b7d8841) i(v.xu.vregister_cf_2728813c13aa9c5f) i(v.xu.vregister_cf_2f47df2410f2be69) i(v.xu.vregister_cf_e1880fd89cfb3a5d) i(v.xu.vregister_cf_4d85aa482b47db42) i(v.xu.vregister_cf_b1fbb596e933bb3e) i(VGND) i(VIN) i(VGAIN) i(VCLK) i(VRESET) v(VPWR) v(XU.FILTER__BUFFER0__FIRST__MIR.t1) v(XU.FILTER__BUFFER0__FIRST__MIR.t0) v(XU.VGND.t65) v(XU.CMP.t3) v(XU.COMPARATOR__PRE.t2) v(XU.VGND.t64) v(XU.FILTER__BUFFER1__FIRST__TAIL.t3) v(XU.FILTER__BUFFER1__PRE.t1) v(XU.FILTER__FILTER1.t2) v(XU.VGND.t128) v(XU.SAMPLE__MF.t2) v(XU.SAMPLE__MB.t2) v(XU.CMP.t2) v(XU.COMPARATOR__PRE.t3) v(XU.VGND.t131) v(XU.PGA__GAIN8__AMP__FIRST__TAIL.t0) v(XU.BIAS.t3) v(XU.VGND.t130) v(XU.FILTER__BUFFER1__FIRST__TAIL.t2) v(XU.FILTER__BUFFER1__PRE.t2) v(XU.FILTER__FILTER1.t4) v(XU.VGND.t97) v(XU.PGA__OUTPUT_BUFFER__FIRST__MIR.t1) v(XU.PGA__OUTPUT_BUFFER__FIRST__MIR.t0) v(XU.PGA__SELECTED.t2) v(XU.PGA__V2.t5) v(XU.GAIN.t0) v(XU.PGA__GAINB.t0) v(XU.GAIN.t1) v(XU.VGND.t45) v(XU.PGA__OUTPUT_BUFFER__FIRST__TAIL.t0) v(XU.BIAS.t4) v(XU.VGND.t44) v(XU.PGA__SELECTED.t0) v(XU.PGA__V8.t2) v(XU.PGA__GAINB.t2) v(XU.VGND.t74) v(XU.D.t2) v(XU.RESET.t0) v(XU.VGND.t73) v(XU.OUT.t2) v(XU.FILTER__BUFFER1__PRE.t3) v(XU.PGA__GAIN2__AMP__FIRST__TAIL.t4) v(XU.PGA__GAIN2__AMP__PRE.t0) v(XU.VIN.t0) v(XU.VGND.t122) v(XU.PGA__GAIN2__AMP__FIRST__MIR.t1) v(XU.PGA__GAIN2__AMP__FIRST__MIR.t0) v(XU.DATA.t1) v(XU.SAMPLE__T.t0) v(XU.CLK.t0) v(XU.PGA__SELECTED.t1) v(XU.PGA__V2.t3) v(XU.PGA__GAINB.t3) v(XU.VGND.t85) v(XU.BIAS_SOURCE__VCM_BUFFER__PRE.t2) v(XU.BIAS_SOURCE__VCM_BUFFER__FIRST__MIR.t4) v(XU.SAMPLE__MF.t4) v(XU.SAMPLE__M.t2) v(XU.SAMPLE__CLKB.t2) v(XU.PGA__OUTPUT_BUFFER__FIRST__TAIL.t4) v(XU.PGA__OUTPUT_BUFFER__FIRST__MIR.t2) v(XU.AMPLIFIED.t4) v(XU.VGND.t21) v(XU.FILTER__MID.t1) v(XU.FILTER__BUFFER0__PRE.t4) v(XU.PGA__SELECTED.t3) v(XU.PGA__V8.t5) v(XU.GAIN.t2) v(XU.VGND.t104) v(XU.FILTER__BUFFER1__PRE.t0) v(XU.FILTER__BUFFER1__FIRST__MIR.t4) v(XU.BIAS_SOURCE__VCM_BUFFER__FIRST__MIR.t3) v(XU.BIAS_SOURCE__VCM_BUFFER__FIRST__MIR.t2) v(XU.D.t1) v(XU.SAMPLE__M.t1) v(XU.CLK.t1) v(XU.BIAS_SOURCE__VCM_BUFFER__FIRST__TAIL.t4) v(XU.BIAS_SOURCE__VCM_BUFFER__PRE.t0) v(XU.BIAS_SOURCE__VCM_RAW.t6) v(XU.VGND.t113) v(XU.FILTER__BUFFER0__FIRST__TAIL.t2) v(XU.FILTER__BUFFER0__PRE.t2) v(XU.FILTER__FILTER0.t4) v(XU.VGND.t35) v(XU.RESET_MUX__SB.t0) v(XU.RESET.t1) v(XU.VGND.t72) v(XU.COMPARATOR__PREAMP__TAIL.t0) v(XU.BIAS.t5) v(XU.VGND.t71) v(XU.SAMPLE__MF.t5) v(XU.SAMPLE__T.t3) v(XU.SAMPLE__CLKB.t3) v(XU.PGA__OUTPUT_BUFFER__FIRST__TAIL.t3) v(XU.PGA__OUTPUT_BUFFER__FIRST__MIR.t3) v(XU.AMPLIFIED.t5) v(XU.VGND.t20) v(XU.PGA__GAIN2__AMP__FIRST__TAIL.t3) v(XU.PGA__GAIN2__AMP__PRE.t1) v(XU.VIN.t1) v(XU.VGND.t112) v(XU.VGND.t23) v(XU.AMPLIFIED.t0) v(XU.BIAS.t6) v(XU.VGND.t22) v(XU.DATA.t2) v(XU.SAMPLE__TB.t2) v(XU.SAMPLE__MB.t0) v(XU.SAMPLE__M.t4) v(XU.BIAS_SOURCE__VCM_BUFFER__FIRST__TAIL.t2) v(XU.BIAS_SOURCE__VCM_BUFFER__FIRST__MIR.t0) v(XU.VCM.t5) v(XU.VGND.t5) v(XU.SAMPLE__TB.t0) v(XU.SAMPLE__T.t4) v(XU.PGA__GAIN8__AMP__FIRST__TAIL.t4) v(XU.PGA__GAIN8__AMP__PRE.t2) v(XU.VIN.t2) v(XU.VGND.t133) v(XU.FILTER__BUFFER0__FIRST__TAIL.t1) v(XU.FILTER__BUFFER0__PRE.t1) v(XU.FILTER__FILTER0.t6) v(XU.VGND.t33) v(XU.VGND.t99) v(XU.BIAS_SOURCE__VCM_BUFFER__FIRST__TAIL.t0) v(XU.BIAS.t7) v(XU.VGND.t98) v(XU.COMPARATOR__PREAMP__MIR.t2) v(XU.COMPARATOR__PREAMP__MIR.t1) v(XU.FILTER__BUFFER1__FIRST__MIR.t3) v(XU.FILTER__BUFFER1__FIRST__MIR.t2) v(XU.COMPARATOR__PREAMP__TAIL.t2) v(XU.COMPARATOR__PRE.t1) v(XU.OUT.t3) v(XU.VGND.t124) v(XU.CMP.t1) v(XU.D.t4) v(XU.RESET_MUX__SB.t2) v(XU.VGND.t79) v(XU.PGA__OUTPUT_BUFFER__FIRST__TAIL.t2) v(XU.PGA__OUTPUT_BUFFER__PRE.t2) v(XU.PGA__SELECTED.t4) v(XU.VGND.t88) v(XU.VGND.t2) v(XU.VCM.t0) v(XU.BIAS.t8) v(XU.VGND.t1) v(XU.PGA__GAIN8__AMP__FIRST__TAIL.t2) v(XU.PGA__GAIN8__AMP__FIRST__MIR.t3) v(XU.PGA__GAIN8__FB.t2) v(XU.VGND.t121) v(XU.VGND.t84) v(XU.D.t5) v(XU.RESET_MUX__SB.t3) v(XU.COMPARATOR__PRE.t0) v(XU.COMPARATOR__PREAMP__MIR.t3) v(XU.PGA__GAIN8__AMP__FIRST__TAIL.t1) v(XU.PGA__GAIN8__AMP__PRE.t0) v(XU.VIN.t3) v(XU.VGND.t54) v(XU.CMP.t0) v(XU.D.t3) v(XU.RESET.t2) v(XU.VGND.t7) v(XU.SAMPLE__CLKB.t1) v(XU.CLK.t2) v(XU.VGND.t6) v(XU.PGA__OUTPUT_BUFFER__FIRST__TAIL.t1) v(XU.PGA__OUTPUT_BUFFER__PRE.t1) v(XU.PGA__SELECTED.t5) v(XU.VGND.t67) v(XU.BIAS_SOURCE__VCM_BUFFER__FIRST__TAIL.t1) v(XU.BIAS_SOURCE__VCM_BUFFER__FIRST__MIR.t1) v(XU.VCM.t6) v(XU.VGND.t63) v(XU.PGA__GAIN2__AMP__FIRST__TAIL.t1) v(XU.PGA__GAIN2__AMP__FIRST__MIR.t3) v(XU.PGA__GAIN2__FB.t2) v(XU.VGND.t87) v(VGND)
set num_threads=1
set numdgt=17
set wr_singlescale
set wr_vecnames
set noaskquit
tran 2e-08 0.0002
let mos_wave_0 = v(OUT)
let mos_wave_1 = -i(VDD)
let mos_wave_2 = v(VIN)
let mos_wave_3 = v(GAIN)
let mos_wave_4 = v(CLK)
let mos_wave_5 = v(RESET)
let mos_wave_6 = v(DATA)
let mos_wave_7 = v(VCM)
let mos_wave_8 = v(BIAS)
wrdata waveform.dat mos_wave_0 mos_wave_1 mos_wave_2 mos_wave_3 mos_wave_4 mos_wave_5 mos_wave_6 mos_wave_7 mos_wave_8
write waveform.raw all
let register_flow_0 = i(v.xu.vregister_cf_364978ad91fabd22)
let register_flow_1 = i(v.xu.vregister_cf_2f3a5d093469eef5)
let register_flow_2 = i(v.xu.vregister_cf_7175e89028bb7248)
let register_flow_3 = i(v.xu.vregister_cf_b03c907f260c2886)
let register_flow_4 = i(v.xu.vregister_cf_49c749606463d3e7)
let register_flow_5 = i(v.xu.vregister_cf_5339a2ad49f84627)
let register_flow_6 = i(v.xu.vregister_cf_d866ad78d458a60d)
let register_flow_7 = i(v.xu.vregister_cf_c4c6ca526db8e569)
let register_flow_8 = i(v.xu.vregister_cf_42918cdd66f3ae1c)
let register_flow_9 = i(v.xu.vregister_cf_05c6904e96e95a07)
let register_flow_10 = i(v.xu.vregister_cf_2cd08cc02cc01151)
let register_flow_11 = i(v.xu.vregister_cf_3fd3b3ec0fd5efd1)
let register_flow_12 = i(v.xu.vregister_cf_ab092755cd55528a)
let register_flow_13 = i(v.xu.vregister_cf_348b92bd8ffb1bd7)
let register_flow_14 = i(v.xu.vregister_cf_252b3710cc6a1ae8)
let register_flow_15 = i(v.xu.vregister_cf_0a2948402ec592a6)
let register_flow_16 = i(v.xu.vregister_cf_4ae0e0a672255849)
let register_flow_17 = i(v.xu.vregister_cf_47d59203f1a40b37)
let register_flow_18 = i(v.xu.vregister_cf_97f755f9997d72fc)
let register_flow_19 = i(v.xu.vregister_cf_0a2200bd559594c6)
let register_flow_20 = i(v.xu.vregister_cf_fbff23537e98467c)
let register_flow_21 = i(v.xu.vregister_cf_19d955342b95dba6)
let register_flow_22 = i(v.xu.vregister_cf_180f1a3a25a05eed)
let register_flow_23 = i(v.xu.vregister_cf_5a1bed08c3e8147b)
let register_flow_24 = i(v.xu.vregister_cf_5e8977893f444654)
let register_flow_25 = i(v.xu.vregister_cf_91543fc7b0b915b6)
let register_flow_26 = i(v.xu.vregister_cf_f9ce593811f5be84)
let register_flow_27 = i(v.xu.vregister_cf_3c863b4c3d76d79a)
let register_flow_28 = i(v.xu.vregister_cf_2e6bfea501a74f1b)
let register_flow_29 = i(v.xu.vregister_cf_8ae07d91a7ec8891)
let register_flow_30 = i(v.xu.vregister_cf_da575a61d8815f68)
let register_flow_31 = i(v.xu.vregister_cf_2a969e9e6fe3c2b5)
let register_flow_32 = i(v.xu.vregister_cf_58d02d6642816e24)
let register_flow_33 = i(v.xu.vregister_cf_df0c7f0461fcbe9d)
let register_flow_34 = i(v.xu.vregister_cf_c1a3cc7e8db487d8)
let register_flow_35 = i(v.xu.vregister_cf_46aeb6a72436bd2c)
let register_flow_36 = i(v.xu.vregister_cf_2f1a58acfd68c6f8)
let register_flow_37 = i(v.xu.vregister_cf_5483726bce058902)
let register_flow_38 = i(v.xu.vregister_cf_d1ce7a36509983e0)
let register_flow_39 = i(v.xu.vregister_cf_663abaf3e8bae0e2)
let register_flow_40 = i(v.xu.vregister_cf_50bdcd4754318caf)
let register_flow_41 = i(v.xu.vregister_cf_75311aafbce4a3d1)
let register_flow_42 = i(v.xu.vregister_cf_9fbc4f8be125a026)
let register_flow_43 = i(v.xu.vregister_cf_888c64d54c22e83e)
let register_flow_44 = i(v.xu.vregister_cf_6aaad9666b7539ee)
let register_flow_45 = i(v.xu.vregister_cf_29e3eda06c59ef82)
let register_flow_46 = i(v.xu.vregister_cf_c3a46168b32a2f5b)
let register_flow_47 = i(v.xu.vregister_cf_30afca0182d35ed6)
let register_flow_48 = i(v.xu.vregister_cf_43fc01830a2a01de)
let register_flow_49 = i(v.xu.vregister_cf_27ac3e6956716256)
let register_flow_50 = i(v.xu.vregister_cf_2c60808c1b7d8841)
let register_flow_51 = i(v.xu.vregister_cf_2728813c13aa9c5f)
let register_flow_52 = i(v.xu.vregister_cf_2f47df2410f2be69)
let register_flow_53 = i(v.xu.vregister_cf_e1880fd89cfb3a5d)
let register_flow_54 = i(v.xu.vregister_cf_4d85aa482b47db42)
let register_flow_55 = i(v.xu.vregister_cf_b1fbb596e933bb3e)
let register_flow_56 = i(VGND)
let register_flow_57 = i(VDD)
let register_flow_58 = i(VIN)
let register_flow_59 = i(VGAIN)
let register_flow_60 = i(VCLK)
let register_flow_61 = i(VRESET)
wrdata current-flow.dat register_flow_0 register_flow_1 register_flow_2 register_flow_3 register_flow_4 register_flow_5 register_flow_6 register_flow_7 register_flow_8 register_flow_9 register_flow_10 register_flow_11 register_flow_12 register_flow_13 register_flow_14 register_flow_15 register_flow_16 register_flow_17 register_flow_18 register_flow_19 register_flow_20 register_flow_21 register_flow_22 register_flow_23 register_flow_24 register_flow_25 register_flow_26 register_flow_27 register_flow_28 register_flow_29 register_flow_30 register_flow_31 register_flow_32 register_flow_33 register_flow_34 register_flow_35 register_flow_36 register_flow_37 register_flow_38 register_flow_39 register_flow_40 register_flow_41 register_flow_42 register_flow_43 register_flow_44 register_flow_45 register_flow_46 register_flow_47 register_flow_48 register_flow_49 register_flow_50 register_flow_51 register_flow_52 register_flow_53 register_flow_54 register_flow_55 register_flow_56 register_flow_57 register_flow_58 register_flow_59 register_flow_60 register_flow_61
let register_voltage_0 = v(VPWR)
let register_voltage_1 = v(XU.FILTER__BUFFER0__FIRST__MIR.t1)
let register_voltage_2 = v(XU.FILTER__BUFFER0__FIRST__MIR.t0)
let register_voltage_3 = v(XU.VGND.t65)
let register_voltage_4 = v(XU.CMP.t3)
let register_voltage_5 = v(XU.COMPARATOR__PRE.t2)
let register_voltage_6 = v(XU.VGND.t64)
let register_voltage_7 = v(XU.FILTER__BUFFER1__FIRST__TAIL.t3)
let register_voltage_8 = v(XU.FILTER__BUFFER1__PRE.t1)
let register_voltage_9 = v(XU.FILTER__FILTER1.t2)
let register_voltage_10 = v(XU.VGND.t128)
let register_voltage_11 = v(XU.SAMPLE__MF.t2)
let register_voltage_12 = v(XU.SAMPLE__MB.t2)
let register_voltage_13 = v(XU.CMP.t2)
let register_voltage_14 = v(XU.COMPARATOR__PRE.t3)
let register_voltage_15 = v(XU.VGND.t131)
let register_voltage_16 = v(XU.PGA__GAIN8__AMP__FIRST__TAIL.t0)
let register_voltage_17 = v(XU.BIAS.t3)
let register_voltage_18 = v(XU.VGND.t130)
let register_voltage_19 = v(XU.FILTER__BUFFER1__FIRST__TAIL.t2)
let register_voltage_20 = v(XU.FILTER__BUFFER1__PRE.t2)
let register_voltage_21 = v(XU.FILTER__FILTER1.t4)
let register_voltage_22 = v(XU.VGND.t97)
let register_voltage_23 = v(XU.PGA__OUTPUT_BUFFER__FIRST__MIR.t1)
let register_voltage_24 = v(XU.PGA__OUTPUT_BUFFER__FIRST__MIR.t0)
let register_voltage_25 = v(XU.PGA__SELECTED.t2)
let register_voltage_26 = v(XU.PGA__V2.t5)
let register_voltage_27 = v(XU.GAIN.t0)
let register_voltage_28 = v(XU.PGA__GAINB.t0)
let register_voltage_29 = v(XU.GAIN.t1)
let register_voltage_30 = v(XU.VGND.t45)
let register_voltage_31 = v(XU.PGA__OUTPUT_BUFFER__FIRST__TAIL.t0)
let register_voltage_32 = v(XU.BIAS.t4)
let register_voltage_33 = v(XU.VGND.t44)
let register_voltage_34 = v(XU.PGA__SELECTED.t0)
let register_voltage_35 = v(XU.PGA__V8.t2)
let register_voltage_36 = v(XU.PGA__GAINB.t2)
let register_voltage_37 = v(XU.VGND.t74)
let register_voltage_38 = v(XU.D.t2)
let register_voltage_39 = v(XU.RESET.t0)
let register_voltage_40 = v(XU.VGND.t73)
let register_voltage_41 = v(XU.OUT.t2)
let register_voltage_42 = v(XU.FILTER__BUFFER1__PRE.t3)
let register_voltage_43 = v(XU.PGA__GAIN2__AMP__FIRST__TAIL.t4)
let register_voltage_44 = v(XU.PGA__GAIN2__AMP__PRE.t0)
let register_voltage_45 = v(XU.VIN.t0)
let register_voltage_46 = v(XU.VGND.t122)
let register_voltage_47 = v(XU.PGA__GAIN2__AMP__FIRST__MIR.t1)
let register_voltage_48 = v(XU.PGA__GAIN2__AMP__FIRST__MIR.t0)
let register_voltage_49 = v(XU.DATA.t1)
let register_voltage_50 = v(XU.SAMPLE__T.t0)
let register_voltage_51 = v(XU.CLK.t0)
let register_voltage_52 = v(XU.PGA__SELECTED.t1)
let register_voltage_53 = v(XU.PGA__V2.t3)
let register_voltage_54 = v(XU.PGA__GAINB.t3)
let register_voltage_55 = v(XU.VGND.t85)
let register_voltage_56 = v(XU.BIAS_SOURCE__VCM_BUFFER__PRE.t2)
let register_voltage_57 = v(XU.BIAS_SOURCE__VCM_BUFFER__FIRST__MIR.t4)
let register_voltage_58 = v(XU.SAMPLE__MF.t4)
let register_voltage_59 = v(XU.SAMPLE__M.t2)
let register_voltage_60 = v(XU.SAMPLE__CLKB.t2)
let register_voltage_61 = v(XU.PGA__OUTPUT_BUFFER__FIRST__TAIL.t4)
let register_voltage_62 = v(XU.PGA__OUTPUT_BUFFER__FIRST__MIR.t2)
let register_voltage_63 = v(XU.AMPLIFIED.t4)
let register_voltage_64 = v(XU.VGND.t21)
let register_voltage_65 = v(XU.FILTER__MID.t1)
let register_voltage_66 = v(XU.FILTER__BUFFER0__PRE.t4)
let register_voltage_67 = v(XU.PGA__SELECTED.t3)
let register_voltage_68 = v(XU.PGA__V8.t5)
let register_voltage_69 = v(XU.GAIN.t2)
let register_voltage_70 = v(XU.VGND.t104)
let register_voltage_71 = v(XU.FILTER__BUFFER1__PRE.t0)
let register_voltage_72 = v(XU.FILTER__BUFFER1__FIRST__MIR.t4)
let register_voltage_73 = v(XU.BIAS_SOURCE__VCM_BUFFER__FIRST__MIR.t3)
let register_voltage_74 = v(XU.BIAS_SOURCE__VCM_BUFFER__FIRST__MIR.t2)
let register_voltage_75 = v(XU.D.t1)
let register_voltage_76 = v(XU.SAMPLE__M.t1)
let register_voltage_77 = v(XU.CLK.t1)
let register_voltage_78 = v(XU.BIAS_SOURCE__VCM_BUFFER__FIRST__TAIL.t4)
let register_voltage_79 = v(XU.BIAS_SOURCE__VCM_BUFFER__PRE.t0)
let register_voltage_80 = v(XU.BIAS_SOURCE__VCM_RAW.t6)
let register_voltage_81 = v(XU.VGND.t113)
let register_voltage_82 = v(XU.FILTER__BUFFER0__FIRST__TAIL.t2)
let register_voltage_83 = v(XU.FILTER__BUFFER0__PRE.t2)
let register_voltage_84 = v(XU.FILTER__FILTER0.t4)
let register_voltage_85 = v(XU.VGND.t35)
let register_voltage_86 = v(XU.RESET_MUX__SB.t0)
let register_voltage_87 = v(XU.RESET.t1)
let register_voltage_88 = v(XU.VGND.t72)
let register_voltage_89 = v(XU.COMPARATOR__PREAMP__TAIL.t0)
let register_voltage_90 = v(XU.BIAS.t5)
let register_voltage_91 = v(XU.VGND.t71)
let register_voltage_92 = v(XU.SAMPLE__MF.t5)
let register_voltage_93 = v(XU.SAMPLE__T.t3)
let register_voltage_94 = v(XU.SAMPLE__CLKB.t3)
let register_voltage_95 = v(XU.PGA__OUTPUT_BUFFER__FIRST__TAIL.t3)
let register_voltage_96 = v(XU.PGA__OUTPUT_BUFFER__FIRST__MIR.t3)
let register_voltage_97 = v(XU.AMPLIFIED.t5)
let register_voltage_98 = v(XU.VGND.t20)
let register_voltage_99 = v(XU.PGA__GAIN2__AMP__FIRST__TAIL.t3)
let register_voltage_100 = v(XU.PGA__GAIN2__AMP__PRE.t1)
let register_voltage_101 = v(XU.VIN.t1)
let register_voltage_102 = v(XU.VGND.t112)
let register_voltage_103 = v(XU.VGND.t23)
let register_voltage_104 = v(XU.AMPLIFIED.t0)
let register_voltage_105 = v(XU.BIAS.t6)
let register_voltage_106 = v(XU.VGND.t22)
let register_voltage_107 = v(XU.DATA.t2)
let register_voltage_108 = v(XU.SAMPLE__TB.t2)
let register_voltage_109 = v(XU.SAMPLE__MB.t0)
let register_voltage_110 = v(XU.SAMPLE__M.t4)
let register_voltage_111 = v(XU.BIAS_SOURCE__VCM_BUFFER__FIRST__TAIL.t2)
let register_voltage_112 = v(XU.BIAS_SOURCE__VCM_BUFFER__FIRST__MIR.t0)
let register_voltage_113 = v(XU.VCM.t5)
let register_voltage_114 = v(XU.VGND.t5)
let register_voltage_115 = v(XU.SAMPLE__TB.t0)
let register_voltage_116 = v(XU.SAMPLE__T.t4)
let register_voltage_117 = v(XU.PGA__GAIN8__AMP__FIRST__TAIL.t4)
let register_voltage_118 = v(XU.PGA__GAIN8__AMP__PRE.t2)
let register_voltage_119 = v(XU.VIN.t2)
let register_voltage_120 = v(XU.VGND.t133)
let register_voltage_121 = v(XU.FILTER__BUFFER0__FIRST__TAIL.t1)
let register_voltage_122 = v(XU.FILTER__BUFFER0__PRE.t1)
let register_voltage_123 = v(XU.FILTER__FILTER0.t6)
let register_voltage_124 = v(XU.VGND.t33)
let register_voltage_125 = v(XU.VGND.t99)
let register_voltage_126 = v(XU.BIAS_SOURCE__VCM_BUFFER__FIRST__TAIL.t0)
let register_voltage_127 = v(XU.BIAS.t7)
let register_voltage_128 = v(XU.VGND.t98)
let register_voltage_129 = v(XU.COMPARATOR__PREAMP__MIR.t2)
let register_voltage_130 = v(XU.COMPARATOR__PREAMP__MIR.t1)
let register_voltage_131 = v(XU.FILTER__BUFFER1__FIRST__MIR.t3)
let register_voltage_132 = v(XU.FILTER__BUFFER1__FIRST__MIR.t2)
let register_voltage_133 = v(XU.COMPARATOR__PREAMP__TAIL.t2)
let register_voltage_134 = v(XU.COMPARATOR__PRE.t1)
let register_voltage_135 = v(XU.OUT.t3)
let register_voltage_136 = v(XU.VGND.t124)
let register_voltage_137 = v(XU.CMP.t1)
let register_voltage_138 = v(XU.D.t4)
let register_voltage_139 = v(XU.RESET_MUX__SB.t2)
let register_voltage_140 = v(XU.VGND.t79)
let register_voltage_141 = v(XU.PGA__OUTPUT_BUFFER__FIRST__TAIL.t2)
let register_voltage_142 = v(XU.PGA__OUTPUT_BUFFER__PRE.t2)
let register_voltage_143 = v(XU.PGA__SELECTED.t4)
let register_voltage_144 = v(XU.VGND.t88)
let register_voltage_145 = v(XU.VGND.t2)
let register_voltage_146 = v(XU.VCM.t0)
let register_voltage_147 = v(XU.BIAS.t8)
let register_voltage_148 = v(XU.VGND.t1)
let register_voltage_149 = v(XU.PGA__GAIN8__AMP__FIRST__TAIL.t2)
let register_voltage_150 = v(XU.PGA__GAIN8__AMP__FIRST__MIR.t3)
let register_voltage_151 = v(XU.PGA__GAIN8__FB.t2)
let register_voltage_152 = v(XU.VGND.t121)
let register_voltage_153 = v(XU.VGND.t84)
let register_voltage_154 = v(XU.D.t5)
let register_voltage_155 = v(XU.RESET_MUX__SB.t3)
let register_voltage_156 = v(XU.COMPARATOR__PRE.t0)
let register_voltage_157 = v(XU.COMPARATOR__PREAMP__MIR.t3)
let register_voltage_158 = v(XU.PGA__GAIN8__AMP__FIRST__TAIL.t1)
let register_voltage_159 = v(XU.PGA__GAIN8__AMP__PRE.t0)
let register_voltage_160 = v(XU.VIN.t3)
let register_voltage_161 = v(XU.VGND.t54)
let register_voltage_162 = v(XU.CMP.t0)
let register_voltage_163 = v(XU.D.t3)
let register_voltage_164 = v(XU.RESET.t2)
let register_voltage_165 = v(XU.VGND.t7)
let register_voltage_166 = v(XU.SAMPLE__CLKB.t1)
let register_voltage_167 = v(XU.CLK.t2)
let register_voltage_168 = v(XU.VGND.t6)
let register_voltage_169 = v(XU.PGA__OUTPUT_BUFFER__FIRST__TAIL.t1)
let register_voltage_170 = v(XU.PGA__OUTPUT_BUFFER__PRE.t1)
let register_voltage_171 = v(XU.PGA__SELECTED.t5)
let register_voltage_172 = v(XU.VGND.t67)
let register_voltage_173 = v(XU.BIAS_SOURCE__VCM_BUFFER__FIRST__TAIL.t1)
let register_voltage_174 = v(XU.BIAS_SOURCE__VCM_BUFFER__FIRST__MIR.t1)
let register_voltage_175 = v(XU.VCM.t6)
let register_voltage_176 = v(XU.VGND.t63)
let register_voltage_177 = v(XU.PGA__GAIN2__AMP__FIRST__TAIL.t1)
let register_voltage_178 = v(XU.PGA__GAIN2__AMP__FIRST__MIR.t3)
let register_voltage_179 = v(XU.PGA__GAIN2__FB.t2)
let register_voltage_180 = v(XU.VGND.t87)
let register_voltage_181 = v(VGND)
let register_voltage_182 = 0*register_flow_0
let register_voltage_183 = v(VIN)
let register_voltage_184 = v(GAIN)
let register_voltage_185 = v(CLK)
let register_voltage_186 = v(RESET)
wrdata node-voltages.dat register_voltage_0 register_voltage_1 register_voltage_2 register_voltage_3 register_voltage_4 register_voltage_5 register_voltage_6 register_voltage_7 register_voltage_8 register_voltage_9 register_voltage_10 register_voltage_11 register_voltage_12 register_voltage_13 register_voltage_14 register_voltage_15 register_voltage_16 register_voltage_17 register_voltage_18 register_voltage_19 register_voltage_20 register_voltage_21 register_voltage_22 register_voltage_23 register_voltage_24 register_voltage_25 register_voltage_26 register_voltage_27 register_voltage_28 register_voltage_29 register_voltage_30 register_voltage_31 register_voltage_32 register_voltage_33 register_voltage_34 register_voltage_35 register_voltage_36 register_voltage_37 register_voltage_38 register_voltage_39 register_voltage_40 register_voltage_41 register_voltage_42 register_voltage_43 register_voltage_44 register_voltage_45 register_voltage_46 register_voltage_47 register_voltage_48 register_voltage_49 register_voltage_50 register_voltage_51 register_voltage_52 register_voltage_53 register_voltage_54 register_voltage_55 register_voltage_56 register_voltage_57 register_voltage_58 register_voltage_59 register_voltage_60 register_voltage_61 register_voltage_62 register_voltage_63 register_voltage_64 register_voltage_65 register_voltage_66 register_voltage_67 register_voltage_68 register_voltage_69 register_voltage_70 register_voltage_71 register_voltage_72 register_voltage_73 register_voltage_74 register_voltage_75 register_voltage_76 register_voltage_77 register_voltage_78 register_voltage_79 register_voltage_80 register_voltage_81 register_voltage_82 register_voltage_83 register_voltage_84 register_voltage_85 register_voltage_86 register_voltage_87 register_voltage_88 register_voltage_89 register_voltage_90 register_voltage_91 register_voltage_92 register_voltage_93 register_voltage_94 register_voltage_95 register_voltage_96 register_voltage_97 register_voltage_98 register_voltage_99 register_voltage_100 register_voltage_101 register_voltage_102 register_voltage_103 register_voltage_104 register_voltage_105 register_voltage_106 register_voltage_107 register_voltage_108 register_voltage_109 register_voltage_110 register_voltage_111 register_voltage_112 register_voltage_113 register_voltage_114 register_voltage_115 register_voltage_116 register_voltage_117 register_voltage_118 register_voltage_119 register_voltage_120 register_voltage_121 register_voltage_122 register_voltage_123 register_voltage_124 register_voltage_125 register_voltage_126 register_voltage_127 register_voltage_128 register_voltage_129 register_voltage_130 register_voltage_131 register_voltage_132 register_voltage_133 register_voltage_134 register_voltage_135 register_voltage_136 register_voltage_137 register_voltage_138 register_voltage_139 register_voltage_140 register_voltage_141 register_voltage_142 register_voltage_143 register_voltage_144 register_voltage_145 register_voltage_146 register_voltage_147 register_voltage_148 register_voltage_149 register_voltage_150 register_voltage_151 register_voltage_152 register_voltage_153 register_voltage_154 register_voltage_155 register_voltage_156 register_voltage_157 register_voltage_158 register_voltage_159 register_voltage_160 register_voltage_161 register_voltage_162 register_voltage_163 register_voltage_164 register_voltage_165 register_voltage_166 register_voltage_167 register_voltage_168 register_voltage_169 register_voltage_170 register_voltage_171 register_voltage_172 register_voltage_173 register_voltage_174 register_voltage_175 register_voltage_176 register_voltage_177 register_voltage_178 register_voltage_179 register_voltage_180 register_voltage_181 register_voltage_182 register_voltage_183 register_voltage_184 register_voltage_185 register_voltage_186
quit
.endc
.end

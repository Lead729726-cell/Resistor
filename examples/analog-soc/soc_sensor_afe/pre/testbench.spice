Resistor analog SoC soc_sensor_afe
.include "./supported-tt.spice"
.options method=gear maxord=2
.include "./current-probe.spice"
.temp 27.0
VGND VGND 0 0
VDD VPWR VGND 1.8
VIN VIN VGND DC 0.9 AC 1 SIN(0.9 0.025 5000)
VGAIN GAIN VGND PULSE(0 1.8 100u 2n 2n 1 2)
VCLK CLK VGND PULSE(0 1.8 250n 2n 2n 498n 1u)
VRESET RESET VGND PWL(0 1.8 5u 1.8 5.002u 0)
CLOAD OUT VGND 50f
XU VIN GAIN CLK RESET OUT DATA VCM BIAS VPWR VGND soc_sensor_afe
.control
save v(OUT) i(VDD) v(VIN) v(GAIN) v(CLK) v(RESET) v(DATA) v(VCM) v(BIAS) i(v.xu.vregister_cf_1cdfa349d923dfb6) i(v.xu.vregister_cf_f7df2c7de04f41ec) i(v.xu.vregister_cf_156fd377ecf44847) i(v.xu.vregister_cf_10874caec9dc87ee) i(v.xu.vregister_cf_fda8c84343d7ad8c) i(v.xu.vregister_cf_24a7912a68e04950) i(v.xu.vregister_cf_a4f143fea9f2cfff) i(v.xu.vregister_cf_eca2d4119abf5ea4) i(v.xu.vregister_cf_642c575fea9eb7d4) i(v.xu.vregister_cf_9d1744eca2d64648) i(v.xu.vregister_cf_e3102478511b8837) i(v.xu.vregister_cf_18f5662f0d50ee36) i(v.xu.vregister_cf_334141ce685e7c2f) i(v.xu.vregister_cf_c53c0b2565f53ef4) i(v.xu.vregister_cf_98a25b8d46859b10) i(v.xu.vregister_cf_122b65ceebd5a700) i(v.xu.vregister_cf_75331bd619524b5d) i(v.xu.vregister_cf_0e13bf8b496f9c68) i(v.xu.vregister_cf_26348b89100366b7) i(v.xu.vregister_cf_fd6e518dd7979607) i(v.xu.vregister_cf_7c0362d20f1bb9aa) i(v.xu.vregister_cf_541e2876687f09d3) i(v.xu.vregister_cf_f6af4d29a72b73e7) i(v.xu.vregister_cf_e16973bbe0bb1549) i(v.xu.vregister_cf_cb520d6f20b8f9af) i(v.xu.vregister_cf_0a9ac7a772237125) i(v.xu.vregister_cf_582c5051c2480a75) i(v.xu.vregister_cf_016483cc89710033) i(v.xu.vregister_cf_29a31ddf48631d60) i(v.xu.vregister_cf_e02b1bb0e5ccf232) i(v.xu.vregister_cf_72de1048f8cca4e7) i(v.xu.vregister_cf_2aed44c57a1c870d) i(v.xu.vregister_cf_ec0811d5885acc03) i(v.xu.vregister_cf_57b2e49526ac4c17) i(v.xu.vregister_cf_36b02b07e7203239) i(v.xu.vregister_cf_e0a711719bf5c4c4) i(v.xu.vregister_cf_33dcc485d4a44380) i(v.xu.vregister_cf_47c0aa59d6a62f8c) i(v.xu.vregister_cf_efb34d6896c2a823) i(v.xu.vregister_cf_2e4d8194109e133b) i(v.xu.vregister_cf_96b9de5fb593ba10) i(v.xu.vregister_cf_2c918fd9ce7bd97b) i(v.xu.vregister_cf_d88b25d6a451af9e) i(v.xu.vregister_cf_e7004b47c293340b) i(v.xu.vregister_cf_a9869b7c758976d0) i(v.xu.vregister_cf_9e2af3326c6b102b) i(v.xu.vregister_cf_fa2ceea394339725) i(v.xu.vregister_cf_082488ca12a10e39) i(v.xu.vregister_cf_543810d82ff6267f) i(v.xu.vregister_cf_6e34886cd940133c) i(v.xu.vregister_cf_9316b654254c7e80) i(v.xu.vregister_cf_8e4fe5689fedce67) i(v.xu.vregister_cf_4e0e120bb22caed8) i(v.xu.vregister_cf_e35a359c098fe927) i(v.xu.vregister_cf_b54f511a9817a5c8) i(v.xu.vregister_cf_567b29a774bcb0f8) i(VGND) i(VIN) i(VGAIN) i(VCLK) i(VRESET) v(VGND) v(XU.BIAS_SOURCE__VCM_BUFFER__FIRST__MIR) v(XU.BIAS_SOURCE__VCM_BUFFER__FIRST__TAIL) v(XU.BIAS_SOURCE__VCM_BUFFER__PRE) v(XU.BIAS_SOURCE__VCM_RAW) v(VPWR) v(XU.CMP) v(XU.COMPARATOR__PRE) v(XU.COMPARATOR__PREAMP__MIR) v(XU.COMPARATOR__PREAMP__TAIL) v(XU.FILTER__BUFFER0__FIRST__MIR) v(XU.FILTER__BUFFER0__FIRST__TAIL) v(XU.FILTER__MID) v(XU.FILTER__BUFFER0__PRE) v(XU.FILTER__FILTER0) v(XU.FILTER__BUFFER1__FIRST__MIR) v(XU.FILTER__BUFFER1__FIRST__TAIL) v(XU.FILTER__BUFFER1__PRE) v(XU.FILTER__FILTER1) v(XU.PGA__AMP__FIRST__MIR) v(XU.PGA__AMP__FIRST__TAIL) v(XU.PGA__FB) v(XU.PGA__AMP__PRE) v(XU.AMPLIFIED) v(XU.PGA__GAINB) v(XU.PGA__LOW) v(XU.RESET_MUX__SB) v(XU.D) v(XU.SAMPLE__CLKB) v(XU.SAMPLE__MB) v(XU.SAMPLE__M) v(XU.SAMPLE__MF) v(XU.SAMPLE__T)
set num_threads=1
set numdgt=17
set wr_singlescale
set wr_vecnames
set noaskquit
tran 2e-08 0.0002
let mos_wave_0 = v(OUT)
let mos_wave_1 = -i(VDD)
let mos_wave_2 = v(VIN)
let mos_wave_3 = v(GAIN)
let mos_wave_4 = v(CLK)
let mos_wave_5 = v(RESET)
let mos_wave_6 = v(DATA)
let mos_wave_7 = v(VCM)
let mos_wave_8 = v(BIAS)
wrdata waveform.dat mos_wave_0 mos_wave_1 mos_wave_2 mos_wave_3 mos_wave_4 mos_wave_5 mos_wave_6 mos_wave_7 mos_wave_8
write waveform.raw all
let register_flow_0 = i(v.xu.vregister_cf_1cdfa349d923dfb6)
let register_flow_1 = i(v.xu.vregister_cf_f7df2c7de04f41ec)
let register_flow_2 = i(v.xu.vregister_cf_156fd377ecf44847)
let register_flow_3 = i(v.xu.vregister_cf_10874caec9dc87ee)
let register_flow_4 = i(v.xu.vregister_cf_fda8c84343d7ad8c)
let register_flow_5 = i(v.xu.vregister_cf_24a7912a68e04950)
let register_flow_6 = i(v.xu.vregister_cf_a4f143fea9f2cfff)
let register_flow_7 = i(v.xu.vregister_cf_eca2d4119abf5ea4)
let register_flow_8 = i(v.xu.vregister_cf_642c575fea9eb7d4)
let register_flow_9 = i(v.xu.vregister_cf_9d1744eca2d64648)
let register_flow_10 = i(v.xu.vregister_cf_e3102478511b8837)
let register_flow_11 = i(v.xu.vregister_cf_18f5662f0d50ee36)
let register_flow_12 = i(v.xu.vregister_cf_334141ce685e7c2f)
let register_flow_13 = i(v.xu.vregister_cf_c53c0b2565f53ef4)
let register_flow_14 = i(v.xu.vregister_cf_98a25b8d46859b10)
let register_flow_15 = i(v.xu.vregister_cf_122b65ceebd5a700)
let register_flow_16 = i(v.xu.vregister_cf_75331bd619524b5d)
let register_flow_17 = i(v.xu.vregister_cf_0e13bf8b496f9c68)
let register_flow_18 = i(v.xu.vregister_cf_26348b89100366b7)
let register_flow_19 = i(v.xu.vregister_cf_fd6e518dd7979607)
let register_flow_20 = i(v.xu.vregister_cf_7c0362d20f1bb9aa)
let register_flow_21 = i(v.xu.vregister_cf_541e2876687f09d3)
let register_flow_22 = i(v.xu.vregister_cf_f6af4d29a72b73e7)
let register_flow_23 = i(v.xu.vregister_cf_e16973bbe0bb1549)
let register_flow_24 = i(v.xu.vregister_cf_cb520d6f20b8f9af)
let register_flow_25 = i(v.xu.vregister_cf_0a9ac7a772237125)
let register_flow_26 = i(v.xu.vregister_cf_582c5051c2480a75)
let register_flow_27 = i(v.xu.vregister_cf_016483cc89710033)
let register_flow_28 = i(v.xu.vregister_cf_29a31ddf48631d60)
let register_flow_29 = i(v.xu.vregister_cf_e02b1bb0e5ccf232)
let register_flow_30 = i(v.xu.vregister_cf_72de1048f8cca4e7)
let register_flow_31 = i(v.xu.vregister_cf_2aed44c57a1c870d)
let register_flow_32 = i(v.xu.vregister_cf_ec0811d5885acc03)
let register_flow_33 = i(v.xu.vregister_cf_57b2e49526ac4c17)
let register_flow_34 = i(v.xu.vregister_cf_36b02b07e7203239)
let register_flow_35 = i(v.xu.vregister_cf_e0a711719bf5c4c4)
let register_flow_36 = i(v.xu.vregister_cf_33dcc485d4a44380)
let register_flow_37 = i(v.xu.vregister_cf_47c0aa59d6a62f8c)
let register_flow_38 = i(v.xu.vregister_cf_efb34d6896c2a823)
let register_flow_39 = i(v.xu.vregister_cf_2e4d8194109e133b)
let register_flow_40 = i(v.xu.vregister_cf_96b9de5fb593ba10)
let register_flow_41 = i(v.xu.vregister_cf_2c918fd9ce7bd97b)
let register_flow_42 = i(v.xu.vregister_cf_d88b25d6a451af9e)
let register_flow_43 = i(v.xu.vregister_cf_e7004b47c293340b)
let register_flow_44 = i(v.xu.vregister_cf_a9869b7c758976d0)
let register_flow_45 = i(v.xu.vregister_cf_9e2af3326c6b102b)
let register_flow_46 = i(v.xu.vregister_cf_fa2ceea394339725)
let register_flow_47 = i(v.xu.vregister_cf_082488ca12a10e39)
let register_flow_48 = i(v.xu.vregister_cf_543810d82ff6267f)
let register_flow_49 = i(v.xu.vregister_cf_6e34886cd940133c)
let register_flow_50 = i(v.xu.vregister_cf_9316b654254c7e80)
let register_flow_51 = i(v.xu.vregister_cf_8e4fe5689fedce67)
let register_flow_52 = i(v.xu.vregister_cf_4e0e120bb22caed8)
let register_flow_53 = i(v.xu.vregister_cf_e35a359c098fe927)
let register_flow_54 = i(v.xu.vregister_cf_b54f511a9817a5c8)
let register_flow_55 = i(v.xu.vregister_cf_567b29a774bcb0f8)
let register_flow_56 = i(VGND)
let register_flow_57 = i(VDD)
let register_flow_58 = i(VIN)
let register_flow_59 = i(VGAIN)
let register_flow_60 = i(VCLK)
let register_flow_61 = i(VRESET)
wrdata current-flow.dat register_flow_0 register_flow_1 register_flow_2 register_flow_3 register_flow_4 register_flow_5 register_flow_6 register_flow_7 register_flow_8 register_flow_9 register_flow_10 register_flow_11 register_flow_12 register_flow_13 register_flow_14 register_flow_15 register_flow_16 register_flow_17 register_flow_18 register_flow_19 register_flow_20 register_flow_21 register_flow_22 register_flow_23 register_flow_24 register_flow_25 register_flow_26 register_flow_27 register_flow_28 register_flow_29 register_flow_30 register_flow_31 register_flow_32 register_flow_33 register_flow_34 register_flow_35 register_flow_36 register_flow_37 register_flow_38 register_flow_39 register_flow_40 register_flow_41 register_flow_42 register_flow_43 register_flow_44 register_flow_45 register_flow_46 register_flow_47 register_flow_48 register_flow_49 register_flow_50 register_flow_51 register_flow_52 register_flow_53 register_flow_54 register_flow_55 register_flow_56 register_flow_57 register_flow_58 register_flow_59 register_flow_60 register_flow_61
let register_voltage_0 = v(BIAS)
let register_voltage_1 = v(VGND)
let register_voltage_2 = v(XU.BIAS_SOURCE__VCM_BUFFER__FIRST__MIR)
let register_voltage_3 = v(XU.BIAS_SOURCE__VCM_BUFFER__FIRST__TAIL)
let register_voltage_4 = v(VCM)
let register_voltage_5 = v(XU.BIAS_SOURCE__VCM_BUFFER__PRE)
let register_voltage_6 = v(XU.BIAS_SOURCE__VCM_RAW)
let register_voltage_7 = v(VPWR)
let register_voltage_8 = v(XU.CMP)
let register_voltage_9 = v(XU.COMPARATOR__PRE)
let register_voltage_10 = v(XU.COMPARATOR__PREAMP__MIR)
let register_voltage_11 = v(XU.COMPARATOR__PREAMP__TAIL)
let register_voltage_12 = v(OUT)
let register_voltage_13 = v(XU.FILTER__BUFFER0__FIRST__MIR)
let register_voltage_14 = v(XU.FILTER__BUFFER0__FIRST__TAIL)
let register_voltage_15 = v(XU.FILTER__MID)
let register_voltage_16 = v(XU.FILTER__BUFFER0__PRE)
let register_voltage_17 = v(XU.FILTER__FILTER0)
let register_voltage_18 = v(XU.FILTER__BUFFER1__FIRST__MIR)
let register_voltage_19 = v(XU.FILTER__BUFFER1__FIRST__TAIL)
let register_voltage_20 = v(XU.FILTER__BUFFER1__PRE)
let register_voltage_21 = v(XU.FILTER__FILTER1)
let register_voltage_22 = v(XU.PGA__AMP__FIRST__MIR)
let register_voltage_23 = v(XU.PGA__AMP__FIRST__TAIL)
let register_voltage_24 = v(XU.PGA__FB)
let register_voltage_25 = v(XU.PGA__AMP__PRE)
let register_voltage_26 = v(VIN)
let register_voltage_27 = v(XU.AMPLIFIED)
let register_voltage_28 = v(XU.PGA__GAINB)
let register_voltage_29 = v(GAIN)
let register_voltage_30 = v(XU.PGA__LOW)
let register_voltage_31 = v(XU.RESET_MUX__SB)
let register_voltage_32 = v(RESET)
let register_voltage_33 = v(XU.D)
let register_voltage_34 = v(XU.SAMPLE__CLKB)
let register_voltage_35 = v(CLK)
let register_voltage_36 = v(XU.SAMPLE__MB)
let register_voltage_37 = v(XU.SAMPLE__M)
let register_voltage_38 = v(XU.SAMPLE__MF)
let register_voltage_39 = v(XU.SAMPLE__T)
let register_voltage_40 = v(DATA)
let register_voltage_41 = 0*register_flow_0
wrdata node-voltages.dat register_voltage_0 register_voltage_1 register_voltage_2 register_voltage_3 register_voltage_4 register_voltage_5 register_voltage_6 register_voltage_7 register_voltage_8 register_voltage_9 register_voltage_10 register_voltage_11 register_voltage_12 register_voltage_13 register_voltage_14 register_voltage_15 register_voltage_16 register_voltage_17 register_voltage_18 register_voltage_19 register_voltage_20 register_voltage_21 register_voltage_22 register_voltage_23 register_voltage_24 register_voltage_25 register_voltage_26 register_voltage_27 register_voltage_28 register_voltage_29 register_voltage_30 register_voltage_31 register_voltage_32 register_voltage_33 register_voltage_34 register_voltage_35 register_voltage_36 register_voltage_37 register_voltage_38 register_voltage_39 register_voltage_40 register_voltage_41
quit
.endc
.end

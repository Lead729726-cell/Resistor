.subckt soc_sensor_afe VIN GAIN CLK RESET OUT DATA VCM BIAS VPWR VGND
XBIAS_SOURCE_C_VCM_P0 BIAS_SOURCE__VCM_RAW VGND sky130_fd_pr__cap_mim_m3_1 w=28.68 l=28.68
XBIAS_SOURCE_C_VCM_P1 BIAS_SOURCE__VCM_RAW VGND sky130_fd_pr__cap_mim_m3_1 w=28.68 l=28.68
XBIAS_SOURCE_C_VCM_P10 BIAS_SOURCE__VCM_RAW VGND sky130_fd_pr__cap_mim_m3_1 w=28.68 l=28.68
XBIAS_SOURCE_C_VCM_P11 BIAS_SOURCE__VCM_RAW VGND sky130_fd_pr__cap_mim_m3_1 w=28.68 l=28.68
XBIAS_SOURCE_C_VCM_P2 BIAS_SOURCE__VCM_RAW VGND sky130_fd_pr__cap_mim_m3_1 w=28.68 l=28.68
XBIAS_SOURCE_C_VCM_P3 BIAS_SOURCE__VCM_RAW VGND sky130_fd_pr__cap_mim_m3_1 w=28.68 l=28.68
XBIAS_SOURCE_C_VCM_P4 BIAS_SOURCE__VCM_RAW VGND sky130_fd_pr__cap_mim_m3_1 w=28.68 l=28.68
XBIAS_SOURCE_C_VCM_P5 BIAS_SOURCE__VCM_RAW VGND sky130_fd_pr__cap_mim_m3_1 w=28.68 l=28.68
XBIAS_SOURCE_C_VCM_P6 BIAS_SOURCE__VCM_RAW VGND sky130_fd_pr__cap_mim_m3_1 w=28.68 l=28.68
XBIAS_SOURCE_C_VCM_P7 BIAS_SOURCE__VCM_RAW VGND sky130_fd_pr__cap_mim_m3_1 w=28.68 l=28.68
XBIAS_SOURCE_C_VCM_P8 BIAS_SOURCE__VCM_RAW VGND sky130_fd_pr__cap_mim_m3_1 w=28.68 l=28.68
XBIAS_SOURCE_C_VCM_P9 BIAS_SOURCE__VCM_RAW VGND sky130_fd_pr__cap_mim_m3_1 w=28.68 l=28.68
XBIAS_SOURCE_N_DIODE register_cf_node_1cdfa349d923dfb6 BIAS register_cf_node_1cdfa349d923dfb6_source VGND sky130_fd_pr__nfet_01v8 w=2 l=1 nf=1 m=1
Vregister_cf_1cdfa349d923dfb6 BIAS register_cf_node_1cdfa349d923dfb6 0
Vregister_cf_1cdfa349d923dfb6_source VGND register_cf_node_1cdfa349d923dfb6_source 0
XBIAS_SOURCE_R_BIAS_P0 VPWR BIAS VGND sky130_fd_pr__res_xhigh_po_1p41 l=20.985
XBIAS_SOURCE_R_VCM_BOTTOM_P0 BIAS_SOURCE__VCM_RAW BIAS_SOURCE_R_VCM_BOTTOM_R0_N0 VGND sky130_fd_pr__res_xhigh_po_1p41 l=23.335
XBIAS_SOURCE_R_VCM_BOTTOM_P1 BIAS_SOURCE_R_VCM_BOTTOM_R0_N0 BIAS_SOURCE_R_VCM_BOTTOM_R0_N1 VGND sky130_fd_pr__res_xhigh_po_1p41 l=23.335
XBIAS_SOURCE_R_VCM_BOTTOM_P2 BIAS_SOURCE_R_VCM_BOTTOM_R0_N1 VGND VGND sky130_fd_pr__res_xhigh_po_1p41 l=23.335
XBIAS_SOURCE_R_VCM_TOP_P0 VPWR BIAS_SOURCE_R_VCM_TOP_R0_N0 VGND sky130_fd_pr__res_xhigh_po_1p41 l=23.335
XBIAS_SOURCE_R_VCM_TOP_P1 BIAS_SOURCE_R_VCM_TOP_R0_N0 BIAS_SOURCE_R_VCM_TOP_R0_N1 VGND sky130_fd_pr__res_xhigh_po_1p41 l=23.335
XBIAS_SOURCE_R_VCM_TOP_P2 BIAS_SOURCE_R_VCM_TOP_R0_N1 BIAS_SOURCE__VCM_RAW VGND sky130_fd_pr__res_xhigh_po_1p41 l=23.335
XBIAS_SOURCE_VCM_BUFFER_C_MILLER_P0 BIAS_SOURCE__VCM_BUFFER__PRE BIAS_SOURCE__VCM_BUFFER__COMP sky130_fd_pr__cap_mim_m3_1 w=28.68 l=28.68
XBIAS_SOURCE_VCM_BUFFER_C_MILLER_P1 BIAS_SOURCE__VCM_BUFFER__PRE BIAS_SOURCE__VCM_BUFFER__COMP sky130_fd_pr__cap_mim_m3_1 w=28.68 l=28.68
XBIAS_SOURCE_VCM_BUFFER_C_MILLER_P2 BIAS_SOURCE__VCM_BUFFER__PRE BIAS_SOURCE__VCM_BUFFER__COMP sky130_fd_pr__cap_mim_m3_1 w=28.68 l=28.68
XBIAS_SOURCE_VCM_BUFFER_FIRST_N_INN register_cf_node_f7df2c7de04f41ec VCM register_cf_node_f7df2c7de04f41ec_source VGND sky130_fd_pr__nfet_01v8 w=10 l=1 nf=1 m=1
Vregister_cf_f7df2c7de04f41ec BIAS_SOURCE__VCM_BUFFER__FIRST__MIR register_cf_node_f7df2c7de04f41ec 0
Vregister_cf_f7df2c7de04f41ec_source BIAS_SOURCE__VCM_BUFFER__FIRST__TAIL register_cf_node_f7df2c7de04f41ec_source 0
XBIAS_SOURCE_VCM_BUFFER_FIRST_N_INP register_cf_node_156fd377ecf44847 BIAS_SOURCE__VCM_RAW register_cf_node_156fd377ecf44847_source VGND sky130_fd_pr__nfet_01v8 w=10 l=1 nf=1 m=1
Vregister_cf_156fd377ecf44847 BIAS_SOURCE__VCM_BUFFER__PRE register_cf_node_156fd377ecf44847 0
Vregister_cf_156fd377ecf44847_source BIAS_SOURCE__VCM_BUFFER__FIRST__TAIL register_cf_node_156fd377ecf44847_source 0
XBIAS_SOURCE_VCM_BUFFER_FIRST_N_TAIL register_cf_node_10874caec9dc87ee BIAS register_cf_node_10874caec9dc87ee_source VGND sky130_fd_pr__nfet_01v8 w=2 l=1 nf=1 m=1
Vregister_cf_10874caec9dc87ee BIAS_SOURCE__VCM_BUFFER__FIRST__TAIL register_cf_node_10874caec9dc87ee 0
Vregister_cf_10874caec9dc87ee_source VGND register_cf_node_10874caec9dc87ee_source 0
XBIAS_SOURCE_VCM_BUFFER_FIRST_P_DIODE register_cf_node_fda8c84343d7ad8c BIAS_SOURCE__VCM_BUFFER__FIRST__MIR register_cf_node_fda8c84343d7ad8c_source VPWR sky130_fd_pr__pfet_01v8_hvt w=20 l=1 nf=1 m=1
Vregister_cf_fda8c84343d7ad8c BIAS_SOURCE__VCM_BUFFER__FIRST__MIR register_cf_node_fda8c84343d7ad8c 0
Vregister_cf_fda8c84343d7ad8c_source VPWR register_cf_node_fda8c84343d7ad8c_source 0
XBIAS_SOURCE_VCM_BUFFER_FIRST_P_MIRROR register_cf_node_24a7912a68e04950 BIAS_SOURCE__VCM_BUFFER__FIRST__MIR register_cf_node_24a7912a68e04950_source VPWR sky130_fd_pr__pfet_01v8_hvt w=20 l=1 nf=1 m=1
Vregister_cf_24a7912a68e04950 BIAS_SOURCE__VCM_BUFFER__PRE register_cf_node_24a7912a68e04950 0
Vregister_cf_24a7912a68e04950_source VPWR register_cf_node_24a7912a68e04950_source 0
XBIAS_SOURCE_VCM_BUFFER_N_SECOND register_cf_node_a4f143fea9f2cfff BIAS register_cf_node_a4f143fea9f2cfff_source VGND sky130_fd_pr__nfet_01v8 w=2 l=1 nf=1 m=1
Vregister_cf_a4f143fea9f2cfff VCM register_cf_node_a4f143fea9f2cfff 0
Vregister_cf_a4f143fea9f2cfff_source VGND register_cf_node_a4f143fea9f2cfff_source 0
XBIAS_SOURCE_VCM_BUFFER_P_SECOND register_cf_node_eca2d4119abf5ea4 BIAS_SOURCE__VCM_BUFFER__PRE register_cf_node_eca2d4119abf5ea4_source VPWR sky130_fd_pr__pfet_01v8_hvt w=40 l=1 nf=1 m=1
Vregister_cf_eca2d4119abf5ea4 VCM register_cf_node_eca2d4119abf5ea4 0
Vregister_cf_eca2d4119abf5ea4_source VPWR register_cf_node_eca2d4119abf5ea4_source 0
XBIAS_SOURCE_VCM_BUFFER_R_ZERO_P0 BIAS_SOURCE__VCM_BUFFER__COMP VCM VGND sky130_fd_pr__res_xhigh_po_1p41 l=3.36
XCOMPARATOR_N_OUT register_cf_node_642c575fea9eb7d4 COMPARATOR__PRE register_cf_node_642c575fea9eb7d4_source VGND sky130_fd_pr__nfet_01v8 w=4 l=0.15 nf=1 m=1
Vregister_cf_642c575fea9eb7d4 CMP register_cf_node_642c575fea9eb7d4 0
Vregister_cf_642c575fea9eb7d4_source VGND register_cf_node_642c575fea9eb7d4_source 0
XCOMPARATOR_PREAMP_N_INN register_cf_node_9d1744eca2d64648 VCM register_cf_node_9d1744eca2d64648_source VGND sky130_fd_pr__nfet_01v8 w=10 l=1 nf=1 m=1
Vregister_cf_9d1744eca2d64648 COMPARATOR__PREAMP__MIR register_cf_node_9d1744eca2d64648 0
Vregister_cf_9d1744eca2d64648_source COMPARATOR__PREAMP__TAIL register_cf_node_9d1744eca2d64648_source 0
XCOMPARATOR_PREAMP_N_INP register_cf_node_e3102478511b8837 OUT register_cf_node_e3102478511b8837_source VGND sky130_fd_pr__nfet_01v8 w=10 l=1 nf=1 m=1
Vregister_cf_e3102478511b8837 COMPARATOR__PRE register_cf_node_e3102478511b8837 0
Vregister_cf_e3102478511b8837_source COMPARATOR__PREAMP__TAIL register_cf_node_e3102478511b8837_source 0
XCOMPARATOR_PREAMP_N_TAIL register_cf_node_18f5662f0d50ee36 BIAS register_cf_node_18f5662f0d50ee36_source VGND sky130_fd_pr__nfet_01v8 w=2 l=1 nf=1 m=1
Vregister_cf_18f5662f0d50ee36 COMPARATOR__PREAMP__TAIL register_cf_node_18f5662f0d50ee36 0
Vregister_cf_18f5662f0d50ee36_source VGND register_cf_node_18f5662f0d50ee36_source 0
XCOMPARATOR_PREAMP_P_DIODE register_cf_node_334141ce685e7c2f COMPARATOR__PREAMP__MIR register_cf_node_334141ce685e7c2f_source VPWR sky130_fd_pr__pfet_01v8_hvt w=20 l=1 nf=1 m=1
Vregister_cf_334141ce685e7c2f COMPARATOR__PREAMP__MIR register_cf_node_334141ce685e7c2f 0
Vregister_cf_334141ce685e7c2f_source VPWR register_cf_node_334141ce685e7c2f_source 0
XCOMPARATOR_PREAMP_P_MIRROR register_cf_node_c53c0b2565f53ef4 COMPARATOR__PREAMP__MIR register_cf_node_c53c0b2565f53ef4_source VPWR sky130_fd_pr__pfet_01v8_hvt w=20 l=1 nf=1 m=1
Vregister_cf_c53c0b2565f53ef4 COMPARATOR__PRE register_cf_node_c53c0b2565f53ef4 0
Vregister_cf_c53c0b2565f53ef4_source VPWR register_cf_node_c53c0b2565f53ef4_source 0
XCOMPARATOR_P_OUT register_cf_node_98a25b8d46859b10 COMPARATOR__PRE register_cf_node_98a25b8d46859b10_source VPWR sky130_fd_pr__pfet_01v8_hvt w=8 l=0.15 nf=1 m=1
Vregister_cf_98a25b8d46859b10 CMP register_cf_node_98a25b8d46859b10 0
Vregister_cf_98a25b8d46859b10_source VPWR register_cf_node_98a25b8d46859b10_source 0
XFILTER_BUFFER0_C_MILLER_P0 FILTER__BUFFER0__PRE FILTER__BUFFER0__COMP sky130_fd_pr__cap_mim_m3_1 w=28.68 l=28.68
XFILTER_BUFFER0_C_MILLER_P1 FILTER__BUFFER0__PRE FILTER__BUFFER0__COMP sky130_fd_pr__cap_mim_m3_1 w=28.68 l=28.68
XFILTER_BUFFER0_C_MILLER_P2 FILTER__BUFFER0__PRE FILTER__BUFFER0__COMP sky130_fd_pr__cap_mim_m3_1 w=28.68 l=28.68
XFILTER_BUFFER0_FIRST_N_INN register_cf_node_122b65ceebd5a700 FILTER__MID register_cf_node_122b65ceebd5a700_source VGND sky130_fd_pr__nfet_01v8 w=10 l=1 nf=1 m=1
Vregister_cf_122b65ceebd5a700 FILTER__BUFFER0__FIRST__MIR register_cf_node_122b65ceebd5a700 0
Vregister_cf_122b65ceebd5a700_source FILTER__BUFFER0__FIRST__TAIL register_cf_node_122b65ceebd5a700_source 0
XFILTER_BUFFER0_FIRST_N_INP register_cf_node_75331bd619524b5d FILTER__FILTER0 register_cf_node_75331bd619524b5d_source VGND sky130_fd_pr__nfet_01v8 w=10 l=1 nf=1 m=1
Vregister_cf_75331bd619524b5d FILTER__BUFFER0__PRE register_cf_node_75331bd619524b5d 0
Vregister_cf_75331bd619524b5d_source FILTER__BUFFER0__FIRST__TAIL register_cf_node_75331bd619524b5d_source 0
XFILTER_BUFFER0_FIRST_N_TAIL register_cf_node_0e13bf8b496f9c68 BIAS register_cf_node_0e13bf8b496f9c68_source VGND sky130_fd_pr__nfet_01v8 w=2 l=1 nf=1 m=1
Vregister_cf_0e13bf8b496f9c68 FILTER__BUFFER0__FIRST__TAIL register_cf_node_0e13bf8b496f9c68 0
Vregister_cf_0e13bf8b496f9c68_source VGND register_cf_node_0e13bf8b496f9c68_source 0
XFILTER_BUFFER0_FIRST_P_DIODE register_cf_node_26348b89100366b7 FILTER__BUFFER0__FIRST__MIR register_cf_node_26348b89100366b7_source VPWR sky130_fd_pr__pfet_01v8_hvt w=20 l=1 nf=1 m=1
Vregister_cf_26348b89100366b7 FILTER__BUFFER0__FIRST__MIR register_cf_node_26348b89100366b7 0
Vregister_cf_26348b89100366b7_source VPWR register_cf_node_26348b89100366b7_source 0
XFILTER_BUFFER0_FIRST_P_MIRROR register_cf_node_fd6e518dd7979607 FILTER__BUFFER0__FIRST__MIR register_cf_node_fd6e518dd7979607_source VPWR sky130_fd_pr__pfet_01v8_hvt w=20 l=1 nf=1 m=1
Vregister_cf_fd6e518dd7979607 FILTER__BUFFER0__PRE register_cf_node_fd6e518dd7979607 0
Vregister_cf_fd6e518dd7979607_source VPWR register_cf_node_fd6e518dd7979607_source 0
XFILTER_BUFFER0_N_SECOND register_cf_node_7c0362d20f1bb9aa BIAS register_cf_node_7c0362d20f1bb9aa_source VGND sky130_fd_pr__nfet_01v8 w=2 l=1 nf=1 m=1
Vregister_cf_7c0362d20f1bb9aa FILTER__MID register_cf_node_7c0362d20f1bb9aa 0
Vregister_cf_7c0362d20f1bb9aa_source VGND register_cf_node_7c0362d20f1bb9aa_source 0
XFILTER_BUFFER0_P_SECOND register_cf_node_541e2876687f09d3 FILTER__BUFFER0__PRE register_cf_node_541e2876687f09d3_source VPWR sky130_fd_pr__pfet_01v8_hvt w=40 l=1 nf=1 m=1
Vregister_cf_541e2876687f09d3 FILTER__MID register_cf_node_541e2876687f09d3 0
Vregister_cf_541e2876687f09d3_source VPWR register_cf_node_541e2876687f09d3_source 0
XFILTER_BUFFER0_R_ZERO_P0 FILTER__BUFFER0__COMP FILTER__MID VGND sky130_fd_pr__res_xhigh_po_1p41 l=3.36
XFILTER_BUFFER1_C_MILLER_P0 FILTER__BUFFER1__PRE FILTER__BUFFER1__COMP sky130_fd_pr__cap_mim_m3_1 w=28.68 l=28.68
XFILTER_BUFFER1_C_MILLER_P1 FILTER__BUFFER1__PRE FILTER__BUFFER1__COMP sky130_fd_pr__cap_mim_m3_1 w=28.68 l=28.68
XFILTER_BUFFER1_C_MILLER_P2 FILTER__BUFFER1__PRE FILTER__BUFFER1__COMP sky130_fd_pr__cap_mim_m3_1 w=28.68 l=28.68
XFILTER_BUFFER1_FIRST_N_INN register_cf_node_f6af4d29a72b73e7 OUT register_cf_node_f6af4d29a72b73e7_source VGND sky130_fd_pr__nfet_01v8 w=10 l=1 nf=1 m=1
Vregister_cf_f6af4d29a72b73e7 FILTER__BUFFER1__FIRST__MIR register_cf_node_f6af4d29a72b73e7 0
Vregister_cf_f6af4d29a72b73e7_source FILTER__BUFFER1__FIRST__TAIL register_cf_node_f6af4d29a72b73e7_source 0
XFILTER_BUFFER1_FIRST_N_INP register_cf_node_e16973bbe0bb1549 FILTER__FILTER1 register_cf_node_e16973bbe0bb1549_source VGND sky130_fd_pr__nfet_01v8 w=10 l=1 nf=1 m=1
Vregister_cf_e16973bbe0bb1549 FILTER__BUFFER1__PRE register_cf_node_e16973bbe0bb1549 0
Vregister_cf_e16973bbe0bb1549_source FILTER__BUFFER1__FIRST__TAIL register_cf_node_e16973bbe0bb1549_source 0
XFILTER_BUFFER1_FIRST_N_TAIL register_cf_node_cb520d6f20b8f9af BIAS register_cf_node_cb520d6f20b8f9af_source VGND sky130_fd_pr__nfet_01v8 w=2 l=1 nf=1 m=1
Vregister_cf_cb520d6f20b8f9af FILTER__BUFFER1__FIRST__TAIL register_cf_node_cb520d6f20b8f9af 0
Vregister_cf_cb520d6f20b8f9af_source VGND register_cf_node_cb520d6f20b8f9af_source 0
XFILTER_BUFFER1_FIRST_P_DIODE register_cf_node_0a9ac7a772237125 FILTER__BUFFER1__FIRST__MIR register_cf_node_0a9ac7a772237125_source VPWR sky130_fd_pr__pfet_01v8_hvt w=20 l=1 nf=1 m=1
Vregister_cf_0a9ac7a772237125 FILTER__BUFFER1__FIRST__MIR register_cf_node_0a9ac7a772237125 0
Vregister_cf_0a9ac7a772237125_source VPWR register_cf_node_0a9ac7a772237125_source 0
XFILTER_BUFFER1_FIRST_P_MIRROR register_cf_node_582c5051c2480a75 FILTER__BUFFER1__FIRST__MIR register_cf_node_582c5051c2480a75_source VPWR sky130_fd_pr__pfet_01v8_hvt w=20 l=1 nf=1 m=1
Vregister_cf_582c5051c2480a75 FILTER__BUFFER1__PRE register_cf_node_582c5051c2480a75 0
Vregister_cf_582c5051c2480a75_source VPWR register_cf_node_582c5051c2480a75_source 0
XFILTER_BUFFER1_N_SECOND register_cf_node_016483cc89710033 BIAS register_cf_node_016483cc89710033_source VGND sky130_fd_pr__nfet_01v8 w=2 l=1 nf=1 m=1
Vregister_cf_016483cc89710033 OUT register_cf_node_016483cc89710033 0
Vregister_cf_016483cc89710033_source VGND register_cf_node_016483cc89710033_source 0
XFILTER_BUFFER1_P_SECOND register_cf_node_29a31ddf48631d60 FILTER__BUFFER1__PRE register_cf_node_29a31ddf48631d60_source VPWR sky130_fd_pr__pfet_01v8_hvt w=40 l=1 nf=1 m=1
Vregister_cf_29a31ddf48631d60 OUT register_cf_node_29a31ddf48631d60 0
Vregister_cf_29a31ddf48631d60_source VPWR register_cf_node_29a31ddf48631d60_source 0
XFILTER_BUFFER1_R_ZERO_P0 FILTER__BUFFER1__COMP OUT VGND sky130_fd_pr__res_xhigh_po_1p41 l=3.36
XFILTER_C_POLE0_P0 FILTER__FILTER0 VGND sky130_fd_pr__cap_mim_m3_1 w=28.68 l=28.68
XFILTER_C_POLE0_P1 FILTER__FILTER0 VGND sky130_fd_pr__cap_mim_m3_1 w=28.68 l=28.68
XFILTER_C_POLE0_P10 FILTER__FILTER0 VGND sky130_fd_pr__cap_mim_m3_1 w=28.68 l=28.68
XFILTER_C_POLE0_P11 FILTER__FILTER0 VGND sky130_fd_pr__cap_mim_m3_1 w=28.68 l=28.68
XFILTER_C_POLE0_P2 FILTER__FILTER0 VGND sky130_fd_pr__cap_mim_m3_1 w=28.68 l=28.68
XFILTER_C_POLE0_P3 FILTER__FILTER0 VGND sky130_fd_pr__cap_mim_m3_1 w=28.68 l=28.68
XFILTER_C_POLE0_P4 FILTER__FILTER0 VGND sky130_fd_pr__cap_mim_m3_1 w=28.68 l=28.68
XFILTER_C_POLE0_P5 FILTER__FILTER0 VGND sky130_fd_pr__cap_mim_m3_1 w=28.68 l=28.68
XFILTER_C_POLE0_P6 FILTER__FILTER0 VGND sky130_fd_pr__cap_mim_m3_1 w=28.68 l=28.68
XFILTER_C_POLE0_P7 FILTER__FILTER0 VGND sky130_fd_pr__cap_mim_m3_1 w=28.68 l=28.68
XFILTER_C_POLE0_P8 FILTER__FILTER0 VGND sky130_fd_pr__cap_mim_m3_1 w=28.68 l=28.68
XFILTER_C_POLE0_P9 FILTER__FILTER0 VGND sky130_fd_pr__cap_mim_m3_1 w=28.68 l=28.68
XFILTER_C_POLE1_P0 FILTER__FILTER1 VGND sky130_fd_pr__cap_mim_m3_1 w=28.68 l=28.68
XFILTER_C_POLE1_P1 FILTER__FILTER1 VGND sky130_fd_pr__cap_mim_m3_1 w=28.68 l=28.68
XFILTER_C_POLE1_P10 FILTER__FILTER1 VGND sky130_fd_pr__cap_mim_m3_1 w=28.68 l=28.68
XFILTER_C_POLE1_P11 FILTER__FILTER1 VGND sky130_fd_pr__cap_mim_m3_1 w=28.68 l=28.68
XFILTER_C_POLE1_P2 FILTER__FILTER1 VGND sky130_fd_pr__cap_mim_m3_1 w=28.68 l=28.68
XFILTER_C_POLE1_P3 FILTER__FILTER1 VGND sky130_fd_pr__cap_mim_m3_1 w=28.68 l=28.68
XFILTER_C_POLE1_P4 FILTER__FILTER1 VGND sky130_fd_pr__cap_mim_m3_1 w=28.68 l=28.68
XFILTER_C_POLE1_P5 FILTER__FILTER1 VGND sky130_fd_pr__cap_mim_m3_1 w=28.68 l=28.68
XFILTER_C_POLE1_P6 FILTER__FILTER1 VGND sky130_fd_pr__cap_mim_m3_1 w=28.68 l=28.68
XFILTER_C_POLE1_P7 FILTER__FILTER1 VGND sky130_fd_pr__cap_mim_m3_1 w=28.68 l=28.68
XFILTER_C_POLE1_P8 FILTER__FILTER1 VGND sky130_fd_pr__cap_mim_m3_1 w=28.68 l=28.68
XFILTER_C_POLE1_P9 FILTER__FILTER1 VGND sky130_fd_pr__cap_mim_m3_1 w=28.68 l=28.68
XFILTER_R_POLE0_P0 AMPLIFIED FILTER__FILTER0 VGND sky130_fd_pr__res_xhigh_po_1p41 l=28.035
XFILTER_R_POLE1_P0 FILTER__MID FILTER__FILTER1 VGND sky130_fd_pr__res_xhigh_po_1p41 l=28.035
XPGA_AMP_C_MILLER_P0 PGA__AMP__PRE PGA__AMP__COMP sky130_fd_pr__cap_mim_m3_1 w=28.68 l=28.68
XPGA_AMP_C_MILLER_P1 PGA__AMP__PRE PGA__AMP__COMP sky130_fd_pr__cap_mim_m3_1 w=28.68 l=28.68
XPGA_AMP_C_MILLER_P2 PGA__AMP__PRE PGA__AMP__COMP sky130_fd_pr__cap_mim_m3_1 w=28.68 l=28.68
XPGA_AMP_FIRST_N_INN register_cf_node_e02b1bb0e5ccf232 PGA__FB register_cf_node_e02b1bb0e5ccf232_source VGND sky130_fd_pr__nfet_01v8 w=10 l=1 nf=1 m=1
Vregister_cf_e02b1bb0e5ccf232 PGA__AMP__FIRST__MIR register_cf_node_e02b1bb0e5ccf232 0
Vregister_cf_e02b1bb0e5ccf232_source PGA__AMP__FIRST__TAIL register_cf_node_e02b1bb0e5ccf232_source 0
XPGA_AMP_FIRST_N_INP register_cf_node_72de1048f8cca4e7 VIN register_cf_node_72de1048f8cca4e7_source VGND sky130_fd_pr__nfet_01v8 w=10 l=1 nf=1 m=1
Vregister_cf_72de1048f8cca4e7 PGA__AMP__PRE register_cf_node_72de1048f8cca4e7 0
Vregister_cf_72de1048f8cca4e7_source PGA__AMP__FIRST__TAIL register_cf_node_72de1048f8cca4e7_source 0
XPGA_AMP_FIRST_N_TAIL register_cf_node_2aed44c57a1c870d BIAS register_cf_node_2aed44c57a1c870d_source VGND sky130_fd_pr__nfet_01v8 w=2 l=1 nf=1 m=1
Vregister_cf_2aed44c57a1c870d PGA__AMP__FIRST__TAIL register_cf_node_2aed44c57a1c870d 0
Vregister_cf_2aed44c57a1c870d_source VGND register_cf_node_2aed44c57a1c870d_source 0
XPGA_AMP_FIRST_P_DIODE register_cf_node_ec0811d5885acc03 PGA__AMP__FIRST__MIR register_cf_node_ec0811d5885acc03_source VPWR sky130_fd_pr__pfet_01v8_hvt w=20 l=1 nf=1 m=1
Vregister_cf_ec0811d5885acc03 PGA__AMP__FIRST__MIR register_cf_node_ec0811d5885acc03 0
Vregister_cf_ec0811d5885acc03_source VPWR register_cf_node_ec0811d5885acc03_source 0
XPGA_AMP_FIRST_P_MIRROR register_cf_node_57b2e49526ac4c17 PGA__AMP__FIRST__MIR register_cf_node_57b2e49526ac4c17_source VPWR sky130_fd_pr__pfet_01v8_hvt w=20 l=1 nf=1 m=1
Vregister_cf_57b2e49526ac4c17 PGA__AMP__PRE register_cf_node_57b2e49526ac4c17 0
Vregister_cf_57b2e49526ac4c17_source VPWR register_cf_node_57b2e49526ac4c17_source 0
XPGA_AMP_N_SECOND register_cf_node_36b02b07e7203239 BIAS register_cf_node_36b02b07e7203239_source VGND sky130_fd_pr__nfet_01v8 w=2 l=1 nf=1 m=1
Vregister_cf_36b02b07e7203239 AMPLIFIED register_cf_node_36b02b07e7203239 0
Vregister_cf_36b02b07e7203239_source VGND register_cf_node_36b02b07e7203239_source 0
XPGA_AMP_P_SECOND register_cf_node_e0a711719bf5c4c4 PGA__AMP__PRE register_cf_node_e0a711719bf5c4c4_source VPWR sky130_fd_pr__pfet_01v8_hvt w=40 l=1 nf=1 m=1
Vregister_cf_e0a711719bf5c4c4 AMPLIFIED register_cf_node_e0a711719bf5c4c4 0
Vregister_cf_e0a711719bf5c4c4_source VPWR register_cf_node_e0a711719bf5c4c4_source 0
XPGA_AMP_R_ZERO_P0 PGA__AMP__COMP AMPLIFIED VGND sky130_fd_pr__res_xhigh_po_1p41 l=3.36
XPGA_GAIN_INVERTER_MN register_cf_node_33dcc485d4a44380 GAIN register_cf_node_33dcc485d4a44380_source VGND sky130_fd_pr__nfet_01v8 w=0.65 l=0.15 nf=1 m=1
Vregister_cf_33dcc485d4a44380 PGA__GAINB register_cf_node_33dcc485d4a44380 0
Vregister_cf_33dcc485d4a44380_source VGND register_cf_node_33dcc485d4a44380_source 0
XPGA_GAIN_INVERTER_MP register_cf_node_47c0aa59d6a62f8c GAIN register_cf_node_47c0aa59d6a62f8c_source VPWR sky130_fd_pr__pfet_01v8_hvt w=0.65 l=0.15 nf=1 m=1
Vregister_cf_47c0aa59d6a62f8c PGA__GAINB register_cf_node_47c0aa59d6a62f8c 0
Vregister_cf_47c0aa59d6a62f8c_source VPWR register_cf_node_47c0aa59d6a62f8c_source 0
XPGA_N_GAIN register_cf_node_efb34d6896c2a823 PGA__GAINB register_cf_node_efb34d6896c2a823_source VGND sky130_fd_pr__nfet_01v8 w=20 l=0.15 nf=1 m=1
Vregister_cf_efb34d6896c2a823 AMPLIFIED register_cf_node_efb34d6896c2a823 0
Vregister_cf_efb34d6896c2a823_source PGA__LOW register_cf_node_efb34d6896c2a823_source 0
XPGA_P_GAIN register_cf_node_2e4d8194109e133b GAIN register_cf_node_2e4d8194109e133b_source VPWR sky130_fd_pr__pfet_01v8_hvt w=20 l=0.15 nf=1 m=1
Vregister_cf_2e4d8194109e133b AMPLIFIED register_cf_node_2e4d8194109e133b 0
Vregister_cf_2e4d8194109e133b_source PGA__LOW register_cf_node_2e4d8194109e133b_source 0
XPGA_R_GROUND_P0 PGA__FB VCM VGND sky130_fd_pr__res_xhigh_po_1p41 l=6.885
XPGA_R_HIGH_P0 AMPLIFIED PGA_R_HIGH_R0_N0 VGND sky130_fd_pr__res_xhigh_po_1p41 l=24.51
XPGA_R_HIGH_P1 PGA_R_HIGH_R0_N0 PGA__FB VGND sky130_fd_pr__res_xhigh_po_1p41 l=24.51
XPGA_R_LOW_P0 PGA__LOW PGA__FB VGND sky130_fd_pr__res_xhigh_po_1p41 l=8.06
XRESET_MUX_IS_MN register_cf_node_96b9de5fb593ba10 RESET register_cf_node_96b9de5fb593ba10_source VGND sky130_fd_pr__nfet_01v8 w=0.65 l=0.15 nf=1 m=1
Vregister_cf_96b9de5fb593ba10 RESET_MUX__SB register_cf_node_96b9de5fb593ba10 0
Vregister_cf_96b9de5fb593ba10_source VGND register_cf_node_96b9de5fb593ba10_source 0
XRESET_MUX_IS_MP register_cf_node_2c918fd9ce7bd97b RESET register_cf_node_2c918fd9ce7bd97b_source VPWR sky130_fd_pr__pfet_01v8_hvt w=0.65 l=0.15 nf=1 m=1
Vregister_cf_2c918fd9ce7bd97b RESET_MUX__SB register_cf_node_2c918fd9ce7bd97b 0
Vregister_cf_2c918fd9ce7bd97b_source VPWR register_cf_node_2c918fd9ce7bd97b_source 0
XRESET_MUX_MNA register_cf_node_d88b25d6a451af9e RESET_MUX__SB register_cf_node_d88b25d6a451af9e_source VGND sky130_fd_pr__nfet_01v8 w=0.65 l=0.15 nf=1 m=1
Vregister_cf_d88b25d6a451af9e D register_cf_node_d88b25d6a451af9e 0
Vregister_cf_d88b25d6a451af9e_source CMP register_cf_node_d88b25d6a451af9e_source 0
XRESET_MUX_MNB register_cf_node_e7004b47c293340b RESET register_cf_node_e7004b47c293340b_source VGND sky130_fd_pr__nfet_01v8 w=0.65 l=0.15 nf=1 m=1
Vregister_cf_e7004b47c293340b D register_cf_node_e7004b47c293340b 0
Vregister_cf_e7004b47c293340b_source VGND register_cf_node_e7004b47c293340b_source 0
XRESET_MUX_MPA register_cf_node_a9869b7c758976d0 RESET register_cf_node_a9869b7c758976d0_source VPWR sky130_fd_pr__pfet_01v8_hvt w=0.65 l=0.15 nf=1 m=1
Vregister_cf_a9869b7c758976d0 D register_cf_node_a9869b7c758976d0 0
Vregister_cf_a9869b7c758976d0_source CMP register_cf_node_a9869b7c758976d0_source 0
XRESET_MUX_MPB register_cf_node_9e2af3326c6b102b RESET_MUX__SB register_cf_node_9e2af3326c6b102b_source VPWR sky130_fd_pr__pfet_01v8_hvt w=0.65 l=0.15 nf=1 m=1
Vregister_cf_9e2af3326c6b102b D register_cf_node_9e2af3326c6b102b 0
Vregister_cf_9e2af3326c6b102b_source VGND register_cf_node_9e2af3326c6b102b_source 0
XSAMPLE_ICLK_MN register_cf_node_fa2ceea394339725 CLK register_cf_node_fa2ceea394339725_source VGND sky130_fd_pr__nfet_01v8 w=0.65 l=0.15 nf=1 m=1
Vregister_cf_fa2ceea394339725 SAMPLE__CLKB register_cf_node_fa2ceea394339725 0
Vregister_cf_fa2ceea394339725_source VGND register_cf_node_fa2ceea394339725_source 0
XSAMPLE_ICLK_MP register_cf_node_082488ca12a10e39 CLK register_cf_node_082488ca12a10e39_source VPWR sky130_fd_pr__pfet_01v8_hvt w=0.65 l=0.15 nf=1 m=1
Vregister_cf_082488ca12a10e39 SAMPLE__CLKB register_cf_node_082488ca12a10e39 0
Vregister_cf_082488ca12a10e39_source VPWR register_cf_node_082488ca12a10e39_source 0
XSAMPLE_M1_MN register_cf_node_543810d82ff6267f SAMPLE__M register_cf_node_543810d82ff6267f_source VGND sky130_fd_pr__nfet_01v8 w=0.65 l=0.15 nf=1 m=1
Vregister_cf_543810d82ff6267f SAMPLE__MB register_cf_node_543810d82ff6267f 0
Vregister_cf_543810d82ff6267f_source VGND register_cf_node_543810d82ff6267f_source 0
XSAMPLE_M1_MP register_cf_node_6e34886cd940133c SAMPLE__M register_cf_node_6e34886cd940133c_source VPWR sky130_fd_pr__pfet_01v8_hvt w=0.65 l=0.15 nf=1 m=1
Vregister_cf_6e34886cd940133c SAMPLE__MB register_cf_node_6e34886cd940133c 0
Vregister_cf_6e34886cd940133c_source VPWR register_cf_node_6e34886cd940133c_source 0
XSAMPLE_M2_MN register_cf_node_9316b654254c7e80 SAMPLE__MB register_cf_node_9316b654254c7e80_source VGND sky130_fd_pr__nfet_01v8 w=0.65 l=0.15 nf=1 m=1
Vregister_cf_9316b654254c7e80 SAMPLE__MF register_cf_node_9316b654254c7e80 0
Vregister_cf_9316b654254c7e80_source VGND register_cf_node_9316b654254c7e80_source 0
XSAMPLE_M2_MP register_cf_node_8e4fe5689fedce67 SAMPLE__MB register_cf_node_8e4fe5689fedce67_source VPWR sky130_fd_pr__pfet_01v8_hvt w=0.65 l=0.15 nf=1 m=1
Vregister_cf_8e4fe5689fedce67 SAMPLE__MF register_cf_node_8e4fe5689fedce67 0
Vregister_cf_8e4fe5689fedce67_source VPWR register_cf_node_8e4fe5689fedce67_source 0
XSAMPLE_MNIN register_cf_node_4e0e120bb22caed8 SAMPLE__CLKB register_cf_node_4e0e120bb22caed8_source VGND sky130_fd_pr__nfet_01v8 w=0.65 l=0.15 nf=1 m=1
Vregister_cf_4e0e120bb22caed8 SAMPLE__M register_cf_node_4e0e120bb22caed8 0
Vregister_cf_4e0e120bb22caed8_source D register_cf_node_4e0e120bb22caed8_source 0
XSAMPLE_MNMF register_cf_node_e35a359c098fe927 CLK register_cf_node_e35a359c098fe927_source VGND sky130_fd_pr__nfet_01v8 w=0.65 l=0.15 nf=1 m=1
Vregister_cf_e35a359c098fe927 SAMPLE__M register_cf_node_e35a359c098fe927 0
Vregister_cf_e35a359c098fe927_source SAMPLE__MF register_cf_node_e35a359c098fe927_source 0
XSAMPLE_MNOUT register_cf_node_b54f511a9817a5c8 CLK register_cf_node_b54f511a9817a5c8_source VGND sky130_fd_pr__nfet_01v8 w=0.65 l=0.15 nf=1 m=1
Vregister_cf_b54f511a9817a5c8 SAMPLE__T register_cf_node_b54f511a9817a5c8 0
Vregister_cf_b54f511a9817a5c8_source SAMPLE__MF register_cf_node_b54f511a9817a5c8_source 0
XSAMPLE_MNSF register_cf_node_567b29a774bcb0f8 SAMPLE__CLKB register_cf_node_567b29a774bcb0f8_source VGND sky130_fd_pr__nfet_01v8 w=0.65 l=0.15 nf=1 m=1
Vregister_cf_567b29a774bcb0f8 SAMPLE__T register_cf_node_567b29a774bcb0f8 0
Vregister_cf_567b29a774bcb0f8_source DATA register_cf_node_567b29a774bcb0f8_source 0
XSAMPLE_MPIN register_cf_node_e65f515ee298f487 CLK register_cf_node_e65f515ee298f487_source VPWR sky130_fd_pr__pfet_01v8_hvt w=0.65 l=0.15 nf=1 m=1
Vregister_cf_e65f515ee298f487 SAMPLE__M register_cf_node_e65f515ee298f487 0
Vregister_cf_e65f515ee298f487_source D register_cf_node_e65f515ee298f487_source 0
XSAMPLE_MPMF register_cf_node_1c8179964864318b SAMPLE__CLKB register_cf_node_1c8179964864318b_source VPWR sky130_fd_pr__pfet_01v8_hvt w=0.65 l=0.15 nf=1 m=1
Vregister_cf_1c8179964864318b SAMPLE__M register_cf_node_1c8179964864318b 0
Vregister_cf_1c8179964864318b_source SAMPLE__MF register_cf_node_1c8179964864318b_source 0
XSAMPLE_MPOUT register_cf_node_679300906744f344 SAMPLE__CLKB register_cf_node_679300906744f344_source VPWR sky130_fd_pr__pfet_01v8_hvt w=0.65 l=0.15 nf=1 m=1
Vregister_cf_679300906744f344 SAMPLE__T register_cf_node_679300906744f344 0
Vregister_cf_679300906744f344_source SAMPLE__MF register_cf_node_679300906744f344_source 0
XSAMPLE_MPSF register_cf_node_05ca899006b0fa84 CLK register_cf_node_05ca899006b0fa84_source VPWR sky130_fd_pr__pfet_01v8_hvt w=0.65 l=0.15 nf=1 m=1
Vregister_cf_05ca899006b0fa84 SAMPLE__T register_cf_node_05ca899006b0fa84 0
Vregister_cf_05ca899006b0fa84_source DATA register_cf_node_05ca899006b0fa84_source 0
XSAMPLE_S1_MN register_cf_node_0d1e2bfdb16cc9ba SAMPLE__T register_cf_node_0d1e2bfdb16cc9ba_source VGND sky130_fd_pr__nfet_01v8 w=0.65 l=0.15 nf=1 m=1
Vregister_cf_0d1e2bfdb16cc9ba SAMPLE__TB register_cf_node_0d1e2bfdb16cc9ba 0
Vregister_cf_0d1e2bfdb16cc9ba_source VGND register_cf_node_0d1e2bfdb16cc9ba_source 0
XSAMPLE_S1_MP register_cf_node_d144fa46c3c84e01 SAMPLE__T register_cf_node_d144fa46c3c84e01_source VPWR sky130_fd_pr__pfet_01v8_hvt w=0.65 l=0.15 nf=1 m=1
Vregister_cf_d144fa46c3c84e01 SAMPLE__TB register_cf_node_d144fa46c3c84e01 0
Vregister_cf_d144fa46c3c84e01_source VPWR register_cf_node_d144fa46c3c84e01_source 0
XSAMPLE_S2_MN register_cf_node_20250172a9d59a27 SAMPLE__TB register_cf_node_20250172a9d59a27_source VGND sky130_fd_pr__nfet_01v8 w=0.65 l=0.15 nf=1 m=1
Vregister_cf_20250172a9d59a27 DATA register_cf_node_20250172a9d59a27 0
Vregister_cf_20250172a9d59a27_source VGND register_cf_node_20250172a9d59a27_source 0
XSAMPLE_S2_MP register_cf_node_93c46687deaacb17 SAMPLE__TB register_cf_node_93c46687deaacb17_source VPWR sky130_fd_pr__pfet_01v8_hvt w=0.65 l=0.15 nf=1 m=1
Vregister_cf_93c46687deaacb17 DATA register_cf_node_93c46687deaacb17 0
Vregister_cf_93c46687deaacb17_source VPWR register_cf_node_93c46687deaacb17_source 0
.ends soc_sensor_afe

* NGSPICE file created from soc_sensor_afe.ext - technology: sky130A

.subckt soc_sensor_afe VPWR DATA CLK BIAS RESET VCM VGND GAIN OUT VIN
X0 AMPLIFIED FILTER__FILTER0 VGND sky130_fd_pr__res_xhigh_po_1p41 l=28.04
X1 VPWR FILTER__BUFFER0__FIRST__MIR FILTER__BUFFER0__FIRST__MIR VPWR sky130_fd_pr__pfet_01v8_hvt ad=5.8 pd=40.58 as=5.8 ps=40.58 w=20 l=1
X2 PGA__OUTPUT_BUFFER__COMP AMPLIFIED VGND sky130_fd_pr__res_xhigh_po_1p41 l=3.36
X3 FILTER__FILTER1 VGND sky130_fd_pr__cap_mim_m3_1 l=28.68 w=28.68
X4 VGND COMPARATOR__PRE CMP VGND sky130_fd_pr__nfet_01v8 ad=1.16 pd=8.58 as=1.16 ps=8.58 w=4 l=0.15
X5 FILTER__BUFFER1__FIRST__TAIL FILTER__FILTER1 FILTER__BUFFER1__PRE VGND sky130_fd_pr__nfet_01v8 ad=1.45 pd=10.58 as=1.45 ps=10.58 w=5 l=1
X6 FILTER__FILTER1 VGND sky130_fd_pr__cap_mim_m3_1 l=28.68 w=28.68
X7 FILTER__BUFFER1__COMP OUT VGND sky130_fd_pr__res_xhigh_po_1p41 l=3.36
X8 PGA__OUTPUT_BUFFER__PRE PGA__OUTPUT_BUFFER__COMP sky130_fd_pr__cap_mim_m3_1 l=28.68 w=28.68
X9 VPWR SAMPLE__MB SAMPLE__MF VPWR sky130_fd_pr__pfet_01v8_hvt ad=0.1885 pd=1.88 as=0.1885 ps=1.88 w=0.65 l=0.15
X10 VPWR COMPARATOR__PRE CMP VPWR sky130_fd_pr__pfet_01v8_hvt ad=2.32 pd=16.58 as=2.32 ps=16.58 w=8 l=0.15
X11 VGND BIAS PGA__GAIN8__AMP__FIRST__TAIL VGND sky130_fd_pr__nfet_01v8 ad=0.58 pd=4.58 as=0.58 ps=4.58 w=2 l=1
X12 FILTER__BUFFER0__PRE FILTER__BUFFER0__COMP sky130_fd_pr__cap_mim_m3_1 l=28.68 w=28.68
X13 FILTER__BUFFER1__FIRST__TAIL FILTER__FILTER1 FILTER__BUFFER1__PRE VGND sky130_fd_pr__nfet_01v8 ad=1.45 pd=10.58 as=1.45 ps=10.58 w=5 l=1
X14 VPWR PGA__OUTPUT_BUFFER__FIRST__MIR PGA__OUTPUT_BUFFER__FIRST__MIR VPWR sky130_fd_pr__pfet_01v8_hvt ad=5.8 pd=40.58 as=5.8 ps=40.58 w=20 l=1
X15 BIAS_SOURCE__VCM_RAW VGND sky130_fd_pr__cap_mim_m3_1 l=28.68 w=28.68
X16 PGA__GAIN8__AMP__PRE PGA__GAIN8__AMP__COMP sky130_fd_pr__cap_mim_m3_1 l=28.68 w=28.68
X17 FILTER__FILTER1 VGND sky130_fd_pr__cap_mim_m3_1 l=28.68 w=28.68
X18 PGA__GAIN2__FB VCM VGND sky130_fd_pr__res_xhigh_po_1p41 l=6.89
X19 FILTER__FILTER1 VGND sky130_fd_pr__cap_mim_m3_1 l=28.68 w=28.68
X20 FILTER__FILTER0 VGND sky130_fd_pr__cap_mim_m3_1 l=28.68 w=28.68
X21 BIAS_SOURCE__VCM_RAW BIAS_SOURCE_R_VCM_BOTTOM_R0_N0 VGND sky130_fd_pr__res_xhigh_po_1p41 l=23.34
X22 PGA__SELECTED GAIN PGA__V2 VPWR sky130_fd_pr__pfet_01v8_hvt ad=5.8 pd=40.58 as=5.8 ps=40.58 w=20 l=0.15
X23 VPWR GAIN PGA__GAINB VPWR sky130_fd_pr__pfet_01v8_hvt ad=0.1885 pd=1.88 as=0.1885 ps=1.88 w=0.65 l=0.15
X24 VGND BIAS PGA__OUTPUT_BUFFER__FIRST__TAIL VGND sky130_fd_pr__nfet_01v8 ad=0.58 pd=4.58 as=0.58 ps=4.58 w=2 l=1
X25 PGA__SELECTED PGA__GAINB PGA__V8 VPWR sky130_fd_pr__pfet_01v8_hvt ad=5.8 pd=40.58 as=5.8 ps=40.58 w=20 l=0.15
X26 FILTER__FILTER0 VGND sky130_fd_pr__cap_mim_m3_1 l=28.68 w=28.68
X27 BIAS_SOURCE__VCM_RAW VGND sky130_fd_pr__cap_mim_m3_1 l=28.68 w=28.68
X28 VGND RESET D VGND sky130_fd_pr__nfet_01v8 ad=0.1885 pd=1.88 as=0.1885 ps=1.88 w=0.65 l=0.15
X29 VPWR FILTER__BUFFER1__PRE OUT VPWR sky130_fd_pr__pfet_01v8_hvt ad=11.6 pd=80.58 as=11.6 ps=80.58 w=40 l=1
X30 PGA__GAIN2__AMP__FIRST__TAIL VIN PGA__GAIN2__AMP__PRE VGND sky130_fd_pr__nfet_01v8 ad=1.45 pd=10.58 as=1.45 ps=10.58 w=5 l=1
X31 VPWR PGA__GAIN2__AMP__FIRST__MIR PGA__GAIN2__AMP__FIRST__MIR VPWR sky130_fd_pr__pfet_01v8_hvt ad=5.8 pd=40.58 as=5.8 ps=40.58 w=20 l=1
X32 BIAS_SOURCE__VCM_RAW VGND sky130_fd_pr__cap_mim_m3_1 l=28.68 w=28.68
X33 DATA CLK SAMPLE__T VPWR sky130_fd_pr__pfet_01v8_hvt ad=0.1885 pd=1.88 as=0.1885 ps=1.88 w=0.65 l=0.15
X34 PGA__SELECTED PGA__GAINB PGA__V2 VGND sky130_fd_pr__nfet_01v8 ad=5.8 pd=40.58 as=5.8 ps=40.58 w=20 l=0.15
X35 BIAS_SOURCE_R_VCM_BOTTOM_R0_N0 BIAS_SOURCE_R_VCM_BOTTOM_R0_N1 VGND sky130_fd_pr__res_xhigh_po_1p41 l=23.34
X36 VPWR BIAS_SOURCE__VCM_BUFFER__FIRST__MIR BIAS_SOURCE__VCM_BUFFER__PRE VPWR sky130_fd_pr__pfet_01v8_hvt ad=5.8 pd=40.58 as=5.8 ps=40.58 w=20 l=1
X37 BIAS_SOURCE__VCM_RAW VGND sky130_fd_pr__cap_mim_m3_1 l=28.68 w=28.68
X38 SAMPLE__MF SAMPLE__CLKB SAMPLE__M VPWR sky130_fd_pr__pfet_01v8_hvt ad=0.1885 pd=1.88 as=0.1885 ps=1.88 w=0.65 l=0.15
X39 PGA__OUTPUT_BUFFER__FIRST__TAIL AMPLIFIED PGA__OUTPUT_BUFFER__FIRST__MIR VGND sky130_fd_pr__nfet_01v8 ad=1.45 pd=10.58 as=1.45 ps=10.58 w=5 l=1
X40 VPWR FILTER__BUFFER0__PRE FILTER__MID VPWR sky130_fd_pr__pfet_01v8_hvt ad=11.6 pd=80.58 as=11.6 ps=80.58 w=40 l=1
X41 PGA__SELECTED GAIN PGA__V8 VGND sky130_fd_pr__nfet_01v8 ad=5.8 pd=40.58 as=5.8 ps=40.58 w=20 l=0.15
X42 FILTER__FILTER0 VGND sky130_fd_pr__cap_mim_m3_1 l=28.68 w=28.68
X43 VPWR FILTER__BUFFER1__FIRST__MIR FILTER__BUFFER1__PRE VPWR sky130_fd_pr__pfet_01v8_hvt ad=5.8 pd=40.58 as=5.8 ps=40.58 w=20 l=1
X44 VPWR BIAS_SOURCE__VCM_BUFFER__FIRST__MIR BIAS_SOURCE__VCM_BUFFER__FIRST__MIR VPWR sky130_fd_pr__pfet_01v8_hvt ad=5.8 pd=40.58 as=5.8 ps=40.58 w=20 l=1
X45 PGA__GAIN2__AMP__PRE PGA__GAIN2__AMP__COMP sky130_fd_pr__cap_mim_m3_1 l=28.68 w=28.68
X46 D CLK SAMPLE__M VPWR sky130_fd_pr__pfet_01v8_hvt ad=0.1885 pd=1.88 as=0.1885 ps=1.88 w=0.65 l=0.15
X47 BIAS_SOURCE__VCM_BUFFER__FIRST__TAIL BIAS_SOURCE__VCM_RAW BIAS_SOURCE__VCM_BUFFER__PRE VGND sky130_fd_pr__nfet_01v8 ad=1.45 pd=10.58 as=1.45 ps=10.58 w=5 l=1
X48 FILTER__BUFFER0__FIRST__TAIL FILTER__FILTER0 FILTER__BUFFER0__PRE VGND sky130_fd_pr__nfet_01v8 ad=1.45 pd=10.58 as=1.45 ps=10.58 w=5 l=1
X49 FILTER__FILTER1 VGND sky130_fd_pr__cap_mim_m3_1 l=28.68 w=28.68
X50 VPWR RESET RESET_MUX__SB VPWR sky130_fd_pr__pfet_01v8_hvt ad=0.1885 pd=1.88 as=0.1885 ps=1.88 w=0.65 l=0.15
X51 VGND BIAS COMPARATOR__PREAMP__TAIL VGND sky130_fd_pr__nfet_01v8 ad=0.58 pd=4.58 as=0.58 ps=4.58 w=2 l=1
X52 PGA__GAIN8__AMP__PRE PGA__GAIN8__AMP__COMP sky130_fd_pr__cap_mim_m3_1 l=28.68 w=28.68
X53 SAMPLE__MF SAMPLE__CLKB SAMPLE__T VPWR sky130_fd_pr__pfet_01v8_hvt ad=0.1885 pd=1.88 as=0.1885 ps=1.88 w=0.65 l=0.15
X54 PGA__OUTPUT_BUFFER__FIRST__TAIL AMPLIFIED PGA__OUTPUT_BUFFER__FIRST__MIR VGND sky130_fd_pr__nfet_01v8 ad=1.45 pd=10.58 as=1.45 ps=10.58 w=5 l=1
X55 FILTER__FILTER0 VGND sky130_fd_pr__cap_mim_m3_1 l=28.68 w=28.68
X56 PGA__GAIN2__AMP__FIRST__TAIL VIN PGA__GAIN2__AMP__PRE VGND sky130_fd_pr__nfet_01v8 ad=1.45 pd=10.58 as=1.45 ps=10.58 w=5 l=1
X57 VGND BIAS AMPLIFIED VGND sky130_fd_pr__nfet_01v8 ad=0.58 pd=4.58 as=0.58 ps=4.58 w=2 l=1
X58 FILTER__FILTER1 VGND sky130_fd_pr__cap_mim_m3_1 l=28.68 w=28.68
X59 VPWR SAMPLE__TB DATA VPWR sky130_fd_pr__pfet_01v8_hvt ad=0.1885 pd=1.88 as=0.1885 ps=1.88 w=0.65 l=0.15
X60 VPWR SAMPLE__M SAMPLE__MB VPWR sky130_fd_pr__pfet_01v8_hvt ad=0.1885 pd=1.88 as=0.1885 ps=1.88 w=0.65 l=0.15
X61 BIAS_SOURCE_R_VCM_BOTTOM_R0_N1 VGND VGND sky130_fd_pr__res_xhigh_po_1p41 l=23.34
X62 FILTER__FILTER1 VGND sky130_fd_pr__cap_mim_m3_1 l=28.68 w=28.68
X63 BIAS_SOURCE__VCM_BUFFER__FIRST__TAIL VCM BIAS_SOURCE__VCM_BUFFER__FIRST__MIR VGND sky130_fd_pr__nfet_01v8 ad=1.45 pd=10.58 as=1.45 ps=10.58 w=5 l=1
X64 VPWR SAMPLE__T SAMPLE__TB VPWR sky130_fd_pr__pfet_01v8_hvt ad=0.1885 pd=1.88 as=0.1885 ps=1.88 w=0.65 l=0.15
X65 PGA__GAIN8__AMP__FIRST__TAIL VIN PGA__GAIN8__AMP__PRE VGND sky130_fd_pr__nfet_01v8 ad=1.45 pd=10.58 as=1.45 ps=10.58 w=5 l=1
X66 FILTER__BUFFER0__FIRST__TAIL FILTER__FILTER0 FILTER__BUFFER0__PRE VGND sky130_fd_pr__nfet_01v8 ad=1.45 pd=10.58 as=1.45 ps=10.58 w=5 l=1
X67 VGND BIAS BIAS_SOURCE__VCM_BUFFER__FIRST__TAIL VGND sky130_fd_pr__nfet_01v8 ad=0.58 pd=4.58 as=0.58 ps=4.58 w=2 l=1
X68 BIAS_SOURCE__VCM_RAW VGND sky130_fd_pr__cap_mim_m3_1 l=28.68 w=28.68
X69 VPWR COMPARATOR__PREAMP__MIR COMPARATOR__PREAMP__MIR VPWR sky130_fd_pr__pfet_01v8_hvt ad=5.8 pd=40.58 as=5.8 ps=40.58 w=20 l=1
X70 VPWR FILTER__BUFFER1__FIRST__MIR FILTER__BUFFER1__FIRST__MIR VPWR sky130_fd_pr__pfet_01v8_hvt ad=5.8 pd=40.58 as=5.8 ps=40.58 w=20 l=1
X71 FILTER__FILTER0 VGND sky130_fd_pr__cap_mim_m3_1 l=28.68 w=28.68
X72 COMPARATOR__PREAMP__TAIL OUT COMPARATOR__PRE VGND sky130_fd_pr__nfet_01v8 ad=2.9 pd=20.58 as=2.9 ps=20.58 w=10 l=1
X73 FILTER__FILTER1 VGND sky130_fd_pr__cap_mim_m3_1 l=28.68 w=28.68
X74 PGA__GAIN2__AMP__PRE PGA__GAIN2__AMP__COMP sky130_fd_pr__cap_mim_m3_1 l=28.68 w=28.68
X75 CMP RESET_MUX__SB D VGND sky130_fd_pr__nfet_01v8 ad=0.1885 pd=1.88 as=0.1885 ps=1.88 w=0.65 l=0.15
X76 PGA__OUTPUT_BUFFER__FIRST__TAIL PGA__SELECTED PGA__OUTPUT_BUFFER__PRE VGND sky130_fd_pr__nfet_01v8 ad=1.45 pd=10.58 as=1.45 ps=10.58 w=5 l=1
X77 VGND BIAS VCM VGND sky130_fd_pr__nfet_01v8 ad=0.58 pd=4.58 as=0.58 ps=4.58 w=2 l=1
X78 PGA__GAIN8__AMP__FIRST__TAIL PGA__GAIN8__FB PGA__GAIN8__AMP__FIRST__MIR VGND sky130_fd_pr__nfet_01v8 ad=1.45 pd=10.58 as=1.45 ps=10.58 w=5 l=1
X79 VGND RESET_MUX__SB D VPWR sky130_fd_pr__pfet_01v8_hvt ad=0.1885 pd=1.88 as=0.1885 ps=1.88 w=0.65 l=0.15
X80 VPWR COMPARATOR__PREAMP__MIR COMPARATOR__PRE VPWR sky130_fd_pr__pfet_01v8_hvt ad=5.8 pd=40.58 as=5.8 ps=40.58 w=20 l=1
X81 FILTER__BUFFER1__PRE FILTER__BUFFER1__COMP sky130_fd_pr__cap_mim_m3_1 l=28.68 w=28.68
X82 BIAS_SOURCE_R_VCM_TOP_R0_N1 BIAS_SOURCE__VCM_RAW VGND sky130_fd_pr__res_xhigh_po_1p41 l=23.34
X83 FILTER__FILTER1 VGND sky130_fd_pr__cap_mim_m3_1 l=28.68 w=28.68
X84 BIAS_SOURCE__VCM_BUFFER__PRE BIAS_SOURCE__VCM_BUFFER__COMP sky130_fd_pr__cap_mim_m3_1 l=28.68 w=28.68
X85 PGA__GAIN8__AMP__FIRST__TAIL VIN PGA__GAIN8__AMP__PRE VGND sky130_fd_pr__nfet_01v8 ad=1.45 pd=10.58 as=1.45 ps=10.58 w=5 l=1
X86 BIAS_SOURCE__VCM_BUFFER__COMP VCM VGND sky130_fd_pr__res_xhigh_po_1p41 l=3.36
X87 FILTER__FILTER0 VGND sky130_fd_pr__cap_mim_m3_1 l=28.68 w=28.68
X88 CMP RESET D VPWR sky130_fd_pr__pfet_01v8_hvt ad=0.1885 pd=1.88 as=0.1885 ps=1.88 w=0.65 l=0.15
X89 BIAS_SOURCE__VCM_RAW VGND sky130_fd_pr__cap_mim_m3_1 l=28.68 w=28.68
X90 FILTER__FILTER1 VGND sky130_fd_pr__cap_mim_m3_1 l=28.68 w=28.68
X91 VGND CLK SAMPLE__CLKB VGND sky130_fd_pr__nfet_01v8 ad=0.1885 pd=1.88 as=0.1885 ps=1.88 w=0.65 l=0.15
X92 PGA__OUTPUT_BUFFER__FIRST__TAIL PGA__SELECTED PGA__OUTPUT_BUFFER__PRE VGND sky130_fd_pr__nfet_01v8 ad=1.45 pd=10.58 as=1.45 ps=10.58 w=5 l=1
X93 BIAS_SOURCE__VCM_BUFFER__FIRST__TAIL VCM BIAS_SOURCE__VCM_BUFFER__FIRST__MIR VGND sky130_fd_pr__nfet_01v8 ad=1.45 pd=10.58 as=1.45 ps=10.58 w=5 l=1
X94 PGA__GAIN2__AMP__FIRST__TAIL PGA__GAIN2__FB PGA__GAIN2__AMP__FIRST__MIR VGND sky130_fd_pr__nfet_01v8 ad=1.45 pd=10.58 as=1.45 ps=10.58 w=5 l=1
X95 PGA__V2 PGA__GAIN2__FB VGND sky130_fd_pr__res_xhigh_po_1p41 l=6.89
X96 FILTER__FILTER0 VGND sky130_fd_pr__cap_mim_m3_1 l=28.68 w=28.68
X97 VGND BIAS FILTER__BUFFER1__FIRST__TAIL VGND sky130_fd_pr__nfet_01v8 ad=0.58 pd=4.58 as=0.58 ps=4.58 w=2 l=1
X98 FILTER__FILTER1 VGND sky130_fd_pr__cap_mim_m3_1 l=28.68 w=28.68
X99 PGA__GAIN8__AMP__COMP PGA__V8 VGND sky130_fd_pr__res_xhigh_po_1p41 l=3.36
X100 PGA__OUTPUT_BUFFER__PRE PGA__OUTPUT_BUFFER__COMP sky130_fd_pr__cap_mim_m3_1 l=28.68 w=28.68
X101 PGA__GAIN2__AMP__COMP PGA__V2 VGND sky130_fd_pr__res_xhigh_po_1p41 l=3.36
X102 FILTER__BUFFER0__PRE FILTER__BUFFER0__COMP sky130_fd_pr__cap_mim_m3_1 l=28.68 w=28.68
X103 BIAS_SOURCE__VCM_RAW VGND sky130_fd_pr__cap_mim_m3_1 l=28.68 w=28.68
X104 FILTER__FILTER0 VGND sky130_fd_pr__cap_mim_m3_1 l=28.68 w=28.68
X105 FILTER__BUFFER1__FIRST__TAIL OUT FILTER__BUFFER1__FIRST__MIR VGND sky130_fd_pr__nfet_01v8 ad=1.45 pd=10.58 as=1.45 ps=10.58 w=5 l=1
X106 FILTER__BUFFER1__PRE FILTER__BUFFER1__COMP sky130_fd_pr__cap_mim_m3_1 l=28.68 w=28.68
X107 VPWR BIAS_SOURCE_R_VCM_TOP_R0_N0 VGND sky130_fd_pr__res_xhigh_po_1p41 l=23.34
X108 VGND BIAS PGA__V2 VGND sky130_fd_pr__nfet_01v8 ad=0.58 pd=4.58 as=0.58 ps=4.58 w=2 l=1
X109 VGND SAMPLE__TB DATA VGND sky130_fd_pr__nfet_01v8 ad=0.1885 pd=1.88 as=0.1885 ps=1.88 w=0.65 l=0.15
X110 BIAS_SOURCE__VCM_BUFFER__FIRST__TAIL BIAS_SOURCE__VCM_RAW BIAS_SOURCE__VCM_BUFFER__PRE VGND sky130_fd_pr__nfet_01v8 ad=1.45 pd=10.58 as=1.45 ps=10.58 w=5 l=1
X111 BIAS_SOURCE__VCM_BUFFER__PRE BIAS_SOURCE__VCM_BUFFER__COMP sky130_fd_pr__cap_mim_m3_1 l=28.68 w=28.68
X112 PGA__GAIN8__FB VCM VGND sky130_fd_pr__res_xhigh_po_1p41 l=6.89
X113 FILTER__BUFFER1__FIRST__TAIL OUT FILTER__BUFFER1__FIRST__MIR VGND sky130_fd_pr__nfet_01v8 ad=1.45 pd=10.58 as=1.45 ps=10.58 w=5 l=1
X114 VGND GAIN PGA__GAINB VGND sky130_fd_pr__nfet_01v8 ad=0.1885 pd=1.88 as=0.1885 ps=1.88 w=0.65 l=0.15
X115 COMPARATOR__PREAMP__TAIL VCM COMPARATOR__PREAMP__MIR VGND sky130_fd_pr__nfet_01v8 ad=2.9 pd=20.58 as=2.9 ps=20.58 w=10 l=1
X116 BIAS_SOURCE_R_VCM_TOP_R0_N0 BIAS_SOURCE_R_VCM_TOP_R0_N1 VGND sky130_fd_pr__res_xhigh_po_1p41 l=23.34
X117 VGND BIAS PGA__GAIN2__AMP__FIRST__TAIL VGND sky130_fd_pr__nfet_01v8 ad=0.58 pd=4.58 as=0.58 ps=4.58 w=2 l=1
X118 BIAS_SOURCE__VCM_RAW VGND sky130_fd_pr__cap_mim_m3_1 l=28.68 w=28.68
X119 VGND BIAS OUT VGND sky130_fd_pr__nfet_01v8 ad=0.58 pd=4.58 as=0.58 ps=4.58 w=2 l=1
X120 PGA__GAIN8__AMP__FIRST__TAIL PGA__GAIN8__FB PGA__GAIN8__AMP__FIRST__MIR VGND sky130_fd_pr__nfet_01v8 ad=1.45 pd=10.58 as=1.45 ps=10.58 w=5 l=1
X121 FILTER__FILTER0 VGND sky130_fd_pr__cap_mim_m3_1 l=28.68 w=28.68
X122 BIAS_SOURCE__VCM_RAW VGND sky130_fd_pr__cap_mim_m3_1 l=28.68 w=28.68
X123 VPWR BIAS VGND sky130_fd_pr__res_xhigh_po_1p41 l=20.99
X124 FILTER__BUFFER0__COMP FILTER__MID VGND sky130_fd_pr__res_xhigh_po_1p41 l=3.36
X125 FILTER__FILTER0 VGND sky130_fd_pr__cap_mim_m3_1 l=28.68 w=28.68
X126 PGA__GAIN2__AMP__PRE PGA__GAIN2__AMP__COMP sky130_fd_pr__cap_mim_m3_1 l=28.68 w=28.68
X127 SAMPLE__MF CLK SAMPLE__T VGND sky130_fd_pr__nfet_01v8 ad=0.1885 pd=1.88 as=0.1885 ps=1.88 w=0.65 l=0.15
X128 VGND BIAS BIAS VGND sky130_fd_pr__nfet_01v8 ad=0.58 pd=4.58 as=0.58 ps=4.58 w=2 l=1
X129 VPWR PGA__OUTPUT_BUFFER__PRE AMPLIFIED VPWR sky130_fd_pr__pfet_01v8_hvt ad=11.6 pd=80.58 as=11.6 ps=80.58 w=40 l=1
X130 VPWR FILTER__BUFFER0__FIRST__MIR FILTER__BUFFER0__PRE VPWR sky130_fd_pr__pfet_01v8_hvt ad=5.8 pd=40.58 as=5.8 ps=40.58 w=20 l=1
X131 SAMPLE__MF CLK SAMPLE__M VGND sky130_fd_pr__nfet_01v8 ad=0.1885 pd=1.88 as=0.1885 ps=1.88 w=0.65 l=0.15
X132 FILTER__BUFFER0__PRE FILTER__BUFFER0__COMP sky130_fd_pr__cap_mim_m3_1 l=28.68 w=28.68
X133 FILTER__FILTER0 VGND sky130_fd_pr__cap_mim_m3_1 l=28.68 w=28.68
X134 PGA__V8 PGA_GAIN8_R_FEEDBACK_R0_N0 VGND sky130_fd_pr__res_xhigh_po_1p41 l=24.51
X135 PGA__OUTPUT_BUFFER__PRE PGA__OUTPUT_BUFFER__COMP sky130_fd_pr__cap_mim_m3_1 l=28.68 w=28.68
X136 PGA__GAIN8__AMP__PRE PGA__GAIN8__AMP__COMP sky130_fd_pr__cap_mim_m3_1 l=28.68 w=28.68
X137 BIAS_SOURCE__VCM_RAW VGND sky130_fd_pr__cap_mim_m3_1 l=28.68 w=28.68
X138 FILTER__BUFFER1__PRE FILTER__BUFFER1__COMP sky130_fd_pr__cap_mim_m3_1 l=28.68 w=28.68
X139 DATA SAMPLE__CLKB SAMPLE__T VGND sky130_fd_pr__nfet_01v8 ad=0.1885 pd=1.88 as=0.1885 ps=1.88 w=0.65 l=0.15
X140 VPWR PGA__GAIN8__AMP__FIRST__MIR PGA__GAIN8__AMP__PRE VPWR sky130_fd_pr__pfet_01v8_hvt ad=5.8 pd=40.58 as=5.8 ps=40.58 w=20 l=1
X141 D SAMPLE__CLKB SAMPLE__M VGND sky130_fd_pr__nfet_01v8 ad=0.1885 pd=1.88 as=0.1885 ps=1.88 w=0.65 l=0.15
X142 VGND RESET RESET_MUX__SB VGND sky130_fd_pr__nfet_01v8 ad=0.1885 pd=1.88 as=0.1885 ps=1.88 w=0.65 l=0.15
X143 VPWR PGA__GAIN2__AMP__FIRST__MIR PGA__GAIN2__AMP__PRE VPWR sky130_fd_pr__pfet_01v8_hvt ad=5.8 pd=40.58 as=5.8 ps=40.58 w=20 l=1
X144 VPWR PGA__OUTPUT_BUFFER__FIRST__MIR PGA__OUTPUT_BUFFER__PRE VPWR sky130_fd_pr__pfet_01v8_hvt ad=5.8 pd=40.58 as=5.8 ps=40.58 w=20 l=1
X145 FILTER__BUFFER0__FIRST__TAIL FILTER__MID FILTER__BUFFER0__FIRST__MIR VGND sky130_fd_pr__nfet_01v8 ad=1.45 pd=10.58 as=1.45 ps=10.58 w=5 l=1
X146 FILTER__FILTER0 VGND sky130_fd_pr__cap_mim_m3_1 l=28.68 w=28.68
X147 PGA__GAIN2__AMP__FIRST__TAIL PGA__GAIN2__FB PGA__GAIN2__AMP__FIRST__MIR VGND sky130_fd_pr__nfet_01v8 ad=1.45 pd=10.58 as=1.45 ps=10.58 w=5 l=1
X148 VPWR PGA__GAIN8__AMP__FIRST__MIR PGA__GAIN8__AMP__FIRST__MIR VPWR sky130_fd_pr__pfet_01v8_hvt ad=5.8 pd=40.58 as=5.8 ps=40.58 w=20 l=1
X149 FILTER__FILTER1 VGND sky130_fd_pr__cap_mim_m3_1 l=28.68 w=28.68
X150 BIAS_SOURCE__VCM_BUFFER__PRE BIAS_SOURCE__VCM_BUFFER__COMP sky130_fd_pr__cap_mim_m3_1 l=28.68 w=28.68
X151 VGND BIAS FILTER__BUFFER0__FIRST__TAIL VGND sky130_fd_pr__nfet_01v8 ad=0.58 pd=4.58 as=0.58 ps=4.58 w=2 l=1
X152 VGND SAMPLE__MB SAMPLE__MF VGND sky130_fd_pr__nfet_01v8 ad=0.1885 pd=1.88 as=0.1885 ps=1.88 w=0.65 l=0.15
X153 VPWR PGA__GAIN8__AMP__PRE PGA__V8 VPWR sky130_fd_pr__pfet_01v8_hvt ad=11.6 pd=80.58 as=11.6 ps=80.58 w=40 l=1
X154 VPWR PGA__GAIN2__AMP__PRE PGA__V2 VPWR sky130_fd_pr__pfet_01v8_hvt ad=11.6 pd=80.58 as=11.6 ps=80.58 w=40 l=1
X155 PGA_GAIN8_R_FEEDBACK_R0_N0 PGA__GAIN8__FB VGND sky130_fd_pr__res_xhigh_po_1p41 l=24.51
X156 VPWR CLK SAMPLE__CLKB VPWR sky130_fd_pr__pfet_01v8_hvt ad=0.1885 pd=1.88 as=0.1885 ps=1.88 w=0.65 l=0.15
X157 FILTER__BUFFER0__FIRST__TAIL FILTER__MID FILTER__BUFFER0__FIRST__MIR VGND sky130_fd_pr__nfet_01v8 ad=1.45 pd=10.58 as=1.45 ps=10.58 w=5 l=1
X158 VGND SAMPLE__M SAMPLE__MB VGND sky130_fd_pr__nfet_01v8 ad=0.1885 pd=1.88 as=0.1885 ps=1.88 w=0.65 l=0.15
X159 FILTER__MID FILTER__FILTER1 VGND sky130_fd_pr__res_xhigh_po_1p41 l=28.04
X160 VGND SAMPLE__T SAMPLE__TB VGND sky130_fd_pr__nfet_01v8 ad=0.1885 pd=1.88 as=0.1885 ps=1.88 w=0.65 l=0.15
X161 VGND BIAS PGA__V8 VGND sky130_fd_pr__nfet_01v8 ad=0.58 pd=4.58 as=0.58 ps=4.58 w=2 l=1
X162 VPWR BIAS_SOURCE__VCM_BUFFER__PRE VCM VPWR sky130_fd_pr__pfet_01v8_hvt ad=11.6 pd=80.58 as=11.6 ps=80.58 w=40 l=1
X163 VGND BIAS FILTER__MID VGND sky130_fd_pr__nfet_01v8 ad=0.58 pd=4.58 as=0.58 ps=4.58 w=2 l=1
X164 BIAS_SOURCE__VCM_RAW VGND sky130_fd_pr__cap_mim_m3_1 l=28.68 w=28.68
X165 BIAS_SOURCE__VCM_RAW VGND sky130_fd_pr__cap_mim_m3_1 l=28.68 w=28.68
.ends

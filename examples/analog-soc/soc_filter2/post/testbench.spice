Resistor analog SoC soc_filter2
.include "./supported-tt.spice"
.options method=gear maxord=2
.include "./pex-simulation.spice"
.temp 27.0
VGND VGND 0 0
VDD VPWR VGND 1.8
VBIAS BIAS VGND 0.9
VIN VIN VGND DC 0.9 AC 1 SIN(0.9 0.025 5000)
CLOAD OUT VGND 50f
XU VPWR VGND OUT BIAS VIN soc_filter2
.control
set num_threads=1
set numdgt=17
set wr_singlescale
set wr_vecnames
set noaskquit
ac dec 60 10 1e9
let mos_wave_0 = mag(v(OUT))
let mos_wave_1 = 180/pi*ph(v(OUT))
wrdata waveform.dat mos_wave_0 mos_wave_1
write waveform.raw all
quit
.endc
.end

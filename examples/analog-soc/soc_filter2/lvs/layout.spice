* NGSPICE file created from soc_filter2.ext - technology: sky130A

.subckt soc_filter2 VPWR VGND OUT BIAS VIN
X0 BUFFER0__FIRST__TAIL MID BUFFER0__FIRST__MIR VGND sky130_fd_pr__nfet_01v8 ad=1.45 pd=10.58 as=1.45 ps=10.58 w=5 l=1
X1 FILTER0 VGND sky130_fd_pr__cap_mim_m3_1 l=28.68 w=28.68
X2 FILTER0 VGND sky130_fd_pr__cap_mim_m3_1 l=28.68 w=28.68
X3 MID FILTER1 VGND sky130_fd_pr__res_xhigh_po_1p41 l=28.04
X4 VPWR BUFFER1__FIRST__MIR BUFFER1__FIRST__MIR VPWR sky130_fd_pr__pfet_01v8_hvt ad=5.8 pd=40.58 as=5.8 ps=40.58 w=20 l=1
X5 FILTER0 VGND sky130_fd_pr__cap_mim_m3_1 l=28.68 w=28.68
X6 FILTER1 VGND sky130_fd_pr__cap_mim_m3_1 l=28.68 w=28.68
X7 FILTER1 VGND sky130_fd_pr__cap_mim_m3_1 l=28.68 w=28.68
X8 BUFFER1__FIRST__TAIL FILTER1 BUFFER1__PRE VGND sky130_fd_pr__nfet_01v8 ad=1.45 pd=10.58 as=1.45 ps=10.58 w=5 l=1
X9 BUFFER0__FIRST__TAIL FILTER0 BUFFER0__PRE VGND sky130_fd_pr__nfet_01v8 ad=1.45 pd=10.58 as=1.45 ps=10.58 w=5 l=1
X10 VPWR BUFFER1__FIRST__MIR BUFFER1__PRE VPWR sky130_fd_pr__pfet_01v8_hvt ad=5.8 pd=40.58 as=5.8 ps=40.58 w=20 l=1
X11 FILTER0 VGND sky130_fd_pr__cap_mim_m3_1 l=28.68 w=28.68
X12 FILTER1 VGND sky130_fd_pr__cap_mim_m3_1 l=28.68 w=28.68
X13 VIN FILTER0 VGND sky130_fd_pr__res_xhigh_po_1p41 l=28.04
X14 FILTER1 VGND sky130_fd_pr__cap_mim_m3_1 l=28.68 w=28.68
X15 FILTER1 VGND sky130_fd_pr__cap_mim_m3_1 l=28.68 w=28.68
X16 VPWR BUFFER0__FIRST__MIR BUFFER0__FIRST__MIR VPWR sky130_fd_pr__pfet_01v8_hvt ad=5.8 pd=40.58 as=5.8 ps=40.58 w=20 l=1
X17 VPWR BUFFER0__PRE MID VPWR sky130_fd_pr__pfet_01v8_hvt ad=11.6 pd=80.58 as=11.6 ps=80.58 w=40 l=1
X18 BUFFER0__PRE BUFFER0__COMP sky130_fd_pr__cap_mim_m3_1 l=28.68 w=28.68
X19 FILTER0 VGND sky130_fd_pr__cap_mim_m3_1 l=28.68 w=28.68
X20 FILTER1 VGND sky130_fd_pr__cap_mim_m3_1 l=28.68 w=28.68
X21 BUFFER1__PRE BUFFER1__COMP sky130_fd_pr__cap_mim_m3_1 l=28.68 w=28.68
X22 VPWR BUFFER0__FIRST__MIR BUFFER0__PRE VPWR sky130_fd_pr__pfet_01v8_hvt ad=5.8 pd=40.58 as=5.8 ps=40.58 w=20 l=1
X23 FILTER0 VGND sky130_fd_pr__cap_mim_m3_1 l=28.68 w=28.68
X24 VGND BIAS BUFFER1__FIRST__TAIL VGND sky130_fd_pr__nfet_01v8 ad=0.58 pd=4.58 as=0.58 ps=4.58 w=2 l=1
X25 FILTER1 VGND sky130_fd_pr__cap_mim_m3_1 l=28.68 w=28.68
X26 BUFFER1__FIRST__TAIL FILTER1 BUFFER1__PRE VGND sky130_fd_pr__nfet_01v8 ad=1.45 pd=10.58 as=1.45 ps=10.58 w=5 l=1
X27 FILTER0 VGND sky130_fd_pr__cap_mim_m3_1 l=28.68 w=28.68
X28 BUFFER0__PRE BUFFER0__COMP sky130_fd_pr__cap_mim_m3_1 l=28.68 w=28.68
X29 BUFFER1__PRE BUFFER1__COMP sky130_fd_pr__cap_mim_m3_1 l=28.68 w=28.68
X30 BUFFER0__FIRST__TAIL MID BUFFER0__FIRST__MIR VGND sky130_fd_pr__nfet_01v8 ad=1.45 pd=10.58 as=1.45 ps=10.58 w=5 l=1
X31 BUFFER1__FIRST__TAIL OUT BUFFER1__FIRST__MIR VGND sky130_fd_pr__nfet_01v8 ad=1.45 pd=10.58 as=1.45 ps=10.58 w=5 l=1
X32 VPWR BUFFER1__PRE OUT VPWR sky130_fd_pr__pfet_01v8_hvt ad=11.6 pd=80.58 as=11.6 ps=80.58 w=40 l=1
X33 FILTER1 VGND sky130_fd_pr__cap_mim_m3_1 l=28.68 w=28.68
X34 VGND BIAS BUFFER0__FIRST__TAIL VGND sky130_fd_pr__nfet_01v8 ad=0.58 pd=4.58 as=0.58 ps=4.58 w=2 l=1
X35 FILTER0 VGND sky130_fd_pr__cap_mim_m3_1 l=28.68 w=28.68
X36 BUFFER0__FIRST__TAIL FILTER0 BUFFER0__PRE VGND sky130_fd_pr__nfet_01v8 ad=1.45 pd=10.58 as=1.45 ps=10.58 w=5 l=1
X37 VGND BIAS OUT VGND sky130_fd_pr__nfet_01v8 ad=0.58 pd=4.58 as=0.58 ps=4.58 w=2 l=1
X38 FILTER0 VGND sky130_fd_pr__cap_mim_m3_1 l=28.68 w=28.68
X39 FILTER0 VGND sky130_fd_pr__cap_mim_m3_1 l=28.68 w=28.68
X40 FILTER1 VGND sky130_fd_pr__cap_mim_m3_1 l=28.68 w=28.68
X41 BUFFER0__PRE BUFFER0__COMP sky130_fd_pr__cap_mim_m3_1 l=28.68 w=28.68
X42 FILTER1 VGND sky130_fd_pr__cap_mim_m3_1 l=28.68 w=28.68
X43 BUFFER1__PRE BUFFER1__COMP sky130_fd_pr__cap_mim_m3_1 l=28.68 w=28.68
X44 BUFFER1__COMP OUT VGND sky130_fd_pr__res_xhigh_po_1p41 l=3.36
X45 VGND BIAS MID VGND sky130_fd_pr__nfet_01v8 ad=0.58 pd=4.58 as=0.58 ps=4.58 w=2 l=1
X46 BUFFER1__FIRST__TAIL OUT BUFFER1__FIRST__MIR VGND sky130_fd_pr__nfet_01v8 ad=1.45 pd=10.58 as=1.45 ps=10.58 w=5 l=1
X47 FILTER0 VGND sky130_fd_pr__cap_mim_m3_1 l=28.68 w=28.68
X48 FILTER1 VGND sky130_fd_pr__cap_mim_m3_1 l=28.68 w=28.68
X49 FILTER0 VGND sky130_fd_pr__cap_mim_m3_1 l=28.68 w=28.68
X50 BUFFER0__COMP MID VGND sky130_fd_pr__res_xhigh_po_1p41 l=3.36
X51 FILTER1 VGND sky130_fd_pr__cap_mim_m3_1 l=28.68 w=28.68
.ends

* NGSPICE file created from soc_filter2.ext - technology: sky130A

.subckt soc_filter2 VPWR OUT VGND BIAS VIN
X0 FILTER1 VGND sky130_fd_pr__cap_mim_m3_1 l=28.68 w=28.68
X1 BUFFER1__PRE BUFFER1__COMP sky130_fd_pr__cap_mim_m3_1 l=28.68 w=28.68
X2 VPWR BUFFER1__FIRST__MIR BUFFER1__FIRST__MIR VPWR sky130_fd_pr__pfet_01v8_hvt ad=5.8 pd=40.58 as=5.8 ps=40.58 w=20 l=1
X3 FILTER0 VGND sky130_fd_pr__cap_mim_m3_1 l=28.68 w=28.68
X4 FILTER0 VGND sky130_fd_pr__cap_mim_m3_1 l=28.68 w=28.68
X5 BUFFER0__FIRST__TAIL FILTER0 BUFFER0__PRE VGND sky130_fd_pr__nfet_01v8 ad=2.9 pd=20.58 as=2.9 ps=20.58 w=10 l=1
X6 VPWR BUFFER1__FIRST__MIR BUFFER1__PRE VPWR sky130_fd_pr__pfet_01v8_hvt ad=5.8 pd=40.58 as=5.8 ps=40.58 w=20 l=1
X7 FILTER0 VGND sky130_fd_pr__cap_mim_m3_1 l=28.68 w=28.68
X8 BUFFER1__FIRST__TAIL OUT BUFFER1__FIRST__MIR VGND sky130_fd_pr__nfet_01v8 ad=2.9 pd=20.58 as=2.9 ps=20.58 w=10 l=1
X9 VPWR BUFFER1__PRE OUT VPWR sky130_fd_pr__pfet_01v8_hvt ad=11.6 pd=80.58 as=11.6 ps=80.58 w=40 l=1
X10 FILTER1 VGND sky130_fd_pr__cap_mim_m3_1 l=28.68 w=28.68
X11 VGND BIAS OUT VGND sky130_fd_pr__nfet_01v8 ad=0.58 pd=4.58 as=0.58 ps=4.58 w=2 l=1
X12 FILTER0 VGND sky130_fd_pr__cap_mim_m3_1 l=28.68 w=28.68
X13 BUFFER1__PRE BUFFER1__COMP sky130_fd_pr__cap_mim_m3_1 l=28.68 w=28.68
X14 VIN FILTER0 VGND sky130_fd_pr__res_xhigh_po_1p41 l=28.04
X15 VPWR BUFFER0__PRE MID VPWR sky130_fd_pr__pfet_01v8_hvt ad=11.6 pd=80.58 as=11.6 ps=80.58 w=40 l=1
X16 BUFFER0__PRE BUFFER0__COMP sky130_fd_pr__cap_mim_m3_1 l=28.68 w=28.68
X17 MID FILTER1 VGND sky130_fd_pr__res_xhigh_po_1p41 l=28.04
X18 VGND BIAS BUFFER1__FIRST__TAIL VGND sky130_fd_pr__nfet_01v8 ad=0.58 pd=4.58 as=0.58 ps=4.58 w=2 l=1
X19 FILTER1 VGND sky130_fd_pr__cap_mim_m3_1 l=28.68 w=28.68
X20 FILTER0 VGND sky130_fd_pr__cap_mim_m3_1 l=28.68 w=28.68
X21 FILTER0 VGND sky130_fd_pr__cap_mim_m3_1 l=28.68 w=28.68
X22 FILTER1 VGND sky130_fd_pr__cap_mim_m3_1 l=28.68 w=28.68
X23 BUFFER1__PRE BUFFER1__COMP sky130_fd_pr__cap_mim_m3_1 l=28.68 w=28.68
X24 BUFFER1__COMP OUT VGND sky130_fd_pr__res_xhigh_po_1p41 l=3.36
X25 VPWR BUFFER0__FIRST__MIR BUFFER0__FIRST__MIR VPWR sky130_fd_pr__pfet_01v8_hvt ad=5.8 pd=40.58 as=5.8 ps=40.58 w=20 l=1
X26 FILTER1 VGND sky130_fd_pr__cap_mim_m3_1 l=28.68 w=28.68
X27 BUFFER0__FIRST__TAIL MID BUFFER0__FIRST__MIR VGND sky130_fd_pr__nfet_01v8 ad=2.9 pd=20.58 as=2.9 ps=20.58 w=10 l=1
X28 BUFFER1__FIRST__TAIL FILTER1 BUFFER1__PRE VGND sky130_fd_pr__nfet_01v8 ad=2.9 pd=20.58 as=2.9 ps=20.58 w=10 l=1
X29 VPWR BUFFER0__FIRST__MIR BUFFER0__PRE VPWR sky130_fd_pr__pfet_01v8_hvt ad=5.8 pd=40.58 as=5.8 ps=40.58 w=20 l=1
X30 VGND BIAS MID VGND sky130_fd_pr__nfet_01v8 ad=0.58 pd=4.58 as=0.58 ps=4.58 w=2 l=1
X31 BUFFER0__PRE BUFFER0__COMP sky130_fd_pr__cap_mim_m3_1 l=28.68 w=28.68
X32 FILTER1 VGND sky130_fd_pr__cap_mim_m3_1 l=28.68 w=28.68
X33 FILTER1 VGND sky130_fd_pr__cap_mim_m3_1 l=28.68 w=28.68
X34 FILTER0 VGND sky130_fd_pr__cap_mim_m3_1 l=28.68 w=28.68
X35 FILTER1 VGND sky130_fd_pr__cap_mim_m3_1 l=28.68 w=28.68
X36 VGND BIAS BUFFER0__FIRST__TAIL VGND sky130_fd_pr__nfet_01v8 ad=0.58 pd=4.58 as=0.58 ps=4.58 w=2 l=1
X37 FILTER0 VGND sky130_fd_pr__cap_mim_m3_1 l=28.68 w=28.68
X38 FILTER0 VGND sky130_fd_pr__cap_mim_m3_1 l=28.68 w=28.68
X39 FILTER0 VGND sky130_fd_pr__cap_mim_m3_1 l=28.68 w=28.68
X40 BUFFER0__PRE BUFFER0__COMP sky130_fd_pr__cap_mim_m3_1 l=28.68 w=28.68
X41 FILTER1 VGND sky130_fd_pr__cap_mim_m3_1 l=28.68 w=28.68
X42 BUFFER0__COMP MID VGND sky130_fd_pr__res_xhigh_po_1p41 l=3.36
X43 FILTER1 VGND sky130_fd_pr__cap_mim_m3_1 l=28.68 w=28.68
X44 FILTER0 VGND sky130_fd_pr__cap_mim_m3_1 l=28.68 w=28.68
X45 FILTER0 VGND sky130_fd_pr__cap_mim_m3_1 l=28.68 w=28.68
X46 FILTER1 VGND sky130_fd_pr__cap_mim_m3_1 l=28.68 w=28.68
X47 FILTER1 VGND sky130_fd_pr__cap_mim_m3_1 l=28.68 w=28.68
.ends

.subckt soc_filter2 VIN BIAS OUT VPWR VGND
XBUFFER0_C_MILLER_P0 BUFFER0__PRE BUFFER0__COMP sky130_fd_pr__cap_mim_m3_1 w=28.68 l=28.68
XBUFFER0_C_MILLER_P1 BUFFER0__PRE BUFFER0__COMP sky130_fd_pr__cap_mim_m3_1 w=28.68 l=28.68
XBUFFER0_C_MILLER_P2 BUFFER0__PRE BUFFER0__COMP sky130_fd_pr__cap_mim_m3_1 w=28.68 l=28.68
XBUFFER0_FIRST_N_INN BUFFER0__FIRST__MIR MID BUFFER0__FIRST__TAIL VGND sky130_fd_pr__nfet_01v8 w=10 l=1 nf=1 m=1
XBUFFER0_FIRST_N_INP BUFFER0__PRE FILTER0 BUFFER0__FIRST__TAIL VGND sky130_fd_pr__nfet_01v8 w=10 l=1 nf=1 m=1
XBUFFER0_FIRST_N_TAIL BUFFER0__FIRST__TAIL BIAS VGND VGND sky130_fd_pr__nfet_01v8 w=2 l=1 nf=1 m=1
XBUFFER0_FIRST_P_DIODE BUFFER0__FIRST__MIR BUFFER0__FIRST__MIR VPWR VPWR sky130_fd_pr__pfet_01v8_hvt w=20 l=1 nf=1 m=1
XBUFFER0_FIRST_P_MIRROR BUFFER0__PRE BUFFER0__FIRST__MIR VPWR VPWR sky130_fd_pr__pfet_01v8_hvt w=20 l=1 nf=1 m=1
XBUFFER0_N_SECOND MID BIAS VGND VGND sky130_fd_pr__nfet_01v8 w=2 l=1 nf=1 m=1
XBUFFER0_P_SECOND MID BUFFER0__PRE VPWR VPWR sky130_fd_pr__pfet_01v8_hvt w=40 l=1 nf=1 m=1
XBUFFER0_R_ZERO_P0 BUFFER0__COMP MID VGND sky130_fd_pr__res_xhigh_po_1p41 l=3.36
XBUFFER1_C_MILLER_P0 BUFFER1__PRE BUFFER1__COMP sky130_fd_pr__cap_mim_m3_1 w=28.68 l=28.68
XBUFFER1_C_MILLER_P1 BUFFER1__PRE BUFFER1__COMP sky130_fd_pr__cap_mim_m3_1 w=28.68 l=28.68
XBUFFER1_C_MILLER_P2 BUFFER1__PRE BUFFER1__COMP sky130_fd_pr__cap_mim_m3_1 w=28.68 l=28.68
XBUFFER1_FIRST_N_INN BUFFER1__FIRST__MIR OUT BUFFER1__FIRST__TAIL VGND sky130_fd_pr__nfet_01v8 w=10 l=1 nf=1 m=1
XBUFFER1_FIRST_N_INP BUFFER1__PRE FILTER1 BUFFER1__FIRST__TAIL VGND sky130_fd_pr__nfet_01v8 w=10 l=1 nf=1 m=1
XBUFFER1_FIRST_N_TAIL BUFFER1__FIRST__TAIL BIAS VGND VGND sky130_fd_pr__nfet_01v8 w=2 l=1 nf=1 m=1
XBUFFER1_FIRST_P_DIODE BUFFER1__FIRST__MIR BUFFER1__FIRST__MIR VPWR VPWR sky130_fd_pr__pfet_01v8_hvt w=20 l=1 nf=1 m=1
XBUFFER1_FIRST_P_MIRROR BUFFER1__PRE BUFFER1__FIRST__MIR VPWR VPWR sky130_fd_pr__pfet_01v8_hvt w=20 l=1 nf=1 m=1
XBUFFER1_N_SECOND OUT BIAS VGND VGND sky130_fd_pr__nfet_01v8 w=2 l=1 nf=1 m=1
XBUFFER1_P_SECOND OUT BUFFER1__PRE VPWR VPWR sky130_fd_pr__pfet_01v8_hvt w=40 l=1 nf=1 m=1
XBUFFER1_R_ZERO_P0 BUFFER1__COMP OUT VGND sky130_fd_pr__res_xhigh_po_1p41 l=3.36
XC_POLE0_P0 FILTER0 VGND sky130_fd_pr__cap_mim_m3_1 w=28.68 l=28.68
XC_POLE0_P1 FILTER0 VGND sky130_fd_pr__cap_mim_m3_1 w=28.68 l=28.68
XC_POLE0_P10 FILTER0 VGND sky130_fd_pr__cap_mim_m3_1 w=28.68 l=28.68
XC_POLE0_P11 FILTER0 VGND sky130_fd_pr__cap_mim_m3_1 w=28.68 l=28.68
XC_POLE0_P2 FILTER0 VGND sky130_fd_pr__cap_mim_m3_1 w=28.68 l=28.68
XC_POLE0_P3 FILTER0 VGND sky130_fd_pr__cap_mim_m3_1 w=28.68 l=28.68
XC_POLE0_P4 FILTER0 VGND sky130_fd_pr__cap_mim_m3_1 w=28.68 l=28.68
XC_POLE0_P5 FILTER0 VGND sky130_fd_pr__cap_mim_m3_1 w=28.68 l=28.68
XC_POLE0_P6 FILTER0 VGND sky130_fd_pr__cap_mim_m3_1 w=28.68 l=28.68
XC_POLE0_P7 FILTER0 VGND sky130_fd_pr__cap_mim_m3_1 w=28.68 l=28.68
XC_POLE0_P8 FILTER0 VGND sky130_fd_pr__cap_mim_m3_1 w=28.68 l=28.68
XC_POLE0_P9 FILTER0 VGND sky130_fd_pr__cap_mim_m3_1 w=28.68 l=28.68
XC_POLE1_P0 FILTER1 VGND sky130_fd_pr__cap_mim_m3_1 w=28.68 l=28.68
XC_POLE1_P1 FILTER1 VGND sky130_fd_pr__cap_mim_m3_1 w=28.68 l=28.68
XC_POLE1_P10 FILTER1 VGND sky130_fd_pr__cap_mim_m3_1 w=28.68 l=28.68
XC_POLE1_P11 FILTER1 VGND sky130_fd_pr__cap_mim_m3_1 w=28.68 l=28.68
XC_POLE1_P2 FILTER1 VGND sky130_fd_pr__cap_mim_m3_1 w=28.68 l=28.68
XC_POLE1_P3 FILTER1 VGND sky130_fd_pr__cap_mim_m3_1 w=28.68 l=28.68
XC_POLE1_P4 FILTER1 VGND sky130_fd_pr__cap_mim_m3_1 w=28.68 l=28.68
XC_POLE1_P5 FILTER1 VGND sky130_fd_pr__cap_mim_m3_1 w=28.68 l=28.68
XC_POLE1_P6 FILTER1 VGND sky130_fd_pr__cap_mim_m3_1 w=28.68 l=28.68
XC_POLE1_P7 FILTER1 VGND sky130_fd_pr__cap_mim_m3_1 w=28.68 l=28.68
XC_POLE1_P8 FILTER1 VGND sky130_fd_pr__cap_mim_m3_1 w=28.68 l=28.68
XC_POLE1_P9 FILTER1 VGND sky130_fd_pr__cap_mim_m3_1 w=28.68 l=28.68
XR_POLE0_P0 VIN FILTER0 VGND sky130_fd_pr__res_xhigh_po_1p41 l=28.035
XR_POLE1_P0 MID FILTER1 VGND sky130_fd_pr__res_xhigh_po_1p41 l=28.035
.ends soc_filter2

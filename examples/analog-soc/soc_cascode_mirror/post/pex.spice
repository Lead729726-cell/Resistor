* NGSPICE file created from soc_cascode_mirror.ext - technology: sky130A

.subckt soc_cascode_mirror VGND REF OUT
X0 LOW_OUT.t0 REF.t2 OUT.t0 VGND.t1 sky130_fd_pr__nfet_01v8 ad=0.58 pd=4.58 as=0.58 ps=4.58 w=2 l=1
X1 VGND.t5 LOW_REF.t3 LOW_OUT.t1 VGND.t4 sky130_fd_pr__nfet_01v8 ad=0.58 pd=4.58 as=0.58 ps=4.58 w=2 l=1
X2 LOW_REF.t0 REF.t0 REF.t1 VGND.t0 sky130_fd_pr__nfet_01v8 ad=0.58 pd=4.58 as=0.58 ps=4.58 w=2 l=1
X3 VGND.t3 LOW_REF.t1 LOW_REF.t2 VGND.t2 sky130_fd_pr__nfet_01v8 ad=0.58 pd=4.58 as=0.58 ps=4.58 w=2 l=1
C0 OUT LOW_REF 0.40336f
C1 REF LOW_REF 2.28089f
C2 LOW_REF LOW_OUT 0.55137f
C3 REF OUT 1.86196f
C4 OUT LOW_OUT 0.32149f
C5 REF LOW_OUT 0.85208f
R0 REF.t1 REF.n0 181.41
R1 REF.n1 REF.t1 174.912
R2 REF REF.t0 139.911
R3 REF REF.t2 139.911
R4 REF REF.n4 28.6132
R5 REF.n4 REF 26.7802
R6 REF.n1 REF 19.837
R7 REF.n2 REF.n1 14.1895
R8 REF.n3 REF.n2 10.3393
R9 REF REF.n0 4.259
R10 REF.n2 REF.n0 3.04672
R11 REF.n3 REF 1.17844
R12 REF.n4 REF.n3 0.393537
R13 OUT.n1 OUT.t0 181.41
R14 OUT.t0 OUT.n0 174.912
R15 OUT OUT.n0 19.837
R16 OUT.n2 OUT.n0 14.1895
R17 OUT OUT.n2 12.9453
R18 OUT.n1 OUT 4.259
R19 OUT.n2 OUT.n1 3.04672
R20 LOW_OUT.n2 LOW_OUT.t1 181.41
R21 LOW_OUT.n5 LOW_OUT.t0 181.41
R22 LOW_OUT.t1 LOW_OUT.n1 174.912
R23 LOW_OUT.t0 LOW_OUT.n0 174.912
R24 LOW_OUT.n4 LOW_OUT.n3 23.5373
R25 LOW_OUT LOW_OUT.n1 19.837
R26 LOW_OUT LOW_OUT.n0 19.837
R27 LOW_OUT.n3 LOW_OUT.n1 14.1895
R28 LOW_OUT.n4 LOW_OUT.n0 14.1895
R29 LOW_OUT.n2 LOW_OUT 4.259
R30 LOW_OUT LOW_OUT.n5 4.259
R31 LOW_OUT.n3 LOW_OUT.n2 3.04672
R32 LOW_OUT.n5 LOW_OUT.n4 3.04672
R33 VGND.n75 VGND.n74 1692.55
R34 VGND.n254 VGND.n238 1692.55
R35 VGND.n207 VGND.n206 1692.55
R36 VGND.n204 VGND.n144 1210.97
R37 VGND.n194 VGND.n176 1210.97
R38 VGND.n164 VGND.n142 1210.97
R39 VGND.n196 VGND.n174 1210.97
R40 VGND.n236 VGND.n112 1210.97
R41 VGND.n226 VGND.n208 1210.97
R42 VGND.n132 VGND.n110 1210.97
R43 VGND.n228 VGND.n137 1210.97
R44 VGND.n97 VGND.n13 1210.97
R45 VGND.n256 VGND.n101 1210.97
R46 VGND.n95 VGND.n76 1210.97
R47 VGND.n105 VGND.n102 1210.97
R48 VGND.n32 VGND.n24 1210.97
R49 VGND.n72 VGND.n20 1210.97
R50 VGND.n58 VGND.n17 1210.97
R51 VGND.n48 VGND.n26 1210.97
R52 VGND.n101 VGND.n100 585
R53 VGND.n252 VGND.n251 585
R54 VGND.n250 VGND.n239 585
R55 VGND.n254 VGND.n239 585
R56 VGND.n249 VGND.n248 585
R57 VGND.n247 VGND.n246 585
R58 VGND.n245 VGND.n244 585
R59 VGND.n243 VGND.n242 585
R60 VGND.n241 VGND.n105 585
R61 VGND.n254 VGND.n105 585
R62 VGND.n240 VGND.n102 585
R63 VGND.n255 VGND.n102 585
R64 VGND.n7 VGND.n5 585
R65 VGND.n9 VGND.n7 585
R66 VGND VGND.n261 585
R67 VGND.n261 VGND.t4 585
R68 VGND.n6 VGND.n4 585
R69 VGND.n8 VGND.n6 585
R70 VGND.n95 VGND.n94 585
R71 VGND.n96 VGND.n95 585
R72 VGND.n93 VGND.n76 585
R73 VGND.n92 VGND.n91 585
R74 VGND.n89 VGND.n77 585
R75 VGND.n87 VGND.n86 585
R76 VGND.n85 VGND.n78 585
R77 VGND.n84 VGND.n83 585
R78 VGND.n81 VGND.n79 585
R79 VGND.n13 VGND.n12 585
R80 VGND.n98 VGND.n97 585
R81 VGND.n97 VGND.n96 585
R82 VGND.n99 VGND.n10 585
R83 VGND.n10 VGND.n8 585
R84 VGND.n260 VGND.n259 585
R85 VGND.t4 VGND.n260 585
R86 VGND.n258 VGND.n11 585
R87 VGND.n11 VGND.n9 585
R88 VGND.n257 VGND.n256 585
R89 VGND.n256 VGND.n255 585
R90 VGND.n224 VGND.n208 585
R91 VGND.n223 VGND.n222 585
R92 VGND.n220 VGND.n209 585
R93 VGND.n220 VGND.n207 585
R94 VGND.n219 VGND.n218 585
R95 VGND.n217 VGND.n216 585
R96 VGND.n215 VGND.n211 585
R97 VGND.n213 VGND.n212 585
R98 VGND.n137 VGND.n136 585
R99 VGND.n207 VGND.n137 585
R100 VGND.n229 VGND.n228 585
R101 VGND.n228 VGND.n227 585
R102 VGND.n230 VGND.n119 585
R103 VGND.n119 VGND.n117 585
R104 VGND.n231 VGND 585
R105 VGND.t0 VGND.n231 585
R106 VGND.n135 VGND.n118 585
R107 VGND.n118 VGND.n111 585
R108 VGND.n134 VGND.n110 585
R109 VGND.n237 VGND.n110 585
R110 VGND.n133 VGND.n132 585
R111 VGND.n131 VGND.n130 585
R112 VGND.n129 VGND.n128 585
R113 VGND.n127 VGND.n126 585
R114 VGND.n125 VGND.n124 585
R115 VGND.n123 VGND.n122 585
R116 VGND.n121 VGND.n120 585
R117 VGND.n114 VGND.n112 585
R118 VGND.n236 VGND.n235 585
R119 VGND.n237 VGND.n236 585
R120 VGND.n234 VGND.n113 585
R121 VGND.n113 VGND.n111 585
R122 VGND.n233 VGND.n232 585
R123 VGND.n232 VGND.t0 585
R124 VGND.n116 VGND.n115 585
R125 VGND.n117 VGND.n116 585
R126 VGND.n226 VGND.n225 585
R127 VGND.n227 VGND.n226 585
R128 VGND.n192 VGND.n176 585
R129 VGND.n191 VGND.n190 585
R130 VGND.n188 VGND.n177 585
R131 VGND.n188 VGND.n175 585
R132 VGND.n187 VGND.n186 585
R133 VGND.n185 VGND.n184 585
R134 VGND.n183 VGND.n179 585
R135 VGND.n181 VGND.n180 585
R136 VGND.n174 VGND.n173 585
R137 VGND.n175 VGND.n174 585
R138 VGND.n197 VGND.n196 585
R139 VGND.n196 VGND.n195 585
R140 VGND.n198 VGND.n151 585
R141 VGND.n151 VGND.n149 585
R142 VGND.n199 VGND 585
R143 VGND.t2 VGND.n199 585
R144 VGND.n167 VGND.n150 585
R145 VGND.n150 VGND.n143 585
R146 VGND.n166 VGND.n142 585
R147 VGND.n205 VGND.n142 585
R148 VGND.n165 VGND.n164 585
R149 VGND.n163 VGND.n162 585
R150 VGND.n161 VGND.n160 585
R151 VGND.n159 VGND.n158 585
R152 VGND.n157 VGND.n156 585
R153 VGND.n155 VGND.n154 585
R154 VGND.n153 VGND.n152 585
R155 VGND.n146 VGND.n144 585
R156 VGND.n204 VGND.n203 585
R157 VGND.n205 VGND.n204 585
R158 VGND.n202 VGND.n145 585
R159 VGND.n145 VGND.n143 585
R160 VGND.n201 VGND.n200 585
R161 VGND.n200 VGND.t2 585
R162 VGND.n148 VGND.n147 585
R163 VGND.n149 VGND.n148 585
R164 VGND.n194 VGND.n193 585
R165 VGND.n195 VGND.n194 585
R166 VGND.n46 VGND.n26 585
R167 VGND.n45 VGND.n44 585
R168 VGND.n28 VGND.n27 585
R169 VGND.n40 VGND.n39 585
R170 VGND.n38 VGND.n31 585
R171 VGND.n37 VGND.n36 585
R172 VGND.n35 VGND.n34 585
R173 VGND.n33 VGND.n32 585
R174 VGND.n24 VGND.n23 585
R175 VGND.n25 VGND.n24 585
R176 VGND.n52 VGND.n51 585
R177 VGND.n51 VGND.n50 585
R178 VGND.n53 VGND.n22 585
R179 VGND.n22 VGND.t1 585
R180 VGND.n55 VGND.n54 585
R181 VGND.n56 VGND.n55 585
R182 VGND.n21 VGND.n20 585
R183 VGND.n20 VGND.n14 585
R184 VGND.n72 VGND.n71 585
R185 VGND.n70 VGND.n19 585
R186 VGND.n69 VGND.n18 585
R187 VGND.n74 VGND.n18 585
R188 VGND.n68 VGND.n67 585
R189 VGND.n66 VGND.n65 585
R190 VGND.n64 VGND.n63 585
R191 VGND.n62 VGND.n61 585
R192 VGND.n60 VGND.n17 585
R193 VGND.n74 VGND.n17 585
R194 VGND.n59 VGND.n58 585
R195 VGND.n58 VGND.n14 585
R196 VGND.n57 VGND.n2 585
R197 VGND.n57 VGND.n56 585
R198 VGND VGND.n1 585
R199 VGND.t1 VGND.n1 585
R200 VGND.n49 VGND.n0 585
R201 VGND.n50 VGND.n49 585
R202 VGND.n48 VGND.n47 585
R203 VGND.n48 VGND.n25 585
R204 VGND.n204 VGND.n145 394
R205 VGND.n200 VGND.n145 394
R206 VGND.n200 VGND.n148 394
R207 VGND.n194 VGND.n148 394
R208 VGND.n154 VGND.n153 394
R209 VGND.n158 VGND.n157 394
R210 VGND.n162 VGND.n161 394
R211 VGND.n150 VGND.n142 394
R212 VGND.n199 VGND.n150 394
R213 VGND.n199 VGND.n151 394
R214 VGND.n196 VGND.n151 394
R215 VGND.n190 VGND.n188 394
R216 VGND.n188 VGND.n187 394
R217 VGND.n184 VGND.n183 394
R218 VGND.n181 VGND.n174 394
R219 VGND.n236 VGND.n113 394
R220 VGND.n232 VGND.n113 394
R221 VGND.n232 VGND.n116 394
R222 VGND.n226 VGND.n116 394
R223 VGND.n122 VGND.n121 394
R224 VGND.n126 VGND.n125 394
R225 VGND.n130 VGND.n129 394
R226 VGND.n118 VGND.n110 394
R227 VGND.n231 VGND.n118 394
R228 VGND.n231 VGND.n119 394
R229 VGND.n228 VGND.n119 394
R230 VGND.n222 VGND.n220 394
R231 VGND.n220 VGND.n219 394
R232 VGND.n216 VGND.n215 394
R233 VGND.n213 VGND.n137 394
R234 VGND.n97 VGND.n10 394
R235 VGND.n260 VGND.n10 394
R236 VGND.n260 VGND.n11 394
R237 VGND.n256 VGND.n11 394
R238 VGND.n83 VGND.n81 394
R239 VGND.n87 VGND.n78 394
R240 VGND.n91 VGND.n89 394
R241 VGND.n95 VGND.n6 394
R242 VGND.n261 VGND.n6 394
R243 VGND.n261 VGND.n7 394
R244 VGND.n102 VGND.n7 394
R245 VGND.n252 VGND.n239 394
R246 VGND.n248 VGND.n239 394
R247 VGND.n246 VGND.n245 394
R248 VGND.n242 VGND.n105 394
R249 VGND.n51 VGND.n24 394
R250 VGND.n51 VGND.n22 394
R251 VGND.n55 VGND.n22 394
R252 VGND.n55 VGND.n20 394
R253 VGND.n19 VGND.n18 394
R254 VGND.n67 VGND.n18 394
R255 VGND.n65 VGND.n64 394
R256 VGND.n61 VGND.n17 394
R257 VGND.n49 VGND.n48 394
R258 VGND.n49 VGND.n1 394
R259 VGND.n57 VGND.n1 394
R260 VGND.n58 VGND.n57 394
R261 VGND.n36 VGND.n35 394
R262 VGND.n40 VGND.n31 394
R263 VGND.n44 VGND.n28 394
R264 VGND.n254 VGND.n253 218.815
R265 VGND.n254 VGND.n103 218.815
R266 VGND.n254 VGND.n104 218.815
R267 VGND.n90 VGND.n75 218.815
R268 VGND.n88 VGND.n75 218.815
R269 VGND.n82 VGND.n75 218.815
R270 VGND.n80 VGND.n75 218.815
R271 VGND.n221 VGND.n207 218.815
R272 VGND.n210 VGND.n207 218.815
R273 VGND.n214 VGND.n207 218.815
R274 VGND.n238 VGND.n109 218.815
R275 VGND.n238 VGND.n108 218.815
R276 VGND.n238 VGND.n107 218.815
R277 VGND.n238 VGND.n106 218.815
R278 VGND.n189 VGND.n175 218.815
R279 VGND.n178 VGND.n175 218.815
R280 VGND.n182 VGND.n175 218.815
R281 VGND.n206 VGND.n141 218.815
R282 VGND.n206 VGND.n140 218.815
R283 VGND.n206 VGND.n139 218.815
R284 VGND.n206 VGND.n138 218.815
R285 VGND.n43 VGND.n42 218.815
R286 VGND.n42 VGND.n41 218.815
R287 VGND.n42 VGND.n30 218.815
R288 VGND.n42 VGND.n29 218.815
R289 VGND.n74 VGND.n73 218.815
R290 VGND.n74 VGND.n15 218.815
R291 VGND.n74 VGND.n16 218.815
R292 VGND.t3 VGND.n168 181.41
R293 VGND.n264 VGND.t5 181.41
R294 VGND.n169 VGND.t3 174.912
R295 VGND.t5 VGND.n263 174.912
R296 VGND.n42 VGND.n25 167.07
R297 VGND.n74 VGND.n14 167.07
R298 VGND.n96 VGND.n75 167.07
R299 VGND.n255 VGND.n254 167.07
R300 VGND.n238 VGND.n237 167.07
R301 VGND.n227 VGND.n207 167.07
R302 VGND.n206 VGND.n205 167.07
R303 VGND.n195 VGND.n175 167.07
R304 VGND.n153 VGND.n138 147.374
R305 VGND.n157 VGND.n139 147.374
R306 VGND.n161 VGND.n140 147.374
R307 VGND.n164 VGND.n141 147.374
R308 VGND.n189 VGND.n176 147.374
R309 VGND.n187 VGND.n178 147.374
R310 VGND.n183 VGND.n182 147.374
R311 VGND.n121 VGND.n106 147.374
R312 VGND.n125 VGND.n107 147.374
R313 VGND.n129 VGND.n108 147.374
R314 VGND.n132 VGND.n109 147.374
R315 VGND.n221 VGND.n208 147.374
R316 VGND.n219 VGND.n210 147.374
R317 VGND.n215 VGND.n214 147.374
R318 VGND.n81 VGND.n80 147.374
R319 VGND.n82 VGND.n78 147.374
R320 VGND.n89 VGND.n88 147.374
R321 VGND.n90 VGND.n76 147.374
R322 VGND.n253 VGND.n101 147.374
R323 VGND.n248 VGND.n103 147.374
R324 VGND.n245 VGND.n104 147.374
R325 VGND.n253 VGND.n252 147.374
R326 VGND.n246 VGND.n103 147.374
R327 VGND.n242 VGND.n104 147.374
R328 VGND.n91 VGND.n90 147.374
R329 VGND.n88 VGND.n87 147.374
R330 VGND.n83 VGND.n82 147.374
R331 VGND.n80 VGND.n13 147.374
R332 VGND.n222 VGND.n221 147.374
R333 VGND.n216 VGND.n210 147.374
R334 VGND.n214 VGND.n213 147.374
R335 VGND.n130 VGND.n109 147.374
R336 VGND.n126 VGND.n108 147.374
R337 VGND.n122 VGND.n107 147.374
R338 VGND.n112 VGND.n106 147.374
R339 VGND.n190 VGND.n189 147.374
R340 VGND.n184 VGND.n178 147.374
R341 VGND.n182 VGND.n181 147.374
R342 VGND.n162 VGND.n141 147.374
R343 VGND.n158 VGND.n140 147.374
R344 VGND.n154 VGND.n139 147.374
R345 VGND.n144 VGND.n138 147.374
R346 VGND.n73 VGND.n72 147.374
R347 VGND.n67 VGND.n15 147.374
R348 VGND.n64 VGND.n16 147.374
R349 VGND.n32 VGND.n29 147.374
R350 VGND.n36 VGND.n30 147.374
R351 VGND.n41 VGND.n40 147.374
R352 VGND.n44 VGND.n43 147.374
R353 VGND.n43 VGND.n26 147.374
R354 VGND.n41 VGND.n28 147.374
R355 VGND.n31 VGND.n30 147.374
R356 VGND.n35 VGND.n29 147.374
R357 VGND.n73 VGND.n19 147.374
R358 VGND.n65 VGND.n15 147.374
R359 VGND.n61 VGND.n16 147.374
R360 VGND.n50 VGND.n25 106.175
R361 VGND.n50 VGND.t1 106.175
R362 VGND.n56 VGND.t1 106.175
R363 VGND.n56 VGND.n14 106.175
R364 VGND.n96 VGND.n8 106.175
R365 VGND.t4 VGND.n8 106.175
R366 VGND.t4 VGND.n9 106.175
R367 VGND.n255 VGND.n9 106.175
R368 VGND.n237 VGND.n111 106.175
R369 VGND.t0 VGND.n111 106.175
R370 VGND.t0 VGND.n117 106.175
R371 VGND.n227 VGND.n117 106.175
R372 VGND.n205 VGND.n143 106.175
R373 VGND.t2 VGND.n143 106.175
R374 VGND.t2 VGND.n149 106.175
R375 VGND.n195 VGND.n149 106.175
R376 VGND.n203 VGND.n146 78.6829
R377 VGND.n193 VGND.n192 78.6829
R378 VGND.n166 VGND.n165 78.6829
R379 VGND.n197 VGND.n173 78.6829
R380 VGND.n235 VGND.n114 78.6829
R381 VGND.n225 VGND.n224 78.6829
R382 VGND.n134 VGND.n133 78.6829
R383 VGND.n229 VGND.n136 78.6829
R384 VGND.n98 VGND.n12 78.6829
R385 VGND.n257 VGND.n100 78.6829
R386 VGND.n94 VGND.n93 78.6829
R387 VGND.n241 VGND.n240 78.6829
R388 VGND.n33 VGND.n23 78.6829
R389 VGND.n47 VGND.n46 78.6829
R390 VGND.n71 VGND.n21 78.6829
R391 VGND.n60 VGND.n59 78.6829
R392 VGND.n203 VGND.n202 25.6005
R393 VGND.n202 VGND.n201 25.6005
R394 VGND.n201 VGND.n147 25.6005
R395 VGND.n193 VGND.n147 25.6005
R396 VGND.n152 VGND.n146 25.6005
R397 VGND.n155 VGND.n152 25.6005
R398 VGND.n156 VGND.n155 25.6005
R399 VGND.n159 VGND.n156 25.6005
R400 VGND.n160 VGND.n159 25.6005
R401 VGND.n163 VGND.n160 25.6005
R402 VGND.n165 VGND.n163 25.6005
R403 VGND.n167 VGND.n166 25.6005
R404 VGND VGND.n167 25.6005
R405 VGND VGND.n198 25.6005
R406 VGND.n198 VGND.n197 25.6005
R407 VGND.n192 VGND.n191 25.6005
R408 VGND.n191 VGND.n177 25.6005
R409 VGND.n186 VGND.n177 25.6005
R410 VGND.n186 VGND.n185 25.6005
R411 VGND.n185 VGND.n179 25.6005
R412 VGND.n180 VGND.n179 25.6005
R413 VGND.n180 VGND.n173 25.6005
R414 VGND.n235 VGND.n234 25.6005
R415 VGND.n234 VGND.n233 25.6005
R416 VGND.n233 VGND.n115 25.6005
R417 VGND.n225 VGND.n115 25.6005
R418 VGND.n120 VGND.n114 25.6005
R419 VGND.n123 VGND.n120 25.6005
R420 VGND.n124 VGND.n123 25.6005
R421 VGND.n127 VGND.n124 25.6005
R422 VGND.n128 VGND.n127 25.6005
R423 VGND.n131 VGND.n128 25.6005
R424 VGND.n133 VGND.n131 25.6005
R425 VGND.n135 VGND.n134 25.6005
R426 VGND VGND.n135 25.6005
R427 VGND VGND.n230 25.6005
R428 VGND.n230 VGND.n229 25.6005
R429 VGND.n224 VGND.n223 25.6005
R430 VGND.n223 VGND.n209 25.6005
R431 VGND.n218 VGND.n209 25.6005
R432 VGND.n218 VGND.n217 25.6005
R433 VGND.n217 VGND.n211 25.6005
R434 VGND.n212 VGND.n211 25.6005
R435 VGND.n212 VGND.n136 25.6005
R436 VGND.n99 VGND.n98 25.6005
R437 VGND.n259 VGND.n99 25.6005
R438 VGND.n259 VGND.n258 25.6005
R439 VGND.n258 VGND.n257 25.6005
R440 VGND.n79 VGND.n12 25.6005
R441 VGND.n84 VGND.n79 25.6005
R442 VGND.n85 VGND.n84 25.6005
R443 VGND.n86 VGND.n85 25.6005
R444 VGND.n86 VGND.n77 25.6005
R445 VGND.n92 VGND.n77 25.6005
R446 VGND.n93 VGND.n92 25.6005
R447 VGND.n94 VGND.n4 25.6005
R448 VGND VGND.n4 25.6005
R449 VGND VGND.n5 25.6005
R450 VGND.n240 VGND.n5 25.6005
R451 VGND.n251 VGND.n100 25.6005
R452 VGND.n251 VGND.n250 25.6005
R453 VGND.n250 VGND.n249 25.6005
R454 VGND.n249 VGND.n247 25.6005
R455 VGND.n247 VGND.n244 25.6005
R456 VGND.n244 VGND.n243 25.6005
R457 VGND.n243 VGND.n241 25.6005
R458 VGND.n34 VGND.n33 25.6005
R459 VGND.n37 VGND.n34 25.6005
R460 VGND.n38 VGND.n37 25.6005
R461 VGND.n39 VGND.n38 25.6005
R462 VGND.n39 VGND.n27 25.6005
R463 VGND.n45 VGND.n27 25.6005
R464 VGND.n46 VGND.n45 25.6005
R465 VGND.n52 VGND.n23 25.6005
R466 VGND.n53 VGND.n52 25.6005
R467 VGND.n54 VGND.n53 25.6005
R468 VGND.n54 VGND.n21 25.6005
R469 VGND.n71 VGND.n70 25.6005
R470 VGND.n70 VGND.n69 25.6005
R471 VGND.n69 VGND.n68 25.6005
R472 VGND.n68 VGND.n66 25.6005
R473 VGND.n66 VGND.n63 25.6005
R474 VGND.n63 VGND.n62 25.6005
R475 VGND.n62 VGND.n60 25.6005
R476 VGND.n47 VGND.n0 25.6005
R477 VGND VGND.n0 25.6005
R478 VGND VGND.n2 25.6005
R479 VGND.n59 VGND.n2 25.6005
R480 VGND VGND.n263 19.837
R481 VGND.n169 VGND 19.837
R482 VGND VGND.n266 19.0947
R483 VGND VGND.n172 18.3251
R484 VGND VGND.n3 18.3251
R485 VGND.n262 VGND 18.3251
R486 VGND.n265 VGND.n263 14.1895
R487 VGND.n170 VGND.n169 14.1895
R488 VGND.n266 VGND.n265 9.92259
R489 VGND.n171 VGND.n170 9.92259
R490 VGND.n264 VGND 4.259
R491 VGND VGND.n168 4.259
R492 VGND.n265 VGND.n264 3.04672
R493 VGND.n170 VGND.n168 3.04672
R494 VGND.n262 VGND.n3 0.911125
R495 VGND.n171 VGND.n3 0.770125
R496 VGND.n172 VGND 0.397062
R497 VGND.n172 VGND.n171 0.12975
R498 VGND.n266 VGND.n262 0.12975
R499 LOW_REF.n2 LOW_REF.t2 181.41
R500 LOW_REF.n7 LOW_REF.t0 181.41
R501 LOW_REF.t2 LOW_REF.n1 174.912
R502 LOW_REF.t0 LOW_REF.n0 174.912
R503 LOW_REF LOW_REF.t1 139.911
R504 LOW_REF LOW_REF.t3 139.911
R505 LOW_REF.n5 LOW_REF 28.2302
R506 LOW_REF.n4 LOW_REF 27.1968
R507 LOW_REF LOW_REF.n1 19.837
R508 LOW_REF LOW_REF.n0 19.837
R509 LOW_REF.n3 LOW_REF.n1 14.1895
R510 LOW_REF.n6 LOW_REF.n0 14.1895
R511 LOW_REF.n4 LOW_REF.n3 11.149
R512 LOW_REF.n6 LOW_REF.n5 10.7559
R513 LOW_REF.n2 LOW_REF 4.259
R514 LOW_REF LOW_REF.n7 4.259
R515 LOW_REF.n3 LOW_REF.n2 3.04672
R516 LOW_REF.n7 LOW_REF.n6 3.04672
R517 LOW_REF.n5 LOW_REF.n4 0.788338
C6 OUT VGND 1.84075f
C7 REF VGND 4.02907f
C8 LOW_OUT VGND 2.34261f $ **FLOATING
C9 LOW_REF VGND 5.37345f $ **FLOATING
C10 LOW_REF.n0 VGND 0.0115f $ **FLOATING
C11 LOW_REF.t0 VGND 0.01873f $ **FLOATING
C12 LOW_REF.t3 VGND 0.2198f $ **FLOATING
C13 LOW_REF.n1 VGND 0.0115f $ **FLOATING
C14 LOW_REF.t2 VGND 0.01873f $ **FLOATING
C15 LOW_REF.n2 VGND 0.01109f $ **FLOATING
C16 LOW_REF.n3 VGND 0.1779f $ **FLOATING
C17 LOW_REF.t1 VGND 0.2198f $ **FLOATING
C18 LOW_REF.n4 VGND 0.52791f $ **FLOATING
C19 LOW_REF.n5 VGND 0.69946f $ **FLOATING
C20 LOW_REF.n6 VGND 0.17121f $ **FLOATING
C21 LOW_REF.n7 VGND 0.01109f $ **FLOATING
C22 REF.t2 VGND 0.23285f $ **FLOATING
C23 REF.n0 VGND 0.01174f $ **FLOATING
C24 REF.t1 VGND 0.01985f $ **FLOATING
C25 REF.n1 VGND 0.01218f $ **FLOATING
C26 REF.n2 VGND 0.1648f $ **FLOATING
C27 REF.n3 VGND 0.3476f $ **FLOATING
C28 REF.t0 VGND 0.23285f $ **FLOATING
C29 REF.n4 VGND 0.89658f $ **FLOATING
.ends

.subckt soc_cascode_mirror REF OUT VGND
XN_OUT LOW_OUT LOW_REF VGND VGND sky130_fd_pr__nfet_01v8 w=2 l=1 nf=1 m=1
XN_OUT_CAS OUT REF LOW_OUT VGND sky130_fd_pr__nfet_01v8 w=2 l=1 nf=1 m=1
XN_REF LOW_REF LOW_REF VGND VGND sky130_fd_pr__nfet_01v8 w=2 l=1 nf=1 m=1
XN_REF_CAS REF REF LOW_REF VGND sky130_fd_pr__nfet_01v8 w=2 l=1 nf=1 m=1
.ends soc_cascode_mirror

.subckt SOC_OTA_FIRST INP INN BIAS OUT VPWR VGND
XN_INN MIR INN TAIL VGND sky130_fd_pr__nfet_01v8 w=10 l=1 nf=1 m=1
XN_INP OUT INP TAIL VGND sky130_fd_pr__nfet_01v8 w=10 l=1 nf=1 m=1
XN_TAIL TAIL BIAS VGND VGND sky130_fd_pr__nfet_01v8 w=2 l=1 nf=1 m=1
XP_DIODE MIR MIR VPWR VPWR sky130_fd_pr__pfet_01v8_hvt w=20 l=1 nf=1 m=1
XP_MIRROR OUT MIR VPWR VPWR sky130_fd_pr__pfet_01v8_hvt w=20 l=1 nf=1 m=1
.ends SOC_OTA_FIRST
.subckt SOC_OTA INP INN BIAS OUT VPWR VGND
CC_MILLER PRE COMP 5e-12
XFIRST INP INN BIAS PRE VPWR VGND SOC_OTA_FIRST
XN_SECOND OUT BIAS VGND VGND sky130_fd_pr__nfet_01v8 w=2 l=1 nf=1 m=1
XP_SECOND OUT PRE VPWR VPWR sky130_fd_pr__pfet_01v8_hvt w=40 l=1 nf=1 m=1
RR_ZERO COMP OUT 5000
.ends SOC_OTA
.subckt soc_bias BIAS VCM VPWR VGND
CC_VCM VCM_RAW VGND 2e-11
XN_DIODE BIAS BIAS VGND VGND sky130_fd_pr__nfet_01v8 w=2 l=1 nf=1 m=1
RR_BIAS VPWR BIAS 30000
RR_VCM_BOTTOM VCM_RAW VGND 100000
RR_VCM_TOP VPWR VCM_RAW 100000
XVCM_BUFFER VCM_RAW VCM BIAS VCM VPWR VGND SOC_OTA
.ends soc_bias

* NGSPICE file created from soc_bias.ext - technology: sky130A

.subckt soc_bias VPWR VGND VCM BIAS
X0 VCM_BUFFER__FIRST__TAIL.t0 VCM.t3 VCM_BUFFER__FIRST__MIR.t2 VGND.t8 sky130_fd_pr__nfet_01v8 ad=2.9 pd=20.58 as=2.9 ps=20.58 w=10 l=1
X1 VCM_RAW.t2 VGND.t5 sky130_fd_pr__cap_mim_m3_1 l=28.68 w=28.68
X2 VGND.t27 BIAS.t3 VCM_BUFFER__FIRST__TAIL.t2 VGND.t26 sky130_fd_pr__nfet_01v8 ad=0.58 pd=4.58 as=0.58 ps=4.58 w=2 l=1
X3 VCM_RAW.t0 R_VCM_BOTTOM_R0_N0.t0 VGND.t0 sky130_fd_pr__res_xhigh_po_1p41 l=23.34
X4 VPWR VCM_BUFFER__PRE.t2 VCM.t2 VPWR sky130_fd_pr__pfet_01v8_hvt ad=11.6 pd=80.58 as=11.6 ps=80.58 w=40 l=1
X5 VCM_RAW.t3 VGND.t19 sky130_fd_pr__cap_mim_m3_1 l=28.68 w=28.68
X6 R_VCM_BOTTOM_R0_N0.t1 R_VCM_BOTTOM_R0_N1.t1 VGND.t18 sky130_fd_pr__res_xhigh_po_1p41 l=23.34
X7 VCM_RAW.t4 VGND.t23 sky130_fd_pr__cap_mim_m3_1 l=28.68 w=28.68
X8 VCM_RAW.t5 VGND.t28 sky130_fd_pr__cap_mim_m3_1 l=28.68 w=28.68
X9 VCM_BUFFER__COMP.t3 VCM.t1 VGND.t7 sky130_fd_pr__res_xhigh_po_1p41 l=3.36
X10 VCM_BUFFER__PRE.t3 VCM_BUFFER__COMP.t2 sky130_fd_pr__cap_mim_m3_1 l=28.68 w=28.68
X11 R_VCM_BOTTOM_R0_N1.t0 VGND.t17 VGND.t16 sky130_fd_pr__res_xhigh_po_1p41 l=23.34
X12 VPWR VCM_BUFFER__FIRST__MIR.t0 VCM_BUFFER__FIRST__MIR.t1 VPWR sky130_fd_pr__pfet_01v8_hvt ad=5.8 pd=40.58 as=5.8 ps=40.58 w=20 l=1
X13 VCM_RAW.t6 VGND.t4 sky130_fd_pr__cap_mim_m3_1 l=28.68 w=28.68
X14 VPWR VCM_BUFFER__FIRST__MIR.t3 VCM_BUFFER__PRE.t0 VPWR sky130_fd_pr__pfet_01v8_hvt ad=5.8 pd=40.58 as=5.8 ps=40.58 w=20 l=1
X15 R_VCM_TOP_R0_N1.t0 VCM_RAW.t1 VGND.t9 sky130_fd_pr__res_xhigh_po_1p41 l=23.34
X16 VGND.t3 BIAS.t4 VCM.t0 VGND.t2 sky130_fd_pr__nfet_01v8 ad=0.58 pd=4.58 as=0.58 ps=4.58 w=2 l=1
X17 VCM_RAW.t7 VGND.t6 sky130_fd_pr__cap_mim_m3_1 l=28.68 w=28.68
X18 VCM_BUFFER__FIRST__TAIL.t1 VCM_RAW.t8 VCM_BUFFER__PRE.t1 VGND.t22 sky130_fd_pr__nfet_01v8 ad=2.9 pd=20.58 as=2.9 ps=20.58 w=10 l=1
X19 VCM_RAW.t9 VGND.t10 sky130_fd_pr__cap_mim_m3_1 l=28.68 w=28.68
X20 VCM_BUFFER__PRE.t4 VCM_BUFFER__COMP.t1 sky130_fd_pr__cap_mim_m3_1 l=28.68 w=28.68
X21 VPWR R_VCM_TOP_R0_N0.t0 VGND.t1 sky130_fd_pr__res_xhigh_po_1p41 l=23.34
X22 R_VCM_TOP_R0_N0.t1 R_VCM_TOP_R0_N1.t1 VGND.t15 sky130_fd_pr__res_xhigh_po_1p41 l=23.34
X23 VCM_RAW.t10 VGND.t20 sky130_fd_pr__cap_mim_m3_1 l=28.68 w=28.68
X24 VPWR BIAS.t2 VGND.t13 sky130_fd_pr__res_xhigh_po_1p41 l=20.99
X25 VCM_RAW.t11 VGND.t25 sky130_fd_pr__cap_mim_m3_1 l=28.68 w=28.68
X26 VGND.t12 BIAS.t0 BIAS.t1 VGND.t11 sky130_fd_pr__nfet_01v8 ad=0.58 pd=4.58 as=0.58 ps=4.58 w=2 l=1
X27 VCM_RAW.t12 VGND.t14 sky130_fd_pr__cap_mim_m3_1 l=28.68 w=28.68
X28 VCM_BUFFER__PRE.t5 VCM_BUFFER__COMP.t0 sky130_fd_pr__cap_mim_m3_1 l=28.68 w=28.68
X29 VCM_RAW.t13 VGND.t24 sky130_fd_pr__cap_mim_m3_1 l=28.68 w=28.68
X30 VCM_RAW.t14 VGND.t21 sky130_fd_pr__cap_mim_m3_1 l=28.68 w=28.68
C0 VCM VCM_RAW 29.7685f
C1 VPWR VCM 7.9147f
C2 VCM_BUFFER__PRE VCM_BUFFER__FIRST__MIR 2.15206f
C3 VCM_BUFFER__FIRST__MIR VCM_BUFFER__FIRST__TAIL 1.05931f
C4 BIAS VCM 34.0961f
C5 VCM_RAW VCM_BUFFER__FIRST__MIR 0.25537f
C6 VPWR VCM_BUFFER__FIRST__MIR 9.56069f
C7 BIAS VCM_BUFFER__FIRST__MIR 0.31227f
C8 VCM VCM_BUFFER__FIRST__MIR 2.06297f
C9 VCM_BUFFER__PRE VCM_BUFFER__FIRST__TAIL 2.61198f
C10 VCM_RAW VCM_BUFFER__PRE 0.64147f
C11 VPWR VCM_BUFFER__PRE 8.04575f
C12 VCM_RAW VCM_BUFFER__FIRST__TAIL 1.55113f
C13 VPWR VCM_BUFFER__FIRST__TAIL 0.44878f
C14 BIAS VCM_BUFFER__PRE 0.26532f
C15 BIAS VCM_BUFFER__FIRST__TAIL 0.2835f
C16 VPWR VCM_RAW 0.00358f
C17 VCM VCM_BUFFER__PRE 5.50689f
C18 VCM VCM_BUFFER__FIRST__TAIL 1.62875f
C19 BIAS VCM_RAW 1.48015f
C20 VPWR BIAS 0.92414f
C21 VCM VGND 52.08488f
C22 BIAS VGND 47.96096f
C23 VPWR VGND 0.1055p
C24 VCM_BUFFER__FIRST__TAIL VGND 12.04112f $ **FLOATING
C25 VCM_BUFFER__FIRST__MIR VGND 9.31251f $ **FLOATING
C26 VCM_RAW VGND 0.96163p $ **FLOATING
C27 VCM_BUFFER__PRE VGND 0.13935p $ **FLOATING
C28 VCM_BUFFER__COMP.t3 VGND 0.6411f $ **FLOATING
C29 VCM_BUFFER__COMP.t1 VGND 72.9234f $ **FLOATING
C30 VCM_BUFFER__COMP.n0 VGND 1.64705f $ **FLOATING
C31 VCM_BUFFER__COMP.t0 VGND 73.2929f $ **FLOATING
C32 VCM_BUFFER__COMP.n1 VGND 1.66572f $ **FLOATING
C33 VCM_BUFFER__COMP.t2 VGND 52.5193f $ **FLOATING
C34 VCM_BUFFER__COMP.n2 VGND 68.6182f $ **FLOATING
C35 VCM_BUFFER__PRE.n0 VGND 0.01275f $ **FLOATING
C36 VCM_BUFFER__PRE.t0 VGND 0.01527f $ **FLOATING
C37 VCM_BUFFER__PRE.t4 VGND 38.6753f $ **FLOATING
C38 VCM_BUFFER__PRE.t3 VGND 38.6753f $ **FLOATING
C39 VCM_BUFFER__PRE.n1 VGND 1.00216f $ **FLOATING
C40 VCM_BUFFER__PRE.t5 VGND 38.6753f $ **FLOATING
C41 VCM_BUFFER__PRE.n2 VGND 0.68515f $ **FLOATING
C42 VCM_BUFFER__PRE.t2 VGND 1.48372f $ **FLOATING
C43 VCM_BUFFER__PRE.n3 VGND 0.55132f $ **FLOATING
C44 VCM_BUFFER__PRE.n4 VGND 0.00621f $ **FLOATING
C45 VCM_BUFFER__PRE.t1 VGND 0.03409f $ **FLOATING
C46 VCM_BUFFER__PRE.n5 VGND 0.11628f $ **FLOATING
C47 VCM_BUFFER__PRE.n6 VGND 0.02052f $ **FLOATING
C48 VCM_BUFFER__PRE.n7 VGND 0.43026f $ **FLOATING
C49 VCM_BUFFER__PRE.n8 VGND 1.07824f $ **FLOATING
C50 VCM_BUFFER__PRE.n9 VGND 0.82715f $ **FLOATING
C51 VCM_BUFFER__PRE.n10 VGND 0.01255f $ **FLOATING
C52 BIAS.t4 VGND 0.32307f $ **FLOATING
C53 BIAS.n0 VGND 0.01629f $ **FLOATING
C54 BIAS.t1 VGND 0.02754f $ **FLOATING
C55 BIAS.n1 VGND 0.0169f $ **FLOATING
C56 BIAS.n2 VGND 0.58622f $ **FLOATING
C57 BIAS.n3 VGND 0.70592f $ **FLOATING
C58 BIAS.t0 VGND 0.32307f $ **FLOATING
C59 BIAS.n4 VGND 1.04433f $ **FLOATING
C60 BIAS.t2 VGND 1.23466f $ **FLOATING
C61 BIAS.n5 VGND 13.8566f $ **FLOATING
C62 BIAS.t3 VGND 0.32307f $ **FLOATING
C63 BIAS.n6 VGND 14.5802f $ **FLOATING
C64 VCM_RAW.t8 VGND 0.01342f $ **FLOATING
C65 VCM_RAW.t1 VGND 0.01688f $ **FLOATING
C66 VCM_RAW.t0 VGND 0.00979f $ **FLOATING
C67 VCM_RAW.n0 VGND 0.0442f $ **FLOATING
C68 VCM_RAW.t13 VGND 1.23841f $ **FLOATING
C69 VCM_RAW.n1 VGND 0.02523f $ **FLOATING
C70 VCM_RAW.t11 VGND 1.23841f $ **FLOATING
C71 VCM_RAW.n2 VGND 0.02443f $ **FLOATING
C72 VCM_RAW.t5 VGND 1.23841f $ **FLOATING
C73 VCM_RAW.n3 VGND 0.02443f $ **FLOATING
C74 VCM_RAW.t9 VGND 1.23841f $ **FLOATING
C75 VCM_RAW.n4 VGND 0.02443f $ **FLOATING
C76 VCM_RAW.t2 VGND 1.23841f $ **FLOATING
C77 VCM_RAW.n5 VGND 0.02443f $ **FLOATING
C78 VCM_RAW.t12 VGND 1.23841f $ **FLOATING
C79 VCM_RAW.n6 VGND 0.02443f $ **FLOATING
C80 VCM_RAW.t3 VGND 1.23841f $ **FLOATING
C81 VCM_RAW.n7 VGND 0.02443f $ **FLOATING
C82 VCM_RAW.t7 VGND 1.23841f $ **FLOATING
C83 VCM_RAW.n8 VGND 0.02443f $ **FLOATING
C84 VCM_RAW.t14 VGND 1.23841f $ **FLOATING
C85 VCM_RAW.n9 VGND 0.02443f $ **FLOATING
C86 VCM_RAW.t6 VGND 1.23841f $ **FLOATING
C87 VCM_RAW.n10 VGND 0.02443f $ **FLOATING
C88 VCM_RAW.t10 VGND 1.23841f $ **FLOATING
C89 VCM_RAW.n11 VGND 0.02443f $ **FLOATING
C90 VCM_RAW.t4 VGND 1.23841f $ **FLOATING
C91 VCM_RAW.n12 VGND 0.03678f $ **FLOATING
C92 VCM_BUFFER__FIRST__TAIL.n0 VGND 0.00584f $ **FLOATING
C93 VCM_BUFFER__FIRST__TAIL.n1 VGND 0.00626f $ **FLOATING
C94 VCM_BUFFER__FIRST__TAIL.t2 VGND 0.0102f $ **FLOATING
C95 VCM_BUFFER__FIRST__TAIL.n2 VGND 0.00604f $ **FLOATING
C96 VCM_BUFFER__FIRST__TAIL.n3 VGND 0.30728f $ **FLOATING
C97 VCM_BUFFER__FIRST__TAIL.n4 VGND 0.01817f $ **FLOATING
C98 VCM_BUFFER__FIRST__TAIL.t1 VGND 0.03204f $ **FLOATING
C99 VCM_BUFFER__FIRST__TAIL.n5 VGND 0.10928f $ **FLOATING
C100 VCM_BUFFER__FIRST__TAIL.n6 VGND 0.00695f $ **FLOATING
C101 VCM_BUFFER__FIRST__TAIL.n7 VGND 0.36776f $ **FLOATING
C102 VCM_BUFFER__FIRST__TAIL.n8 VGND 1.2069f $ **FLOATING
C103 VCM_BUFFER__FIRST__TAIL.n9 VGND 0.35235f $ **FLOATING
C104 VCM_BUFFER__FIRST__TAIL.t0 VGND 0.03204f $ **FLOATING
C105 VCM_BUFFER__FIRST__TAIL.n10 VGND 0.10928f $ **FLOATING
C106 VCM_BUFFER__FIRST__TAIL.n11 VGND 0.01929f $ **FLOATING
C107 VCM_BUFFER__FIRST__MIR.n0 VGND 0.0364f $ **FLOATING
C108 VCM_BUFFER__FIRST__MIR.t1 VGND 0.04361f $ **FLOATING
C109 VCM_BUFFER__FIRST__MIR.t3 VGND 2.21831f $ **FLOATING
C110 VCM_BUFFER__FIRST__MIR.t0 VGND 2.21831f $ **FLOATING
C111 VCM_BUFFER__FIRST__MIR.n1 VGND 1.8402f $ **FLOATING
C112 VCM_BUFFER__FIRST__MIR.n2 VGND 0.01775f $ **FLOATING
C113 VCM_BUFFER__FIRST__MIR.t2 VGND 0.09735f $ **FLOATING
C114 VCM_BUFFER__FIRST__MIR.n3 VGND 0.33207f $ **FLOATING
C115 VCM_BUFFER__FIRST__MIR.n4 VGND 0.0586f $ **FLOATING
C116 VCM_BUFFER__FIRST__MIR.n5 VGND 1.06119f $ **FLOATING
C117 VCM_BUFFER__FIRST__MIR.n6 VGND 1.8849f $ **FLOATING
C118 VCM_BUFFER__FIRST__MIR.n7 VGND 2.33428f $ **FLOATING
C119 VCM_BUFFER__FIRST__MIR.n8 VGND 0.03583f $ **FLOATING
C120 VCM.t1 VGND 4.82542f $ **FLOATING
C121 VCM.n0 VGND 0.03424f $ **FLOATING
C122 VCM.t0 VGND 0.05579f $ **FLOATING
C123 VCM.n1 VGND 0.03301f $ **FLOATING
C124 VCM.n2 VGND 1.23776f $ **FLOATING
C125 VCM.n3 VGND 12.7865f $ **FLOATING
C126 VCM.n4 VGND 0.7056f $ **FLOATING
C127 VCM.t2 VGND 0.70092f $ **FLOATING
C128 VCM.n5 VGND 3.05179f $ **FLOATING
C129 VCM.n6 VGND 0.27454f $ **FLOATING
C130 VCM.n7 VGND 2.95643f $ **FLOATING
C131 VCM.n8 VGND 2.95548f $ **FLOATING
C132 VCM.n9 VGND 27.1541f $ **FLOATING
C133 VCM.t3 VGND 2.15422f $ **FLOATING
rmesh_equiv_0 bias bias.n0 4.2590000000000003
rmesh_equiv_1 bias bias.n1 19.837
rmesh_equiv_10 bias.n1 bias.n2 14.189499999999999
rmesh_equiv_100 vcm_buffer__pre.n0 vcm_buffer__pre.n9 11.4361
rmesh_equiv_101 vcm_buffer__pre.n0 vcm_buffer__pre.t0 381.113
rmesh_equiv_102 vcm_buffer__pre.n1 vcm_buffer__pre.n2 4.1529499999999997
rmesh_equiv_103 vcm_buffer__pre.n10 vcm_buffer__pre.n9 2.4407800000000002
rmesh_equiv_104 vcm_buffer__pre.n10 vcm_buffer__pre.t0 387.11000000000001
rmesh_equiv_105 vcm_buffer__pre.n2 vcm_buffer__pre.n3 3.1113099999999996
rmesh_equiv_106 vcm_buffer__pre.n3 vcm_buffer__pre.n8 2.2512099999999999
rmesh_equiv_107 vcm_buffer__pre.n4 vcm_buffer__pre.n5 13.389300000000002
rmesh_equiv_108 vcm_buffer__pre.n4 vcm_buffer__pre.n7 0.75515399999999999
rmesh_equiv_109 vcm_buffer__pre.n5 vcm_buffer__pre.n6 14.121399999999998
rmesh_equiv_11 bias.n1 bias.t1 174.91200000000001
rmesh_equiv_110 vcm_buffer__pre.n5 vcm_buffer__pre.t1 1.7404999999999999
rmesh_equiv_111 vcm_buffer__pre.n6 vcm_buffer__pre.n7 1.13588
rmesh_equiv_112 vcm_buffer__pre.n7 vcm_buffer__pre.n8 20.5793
rmesh_equiv_113 vcm_buffer__pre.n8 vcm_buffer__pre.n9 17.804500000000001
rmesh_equiv_114 vcm_raw vcm_raw.n1 4.5902000000000003
rmesh_equiv_115 vcm_raw vcm_raw.n10 4.5902000000000003
rmesh_equiv_116 vcm_raw vcm_raw.n11 4.5902000000000003
rmesh_equiv_117 vcm_raw vcm_raw.n12 4.0622796157469585
rmesh_equiv_118 vcm_raw vcm_raw.n2 4.5902000000000003
rmesh_equiv_119 vcm_raw vcm_raw.n3 4.5902000000000003
rmesh_equiv_12 bias.n2 bias.n3 16.554500000000001
rmesh_equiv_120 vcm_raw vcm_raw.n4 4.5902000000000003
rmesh_equiv_121 vcm_raw vcm_raw.n5 4.5902000000000003
rmesh_equiv_122 vcm_raw vcm_raw.n6 4.5902000000000003
rmesh_equiv_123 vcm_raw vcm_raw.n7 4.5902000000000003
rmesh_equiv_124 vcm_raw vcm_raw.n8 4.5902000000000003
rmesh_equiv_125 vcm_raw vcm_raw.n9 4.5902000000000003
rmesh_equiv_126 vcm_raw vcm_raw.t10 0.00141837
rmesh_equiv_127 vcm_raw vcm_raw.t11 0.00141837
rmesh_equiv_128 vcm_raw vcm_raw.t12 0.00141837
rmesh_equiv_129 vcm_raw vcm_raw.t13 0.00141837
rmesh_equiv_13 bias.n3 bias.n4 0.39353700000000003
rmesh_equiv_130 vcm_raw vcm_raw.t14 0.00141837
rmesh_equiv_131 vcm_raw vcm_raw.t2 0.00141837
rmesh_equiv_132 vcm_raw vcm_raw.t3 0.00141837
rmesh_equiv_133 vcm_raw vcm_raw.t4 0.00141837
rmesh_equiv_134 vcm_raw vcm_raw.t5 0.00141837
rmesh_equiv_135 vcm_raw vcm_raw.t6 0.00141837
rmesh_equiv_136 vcm_raw vcm_raw.t7 0.00141837
rmesh_equiv_137 vcm_raw vcm_raw.t8 332.71199999999999
rmesh_equiv_138 vcm_raw vcm_raw.t9 0.00141837
rmesh_equiv_139 vcm_raw.n0 vcm_raw.n1 4.4643300000000004
rmesh_equiv_14 bias.n4 bias.n5 0.79479999999999995
rmesh_equiv_140 vcm_raw.n0 vcm_raw.t0 23.340499999999999
rmesh_equiv_141 vcm_raw.n0 vcm_raw.t1 33.454099999999997
rmesh_equiv_142 vcm_raw.n1 vcm_raw.n2 4.1529499999999997
rmesh_equiv_143 vcm_raw.n10 vcm_raw.n11 4.1529499999999997
rmesh_equiv_144 vcm_raw.n10 vcm_raw.n9 4.1529499999999997
rmesh_equiv_145 vcm_raw.n11 vcm_raw.n12 4.1529499999999997
rmesh_equiv_146 vcm_raw.n2 vcm_raw.n3 4.1529499999999997
rmesh_equiv_147 vcm_raw.n3 vcm_raw.n4 4.1529499999999997
rmesh_equiv_148 vcm_raw.n4 vcm_raw.n5 4.1529499999999997
rmesh_equiv_149 vcm_raw.n5 vcm_raw.n6 4.1529499999999997
rmesh_equiv_15 bias.n5 bias.n6 60.478900000000003
rmesh_equiv_150 vcm_raw.n6 vcm_raw.n7 4.1529499999999997
rmesh_equiv_151 vcm_raw.n7 vcm_raw.n8 4.1529499999999997
rmesh_equiv_152 vcm_raw.n8 vcm_raw.n9 4.1529499999999997
rmesh_equiv_153 vgnd vgnd.n1408 26406.414519288679
rmesh_equiv_154 vgnd vgnd.n1411 344.39788677439924
rmesh_equiv_155 vgnd vgnd.n184 20468.713182408905
rmesh_equiv_156 vgnd vgnd.n185 314.73007401223111
rmesh_equiv_157 vgnd vgnd.n281 14684.703893909062
rmesh_equiv_158 vgnd vgnd.n285 1906.2618614348219
rmesh_equiv_159 vgnd vgnd.n2897 207.54424708100061
rmesh_equiv_16 bias.n5 bias.t2 31.571200000000001
rmesh_equiv_160 vgnd vgnd.n3116 1895.8137562079241
rmesh_equiv_161 vgnd vgnd.n3118 1899.6794750081713
rmesh_equiv_162 vgnd vgnd.n3122 408.61204540839276
rmesh_equiv_163 vgnd vgnd.n3128 1113.4700950986694
rmesh_equiv_164 vgnd vgnd.n328 169.26347762818747
rmesh_equiv_165 vgnd vgnd.n330 8076.9525291074597
rmesh_equiv_166 vgnd vgnd.n3313 207.67553044254652
rmesh_equiv_167 vgnd vgnd.n332 164.35716309672193
rmesh_equiv_168 vgnd vgnd.n3611 608.56467861519116
rmesh_equiv_169 vgnd vgnd.n3615 6735.0405525862025
rmesh_equiv_17 r_vcm_bottom_r0_n0.t0 r_vcm_bottom_r0_n0.t1 47.8142
rmesh_equiv_170 vgnd vgnd.n3622 208.00022414399382
rmesh_equiv_171 vgnd vgnd.n364 1458.1035139476091
rmesh_equiv_172 vgnd vgnd.n366 2076.9932295808353
rmesh_equiv_173 vgnd vgnd.n434 133.00193677738596
rmesh_equiv_174 vgnd vgnd.n655 222.04157986086918
rmesh_equiv_175 vgnd vgnd.n659 116.91516453628688
rmesh_equiv_176 vgnd vgnd.t0 125.39484245654619
rmesh_equiv_177 vgnd vgnd.t1 200.85965561544171
rmesh_equiv_178 vgnd vgnd.t11 122.79277084363956
rmesh_equiv_179 vgnd vgnd.t12 93.474807630367678
rmesh_equiv_18 r_vcm_bottom_r0_n1.t0 r_vcm_bottom_r0_n1.t1 57.627400000000002
rmesh_equiv_180 vgnd vgnd.t13 131.29145401741116
rmesh_equiv_181 vgnd vgnd.t15 128.72758031489519
rmesh_equiv_182 vgnd vgnd.t16 202.17993378960688
rmesh_equiv_183 vgnd vgnd.t17 59.659963735446105
rmesh_equiv_184 vgnd vgnd.t18 130.53105715864626
rmesh_equiv_185 vgnd vgnd.t2 123.57191116617149
rmesh_equiv_186 vgnd vgnd.t20 41.76345773651137
rmesh_equiv_187 vgnd vgnd.t21 282.4351572849755
rmesh_equiv_188 vgnd vgnd.t22 298.66132014693142
rmesh_equiv_189 vgnd vgnd.t23 17.590688017671408
rmesh_equiv_19 r_vcm_top_r0_n0.t0 r_vcm_top_r0_n0.t1 46.980899999999998
rmesh_equiv_190 vgnd vgnd.t24 21.994290784348813
rmesh_equiv_191 vgnd vgnd.t25 53.376235316459649
rmesh_equiv_192 vgnd vgnd.t27 98.503847473787431
rmesh_equiv_193 vgnd vgnd.t28 148.71517715508887
rmesh_equiv_194 vgnd vgnd.t3 97.685035958818617
rmesh_equiv_195 vgnd vgnd.t4 101.37045663579258
rmesh_equiv_196 vgnd vgnd.t7 124.46149577956346
rmesh_equiv_197 vgnd vgnd.t8 201.46457635876345
rmesh_equiv_198 vgnd vgnd.t9 297.27498134458011
rmesh_equiv_199 vgnd.n1408 vgnd.n1411 23993.125196327492
rmesh_equiv_2 bias bias.n3 0.25606299999999999
rmesh_equiv_20 r_vcm_top_r0_n1.t0 r_vcm_top_r0_n1.t1 56.7941
rmesh_equiv_200 vgnd.n1408 vgnd.n3116 4001.7919961119474
rmesh_equiv_201 vgnd.n1408 vgnd.n3118 2020.2930039264036
rmesh_equiv_202 vgnd.n1408 vgnd.n3122 673.89926328459251
rmesh_equiv_203 vgnd.n1408 vgnd.n3128 384.89548078523745
rmesh_equiv_204 vgnd.n1408 vgnd.n3313 524315134.29096609
rmesh_equiv_205 vgnd.n1408 vgnd.t0 97520.823143774673
rmesh_equiv_206 vgnd.n1408 vgnd.t18 8979809.7336308435
rmesh_equiv_207 vgnd.n1408 vgnd.t9 616.67295425859004
rmesh_equiv_208 vgnd.n1411 vgnd.n2897 40108521.964874566
rmesh_equiv_209 vgnd.n1411 vgnd.n3116 15780.235486856018
rmesh_equiv_21 vcm vcm.n0 19.837
rmesh_equiv_210 vgnd.n1411 vgnd.n3118 15812.658565722164
rmesh_equiv_211 vgnd.n1411 vgnd.n3122 572.49847654948519
rmesh_equiv_212 vgnd.n1411 vgnd.n3128 29492.947142635425
rmesh_equiv_213 vgnd.n1411 vgnd.n3313 524315134.29096609
rmesh_equiv_214 vgnd.n1411 vgnd.t0 97520.823143774673
rmesh_equiv_215 vgnd.n1411 vgnd.t1 5991361.6828663796
rmesh_equiv_216 vgnd.n1411 vgnd.t15 59504.077218361293
rmesh_equiv_217 vgnd.n1411 vgnd.t18 8979809.7336308435
rmesh_equiv_218 vgnd.n1411 vgnd.t9 616.67295425859004
rmesh_equiv_219 vgnd.n184 vgnd.n185 185741.15691115774
rmesh_equiv_22 vcm vcm.n1 4.2590000000000003
rmesh_equiv_220 vgnd.n184 vgnd.n281 5407.105392814633
rmesh_equiv_221 vgnd.n184 vgnd.n287 1861.1415946970819
rmesh_equiv_222 vgnd.n184 vgnd.n320 12305.085349681374
rmesh_equiv_223 vgnd.n184 vgnd.n322 526.22552770447749
rmesh_equiv_224 vgnd.n184 vgnd.n332 680.81051771011187
rmesh_equiv_225 vgnd.n184 vgnd.n3622 127348.48757407958
rmesh_equiv_226 vgnd.n184 vgnd.t2 11545.971011027332
rmesh_equiv_227 vgnd.n184 vgnd.t26 884.1291348700031
rmesh_equiv_228 vgnd.n184 vgnd.t7 29969444.871156573
rmesh_equiv_229 vgnd.n184 vgnd.t8 18641.186418000918
rmesh_equiv_23 vcm vcm.n4 33.9895
rmesh_equiv_230 vgnd.n185 vgnd.n281 8518.8704474047481
rmesh_equiv_231 vgnd.n185 vgnd.n285 1105.8560684540639
rmesh_equiv_232 vgnd.n185 vgnd.n328 2895.8018898371597
rmesh_equiv_233 vgnd.n185 vgnd.n330 369.59779367798893
rmesh_equiv_234 vgnd.n185 vgnd.n332 1540.0362363369115
rmesh_equiv_235 vgnd.n185 vgnd.n3622 115257.68165005257
rmesh_equiv_236 vgnd.n185 vgnd.t2 238712.02666306484
rmesh_equiv_237 vgnd.n185 vgnd.t7 619615874.34509146
rmesh_equiv_238 vgnd.n185 vgnd.t8 16871.342335301877
rmesh_equiv_239 vgnd.n281 vgnd.n285 25511.409503124058
rmesh_equiv_24 vcm vcm.n6 6.9688099999999995
rmesh_equiv_240 vgnd.n281 vgnd.n287 14722.075518278534
rmesh_equiv_241 vgnd.n281 vgnd.n320 743.94079028835688
rmesh_equiv_242 vgnd.n281 vgnd.n322 7559.8315777736861
rmesh_equiv_243 vgnd.n281 vgnd.n328 35149.541188472424
rmesh_equiv_244 vgnd.n281 vgnd.n330 697.55506021508097
rmesh_equiv_245 vgnd.n281 vgnd.n332 352.8780814232282
rmesh_equiv_246 vgnd.n281 vgnd.t26 3987.4343783077097
rmesh_equiv_247 vgnd.n285 vgnd.n287 11825.13468727295
rmesh_equiv_248 vgnd.n285 vgnd.n320 7328.6908875007684
rmesh_equiv_249 vgnd.n285 vgnd.n322 6656.4879854530382
rmesh_equiv_25 vcm vcm.n9 20.777277176975304
rmesh_equiv_250 vgnd.n285 vgnd.n328 472.41796020972009
rmesh_equiv_251 vgnd.n285 vgnd.n330 641.99811307556843
rmesh_equiv_252 vgnd.n285 vgnd.n332 15821.414558644625
rmesh_equiv_253 vgnd.n287 vgnd.n320 1481.5396722393079
rmesh_equiv_254 vgnd.n287 vgnd.n322 349.98269739429838
rmesh_equiv_255 vgnd.n287 vgnd.n328 6656.4879854530382
rmesh_equiv_256 vgnd.n287 vgnd.n330 7328.6908875007684
rmesh_equiv_257 vgnd.n287 vgnd.n332 4040.4316579407378
rmesh_equiv_258 vgnd.n287 vgnd.t26 608.40282688822072
rmesh_equiv_259 vgnd.n2897 vgnd.n3116 3389454.2552993898
rmesh_equiv_26 vcm vcm.t3 332.71199999999999
rmesh_equiv_260 vgnd.n2897 vgnd.n3118 3396662.6259899018
rmesh_equiv_261 vgnd.n2897 vgnd.n3122 862029.62353209895
rmesh_equiv_262 vgnd.n2897 vgnd.t1 90.241870824332196
rmesh_equiv_263 vgnd.n2897 vgnd.t11 63697.44580241364
rmesh_equiv_264 vgnd.n2897 vgnd.t13 719.24040100044431
rmesh_equiv_265 vgnd.n2897 vgnd.t15 8304.1585210291305
rmesh_equiv_266 vgnd.n3116 vgnd.n3118 293.83423482908125
rmesh_equiv_267 vgnd.n3116 vgnd.n3122 321.69687306024446
rmesh_equiv_268 vgnd.n3116 vgnd.n3128 3560.2042816996477
rmesh_equiv_269 vgnd.n3116 vgnd.t1 506312.50807032012
rmesh_equiv_27 vcm.n0 vcm.n2 14.189499999999999
rmesh_equiv_270 vgnd.n3116 vgnd.t15 5028.5160822447406
rmesh_equiv_271 vgnd.n3118 vgnd.n3122 322.04627825493606
rmesh_equiv_272 vgnd.n3118 vgnd.n3128 172.90150716397031
rmesh_equiv_273 vgnd.n3118 vgnd.t1 507389.28561871377
rmesh_equiv_274 vgnd.n3118 vgnd.t15 5039.2102545845337
rmesh_equiv_275 vgnd.n3122 vgnd.n3128 3626.8503868168286
rmesh_equiv_276 vgnd.n3122 vgnd.t1 128768.92497931021
rmesh_equiv_277 vgnd.n3122 vgnd.t15 1278.8872481536571
rmesh_equiv_278 vgnd.n3122 vgnd.t9 59.24793821952138
rmesh_equiv_279 vgnd.n3128 vgnd.n3313 19335746.747241028
rmesh_equiv_28 vcm.n0 vcm.t0 174.91200000000001
rmesh_equiv_280 vgnd.n3128 vgnd.t0 3596.3828155379611
rmesh_equiv_281 vgnd.n3128 vgnd.t18 331158.33492523234
rmesh_equiv_282 vgnd.n3128 vgnd.t9 322.10631368368303
rmesh_equiv_283 vgnd.n320 vgnd.n322 1586.8066286580693
rmesh_equiv_284 vgnd.n320 vgnd.n328 4125.3942666929725
rmesh_equiv_285 vgnd.n320 vgnd.n330 263.01346535148565
rmesh_equiv_286 vgnd.n320 vgnd.n332 2445.7040838288308
rmesh_equiv_287 vgnd.n320 vgnd.t26 57.720611180958343
rmesh_equiv_288 vgnd.n322 vgnd.n328 51.600789359185825
rmesh_equiv_289 vgnd.n322 vgnd.n330 4125.3942666929725
rmesh_equiv_29 vcm.n1 vcm.n2 3.0467200000000001
rmesh_equiv_290 vgnd.n322 vgnd.n332 1118.8989765236236
rmesh_equiv_291 vgnd.n322 vgnd.t26 1922.4930724746139
rmesh_equiv_292 vgnd.n328 vgnd.n330 1703.5636641986459
rmesh_equiv_293 vgnd.n328 vgnd.n332 233783.07302186851
rmesh_equiv_294 vgnd.n330 vgnd.n332 1215.9640626449034
rmesh_equiv_295 vgnd.n3313 vgnd.n3611 8690130.2118998971
rmesh_equiv_296 vgnd.n3313 vgnd.n3615 53009040.877152264
rmesh_equiv_297 vgnd.n3313 vgnd.n364 2262000.7584069073
rmesh_equiv_298 vgnd.n3313 vgnd.n366 679868.60188200639
rmesh_equiv_299 vgnd.n3313 vgnd.n434 1510582.2377407681
rmesh_equiv_3 bias bias.n4 32.995399999999997
rmesh_equiv_30 vcm.n1 vcm.t0 181.41
rmesh_equiv_300 vgnd.n3313 vgnd.t0 66196.669642773835
rmesh_equiv_301 vgnd.n3313 vgnd.t16 89.369387309844768
rmesh_equiv_302 vgnd.n3313 vgnd.t18 719.79492352001637
rmesh_equiv_303 vgnd.n3313 vgnd.t9 8012964.7484088065
rmesh_equiv_304 vgnd.n332 vgnd.t26 1277.3195072841893
rmesh_equiv_305 vgnd.n3611 vgnd.n3615 61008.182401667822
rmesh_equiv_306 vgnd.n3611 vgnd.n3622 178179.37678746873
rmesh_equiv_307 vgnd.n3611 vgnd.n364 5058.4258030364417
rmesh_equiv_308 vgnd.n3611 vgnd.n366 466.20474143143809
rmesh_equiv_309 vgnd.n3611 vgnd.n434 721.90393300374751
rmesh_equiv_31 vcm.n2 vcm.n3 16.9712
rmesh_equiv_310 vgnd.n3611 vgnd.t16 1298120.9633277843
rmesh_equiv_311 vgnd.n3611 vgnd.t22 3660.7957995400352
rmesh_equiv_312 vgnd.n3615 vgnd.n3622 13926.396504573881
rmesh_equiv_313 vgnd.n3615 vgnd.n364 334.80434961834698
rmesh_equiv_314 vgnd.n3615 vgnd.n366 1249.3415356539879
rmesh_equiv_315 vgnd.n3615 vgnd.n434 23305.47490464084
rmesh_equiv_316 vgnd.n3615 vgnd.t16 7918425.3320280919
rmesh_equiv_317 vgnd.n3615 vgnd.t22 393.60454904920954
rmesh_equiv_318 vgnd.n3622 vgnd.n364 2773.9086332832289
rmesh_equiv_319 vgnd.n3622 vgnd.n366 268763.00236412394
rmesh_equiv_32 vcm.n3 vcm.n8 0.91758700000000015
rmesh_equiv_320 vgnd.n3622 vgnd.n434 1413695.3170875334
rmesh_equiv_321 vgnd.n3622 vgnd.t2 163666.55655011974
rmesh_equiv_322 vgnd.n3622 vgnd.t22 923.83241139899633
rmesh_equiv_323 vgnd.n3622 vgnd.t7 424823155.98195916
rmesh_equiv_324 vgnd.n3622 vgnd.t8 86.142180011879944
rmesh_equiv_325 vgnd.n364 vgnd.n366 323.87648064028548
rmesh_equiv_326 vgnd.n364 vgnd.n434 949.07404146740839
rmesh_equiv_327 vgnd.n364 vgnd.t16 337894.89132515399
rmesh_equiv_328 vgnd.n364 vgnd.t22 496.17415139574888
rmesh_equiv_329 vgnd.n366 vgnd.n434 300.61665693568506
rmesh_equiv_33 vcm.n3 vcm.t1 42.654000000000003
rmesh_equiv_330 vgnd.n366 vgnd.t16 101557.93559949826
rmesh_equiv_331 vgnd.n366 vgnd.t22 28.115018131967442
rmesh_equiv_332 vgnd.n434 vgnd.t16 225648.91685474251
rmesh_equiv_333 vgnd.n434 vgnd.t22 29045.167695229211
rmesh_equiv_334 vgnd.n655 vgnd.n659 66.679545749905714
rmesh_equiv_335 vgnd.n655 vgnd.t14 30.441757823784851
rmesh_equiv_336 vgnd.n655 vgnd.t19 12.541652750628479
rmesh_equiv_337 vgnd.n655 vgnd.t20 69.81190408193055
rmesh_equiv_338 vgnd.n655 vgnd.t21 12.482991621761396
rmesh_equiv_339 vgnd.n655 vgnd.t23 166.22146460121985
rmesh_equiv_34 vcm.n4 vcm.n5 13.2728
rmesh_equiv_340 vgnd.n655 vgnd.t27 38384.943334578857
rmesh_equiv_341 vgnd.n655 vgnd.t3 45250.680765835692
rmesh_equiv_342 vgnd.n655 vgnd.t4 29.504116666856561
rmesh_equiv_343 vgnd.n655 vgnd.t5 84.815861981192171
rmesh_equiv_344 vgnd.n655 vgnd.t6 5.2825199999999999
rmesh_equiv_345 vgnd.n659 vgnd.t10 5.2825199999999999
rmesh_equiv_346 vgnd.n659 vgnd.t12 299303.35586928931
rmesh_equiv_347 vgnd.n659 vgnd.t14 30.441757823784851
rmesh_equiv_348 vgnd.n659 vgnd.t17 893.75126732499086
rmesh_equiv_349 vgnd.n659 vgnd.t19 84.815861981192171
rmesh_equiv_35 vcm.n4 vcm.n7 0.51338700000000004
rmesh_equiv_350 vgnd.n659 vgnd.t24 67.414287445613539
rmesh_equiv_351 vgnd.n659 vgnd.t25 29.321605460932702
rmesh_equiv_352 vgnd.n659 vgnd.t28 12.471203655910019
rmesh_equiv_353 vgnd.n659 vgnd.t5 12.541652750628479
rmesh_equiv_354 vgnd.t0 vgnd.t18 1133.733244599131
rmesh_equiv_355 vgnd.t0 vgnd.t9 1490.3840590899763
rmesh_equiv_356 vgnd.t1 vgnd.t15 1240.4649868403064
rmesh_equiv_357 vgnd.t11 vgnd.t13 1088.2203616131721
rmesh_equiv_358 vgnd.t12 vgnd.t17 152729.77998946432
rmesh_equiv_359 vgnd.t12 vgnd.t24 56305.484988454453
rmesh_equiv_36 vcm.n5 vcm.n6 13.200100000000001
rmesh_equiv_360 vgnd.t12 vgnd.t25 136643.40650118908
rmesh_equiv_361 vgnd.t12 vgnd.t28 380711.53359579062
rmesh_equiv_362 vgnd.t14 vgnd.t19 38.72167845490555
rmesh_equiv_363 vgnd.t14 vgnd.t5 38.72167845490555
rmesh_equiv_364 vgnd.t17 vgnd.t24 168.13409398508827
rmesh_equiv_365 vgnd.t17 vgnd.t25 408.03156843111282
rmesh_equiv_366 vgnd.t17 vgnd.t28 1136.8446392731942
rmesh_equiv_367 vgnd.t18 vgnd.t9 137235.97534583317
rmesh_equiv_368 vgnd.t19 vgnd.t5 107.88511473359598
rmesh_equiv_369 vgnd.t2 vgnd.t7 17327.900089248677
rmesh_equiv_37 vcm.n5 vcm.t2 0.71462499999999995
rmesh_equiv_370 vgnd.t2 vgnd.t8 23957.401058794021
rmesh_equiv_371 vgnd.t20 vgnd.t21 88.800197341860596
rmesh_equiv_372 vgnd.t20 vgnd.t23 31.264338490673225
rmesh_equiv_373 vgnd.t20 vgnd.t27 7219.764693065863
rmesh_equiv_374 vgnd.t20 vgnd.t3 8511.1306400202466
rmesh_equiv_375 vgnd.t20 vgnd.t4 31.871798965913506
rmesh_equiv_376 vgnd.t21 vgnd.t23 211.43240616555372
rmesh_equiv_377 vgnd.t21 vgnd.t27 48825.348454419043
rmesh_equiv_378 vgnd.t21 vgnd.t3 57558.512902669769
rmesh_equiv_379 vgnd.t21 vgnd.t4 37.52900621847197
rmesh_equiv_38 vcm.n6 vcm.n7 0.27270899999999998
rmesh_equiv_380 vgnd.t23 vgnd.t27 3040.9509930422137
rmesh_equiv_381 vgnd.t23 vgnd.t3 3584.8718444438468
rmesh_equiv_382 vgnd.t23 vgnd.t4 75.886443340270006
rmesh_equiv_383 vgnd.t24 vgnd.t25 30.777195453304195
rmesh_equiv_384 vgnd.t24 vgnd.t28 85.750447685910615
rmesh_equiv_385 vgnd.t25 vgnd.t28 37.296853388431423
rmesh_equiv_386 vgnd.t27 vgnd.t3 156527.76971952067
rmesh_equiv_387 vgnd.t27 vgnd.t4 17524.191803190359
rmesh_equiv_388 vgnd.t3 vgnd.t4 20658.66300891705
rmesh_equiv_389 vgnd.t7 vgnd.t8 62185329.376106821
rmesh_equiv_39 vcm.n7 vcm.n8 16.9712
rmesh_equiv_4 bias bias.n6 16.94664149193358
rmesh_equiv_40 vcm.n8 vcm.n9 3.3057699999999994
rmesh_equiv_41 vcm_buffer__comp.n0 vcm_buffer__comp.n1 4.1529499999999997
rmesh_equiv_42 vcm_buffer__comp.n0 vcm_buffer__comp.t1 4.7185199999999998
rmesh_equiv_43 vcm_buffer__comp.n0 vcm_buffer__comp.t3 26.609300000000001
rmesh_equiv_44 vcm_buffer__comp.n1 vcm_buffer__comp.n2 4.7105199999999998
rmesh_equiv_45 vcm_buffer__comp.n1 vcm_buffer__comp.t0 8.8709699999999998
rmesh_equiv_46 vcm_buffer__comp.n2 vcm_buffer__comp.t2 0.025939499999999997
rmesh_equiv_47 vcm_buffer__first__mir vcm_buffer__first__mir.n0 22.8553
rmesh_equiv_48 vcm_buffer__first__mir vcm_buffer__first__mir.n1 15.571552633952864
rmesh_equiv_49 vcm_buffer__first__mir vcm_buffer__first__mir.n2 6.3200399999999997
rmesh_equiv_5 bias bias.t0 139.911
rmesh_equiv_50 vcm_buffer__first__mir vcm_buffer__first__mir.n4 33.130400000000002
rmesh_equiv_51 vcm_buffer__first__mir vcm_buffer__first__mir.n8 4.8770699999999998
rmesh_equiv_52 vcm_buffer__first__mir vcm_buffer__first__mir.t0 572.84699999999998
rmesh_equiv_53 vcm_buffer__first__mir vcm_buffer__first__mir.t3 572.84699999999998
rmesh_equiv_54 vcm_buffer__first__mir.n0 vcm_buffer__first__mir.n7 11.4361
rmesh_equiv_55 vcm_buffer__first__mir.n0 vcm_buffer__first__mir.t1 381.113
rmesh_equiv_56 vcm_buffer__first__mir.n1 vcm_buffer__first__mir.n6 0.39353700000000003
rmesh_equiv_57 vcm_buffer__first__mir.n2 vcm_buffer__first__mir.n3 13.389300000000002
rmesh_equiv_58 vcm_buffer__first__mir.n2 vcm_buffer__first__mir.n5 0.75515399999999999
rmesh_equiv_59 vcm_buffer__first__mir.n3 vcm_buffer__first__mir.n4 14.121399999999998
rmesh_equiv_6 bias bias.t3 139.911
rmesh_equiv_60 vcm_buffer__first__mir.n3 vcm_buffer__first__mir.t2 1.7404999999999999
rmesh_equiv_61 vcm_buffer__first__mir.n4 vcm_buffer__first__mir.n5 1.13588
rmesh_equiv_62 vcm_buffer__first__mir.n5 vcm_buffer__first__mir.n6 18.305
rmesh_equiv_63 vcm_buffer__first__mir.n6 vcm_buffer__first__mir.n7 17.387899999999998
rmesh_equiv_64 vcm_buffer__first__mir.n7 vcm_buffer__first__mir.n8 2.4407800000000002
rmesh_equiv_65 vcm_buffer__first__mir.n8 vcm_buffer__first__mir.t1 387.11000000000001
rmesh_equiv_66 vcm_buffer__first__tail vcm_buffer__first__tail.n0 6.3200399999999997
rmesh_equiv_67 vcm_buffer__first__tail vcm_buffer__first__tail.n1 19.837
rmesh_equiv_68 vcm_buffer__first__tail vcm_buffer__first__tail.n11 33.130400000000002
rmesh_equiv_69 vcm_buffer__first__tail vcm_buffer__first__tail.n2 4.2590000000000003
rmesh_equiv_7 bias bias.t4 139.911
rmesh_equiv_70 vcm_buffer__first__tail vcm_buffer__first__tail.n4 7.0733300000000003
rmesh_equiv_71 vcm_buffer__first__tail vcm_buffer__first__tail.n6 26.391300000000001
rmesh_equiv_72 vcm_buffer__first__tail.n0 vcm_buffer__first__tail.n10 13.389300000000002
rmesh_equiv_73 vcm_buffer__first__tail.n0 vcm_buffer__first__tail.n9 0.75515399999999999
rmesh_equiv_74 vcm_buffer__first__tail.n1 vcm_buffer__first__tail.n3 14.189499999999999
rmesh_equiv_75 vcm_buffer__first__tail.n1 vcm_buffer__first__tail.t2 174.91200000000001
rmesh_equiv_76 vcm_buffer__first__tail.n10 vcm_buffer__first__tail.n11 14.121399999999998
rmesh_equiv_77 vcm_buffer__first__tail.n10 vcm_buffer__first__tail.t0 1.7404999999999999
rmesh_equiv_78 vcm_buffer__first__tail.n11 vcm_buffer__first__tail.n9 1.13588
rmesh_equiv_79 vcm_buffer__first__tail.n2 vcm_buffer__first__tail.n3 3.0467200000000001
rmesh_equiv_8 bias.n0 bias.n2 3.0467200000000001
rmesh_equiv_80 vcm_buffer__first__tail.n2 vcm_buffer__first__tail.t2 181.41
rmesh_equiv_81 vcm_buffer__first__tail.n3 vcm_buffer__first__tail.n8 20.720400000000001
rmesh_equiv_82 vcm_buffer__first__tail.n4 vcm_buffer__first__tail.n5 14.985300000000001
rmesh_equiv_83 vcm_buffer__first__tail.n4 vcm_buffer__first__tail.n7 0.24337299999999998
rmesh_equiv_84 vcm_buffer__first__tail.n5 vcm_buffer__first__tail.n6 11.248699999999999
rmesh_equiv_85 vcm_buffer__first__tail.n5 vcm_buffer__first__tail.t1 1.7404999999999999
rmesh_equiv_86 vcm_buffer__first__tail.n6 vcm_buffer__first__tail.n7 3.1501399999999999
rmesh_equiv_87 vcm_buffer__first__tail.n7 vcm_buffer__first__tail.n8 19.131799999999998
rmesh_equiv_88 vcm_buffer__first__tail.n8 vcm_buffer__first__tail.n9 18.2212
rmesh_equiv_89 vcm_buffer__pre vcm_buffer__pre.n0 22.8553
rmesh_equiv_9 bias.n0 bias.t1 181.41
rmesh_equiv_90 vcm_buffer__pre vcm_buffer__pre.n1 3.0716771718006117
rmesh_equiv_91 vcm_buffer__pre vcm_buffer__pre.n10 4.8770699999999998
rmesh_equiv_92 vcm_buffer__pre vcm_buffer__pre.n2 4.7030000000000003
rmesh_equiv_93 vcm_buffer__pre vcm_buffer__pre.n3 27.632600000000004
rmesh_equiv_94 vcm_buffer__pre vcm_buffer__pre.n4 6.3200399999999997
rmesh_equiv_95 vcm_buffer__pre vcm_buffer__pre.n6 33.130400000000002
rmesh_equiv_96 vcm_buffer__pre vcm_buffer__pre.t2 1054.8499999999999
rmesh_equiv_97 vcm_buffer__pre vcm_buffer__pre.t3 0.00141837
rmesh_equiv_98 vcm_buffer__pre vcm_buffer__pre.t4 0.00141837
rmesh_equiv_99 vcm_buffer__pre vcm_buffer__pre.t5 0.00141837
.ends

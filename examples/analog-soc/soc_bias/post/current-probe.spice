* NGSPICE file created from soc_bias.ext - technology: sky130A

.subckt soc_bias VGND VPWR VCM BIAS
X0 VCM_RAW.t2 VGND.t18 sky130_fd_pr__cap_mim_m3_1 l=28.68 w=28.68
X1 VCM_RAW.t1 R_VCM_BOTTOM_R0_N0.t1 VGND.t24 sky130_fd_pr__res_xhigh_po_1p41 l=23.34
X2 VCM_RAW.t3 VGND.t17 sky130_fd_pr__cap_mim_m3_1 l=28.68 w=28.68
X3 R_VCM_BOTTOM_R0_N0.t0 R_VCM_BOTTOM_R0_N1.t0 VGND.t19 sky130_fd_pr__res_xhigh_po_1p41 l=23.34
X4 register_cf_node_2f8e879de146637c VCM_BUFFER__FIRST__MIR.t4 register_cf_node_2f8e879de146637c_source VPWR sky130_fd_pr__pfet_01v8_hvt ad=5.8 pd=40.58 as=5.8 ps=40.58 w=20 l=1
Vregister_cf_2f8e879de146637c VPWR register_cf_node_2f8e879de146637c 0
Vregister_cf_2f8e879de146637c_source VCM_BUFFER__PRE.t0 register_cf_node_2f8e879de146637c_source 0
X5 VCM_RAW.t4 VGND.t16 sky130_fd_pr__cap_mim_m3_1 l=28.68 w=28.68
X6 register_cf_node_b283300717e1569e VCM_BUFFER__FIRST__MIR.t0 register_cf_node_b283300717e1569e_source VPWR sky130_fd_pr__pfet_01v8_hvt ad=5.8 pd=40.58 as=5.8 ps=40.58 w=20 l=1
Vregister_cf_b283300717e1569e VPWR register_cf_node_b283300717e1569e 0
Vregister_cf_b283300717e1569e_source VCM_BUFFER__FIRST__MIR.t1 register_cf_node_b283300717e1569e_source 0
X7 VCM_RAW.t5 VGND.t15 sky130_fd_pr__cap_mim_m3_1 l=28.68 w=28.68
X8 register_cf_node_c28de828beac56d0 VCM_RAW.t6 register_cf_node_c28de828beac56d0_source VGND.t14 sky130_fd_pr__nfet_01v8 ad=1.45 pd=10.58 as=1.45 ps=10.58 w=5 l=1
Vregister_cf_c28de828beac56d0 VCM_BUFFER__FIRST__TAIL.t2 register_cf_node_c28de828beac56d0 0
Vregister_cf_c28de828beac56d0_source VCM_BUFFER__PRE.t1 register_cf_node_c28de828beac56d0_source 0
X9 R_VCM_BOTTOM_R0_N1.t1 VGND.t21 VGND.t20 sky130_fd_pr__res_xhigh_po_1p41 l=23.34
X10 register_cf_node_3727ac57d08ab503 VCM.t3 register_cf_node_3727ac57d08ab503_source VGND.t30 sky130_fd_pr__nfet_01v8 ad=1.45 pd=10.58 as=1.45 ps=10.58 w=5 l=1
Vregister_cf_3727ac57d08ab503 VCM_BUFFER__FIRST__TAIL.t4 register_cf_node_3727ac57d08ab503 0
Vregister_cf_3727ac57d08ab503_source VCM_BUFFER__FIRST__MIR.t3 register_cf_node_3727ac57d08ab503_source 0
X11 register_cf_node_ea482a702a8df179 BIAS.t3 register_cf_node_ea482a702a8df179_source VGND.t3 sky130_fd_pr__nfet_01v8 ad=0.58 pd=4.58 as=0.58 ps=4.58 w=2 l=1
Vregister_cf_ea482a702a8df179 VGND.t4 register_cf_node_ea482a702a8df179 0
Vregister_cf_ea482a702a8df179_source VCM_BUFFER__FIRST__TAIL.t0 register_cf_node_ea482a702a8df179_source 0
X12 VCM_RAW.t7 VGND.t13 sky130_fd_pr__cap_mim_m3_1 l=28.68 w=28.68
X13 register_cf_node_36ad016f8048c663 BIAS.t4 register_cf_node_36ad016f8048c663_source VGND.t0 sky130_fd_pr__nfet_01v8 ad=0.58 pd=4.58 as=0.58 ps=4.58 w=2 l=1
Vregister_cf_36ad016f8048c663 VGND.t1 register_cf_node_36ad016f8048c663 0
Vregister_cf_36ad016f8048c663_source VCM.t0 register_cf_node_36ad016f8048c663_source 0
X14 R_VCM_TOP_R0_N1.t0 VCM_RAW.t0 VGND.t2 sky130_fd_pr__res_xhigh_po_1p41 l=23.34
X15 VCM_BUFFER__COMP.t3 VCM.t2 VGND.t28 sky130_fd_pr__res_xhigh_po_1p41 l=3.36
X16 VCM_BUFFER__PRE.t3 VCM_BUFFER__COMP.t2 sky130_fd_pr__cap_mim_m3_1 l=28.68 w=28.68
X17 VCM_RAW.t8 VGND.t12 sky130_fd_pr__cap_mim_m3_1 l=28.68 w=28.68
X18 register_cf_node_0dbc9d465d659a93 VCM.t4 register_cf_node_0dbc9d465d659a93_source VGND.t29 sky130_fd_pr__nfet_01v8 ad=1.45 pd=10.58 as=1.45 ps=10.58 w=5 l=1
Vregister_cf_0dbc9d465d659a93 VCM_BUFFER__FIRST__TAIL.t3 register_cf_node_0dbc9d465d659a93 0
Vregister_cf_0dbc9d465d659a93_source VCM_BUFFER__FIRST__MIR.t2 register_cf_node_0dbc9d465d659a93_source 0
X19 VCM_RAW.t9 VGND.t11 sky130_fd_pr__cap_mim_m3_1 l=28.68 w=28.68
X20 VPWR R_VCM_TOP_R0_N0.t1 VGND.t27 sky130_fd_pr__res_xhigh_po_1p41 l=23.34
X21 register_cf_node_32753ad247ad986f VCM_RAW.t10 register_cf_node_32753ad247ad986f_source VGND.t10 sky130_fd_pr__nfet_01v8 ad=1.45 pd=10.58 as=1.45 ps=10.58 w=5 l=1
Vregister_cf_32753ad247ad986f VCM_BUFFER__FIRST__TAIL.t1 register_cf_node_32753ad247ad986f 0
Vregister_cf_32753ad247ad986f_source VCM_BUFFER__PRE.t2 register_cf_node_32753ad247ad986f_source 0
X22 VCM_BUFFER__PRE.t4 VCM_BUFFER__COMP.t1 sky130_fd_pr__cap_mim_m3_1 l=28.68 w=28.68
X23 R_VCM_TOP_R0_N0.t0 R_VCM_TOP_R0_N1.t1 VGND.t26 sky130_fd_pr__res_xhigh_po_1p41 l=23.34
X24 VCM_RAW.t11 VGND.t9 sky130_fd_pr__cap_mim_m3_1 l=28.68 w=28.68
X25 VPWR BIAS.t2 VGND.t25 sky130_fd_pr__res_xhigh_po_1p41 l=20.99
X26 VCM_RAW.t12 VGND.t8 sky130_fd_pr__cap_mim_m3_1 l=28.68 w=28.68
X27 register_cf_node_a87bf144a7f86220 BIAS.t0 register_cf_node_a87bf144a7f86220_source VGND.t22 sky130_fd_pr__nfet_01v8 ad=0.58 pd=4.58 as=0.58 ps=4.58 w=2 l=1
Vregister_cf_a87bf144a7f86220 VGND.t23 register_cf_node_a87bf144a7f86220 0
Vregister_cf_a87bf144a7f86220_source BIAS.t1 register_cf_node_a87bf144a7f86220_source 0
X28 VCM_RAW.t13 VGND.t7 sky130_fd_pr__cap_mim_m3_1 l=28.68 w=28.68
X29 VCM_BUFFER__PRE.t5 VCM_BUFFER__COMP.t0 sky130_fd_pr__cap_mim_m3_1 l=28.68 w=28.68
X30 register_cf_node_b5c843ff068fe564 VCM_BUFFER__PRE.t6 register_cf_node_b5c843ff068fe564_source VPWR sky130_fd_pr__pfet_01v8_hvt ad=11.6 pd=80.58 as=11.6 ps=80.58 w=40 l=1
Vregister_cf_b5c843ff068fe564 VPWR register_cf_node_b5c843ff068fe564 0
Vregister_cf_b5c843ff068fe564_source VCM.t1 register_cf_node_b5c843ff068fe564_source 0
X31 VCM_RAW.t14 VGND.t6 sky130_fd_pr__cap_mim_m3_1 l=28.68 w=28.68
X32 VCM_RAW.t15 VGND.t5 sky130_fd_pr__cap_mim_m3_1 l=28.68 w=28.68
C0 VPWR VCM_BUFFER__FIRST__MIR 10.112f
C1 VCM VCM_BUFFER__PRE 6.21624f
C2 VCM_BUFFER__FIRST__TAIL VCM_BUFFER__FIRST__MIR 3.58865f
C3 VCM_BUFFER__FIRST__TAIL VPWR 0.38453f
C4 VCM_BUFFER__PRE VCM_RAW 2.20124f
C5 BIAS VCM_BUFFER__FIRST__MIR 0.39086f
C6 VPWR BIAS 0.92397f
C7 VCM_BUFFER__FIRST__TAIL BIAS 0.42801f
C8 VCM VCM_BUFFER__FIRST__MIR 0.97608f
C9 VPWR VCM 7.93237f
C10 VCM_BUFFER__FIRST__TAIL VCM 3.15837f
C11 VPWR VCM_RAW 0.00831f
C12 VCM_BUFFER__FIRST__MIR VCM_RAW 0.69259f
C13 BIAS VCM 35.1425f
C14 VCM_BUFFER__FIRST__TAIL VCM_RAW 3.2186f
C15 BIAS VCM_RAW 1.55765f
C16 VCM VCM_RAW 31.3013f
C17 VPWR VCM_BUFFER__PRE 8.04142f
C18 VCM_BUFFER__FIRST__MIR VCM_BUFFER__PRE 1.21996f
C19 VCM_BUFFER__FIRST__TAIL VCM_BUFFER__PRE 3.81106f
C20 BIAS VCM_BUFFER__PRE 0.34391f
C21 VCM VGND 54.94289f
C22 BIAS VGND 48.80451f
C23 VPWR VGND 0.10743p
C24 VCM_BUFFER__FIRST__TAIL VGND 14.89761f $ **FLOATING
C25 VCM_BUFFER__FIRST__MIR VGND 15.0283f $ **FLOATING
C26 VCM_RAW VGND 0.96695p $ **FLOATING
C27 VCM_BUFFER__PRE VGND 0.14205p $ **FLOATING
C28 VCM_BUFFER__COMP.t3 VGND 0.6411f $ **FLOATING
C29 VCM_BUFFER__COMP.t0 VGND 72.9234f $ **FLOATING
C30 VCM_BUFFER__COMP.n0 VGND 1.64705f $ **FLOATING
C31 VCM_BUFFER__COMP.t1 VGND 73.2929f $ **FLOATING
C32 VCM_BUFFER__COMP.n1 VGND 1.66572f $ **FLOATING
C33 VCM_BUFFER__COMP.t2 VGND 52.5193f $ **FLOATING
C34 VCM_BUFFER__COMP.n2 VGND 68.6182f $ **FLOATING
C35 BIAS.t4 VGND 0.3254f $ **FLOATING
C36 BIAS.n0 VGND 0.01641f $ **FLOATING
C37 BIAS.t1 VGND 0.02773f $ **FLOATING
C38 BIAS.n1 VGND 0.01702f $ **FLOATING
C39 BIAS.n2 VGND 0.59044f $ **FLOATING
C40 BIAS.n3 VGND 0.71101f $ **FLOATING
C41 BIAS.t0 VGND 0.3254f $ **FLOATING
C42 BIAS.n4 VGND 1.05185f $ **FLOATING
C43 BIAS.t2 VGND 1.24354f $ **FLOATING
C44 BIAS.n5 VGND 14.3336f $ **FLOATING
C45 BIAS.t3 VGND 0.3254f $ **FLOATING
C46 BIAS.n6 VGND 15.0625f $ **FLOATING
C47 VCM.t2 VGND 4.8345f $ **FLOATING
C48 VCM.n0 VGND 0.0343f $ **FLOATING
C49 VCM.t0 VGND 0.0559f $ **FLOATING
C50 VCM.n1 VGND 0.03308f $ **FLOATING
C51 VCM.n2 VGND 1.24009f $ **FLOATING
C52 VCM.n3 VGND 12.8105f $ **FLOATING
C53 VCM.n4 VGND 0.70692f $ **FLOATING
C54 VCM.t1 VGND 0.70224f $ **FLOATING
C55 VCM.n5 VGND 3.05754f $ **FLOATING
C56 VCM.n6 VGND 0.27506f $ **FLOATING
C57 VCM.n7 VGND 2.962f $ **FLOATING
C58 VCM.n8 VGND 3.34122f $ **FLOATING
C59 VCM.t3 VGND 1.22979f $ **FLOATING
C60 VCM.n9 VGND 3.73f $ **FLOATING
C61 VCM.n10 VGND 26.3731f $ **FLOATING
C62 VCM.t4 VGND 1.22979f $ **FLOATING
C63 VCM_BUFFER__FIRST__TAIL.n0 VGND 0.02265f $ **FLOATING
C64 VCM_BUFFER__FIRST__TAIL.t0 VGND 0.0369f $ **FLOATING
C65 VCM_BUFFER__FIRST__TAIL.n1 VGND 0.03061f $ **FLOATING
C66 VCM_BUFFER__FIRST__TAIL.t2 VGND 0.03737f $ **FLOATING
C67 VCM_BUFFER__FIRST__TAIL.n2 VGND 0.03061f $ **FLOATING
C68 VCM_BUFFER__FIRST__TAIL.n3 VGND 1.28932f $ **FLOATING
C69 VCM_BUFFER__FIRST__TAIL.n4 VGND 0.03061f $ **FLOATING
C70 VCM_BUFFER__FIRST__TAIL.t3 VGND 0.03737f $ **FLOATING
C71 VCM_BUFFER__FIRST__TAIL.n5 VGND 0.03061f $ **FLOATING
C72 VCM_BUFFER__FIRST__TAIL.n6 VGND 1.23359f $ **FLOATING
C73 VCM_BUFFER__FIRST__TAIL.n7 VGND 2.52415f $ **FLOATING
C74 VCM_BUFFER__FIRST__TAIL.n8 VGND 0.03061f $ **FLOATING
C75 VCM_BUFFER__FIRST__TAIL.t4 VGND 0.03737f $ **FLOATING
C76 VCM_BUFFER__FIRST__TAIL.n9 VGND 0.03061f $ **FLOATING
C77 VCM_BUFFER__FIRST__TAIL.n10 VGND 1.23359f $ **FLOATING
C78 VCM_BUFFER__FIRST__TAIL.n11 VGND 1.40904f $ **FLOATING
C79 VCM_BUFFER__FIRST__TAIL.n12 VGND 0.03061f $ **FLOATING
C80 VCM_BUFFER__FIRST__TAIL.t1 VGND 0.03737f $ **FLOATING
C81 VCM_BUFFER__FIRST__TAIL.n13 VGND 0.03061f $ **FLOATING
C82 VCM_BUFFER__FIRST__TAIL.n14 VGND 1.23359f $ **FLOATING
C83 VCM_BUFFER__FIRST__TAIL.n15 VGND 3.25105f $ **FLOATING
C84 VCM_BUFFER__FIRST__TAIL.n16 VGND 1.11164f $ **FLOATING
C85 VCM_BUFFER__FIRST__TAIL.n17 VGND 0.02184f $ **FLOATING
C86 VCM_BUFFER__PRE.n0 VGND 0.01281f $ **FLOATING
C87 VCM_BUFFER__PRE.t0 VGND 0.01534f $ **FLOATING
C88 VCM_BUFFER__PRE.t5 VGND 38.8588f $ **FLOATING
C89 VCM_BUFFER__PRE.t3 VGND 38.8588f $ **FLOATING
C90 VCM_BUFFER__PRE.n1 VGND 1.00692f $ **FLOATING
C91 VCM_BUFFER__PRE.t4 VGND 38.8588f $ **FLOATING
C92 VCM_BUFFER__PRE.n2 VGND 0.6884f $ **FLOATING
C93 VCM_BUFFER__PRE.t6 VGND 1.49076f $ **FLOATING
C94 VCM_BUFFER__PRE.n3 VGND 0.55393f $ **FLOATING
C95 VCM_BUFFER__PRE.n4 VGND 0.00904f $ **FLOATING
C96 VCM_BUFFER__PRE.t1 VGND 0.01104f $ **FLOATING
C97 VCM_BUFFER__PRE.n5 VGND 0.00904f $ **FLOATING
C98 VCM_BUFFER__PRE.n6 VGND 0.41955f $ **FLOATING
C99 VCM_BUFFER__PRE.n7 VGND 0.00904f $ **FLOATING
C100 VCM_BUFFER__PRE.t2 VGND 0.01104f $ **FLOATING
C101 VCM_BUFFER__PRE.n8 VGND 0.00904f $ **FLOATING
C102 VCM_BUFFER__PRE.n9 VGND 0.35472f $ **FLOATING
C103 VCM_BUFFER__PRE.n10 VGND 1.04882f $ **FLOATING
C104 VCM_BUFFER__PRE.n11 VGND 0.58931f $ **FLOATING
C105 VCM_BUFFER__PRE.n12 VGND 0.83108f $ **FLOATING
C106 VCM_BUFFER__PRE.n13 VGND 0.01261f $ **FLOATING
C107 VCM_BUFFER__FIRST__MIR.n0 VGND 0.02947f $ **FLOATING
C108 VCM_BUFFER__FIRST__MIR.t1 VGND 0.0353f $ **FLOATING
C109 VCM_BUFFER__FIRST__MIR.t4 VGND 1.79603f $ **FLOATING
C110 VCM_BUFFER__FIRST__MIR.t0 VGND 1.79603f $ **FLOATING
C111 VCM_BUFFER__FIRST__MIR.n1 VGND 1.69257f $ **FLOATING
C112 VCM_BUFFER__FIRST__MIR.n2 VGND 0.02081f $ **FLOATING
C113 VCM_BUFFER__FIRST__MIR.t2 VGND 0.02541f $ **FLOATING
C114 VCM_BUFFER__FIRST__MIR.n3 VGND 0.02081f $ **FLOATING
C115 VCM_BUFFER__FIRST__MIR.n4 VGND 0.89979f $ **FLOATING
C116 VCM_BUFFER__FIRST__MIR.n5 VGND 0.02081f $ **FLOATING
C117 VCM_BUFFER__FIRST__MIR.t3 VGND 0.02541f $ **FLOATING
C118 VCM_BUFFER__FIRST__MIR.n6 VGND 0.02081f $ **FLOATING
C119 VCM_BUFFER__FIRST__MIR.n7 VGND 0.86157f $ **FLOATING
C120 VCM_BUFFER__FIRST__MIR.n8 VGND 1.93673f $ **FLOATING
C121 VCM_BUFFER__FIRST__MIR.n9 VGND 1.05863f $ **FLOATING
C122 VCM_BUFFER__FIRST__MIR.n10 VGND 1.95778f $ **FLOATING
C123 VCM_BUFFER__FIRST__MIR.n11 VGND 0.02901f $ **FLOATING
C124 VCM_RAW.t10 VGND 0.00941f $ **FLOATING
C125 VCM_RAW.t0 VGND 0.02883f $ **FLOATING
C126 VCM_RAW.t1 VGND 0.01205f $ **FLOATING
C127 VCM_RAW.n0 VGND 0.04632f $ **FLOATING
C128 VCM_RAW.t14 VGND 1.52356f $ **FLOATING
C129 VCM_RAW.n1 VGND 0.03104f $ **FLOATING
C130 VCM_RAW.t12 VGND 1.52356f $ **FLOATING
C131 VCM_RAW.n2 VGND 0.03006f $ **FLOATING
C132 VCM_RAW.t5 VGND 1.52356f $ **FLOATING
C133 VCM_RAW.n3 VGND 0.03006f $ **FLOATING
C134 VCM_RAW.t9 VGND 1.52356f $ **FLOATING
C135 VCM_RAW.n4 VGND 0.03006f $ **FLOATING
C136 VCM_RAW.t2 VGND 1.52356f $ **FLOATING
C137 VCM_RAW.n5 VGND 0.03006f $ **FLOATING
C138 VCM_RAW.t13 VGND 1.52356f $ **FLOATING
C139 VCM_RAW.n6 VGND 0.03006f $ **FLOATING
C140 VCM_RAW.t3 VGND 1.52356f $ **FLOATING
C141 VCM_RAW.n7 VGND 0.03006f $ **FLOATING
C142 VCM_RAW.t8 VGND 1.52356f $ **FLOATING
C143 VCM_RAW.n8 VGND 0.03006f $ **FLOATING
C144 VCM_RAW.t15 VGND 1.52356f $ **FLOATING
C145 VCM_RAW.n9 VGND 0.03006f $ **FLOATING
C146 VCM_RAW.t7 VGND 1.52356f $ **FLOATING
C147 VCM_RAW.n10 VGND 0.03006f $ **FLOATING
C148 VCM_RAW.t11 VGND 1.52356f $ **FLOATING
C149 VCM_RAW.n11 VGND 0.03006f $ **FLOATING
C150 VCM_RAW.t4 VGND 1.52356f $ **FLOATING
C151 VCM_RAW.n12 VGND 0.02605f $ **FLOATING
C152 VCM_RAW.t6 VGND 0.00941f $ **FLOATING
C153 VCM_RAW.n13 VGND 0.0507f $ **FLOATING
rmesh_equiv_0 bias bias.n0 4.2590000000000003
rmesh_equiv_1 bias bias.n1 19.837
rmesh_equiv_10 bias.n1 bias.n2 14.189499999999999
rmesh_equiv_100 vcm_buffer__first__tail.n15 vcm_buffer__first__tail.n16 20.720400000000001
rmesh_equiv_101 vcm_buffer__first__tail.n16 vcm_buffer__first__tail.n17 3.0467200000000001
rmesh_equiv_102 vcm_buffer__first__tail.n17 vcm_buffer__first__tail.t0 181.41
rmesh_equiv_103 vcm_buffer__first__tail.n2 vcm_buffer__first__tail.n3 5.2415200000000004
rmesh_equiv_104 vcm_buffer__first__tail.n2 vcm_buffer__first__tail.t2 174.857
rmesh_equiv_105 vcm_buffer__first__tail.n3 vcm_buffer__first__tail.n7 19.131799999999998
rmesh_equiv_106 vcm_buffer__first__tail.n4 vcm_buffer__first__tail.n6 5.2415200000000004
rmesh_equiv_107 vcm_buffer__first__tail.n4 vcm_buffer__first__tail.t3 174.857
rmesh_equiv_108 vcm_buffer__first__tail.n5 vcm_buffer__first__tail.n6 5.2415200000000004
rmesh_equiv_109 vcm_buffer__first__tail.n5 vcm_buffer__first__tail.t3 174.857
rmesh_equiv_11 bias.n1 bias.t1 174.91200000000001
rmesh_equiv_110 vcm_buffer__first__tail.n6 vcm_buffer__first__tail.n7 18.2212
rmesh_equiv_111 vcm_buffer__first__tail.n8 vcm_buffer__first__tail.t4 174.857
rmesh_equiv_112 vcm_buffer__first__tail.n9 vcm_buffer__first__tail.t4 174.857
rmesh_equiv_113 vcm_buffer__pre vcm_buffer__pre.n0 22.8553
rmesh_equiv_114 vcm_buffer__pre vcm_buffer__pre.n1 3.0716771718006117
rmesh_equiv_115 vcm_buffer__pre vcm_buffer__pre.n13 4.8770699999999998
rmesh_equiv_116 vcm_buffer__pre vcm_buffer__pre.n2 4.7030000000000003
rmesh_equiv_117 vcm_buffer__pre vcm_buffer__pre.n3 27.632600000000004
rmesh_equiv_118 vcm_buffer__pre vcm_buffer__pre.n4 15.6333
rmesh_equiv_119 vcm_buffer__pre vcm_buffer__pre.n5 15.6333
rmesh_equiv_12 bias.n2 bias.n3 16.554500000000001
rmesh_equiv_120 vcm_buffer__pre vcm_buffer__pre.n7 15.6333
rmesh_equiv_121 vcm_buffer__pre vcm_buffer__pre.n8 15.6333
rmesh_equiv_122 vcm_buffer__pre vcm_buffer__pre.t3 0.00141837
rmesh_equiv_123 vcm_buffer__pre vcm_buffer__pre.t4 0.00141837
rmesh_equiv_124 vcm_buffer__pre vcm_buffer__pre.t5 0.00141837
rmesh_equiv_125 vcm_buffer__pre vcm_buffer__pre.t6 1054.8499999999999
rmesh_equiv_126 vcm_buffer__pre.n0 vcm_buffer__pre.n12 11.4361
rmesh_equiv_127 vcm_buffer__pre.n0 vcm_buffer__pre.t0 381.113
rmesh_equiv_128 vcm_buffer__pre.n1 vcm_buffer__pre.n2 4.1529499999999997
rmesh_equiv_129 vcm_buffer__pre.n10 vcm_buffer__pre.n11 1.8528899999999999
rmesh_equiv_13 bias.n3 bias.n4 0.39353700000000003
rmesh_equiv_130 vcm_buffer__pre.n10 vcm_buffer__pre.n6 20.559899999999999
rmesh_equiv_131 vcm_buffer__pre.n10 vcm_buffer__pre.n9 17.804500000000001
rmesh_equiv_132 vcm_buffer__pre.n11 vcm_buffer__pre.n12 17.804500000000001
rmesh_equiv_133 vcm_buffer__pre.n11 vcm_buffer__pre.n3 2.2512099999999999
rmesh_equiv_134 vcm_buffer__pre.n12 vcm_buffer__pre.n13 2.4407800000000002
rmesh_equiv_135 vcm_buffer__pre.n13 vcm_buffer__pre.t0 387.11000000000001
rmesh_equiv_136 vcm_buffer__pre.n2 vcm_buffer__pre.n3 3.1113099999999996
rmesh_equiv_137 vcm_buffer__pre.n4 vcm_buffer__pre.n6 5.2415200000000004
rmesh_equiv_138 vcm_buffer__pre.n4 vcm_buffer__pre.t1 174.857
rmesh_equiv_139 vcm_buffer__pre.n5 vcm_buffer__pre.n6 5.2415200000000004
rmesh_equiv_14 bias.n4 bias.n5 0.79479999999999995
rmesh_equiv_140 vcm_buffer__pre.n5 vcm_buffer__pre.t1 174.857
rmesh_equiv_141 vcm_buffer__pre.n7 vcm_buffer__pre.n9 5.2415200000000004
rmesh_equiv_142 vcm_buffer__pre.n7 vcm_buffer__pre.t2 174.857
rmesh_equiv_143 vcm_buffer__pre.n8 vcm_buffer__pre.n9 5.2415200000000004
rmesh_equiv_144 vcm_buffer__pre.n8 vcm_buffer__pre.t2 174.857
rmesh_equiv_145 vcm_raw vcm_raw.n1 4.5902000000000003
rmesh_equiv_146 vcm_raw vcm_raw.n10 4.5902000000000003
rmesh_equiv_147 vcm_raw vcm_raw.n11 4.5902000000000003
rmesh_equiv_148 vcm_raw vcm_raw.n12 4.5902000000000003
rmesh_equiv_149 vcm_raw vcm_raw.n13 17.315439116953431
rmesh_equiv_15 bias.n5 bias.n6 62.323700000000002
rmesh_equiv_150 vcm_raw vcm_raw.n2 4.5902000000000003
rmesh_equiv_151 vcm_raw vcm_raw.n3 4.5902000000000003
rmesh_equiv_152 vcm_raw vcm_raw.n4 4.5902000000000003
rmesh_equiv_153 vcm_raw vcm_raw.n5 4.5902000000000003
rmesh_equiv_154 vcm_raw vcm_raw.n6 4.5902000000000003
rmesh_equiv_155 vcm_raw vcm_raw.n7 4.5902000000000003
rmesh_equiv_156 vcm_raw vcm_raw.n8 4.5902000000000003
rmesh_equiv_157 vcm_raw vcm_raw.n9 4.5902000000000003
rmesh_equiv_158 vcm_raw vcm_raw.t10 212.21199999999999
rmesh_equiv_159 vcm_raw vcm_raw.t11 0.00141837
rmesh_equiv_16 bias.n5 bias.t2 31.571200000000001
rmesh_equiv_160 vcm_raw vcm_raw.t12 0.00141837
rmesh_equiv_161 vcm_raw vcm_raw.t13 0.00141837
rmesh_equiv_162 vcm_raw vcm_raw.t14 0.00141837
rmesh_equiv_163 vcm_raw vcm_raw.t15 0.00141837
rmesh_equiv_164 vcm_raw vcm_raw.t2 0.00141837
rmesh_equiv_165 vcm_raw vcm_raw.t3 0.00141837
rmesh_equiv_166 vcm_raw vcm_raw.t4 0.00141837
rmesh_equiv_167 vcm_raw vcm_raw.t5 0.00141837
rmesh_equiv_168 vcm_raw vcm_raw.t6 212.21199999999999
rmesh_equiv_169 vcm_raw vcm_raw.t7 0.00141837
rmesh_equiv_17 r_vcm_bottom_r0_n0.t0 r_vcm_bottom_r0_n0.t1 57.627400000000002
rmesh_equiv_170 vcm_raw vcm_raw.t8 0.00141837
rmesh_equiv_171 vcm_raw vcm_raw.t9 0.00141837
rmesh_equiv_172 vcm_raw.n0 vcm_raw.n1 4.4643300000000004
rmesh_equiv_173 vcm_raw.n0 vcm_raw.t0 23.640799999999999
rmesh_equiv_174 vcm_raw.n0 vcm_raw.t1 23.340499999999999
rmesh_equiv_175 vcm_raw.n1 vcm_raw.n2 4.1529499999999997
rmesh_equiv_176 vcm_raw.n10 vcm_raw.n11 4.1529499999999997
rmesh_equiv_177 vcm_raw.n10 vcm_raw.n9 4.1529499999999997
rmesh_equiv_178 vcm_raw.n11 vcm_raw.n12 4.1529499999999997
rmesh_equiv_179 vcm_raw.n12 vcm_raw.n13 2.8816000000000002
rmesh_equiv_18 r_vcm_bottom_r0_n1.t0 r_vcm_bottom_r0_n1.t1 47.8142
rmesh_equiv_180 vcm_raw.n2 vcm_raw.n3 4.1529499999999997
rmesh_equiv_181 vcm_raw.n3 vcm_raw.n4 4.1529499999999997
rmesh_equiv_182 vcm_raw.n4 vcm_raw.n5 4.1529499999999997
rmesh_equiv_183 vcm_raw.n5 vcm_raw.n6 4.1529499999999997
rmesh_equiv_184 vcm_raw.n6 vcm_raw.n7 4.1529499999999997
rmesh_equiv_185 vcm_raw.n7 vcm_raw.n8 4.1529499999999997
rmesh_equiv_186 vcm_raw.n8 vcm_raw.n9 4.1529499999999997
rmesh_equiv_187 vgnd vgnd.n1106 39128.727499954839
rmesh_equiv_188 vgnd vgnd.n1526 137.94060233444205
rmesh_equiv_189 vgnd vgnd.n1528 592.58442473747562
rmesh_equiv_19 r_vcm_top_r0_n0.t0 r_vcm_top_r0_n0.t1 56.7941
rmesh_equiv_190 vgnd vgnd.n1530 1380.8136458625729
rmesh_equiv_191 vgnd vgnd.n185 317.09136811126029
rmesh_equiv_192 vgnd vgnd.n221 14684.703893909062
rmesh_equiv_193 vgnd vgnd.n225 1906.2618614348219
rmesh_equiv_194 vgnd vgnd.n268 169.26347762818747
rmesh_equiv_195 vgnd vgnd.n270 8076.9525291074597
rmesh_equiv_196 vgnd vgnd.n272 164.35716309672193
rmesh_equiv_197 vgnd vgnd.n3073 227.97526774298768
rmesh_equiv_198 vgnd vgnd.n3078 11943.330469006574
rmesh_equiv_199 vgnd vgnd.n3092 209.64011782638775
rmesh_equiv_2 bias bias.n3 0.25606299999999999
rmesh_equiv_20 r_vcm_top_r0_n1.t0 r_vcm_top_r0_n1.t1 56.7941
rmesh_equiv_200 vgnd vgnd.n3486 20.93396131186871
rmesh_equiv_201 vgnd vgnd.n3494 35.846238334892789
rmesh_equiv_202 vgnd vgnd.n3783 239.91784655928026
rmesh_equiv_203 vgnd vgnd.n3801 279.57327934432823
rmesh_equiv_204 vgnd vgnd.n401 233.37088440488969
rmesh_equiv_205 vgnd vgnd.t0 183.67620061446524
rmesh_equiv_206 vgnd vgnd.t1 96.381960109746316
rmesh_equiv_207 vgnd vgnd.t10 193.90903061100875
rmesh_equiv_208 vgnd vgnd.t14 122.07069158324995
rmesh_equiv_209 vgnd vgnd.t16 16.81381862424767
rmesh_equiv_21 vcm vcm.n0 19.837
rmesh_equiv_210 vgnd vgnd.t19 130.58620409594522
rmesh_equiv_211 vgnd vgnd.t2 682.65645467364288
rmesh_equiv_212 vgnd vgnd.t20 200.1181239511547
rmesh_equiv_213 vgnd vgnd.t21 62.673827414025652
rmesh_equiv_214 vgnd vgnd.t22 122.27487861967562
rmesh_equiv_215 vgnd vgnd.t23 93.494184721272632
rmesh_equiv_216 vgnd vgnd.t24 213.94102574378584
rmesh_equiv_217 vgnd vgnd.t25 124.47020647774907
rmesh_equiv_218 vgnd vgnd.t26 130.02266705785141
rmesh_equiv_219 vgnd vgnd.t27 123.84577036485558
rmesh_equiv_22 vcm vcm.n1 4.2590000000000003
rmesh_equiv_220 vgnd vgnd.t28 123.96476019218369
rmesh_equiv_221 vgnd vgnd.t29 121.99381063973436
rmesh_equiv_222 vgnd vgnd.t30 122.40927051186965
rmesh_equiv_223 vgnd vgnd.t4 96.936822220921769
rmesh_equiv_224 vgnd vgnd.t6 27.201151640767154
rmesh_equiv_225 vgnd vgnd.t9 46.569770070194387
rmesh_equiv_226 vgnd.n1106 vgnd.n1526 9995.7258264195734
rmesh_equiv_227 vgnd.n1106 vgnd.n1528 40300.191865973611
rmesh_equiv_228 vgnd.n1106 vgnd.n1530 1015.5527750572817
rmesh_equiv_229 vgnd.n1106 vgnd.n3073 2894.570007887382
rmesh_equiv_23 vcm vcm.n10 21.139272246169156
rmesh_equiv_230 vgnd.n1106 vgnd.n3078 343.34541212197058
rmesh_equiv_231 vgnd.n1106 vgnd.n3092 318920.09376239468
rmesh_equiv_232 vgnd.n1106 vgnd.t2 453.69734250764861
rmesh_equiv_233 vgnd.n1106 vgnd.t24 46662.319670026627
rmesh_equiv_234 vgnd.n1526 vgnd.n1528 768.52070091504072
rmesh_equiv_235 vgnd.n1526 vgnd.n1530 314.87464874872961
rmesh_equiv_236 vgnd.n1526 vgnd.n3073 175966.55181269679
rmesh_equiv_237 vgnd.n1526 vgnd.n3078 1408.8979443677138
rmesh_equiv_238 vgnd.n1526 vgnd.n3092 21833.567733319385
rmesh_equiv_239 vgnd.n1526 vgnd.t2 33382.04903529679
rmesh_equiv_24 vcm vcm.n4 33.9895
rmesh_equiv_240 vgnd.n1526 vgnd.t24 3194.5460227675999
rmesh_equiv_241 vgnd.n1528 vgnd.n1530 472.2835904389089
rmesh_equiv_242 vgnd.n1528 vgnd.n3073 21034.337646736076
rmesh_equiv_243 vgnd.n1528 vgnd.n3078 7719.2275935614625
rmesh_equiv_244 vgnd.n1528 vgnd.n3092 135687.52126313967
rmesh_equiv_245 vgnd.n1528 vgnd.t2 3990.3565962680191
rmesh_equiv_246 vgnd.n1528 vgnd.t24 19852.918070227701
rmesh_equiv_247 vgnd.n1530 vgnd.n3073 31743.997728899994
rmesh_equiv_248 vgnd.n1530 vgnd.n3078 454.46822196656876
rmesh_equiv_249 vgnd.n1530 vgnd.n3092 10255.464817948714
rmesh_equiv_25 vcm vcm.n6 6.9688099999999995
rmesh_equiv_250 vgnd.n1530 vgnd.t2 27.506385055017503
rmesh_equiv_251 vgnd.n1530 vgnd.t24 1500.5130973539854
rmesh_equiv_252 vgnd.n185 vgnd.n221 8518.8704474047481
rmesh_equiv_253 vgnd.n185 vgnd.n225 1105.8560684540639
rmesh_equiv_254 vgnd.n185 vgnd.n233 13577115.258821832
rmesh_equiv_255 vgnd.n185 vgnd.n245 744359.08502652438
rmesh_equiv_256 vgnd.n185 vgnd.n247 5472116.0432187133
rmesh_equiv_257 vgnd.n185 vgnd.n248 395375.46931309649
rmesh_equiv_258 vgnd.n185 vgnd.n250 1785700.9542265299
rmesh_equiv_259 vgnd.n185 vgnd.n268 2895.8018898371597
rmesh_equiv_26 vcm vcm.n9 32.891300000000001
rmesh_equiv_260 vgnd.n185 vgnd.n270 369.59779367798893
rmesh_equiv_261 vgnd.n185 vgnd.n272 1540.0362363369115
rmesh_equiv_262 vgnd.n185 vgnd.n3783 10918.195470440754
rmesh_equiv_263 vgnd.n185 vgnd.n3801 181269.72176901661
rmesh_equiv_264 vgnd.n221 vgnd.n225 25511.409503124058
rmesh_equiv_265 vgnd.n221 vgnd.n227 63210.081951182285
rmesh_equiv_266 vgnd.n221 vgnd.n228 1246.4325845872922
rmesh_equiv_267 vgnd.n221 vgnd.n256 1602.6455941866429
rmesh_equiv_268 vgnd.n221 vgnd.n260 793.44914362031
rmesh_equiv_269 vgnd.n221 vgnd.n262 35581.5948143403
rmesh_equiv_27 vcm vcm.t3 212.21199999999999
rmesh_equiv_270 vgnd.n221 vgnd.n268 35149.541188472424
rmesh_equiv_271 vgnd.n221 vgnd.n270 697.55506021508097
rmesh_equiv_272 vgnd.n221 vgnd.n272 447.58057305186935
rmesh_equiv_273 vgnd.n225 vgnd.n227 11825.13468727295
rmesh_equiv_274 vgnd.n225 vgnd.n260 7328.6908875007684
rmesh_equiv_275 vgnd.n225 vgnd.n262 6656.4879854530382
rmesh_equiv_276 vgnd.n225 vgnd.n268 472.41796020972009
rmesh_equiv_277 vgnd.n225 vgnd.n270 641.99811307556843
rmesh_equiv_278 vgnd.n225 vgnd.n272 15821.414558644625
rmesh_equiv_279 vgnd.n227 vgnd.n228 9988.6308671392981
rmesh_equiv_28 vcm vcm.t4 212.21199999999999
rmesh_equiv_280 vgnd.n227 vgnd.n233 1246.4325845872922
rmesh_equiv_281 vgnd.n227 vgnd.n250 1602.6455941866429
rmesh_equiv_282 vgnd.n227 vgnd.n254 975.59686257543387
rmesh_equiv_283 vgnd.n227 vgnd.n260 1545.1765253692276
rmesh_equiv_284 vgnd.n227 vgnd.n262 471.40400710926707
rmesh_equiv_285 vgnd.n227 vgnd.n268 6656.4879854530382
rmesh_equiv_286 vgnd.n227 vgnd.n270 7328.6908875007684
rmesh_equiv_287 vgnd.n227 vgnd.t3 993.92170248666491
rmesh_equiv_288 vgnd.n228 vgnd.n233 70069.957449482608
rmesh_equiv_289 vgnd.n228 vgnd.n245 32137.761149739021
rmesh_equiv_29 vcm.n0 vcm.n2 14.189499999999999
rmesh_equiv_290 vgnd.n228 vgnd.n247 3853.3103881033862
rmesh_equiv_291 vgnd.n228 vgnd.n248 13944.640198677294
rmesh_equiv_292 vgnd.n228 vgnd.n254 879.60391700341245
rmesh_equiv_293 vgnd.n228 vgnd.n256 464.38003136541266
rmesh_equiv_294 vgnd.n228 vgnd.n260 1915.8741659494272
rmesh_equiv_295 vgnd.n228 vgnd.n272 1602.6455941866429
rmesh_equiv_296 vgnd.n228 vgnd.t3 993.92170248666491
rmesh_equiv_297 vgnd.n233 vgnd.n245 9296.4194495191859
rmesh_equiv_298 vgnd.n233 vgnd.n247 18193.851156858815
rmesh_equiv_299 vgnd.n233 vgnd.n248 687.64293728023881
rmesh_equiv_3 bias bias.n4 32.995399999999997
rmesh_equiv_30 vcm.n0 vcm.t0 174.91200000000001
rmesh_equiv_300 vgnd.n233 vgnd.n250 456.58883377745701
rmesh_equiv_301 vgnd.n233 vgnd.n254 795.02558533839033
rmesh_equiv_302 vgnd.n233 vgnd.n256 29319.520554541836
rmesh_equiv_303 vgnd.n233 vgnd.n262 1602.6455941866429
rmesh_equiv_304 vgnd.n233 vgnd.n3783 781531.07532870758
rmesh_equiv_305 vgnd.n233 vgnd.n3801 542043.61762842594
rmesh_equiv_306 vgnd.n245 vgnd.n247 858.44275073716051
rmesh_equiv_307 vgnd.n245 vgnd.n248 678.80431226276642
rmesh_equiv_308 vgnd.n245 vgnd.n250 190.97680430000369
rmesh_equiv_309 vgnd.n245 vgnd.n254 19917.550498283981
rmesh_equiv_31 vcm.n1 vcm.n2 3.0467200000000001
rmesh_equiv_310 vgnd.n245 vgnd.n256 140.01165168681891
rmesh_equiv_311 vgnd.n245 vgnd.n3783 42847.080919747124
rmesh_equiv_312 vgnd.n245 vgnd.n3801 29717.291454839899
rmesh_equiv_313 vgnd.n247 vgnd.n248 466.2505705850956
rmesh_equiv_314 vgnd.n247 vgnd.n250 15558.592268463875
rmesh_equiv_315 vgnd.n247 vgnd.n254 2388.1098587738652
rmesh_equiv_316 vgnd.n247 vgnd.n256 636.59782753373258
rmesh_equiv_317 vgnd.n247 vgnd.n3783 314988.0261052819
rmesh_equiv_318 vgnd.n247 vgnd.n3801 218465.08036540067
rmesh_equiv_319 vgnd.n248 vgnd.n250 939.1062892685278
rmesh_equiv_32 vcm.n1 vcm.t0 181.41
rmesh_equiv_320 vgnd.n248 vgnd.n254 270.4435322960486
rmesh_equiv_321 vgnd.n248 vgnd.n256 5834.8853033851556
rmesh_equiv_322 vgnd.n248 vgnd.n3783 22758.753225585442
rmesh_equiv_323 vgnd.n248 vgnd.n3801 15784.7043074012
rmesh_equiv_324 vgnd.n250 vgnd.n254 6276.5027873174149
rmesh_equiv_325 vgnd.n250 vgnd.n262 112.9598387496471
rmesh_equiv_326 vgnd.n250 vgnd.n3783 102789.19787952525
rmesh_equiv_327 vgnd.n250 vgnd.n3801 71291.123834465659
rmesh_equiv_328 vgnd.n254 vgnd.n256 1567.0326138588462
rmesh_equiv_329 vgnd.n254 vgnd.n262 6276.5027873174149
rmesh_equiv_33 vcm.n10 vcm.n9 0.91112499999999996
rmesh_equiv_330 vgnd.n254 vgnd.t3 197.80061286358978
rmesh_equiv_331 vgnd.n256 vgnd.n260 6276.5027873174149
rmesh_equiv_332 vgnd.n256 vgnd.n272 112.9598387496471
rmesh_equiv_333 vgnd.n260 vgnd.n262 1705.3883660446511
rmesh_equiv_334 vgnd.n260 vgnd.n268 4125.3942666929725
rmesh_equiv_335 vgnd.n260 vgnd.n270 263.01346535148565
rmesh_equiv_336 vgnd.n260 vgnd.n272 6276.5027873174149
rmesh_equiv_337 vgnd.n260 vgnd.t3 58.210600000000007
rmesh_equiv_338 vgnd.n262 vgnd.n268 51.600789359185825
rmesh_equiv_339 vgnd.n262 vgnd.n270 4125.3942666929725
rmesh_equiv_34 vcm.n2 vcm.n3 16.9712
rmesh_equiv_340 vgnd.n268 vgnd.n270 1703.5636641986459
rmesh_equiv_341 vgnd.n268 vgnd.n272 233783.07302186851
rmesh_equiv_342 vgnd.n270 vgnd.n272 1215.9640626449034
rmesh_equiv_343 vgnd.n3073 vgnd.n3078 237.35461388997064
rmesh_equiv_344 vgnd.n3073 vgnd.t2 108.24481052468347
rmesh_equiv_345 vgnd.n3073 vgnd.t22 535434493.01057059
rmesh_equiv_346 vgnd.n3073 vgnd.t25 6001766.6515317056
rmesh_equiv_347 vgnd.n3073 vgnd.t26 700.51403585529033
rmesh_equiv_348 vgnd.n3073 vgnd.t27 64865.844176613471
rmesh_equiv_349 vgnd.n3078 vgnd.n3092 44899.991514757749
rmesh_equiv_35 vcm.n3 vcm.n8 0.91758700000000015
rmesh_equiv_350 vgnd.n3078 vgnd.t2 1551.4314544748129
rmesh_equiv_351 vgnd.n3078 vgnd.t24 6569.4755464484824
rmesh_equiv_352 vgnd.n3092 vgnd.n401 484784.7533320947
rmesh_equiv_353 vgnd.n3092 vgnd.t19 700.52104163583545
rmesh_equiv_354 vgnd.n3092 vgnd.t20 70930.560894638082
rmesh_equiv_355 vgnd.n3092 vgnd.t24 88.513937932929494
rmesh_equiv_356 vgnd.n3486 vgnd.n3490 65.2357795679806
rmesh_equiv_357 vgnd.n3486 vgnd.t11 30.599098159756974
rmesh_equiv_358 vgnd.n3486 vgnd.t15 12.703646861012352
rmesh_equiv_359 vgnd.n3486 vgnd.t18 84.751298768036492
rmesh_equiv_36 vcm.n3 vcm.t2 42.654000000000003
rmesh_equiv_360 vgnd.n3486 vgnd.t21 161.30522391135551
rmesh_equiv_361 vgnd.n3486 vgnd.t23 54088.872948543649
rmesh_equiv_362 vgnd.n3486 vgnd.t6 12.308947064526558
rmesh_equiv_363 vgnd.n3486 vgnd.t8 5.3953199999999999
rmesh_equiv_364 vgnd.n3490 vgnd.n3494 65.2357795679806
rmesh_equiv_365 vgnd.n3490 vgnd.t11 30.599098159756974
rmesh_equiv_366 vgnd.n3490 vgnd.t12 30.599098159756974
rmesh_equiv_367 vgnd.n3490 vgnd.t15 84.751298768036492
rmesh_equiv_368 vgnd.n3490 vgnd.t17 12.703646861012352
rmesh_equiv_369 vgnd.n3490 vgnd.t18 12.703646861012352
rmesh_equiv_37 vcm.n4 vcm.n5 13.2728
rmesh_equiv_370 vgnd.n3490 vgnd.t5 84.751298768036492
rmesh_equiv_371 vgnd.n3490 vgnd.t7 5.3953199999999999
rmesh_equiv_372 vgnd.n3494 vgnd.t1 11309.29001720871
rmesh_equiv_373 vgnd.n3494 vgnd.t12 30.599098159756974
rmesh_equiv_374 vgnd.n3494 vgnd.t13 5.3953199999999999
rmesh_equiv_375 vgnd.n3494 vgnd.t16 31.098854118739606
rmesh_equiv_376 vgnd.n3494 vgnd.t17 84.751298768036492
rmesh_equiv_377 vgnd.n3494 vgnd.t4 9614.2484551512098
rmesh_equiv_378 vgnd.n3494 vgnd.t5 12.703646861012352
rmesh_equiv_379 vgnd.n3494 vgnd.t9 12.734320933203961
rmesh_equiv_38 vcm.n4 vcm.n7 0.51338700000000004
rmesh_equiv_380 vgnd.n3783 vgnd.n3801 10434.316707050519
rmesh_equiv_381 vgnd.n3783 vgnd.n401 535379059639.25684
rmesh_equiv_382 vgnd.n3783 vgnd.t10 86.74664126022752
rmesh_equiv_383 vgnd.n3783 vgnd.t14 108521638.04895565
rmesh_equiv_384 vgnd.n3783 vgnd.t29 1013254.579182346
rmesh_equiv_385 vgnd.n3783 vgnd.t30 9375.3133268809652
rmesh_equiv_386 vgnd.n3801 vgnd.t0 90.653601458329888
rmesh_equiv_387 vgnd.n3801 vgnd.t28 237197.09854598984
rmesh_equiv_388 vgnd.n401 vgnd.t10 65695812138.121758
rmesh_equiv_389 vgnd.n401 vgnd.t14 48206.685690890081
rmesh_equiv_39 vcm.n5 vcm.n6 13.200100000000001
rmesh_equiv_390 vgnd.n401 vgnd.t19 8204.273409229485
rmesh_equiv_391 vgnd.n401 vgnd.t20 88.48047787704499
rmesh_equiv_392 vgnd.n401 vgnd.t29 5210032.0716846399
rmesh_equiv_393 vgnd.n401 vgnd.t30 563087981.57976198
rmesh_equiv_394 vgnd.t0 vgnd.t28 17689.838039179642
rmesh_equiv_395 vgnd.t1 vgnd.t16 5304.6668200402892
rmesh_equiv_396 vgnd.t1 vgnd.t4 155646.88144551334
rmesh_equiv_397 vgnd.t1 vgnd.t9 14692.504994196057
rmesh_equiv_398 vgnd.t10 vgnd.t14 13316578.259503281
rmesh_equiv_399 vgnd.t10 vgnd.t29 124335.4241888134
rmesh_equiv_4 bias bias.n6 16.94664149193358
rmesh_equiv_40 vcm.n5 vcm.t1 0.71462499999999995
rmesh_equiv_400 vgnd.t10 vgnd.t30 1150.4350272381082
rmesh_equiv_401 vgnd.t11 vgnd.t15 39.752928950095715
rmesh_equiv_402 vgnd.t11 vgnd.t18 39.752928950095715
rmesh_equiv_403 vgnd.t12 vgnd.t17 39.752928950095715
rmesh_equiv_404 vgnd.t12 vgnd.t5 39.752928950095715
rmesh_equiv_405 vgnd.t14 vgnd.t29 1056.0764462618008
rmesh_equiv_406 vgnd.t14 vgnd.t30 114138.2521906825
rmesh_equiv_407 vgnd.t15 vgnd.t18 110.10495605994841
rmesh_equiv_408 vgnd.t16 vgnd.t4 4509.6009300371479
rmesh_equiv_409 vgnd.t16 vgnd.t9 40.402188710174251
rmesh_equiv_41 vcm.n6 vcm.n7 0.27270899999999998
rmesh_equiv_410 vgnd.t17 vgnd.t5 110.10495605994841
rmesh_equiv_411 vgnd.t19 vgnd.t20 1200.3960740303376
rmesh_equiv_412 vgnd.t21 vgnd.t23 161935.7482176208
rmesh_equiv_413 vgnd.t21 vgnd.t6 209.59663537607847
rmesh_equiv_414 vgnd.t22 vgnd.t25 1052.7471903982259
rmesh_equiv_415 vgnd.t22 vgnd.t26 9061446.6111291498
rmesh_equiv_416 vgnd.t22 vgnd.t27 97724.818080863261
rmesh_equiv_417 vgnd.t23 vgnd.t6 70281.950617600887
rmesh_equiv_418 vgnd.t25 vgnd.t26 101571.13296814864
rmesh_equiv_419 vgnd.t25 vgnd.t27 1095.4123461245681
rmesh_equiv_42 vcm.n7 vcm.n8 16.9712
rmesh_equiv_420 vgnd.t26 vgnd.t27 1097.7596541965811
rmesh_equiv_421 vgnd.t29 vgnd.t30 1065.6962866696374
rmesh_equiv_422 vgnd.t4 vgnd.t9 12490.385623483651
rmesh_equiv_43 vcm.n8 vcm.n9 4.2281500000000003
rmesh_equiv_44 vcm_buffer__comp.n0 vcm_buffer__comp.n1 4.1529499999999997
rmesh_equiv_45 vcm_buffer__comp.n0 vcm_buffer__comp.t0 4.7185199999999998
rmesh_equiv_46 vcm_buffer__comp.n0 vcm_buffer__comp.t3 26.609300000000001
rmesh_equiv_47 vcm_buffer__comp.n1 vcm_buffer__comp.n2 4.7105199999999998
rmesh_equiv_48 vcm_buffer__comp.n1 vcm_buffer__comp.t1 8.8709699999999998
rmesh_equiv_49 vcm_buffer__comp.n2 vcm_buffer__comp.t2 0.025939499999999997
rmesh_equiv_5 bias bias.t0 139.911
rmesh_equiv_50 vcm_buffer__first__mir vcm_buffer__first__mir.n0 22.8553
rmesh_equiv_51 vcm_buffer__first__mir vcm_buffer__first__mir.n1 16.196684669883751
rmesh_equiv_52 vcm_buffer__first__mir vcm_buffer__first__mir.n11 4.8770699999999998
rmesh_equiv_53 vcm_buffer__first__mir vcm_buffer__first__mir.n2 15.6333
rmesh_equiv_54 vcm_buffer__first__mir vcm_buffer__first__mir.n3 15.6333
rmesh_equiv_55 vcm_buffer__first__mir vcm_buffer__first__mir.n5 15.6333
rmesh_equiv_56 vcm_buffer__first__mir vcm_buffer__first__mir.n6 15.6333
rmesh_equiv_57 vcm_buffer__first__mir vcm_buffer__first__mir.t0 572.84699999999998
rmesh_equiv_58 vcm_buffer__first__mir vcm_buffer__first__mir.t4 572.84699999999998
rmesh_equiv_59 vcm_buffer__first__mir.n0 vcm_buffer__first__mir.n10 11.4361
rmesh_equiv_6 bias bias.t3 139.911
rmesh_equiv_60 vcm_buffer__first__mir.n0 vcm_buffer__first__mir.t1 381.113
rmesh_equiv_61 vcm_buffer__first__mir.n1 vcm_buffer__first__mir.n9 0.39353700000000003
rmesh_equiv_62 vcm_buffer__first__mir.n10 vcm_buffer__first__mir.n11 2.4407800000000002
rmesh_equiv_63 vcm_buffer__first__mir.n10 vcm_buffer__first__mir.n9 18.637899999999998
rmesh_equiv_64 vcm_buffer__first__mir.n11 vcm_buffer__first__mir.t1 387.11000000000001
rmesh_equiv_65 vcm_buffer__first__mir.n2 vcm_buffer__first__mir.n4 5.2415200000000004
rmesh_equiv_66 vcm_buffer__first__mir.n2 vcm_buffer__first__mir.t2 174.857
rmesh_equiv_67 vcm_buffer__first__mir.n3 vcm_buffer__first__mir.n4 5.2415200000000004
rmesh_equiv_68 vcm_buffer__first__mir.n3 vcm_buffer__first__mir.t2 174.857
rmesh_equiv_69 vcm_buffer__first__mir.n4 vcm_buffer__first__mir.n8 19.548500000000001
rmesh_equiv_7 bias bias.t4 139.911
rmesh_equiv_70 vcm_buffer__first__mir.n5 vcm_buffer__first__mir.n7 5.2415200000000004
rmesh_equiv_71 vcm_buffer__first__mir.n5 vcm_buffer__first__mir.t3 174.857
rmesh_equiv_72 vcm_buffer__first__mir.n6 vcm_buffer__first__mir.n7 5.2415200000000004
rmesh_equiv_73 vcm_buffer__first__mir.n6 vcm_buffer__first__mir.t3 174.857
rmesh_equiv_74 vcm_buffer__first__mir.n7 vcm_buffer__first__mir.n8 18.637899999999998
rmesh_equiv_75 vcm_buffer__first__mir.n8 vcm_buffer__first__mir.n9 1.83996
rmesh_equiv_76 vcm_buffer__first__tail vcm_buffer__first__tail.n0 19.837
rmesh_equiv_77 vcm_buffer__first__tail vcm_buffer__first__tail.n1 15.6333
rmesh_equiv_78 vcm_buffer__first__tail vcm_buffer__first__tail.n12 15.6333
rmesh_equiv_79 vcm_buffer__first__tail vcm_buffer__first__tail.n13 15.6333
rmesh_equiv_8 bias.n0 bias.n2 3.0467200000000001
rmesh_equiv_80 vcm_buffer__first__tail vcm_buffer__first__tail.n17 4.2590000000000003
rmesh_equiv_81 vcm_buffer__first__tail vcm_buffer__first__tail.n2 15.6333
rmesh_equiv_82 vcm_buffer__first__tail vcm_buffer__first__tail.n4 15.6333
rmesh_equiv_83 vcm_buffer__first__tail vcm_buffer__first__tail.n5 15.6333
rmesh_equiv_84 vcm_buffer__first__tail vcm_buffer__first__tail.n8 15.6333
rmesh_equiv_85 vcm_buffer__first__tail vcm_buffer__first__tail.n9 15.6333
rmesh_equiv_86 vcm_buffer__first__tail.n0 vcm_buffer__first__tail.n16 14.189499999999999
rmesh_equiv_87 vcm_buffer__first__tail.n0 vcm_buffer__first__tail.t0 174.91200000000001
rmesh_equiv_88 vcm_buffer__first__tail.n1 vcm_buffer__first__tail.n3 5.2415200000000004
rmesh_equiv_89 vcm_buffer__first__tail.n1 vcm_buffer__first__tail.t2 174.857
rmesh_equiv_9 bias.n0 bias.t1 181.41
rmesh_equiv_90 vcm_buffer__first__tail.n10 vcm_buffer__first__tail.n11 18.2212
rmesh_equiv_91 vcm_buffer__first__tail.n10 vcm_buffer__first__tail.n8 5.2415200000000004
rmesh_equiv_92 vcm_buffer__first__tail.n10 vcm_buffer__first__tail.n9 5.2415200000000004
rmesh_equiv_93 vcm_buffer__first__tail.n11 vcm_buffer__first__tail.n15 0.91112499999999996
rmesh_equiv_94 vcm_buffer__first__tail.n11 vcm_buffer__first__tail.n7 0.91112499999999996
rmesh_equiv_95 vcm_buffer__first__tail.n12 vcm_buffer__first__tail.n14 5.2415200000000004
rmesh_equiv_96 vcm_buffer__first__tail.n12 vcm_buffer__first__tail.t1 174.857
rmesh_equiv_97 vcm_buffer__first__tail.n13 vcm_buffer__first__tail.n14 5.2415200000000004
rmesh_equiv_98 vcm_buffer__first__tail.n13 vcm_buffer__first__tail.t1 174.857
rmesh_equiv_99 vcm_buffer__first__tail.n14 vcm_buffer__first__tail.n15 18.2212
.ends

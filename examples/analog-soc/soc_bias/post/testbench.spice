Resistor analog SoC soc_bias
.include "./supported-tt.spice"
.options method=gear maxord=2
.include "./current-probe.spice"
.temp 27.0
VGND VGND 0 0
VDD VPWR VGND 1.8
.nodeset v(VCM)=0.9
XU VGND VPWR VCM BIAS soc_bias
.control
save v(VCM) i(VDD) v(BIAS) i(v.xu.vregister_cf_2f8e879de146637c) i(v.xu.vregister_cf_b283300717e1569e) i(v.xu.vregister_cf_c28de828beac56d0) i(v.xu.vregister_cf_3727ac57d08ab503) i(v.xu.vregister_cf_ea482a702a8df179) i(v.xu.vregister_cf_36ad016f8048c663) i(v.xu.vregister_cf_0dbc9d465d659a93) i(v.xu.vregister_cf_32753ad247ad986f) i(v.xu.vregister_cf_a87bf144a7f86220) i(v.xu.vregister_cf_b5c843ff068fe564) i(VGND) v(VPWR) v(XU.VCM_BUFFER__PRE.t0) v(XU.VCM_BUFFER__FIRST__MIR.t4) v(XU.VCM_BUFFER__FIRST__MIR.t1) v(XU.VCM_BUFFER__FIRST__MIR.t0) v(XU.VCM_BUFFER__FIRST__TAIL.t2) v(XU.VCM_BUFFER__PRE.t1) v(XU.VCM_RAW.t6) v(XU.VGND.t14) v(XU.VCM_BUFFER__FIRST__TAIL.t4) v(XU.VCM_BUFFER__FIRST__MIR.t3) v(XU.VCM.t3) v(XU.VGND.t30) v(XU.VGND.t4) v(XU.VCM_BUFFER__FIRST__TAIL.t0) v(XU.BIAS.t3) v(XU.VGND.t3) v(XU.VGND.t1) v(XU.VCM.t0) v(XU.BIAS.t4) v(XU.VGND.t0) v(XU.VCM_BUFFER__FIRST__TAIL.t3) v(XU.VCM_BUFFER__FIRST__MIR.t2) v(XU.VCM.t4) v(XU.VGND.t29) v(XU.VCM_BUFFER__FIRST__TAIL.t1) v(XU.VCM_BUFFER__PRE.t2) v(XU.VCM_RAW.t10) v(XU.VGND.t10) v(XU.VGND.t23) v(XU.BIAS.t1) v(XU.BIAS.t0) v(XU.VGND.t22) v(XU.VCM.t1) v(XU.VCM_BUFFER__PRE.t6) v(VGND)
set num_threads=1
set numdgt=17
set wr_singlescale
set wr_vecnames
set noaskquit
tran 2e-08 0.0002
let mos_wave_0 = v(VCM)
let mos_wave_1 = -i(VDD)
let mos_wave_2 = v(BIAS)
wrdata waveform.dat mos_wave_0 mos_wave_1 mos_wave_2
write waveform.raw all
let register_flow_0 = i(v.xu.vregister_cf_2f8e879de146637c)
let register_flow_1 = i(v.xu.vregister_cf_b283300717e1569e)
let register_flow_2 = i(v.xu.vregister_cf_c28de828beac56d0)
let register_flow_3 = i(v.xu.vregister_cf_3727ac57d08ab503)
let register_flow_4 = i(v.xu.vregister_cf_ea482a702a8df179)
let register_flow_5 = i(v.xu.vregister_cf_36ad016f8048c663)
let register_flow_6 = i(v.xu.vregister_cf_0dbc9d465d659a93)
let register_flow_7 = i(v.xu.vregister_cf_32753ad247ad986f)
let register_flow_8 = i(v.xu.vregister_cf_a87bf144a7f86220)
let register_flow_9 = i(v.xu.vregister_cf_b5c843ff068fe564)
let register_flow_10 = i(VGND)
let register_flow_11 = i(VDD)
wrdata current-flow.dat register_flow_0 register_flow_1 register_flow_2 register_flow_3 register_flow_4 register_flow_5 register_flow_6 register_flow_7 register_flow_8 register_flow_9 register_flow_10 register_flow_11
let register_voltage_0 = v(VPWR)
let register_voltage_1 = v(XU.VCM_BUFFER__PRE.t0)
let register_voltage_2 = v(XU.VCM_BUFFER__FIRST__MIR.t4)
let register_voltage_3 = v(XU.VCM_BUFFER__FIRST__MIR.t1)
let register_voltage_4 = v(XU.VCM_BUFFER__FIRST__MIR.t0)
let register_voltage_5 = v(XU.VCM_BUFFER__FIRST__TAIL.t2)
let register_voltage_6 = v(XU.VCM_BUFFER__PRE.t1)
let register_voltage_7 = v(XU.VCM_RAW.t6)
let register_voltage_8 = v(XU.VGND.t14)
let register_voltage_9 = v(XU.VCM_BUFFER__FIRST__TAIL.t4)
let register_voltage_10 = v(XU.VCM_BUFFER__FIRST__MIR.t3)
let register_voltage_11 = v(XU.VCM.t3)
let register_voltage_12 = v(XU.VGND.t30)
let register_voltage_13 = v(XU.VGND.t4)
let register_voltage_14 = v(XU.VCM_BUFFER__FIRST__TAIL.t0)
let register_voltage_15 = v(XU.BIAS.t3)
let register_voltage_16 = v(XU.VGND.t3)
let register_voltage_17 = v(XU.VGND.t1)
let register_voltage_18 = v(XU.VCM.t0)
let register_voltage_19 = v(XU.BIAS.t4)
let register_voltage_20 = v(XU.VGND.t0)
let register_voltage_21 = v(XU.VCM_BUFFER__FIRST__TAIL.t3)
let register_voltage_22 = v(XU.VCM_BUFFER__FIRST__MIR.t2)
let register_voltage_23 = v(XU.VCM.t4)
let register_voltage_24 = v(XU.VGND.t29)
let register_voltage_25 = v(XU.VCM_BUFFER__FIRST__TAIL.t1)
let register_voltage_26 = v(XU.VCM_BUFFER__PRE.t2)
let register_voltage_27 = v(XU.VCM_RAW.t10)
let register_voltage_28 = v(XU.VGND.t10)
let register_voltage_29 = v(XU.VGND.t23)
let register_voltage_30 = v(XU.BIAS.t1)
let register_voltage_31 = v(XU.BIAS.t0)
let register_voltage_32 = v(XU.VGND.t22)
let register_voltage_33 = v(XU.VCM.t1)
let register_voltage_34 = v(XU.VCM_BUFFER__PRE.t6)
let register_voltage_35 = v(VGND)
let register_voltage_36 = 0*register_flow_0
wrdata node-voltages.dat register_voltage_0 register_voltage_1 register_voltage_2 register_voltage_3 register_voltage_4 register_voltage_5 register_voltage_6 register_voltage_7 register_voltage_8 register_voltage_9 register_voltage_10 register_voltage_11 register_voltage_12 register_voltage_13 register_voltage_14 register_voltage_15 register_voltage_16 register_voltage_17 register_voltage_18 register_voltage_19 register_voltage_20 register_voltage_21 register_voltage_22 register_voltage_23 register_voltage_24 register_voltage_25 register_voltage_26 register_voltage_27 register_voltage_28 register_voltage_29 register_voltage_30 register_voltage_31 register_voltage_32 register_voltage_33 register_voltage_34 register_voltage_35 register_voltage_36
quit
.endc
.end

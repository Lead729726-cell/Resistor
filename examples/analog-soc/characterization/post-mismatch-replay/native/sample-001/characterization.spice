Resistor owned characterization controller
.control
set noaskquit
set num_threads=1
unset klu
setseed 729726
source /workspace/.runtime/eda/runs/f0dc409facac488a88ec1cabee3ddb95/follower.spice
set numdgt=17
set wr_singlescale
set wr_vecnames
op
let sample_index=0
setscale sample_index
let supply_current=-i(VDD)
wrdata offset.dat v(OUT) v(INP) supply_current
quit
.endc
.end

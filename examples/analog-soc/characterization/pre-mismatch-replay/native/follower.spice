Resistor actual OTA voltage follower characterization
.include "/workspace/.runtime/eda/runs/d2b76475f86c4cbbbc62fe36c257b48a/supported-tt.spice"
.include "/workspace/.runtime/eda/runs/d2b76475f86c4cbbbc62fe36c257b48a/reference.spice"
.temp 27.0
VGND VGND 0 0
VDD VPWR VGND 1.8
VINP INP VGND DC 0.90000000000000002 AC 1
VBIAS BIAS VGND 0.9
CLOAD OUT VGND 1p
XU INP OUT BIAS OUT VPWR VGND soc_miller_ota
.end

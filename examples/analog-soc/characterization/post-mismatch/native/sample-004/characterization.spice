Resistor owned characterization controller
.control
set noaskquit
set num_threads=1
unset klu
setseed 729729
source /workspace/.runtime/eda/runs/d496ddd835a44230af9d91329b9241a0/follower.spice
set numdgt=17
set wr_singlescale
set wr_vecnames
op
let sample_index=0
setscale sample_index
let supply_current=-i(VDD)
wrdata offset.dat v(OUT) v(INP) supply_current
quit
.endc
.end

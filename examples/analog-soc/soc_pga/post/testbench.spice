Resistor analog SoC soc_pga
.include "./supported-tt.spice"
.options method=gear maxord=2
.include "./current-probe.spice"
.temp 27.0
VGND VGND 0 0
VDD VPWR VGND 1.8
VBIAS BIAS VGND 0.9
VCM VCM VGND 0.9
VIN VIN VGND DC 0.9 AC 1 SIN(0.9 0.025 5000)
VGAIN GAIN VGND PULSE(0 1.8 100u 2n 2n 1 2)
CLOAD OUT VGND 50f
XU VPWR OUT BIAS GAIN VGND VCM VIN soc_pga
.control
save v(OUT) i(VDD) v(VIN) v(GAIN) i(v.xu.vregister_cf_312e3edd9e44762b) i(v.xu.vregister_cf_d953608209b6203c) i(v.xu.vregister_cf_d8993326838a9d1f) i(v.xu.vregister_cf_48e24b57b2858724) i(v.xu.vregister_cf_55c22409457ffa2b) i(v.xu.vregister_cf_8c25e32194cf0ea1) i(v.xu.vregister_cf_73b03ba63fc8c827) i(v.xu.vregister_cf_c94a91fbbdeabd79) i(v.xu.vregister_cf_9e35ad6c31d34ba6) i(v.xu.vregister_cf_94f8f4857a333a6e) i(v.xu.vregister_cf_1a6757184ac6b498) i(v.xu.vregister_cf_136c1a42e9ff459b) i(v.xu.vregister_cf_78a8a5817f190ad2) i(v.xu.vregister_cf_8d650daa64b33fa4) i(v.xu.vregister_cf_20a0499853bb0c9d) i(v.xu.vregister_cf_5b2a9f50038db3d1) i(v.xu.vregister_cf_92b5ba1ba0fc9711) i(v.xu.vregister_cf_25382f22d5e0f9c4) i(v.xu.vregister_cf_bcb3b4807c63af31) i(v.xu.vregister_cf_99b886bb92c1717a) i(v.xu.vregister_cf_8265073df66edb8c) i(v.xu.vregister_cf_92dcac895ca87ee6) i(v.xu.vregister_cf_dc4174e13f13f45f) i(v.xu.vregister_cf_0d7d0533c59c3d29) i(v.xu.vregister_cf_ed161a698e64f790) i(v.xu.vregister_cf_710e881db0c0b62c) i(v.xu.vregister_cf_69de4e49c2f0a644) i(v.xu.vregister_cf_24aff15dc5793e6e) i(v.xu.vregister_cf_c407d7156a1b966c) i(v.xu.vregister_cf_89be12ac925e1a7f) i(v.xu.vregister_cf_ade8fb5cf3d4a6ff) i(v.xu.vregister_cf_4c2b109a5da3f5bc) i(v.xu.vregister_cf_84b8a24b63bab397) i(VGND) i(VBIAS) i(VCM) i(VIN) i(VGAIN) v(XU.VPWR.t6) v(XU.GAINB.t0) v(XU.GAIN.t0) v(XU.VPWR.t5) v(XU.OUTPUT_BUFFER__FIRST__TAIL.t2) v(XU.OUTPUT_BUFFER__PRE.t1) v(XU.SELECTED.t4) v(XU.VGND.t27) v(XU.OUTPUT_BUFFER__FIRST__TAIL.t1) v(XU.OUTPUT_BUFFER__PRE.t2) v(XU.SELECTED.t5) v(XU.VGND.t26) v(XU.GAIN2__AMP__FIRST__TAIL.t2) v(XU.GAIN2__AMP__PRE.t2) v(XU.VIN.t0) v(XU.VGND.t21) v(XU.VPWR.t19) v(XU.GAIN8__AMP__PRE.t2) v(XU.GAIN8__AMP__FIRST__MIR.t4) v(XU.VPWR.t18) v(XU.VPWR.t14) v(XU.GAIN8__AMP__FIRST__MIR.t3) v(XU.GAIN8__AMP__FIRST__MIR.t2) v(XU.VPWR.t13) v(XU.OUTPUT_BUFFER__FIRST__TAIL.t3) v(XU.OUTPUT_BUFFER__FIRST__MIR.t1) v(XU.OUT.t3) v(XU.VGND.t34) v(XU.GAIN8__AMP__FIRST__TAIL.t4) v(XU.GAIN8__AMP__FIRST__MIR.t0) v(XU.GAIN8__FB.t2) v(XU.VGND.t15) v(XU.GAIN2__AMP__FIRST__TAIL.t4) v(XU.GAIN2__AMP__FIRST__MIR.t3) v(XU.GAIN2__FB.t2) v(XU.VGND.t5) v(XU.VGND.t3) v(XU.GAIN2__AMP__FIRST__TAIL.t0) v(XU.BIAS.t0) v(XU.VGND.t2) v(XU.VGND.t23) v(XU.V2.t3) v(XU.BIAS.t1) v(XU.VGND.t22) v(XU.SELECTED.t2) v(XU.V2.t5) v(XU.GAINB.t2) v(XU.VGND.t28) v(XU.GAIN8__AMP__FIRST__TAIL.t2) v(XU.GAIN8__AMP__PRE.t1) v(XU.VIN.t1) v(XU.VGND.t13) v(XU.VGND.t10) v(XU.GAINB.t1) v(XU.GAIN.t1) v(XU.VGND.t9) v(XU.VPWR.t8) v(XU.OUT.t1) v(XU.OUTPUT_BUFFER__PRE.t5) v(XU.VPWR.t7) v(XU.GAIN8__AMP__FIRST__TAIL.t1) v(XU.GAIN8__AMP__PRE.t0) v(XU.VIN.t2) v(XU.VGND.t4) v(XU.VPWR.t21) v(XU.V2.t4) v(XU.GAIN2__AMP__PRE.t6) v(XU.VPWR.t20) v(XU.GAIN8__AMP__FIRST__TAIL.t3) v(XU.GAIN8__AMP__FIRST__MIR.t1) v(XU.GAIN8__FB.t3) v(XU.VGND.t16) v(XU.VPWR.t10) v(XU.V8.t4) v(XU.GAIN8__AMP__PRE.t6) v(XU.VPWR.t9) v(XU.VPWR.t16) v(XU.GAIN2__AMP__PRE.t0) v(XU.GAIN2__AMP__FIRST__MIR.t4) v(XU.VPWR.t15) v(XU.VGND.t1) v(XU.GAIN8__AMP__FIRST__TAIL.t0) v(XU.BIAS.t2) v(XU.VGND.t0) v(XU.OUTPUT_BUFFER__FIRST__TAIL.t4) v(XU.OUTPUT_BUFFER__FIRST__MIR.t0) v(XU.OUT.t4) v(XU.VGND.t35) v(XU.VPWR.t12) v(XU.GAIN2__AMP__FIRST__MIR.t1) v(XU.GAIN2__AMP__FIRST__MIR.t0) v(XU.VPWR.t11) v(XU.VGND.t7) v(XU.OUTPUT_BUFFER__FIRST__TAIL.t0) v(XU.BIAS.t3) v(XU.VGND.t6) v(XU.VPWR.t3) v(XU.OUTPUT_BUFFER__FIRST__MIR.t3) v(XU.OUTPUT_BUFFER__FIRST__MIR.t2) v(XU.VPWR.t2) v(XU.SELECTED.t1) v(XU.V2.t0) v(XU.GAIN.t2) v(XU.VPWR.t4) v(XU.GAIN2__AMP__FIRST__TAIL.t1) v(XU.GAIN2__AMP__PRE.t1) v(XU.VIN.t3) v(XU.VGND.t25) v(XU.GAIN2__AMP__FIRST__TAIL.t3) v(XU.GAIN2__AMP__FIRST__MIR.t2) v(XU.GAIN2__FB.t3) v(XU.VGND.t33) v(XU.VGND.t30) v(XU.V8.t2) v(XU.BIAS.t4) v(XU.VGND.t29) v(XU.SELECTED.t3) v(XU.V8.t5) v(XU.GAINB.t3) v(XU.VPWR.t17) v(XU.VPWR.t1) v(XU.OUTPUT_BUFFER__PRE.t0) v(XU.OUTPUT_BUFFER__FIRST__MIR.t4) v(XU.VPWR.t0) v(XU.SELECTED.t0) v(XU.V8.t0) v(XU.GAIN.t3) v(XU.VGND.t8) v(XU.VGND.t32) v(XU.OUT.t2) v(XU.BIAS.t5) v(XU.VGND.t31) v(VGND) v(VPWR) v(BIAS) v(VCM)
set num_threads=1
set numdgt=17
set wr_singlescale
set wr_vecnames
set noaskquit
tran 2e-08 0.0002
let mos_wave_0 = v(OUT)
let mos_wave_1 = -i(VDD)
let mos_wave_2 = v(VIN)
let mos_wave_3 = v(GAIN)
wrdata waveform.dat mos_wave_0 mos_wave_1 mos_wave_2 mos_wave_3
write waveform.raw all
let register_flow_0 = i(v.xu.vregister_cf_312e3edd9e44762b)
let register_flow_1 = i(v.xu.vregister_cf_d953608209b6203c)
let register_flow_2 = i(v.xu.vregister_cf_d8993326838a9d1f)
let register_flow_3 = i(v.xu.vregister_cf_48e24b57b2858724)
let register_flow_4 = i(v.xu.vregister_cf_55c22409457ffa2b)
let register_flow_5 = i(v.xu.vregister_cf_8c25e32194cf0ea1)
let register_flow_6 = i(v.xu.vregister_cf_73b03ba63fc8c827)
let register_flow_7 = i(v.xu.vregister_cf_c94a91fbbdeabd79)
let register_flow_8 = i(v.xu.vregister_cf_9e35ad6c31d34ba6)
let register_flow_9 = i(v.xu.vregister_cf_94f8f4857a333a6e)
let register_flow_10 = i(v.xu.vregister_cf_1a6757184ac6b498)
let register_flow_11 = i(v.xu.vregister_cf_136c1a42e9ff459b)
let register_flow_12 = i(v.xu.vregister_cf_78a8a5817f190ad2)
let register_flow_13 = i(v.xu.vregister_cf_8d650daa64b33fa4)
let register_flow_14 = i(v.xu.vregister_cf_20a0499853bb0c9d)
let register_flow_15 = i(v.xu.vregister_cf_5b2a9f50038db3d1)
let register_flow_16 = i(v.xu.vregister_cf_92b5ba1ba0fc9711)
let register_flow_17 = i(v.xu.vregister_cf_25382f22d5e0f9c4)
let register_flow_18 = i(v.xu.vregister_cf_bcb3b4807c63af31)
let register_flow_19 = i(v.xu.vregister_cf_99b886bb92c1717a)
let register_flow_20 = i(v.xu.vregister_cf_8265073df66edb8c)
let register_flow_21 = i(v.xu.vregister_cf_92dcac895ca87ee6)
let register_flow_22 = i(v.xu.vregister_cf_dc4174e13f13f45f)
let register_flow_23 = i(v.xu.vregister_cf_0d7d0533c59c3d29)
let register_flow_24 = i(v.xu.vregister_cf_ed161a698e64f790)
let register_flow_25 = i(v.xu.vregister_cf_710e881db0c0b62c)
let register_flow_26 = i(v.xu.vregister_cf_69de4e49c2f0a644)
let register_flow_27 = i(v.xu.vregister_cf_24aff15dc5793e6e)
let register_flow_28 = i(v.xu.vregister_cf_c407d7156a1b966c)
let register_flow_29 = i(v.xu.vregister_cf_89be12ac925e1a7f)
let register_flow_30 = i(v.xu.vregister_cf_ade8fb5cf3d4a6ff)
let register_flow_31 = i(v.xu.vregister_cf_4c2b109a5da3f5bc)
let register_flow_32 = i(v.xu.vregister_cf_84b8a24b63bab397)
let register_flow_33 = i(VGND)
let register_flow_34 = i(VDD)
let register_flow_35 = i(VBIAS)
let register_flow_36 = i(VCM)
let register_flow_37 = i(VIN)
let register_flow_38 = i(VGAIN)
wrdata current-flow.dat register_flow_0 register_flow_1 register_flow_2 register_flow_3 register_flow_4 register_flow_5 register_flow_6 register_flow_7 register_flow_8 register_flow_9 register_flow_10 register_flow_11 register_flow_12 register_flow_13 register_flow_14 register_flow_15 register_flow_16 register_flow_17 register_flow_18 register_flow_19 register_flow_20 register_flow_21 register_flow_22 register_flow_23 register_flow_24 register_flow_25 register_flow_26 register_flow_27 register_flow_28 register_flow_29 register_flow_30 register_flow_31 register_flow_32 register_flow_33 register_flow_34 register_flow_35 register_flow_36 register_flow_37 register_flow_38
let register_voltage_0 = v(XU.VPWR.t6)
let register_voltage_1 = v(XU.GAINB.t0)
let register_voltage_2 = v(XU.GAIN.t0)
let register_voltage_3 = v(XU.VPWR.t5)
let register_voltage_4 = v(XU.OUTPUT_BUFFER__FIRST__TAIL.t2)
let register_voltage_5 = v(XU.OUTPUT_BUFFER__PRE.t1)
let register_voltage_6 = v(XU.SELECTED.t4)
let register_voltage_7 = v(XU.VGND.t27)
let register_voltage_8 = v(XU.OUTPUT_BUFFER__FIRST__TAIL.t1)
let register_voltage_9 = v(XU.OUTPUT_BUFFER__PRE.t2)
let register_voltage_10 = v(XU.SELECTED.t5)
let register_voltage_11 = v(XU.VGND.t26)
let register_voltage_12 = v(XU.GAIN2__AMP__FIRST__TAIL.t2)
let register_voltage_13 = v(XU.GAIN2__AMP__PRE.t2)
let register_voltage_14 = v(XU.VIN.t0)
let register_voltage_15 = v(XU.VGND.t21)
let register_voltage_16 = v(XU.VPWR.t19)
let register_voltage_17 = v(XU.GAIN8__AMP__PRE.t2)
let register_voltage_18 = v(XU.GAIN8__AMP__FIRST__MIR.t4)
let register_voltage_19 = v(XU.VPWR.t18)
let register_voltage_20 = v(XU.VPWR.t14)
let register_voltage_21 = v(XU.GAIN8__AMP__FIRST__MIR.t3)
let register_voltage_22 = v(XU.GAIN8__AMP__FIRST__MIR.t2)
let register_voltage_23 = v(XU.VPWR.t13)
let register_voltage_24 = v(XU.OUTPUT_BUFFER__FIRST__TAIL.t3)
let register_voltage_25 = v(XU.OUTPUT_BUFFER__FIRST__MIR.t1)
let register_voltage_26 = v(XU.OUT.t3)
let register_voltage_27 = v(XU.VGND.t34)
let register_voltage_28 = v(XU.GAIN8__AMP__FIRST__TAIL.t4)
let register_voltage_29 = v(XU.GAIN8__AMP__FIRST__MIR.t0)
let register_voltage_30 = v(XU.GAIN8__FB.t2)
let register_voltage_31 = v(XU.VGND.t15)
let register_voltage_32 = v(XU.GAIN2__AMP__FIRST__TAIL.t4)
let register_voltage_33 = v(XU.GAIN2__AMP__FIRST__MIR.t3)
let register_voltage_34 = v(XU.GAIN2__FB.t2)
let register_voltage_35 = v(XU.VGND.t5)
let register_voltage_36 = v(XU.VGND.t3)
let register_voltage_37 = v(XU.GAIN2__AMP__FIRST__TAIL.t0)
let register_voltage_38 = v(XU.BIAS.t0)
let register_voltage_39 = v(XU.VGND.t2)
let register_voltage_40 = v(XU.VGND.t23)
let register_voltage_41 = v(XU.V2.t3)
let register_voltage_42 = v(XU.BIAS.t1)
let register_voltage_43 = v(XU.VGND.t22)
let register_voltage_44 = v(XU.SELECTED.t2)
let register_voltage_45 = v(XU.V2.t5)
let register_voltage_46 = v(XU.GAINB.t2)
let register_voltage_47 = v(XU.VGND.t28)
let register_voltage_48 = v(XU.GAIN8__AMP__FIRST__TAIL.t2)
let register_voltage_49 = v(XU.GAIN8__AMP__PRE.t1)
let register_voltage_50 = v(XU.VIN.t1)
let register_voltage_51 = v(XU.VGND.t13)
let register_voltage_52 = v(XU.VGND.t10)
let register_voltage_53 = v(XU.GAINB.t1)
let register_voltage_54 = v(XU.GAIN.t1)
let register_voltage_55 = v(XU.VGND.t9)
let register_voltage_56 = v(XU.VPWR.t8)
let register_voltage_57 = v(XU.OUT.t1)
let register_voltage_58 = v(XU.OUTPUT_BUFFER__PRE.t5)
let register_voltage_59 = v(XU.VPWR.t7)
let register_voltage_60 = v(XU.GAIN8__AMP__FIRST__TAIL.t1)
let register_voltage_61 = v(XU.GAIN8__AMP__PRE.t0)
let register_voltage_62 = v(XU.VIN.t2)
let register_voltage_63 = v(XU.VGND.t4)
let register_voltage_64 = v(XU.VPWR.t21)
let register_voltage_65 = v(XU.V2.t4)
let register_voltage_66 = v(XU.GAIN2__AMP__PRE.t6)
let register_voltage_67 = v(XU.VPWR.t20)
let register_voltage_68 = v(XU.GAIN8__AMP__FIRST__TAIL.t3)
let register_voltage_69 = v(XU.GAIN8__AMP__FIRST__MIR.t1)
let register_voltage_70 = v(XU.GAIN8__FB.t3)
let register_voltage_71 = v(XU.VGND.t16)
let register_voltage_72 = v(XU.VPWR.t10)
let register_voltage_73 = v(XU.V8.t4)
let register_voltage_74 = v(XU.GAIN8__AMP__PRE.t6)
let register_voltage_75 = v(XU.VPWR.t9)
let register_voltage_76 = v(XU.VPWR.t16)
let register_voltage_77 = v(XU.GAIN2__AMP__PRE.t0)
let register_voltage_78 = v(XU.GAIN2__AMP__FIRST__MIR.t4)
let register_voltage_79 = v(XU.VPWR.t15)
let register_voltage_80 = v(XU.VGND.t1)
let register_voltage_81 = v(XU.GAIN8__AMP__FIRST__TAIL.t0)
let register_voltage_82 = v(XU.BIAS.t2)
let register_voltage_83 = v(XU.VGND.t0)
let register_voltage_84 = v(XU.OUTPUT_BUFFER__FIRST__TAIL.t4)
let register_voltage_85 = v(XU.OUTPUT_BUFFER__FIRST__MIR.t0)
let register_voltage_86 = v(XU.OUT.t4)
let register_voltage_87 = v(XU.VGND.t35)
let register_voltage_88 = v(XU.VPWR.t12)
let register_voltage_89 = v(XU.GAIN2__AMP__FIRST__MIR.t1)
let register_voltage_90 = v(XU.GAIN2__AMP__FIRST__MIR.t0)
let register_voltage_91 = v(XU.VPWR.t11)
let register_voltage_92 = v(XU.VGND.t7)
let register_voltage_93 = v(XU.OUTPUT_BUFFER__FIRST__TAIL.t0)
let register_voltage_94 = v(XU.BIAS.t3)
let register_voltage_95 = v(XU.VGND.t6)
let register_voltage_96 = v(XU.VPWR.t3)
let register_voltage_97 = v(XU.OUTPUT_BUFFER__FIRST__MIR.t3)
let register_voltage_98 = v(XU.OUTPUT_BUFFER__FIRST__MIR.t2)
let register_voltage_99 = v(XU.VPWR.t2)
let register_voltage_100 = v(XU.SELECTED.t1)
let register_voltage_101 = v(XU.V2.t0)
let register_voltage_102 = v(XU.GAIN.t2)
let register_voltage_103 = v(XU.VPWR.t4)
let register_voltage_104 = v(XU.GAIN2__AMP__FIRST__TAIL.t1)
let register_voltage_105 = v(XU.GAIN2__AMP__PRE.t1)
let register_voltage_106 = v(XU.VIN.t3)
let register_voltage_107 = v(XU.VGND.t25)
let register_voltage_108 = v(XU.GAIN2__AMP__FIRST__TAIL.t3)
let register_voltage_109 = v(XU.GAIN2__AMP__FIRST__MIR.t2)
let register_voltage_110 = v(XU.GAIN2__FB.t3)
let register_voltage_111 = v(XU.VGND.t33)
let register_voltage_112 = v(XU.VGND.t30)
let register_voltage_113 = v(XU.V8.t2)
let register_voltage_114 = v(XU.BIAS.t4)
let register_voltage_115 = v(XU.VGND.t29)
let register_voltage_116 = v(XU.SELECTED.t3)
let register_voltage_117 = v(XU.V8.t5)
let register_voltage_118 = v(XU.GAINB.t3)
let register_voltage_119 = v(XU.VPWR.t17)
let register_voltage_120 = v(XU.VPWR.t1)
let register_voltage_121 = v(XU.OUTPUT_BUFFER__PRE.t0)
let register_voltage_122 = v(XU.OUTPUT_BUFFER__FIRST__MIR.t4)
let register_voltage_123 = v(XU.VPWR.t0)
let register_voltage_124 = v(XU.SELECTED.t0)
let register_voltage_125 = v(XU.V8.t0)
let register_voltage_126 = v(XU.GAIN.t3)
let register_voltage_127 = v(XU.VGND.t8)
let register_voltage_128 = v(XU.VGND.t32)
let register_voltage_129 = v(XU.OUT.t2)
let register_voltage_130 = v(XU.BIAS.t5)
let register_voltage_131 = v(XU.VGND.t31)
let register_voltage_132 = v(VGND)
let register_voltage_133 = 0*register_flow_0
let register_voltage_134 = v(VPWR)
let register_voltage_135 = v(BIAS)
let register_voltage_136 = v(VCM)
let register_voltage_137 = v(VIN)
let register_voltage_138 = v(GAIN)
wrdata node-voltages.dat register_voltage_0 register_voltage_1 register_voltage_2 register_voltage_3 register_voltage_4 register_voltage_5 register_voltage_6 register_voltage_7 register_voltage_8 register_voltage_9 register_voltage_10 register_voltage_11 register_voltage_12 register_voltage_13 register_voltage_14 register_voltage_15 register_voltage_16 register_voltage_17 register_voltage_18 register_voltage_19 register_voltage_20 register_voltage_21 register_voltage_22 register_voltage_23 register_voltage_24 register_voltage_25 register_voltage_26 register_voltage_27 register_voltage_28 register_voltage_29 register_voltage_30 register_voltage_31 register_voltage_32 register_voltage_33 register_voltage_34 register_voltage_35 register_voltage_36 register_voltage_37 register_voltage_38 register_voltage_39 register_voltage_40 register_voltage_41 register_voltage_42 register_voltage_43 register_voltage_44 register_voltage_45 register_voltage_46 register_voltage_47 register_voltage_48 register_voltage_49 register_voltage_50 register_voltage_51 register_voltage_52 register_voltage_53 register_voltage_54 register_voltage_55 register_voltage_56 register_voltage_57 register_voltage_58 register_voltage_59 register_voltage_60 register_voltage_61 register_voltage_62 register_voltage_63 register_voltage_64 register_voltage_65 register_voltage_66 register_voltage_67 register_voltage_68 register_voltage_69 register_voltage_70 register_voltage_71 register_voltage_72 register_voltage_73 register_voltage_74 register_voltage_75 register_voltage_76 register_voltage_77 register_voltage_78 register_voltage_79 register_voltage_80 register_voltage_81 register_voltage_82 register_voltage_83 register_voltage_84 register_voltage_85 register_voltage_86 register_voltage_87 register_voltage_88 register_voltage_89 register_voltage_90 register_voltage_91 register_voltage_92 register_voltage_93 register_voltage_94 register_voltage_95 register_voltage_96 register_voltage_97 register_voltage_98 register_voltage_99 register_voltage_100 register_voltage_101 register_voltage_102 register_voltage_103 register_voltage_104 register_voltage_105 register_voltage_106 register_voltage_107 register_voltage_108 register_voltage_109 register_voltage_110 register_voltage_111 register_voltage_112 register_voltage_113 register_voltage_114 register_voltage_115 register_voltage_116 register_voltage_117 register_voltage_118 register_voltage_119 register_voltage_120 register_voltage_121 register_voltage_122 register_voltage_123 register_voltage_124 register_voltage_125 register_voltage_126 register_voltage_127 register_voltage_128 register_voltage_129 register_voltage_130 register_voltage_131 register_voltage_132 register_voltage_133 register_voltage_134 register_voltage_135 register_voltage_136 register_voltage_137 register_voltage_138
quit
.endc
.end

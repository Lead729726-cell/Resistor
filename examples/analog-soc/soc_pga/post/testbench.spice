Resistor analog SoC soc_pga
.include "./supported-tt.spice"
.options method=gear maxord=2
.include "./current-probe.spice"
.temp 27.0
VGND VGND 0 0
VDD VPWR VGND 1.8
VBIAS BIAS VGND 0.9
VCM VCM VGND 0.9
VIN VIN VGND DC 0.9 AC 1 SIN(0.9 0.025 5000)
VGAIN GAIN VGND PULSE(0 1.8 100u 2n 2n 1 2)
CLOAD OUT VGND 50f
XU VGND OUT VCM VPWR BIAS GAIN VIN soc_pga
.control
save v(OUT) i(VDD) v(VIN) v(GAIN) i(v.xu.vregister_cf_312e3edd9e44762b) i(v.xu.vregister_cf_a60e6ca5ab433b6c) i(v.xu.vregister_cf_303007dd1d269360) i(v.xu.vregister_cf_48e24b57b2858724) i(v.xu.vregister_cf_aaf9080a22b05a3b) i(v.xu.vregister_cf_55c22409457ffa2b) i(v.xu.vregister_cf_da573ecc7c5c91a0) i(v.xu.vregister_cf_73b03ba63fc8c827) i(v.xu.vregister_cf_5d8b12250d66d708) i(v.xu.vregister_cf_035e1ed724895bd5) i(v.xu.vregister_cf_9e35ad6c31d34ba6) i(VGND) i(VBIAS) i(VCM) i(VIN) i(VGAIN) v(XU.LOW.t2) v(XU.OUT.t5) v(XU.GAINB.t2) v(XU.VGND.t13) v(XU.VGND.t8) v(XU.GAINB.t0) v(XU.GAIN.t0) v(XU.VGND.t7) v(XU.VPWR.t8) v(XU.OUT.t3) v(XU.AMP__PRE.t4) v(XU.VPWR.t7) v(XU.AMP__FIRST__TAIL.t1) v(XU.AMP__FIRST__MIR.t2) v(XU.FB.t3) v(XU.VGND.t3) v(XU.VGND.t6) v(XU.AMP__FIRST__TAIL.t0) v(XU.BIAS.t0) v(XU.VGND.t5) v(XU.AMP__FIRST__TAIL.t2) v(XU.AMP__PRE.t1) v(XU.VIN.t0) v(XU.VGND.t11) v(XU.VPWR.t4) v(XU.GAINB.t1) v(XU.GAIN.t1) v(XU.VPWR.t3) v(XU.VGND.t1) v(XU.OUT.t0) v(XU.BIAS.t1) v(XU.VGND.t0) v(XU.VPWR.t1) v(XU.AMP__FIRST__MIR.t1) v(XU.AMP__FIRST__MIR.t0) v(XU.VPWR.t0) v(XU.VPWR.t6) v(XU.AMP__PRE.t0) v(XU.AMP__FIRST__MIR.t3) v(XU.VPWR.t5) v(XU.LOW.t0) v(XU.OUT.t1) v(XU.GAIN.t2) v(XU.VPWR.t2) v(VGND) v(VPWR) v(BIAS) v(VCM)
set num_threads=1
set numdgt=17
set wr_singlescale
set wr_vecnames
set noaskquit
tran 2e-08 0.0002
let mos_wave_0 = v(OUT)
let mos_wave_1 = -i(VDD)
let mos_wave_2 = v(VIN)
let mos_wave_3 = v(GAIN)
wrdata waveform.dat mos_wave_0 mos_wave_1 mos_wave_2 mos_wave_3
write waveform.raw all
let register_flow_0 = i(v.xu.vregister_cf_312e3edd9e44762b)
let register_flow_1 = i(v.xu.vregister_cf_a60e6ca5ab433b6c)
let register_flow_2 = i(v.xu.vregister_cf_303007dd1d269360)
let register_flow_3 = i(v.xu.vregister_cf_48e24b57b2858724)
let register_flow_4 = i(v.xu.vregister_cf_aaf9080a22b05a3b)
let register_flow_5 = i(v.xu.vregister_cf_55c22409457ffa2b)
let register_flow_6 = i(v.xu.vregister_cf_da573ecc7c5c91a0)
let register_flow_7 = i(v.xu.vregister_cf_73b03ba63fc8c827)
let register_flow_8 = i(v.xu.vregister_cf_5d8b12250d66d708)
let register_flow_9 = i(v.xu.vregister_cf_035e1ed724895bd5)
let register_flow_10 = i(v.xu.vregister_cf_9e35ad6c31d34ba6)
let register_flow_11 = i(VGND)
let register_flow_12 = i(VDD)
let register_flow_13 = i(VBIAS)
let register_flow_14 = i(VCM)
let register_flow_15 = i(VIN)
let register_flow_16 = i(VGAIN)
wrdata current-flow.dat register_flow_0 register_flow_1 register_flow_2 register_flow_3 register_flow_4 register_flow_5 register_flow_6 register_flow_7 register_flow_8 register_flow_9 register_flow_10 register_flow_11 register_flow_12 register_flow_13 register_flow_14 register_flow_15 register_flow_16
let register_voltage_0 = v(XU.LOW.t2)
let register_voltage_1 = v(XU.OUT.t5)
let register_voltage_2 = v(XU.GAINB.t2)
let register_voltage_3 = v(XU.VGND.t13)
let register_voltage_4 = v(XU.VGND.t8)
let register_voltage_5 = v(XU.GAINB.t0)
let register_voltage_6 = v(XU.GAIN.t0)
let register_voltage_7 = v(XU.VGND.t7)
let register_voltage_8 = v(XU.VPWR.t8)
let register_voltage_9 = v(XU.OUT.t3)
let register_voltage_10 = v(XU.AMP__PRE.t4)
let register_voltage_11 = v(XU.VPWR.t7)
let register_voltage_12 = v(XU.AMP__FIRST__TAIL.t1)
let register_voltage_13 = v(XU.AMP__FIRST__MIR.t2)
let register_voltage_14 = v(XU.FB.t3)
let register_voltage_15 = v(XU.VGND.t3)
let register_voltage_16 = v(XU.VGND.t6)
let register_voltage_17 = v(XU.AMP__FIRST__TAIL.t0)
let register_voltage_18 = v(XU.BIAS.t0)
let register_voltage_19 = v(XU.VGND.t5)
let register_voltage_20 = v(XU.AMP__FIRST__TAIL.t2)
let register_voltage_21 = v(XU.AMP__PRE.t1)
let register_voltage_22 = v(XU.VIN.t0)
let register_voltage_23 = v(XU.VGND.t11)
let register_voltage_24 = v(XU.VPWR.t4)
let register_voltage_25 = v(XU.GAINB.t1)
let register_voltage_26 = v(XU.GAIN.t1)
let register_voltage_27 = v(XU.VPWR.t3)
let register_voltage_28 = v(XU.VGND.t1)
let register_voltage_29 = v(XU.OUT.t0)
let register_voltage_30 = v(XU.BIAS.t1)
let register_voltage_31 = v(XU.VGND.t0)
let register_voltage_32 = v(XU.VPWR.t1)
let register_voltage_33 = v(XU.AMP__FIRST__MIR.t1)
let register_voltage_34 = v(XU.AMP__FIRST__MIR.t0)
let register_voltage_35 = v(XU.VPWR.t0)
let register_voltage_36 = v(XU.VPWR.t6)
let register_voltage_37 = v(XU.AMP__PRE.t0)
let register_voltage_38 = v(XU.AMP__FIRST__MIR.t3)
let register_voltage_39 = v(XU.VPWR.t5)
let register_voltage_40 = v(XU.LOW.t0)
let register_voltage_41 = v(XU.OUT.t1)
let register_voltage_42 = v(XU.GAIN.t2)
let register_voltage_43 = v(XU.VPWR.t2)
let register_voltage_44 = v(VGND)
let register_voltage_45 = 0*register_flow_0
let register_voltage_46 = v(VPWR)
let register_voltage_47 = v(BIAS)
let register_voltage_48 = v(VCM)
let register_voltage_49 = v(VIN)
let register_voltage_50 = v(GAIN)
wrdata node-voltages.dat register_voltage_0 register_voltage_1 register_voltage_2 register_voltage_3 register_voltage_4 register_voltage_5 register_voltage_6 register_voltage_7 register_voltage_8 register_voltage_9 register_voltage_10 register_voltage_11 register_voltage_12 register_voltage_13 register_voltage_14 register_voltage_15 register_voltage_16 register_voltage_17 register_voltage_18 register_voltage_19 register_voltage_20 register_voltage_21 register_voltage_22 register_voltage_23 register_voltage_24 register_voltage_25 register_voltage_26 register_voltage_27 register_voltage_28 register_voltage_29 register_voltage_30 register_voltage_31 register_voltage_32 register_voltage_33 register_voltage_34 register_voltage_35 register_voltage_36 register_voltage_37 register_voltage_38 register_voltage_39 register_voltage_40 register_voltage_41 register_voltage_42 register_voltage_43 register_voltage_44 register_voltage_45 register_voltage_46 register_voltage_47 register_voltage_48 register_voltage_49 register_voltage_50
quit
.endc
.end

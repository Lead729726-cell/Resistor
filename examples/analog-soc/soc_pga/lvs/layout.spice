* NGSPICE file created from soc_pga.ext - technology: sky130A

.subckt soc_pga VGND OUT VCM VPWR BIAS GAIN VIN
X0 LOW GAINB OUT VGND sky130_fd_pr__nfet_01v8 ad=5.8 pd=40.58 as=5.8 ps=40.58 w=20 l=0.15
X1 OUT R_HIGH_R0_N0 VGND sky130_fd_pr__res_xhigh_po_1p41 l=24.51
X2 AMP__PRE AMP__COMP sky130_fd_pr__cap_mim_m3_1 l=28.68 w=28.68
X3 AMP__PRE AMP__COMP sky130_fd_pr__cap_mim_m3_1 l=28.68 w=28.68
X4 VGND GAIN GAINB VGND sky130_fd_pr__nfet_01v8 ad=0.1885 pd=1.88 as=0.1885 ps=1.88 w=0.65 l=0.15
X5 VPWR AMP__PRE OUT VPWR sky130_fd_pr__pfet_01v8_hvt ad=11.6 pd=80.58 as=11.6 ps=80.58 w=40 l=1
X6 AMP__FIRST__TAIL FB AMP__FIRST__MIR VGND sky130_fd_pr__nfet_01v8 ad=2.9 pd=20.58 as=2.9 ps=20.58 w=10 l=1
X7 VGND BIAS AMP__FIRST__TAIL VGND sky130_fd_pr__nfet_01v8 ad=0.58 pd=4.58 as=0.58 ps=4.58 w=2 l=1
X8 AMP__FIRST__TAIL VIN AMP__PRE VGND sky130_fd_pr__nfet_01v8 ad=2.9 pd=20.58 as=2.9 ps=20.58 w=10 l=1
X9 AMP__COMP OUT VGND sky130_fd_pr__res_xhigh_po_1p41 l=3.36
X10 VPWR GAIN GAINB VPWR sky130_fd_pr__pfet_01v8_hvt ad=0.1885 pd=1.88 as=0.1885 ps=1.88 w=0.65 l=0.15
X11 VGND BIAS OUT VGND sky130_fd_pr__nfet_01v8 ad=0.58 pd=4.58 as=0.58 ps=4.58 w=2 l=1
X12 AMP__PRE AMP__COMP sky130_fd_pr__cap_mim_m3_1 l=28.68 w=28.68
X13 FB VCM VGND sky130_fd_pr__res_xhigh_po_1p41 l=6.89
X14 R_HIGH_R0_N0 FB VGND sky130_fd_pr__res_xhigh_po_1p41 l=24.51
X15 VPWR AMP__FIRST__MIR AMP__FIRST__MIR VPWR sky130_fd_pr__pfet_01v8_hvt ad=5.8 pd=40.58 as=5.8 ps=40.58 w=20 l=1
X16 LOW FB VGND sky130_fd_pr__res_xhigh_po_1p41 l=8.06
X17 VPWR AMP__FIRST__MIR AMP__PRE VPWR sky130_fd_pr__pfet_01v8_hvt ad=5.8 pd=40.58 as=5.8 ps=40.58 w=20 l=1
X18 LOW GAIN OUT VPWR sky130_fd_pr__pfet_01v8_hvt ad=5.8 pd=40.58 as=5.8 ps=40.58 w=20 l=0.15
.ends

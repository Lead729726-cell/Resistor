Resistor analog SoC soc_pga
.include "./supported-tt.spice"
.options method=gear maxord=2
.include "./current-probe.spice"
.temp 27.0
VGND VGND 0 0
VDD VPWR VGND 1.8
VBIAS BIAS VGND 0.9
VCM VCM VGND 0.9
VIN VIN VGND DC 0.9 AC 1 SIN(0.9 0.025 5000)
VGAIN GAIN VGND PULSE(0 1.8 100u 2n 2n 1 2)
CLOAD OUT VGND 50f
XU VIN GAIN VCM BIAS OUT VPWR VGND soc_pga
.control
save v(OUT) i(VDD) v(VIN) v(GAIN) i(v.xu.vregister_cf_77c4560b6388babf) i(v.xu.vregister_cf_28c384bf0cb297f8) i(v.xu.vregister_cf_ea04b0b6e1ac9086) i(v.xu.vregister_cf_413bc7a49e70111c) i(v.xu.vregister_cf_6cd0bdba4494d382) i(v.xu.vregister_cf_bdf83b64ad4e9883) i(v.xu.vregister_cf_5504dd7f27ca564d) i(v.xu.vregister_cf_e7e336b00d51fca7) i(v.xu.vregister_cf_2dfb2478aad30aab) i(v.xu.vregister_cf_cddc20703f546d7c) i(v.xu.vregister_cf_7641ed29816ec63f) i(VGND) i(VBIAS) i(VCM) i(VIN) i(VGAIN) v(XU.AMP__FIRST__MIR) v(XU.AMP__FIRST__TAIL) v(XU.FB) v(VGND) v(XU.AMP__PRE) v(BIAS) v(VPWR) v(XU.GAINB) v(XU.LOW) v(VCM)
set num_threads=1
set numdgt=17
set wr_singlescale
set wr_vecnames
set noaskquit
tran 2e-08 0.0002
let mos_wave_0 = v(OUT)
let mos_wave_1 = -i(VDD)
let mos_wave_2 = v(VIN)
let mos_wave_3 = v(GAIN)
wrdata waveform.dat mos_wave_0 mos_wave_1 mos_wave_2 mos_wave_3
write waveform.raw all
let register_flow_0 = i(v.xu.vregister_cf_77c4560b6388babf)
let register_flow_1 = i(v.xu.vregister_cf_28c384bf0cb297f8)
let register_flow_2 = i(v.xu.vregister_cf_ea04b0b6e1ac9086)
let register_flow_3 = i(v.xu.vregister_cf_413bc7a49e70111c)
let register_flow_4 = i(v.xu.vregister_cf_6cd0bdba4494d382)
let register_flow_5 = i(v.xu.vregister_cf_bdf83b64ad4e9883)
let register_flow_6 = i(v.xu.vregister_cf_5504dd7f27ca564d)
let register_flow_7 = i(v.xu.vregister_cf_e7e336b00d51fca7)
let register_flow_8 = i(v.xu.vregister_cf_2dfb2478aad30aab)
let register_flow_9 = i(v.xu.vregister_cf_cddc20703f546d7c)
let register_flow_10 = i(v.xu.vregister_cf_7641ed29816ec63f)
let register_flow_11 = i(VGND)
let register_flow_12 = i(VDD)
let register_flow_13 = i(VBIAS)
let register_flow_14 = i(VCM)
let register_flow_15 = i(VIN)
let register_flow_16 = i(VGAIN)
wrdata current-flow.dat register_flow_0 register_flow_1 register_flow_2 register_flow_3 register_flow_4 register_flow_5 register_flow_6 register_flow_7 register_flow_8 register_flow_9 register_flow_10 register_flow_11 register_flow_12 register_flow_13 register_flow_14 register_flow_15 register_flow_16
let register_voltage_0 = v(XU.AMP__FIRST__MIR)
let register_voltage_1 = v(XU.AMP__FIRST__TAIL)
let register_voltage_2 = v(XU.FB)
let register_voltage_3 = v(VGND)
let register_voltage_4 = v(XU.AMP__PRE)
let register_voltage_5 = v(VIN)
let register_voltage_6 = v(BIAS)
let register_voltage_7 = v(VPWR)
let register_voltage_8 = v(OUT)
let register_voltage_9 = v(XU.GAINB)
let register_voltage_10 = v(GAIN)
let register_voltage_11 = v(XU.LOW)
let register_voltage_12 = 0*register_flow_0
let register_voltage_13 = v(VCM)
wrdata node-voltages.dat register_voltage_0 register_voltage_1 register_voltage_2 register_voltage_3 register_voltage_4 register_voltage_5 register_voltage_6 register_voltage_7 register_voltage_8 register_voltage_9 register_voltage_10 register_voltage_11 register_voltage_12 register_voltage_13
quit
.endc
.end

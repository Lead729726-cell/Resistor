.subckt soc_pga VIN GAIN VCM BIAS OUT VPWR VGND
XAMP_C_MILLER_P0 AMP__PRE AMP__COMP sky130_fd_pr__cap_mim_m3_1 w=28.68 l=28.68
XAMP_C_MILLER_P1 AMP__PRE AMP__COMP sky130_fd_pr__cap_mim_m3_1 w=28.68 l=28.68
XAMP_C_MILLER_P2 AMP__PRE AMP__COMP sky130_fd_pr__cap_mim_m3_1 w=28.68 l=28.68
XAMP_FIRST_N_INN register_cf_node_77c4560b6388babf FB register_cf_node_77c4560b6388babf_source VGND sky130_fd_pr__nfet_01v8 w=10 l=1 nf=1 m=1
Vregister_cf_77c4560b6388babf AMP__FIRST__MIR register_cf_node_77c4560b6388babf 0
Vregister_cf_77c4560b6388babf_source AMP__FIRST__TAIL register_cf_node_77c4560b6388babf_source 0
XAMP_FIRST_N_INP register_cf_node_28c384bf0cb297f8 VIN register_cf_node_28c384bf0cb297f8_source VGND sky130_fd_pr__nfet_01v8 w=10 l=1 nf=1 m=1
Vregister_cf_28c384bf0cb297f8 AMP__PRE register_cf_node_28c384bf0cb297f8 0
Vregister_cf_28c384bf0cb297f8_source AMP__FIRST__TAIL register_cf_node_28c384bf0cb297f8_source 0
XAMP_FIRST_N_TAIL register_cf_node_ea04b0b6e1ac9086 BIAS register_cf_node_ea04b0b6e1ac9086_source VGND sky130_fd_pr__nfet_01v8 w=2 l=1 nf=1 m=1
Vregister_cf_ea04b0b6e1ac9086 AMP__FIRST__TAIL register_cf_node_ea04b0b6e1ac9086 0
Vregister_cf_ea04b0b6e1ac9086_source VGND register_cf_node_ea04b0b6e1ac9086_source 0
XAMP_FIRST_P_DIODE register_cf_node_413bc7a49e70111c AMP__FIRST__MIR register_cf_node_413bc7a49e70111c_source VPWR sky130_fd_pr__pfet_01v8_hvt w=20 l=1 nf=1 m=1
Vregister_cf_413bc7a49e70111c AMP__FIRST__MIR register_cf_node_413bc7a49e70111c 0
Vregister_cf_413bc7a49e70111c_source VPWR register_cf_node_413bc7a49e70111c_source 0
XAMP_FIRST_P_MIRROR register_cf_node_6cd0bdba4494d382 AMP__FIRST__MIR register_cf_node_6cd0bdba4494d382_source VPWR sky130_fd_pr__pfet_01v8_hvt w=20 l=1 nf=1 m=1
Vregister_cf_6cd0bdba4494d382 AMP__PRE register_cf_node_6cd0bdba4494d382 0
Vregister_cf_6cd0bdba4494d382_source VPWR register_cf_node_6cd0bdba4494d382_source 0
XAMP_N_SECOND register_cf_node_bdf83b64ad4e9883 BIAS register_cf_node_bdf83b64ad4e9883_source VGND sky130_fd_pr__nfet_01v8 w=2 l=1 nf=1 m=1
Vregister_cf_bdf83b64ad4e9883 OUT register_cf_node_bdf83b64ad4e9883 0
Vregister_cf_bdf83b64ad4e9883_source VGND register_cf_node_bdf83b64ad4e9883_source 0
XAMP_P_SECOND register_cf_node_5504dd7f27ca564d AMP__PRE register_cf_node_5504dd7f27ca564d_source VPWR sky130_fd_pr__pfet_01v8_hvt w=40 l=1 nf=1 m=1
Vregister_cf_5504dd7f27ca564d OUT register_cf_node_5504dd7f27ca564d 0
Vregister_cf_5504dd7f27ca564d_source VPWR register_cf_node_5504dd7f27ca564d_source 0
XAMP_R_ZERO_P0 AMP__COMP OUT VGND sky130_fd_pr__res_xhigh_po_1p41 l=3.36
XGAIN_INVERTER_MN register_cf_node_e7e336b00d51fca7 GAIN register_cf_node_e7e336b00d51fca7_source VGND sky130_fd_pr__nfet_01v8 w=0.65 l=0.15 nf=1 m=1
Vregister_cf_e7e336b00d51fca7 GAINB register_cf_node_e7e336b00d51fca7 0
Vregister_cf_e7e336b00d51fca7_source VGND register_cf_node_e7e336b00d51fca7_source 0
XGAIN_INVERTER_MP register_cf_node_2dfb2478aad30aab GAIN register_cf_node_2dfb2478aad30aab_source VPWR sky130_fd_pr__pfet_01v8_hvt w=0.65 l=0.15 nf=1 m=1
Vregister_cf_2dfb2478aad30aab GAINB register_cf_node_2dfb2478aad30aab 0
Vregister_cf_2dfb2478aad30aab_source VPWR register_cf_node_2dfb2478aad30aab_source 0
XN_GAIN register_cf_node_cddc20703f546d7c GAINB register_cf_node_cddc20703f546d7c_source VGND sky130_fd_pr__nfet_01v8 w=20 l=0.15 nf=1 m=1
Vregister_cf_cddc20703f546d7c OUT register_cf_node_cddc20703f546d7c 0
Vregister_cf_cddc20703f546d7c_source LOW register_cf_node_cddc20703f546d7c_source 0
XP_GAIN register_cf_node_7641ed29816ec63f GAIN register_cf_node_7641ed29816ec63f_source VPWR sky130_fd_pr__pfet_01v8_hvt w=20 l=0.15 nf=1 m=1
Vregister_cf_7641ed29816ec63f OUT register_cf_node_7641ed29816ec63f 0
Vregister_cf_7641ed29816ec63f_source LOW register_cf_node_7641ed29816ec63f_source 0
XR_GROUND_P0 FB VCM VGND sky130_fd_pr__res_xhigh_po_1p41 l=6.885
XR_HIGH_P0 OUT R_HIGH_R0_N0 VGND sky130_fd_pr__res_xhigh_po_1p41 l=24.51
XR_HIGH_P1 R_HIGH_R0_N0 FB VGND sky130_fd_pr__res_xhigh_po_1p41 l=24.51
XR_LOW_P0 LOW FB VGND sky130_fd_pr__res_xhigh_po_1p41 l=8.06
.ends soc_pga

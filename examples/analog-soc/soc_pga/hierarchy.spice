.subckt SOC_OTA_FIRST INP INN BIAS OUT VPWR VGND
XN_INN0 MIR INN TAIL VGND sky130_fd_pr__nfet_01v8 w=5 l=1 nf=1 m=1
XN_INN1 MIR INN TAIL VGND sky130_fd_pr__nfet_01v8 w=5 l=1 nf=1 m=1
XN_INP0 OUT INP TAIL VGND sky130_fd_pr__nfet_01v8 w=5 l=1 nf=1 m=1
XN_INP1 OUT INP TAIL VGND sky130_fd_pr__nfet_01v8 w=5 l=1 nf=1 m=1
XN_TAIL TAIL BIAS VGND VGND sky130_fd_pr__nfet_01v8 w=2 l=1 nf=1 m=1
XP_DIODE MIR MIR VPWR VPWR sky130_fd_pr__pfet_01v8_hvt w=20 l=1 nf=1 m=1
XP_MIRROR OUT MIR VPWR VPWR sky130_fd_pr__pfet_01v8_hvt w=20 l=1 nf=1 m=1
.ends SOC_OTA_FIRST
.subckt SOC_OTA INP INN BIAS OUT VPWR VGND
CC_MILLER PRE COMP 5e-12
XFIRST INP INN BIAS PRE VPWR VGND SOC_OTA_FIRST
XN_SECOND OUT BIAS VGND VGND sky130_fd_pr__nfet_01v8 w=2 l=1 nf=1 m=1
XP_SECOND OUT PRE VPWR VPWR sky130_fd_pr__pfet_01v8_hvt w=40 l=1 nf=1 m=1
RR_ZERO COMP OUT 5000
.ends SOC_OTA
.subckt SOC_GAIN2 VIN VCM BIAS OUT VPWR VGND
XAMP VIN FB BIAS OUT VPWR VGND SOC_OTA
RR_FEEDBACK OUT FB 10000
RR_GROUND FB VCM 10000
.ends SOC_GAIN2
.subckt SOC_GAIN8 VIN VCM BIAS OUT VPWR VGND
XAMP VIN FB BIAS OUT VPWR VGND SOC_OTA
RR_FEEDBACK OUT FB 70000
RR_GROUND FB VCM 10000
.ends SOC_GAIN8
.subckt INV A Y VPWR VGND
XMN Y A VGND VGND sky130_fd_pr__nfet_01v8 w=0.65 l=0.15 nf=1 m=1
XMP Y A VPWR VPWR sky130_fd_pr__pfet_01v8_hvt w=0.65 l=0.15 nf=1 m=1
.ends INV
.subckt soc_pga VIN GAIN VCM BIAS OUT VPWR VGND
XGAIN2 VIN VCM BIAS V2 VPWR VGND SOC_GAIN2
XGAIN8 VIN VCM BIAS V8 VPWR VGND SOC_GAIN8
XGAIN_INVERTER GAIN GAINB VPWR VGND INV
XN_HIGH V8 GAIN SELECTED VGND sky130_fd_pr__nfet_01v8 w=20 l=0.15 nf=1 m=1
XN_LOW V2 GAINB SELECTED VGND sky130_fd_pr__nfet_01v8 w=20 l=0.15 nf=1 m=1
XOUTPUT_BUFFER SELECTED OUT BIAS OUT VPWR VGND SOC_OTA
XP_HIGH V8 GAINB SELECTED VPWR sky130_fd_pr__pfet_01v8_hvt w=20 l=0.15 nf=1 m=1
XP_LOW V2 GAIN SELECTED VPWR sky130_fd_pr__pfet_01v8_hvt w=20 l=0.15 nf=1 m=1
.ends soc_pga

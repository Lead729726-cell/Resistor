.subckt soc_tia IIN VCM BIAS OUT VPWR VGND
XAMP_C_MILLER_P0 AMP__PRE AMP__COMP sky130_fd_pr__cap_mim_m3_1 w=28.68 l=28.68
XAMP_C_MILLER_P1 AMP__PRE AMP__COMP sky130_fd_pr__cap_mim_m3_1 w=28.68 l=28.68
XAMP_C_MILLER_P2 AMP__PRE AMP__COMP sky130_fd_pr__cap_mim_m3_1 w=28.68 l=28.68
XAMP_FIRST_N_INN AMP__FIRST__MIR IIN AMP__FIRST__TAIL VGND sky130_fd_pr__nfet_01v8 w=10 l=1 nf=1 m=1
XAMP_FIRST_N_INP AMP__PRE VCM AMP__FIRST__TAIL VGND sky130_fd_pr__nfet_01v8 w=10 l=1 nf=1 m=1
XAMP_FIRST_N_TAIL AMP__FIRST__TAIL BIAS VGND VGND sky130_fd_pr__nfet_01v8 w=2 l=1 nf=1 m=1
XAMP_FIRST_P_DIODE AMP__FIRST__MIR AMP__FIRST__MIR VPWR VPWR sky130_fd_pr__pfet_01v8_hvt w=20 l=1 nf=1 m=1
XAMP_FIRST_P_MIRROR AMP__PRE AMP__FIRST__MIR VPWR VPWR sky130_fd_pr__pfet_01v8_hvt w=20 l=1 nf=1 m=1
XAMP_N_SECOND OUT BIAS VGND VGND sky130_fd_pr__nfet_01v8 w=2 l=1 nf=1 m=1
XAMP_P_SECOND OUT AMP__PRE VPWR VPWR sky130_fd_pr__pfet_01v8_hvt w=40 l=1 nf=1 m=1
XAMP_R_ZERO_P0 AMP__COMP OUT VGND sky130_fd_pr__res_xhigh_po_1p41 l=3.36
XC_FEEDBACK_P0 OUT IIN sky130_fd_pr__cap_mim_m3_1 w=22.17 l=22.17
XR_FEEDBACK_P0 OUT R_FEEDBACK_R0_N0 VGND sky130_fd_pr__res_xhigh_po_1p41 l=23.335
XR_FEEDBACK_P1 R_FEEDBACK_R0_N0 R_FEEDBACK_R0_N1 VGND sky130_fd_pr__res_xhigh_po_1p41 l=23.335
XR_FEEDBACK_P2 R_FEEDBACK_R0_N1 IIN VGND sky130_fd_pr__res_xhigh_po_1p41 l=23.335
.ends soc_tia

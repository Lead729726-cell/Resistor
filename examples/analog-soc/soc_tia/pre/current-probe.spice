.subckt soc_tia IIN VCM BIAS OUT VPWR VGND
XAMP_C_MILLER_P0 AMP__PRE AMP__COMP sky130_fd_pr__cap_mim_m3_1 w=28.68 l=28.68
XAMP_C_MILLER_P1 AMP__PRE AMP__COMP sky130_fd_pr__cap_mim_m3_1 w=28.68 l=28.68
XAMP_C_MILLER_P2 AMP__PRE AMP__COMP sky130_fd_pr__cap_mim_m3_1 w=28.68 l=28.68
XAMP_FIRST_N_INN0 register_cf_node_d6f90f75490fea4a IIN register_cf_node_d6f90f75490fea4a_source VGND sky130_fd_pr__nfet_01v8 w=5 l=1 nf=1 m=1
Vregister_cf_d6f90f75490fea4a AMP__FIRST__MIR register_cf_node_d6f90f75490fea4a 0
Vregister_cf_d6f90f75490fea4a_source AMP__FIRST__TAIL register_cf_node_d6f90f75490fea4a_source 0
XAMP_FIRST_N_INN1 register_cf_node_bd31542253e56214 IIN register_cf_node_bd31542253e56214_source VGND sky130_fd_pr__nfet_01v8 w=5 l=1 nf=1 m=1
Vregister_cf_bd31542253e56214 AMP__FIRST__MIR register_cf_node_bd31542253e56214 0
Vregister_cf_bd31542253e56214_source AMP__FIRST__TAIL register_cf_node_bd31542253e56214_source 0
XAMP_FIRST_N_INP0 register_cf_node_7e25c59bcd3edfc6 VCM register_cf_node_7e25c59bcd3edfc6_source VGND sky130_fd_pr__nfet_01v8 w=5 l=1 nf=1 m=1
Vregister_cf_7e25c59bcd3edfc6 AMP__PRE register_cf_node_7e25c59bcd3edfc6 0
Vregister_cf_7e25c59bcd3edfc6_source AMP__FIRST__TAIL register_cf_node_7e25c59bcd3edfc6_source 0
XAMP_FIRST_N_INP1 register_cf_node_070984e441913c39 VCM register_cf_node_070984e441913c39_source VGND sky130_fd_pr__nfet_01v8 w=5 l=1 nf=1 m=1
Vregister_cf_070984e441913c39 AMP__PRE register_cf_node_070984e441913c39 0
Vregister_cf_070984e441913c39_source AMP__FIRST__TAIL register_cf_node_070984e441913c39_source 0
XAMP_FIRST_N_TAIL register_cf_node_f9a25b45702385e2 BIAS register_cf_node_f9a25b45702385e2_source VGND sky130_fd_pr__nfet_01v8 w=2 l=1 nf=1 m=1
Vregister_cf_f9a25b45702385e2 AMP__FIRST__TAIL register_cf_node_f9a25b45702385e2 0
Vregister_cf_f9a25b45702385e2_source VGND register_cf_node_f9a25b45702385e2_source 0
XAMP_FIRST_P_DIODE register_cf_node_d68525ab798b50da AMP__FIRST__MIR register_cf_node_d68525ab798b50da_source VPWR sky130_fd_pr__pfet_01v8_hvt w=20 l=1 nf=1 m=1
Vregister_cf_d68525ab798b50da AMP__FIRST__MIR register_cf_node_d68525ab798b50da 0
Vregister_cf_d68525ab798b50da_source VPWR register_cf_node_d68525ab798b50da_source 0
XAMP_FIRST_P_MIRROR register_cf_node_50c72756537eac7b AMP__FIRST__MIR register_cf_node_50c72756537eac7b_source VPWR sky130_fd_pr__pfet_01v8_hvt w=20 l=1 nf=1 m=1
Vregister_cf_50c72756537eac7b AMP__PRE register_cf_node_50c72756537eac7b 0
Vregister_cf_50c72756537eac7b_source VPWR register_cf_node_50c72756537eac7b_source 0
XAMP_N_SECOND register_cf_node_3f5de34c96f32878 BIAS register_cf_node_3f5de34c96f32878_source VGND sky130_fd_pr__nfet_01v8 w=2 l=1 nf=1 m=1
Vregister_cf_3f5de34c96f32878 OUT register_cf_node_3f5de34c96f32878 0
Vregister_cf_3f5de34c96f32878_source VGND register_cf_node_3f5de34c96f32878_source 0
XAMP_P_SECOND register_cf_node_f6a8771ad017e01c AMP__PRE register_cf_node_f6a8771ad017e01c_source VPWR sky130_fd_pr__pfet_01v8_hvt w=40 l=1 nf=1 m=1
Vregister_cf_f6a8771ad017e01c OUT register_cf_node_f6a8771ad017e01c 0
Vregister_cf_f6a8771ad017e01c_source VPWR register_cf_node_f6a8771ad017e01c_source 0
XAMP_R_ZERO_P0 AMP__COMP OUT VGND sky130_fd_pr__res_xhigh_po_1p41 l=3.36
XC_FEEDBACK_P0 OUT IIN sky130_fd_pr__cap_mim_m3_1 w=22.17 l=22.17
XR_FEEDBACK_P0 OUT R_FEEDBACK_R0_N0 VGND sky130_fd_pr__res_xhigh_po_1p41 l=23.335
XR_FEEDBACK_P1 R_FEEDBACK_R0_N0 R_FEEDBACK_R0_N1 VGND sky130_fd_pr__res_xhigh_po_1p41 l=23.335
XR_FEEDBACK_P2 R_FEEDBACK_R0_N1 IIN VGND sky130_fd_pr__res_xhigh_po_1p41 l=23.335
.ends soc_tia

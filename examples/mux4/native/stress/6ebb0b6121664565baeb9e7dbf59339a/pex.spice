* NGSPICE file created from mux4.ext - technology: sky130A

.subckt mux4 VPWR VGND Y S0 D3 D2 S1 D1 D0
X0 VPWR.t4 S1.t0 S1B.t0 VPWR.t3 sky130_fd_pr__pfet_01v8_hvt ad=0.1885 pd=1.88 as=0.1885 ps=1.88 w=0.65 l=0.15
X1 D3.t0 S0.t0 N23.t1 VGND.t8 sky130_fd_pr__nfet_01v8 ad=0.1885 pd=1.88 as=0.1885 ps=1.88 w=0.65 l=0.15
X2 N01.t0 S1.t1 MUX_RAW.t1 VPWR.t2 sky130_fd_pr__pfet_01v8_hvt ad=0.1885 pd=1.88 as=0.1885 ps=1.88 w=0.65 l=0.15
X3 VGND.t4 MUX_RAW.t4 BUF_N.t1 VGND.t3 sky130_fd_pr__nfet_01v8 ad=0.1885 pd=1.88 as=0.1885 ps=1.88 w=0.65 l=0.15
X4 VPWR.t6 BUF_N.t2 Y.t0 VPWR.t5 sky130_fd_pr__pfet_01v8_hvt ad=0.1885 pd=1.88 as=0.1885 ps=1.88 w=0.65 l=0.15
X5 VGND.t2 S1.t2 S1B.t1 VGND.t1 sky130_fd_pr__nfet_01v8 ad=0.1885 pd=1.88 as=0.1885 ps=1.88 w=0.65 l=0.15
X6 D0.t0 S0.t1 N01.t2 VPWR.t8 sky130_fd_pr__pfet_01v8_hvt ad=0.1885 pd=1.88 as=0.1885 ps=1.88 w=0.65 l=0.15
X7 N01.t3 S1B.t2 MUX_RAW.t2 VGND.t9 sky130_fd_pr__nfet_01v8 ad=0.1885 pd=1.88 as=0.1885 ps=1.88 w=0.65 l=0.15
X8 D1.t0 S0B.t2 N01.t4 VPWR.t12 sky130_fd_pr__pfet_01v8_hvt ad=0.1885 pd=1.88 as=0.1885 ps=1.88 w=0.65 l=0.15
X9 N23.t3 S1B.t3 MUX_RAW.t3 VPWR.t11 sky130_fd_pr__pfet_01v8_hvt ad=0.1885 pd=1.88 as=0.1885 ps=1.88 w=0.65 l=0.15
X10 VGND.t11 BUF_N.t3 Y.t1 VGND.t10 sky130_fd_pr__nfet_01v8 ad=0.1885 pd=1.88 as=0.1885 ps=1.88 w=0.65 l=0.15
X11 VPWR.t10 MUX_RAW.t5 BUF_N.t0 VPWR.t9 sky130_fd_pr__pfet_01v8_hvt ad=0.1885 pd=1.88 as=0.1885 ps=1.88 w=0.65 l=0.15
X12 VPWR.t1 S0.t2 S0B.t0 VPWR.t0 sky130_fd_pr__pfet_01v8_hvt ad=0.1885 pd=1.88 as=0.1885 ps=1.88 w=0.65 l=0.15
X13 D0.t1 S0B.t3 N01.t5 VGND.t12 sky130_fd_pr__nfet_01v8 ad=0.1885 pd=1.88 as=0.1885 ps=1.88 w=0.65 l=0.15
X14 N23.t0 S1.t3 MUX_RAW.t0 VGND.t0 sky130_fd_pr__nfet_01v8 ad=0.1885 pd=1.88 as=0.1885 ps=1.88 w=0.65 l=0.15
X15 D1.t1 S0.t3 N01.t1 VGND.t7 sky130_fd_pr__nfet_01v8 ad=0.1885 pd=1.88 as=0.1885 ps=1.88 w=0.65 l=0.15
X16 D2.t1 S0.t4 N23.t2 VPWR.t7 sky130_fd_pr__pfet_01v8_hvt ad=0.1885 pd=1.88 as=0.1885 ps=1.88 w=0.65 l=0.15
X17 VGND.t6 S0.t5 S0B.t1 VGND.t5 sky130_fd_pr__nfet_01v8 ad=0.1885 pd=1.88 as=0.1885 ps=1.88 w=0.65 l=0.15
X18 D2.t0 S0B.t4 N23.t5 VGND.t13 sky130_fd_pr__nfet_01v8 ad=0.1885 pd=1.88 as=0.1885 ps=1.88 w=0.65 l=0.15
X19 D3.t1 S0B.t5 N23.t4 VPWR.t13 sky130_fd_pr__pfet_01v8_hvt ad=0.1885 pd=1.88 as=0.1885 ps=1.88 w=0.65 l=0.15
C0 D0 S1B 0.22986f
C1 S1 N23 0.96108f
C2 S1 S0B 9.00044f
C3 D1 D3 0.125f
C4 D0 N23 0.37145f
C5 D0 S0B 0.60858f
C6 N01 S1B 0.88643f
C7 S0 S1B 0.37149f
C8 S1 VPWR 0.63933f
C9 N01 N23 9.10711f
C10 N01 S0B 1.68055f
C11 D0 VPWR 0.13235f
C12 S0 N23 10.5739f
C13 S0 S0B 10.8097f
C14 D2 D3 8.85184f
C15 D3 Y 0.14118f
C16 BUF_N D3 0.14604f
C17 VPWR N01 0.37755f
C18 D3 MUX_RAW 9.19831f
C19 D0 S1 0.22944f
C20 VPWR S0 0.94313f
C21 D1 D2 8.85201f
C22 D1 Y 0.14127f
C23 D1 BUF_N 0.14845f
C24 S1 N01 0.94289f
C25 D1 MUX_RAW 0.39003f
C26 S1 S0 0.33562f
C27 D3 S1B 0.22957f
C28 D0 N01 0.75914f
C29 D0 S0 0.60766f
C30 D2 Y 0.14118f
C31 D3 N23 0.73768f
C32 D3 S0B 0.83322f
C33 D1 S1B 0.22964f
C34 D2 BUF_N 0.14672f
C35 D2 MUX_RAW 0.39053f
C36 BUF_N Y 0.58876f
C37 MUX_RAW Y 0.2156f
C38 S0 N01 1.64947f
C39 BUF_N MUX_RAW 0.87979f
C40 D1 N23 0.43876f
C41 VPWR D3 0.12805f
C42 D1 S0B 0.68003f
C43 D2 S1B 0.2296f
C44 S1B Y 8.86334f
C45 D1 VPWR 0.13019f
C46 S1 D3 0.2296f
C47 BUF_N S1B 0.27155f
C48 S1B MUX_RAW 1.3204f
C49 D2 N23 0.80481f
C50 D2 S0B 0.7616f
C51 N23 Y 0.14207f
C52 S0B Y 0.14316f
C53 D0 D3 0.12445f
C54 BUF_N N23 0.47959f
C55 D1 S1 0.22943f
C56 MUX_RAW N23 0.80135f
C57 BUF_N S0B 0.39205f
C58 S0B MUX_RAW 0.36661f
C59 VPWR D2 0.12888f
C60 VPWR Y 0.26282f
C61 D3 N01 0.37244f
C62 D1 D0 8.8523f
C63 S0 D3 0.84625f
C64 VPWR BUF_N 0.79062f
C65 VPWR MUX_RAW 0.58792f
C66 S1B N23 0.93597f
C67 S1 D2 0.22943f
C68 S1B S0B 0.28231f
C69 S1 Y 0.15142f
C70 D1 N01 0.71459f
C71 D1 S0 0.68929f
C72 S1 BUF_N 0.27055f
C73 S1 MUX_RAW 1.32548f
C74 D0 D2 0.12524f
C75 S0B N23 1.81727f
C76 D0 Y 0.14144f
C77 VPWR S1B 0.56682f
C78 D0 BUF_N 8.86831f
C79 D0 MUX_RAW 0.39014f
C80 D2 N01 0.37189f
C81 VPWR N23 0.37611f
C82 N01 Y 0.14189f
C83 D2 S0 0.76095f
C84 VPWR S0B 0.87077f
C85 S0 Y 0.14242f
C86 S1 S1B 10.9489f
C87 BUF_N N01 0.43528f
C88 N01 MUX_RAW 9.58615f
C89 S0 BUF_N 0.39667f
C90 S0 MUX_RAW 0.38277f
R0 S1 S1.t0 330.341
R1 S1 S1.t1 330.341
R2 S1 S1.t2 315.88
R3 S1 S1.t3 315.88
R4 S1 S1.n2 33.2572
R5 S1.n1 S1 31.154
R6 S1.n2 S1 31.1384
R7 S1.n0 S1 31.1384
R8 S1.n2 S1.n1 6.33375
R9 S1.n0 S1 1.63962
R10 S1.n1 S1.n0 0.69375
R11 S1B.t0 S1B.n0 700.484
R12 S1B.n7 S1B.t0 700.484
R13 S1B S1B.t3 330.341
R14 S1B S1B.t2 315.88
R15 S1B.t1 S1B.n2 255.345
R16 S1B.n3 S1B.t1 255.345
R17 S1B.n1 S1B 32.1788
R18 S1B.n1 S1B 31.5012
R19 S1B.n6 S1B.n5 13.761
R20 S1B.n5 S1B.n4 13.0677
R21 S1B S1B.n2 12.8005
R22 S1B.n3 S1B 12.8005
R23 S1B S1B.n0 12.8005
R24 S1B S1B.n7 12.8005
R25 S1B.n4 S1B.n2 10.1513
R26 S1B.n4 S1B.n3 10.1513
R27 S1B.n6 S1B.n0 10.1513
R28 S1B.n7 S1B.n6 10.1513
R29 S1B.n5 S1B.n1 7.13275
R30 VPWR.n55 VPWR.n43 832.942
R31 VPWR.n66 VPWR.n44 832.942
R32 VPWR.n68 VPWR.n41 832.942
R33 VPWR.n50 VPWR.n40 832.942
R34 VPWR.n92 VPWR.n80 832.942
R35 VPWR.n103 VPWR.n81 832.942
R36 VPWR.n105 VPWR.n78 832.942
R37 VPWR.n87 VPWR.n77 832.942
R38 VPWR.n125 VPWR.n113 832.942
R39 VPWR.n136 VPWR.n114 832.942
R40 VPWR.n138 VPWR.n111 832.942
R41 VPWR.n120 VPWR.n110 832.942
R42 VPWR.n158 VPWR.n146 832.942
R43 VPWR.n169 VPWR.n147 832.942
R44 VPWR.n171 VPWR.n144 832.942
R45 VPWR.n153 VPWR.n143 832.942
R46 VPWR.n191 VPWR.n179 832.942
R47 VPWR.n202 VPWR.n180 832.942
R48 VPWR.n204 VPWR.n177 832.942
R49 VPWR.n186 VPWR.n176 832.942
R50 VPWR.n224 VPWR.n212 832.942
R51 VPWR.n235 VPWR.n213 832.942
R52 VPWR.n237 VPWR.n210 832.942
R53 VPWR.n219 VPWR.n209 832.942
R54 VPWR.n257 VPWR.n245 832.942
R55 VPWR.n268 VPWR.n246 832.942
R56 VPWR.n270 VPWR.n243 832.942
R57 VPWR.n252 VPWR.n242 832.942
R58 VPWR.n290 VPWR.n278 832.942
R59 VPWR.n301 VPWR.n279 832.942
R60 VPWR.n303 VPWR.n276 832.942
R61 VPWR.n285 VPWR.n275 832.942
R62 VPWR.n327 VPWR.n315 832.942
R63 VPWR.n338 VPWR.n316 832.942
R64 VPWR.n340 VPWR.n313 832.942
R65 VPWR.n322 VPWR.n312 832.942
R66 VPWR.n18 VPWR.n6 832.942
R67 VPWR.n29 VPWR.n7 832.942
R68 VPWR.n31 VPWR.n4 832.942
R69 VPWR.n13 VPWR.n3 832.942
R70 VPWR.t1 VPWR.n34 700.484
R71 VPWR.n35 VPWR.t1 700.484
R72 VPWR.t4 VPWR.n71 700.484
R73 VPWR.n72 VPWR.t4 700.484
R74 VPWR.t10 VPWR.n306 700.484
R75 VPWR.n307 VPWR.t10 700.484
R76 VPWR.t6 VPWR.n0 700.484
R77 VPWR.n344 VPWR.t6 700.484
R78 VPWR.n66 VPWR.n43 240
R79 VPWR.n62 VPWR.n60 240
R80 VPWR.n68 VPWR.n40 240
R81 VPWR.n47 VPWR.n46 240
R82 VPWR.n103 VPWR.n80 240
R83 VPWR.n99 VPWR.n97 240
R84 VPWR.n105 VPWR.n77 240
R85 VPWR.n84 VPWR.n83 240
R86 VPWR.n136 VPWR.n113 240
R87 VPWR.n132 VPWR.n130 240
R88 VPWR.n138 VPWR.n110 240
R89 VPWR.n117 VPWR.n116 240
R90 VPWR.n169 VPWR.n146 240
R91 VPWR.n165 VPWR.n163 240
R92 VPWR.n171 VPWR.n143 240
R93 VPWR.n150 VPWR.n149 240
R94 VPWR.n202 VPWR.n179 240
R95 VPWR.n198 VPWR.n196 240
R96 VPWR.n204 VPWR.n176 240
R97 VPWR.n183 VPWR.n182 240
R98 VPWR.n235 VPWR.n212 240
R99 VPWR.n231 VPWR.n229 240
R100 VPWR.n237 VPWR.n209 240
R101 VPWR.n216 VPWR.n215 240
R102 VPWR.n268 VPWR.n245 240
R103 VPWR.n264 VPWR.n262 240
R104 VPWR.n270 VPWR.n242 240
R105 VPWR.n249 VPWR.n248 240
R106 VPWR.n301 VPWR.n278 240
R107 VPWR.n297 VPWR.n295 240
R108 VPWR.n303 VPWR.n275 240
R109 VPWR.n282 VPWR.n281 240
R110 VPWR.n338 VPWR.n315 240
R111 VPWR.n334 VPWR.n332 240
R112 VPWR.n340 VPWR.n312 240
R113 VPWR.n319 VPWR.n318 240
R114 VPWR.n29 VPWR.n6 240
R115 VPWR.n25 VPWR.n23 240
R116 VPWR.n31 VPWR.n3 240
R117 VPWR.n10 VPWR.n9 240
R118 VPWR.n53 VPWR.n52 207.394
R119 VPWR.n67 VPWR.n42 207.394
R120 VPWR.n90 VPWR.n89 207.394
R121 VPWR.n104 VPWR.n79 207.394
R122 VPWR.n123 VPWR.n122 207.394
R123 VPWR.n137 VPWR.n112 207.394
R124 VPWR.n156 VPWR.n155 207.394
R125 VPWR.n170 VPWR.n145 207.394
R126 VPWR.n189 VPWR.n188 207.394
R127 VPWR.n203 VPWR.n178 207.394
R128 VPWR.n222 VPWR.n221 207.394
R129 VPWR.n236 VPWR.n211 207.394
R130 VPWR.n255 VPWR.n254 207.394
R131 VPWR.n269 VPWR.n244 207.394
R132 VPWR.n288 VPWR.n287 207.394
R133 VPWR.n302 VPWR.n277 207.394
R134 VPWR.n325 VPWR.n324 207.394
R135 VPWR.n339 VPWR.n314 207.394
R136 VPWR.n16 VPWR.n15 207.394
R137 VPWR.n30 VPWR.n5 207.394
R138 VPWR.n50 VPWR.n49 185
R139 VPWR.n48 VPWR.n47 185
R140 VPWR.n46 VPWR.n45 185
R141 VPWR.n56 VPWR.n55 185
R142 VPWR.n57 VPWR.n43 185
R143 VPWR.n52 VPWR.n43 185
R144 VPWR.n66 VPWR.n65 185
R145 VPWR.n67 VPWR.n66 185
R146 VPWR.n64 VPWR.n44 185
R147 VPWR.n63 VPWR.n62 185
R148 VPWR.n60 VPWR.n58 185
R149 VPWR.n41 VPWR.n39 185
R150 VPWR.n69 VPWR.n68 185
R151 VPWR.n68 VPWR.n67 185
R152 VPWR.n40 VPWR.n38 185
R153 VPWR.n52 VPWR.n40 185
R154 VPWR.n87 VPWR.n86 185
R155 VPWR.n85 VPWR.n84 185
R156 VPWR.n83 VPWR.n82 185
R157 VPWR.n93 VPWR.n92 185
R158 VPWR.n94 VPWR.n80 185
R159 VPWR.n89 VPWR.n80 185
R160 VPWR.n103 VPWR.n102 185
R161 VPWR.n104 VPWR.n103 185
R162 VPWR.n101 VPWR.n81 185
R163 VPWR.n100 VPWR.n99 185
R164 VPWR.n97 VPWR.n95 185
R165 VPWR.n78 VPWR.n76 185
R166 VPWR.n106 VPWR.n105 185
R167 VPWR.n105 VPWR.n104 185
R168 VPWR.n77 VPWR.n75 185
R169 VPWR.n89 VPWR.n77 185
R170 VPWR.n120 VPWR.n119 185
R171 VPWR.n118 VPWR.n117 185
R172 VPWR.n116 VPWR.n115 185
R173 VPWR.n126 VPWR.n125 185
R174 VPWR.n127 VPWR.n113 185
R175 VPWR.n122 VPWR.n113 185
R176 VPWR.n136 VPWR.n135 185
R177 VPWR.n137 VPWR.n136 185
R178 VPWR.n134 VPWR.n114 185
R179 VPWR.n133 VPWR.n132 185
R180 VPWR.n130 VPWR.n128 185
R181 VPWR.n111 VPWR.n109 185
R182 VPWR.n139 VPWR.n138 185
R183 VPWR.n138 VPWR.n137 185
R184 VPWR.n110 VPWR.n108 185
R185 VPWR.n122 VPWR.n110 185
R186 VPWR.n153 VPWR.n152 185
R187 VPWR.n151 VPWR.n150 185
R188 VPWR.n149 VPWR.n148 185
R189 VPWR.n159 VPWR.n158 185
R190 VPWR.n160 VPWR.n146 185
R191 VPWR.n155 VPWR.n146 185
R192 VPWR.n169 VPWR.n168 185
R193 VPWR.n170 VPWR.n169 185
R194 VPWR.n167 VPWR.n147 185
R195 VPWR.n166 VPWR.n165 185
R196 VPWR.n163 VPWR.n161 185
R197 VPWR.n144 VPWR.n142 185
R198 VPWR.n172 VPWR.n171 185
R199 VPWR.n171 VPWR.n170 185
R200 VPWR.n143 VPWR.n141 185
R201 VPWR.n155 VPWR.n143 185
R202 VPWR.n186 VPWR.n185 185
R203 VPWR.n184 VPWR.n183 185
R204 VPWR.n182 VPWR.n181 185
R205 VPWR.n192 VPWR.n191 185
R206 VPWR.n193 VPWR.n179 185
R207 VPWR.n188 VPWR.n179 185
R208 VPWR.n202 VPWR.n201 185
R209 VPWR.n203 VPWR.n202 185
R210 VPWR.n200 VPWR.n180 185
R211 VPWR.n199 VPWR.n198 185
R212 VPWR.n196 VPWR.n194 185
R213 VPWR.n177 VPWR.n175 185
R214 VPWR.n205 VPWR.n204 185
R215 VPWR.n204 VPWR.n203 185
R216 VPWR.n176 VPWR.n174 185
R217 VPWR.n188 VPWR.n176 185
R218 VPWR.n219 VPWR.n218 185
R219 VPWR.n217 VPWR.n216 185
R220 VPWR.n215 VPWR.n214 185
R221 VPWR.n225 VPWR.n224 185
R222 VPWR.n226 VPWR.n212 185
R223 VPWR.n221 VPWR.n212 185
R224 VPWR.n235 VPWR.n234 185
R225 VPWR.n236 VPWR.n235 185
R226 VPWR.n233 VPWR.n213 185
R227 VPWR.n232 VPWR.n231 185
R228 VPWR.n229 VPWR.n227 185
R229 VPWR.n210 VPWR.n208 185
R230 VPWR.n238 VPWR.n237 185
R231 VPWR.n237 VPWR.n236 185
R232 VPWR.n209 VPWR.n207 185
R233 VPWR.n221 VPWR.n209 185
R234 VPWR.n252 VPWR.n251 185
R235 VPWR.n250 VPWR.n249 185
R236 VPWR.n248 VPWR.n247 185
R237 VPWR.n258 VPWR.n257 185
R238 VPWR.n259 VPWR.n245 185
R239 VPWR.n254 VPWR.n245 185
R240 VPWR.n268 VPWR.n267 185
R241 VPWR.n269 VPWR.n268 185
R242 VPWR.n266 VPWR.n246 185
R243 VPWR.n265 VPWR.n264 185
R244 VPWR.n262 VPWR.n260 185
R245 VPWR.n243 VPWR.n241 185
R246 VPWR.n271 VPWR.n270 185
R247 VPWR.n270 VPWR.n269 185
R248 VPWR.n242 VPWR.n240 185
R249 VPWR.n254 VPWR.n242 185
R250 VPWR.n285 VPWR.n284 185
R251 VPWR.n283 VPWR.n282 185
R252 VPWR.n281 VPWR.n280 185
R253 VPWR.n291 VPWR.n290 185
R254 VPWR.n292 VPWR.n278 185
R255 VPWR.n287 VPWR.n278 185
R256 VPWR.n301 VPWR.n300 185
R257 VPWR.n302 VPWR.n301 185
R258 VPWR.n299 VPWR.n279 185
R259 VPWR.n298 VPWR.n297 185
R260 VPWR.n295 VPWR.n293 185
R261 VPWR.n276 VPWR.n274 185
R262 VPWR.n304 VPWR.n303 185
R263 VPWR.n303 VPWR.n302 185
R264 VPWR.n275 VPWR.n273 185
R265 VPWR.n287 VPWR.n275 185
R266 VPWR.n322 VPWR.n321 185
R267 VPWR.n320 VPWR.n319 185
R268 VPWR.n318 VPWR.n317 185
R269 VPWR.n328 VPWR.n327 185
R270 VPWR.n329 VPWR.n315 185
R271 VPWR.n324 VPWR.n315 185
R272 VPWR.n338 VPWR.n337 185
R273 VPWR.n339 VPWR.n338 185
R274 VPWR.n336 VPWR.n316 185
R275 VPWR.n335 VPWR.n334 185
R276 VPWR.n332 VPWR.n330 185
R277 VPWR.n313 VPWR.n311 185
R278 VPWR.n341 VPWR.n340 185
R279 VPWR.n340 VPWR.n339 185
R280 VPWR.n312 VPWR.n310 185
R281 VPWR.n324 VPWR.n312 185
R282 VPWR.n13 VPWR.n12 185
R283 VPWR.n11 VPWR.n10 185
R284 VPWR.n9 VPWR.n8 185
R285 VPWR.n19 VPWR.n18 185
R286 VPWR.n20 VPWR.n6 185
R287 VPWR.n15 VPWR.n6 185
R288 VPWR.n29 VPWR.n28 185
R289 VPWR.n30 VPWR.n29 185
R290 VPWR.n27 VPWR.n7 185
R291 VPWR.n26 VPWR.n25 185
R292 VPWR.n23 VPWR.n21 185
R293 VPWR.n4 VPWR.n2 185
R294 VPWR.n32 VPWR.n31 185
R295 VPWR.n31 VPWR.n30 185
R296 VPWR.n3 VPWR.n1 185
R297 VPWR.n15 VPWR.n3 185
R298 VPWR.n57 VPWR.n56 88.8476
R299 VPWR.n49 VPWR.n38 88.8476
R300 VPWR.n65 VPWR.n64 88.8476
R301 VPWR.n69 VPWR.n39 88.8476
R302 VPWR.n94 VPWR.n93 88.8476
R303 VPWR.n86 VPWR.n75 88.8476
R304 VPWR.n102 VPWR.n101 88.8476
R305 VPWR.n106 VPWR.n76 88.8476
R306 VPWR.n127 VPWR.n126 88.8476
R307 VPWR.n119 VPWR.n108 88.8476
R308 VPWR.n135 VPWR.n134 88.8476
R309 VPWR.n139 VPWR.n109 88.8476
R310 VPWR.n160 VPWR.n159 88.8476
R311 VPWR.n152 VPWR.n141 88.8476
R312 VPWR.n168 VPWR.n167 88.8476
R313 VPWR.n172 VPWR.n142 88.8476
R314 VPWR.n193 VPWR.n192 88.8476
R315 VPWR.n185 VPWR.n174 88.8476
R316 VPWR.n201 VPWR.n200 88.8476
R317 VPWR.n205 VPWR.n175 88.8476
R318 VPWR.n226 VPWR.n225 88.8476
R319 VPWR.n218 VPWR.n207 88.8476
R320 VPWR.n234 VPWR.n233 88.8476
R321 VPWR.n238 VPWR.n208 88.8476
R322 VPWR.n259 VPWR.n258 88.8476
R323 VPWR.n251 VPWR.n240 88.8476
R324 VPWR.n267 VPWR.n266 88.8476
R325 VPWR.n271 VPWR.n241 88.8476
R326 VPWR.n292 VPWR.n291 88.8476
R327 VPWR.n284 VPWR.n273 88.8476
R328 VPWR.n300 VPWR.n299 88.8476
R329 VPWR.n304 VPWR.n274 88.8476
R330 VPWR.n329 VPWR.n328 88.8476
R331 VPWR.n321 VPWR.n310 88.8476
R332 VPWR.n337 VPWR.n336 88.8476
R333 VPWR.n341 VPWR.n311 88.8476
R334 VPWR.n20 VPWR.n19 88.8476
R335 VPWR.n12 VPWR.n1 88.8476
R336 VPWR.n28 VPWR.n27 88.8476
R337 VPWR.n32 VPWR.n2 88.8476
R338 VPWR.n61 VPWR.n44 72.7879
R339 VPWR.n59 VPWR.n41 72.7879
R340 VPWR.n55 VPWR.n54 72.7879
R341 VPWR.n51 VPWR.n47 72.7879
R342 VPWR.n51 VPWR.n50 72.7879
R343 VPWR.n54 VPWR.n46 72.7879
R344 VPWR.n62 VPWR.n61 72.7879
R345 VPWR.n60 VPWR.n59 72.7879
R346 VPWR.n98 VPWR.n81 72.7879
R347 VPWR.n96 VPWR.n78 72.7879
R348 VPWR.n92 VPWR.n91 72.7879
R349 VPWR.n88 VPWR.n84 72.7879
R350 VPWR.n88 VPWR.n87 72.7879
R351 VPWR.n91 VPWR.n83 72.7879
R352 VPWR.n99 VPWR.n98 72.7879
R353 VPWR.n97 VPWR.n96 72.7879
R354 VPWR.n131 VPWR.n114 72.7879
R355 VPWR.n129 VPWR.n111 72.7879
R356 VPWR.n125 VPWR.n124 72.7879
R357 VPWR.n121 VPWR.n117 72.7879
R358 VPWR.n121 VPWR.n120 72.7879
R359 VPWR.n124 VPWR.n116 72.7879
R360 VPWR.n132 VPWR.n131 72.7879
R361 VPWR.n130 VPWR.n129 72.7879
R362 VPWR.n164 VPWR.n147 72.7879
R363 VPWR.n162 VPWR.n144 72.7879
R364 VPWR.n158 VPWR.n157 72.7879
R365 VPWR.n154 VPWR.n150 72.7879
R366 VPWR.n154 VPWR.n153 72.7879
R367 VPWR.n157 VPWR.n149 72.7879
R368 VPWR.n165 VPWR.n164 72.7879
R369 VPWR.n163 VPWR.n162 72.7879
R370 VPWR.n197 VPWR.n180 72.7879
R371 VPWR.n195 VPWR.n177 72.7879
R372 VPWR.n191 VPWR.n190 72.7879
R373 VPWR.n187 VPWR.n183 72.7879
R374 VPWR.n187 VPWR.n186 72.7879
R375 VPWR.n190 VPWR.n182 72.7879
R376 VPWR.n198 VPWR.n197 72.7879
R377 VPWR.n196 VPWR.n195 72.7879
R378 VPWR.n230 VPWR.n213 72.7879
R379 VPWR.n228 VPWR.n210 72.7879
R380 VPWR.n224 VPWR.n223 72.7879
R381 VPWR.n220 VPWR.n216 72.7879
R382 VPWR.n220 VPWR.n219 72.7879
R383 VPWR.n223 VPWR.n215 72.7879
R384 VPWR.n231 VPWR.n230 72.7879
R385 VPWR.n229 VPWR.n228 72.7879
R386 VPWR.n263 VPWR.n246 72.7879
R387 VPWR.n261 VPWR.n243 72.7879
R388 VPWR.n257 VPWR.n256 72.7879
R389 VPWR.n253 VPWR.n249 72.7879
R390 VPWR.n253 VPWR.n252 72.7879
R391 VPWR.n256 VPWR.n248 72.7879
R392 VPWR.n264 VPWR.n263 72.7879
R393 VPWR.n262 VPWR.n261 72.7879
R394 VPWR.n296 VPWR.n279 72.7879
R395 VPWR.n294 VPWR.n276 72.7879
R396 VPWR.n290 VPWR.n289 72.7879
R397 VPWR.n286 VPWR.n282 72.7879
R398 VPWR.n286 VPWR.n285 72.7879
R399 VPWR.n289 VPWR.n281 72.7879
R400 VPWR.n297 VPWR.n296 72.7879
R401 VPWR.n295 VPWR.n294 72.7879
R402 VPWR.n333 VPWR.n316 72.7879
R403 VPWR.n331 VPWR.n313 72.7879
R404 VPWR.n327 VPWR.n326 72.7879
R405 VPWR.n323 VPWR.n319 72.7879
R406 VPWR.n323 VPWR.n322 72.7879
R407 VPWR.n326 VPWR.n318 72.7879
R408 VPWR.n334 VPWR.n333 72.7879
R409 VPWR.n332 VPWR.n331 72.7879
R410 VPWR.n24 VPWR.n7 72.7879
R411 VPWR.n22 VPWR.n4 72.7879
R412 VPWR.n18 VPWR.n17 72.7879
R413 VPWR.n14 VPWR.n10 72.7879
R414 VPWR.n14 VPWR.n13 72.7879
R415 VPWR.n17 VPWR.n9 72.7879
R416 VPWR.n25 VPWR.n24 72.7879
R417 VPWR.n23 VPWR.n22 72.7879
R418 VPWR.n52 VPWR.t3 56.8667
R419 VPWR.n67 VPWR.t3 56.8667
R420 VPWR.n89 VPWR.t8 56.8667
R421 VPWR.n104 VPWR.t8 56.8667
R422 VPWR.n122 VPWR.t12 56.8667
R423 VPWR.n137 VPWR.t12 56.8667
R424 VPWR.n155 VPWR.t7 56.8667
R425 VPWR.n170 VPWR.t7 56.8667
R426 VPWR.n188 VPWR.t13 56.8667
R427 VPWR.n203 VPWR.t13 56.8667
R428 VPWR.n221 VPWR.t2 56.8667
R429 VPWR.n236 VPWR.t2 56.8667
R430 VPWR.n254 VPWR.t11 56.8667
R431 VPWR.n269 VPWR.t11 56.8667
R432 VPWR.n287 VPWR.t9 56.8667
R433 VPWR.n302 VPWR.t9 56.8667
R434 VPWR.n324 VPWR.t5 56.8667
R435 VPWR.n339 VPWR.t5 56.8667
R436 VPWR.n15 VPWR.t0 56.8667
R437 VPWR.n30 VPWR.t0 56.8667
R438 VPWR.n53 VPWR.n51 56.1076
R439 VPWR.n54 VPWR.n53 56.1076
R440 VPWR.n61 VPWR.n42 56.1076
R441 VPWR.n59 VPWR.n42 56.1076
R442 VPWR.n90 VPWR.n88 56.1076
R443 VPWR.n91 VPWR.n90 56.1076
R444 VPWR.n98 VPWR.n79 56.1076
R445 VPWR.n96 VPWR.n79 56.1076
R446 VPWR.n123 VPWR.n121 56.1076
R447 VPWR.n124 VPWR.n123 56.1076
R448 VPWR.n131 VPWR.n112 56.1076
R449 VPWR.n129 VPWR.n112 56.1076
R450 VPWR.n156 VPWR.n154 56.1076
R451 VPWR.n157 VPWR.n156 56.1076
R452 VPWR.n164 VPWR.n145 56.1076
R453 VPWR.n162 VPWR.n145 56.1076
R454 VPWR.n189 VPWR.n187 56.1076
R455 VPWR.n190 VPWR.n189 56.1076
R456 VPWR.n197 VPWR.n178 56.1076
R457 VPWR.n195 VPWR.n178 56.1076
R458 VPWR.n222 VPWR.n220 56.1076
R459 VPWR.n223 VPWR.n222 56.1076
R460 VPWR.n230 VPWR.n211 56.1076
R461 VPWR.n228 VPWR.n211 56.1076
R462 VPWR.n255 VPWR.n253 56.1076
R463 VPWR.n256 VPWR.n255 56.1076
R464 VPWR.n263 VPWR.n244 56.1076
R465 VPWR.n261 VPWR.n244 56.1076
R466 VPWR.n288 VPWR.n286 56.1076
R467 VPWR.n289 VPWR.n288 56.1076
R468 VPWR.n296 VPWR.n277 56.1076
R469 VPWR.n294 VPWR.n277 56.1076
R470 VPWR.n325 VPWR.n323 56.1076
R471 VPWR.n326 VPWR.n325 56.1076
R472 VPWR.n333 VPWR.n314 56.1076
R473 VPWR.n331 VPWR.n314 56.1076
R474 VPWR.n16 VPWR.n14 56.1076
R475 VPWR.n17 VPWR.n16 56.1076
R476 VPWR.n24 VPWR.n5 56.1076
R477 VPWR.n22 VPWR.n5 56.1076
R478 VPWR.n56 VPWR.n45 25.6005
R479 VPWR.n48 VPWR.n45 25.6005
R480 VPWR.n49 VPWR.n48 25.6005
R481 VPWR.n65 VPWR.n57 25.6005
R482 VPWR.n64 VPWR.n63 25.6005
R483 VPWR.n63 VPWR.n58 25.6005
R484 VPWR.n58 VPWR.n39 25.6005
R485 VPWR.n93 VPWR.n82 25.6005
R486 VPWR.n85 VPWR.n82 25.6005
R487 VPWR.n86 VPWR.n85 25.6005
R488 VPWR.n102 VPWR.n94 25.6005
R489 VPWR.n101 VPWR.n100 25.6005
R490 VPWR.n100 VPWR.n95 25.6005
R491 VPWR.n95 VPWR.n76 25.6005
R492 VPWR.n126 VPWR.n115 25.6005
R493 VPWR.n118 VPWR.n115 25.6005
R494 VPWR.n119 VPWR.n118 25.6005
R495 VPWR.n135 VPWR.n127 25.6005
R496 VPWR.n134 VPWR.n133 25.6005
R497 VPWR.n133 VPWR.n128 25.6005
R498 VPWR.n128 VPWR.n109 25.6005
R499 VPWR.n159 VPWR.n148 25.6005
R500 VPWR.n151 VPWR.n148 25.6005
R501 VPWR.n152 VPWR.n151 25.6005
R502 VPWR.n168 VPWR.n160 25.6005
R503 VPWR.n167 VPWR.n166 25.6005
R504 VPWR.n166 VPWR.n161 25.6005
R505 VPWR.n161 VPWR.n142 25.6005
R506 VPWR.n192 VPWR.n181 25.6005
R507 VPWR.n184 VPWR.n181 25.6005
R508 VPWR.n185 VPWR.n184 25.6005
R509 VPWR.n201 VPWR.n193 25.6005
R510 VPWR.n200 VPWR.n199 25.6005
R511 VPWR.n199 VPWR.n194 25.6005
R512 VPWR.n194 VPWR.n175 25.6005
R513 VPWR.n225 VPWR.n214 25.6005
R514 VPWR.n217 VPWR.n214 25.6005
R515 VPWR.n218 VPWR.n217 25.6005
R516 VPWR.n234 VPWR.n226 25.6005
R517 VPWR.n233 VPWR.n232 25.6005
R518 VPWR.n232 VPWR.n227 25.6005
R519 VPWR.n227 VPWR.n208 25.6005
R520 VPWR.n258 VPWR.n247 25.6005
R521 VPWR.n250 VPWR.n247 25.6005
R522 VPWR.n251 VPWR.n250 25.6005
R523 VPWR.n267 VPWR.n259 25.6005
R524 VPWR.n266 VPWR.n265 25.6005
R525 VPWR.n265 VPWR.n260 25.6005
R526 VPWR.n260 VPWR.n241 25.6005
R527 VPWR.n291 VPWR.n280 25.6005
R528 VPWR.n283 VPWR.n280 25.6005
R529 VPWR.n284 VPWR.n283 25.6005
R530 VPWR.n300 VPWR.n292 25.6005
R531 VPWR.n299 VPWR.n298 25.6005
R532 VPWR.n298 VPWR.n293 25.6005
R533 VPWR.n293 VPWR.n274 25.6005
R534 VPWR.n328 VPWR.n317 25.6005
R535 VPWR.n320 VPWR.n317 25.6005
R536 VPWR.n321 VPWR.n320 25.6005
R537 VPWR.n337 VPWR.n329 25.6005
R538 VPWR.n336 VPWR.n335 25.6005
R539 VPWR.n335 VPWR.n330 25.6005
R540 VPWR.n330 VPWR.n311 25.6005
R541 VPWR.n19 VPWR.n8 25.6005
R542 VPWR.n11 VPWR.n8 25.6005
R543 VPWR.n12 VPWR.n11 25.6005
R544 VPWR.n28 VPWR.n20 25.6005
R545 VPWR.n27 VPWR.n26 25.6005
R546 VPWR.n26 VPWR.n21 25.6005
R547 VPWR.n21 VPWR.n2 25.6005
R548 VPWR.n70 VPWR 18.7192
R549 VPWR.n107 VPWR 18.7192
R550 VPWR.n140 VPWR 18.7192
R551 VPWR.n173 VPWR 18.7192
R552 VPWR.n206 VPWR 18.7192
R553 VPWR.n239 VPWR 18.7192
R554 VPWR.n272 VPWR 18.7192
R555 VPWR.n305 VPWR 18.7192
R556 VPWR.n342 VPWR 18.7192
R557 VPWR.n33 VPWR 18.7192
R558 VPWR VPWR.n34 12.8005
R559 VPWR.n35 VPWR 12.8005
R560 VPWR VPWR.n38 12.8005
R561 VPWR VPWR.n69 12.8005
R562 VPWR VPWR.n71 12.8005
R563 VPWR.n72 VPWR 12.8005
R564 VPWR VPWR.n75 12.8005
R565 VPWR VPWR.n106 12.8005
R566 VPWR VPWR.n108 12.8005
R567 VPWR VPWR.n139 12.8005
R568 VPWR VPWR.n141 12.8005
R569 VPWR VPWR.n172 12.8005
R570 VPWR VPWR.n174 12.8005
R571 VPWR VPWR.n205 12.8005
R572 VPWR VPWR.n207 12.8005
R573 VPWR VPWR.n238 12.8005
R574 VPWR VPWR.n240 12.8005
R575 VPWR VPWR.n271 12.8005
R576 VPWR VPWR.n273 12.8005
R577 VPWR VPWR.n304 12.8005
R578 VPWR VPWR.n306 12.8005
R579 VPWR.n307 VPWR 12.8005
R580 VPWR VPWR.n310 12.8005
R581 VPWR VPWR.n341 12.8005
R582 VPWR VPWR.n0 12.8005
R583 VPWR VPWR.n344 12.8005
R584 VPWR VPWR.n1 12.8005
R585 VPWR VPWR.n32 12.8005
R586 VPWR.n343 VPWR.n342 10.1986
R587 VPWR.n36 VPWR.n34 10.1513
R588 VPWR.n36 VPWR.n35 10.1513
R589 VPWR.n73 VPWR.n71 10.1513
R590 VPWR.n73 VPWR.n72 10.1513
R591 VPWR.n308 VPWR.n306 10.1513
R592 VPWR.n308 VPWR.n307 10.1513
R593 VPWR.n343 VPWR.n0 10.1513
R594 VPWR.n344 VPWR.n343 10.1513
R595 VPWR.n37 VPWR.n36 10.1163
R596 VPWR.n74 VPWR.n73 10.1163
R597 VPWR.n309 VPWR.n308 10.1163
R598 VPWR.n305 VPWR.n272 1.39875
R599 VPWR.n272 VPWR.n239 1.39875
R600 VPWR.n239 VPWR.n206 1.39875
R601 VPWR.n206 VPWR.n173 1.39875
R602 VPWR.n173 VPWR.n140 1.39875
R603 VPWR.n140 VPWR.n107 1.39875
R604 VPWR.n342 VPWR.n309 1.30475
R605 VPWR.n107 VPWR.n74 1.30475
R606 VPWR.n70 VPWR.n37 1.30475
R607 VPWR.n33 VPWR 0.229625
R608 VPWR.n309 VPWR.n305 0.08275
R609 VPWR.n74 VPWR.n70 0.08275
R610 VPWR.n37 VPWR.n33 0.08275
R611 S0 S0.t2 330.341
R612 S0 S0.t1 330.341
R613 S0 S0.t4 330.341
R614 S0 S0.t5 315.88
R615 S0 S0.t3 315.88
R616 S0 S0.t0 315.88
R617 S0 S0.n4 32.5628
R618 S0.n1 S0 30.4596
R619 S0.n3 S0 30.4596
R620 S0.n2 S0 30.4439
R621 S0.n4 S0 30.4439
R622 S0.n0 S0 30.4439
R623 S0.n3 S0.n2 2.10375
R624 S0.n2 S0.n1 2.10375
R625 S0.n4 S0.n3 0.69375
R626 S0.n1 S0.n0 0.69375
R627 S0.n0 S0 0.229625
R628 N23.t3 N23.n16 700.484
R629 N23.n17 N23.t3 700.484
R630 N23.t4 N23.n8 700.484
R631 N23.n9 N23.t4 700.484
R632 N23.t2 N23.n1 700.484
R633 N23.n2 N23.t2 700.484
R634 N23.t1 N23.n12 255.345
R635 N23.n13 N23.t1 255.345
R636 N23.t5 N23.n4 255.345
R637 N23.n5 N23.t5 255.345
R638 N23.t0 N23.n0 255.345
R639 N23.n21 N23.t0 255.345
R640 N23 N23.n16 12.8005
R641 N23.n17 N23 12.8005
R642 N23 N23.n12 12.8005
R643 N23.n13 N23 12.8005
R644 N23 N23.n8 12.8005
R645 N23.n9 N23 12.8005
R646 N23 N23.n4 12.8005
R647 N23.n5 N23 12.8005
R648 N23 N23.n1 12.8005
R649 N23.n2 N23 12.8005
R650 N23 N23.n0 12.8005
R651 N23 N23.n21 12.8005
R652 N23.n20 N23.n19 12.3721
R653 N23.n7 N23.n3 12.3721
R654 N23.n19 N23.n18 11.6788
R655 N23.n15 N23.n14 11.6788
R656 N23.n11 N23.n10 11.6788
R657 N23.n7 N23.n6 11.6788
R658 N23.n18 N23.n16 10.1513
R659 N23.n18 N23.n17 10.1513
R660 N23.n14 N23.n12 10.1513
R661 N23.n14 N23.n13 10.1513
R662 N23.n10 N23.n8 10.1513
R663 N23.n10 N23.n9 10.1513
R664 N23.n6 N23.n4 10.1513
R665 N23.n6 N23.n5 10.1513
R666 N23.n3 N23.n1 10.1513
R667 N23.n3 N23.n2 10.1513
R668 N23.n20 N23.n0 10.1513
R669 N23.n21 N23.n20 10.1513
R670 N23.n19 N23.n15 2.29175
R671 N23.n11 N23.n7 0.69375
R672 N23.n15 N23.n11 0.69375
R673 D3.t1 D3.n1 700.484
R674 D3.n2 D3.t1 700.484
R675 D3.t0 D3.n0 255.345
R676 D3.n6 D3.t0 255.345
R677 D3 D3.n0 12.8005
R678 D3 D3.n6 12.8005
R679 D3 D3.n1 12.8005
R680 D3.n2 D3 12.8005
R681 D3.n5 D3.n4 11.3304
R682 D3.n4 D3.n3 10.6372
R683 D3.n5 D3.n0 10.1513
R684 D3.n6 D3.n5 10.1513
R685 D3.n3 D3.n1 10.1513
R686 D3.n3 D3.n2 10.1513
R687 D3.n4 D3 7.37363
R688 VGND.n273 VGND.n272 18245.7
R689 VGND.n332 VGND.n331 4212.17
R690 VGND.n280 VGND.n9 3817.79
R691 VGND.n280 VGND.n279 3817.79
R692 VGND.n279 VGND.n278 3817.79
R693 VGND.n278 VGND.n277 3817.79
R694 VGND.n277 VGND.n276 3817.79
R695 VGND.n276 VGND.n275 3817.79
R696 VGND.n275 VGND.n274 3817.79
R697 VGND.n274 VGND.n273 3817.79
R698 VGND.n332 VGND.n9 3316.7
R699 VGND.n272 VGND.n271 2144.11
R700 VGND.n271 VGND.n270 2144.11
R701 VGND.n270 VGND.n269 2144.11
R702 VGND.n269 VGND.n268 2144.11
R703 VGND.n268 VGND.n267 2144.11
R704 VGND.n267 VGND.n266 2144.11
R705 VGND.n266 VGND.n10 2144.11
R706 VGND.n331 VGND.n10 2144.11
R707 VGND.n316 VGND.n307 1315.26
R708 VGND.n313 VGND.n310 1315.26
R709 VGND.n305 VGND.n12 1315.26
R710 VGND.n328 VGND.n13 1315.26
R711 VGND.n55 VGND.n51 1315.26
R712 VGND.n57 VGND.n53 1315.26
R713 VGND.n68 VGND.n49 1315.26
R714 VGND.n71 VGND.n70 1315.26
R715 VGND.n90 VGND.n86 1315.26
R716 VGND.n92 VGND.n88 1315.26
R717 VGND.n103 VGND.n84 1315.26
R718 VGND.n106 VGND.n105 1315.26
R719 VGND.n125 VGND.n121 1315.26
R720 VGND.n127 VGND.n123 1315.26
R721 VGND.n138 VGND.n119 1315.26
R722 VGND.n141 VGND.n140 1315.26
R723 VGND.n156 VGND.n152 1315.26
R724 VGND.n158 VGND.n154 1315.26
R725 VGND.n169 VGND.n150 1315.26
R726 VGND.n172 VGND.n171 1315.26
R727 VGND.n187 VGND.n183 1315.26
R728 VGND.n189 VGND.n185 1315.26
R729 VGND.n200 VGND.n181 1315.26
R730 VGND.n203 VGND.n202 1315.26
R731 VGND.n220 VGND.n212 1315.26
R732 VGND.n217 VGND.n214 1315.26
R733 VGND.n210 VGND.n41 1315.26
R734 VGND.n232 VGND.n42 1315.26
R735 VGND.n251 VGND.n243 1315.26
R736 VGND.n248 VGND.n245 1315.26
R737 VGND.n241 VGND.n236 1315.26
R738 VGND.n263 VGND.n237 1315.26
R739 VGND.n282 VGND.n24 1315.26
R740 VGND.n284 VGND.n26 1315.26
R741 VGND.n295 VGND.n22 1315.26
R742 VGND.n298 VGND.n297 1315.26
R743 VGND.n346 VGND.n334 1315.26
R744 VGND.n357 VGND.n335 1315.26
R745 VGND.n359 VGND.n8 1315.26
R746 VGND.n341 VGND.n7 1315.26
R747 VGND.n272 VGND.n35 1101.11
R748 VGND.n271 VGND.n36 1101.11
R749 VGND.n270 VGND.n37 1101.11
R750 VGND.n269 VGND.n38 1101.11
R751 VGND.n268 VGND.n39 1101.11
R752 VGND.n267 VGND.n234 1101.11
R753 VGND.n266 VGND.n265 1101.11
R754 VGND.n20 VGND.n10 1101.11
R755 VGND.n331 VGND.n330 1101.11
R756 VGND.n59 VGND.n53 585
R757 VGND.n53 VGND.n52 585
R758 VGND.n62 VGND.n61 585
R759 VGND.n63 VGND.n62 585
R760 VGND.n60 VGND.n46 585
R761 VGND.n47 VGND.n46 585
R762 VGND.n70 VGND.n44 585
R763 VGND.n70 VGND.n69 585
R764 VGND.n72 VGND.n71 585
R765 VGND.n49 VGND.n43 585
R766 VGND.n68 VGND.n67 585
R767 VGND.n69 VGND.n68 585
R768 VGND.n66 VGND.n48 585
R769 VGND.n48 VGND.n47 585
R770 VGND.n65 VGND.n64 585
R771 VGND.n64 VGND.n63 585
R772 VGND.n51 VGND.n50 585
R773 VGND.n52 VGND.n51 585
R774 VGND.n55 VGND.n54 585
R775 VGND.n58 VGND.n57 585
R776 VGND.n94 VGND.n88 585
R777 VGND.n88 VGND.n87 585
R778 VGND.n97 VGND.n96 585
R779 VGND.n98 VGND.n97 585
R780 VGND.n95 VGND.n81 585
R781 VGND.n82 VGND.n81 585
R782 VGND.n105 VGND.n79 585
R783 VGND.n105 VGND.n104 585
R784 VGND.n107 VGND.n106 585
R785 VGND.n84 VGND.n78 585
R786 VGND.n103 VGND.n102 585
R787 VGND.n104 VGND.n103 585
R788 VGND.n101 VGND.n83 585
R789 VGND.n83 VGND.n82 585
R790 VGND.n100 VGND.n99 585
R791 VGND.n99 VGND.n98 585
R792 VGND.n86 VGND.n85 585
R793 VGND.n87 VGND.n86 585
R794 VGND.n90 VGND.n89 585
R795 VGND.n93 VGND.n92 585
R796 VGND.n129 VGND.n123 585
R797 VGND.n123 VGND.n122 585
R798 VGND.n132 VGND.n131 585
R799 VGND.n133 VGND.n132 585
R800 VGND.n130 VGND.n116 585
R801 VGND.n117 VGND.n116 585
R802 VGND.n140 VGND.n114 585
R803 VGND.n140 VGND.n139 585
R804 VGND.n142 VGND.n141 585
R805 VGND.n119 VGND.n113 585
R806 VGND.n138 VGND.n137 585
R807 VGND.n139 VGND.n138 585
R808 VGND.n136 VGND.n118 585
R809 VGND.n118 VGND.n117 585
R810 VGND.n135 VGND.n134 585
R811 VGND.n134 VGND.n133 585
R812 VGND.n121 VGND.n120 585
R813 VGND.n122 VGND.n121 585
R814 VGND.n125 VGND.n124 585
R815 VGND.n128 VGND.n127 585
R816 VGND.n160 VGND.n154 585
R817 VGND.n154 VGND.n153 585
R818 VGND.n163 VGND.n162 585
R819 VGND.n164 VGND.n163 585
R820 VGND.n161 VGND.n147 585
R821 VGND.n148 VGND.n147 585
R822 VGND.n171 VGND.n145 585
R823 VGND.n171 VGND.n170 585
R824 VGND.n173 VGND.n172 585
R825 VGND.n150 VGND.n144 585
R826 VGND.n169 VGND.n168 585
R827 VGND.n170 VGND.n169 585
R828 VGND.n167 VGND.n149 585
R829 VGND.n149 VGND.n148 585
R830 VGND.n166 VGND.n165 585
R831 VGND.n165 VGND.n164 585
R832 VGND.n152 VGND.n151 585
R833 VGND.n153 VGND.n152 585
R834 VGND.n156 VGND.n155 585
R835 VGND.n159 VGND.n158 585
R836 VGND.n191 VGND.n185 585
R837 VGND.n185 VGND.n184 585
R838 VGND.n194 VGND.n193 585
R839 VGND.n195 VGND.n194 585
R840 VGND.n192 VGND.n178 585
R841 VGND.n179 VGND.n178 585
R842 VGND.n202 VGND.n176 585
R843 VGND.n202 VGND.n201 585
R844 VGND.n204 VGND.n203 585
R845 VGND.n181 VGND.n175 585
R846 VGND.n200 VGND.n199 585
R847 VGND.n201 VGND.n200 585
R848 VGND.n198 VGND.n180 585
R849 VGND.n180 VGND.n179 585
R850 VGND.n197 VGND.n196 585
R851 VGND.n196 VGND.n195 585
R852 VGND.n183 VGND.n182 585
R853 VGND.n184 VGND.n183 585
R854 VGND.n187 VGND.n186 585
R855 VGND.n190 VGND.n189 585
R856 VGND.n217 VGND.n216 585
R857 VGND.n219 VGND.n217 585
R858 VGND.n208 VGND.n207 585
R859 VGND.n218 VGND.n208 585
R860 VGND.n229 VGND.n228 585
R861 VGND.n228 VGND.n227 585
R862 VGND.n230 VGND.n42 585
R863 VGND.n42 VGND.n40 585
R864 VGND.n232 VGND.n231 585
R865 VGND.n223 VGND.n41 585
R866 VGND.n224 VGND.n210 585
R867 VGND.n210 VGND.n40 585
R868 VGND.n226 VGND.n225 585
R869 VGND.n227 VGND.n226 585
R870 VGND.n222 VGND.n209 585
R871 VGND.n218 VGND.n209 585
R872 VGND.n221 VGND.n220 585
R873 VGND.n220 VGND.n219 585
R874 VGND.n212 VGND.n211 585
R875 VGND.n215 VGND.n214 585
R876 VGND.n248 VGND.n247 585
R877 VGND.n250 VGND.n248 585
R878 VGND.n239 VGND.n238 585
R879 VGND.n249 VGND.n239 585
R880 VGND.n260 VGND.n259 585
R881 VGND.n259 VGND.n258 585
R882 VGND.n261 VGND.n237 585
R883 VGND.n237 VGND.n235 585
R884 VGND.n263 VGND.n262 585
R885 VGND.n254 VGND.n236 585
R886 VGND.n255 VGND.n241 585
R887 VGND.n241 VGND.n235 585
R888 VGND.n257 VGND.n256 585
R889 VGND.n258 VGND.n257 585
R890 VGND.n253 VGND.n240 585
R891 VGND.n249 VGND.n240 585
R892 VGND.n252 VGND.n251 585
R893 VGND.n251 VGND.n250 585
R894 VGND.n243 VGND.n242 585
R895 VGND.n246 VGND.n245 585
R896 VGND.n286 VGND.n26 585
R897 VGND.n26 VGND.n25 585
R898 VGND.n289 VGND.n288 585
R899 VGND.n290 VGND.n289 585
R900 VGND.n287 VGND.n18 585
R901 VGND.n19 VGND.n18 585
R902 VGND.n297 VGND.n16 585
R903 VGND.n297 VGND.n296 585
R904 VGND.n299 VGND.n298 585
R905 VGND.n22 VGND.n15 585
R906 VGND.n295 VGND.n294 585
R907 VGND.n296 VGND.n295 585
R908 VGND.n293 VGND.n21 585
R909 VGND.n21 VGND.n19 585
R910 VGND.n292 VGND.n291 585
R911 VGND.n291 VGND.n290 585
R912 VGND.n24 VGND.n23 585
R913 VGND.n25 VGND.n24 585
R914 VGND.n282 VGND.n27 585
R915 VGND.n285 VGND.n284 585
R916 VGND.n313 VGND.n312 585
R917 VGND.n315 VGND.n313 585
R918 VGND.n303 VGND.n302 585
R919 VGND.n314 VGND.n303 585
R920 VGND.n325 VGND.n324 585
R921 VGND.n324 VGND.n323 585
R922 VGND.n326 VGND.n13 585
R923 VGND.n13 VGND.n11 585
R924 VGND.n328 VGND.n327 585
R925 VGND.n319 VGND.n12 585
R926 VGND.n320 VGND.n305 585
R927 VGND.n305 VGND.n11 585
R928 VGND.n322 VGND.n321 585
R929 VGND.n323 VGND.n322 585
R930 VGND.n318 VGND.n304 585
R931 VGND.n314 VGND.n304 585
R932 VGND.n317 VGND.n316 585
R933 VGND.n316 VGND.n315 585
R934 VGND.n307 VGND.n306 585
R935 VGND.n311 VGND.n310 585
R936 VGND.n341 VGND.n340 585
R937 VGND.n339 VGND.n338 585
R938 VGND.n337 VGND.n336 585
R939 VGND.n347 VGND.n346 585
R940 VGND.n348 VGND.n334 585
R941 VGND.n343 VGND.n334 585
R942 VGND.n357 VGND.n356 585
R943 VGND.n358 VGND.n357 585
R944 VGND.n355 VGND.n335 585
R945 VGND.n354 VGND.n353 585
R946 VGND.n351 VGND.n349 585
R947 VGND.n8 VGND.n6 585
R948 VGND.n360 VGND.n359 585
R949 VGND.n359 VGND.n358 585
R950 VGND.n7 VGND.n5 585
R951 VGND.n343 VGND.n7 585
R952 VGND.n333 VGND.n332 481.729
R953 VGND.n316 VGND.n304 394
R954 VGND.n322 VGND.n304 394
R955 VGND.n322 VGND.n305 394
R956 VGND.n313 VGND.n303 394
R957 VGND.n324 VGND.n303 394
R958 VGND.n324 VGND.n13 394
R959 VGND.n64 VGND.n51 394
R960 VGND.n64 VGND.n48 394
R961 VGND.n68 VGND.n48 394
R962 VGND.n62 VGND.n53 394
R963 VGND.n62 VGND.n46 394
R964 VGND.n70 VGND.n46 394
R965 VGND.n99 VGND.n86 394
R966 VGND.n99 VGND.n83 394
R967 VGND.n103 VGND.n83 394
R968 VGND.n97 VGND.n88 394
R969 VGND.n97 VGND.n81 394
R970 VGND.n105 VGND.n81 394
R971 VGND.n134 VGND.n121 394
R972 VGND.n134 VGND.n118 394
R973 VGND.n138 VGND.n118 394
R974 VGND.n132 VGND.n123 394
R975 VGND.n132 VGND.n116 394
R976 VGND.n140 VGND.n116 394
R977 VGND.n165 VGND.n152 394
R978 VGND.n165 VGND.n149 394
R979 VGND.n169 VGND.n149 394
R980 VGND.n163 VGND.n154 394
R981 VGND.n163 VGND.n147 394
R982 VGND.n171 VGND.n147 394
R983 VGND.n196 VGND.n183 394
R984 VGND.n196 VGND.n180 394
R985 VGND.n200 VGND.n180 394
R986 VGND.n194 VGND.n185 394
R987 VGND.n194 VGND.n178 394
R988 VGND.n202 VGND.n178 394
R989 VGND.n220 VGND.n209 394
R990 VGND.n226 VGND.n209 394
R991 VGND.n226 VGND.n210 394
R992 VGND.n217 VGND.n208 394
R993 VGND.n228 VGND.n208 394
R994 VGND.n228 VGND.n42 394
R995 VGND.n251 VGND.n240 394
R996 VGND.n257 VGND.n240 394
R997 VGND.n257 VGND.n241 394
R998 VGND.n248 VGND.n239 394
R999 VGND.n259 VGND.n239 394
R1000 VGND.n259 VGND.n237 394
R1001 VGND.n291 VGND.n24 394
R1002 VGND.n291 VGND.n21 394
R1003 VGND.n295 VGND.n21 394
R1004 VGND.n289 VGND.n26 394
R1005 VGND.n289 VGND.n18 394
R1006 VGND.n297 VGND.n18 394
R1007 VGND.n357 VGND.n334 394
R1008 VGND.n353 VGND.n351 394
R1009 VGND.n359 VGND.n7 394
R1010 VGND.n338 VGND.n337 394
R1011 VGND.n344 VGND.n343 380.474
R1012 VGND.n358 VGND.n333 380.474
R1013 VGND.n52 VGND.n34 266.937
R1014 VGND.n69 VGND.n35 266.937
R1015 VGND.n87 VGND.n33 266.937
R1016 VGND.n104 VGND.n36 266.937
R1017 VGND.n122 VGND.n32 266.937
R1018 VGND.n139 VGND.n37 266.937
R1019 VGND.n153 VGND.n31 266.937
R1020 VGND.n170 VGND.n38 266.937
R1021 VGND.n184 VGND.n30 266.937
R1022 VGND.n201 VGND.n39 266.937
R1023 VGND.n219 VGND.n29 266.937
R1024 VGND.n234 VGND.n40 266.937
R1025 VGND.n250 VGND.n28 266.937
R1026 VGND.n265 VGND.n235 266.937
R1027 VGND.n281 VGND.n25 266.937
R1028 VGND.n296 VGND.n20 266.937
R1029 VGND.n315 VGND.n308 266.937
R1030 VGND.n330 VGND.n11 266.937
R1031 VGND.t6 VGND.n74 255.345
R1032 VGND.n75 VGND.t6 255.345
R1033 VGND.t2 VGND.n109 255.345
R1034 VGND.n110 VGND.t2 255.345
R1035 VGND.t4 VGND.n1 255.345
R1036 VGND.n2 VGND.t4 255.345
R1037 VGND.t11 VGND.n0 255.345
R1038 VGND.n363 VGND.t11 255.345
R1039 VGND.n45 VGND.n35 218.815
R1040 VGND.n56 VGND.n34 218.815
R1041 VGND.n80 VGND.n36 218.815
R1042 VGND.n91 VGND.n33 218.815
R1043 VGND.n115 VGND.n37 218.815
R1044 VGND.n126 VGND.n32 218.815
R1045 VGND.n146 VGND.n38 218.815
R1046 VGND.n157 VGND.n31 218.815
R1047 VGND.n177 VGND.n39 218.815
R1048 VGND.n188 VGND.n30 218.815
R1049 VGND.n234 VGND.n233 218.815
R1050 VGND.n213 VGND.n29 218.815
R1051 VGND.n265 VGND.n264 218.815
R1052 VGND.n244 VGND.n28 218.815
R1053 VGND.n20 VGND.n17 218.815
R1054 VGND.n283 VGND.n281 218.815
R1055 VGND.n330 VGND.n329 218.815
R1056 VGND.n309 VGND.n308 218.815
R1057 VGND.n344 VGND.n342 218.815
R1058 VGND.n345 VGND.n344 218.815
R1059 VGND.n352 VGND.n333 218.815
R1060 VGND.n350 VGND.n333 218.815
R1061 VGND.n63 VGND.n52 151.264
R1062 VGND.n69 VGND.n47 151.264
R1063 VGND.n98 VGND.n87 151.264
R1064 VGND.n104 VGND.n82 151.264
R1065 VGND.n133 VGND.n122 151.264
R1066 VGND.n139 VGND.n117 151.264
R1067 VGND.n164 VGND.n153 151.264
R1068 VGND.n170 VGND.n148 151.264
R1069 VGND.n195 VGND.n184 151.264
R1070 VGND.n201 VGND.n179 151.264
R1071 VGND.n219 VGND.n218 151.264
R1072 VGND.n227 VGND.n40 151.264
R1073 VGND.n250 VGND.n249 151.264
R1074 VGND.n258 VGND.n235 151.264
R1075 VGND.n290 VGND.n25 151.264
R1076 VGND.n296 VGND.n19 151.264
R1077 VGND.n315 VGND.n314 151.264
R1078 VGND.n323 VGND.n11 151.264
R1079 VGND.n309 VGND.n307 147.374
R1080 VGND.n329 VGND.n328 147.374
R1081 VGND.n56 VGND.n55 147.374
R1082 VGND.n71 VGND.n45 147.374
R1083 VGND.n49 VGND.n45 147.374
R1084 VGND.n57 VGND.n56 147.374
R1085 VGND.n91 VGND.n90 147.374
R1086 VGND.n106 VGND.n80 147.374
R1087 VGND.n84 VGND.n80 147.374
R1088 VGND.n92 VGND.n91 147.374
R1089 VGND.n126 VGND.n125 147.374
R1090 VGND.n141 VGND.n115 147.374
R1091 VGND.n119 VGND.n115 147.374
R1092 VGND.n127 VGND.n126 147.374
R1093 VGND.n157 VGND.n156 147.374
R1094 VGND.n172 VGND.n146 147.374
R1095 VGND.n150 VGND.n146 147.374
R1096 VGND.n158 VGND.n157 147.374
R1097 VGND.n188 VGND.n187 147.374
R1098 VGND.n203 VGND.n177 147.374
R1099 VGND.n181 VGND.n177 147.374
R1100 VGND.n189 VGND.n188 147.374
R1101 VGND.n213 VGND.n212 147.374
R1102 VGND.n233 VGND.n232 147.374
R1103 VGND.n233 VGND.n41 147.374
R1104 VGND.n214 VGND.n213 147.374
R1105 VGND.n244 VGND.n243 147.374
R1106 VGND.n264 VGND.n263 147.374
R1107 VGND.n264 VGND.n236 147.374
R1108 VGND.n245 VGND.n244 147.374
R1109 VGND.n283 VGND.n282 147.374
R1110 VGND.n298 VGND.n17 147.374
R1111 VGND.n22 VGND.n17 147.374
R1112 VGND.n284 VGND.n283 147.374
R1113 VGND.n329 VGND.n12 147.374
R1114 VGND.n310 VGND.n309 147.374
R1115 VGND.n352 VGND.n335 147.374
R1116 VGND.n350 VGND.n8 147.374
R1117 VGND.n346 VGND.n345 147.374
R1118 VGND.n342 VGND.n338 147.374
R1119 VGND.n342 VGND.n341 147.374
R1120 VGND.n345 VGND.n337 147.374
R1121 VGND.n353 VGND.n352 147.374
R1122 VGND.n351 VGND.n350 147.374
R1123 VGND.n273 VGND.n34 137.917
R1124 VGND.n274 VGND.n33 137.917
R1125 VGND.n275 VGND.n32 137.917
R1126 VGND.n276 VGND.n31 137.917
R1127 VGND.n277 VGND.n30 137.917
R1128 VGND.n278 VGND.n29 137.917
R1129 VGND.n279 VGND.n28 137.917
R1130 VGND.n281 VGND.n280 137.917
R1131 VGND.n308 VGND.n9 137.917
R1132 VGND.n343 VGND.t10 104.325
R1133 VGND.n358 VGND.t10 104.325
R1134 VGND.n317 VGND.n306 85.4593
R1135 VGND.n312 VGND.n311 85.4593
R1136 VGND.n320 VGND.n319 85.4593
R1137 VGND.n327 VGND.n326 85.4593
R1138 VGND.n54 VGND.n50 85.4593
R1139 VGND.n59 VGND.n58 85.4593
R1140 VGND.n67 VGND.n43 85.4593
R1141 VGND.n72 VGND.n44 85.4593
R1142 VGND.n89 VGND.n85 85.4593
R1143 VGND.n94 VGND.n93 85.4593
R1144 VGND.n102 VGND.n78 85.4593
R1145 VGND.n107 VGND.n79 85.4593
R1146 VGND.n124 VGND.n120 85.4593
R1147 VGND.n129 VGND.n128 85.4593
R1148 VGND.n137 VGND.n113 85.4593
R1149 VGND.n142 VGND.n114 85.4593
R1150 VGND.n155 VGND.n151 85.4593
R1151 VGND.n160 VGND.n159 85.4593
R1152 VGND.n168 VGND.n144 85.4593
R1153 VGND.n173 VGND.n145 85.4593
R1154 VGND.n186 VGND.n182 85.4593
R1155 VGND.n191 VGND.n190 85.4593
R1156 VGND.n199 VGND.n175 85.4593
R1157 VGND.n204 VGND.n176 85.4593
R1158 VGND.n221 VGND.n211 85.4593
R1159 VGND.n216 VGND.n215 85.4593
R1160 VGND.n224 VGND.n223 85.4593
R1161 VGND.n231 VGND.n230 85.4593
R1162 VGND.n252 VGND.n242 85.4593
R1163 VGND.n247 VGND.n246 85.4593
R1164 VGND.n255 VGND.n254 85.4593
R1165 VGND.n262 VGND.n261 85.4593
R1166 VGND.n27 VGND.n23 85.4593
R1167 VGND.n286 VGND.n285 85.4593
R1168 VGND.n294 VGND.n15 85.4593
R1169 VGND.n299 VGND.n16 85.4593
R1170 VGND.n348 VGND.n347 85.4593
R1171 VGND.n340 VGND.n5 85.4593
R1172 VGND.n356 VGND.n355 85.4593
R1173 VGND.n360 VGND.n6 85.4593
R1174 VGND.n63 VGND.t5 75.6325
R1175 VGND.t5 VGND.n47 75.6325
R1176 VGND.n98 VGND.t1 75.6325
R1177 VGND.t1 VGND.n82 75.6325
R1178 VGND.n133 VGND.t12 75.6325
R1179 VGND.t12 VGND.n117 75.6325
R1180 VGND.n164 VGND.t7 75.6325
R1181 VGND.t7 VGND.n148 75.6325
R1182 VGND.n195 VGND.t13 75.6325
R1183 VGND.t13 VGND.n179 75.6325
R1184 VGND.n218 VGND.t8 75.6325
R1185 VGND.n227 VGND.t8 75.6325
R1186 VGND.n249 VGND.t9 75.6325
R1187 VGND.n258 VGND.t9 75.6325
R1188 VGND.n290 VGND.t0 75.6325
R1189 VGND.t0 VGND.n19 75.6325
R1190 VGND.n314 VGND.t3 75.6325
R1191 VGND.n323 VGND.t3 75.6325
R1192 VGND.n311 VGND.n306 25.6005
R1193 VGND.n318 VGND.n317 25.6005
R1194 VGND.n321 VGND.n318 25.6005
R1195 VGND.n321 VGND.n320 25.6005
R1196 VGND.n312 VGND.n302 25.6005
R1197 VGND.n325 VGND.n302 25.6005
R1198 VGND.n326 VGND.n325 25.6005
R1199 VGND.n58 VGND.n54 25.6005
R1200 VGND.n65 VGND.n50 25.6005
R1201 VGND.n66 VGND.n65 25.6005
R1202 VGND.n67 VGND.n66 25.6005
R1203 VGND.n61 VGND.n59 25.6005
R1204 VGND.n61 VGND.n60 25.6005
R1205 VGND.n60 VGND.n44 25.6005
R1206 VGND.n93 VGND.n89 25.6005
R1207 VGND.n100 VGND.n85 25.6005
R1208 VGND.n101 VGND.n100 25.6005
R1209 VGND.n102 VGND.n101 25.6005
R1210 VGND.n96 VGND.n94 25.6005
R1211 VGND.n96 VGND.n95 25.6005
R1212 VGND.n95 VGND.n79 25.6005
R1213 VGND.n128 VGND.n124 25.6005
R1214 VGND.n135 VGND.n120 25.6005
R1215 VGND.n136 VGND.n135 25.6005
R1216 VGND.n137 VGND.n136 25.6005
R1217 VGND.n131 VGND.n129 25.6005
R1218 VGND.n131 VGND.n130 25.6005
R1219 VGND.n130 VGND.n114 25.6005
R1220 VGND.n159 VGND.n155 25.6005
R1221 VGND.n166 VGND.n151 25.6005
R1222 VGND.n167 VGND.n166 25.6005
R1223 VGND.n168 VGND.n167 25.6005
R1224 VGND.n162 VGND.n160 25.6005
R1225 VGND.n162 VGND.n161 25.6005
R1226 VGND.n161 VGND.n145 25.6005
R1227 VGND.n190 VGND.n186 25.6005
R1228 VGND.n197 VGND.n182 25.6005
R1229 VGND.n198 VGND.n197 25.6005
R1230 VGND.n199 VGND.n198 25.6005
R1231 VGND.n193 VGND.n191 25.6005
R1232 VGND.n193 VGND.n192 25.6005
R1233 VGND.n192 VGND.n176 25.6005
R1234 VGND.n215 VGND.n211 25.6005
R1235 VGND.n222 VGND.n221 25.6005
R1236 VGND.n225 VGND.n222 25.6005
R1237 VGND.n225 VGND.n224 25.6005
R1238 VGND.n216 VGND.n207 25.6005
R1239 VGND.n229 VGND.n207 25.6005
R1240 VGND.n230 VGND.n229 25.6005
R1241 VGND.n246 VGND.n242 25.6005
R1242 VGND.n253 VGND.n252 25.6005
R1243 VGND.n256 VGND.n253 25.6005
R1244 VGND.n256 VGND.n255 25.6005
R1245 VGND.n247 VGND.n238 25.6005
R1246 VGND.n260 VGND.n238 25.6005
R1247 VGND.n261 VGND.n260 25.6005
R1248 VGND.n285 VGND.n27 25.6005
R1249 VGND.n292 VGND.n23 25.6005
R1250 VGND.n293 VGND.n292 25.6005
R1251 VGND.n294 VGND.n293 25.6005
R1252 VGND.n288 VGND.n286 25.6005
R1253 VGND.n288 VGND.n287 25.6005
R1254 VGND.n287 VGND.n16 25.6005
R1255 VGND.n347 VGND.n336 25.6005
R1256 VGND.n339 VGND.n336 25.6005
R1257 VGND.n340 VGND.n339 25.6005
R1258 VGND.n356 VGND.n348 25.6005
R1259 VGND.n355 VGND.n354 25.6005
R1260 VGND.n354 VGND.n349 25.6005
R1261 VGND.n349 VGND.n6 25.6005
R1262 VGND VGND.n301 18.214
R1263 VGND.n73 VGND 18.214
R1264 VGND.n108 VGND 18.214
R1265 VGND.n143 VGND 18.214
R1266 VGND.n174 VGND 18.214
R1267 VGND.n205 VGND 18.214
R1268 VGND VGND.n206 18.214
R1269 VGND VGND.n14 18.214
R1270 VGND.n300 VGND 18.214
R1271 VGND.n361 VGND 18.214
R1272 VGND VGND.n109 12.8005
R1273 VGND.n110 VGND 12.8005
R1274 VGND VGND.n1 12.8005
R1275 VGND.n2 VGND 12.8005
R1276 VGND.n319 VGND 12.8005
R1277 VGND.n327 VGND 12.8005
R1278 VGND VGND.n43 12.8005
R1279 VGND VGND.n72 12.8005
R1280 VGND VGND.n78 12.8005
R1281 VGND VGND.n107 12.8005
R1282 VGND VGND.n113 12.8005
R1283 VGND VGND.n142 12.8005
R1284 VGND VGND.n144 12.8005
R1285 VGND VGND.n173 12.8005
R1286 VGND VGND.n175 12.8005
R1287 VGND VGND.n204 12.8005
R1288 VGND.n223 VGND 12.8005
R1289 VGND.n231 VGND 12.8005
R1290 VGND.n254 VGND 12.8005
R1291 VGND.n262 VGND 12.8005
R1292 VGND VGND.n15 12.8005
R1293 VGND VGND.n299 12.8005
R1294 VGND VGND.n5 12.8005
R1295 VGND VGND.n360 12.8005
R1296 VGND VGND.n0 12.8005
R1297 VGND VGND.n363 12.8005
R1298 VGND VGND.n74 12.8005
R1299 VGND.n75 VGND 12.8005
R1300 VGND.n111 VGND.n109 10.1513
R1301 VGND.n111 VGND.n110 10.1513
R1302 VGND.n3 VGND.n1 10.1513
R1303 VGND.n3 VGND.n2 10.1513
R1304 VGND.n362 VGND.n0 10.1513
R1305 VGND.n363 VGND.n362 10.1513
R1306 VGND.n76 VGND.n74 10.1513
R1307 VGND.n76 VGND.n75 10.1513
R1308 VGND.n362 VGND.n361 9.67774
R1309 VGND.n112 VGND.n111 9.59549
R1310 VGND.n4 VGND.n3 9.59549
R1311 VGND.n77 VGND.n76 9.59549
R1312 VGND.n301 VGND.n300 1.39875
R1313 VGND.n300 VGND.n14 1.39875
R1314 VGND.n206 VGND.n14 1.39875
R1315 VGND.n206 VGND.n205 1.39875
R1316 VGND.n205 VGND.n174 1.39875
R1317 VGND.n174 VGND.n143 1.39875
R1318 VGND.n361 VGND.n4 1.30475
R1319 VGND.n143 VGND.n112 1.30475
R1320 VGND.n108 VGND.n77 1.30475
R1321 VGND.n73 VGND 0.934625
R1322 VGND.n77 VGND.n73 0.08275
R1323 VGND.n301 VGND.n4 0.08275
R1324 VGND.n112 VGND.n108 0.08275
R1325 MUX_RAW.t3 MUX_RAW.n9 700.484
R1326 MUX_RAW.n10 MUX_RAW.t3 700.484
R1327 MUX_RAW.t1 MUX_RAW.n2 700.484
R1328 MUX_RAW.n3 MUX_RAW.t1 700.484
R1329 MUX_RAW MUX_RAW.t5 330.341
R1330 MUX_RAW MUX_RAW.t4 315.88
R1331 MUX_RAW.t2 MUX_RAW.n5 255.345
R1332 MUX_RAW.n6 MUX_RAW.t2 255.345
R1333 MUX_RAW.t0 MUX_RAW.n0 255.345
R1334 MUX_RAW.n15 MUX_RAW.t0 255.345
R1335 MUX_RAW.n1 MUX_RAW 30.1111
R1336 MUX_RAW.n1 MUX_RAW 29.4023
R1337 MUX_RAW MUX_RAW.n9 12.8005
R1338 MUX_RAW.n10 MUX_RAW 12.8005
R1339 MUX_RAW MUX_RAW.n5 12.8005
R1340 MUX_RAW.n6 MUX_RAW 12.8005
R1341 MUX_RAW MUX_RAW.n2 12.8005
R1342 MUX_RAW.n3 MUX_RAW 12.8005
R1343 MUX_RAW MUX_RAW.n0 12.8005
R1344 MUX_RAW MUX_RAW.n15 12.8005
R1345 MUX_RAW.n8 MUX_RAW.n4 11.6776
R1346 MUX_RAW.n14 MUX_RAW.n13 10.9844
R1347 MUX_RAW.n12 MUX_RAW.n11 10.9844
R1348 MUX_RAW.n8 MUX_RAW.n7 10.9844
R1349 MUX_RAW.n11 MUX_RAW.n9 10.1513
R1350 MUX_RAW.n11 MUX_RAW.n10 10.1513
R1351 MUX_RAW.n7 MUX_RAW.n5 10.1513
R1352 MUX_RAW.n7 MUX_RAW.n6 10.1513
R1353 MUX_RAW.n4 MUX_RAW.n2 10.1513
R1354 MUX_RAW.n4 MUX_RAW.n3 10.1513
R1355 MUX_RAW.n14 MUX_RAW.n0 10.1513
R1356 MUX_RAW.n15 MUX_RAW.n14 10.1513
R1357 MUX_RAW.n13 MUX_RAW.n1 0.78775
R1358 MUX_RAW.n12 MUX_RAW.n8 0.69375
R1359 MUX_RAW.n13 MUX_RAW.n12 0.69375
R1360 N01.t4 N01.n11 700.484
R1361 N01.n12 N01.t4 700.484
R1362 N01.t2 N01.n4 700.484
R1363 N01.n5 N01.t2 700.484
R1364 N01.t0 N01.n0 700.484
R1365 N01.n21 N01.t0 700.484
R1366 N01.t1 N01.n15 255.345
R1367 N01.n16 N01.t1 255.345
R1368 N01.t5 N01.n7 255.345
R1369 N01.n8 N01.t5 255.345
R1370 N01.t3 N01.n1 255.345
R1371 N01.n2 N01.t3 255.345
R1372 N01 N01.n15 12.8005
R1373 N01.n16 N01 12.8005
R1374 N01 N01.n11 12.8005
R1375 N01.n12 N01 12.8005
R1376 N01 N01.n7 12.8005
R1377 N01.n8 N01 12.8005
R1378 N01 N01.n4 12.8005
R1379 N01.n5 N01 12.8005
R1380 N01 N01.n1 12.8005
R1381 N01.n2 N01 12.8005
R1382 N01 N01.n0 12.8005
R1383 N01 N01.n21 12.8005
R1384 N01.n10 N01.n6 12.0248
R1385 N01.n19 N01.n3 12.0248
R1386 N01.n20 N01.n19 11.3316
R1387 N01.n18 N01.n17 11.3316
R1388 N01.n14 N01.n13 11.3316
R1389 N01.n10 N01.n9 11.3316
R1390 N01.n17 N01.n15 10.1513
R1391 N01.n17 N01.n16 10.1513
R1392 N01.n13 N01.n11 10.1513
R1393 N01.n13 N01.n12 10.1513
R1394 N01.n9 N01.n7 10.1513
R1395 N01.n9 N01.n8 10.1513
R1396 N01.n6 N01.n4 10.1513
R1397 N01.n6 N01.n5 10.1513
R1398 N01.n3 N01.n1 10.1513
R1399 N01.n3 N01.n2 10.1513
R1400 N01.n20 N01.n0 10.1513
R1401 N01.n21 N01.n20 10.1513
R1402 N01.n19 N01.n18 3.70175
R1403 N01.n14 N01.n10 0.69375
R1404 N01.n18 N01.n14 0.69375
R1405 BUF_N.t0 BUF_N.n0 700.484
R1406 BUF_N.n7 BUF_N.t0 700.484
R1407 BUF_N BUF_N.t2 330.341
R1408 BUF_N BUF_N.t3 315.88
R1409 BUF_N.t1 BUF_N.n2 255.345
R1410 BUF_N.n3 BUF_N.t1 255.345
R1411 BUF_N.n1 BUF_N 28.375
R1412 BUF_N.n1 BUF_N 27.6661
R1413 BUF_N BUF_N.n2 12.8005
R1414 BUF_N.n3 BUF_N 12.8005
R1415 BUF_N BUF_N.n0 12.8005
R1416 BUF_N BUF_N.n7 12.8005
R1417 BUF_N.n4 BUF_N.n2 10.1513
R1418 BUF_N.n4 BUF_N.n3 10.1513
R1419 BUF_N.n6 BUF_N.n0 10.1513
R1420 BUF_N.n7 BUF_N.n6 10.1513
R1421 BUF_N.n6 BUF_N.n5 9.94151
R1422 BUF_N.n5 BUF_N.n4 9.24826
R1423 BUF_N.n5 BUF_N.n1 0.78775
R1424 Y.t0 Y.n1 700.484
R1425 Y.n2 Y.t0 700.484
R1426 Y.t1 Y.n0 255.345
R1427 Y.n6 Y.t1 255.345
R1428 Y.n5 Y.n4 14.1082
R1429 Y.n4 Y.n3 13.4149
R1430 Y.n4 Y 12.8256
R1431 Y Y.n0 12.8005
R1432 Y Y.n6 12.8005
R1433 Y Y.n1 12.8005
R1434 Y.n2 Y 12.8005
R1435 Y.n5 Y.n0 10.1513
R1436 Y.n6 Y.n5 10.1513
R1437 Y.n3 Y.n1 10.1513
R1438 Y.n3 Y.n2 10.1513
R1439 D0.t0 D0.n1 700.484
R1440 D0.n2 D0.t0 700.484
R1441 D0.t1 D0.n0 255.345
R1442 D0.n6 D0.t1 255.345
R1443 D0 D0.n0 12.8005
R1444 D0 D0.n6 12.8005
R1445 D0 D0.n1 12.8005
R1446 D0.n2 D0 12.8005
R1447 D0.n5 D0.n4 10.2887
R1448 D0.n5 D0.n0 10.1513
R1449 D0.n6 D0.n5 10.1513
R1450 D0.n3 D0.n1 10.1513
R1451 D0.n3 D0.n2 10.1513
R1452 D0.n4 D0.n3 9.59549
R1453 D0.n4 D0 3.14363
R1454 S0B.t0 S0B.n0 700.484
R1455 S0B.n9 S0B.t0 700.484
R1456 S0B S0B.t2 330.341
R1457 S0B S0B.t5 330.341
R1458 S0B S0B.t3 315.88
R1459 S0B S0B.t4 315.88
R1460 S0B.t1 S0B.n4 255.345
R1461 S0B.n5 S0B.t1 255.345
R1462 S0B.n1 S0B 31.4844
R1463 S0B.n3 S0B 30.8068
R1464 S0B.n1 S0B 30.8068
R1465 S0B.n2 S0B 30.7911
R1466 S0B.n8 S0B.n7 13.0665
R1467 S0B S0B.n4 12.8005
R1468 S0B.n5 S0B 12.8005
R1469 S0B S0B.n0 12.8005
R1470 S0B S0B.n9 12.8005
R1471 S0B.n7 S0B.n6 12.3733
R1472 S0B.n6 S0B.n4 10.1513
R1473 S0B.n6 S0B.n5 10.1513
R1474 S0B.n8 S0B.n0 10.1513
R1475 S0B.n9 S0B.n8 10.1513
R1476 S0B.n7 S0B.n3 2.90275
R1477 S0B.n2 S0B.n1 2.10375
R1478 S0B.n3 S0B.n2 0.69375
R1479 D1.t0 D1.n1 700.484
R1480 D1.n2 D1.t0 700.484
R1481 D1.t1 D1.n0 255.345
R1482 D1.n6 D1.t1 255.345
R1483 D1 D1.n0 12.8005
R1484 D1 D1.n6 12.8005
R1485 D1 D1.n1 12.8005
R1486 D1.n2 D1 12.8005
R1487 D1.n5 D1.n4 10.636
R1488 D1.n5 D1.n0 10.1513
R1489 D1.n6 D1.n5 10.1513
R1490 D1.n3 D1.n1 10.1513
R1491 D1.n3 D1.n2 10.1513
R1492 D1.n4 D1.n3 9.94271
R1493 D1.n4 D1 4.55362
R1494 D2.t1 D2.n1 700.484
R1495 D2.n2 D2.t1 700.484
R1496 D2.t0 D2.n0 255.345
R1497 D2.n6 D2.t0 255.345
R1498 D2 D2.n0 12.8005
R1499 D2 D2.n6 12.8005
R1500 D2 D2.n1 12.8005
R1501 D2.n2 D2 12.8005
R1502 D2.n5 D2.n4 10.9832
R1503 D2.n4 D2.n3 10.2899
R1504 D2.n5 D2.n0 10.1513
R1505 D2.n6 D2.n5 10.1513
R1506 D2.n3 D2.n1 10.1513
R1507 D2.n3 D2.n2 10.1513
R1508 D2.n4 D2 5.96363
C91 Y VGND 11.58837f
C92 D3 VGND 17.88253f
C93 D2 VGND 45.84177f
C94 S1 VGND 7.02179f
C95 S0 VGND 7.85294f
C96 VPWR VGND 28.6719f
C97 BUF_N VGND 5.88364f $ **FLOATING
C98 N23 VGND 4.62735f $ **FLOATING
C99 N01 VGND 4.29195f $ **FLOATING
C100 S1B VGND 5.59091f $ **FLOATING
C101 S0B VGND 7.58466f $ **FLOATING
C102 D2.n0 VGND 0.26502f $ **FLOATING
C103 D2.n1 VGND 0.23198f $ **FLOATING
C104 D2.t1 VGND 0.7105f $ **FLOATING
C105 D2.n2 VGND 0.23198f $ **FLOATING
C106 D2.n3 VGND 5.23147f $ **FLOATING
C107 D2.t0 VGND 0.64441f $ **FLOATING
C108 D2.n6 VGND 0.26502f $ **FLOATING
C109 D1.n4 VGND 42.9889f $ **FLOATING
C110 D1.n5 VGND 1.96304f $ **FLOATING
C111 S0B.n0 VGND 0.0351f $ **FLOATING
C112 S0B.t5 VGND 0.15073f $ **FLOATING
C113 S0B.t4 VGND 0.14505f $ **FLOATING
C114 S0B.t2 VGND 0.15073f $ **FLOATING
C115 S0B.n2 VGND 5.38786f $ **FLOATING
C116 S0B.t3 VGND 0.14505f $ **FLOATING
C117 S0B.n3 VGND 6.27934f $ **FLOATING
C118 S0B.n4 VGND 0.0401f $ **FLOATING
C119 S0B.t1 VGND 0.09751f $ **FLOATING
C120 S0B.n5 VGND 0.0401f $ **FLOATING
C121 S0B.n6 VGND 1.42639f $ **FLOATING
C122 S0B.n7 VGND 7.74483f $ **FLOATING
C123 S0B.n8 VGND 1.54613f $ **FLOATING
C124 S0B.t0 VGND 0.10752f $ **FLOATING
C125 S0B.n9 VGND 0.0351f $ **FLOATING
C126 D0.n4 VGND 23.8705f $ **FLOATING
C127 D0.n5 VGND 1.33157f $ **FLOATING
C128 Y.n0 VGND 0.00958f $ **FLOATING
C129 Y.n1 VGND 0.00839f $ **FLOATING
C130 Y.t0 VGND 0.02569f $ **FLOATING
C131 Y.n2 VGND 0.00839f $ **FLOATING
C132 Y.n3 VGND 0.41855f $ **FLOATING
C133 Y.n4 VGND 4.55505f $ **FLOATING
C134 Y.n5 VGND 0.44459f $ **FLOATING
C135 Y.t1 VGND 0.0233f $ **FLOATING
C136 Y.n6 VGND 0.00958f $ **FLOATING
C137 BUF_N.n5 VGND 10.8561f $ **FLOATING
C138 BUF_N.n6 VGND 0.63666f $ **FLOATING
C139 N01.n0 VGND 0.04767f $ **FLOATING
C140 N01.n1 VGND 0.05446f $ **FLOATING
C141 N01.t3 VGND 0.13243f $ **FLOATING
C142 N01.n2 VGND 0.05446f $ **FLOATING
C143 N01.n3 VGND 0.91658f $ **FLOATING
C144 N01.n4 VGND 0.04767f $ **FLOATING
C145 N01.t2 VGND 0.14601f $ **FLOATING
C146 N01.n5 VGND 0.04767f $ **FLOATING
C147 N01.n6 VGND 1.16065f $ **FLOATING
C148 N01.n7 VGND 0.05446f $ **FLOATING
C149 N01.t5 VGND 0.13243f $ **FLOATING
C150 N01.n8 VGND 0.05446f $ **FLOATING
C151 N01.n9 VGND 1.50194f $ **FLOATING
C152 N01.n11 VGND 0.04767f $ **FLOATING
C153 N01.t4 VGND 0.14601f $ **FLOATING
C154 N01.n12 VGND 0.04767f $ **FLOATING
C155 N01.n13 VGND 1.50194f $ **FLOATING
C156 N01.n14 VGND 3.78213f $ **FLOATING
C157 N01.n15 VGND 0.05446f $ **FLOATING
C158 N01.t1 VGND 0.13243f $ **FLOATING
C159 N01.n16 VGND 0.05446f $ **FLOATING
C160 N01.n17 VGND 1.50194f $ **FLOATING
C161 N01.n18 VGND 8.29782f $ **FLOATING
C162 N01.n20 VGND 1.50194f $ **FLOATING
C163 N01.t0 VGND 0.14601f $ **FLOATING
C164 N01.n21 VGND 0.04767f $ **FLOATING
C165 MUX_RAW.n4 VGND 0.12277f $ **FLOATING
C166 MUX_RAW.n8 VGND 0.2609p $ **FLOATING
C167 D3.n0 VGND 0.07726f $ **FLOATING
C168 D3.n1 VGND 0.06762f $ **FLOATING
C169 D3.t1 VGND 0.20712f $ **FLOATING
C170 D3.n2 VGND 0.06762f $ **FLOATING
C171 D3.n3 VGND 1.72532f $ **FLOATING
C172 D3.n5 VGND 0.44632f $ **FLOATING
C173 D3.t0 VGND 0.18785f $ **FLOATING
C174 D3.n6 VGND 0.07726f $ **FLOATING
C175 N23.n0 VGND 0.08839f $ **FLOATING
C176 N23.n1 VGND 0.07737f $ **FLOATING
C177 N23.t2 VGND 0.23697f $ **FLOATING
C178 N23.n2 VGND 0.07737f $ **FLOATING
C179 N23.n3 VGND 1.3791f $ **FLOATING
C180 N23.n4 VGND 0.08839f $ **FLOATING
C181 N23.t5 VGND 0.21493f $ **FLOATING
C182 N23.n5 VGND 0.08839f $ **FLOATING
C183 N23.n6 VGND 2.67172f $ **FLOATING
C184 N23.n8 VGND 0.07737f $ **FLOATING
C185 N23.t4 VGND 0.23697f $ **FLOATING
C186 N23.n9 VGND 0.07737f $ **FLOATING
C187 N23.n10 VGND 2.67172f $ **FLOATING
C188 N23.n11 VGND 6.41955f $ **FLOATING
C189 N23.n12 VGND 0.08839f $ **FLOATING
C190 N23.t1 VGND 0.21493f $ **FLOATING
C191 N23.n13 VGND 0.08839f $ **FLOATING
C192 N23.n14 VGND 2.67172f $ **FLOATING
C193 N23.n15 VGND 10.313f $ **FLOATING
C194 N23.n16 VGND 0.07737f $ **FLOATING
C195 N23.t3 VGND 0.23697f $ **FLOATING
C196 N23.n17 VGND 0.07737f $ **FLOATING
C197 N23.n18 VGND 2.67172f $ **FLOATING
C198 N23.n19 VGND 1.50948f $ **FLOATING
C199 N23.n20 VGND 2.14912f $ **FLOATING
C200 N23.t0 VGND 0.21493f $ **FLOATING
C201 N23.n21 VGND 0.08839f $ **FLOATING
C202 S0.t2 VGND 0.14991f $ **FLOATING
C203 S0.n0 VGND 3.11392f $ **FLOATING
C204 S0.t5 VGND 0.14426f $ **FLOATING
C205 S0.n1 VGND 5.1842f $ **FLOATING
C206 S0.t1 VGND 0.14991f $ **FLOATING
C207 S0.n2 VGND 6.72618f $ **FLOATING
C208 S0.t3 VGND 0.14426f $ **FLOATING
C209 S0.n3 VGND 5.1842f $ **FLOATING
C210 S0.t4 VGND 0.14991f $ **FLOATING
C211 S0.t0 VGND 0.14426f $ **FLOATING
C212 S1B.n0 VGND 0.03176f $ **FLOATING
C213 S1B.t3 VGND 0.13637f $ **FLOATING
C214 S1B.t2 VGND 0.13123f $ **FLOATING
C215 S1B.n1 VGND 6.06366f $ **FLOATING
C216 S1B.n2 VGND 0.03628f $ **FLOATING
C217 S1B.t1 VGND 0.08823f $ **FLOATING
C218 S1B.n3 VGND 0.03628f $ **FLOATING
C219 S1B.n4 VGND 1.48622f $ **FLOATING
C220 S1B.n5 VGND 9.0081f $ **FLOATING
C221 S1B.n6 VGND 1.45845f $ **FLOATING
C222 S1B.t0 VGND 0.09727f $ **FLOATING
C223 S1B.n7 VGND 0.03176f $ **FLOATING
C224 S1.t0 VGND 0.09898f $ **FLOATING
C225 S1.n0 VGND 3.32086f $ **FLOATING
C226 S1.t2 VGND 0.09525f $ **FLOATING
C227 S1.n1 VGND 6.734f $ **FLOATING
C228 S1.t1 VGND 0.09898f $ **FLOATING
C229 S1.n2 VGND 6.66131f $ **FLOATING
C230 S1.t3 VGND 0.09525f $ **FLOATING
.ends

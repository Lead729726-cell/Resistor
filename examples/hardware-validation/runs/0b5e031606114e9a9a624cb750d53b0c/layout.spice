* NGSPICE file created from SOC_TOP.ext - technology: sky130A

.subckt DIGITAL_logic_inv VGND a VPWR y
X0 VGND a N_3 VGND sky130_fd_pr__nfet_01v8 ad=0.1885 pd=1.88 as=0.1885 ps=1.88 w=0.65 l=0.15
X1 VGND N_3 OUT_y_0__N VGND sky130_fd_pr__nfet_01v8 ad=0.1885 pd=1.88 as=0.1885 ps=1.88 w=0.65 l=0.15
X2 VPWR N_3 OUT_y_0__N VPWR sky130_fd_pr__pfet_01v8_hvt ad=0.1885 pd=1.88 as=0.1885 ps=1.88 w=0.65 l=0.15
X3 VGND OUT_y_0__N y VGND sky130_fd_pr__nfet_01v8 ad=0.1885 pd=1.88 as=0.1885 ps=1.88 w=0.65 l=0.15
X4 VPWR OUT_y_0__N y VPWR sky130_fd_pr__pfet_01v8_hvt ad=0.1885 pd=1.88 as=0.1885 ps=1.88 w=0.65 l=0.15
X5 VPWR a N_3 VPWR sky130_fd_pr__pfet_01v8_hvt ad=0.1885 pd=1.88 as=0.1885 ps=1.88 w=0.65 l=0.15
.ends

.subckt ANALOG_current_mirror REF OUT VGND
X0 VGND REF OUT VGND sky130_fd_pr__nfet_01v8 ad=0.1885 pd=1.88 as=0.1885 ps=1.88 w=0.65 l=0.15
X1 VGND REF REF VGND sky130_fd_pr__nfet_01v8 ad=0.1885 pd=1.88 as=0.1885 ps=1.88 w=0.65 l=0.15
.ends

.subckt SOC_TOP
XDIGITAL_logic_inv_0 VSUBS DIGITAL_logic_inv_0/a DIGITAL_logic_inv_0/VPWR DIGITAL_logic_inv_0/y
+ DIGITAL_logic_inv
XANALOG_current_mirror_0 ANALOG_current_mirror_0/REF ANALOG_current_mirror_0/OUT VSUBS
+ ANALOG_current_mirror
.ends

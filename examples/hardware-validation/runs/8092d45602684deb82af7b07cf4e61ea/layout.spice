* NGSPICE file created from SOC_TOP.ext - technology: sky130A

.subckt SOC_TOP VPWR VGND IN DIGITAL_OUT ANALOG_OUT
X0 VGND IN DIGITAL__N_3 VGND sky130_fd_pr__nfet_01v8 ad=0.1885 pd=1.88 as=0.1885 ps=1.88 w=0.65 l=0.15
X1 VGND DIGITAL__N_3 DIGITAL__OUT_y_0__N VGND sky130_fd_pr__nfet_01v8 ad=0.1885 pd=1.88 as=0.1885 ps=1.88 w=0.65 l=0.15
X2 VGND DIGITAL_OUT DIGITAL_OUT VGND sky130_fd_pr__nfet_01v8 ad=0.1885 pd=1.88 as=0.1885 ps=1.88 w=0.65 l=0.15
X3 VGND DIGITAL__OUT_y_0__N DIGITAL_OUT VGND sky130_fd_pr__nfet_01v8 ad=0.1885 pd=1.88 as=0.1885 ps=1.88 w=0.65 l=0.15
X4 VPWR DIGITAL__OUT_y_0__N DIGITAL_OUT VPWR sky130_fd_pr__pfet_01v8_hvt ad=0.1885 pd=1.88 as=0.1885 ps=1.88 w=0.65 l=0.15
X5 VPWR IN DIGITAL__N_3 VPWR sky130_fd_pr__pfet_01v8_hvt ad=0.1885 pd=1.88 as=0.1885 ps=1.88 w=0.65 l=0.15
X6 VGND DIGITAL_OUT ANALOG_OUT VGND sky130_fd_pr__nfet_01v8 ad=0.1885 pd=1.88 as=0.1885 ps=1.88 w=0.65 l=0.15
X7 VPWR DIGITAL__N_3 DIGITAL__OUT_y_0__N VPWR sky130_fd_pr__pfet_01v8_hvt ad=0.1885 pd=1.88 as=0.1885 ps=1.88 w=0.65 l=0.15
.ends

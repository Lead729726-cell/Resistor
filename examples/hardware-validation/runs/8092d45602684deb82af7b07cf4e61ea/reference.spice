.subckt SOC_TOP VPWR VGND IN DIGITAL_OUT ANALOG_OUT
XANALOG_MN2 ANALOG_OUT DIGITAL_OUT VGND VGND sky130_fd_pr__nfet_01v8 w=0.65 l=0.15 nf=1 m=1
XANALOG_MN1 DIGITAL_OUT DIGITAL_OUT VGND VGND sky130_fd_pr__nfet_01v8 w=0.65 l=0.15 nf=1 m=1
XDIGITAL_G0_MP DIGITAL__N_3 IN VPWR VPWR sky130_fd_pr__pfet_01v8_hvt w=0.65 l=0.15 nf=1 m=1
XDIGITAL_G0_MN DIGITAL__N_3 IN VGND VGND sky130_fd_pr__nfet_01v8 w=0.65 l=0.15 nf=1 m=1
XDIGITAL_OUT_y_0_I0_MP DIGITAL__OUT_y_0__N DIGITAL__N_3 VPWR VPWR sky130_fd_pr__pfet_01v8_hvt w=0.65 l=0.15 nf=1 m=1
XDIGITAL_OUT_y_0_I0_MN DIGITAL__OUT_y_0__N DIGITAL__N_3 VGND VGND sky130_fd_pr__nfet_01v8 w=0.65 l=0.15 nf=1 m=1
XDIGITAL_OUT_y_0_I1_MP DIGITAL_OUT DIGITAL__OUT_y_0__N VPWR VPWR sky130_fd_pr__pfet_01v8_hvt w=0.65 l=0.15 nf=1 m=1
XDIGITAL_OUT_y_0_I1_MN DIGITAL_OUT DIGITAL__OUT_y_0__N VGND VGND sky130_fd_pr__nfet_01v8 w=0.65 l=0.15 nf=1 m=1
.ends SOC_TOP

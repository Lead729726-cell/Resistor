* NGSPICE file created from SOC_TOP.ext - technology: sky130A

.subckt SOC_TOP VPWR VGND IN DIGITAL_OUT ANALOG_OUT
X0 VGND.t3 IN.t0 DIGITAL__N_3.t0 VGND.t2 sky130_fd_pr__nfet_01v8 ad=0.1885 pd=1.88 as=0.1885 ps=1.88 w=0.65 l=0.15
X1 VGND.t9 DIGITAL__N_3.t2 DIGITAL__OUT_y_0__N.t0 VGND.t8 sky130_fd_pr__nfet_01v8 ad=0.1885 pd=1.88 as=0.1885 ps=1.88 w=0.65 l=0.15
X2 VGND.t5 DIGITAL_OUT.t0 DIGITAL_OUT.t1 VGND.t4 sky130_fd_pr__nfet_01v8 ad=0.1885 pd=1.88 as=0.1885 ps=1.88 w=0.65 l=0.15
X3 VGND.t1 DIGITAL__OUT_y_0__N.t2 DIGITAL_OUT.t2 VGND.t0 sky130_fd_pr__nfet_01v8 ad=0.1885 pd=1.88 as=0.1885 ps=1.88 w=0.65 l=0.15
X4 VPWR.t1 DIGITAL__OUT_y_0__N.t3 DIGITAL_OUT.t3 VPWR.t0 sky130_fd_pr__pfet_01v8_hvt ad=0.1885 pd=1.88 as=0.1885 ps=1.88 w=0.65 l=0.15
X5 VPWR.t3 IN.t1 DIGITAL__N_3.t1 VPWR.t2 sky130_fd_pr__pfet_01v8_hvt ad=0.1885 pd=1.88 as=0.1885 ps=1.88 w=0.65 l=0.15
X6 VGND.t7 DIGITAL_OUT.t4 ANALOG_OUT.t0 VGND.t6 sky130_fd_pr__nfet_01v8 ad=0.1885 pd=1.88 as=0.1885 ps=1.88 w=0.65 l=0.15
X7 VPWR.t5 DIGITAL__N_3.t3 DIGITAL__OUT_y_0__N.t1 VPWR.t4 sky130_fd_pr__pfet_01v8_hvt ad=0.1885 pd=1.88 as=0.1885 ps=1.88 w=0.65 l=0.15
C0 VPWR DIGITAL__N_3 0.70351f
C1 VPWR DIGITAL__OUT_y_0__N 0.69839f
C2 IN ANALOG_OUT 0.00236f
C3 IN DIGITAL_OUT 0
C4 ANALOG_OUT DIGITAL_OUT 5.208f
C5 IN DIGITAL__N_3 1.88887f
C6 ANALOG_OUT DIGITAL__N_3 0.04333f
C7 IN DIGITAL__OUT_y_0__N 0.0559f
C8 ANALOG_OUT DIGITAL__OUT_y_0__N 3.59748f
C9 IN VPWR 0.43984f
C10 ANALOG_OUT VPWR 0.00125f
C11 DIGITAL__N_3 DIGITAL_OUT 0.06836f
C12 DIGITAL__OUT_y_0__N DIGITAL_OUT 0.66923f
C13 VPWR DIGITAL_OUT 0.26849f
C14 DIGITAL__OUT_y_0__N DIGITAL__N_3 3.08046f
R0 IN IN.t1 330.341
R1 IN IN.t0 315.88
R2 IN.n0 IN 29.9353
R3 IN.n0 IN 29.3671
R4 IN IN.n0 4.74804
R5 DIGITAL__N_3.t1 DIGITAL__N_3.n2 700.484
R6 DIGITAL__N_3.n3 DIGITAL__N_3.t1 700.484
R7 DIGITAL__N_3 DIGITAL__N_3.t3 330.341
R8 DIGITAL__N_3 DIGITAL__N_3.t2 315.88
R9 DIGITAL__N_3.t0 DIGITAL__N_3.n0 255.345
R10 DIGITAL__N_3.n7 DIGITAL__N_3.t0 255.345
R11 DIGITAL__N_3.n1 DIGITAL__N_3 30.352
R12 DIGITAL__N_3.n1 DIGITAL__N_3 29.7837
R13 DIGITAL__N_3 DIGITAL__N_3.n2 12.8005
R14 DIGITAL__N_3.n3 DIGITAL__N_3 12.8005
R15 DIGITAL__N_3 DIGITAL__N_3.n0 12.8005
R16 DIGITAL__N_3 DIGITAL__N_3.n7 12.8005
R17 DIGITAL__N_3.n5 DIGITAL__N_3.n4 11.0047
R18 DIGITAL__N_3.n6 DIGITAL__N_3.n5 10.4521
R19 DIGITAL__N_3.n4 DIGITAL__N_3.n2 10.1513
R20 DIGITAL__N_3.n4 DIGITAL__N_3.n3 10.1513
R21 DIGITAL__N_3.n6 DIGITAL__N_3.n0 10.1513
R22 DIGITAL__N_3.n7 DIGITAL__N_3.n6 10.1513
R23 DIGITAL__N_3.n5 DIGITAL__N_3.n1 0.789708
R24 VGND.n160 VGND.n158 3632.52
R25 VGND.n135 VGND.n134 3632.52
R26 VGND.n87 VGND.n86 1515.12
R27 VGND.n111 VGND.n110 1515.12
R28 VGND.n122 VGND.n112 1315.26
R29 VGND.n132 VGND.n23 1315.26
R30 VGND.n124 VGND.n26 1315.26
R31 VGND.n126 VGND.n125 1315.26
R32 VGND.n98 VGND.n88 1315.26
R33 VGND.n108 VGND.n31 1315.26
R34 VGND.n100 VGND.n34 1315.26
R35 VGND.n102 VGND.n101 1315.26
R36 VGND.n146 VGND.n136 1315.26
R37 VGND.n156 VGND.n15 1315.26
R38 VGND.n148 VGND.n18 1315.26
R39 VGND.n150 VGND.n149 1315.26
R40 VGND.n168 VGND.n9 1315.26
R41 VGND.n179 VGND.n10 1315.26
R42 VGND.n163 VGND.n6 1315.26
R43 VGND.n181 VGND.n7 1315.26
R44 VGND.n74 VGND.n64 1315.26
R45 VGND.n84 VGND.n39 1315.26
R46 VGND.n78 VGND.n77 1315.26
R47 VGND.n76 VGND.n42 1315.26
R48 VGND.n177 VGND.n10 585
R49 VGND.n176 VGND.n175 585
R50 VGND.n173 VGND.n171 585
R51 VGND.n7 VGND.n5 585
R52 VGND.n182 VGND.n181 585
R53 VGND.n181 VGND.n180 585
R54 VGND.n6 VGND.n4 585
R55 VGND.n159 VGND.n6 585
R56 VGND.n163 VGND.n162 585
R57 VGND.n165 VGND.n161 585
R58 VGND.n166 VGND.n11 585
R59 VGND.n169 VGND.n168 585
R60 VGND.n170 VGND.n9 585
R61 VGND.n159 VGND.n9 585
R62 VGND.n179 VGND.n178 585
R63 VGND.n180 VGND.n179 585
R64 VGND.n156 VGND.n155 585
R65 VGND.n154 VGND.n14 585
R66 VGND.n153 VGND.n152 585
R67 VGND.n151 VGND.n150 585
R68 VGND.n149 VGND.n17 585
R69 VGND.n149 VGND.n12 585
R70 VGND.n148 VGND.n19 585
R71 VGND.n148 VGND.n147 585
R72 VGND.n137 VGND.n18 585
R73 VGND.n141 VGND.n138 585
R74 VGND.n143 VGND.n142 585
R75 VGND.n144 VGND.n136 585
R76 VGND.n146 VGND.n145 585
R77 VGND.n147 VGND.n146 585
R78 VGND.n16 VGND.n15 585
R79 VGND.n15 VGND.n12 585
R80 VGND.n108 VGND.n107 585
R81 VGND.n106 VGND.n30 585
R82 VGND.n105 VGND.n104 585
R83 VGND.n103 VGND.n102 585
R84 VGND.n101 VGND.n33 585
R85 VGND.n101 VGND.n28 585
R86 VGND.n100 VGND.n35 585
R87 VGND.n100 VGND.n99 585
R88 VGND.n89 VGND.n34 585
R89 VGND.n93 VGND.n90 585
R90 VGND.n95 VGND.n94 585
R91 VGND.n96 VGND.n88 585
R92 VGND.n98 VGND.n97 585
R93 VGND.n99 VGND.n98 585
R94 VGND.n32 VGND.n31 585
R95 VGND.n31 VGND.n28 585
R96 VGND.n132 VGND.n131 585
R97 VGND.n130 VGND.n22 585
R98 VGND.n129 VGND.n128 585
R99 VGND.n127 VGND.n126 585
R100 VGND.n125 VGND.n25 585
R101 VGND.n125 VGND.n20 585
R102 VGND.n124 VGND.n27 585
R103 VGND.n124 VGND.n123 585
R104 VGND.n113 VGND.n26 585
R105 VGND.n117 VGND.n114 585
R106 VGND.n119 VGND.n118 585
R107 VGND.n120 VGND.n112 585
R108 VGND.n122 VGND.n121 585
R109 VGND.n123 VGND.n122 585
R110 VGND.n24 VGND.n23 585
R111 VGND.n23 VGND.n20 585
R112 VGND.n65 VGND.n42 585
R113 VGND.n68 VGND.n66 585
R114 VGND.n71 VGND.n70 585
R115 VGND.n72 VGND.n64 585
R116 VGND.n74 VGND.n73 585
R117 VGND.n75 VGND.n74 585
R118 VGND.n40 VGND.n39 585
R119 VGND.n39 VGND.n36 585
R120 VGND.n84 VGND.n83 585
R121 VGND.n82 VGND.n38 585
R122 VGND.n81 VGND.n80 585
R123 VGND.n79 VGND.n78 585
R124 VGND.n77 VGND.n41 585
R125 VGND.n77 VGND.n36 585
R126 VGND.n76 VGND.n62 585
R127 VGND.n76 VGND.n75 585
R128 VGND.n122 VGND.n23 394
R129 VGND.n118 VGND.n117 394
R130 VGND.n125 VGND.n124 394
R131 VGND.n128 VGND.n22 394
R132 VGND.n98 VGND.n31 394
R133 VGND.n94 VGND.n93 394
R134 VGND.n101 VGND.n100 394
R135 VGND.n104 VGND.n30 394
R136 VGND.n146 VGND.n15 394
R137 VGND.n142 VGND.n141 394
R138 VGND.n149 VGND.n148 394
R139 VGND.n152 VGND.n14 394
R140 VGND.n179 VGND.n9 394
R141 VGND.n166 VGND.n165 394
R142 VGND.n181 VGND.n6 394
R143 VGND.n175 VGND.n173 394
R144 VGND.n74 VGND.n39 394
R145 VGND.n80 VGND.n38 394
R146 VGND.n77 VGND.n76 394
R147 VGND.n70 VGND.n68 394
R148 VGND.t3 VGND.n0 255.345
R149 VGND.n1 VGND.t3 255.345
R150 VGND.t9 VGND.n47 255.345
R151 VGND.n48 VGND.t9 255.345
R152 VGND.t1 VGND.n52 255.345
R153 VGND.n53 VGND.t1 255.345
R154 VGND.t5 VGND.n57 255.345
R155 VGND.n58 VGND.t5 255.345
R156 VGND.t7 VGND.n43 255.345
R157 VGND.n44 VGND.t7 255.345
R158 VGND.n174 VGND.n8 218.815
R159 VGND.n172 VGND.n8 218.815
R160 VGND.n164 VGND.n160 218.815
R161 VGND.n167 VGND.n160 218.815
R162 VGND.n158 VGND.n157 218.815
R163 VGND.n158 VGND.n13 218.815
R164 VGND.n140 VGND.n135 218.815
R165 VGND.n139 VGND.n135 218.815
R166 VGND.n110 VGND.n109 218.815
R167 VGND.n110 VGND.n29 218.815
R168 VGND.n92 VGND.n87 218.815
R169 VGND.n91 VGND.n87 218.815
R170 VGND.n134 VGND.n133 218.815
R171 VGND.n134 VGND.n21 218.815
R172 VGND.n116 VGND.n111 218.815
R173 VGND.n115 VGND.n111 218.815
R174 VGND.n67 VGND.n63 218.815
R175 VGND.n69 VGND.n63 218.815
R176 VGND.n86 VGND.n85 218.815
R177 VGND.n86 VGND.n37 218.815
R178 VGND.n160 VGND.n159 173.316
R179 VGND.n180 VGND.n8 173.316
R180 VGND.n147 VGND.n135 173.316
R181 VGND.n158 VGND.n12 173.316
R182 VGND.n75 VGND.n63 173.316
R183 VGND.n86 VGND.n36 173.316
R184 VGND.n99 VGND.n87 173.316
R185 VGND.n110 VGND.n28 173.316
R186 VGND.n123 VGND.n111 173.316
R187 VGND.n134 VGND.n20 173.316
R188 VGND.n118 VGND.n115 147.374
R189 VGND.n116 VGND.n26 147.374
R190 VGND.n133 VGND.n132 147.374
R191 VGND.n126 VGND.n21 147.374
R192 VGND.n94 VGND.n91 147.374
R193 VGND.n92 VGND.n34 147.374
R194 VGND.n109 VGND.n108 147.374
R195 VGND.n102 VGND.n29 147.374
R196 VGND.n142 VGND.n139 147.374
R197 VGND.n140 VGND.n18 147.374
R198 VGND.n157 VGND.n156 147.374
R199 VGND.n150 VGND.n13 147.374
R200 VGND.n167 VGND.n166 147.374
R201 VGND.n164 VGND.n163 147.374
R202 VGND.n174 VGND.n10 147.374
R203 VGND.n172 VGND.n7 147.374
R204 VGND.n175 VGND.n174 147.374
R205 VGND.n173 VGND.n172 147.374
R206 VGND.n165 VGND.n164 147.374
R207 VGND.n168 VGND.n167 147.374
R208 VGND.n157 VGND.n14 147.374
R209 VGND.n152 VGND.n13 147.374
R210 VGND.n141 VGND.n140 147.374
R211 VGND.n139 VGND.n136 147.374
R212 VGND.n109 VGND.n30 147.374
R213 VGND.n104 VGND.n29 147.374
R214 VGND.n93 VGND.n92 147.374
R215 VGND.n91 VGND.n88 147.374
R216 VGND.n133 VGND.n22 147.374
R217 VGND.n128 VGND.n21 147.374
R218 VGND.n117 VGND.n116 147.374
R219 VGND.n115 VGND.n112 147.374
R220 VGND.n85 VGND.n84 147.374
R221 VGND.n78 VGND.n37 147.374
R222 VGND.n69 VGND.n64 147.374
R223 VGND.n68 VGND.n67 147.374
R224 VGND.n67 VGND.n42 147.374
R225 VGND.n70 VGND.n69 147.374
R226 VGND.n85 VGND.n38 147.374
R227 VGND.n80 VGND.n37 147.374
R228 VGND.n121 VGND.n120 85.4593
R229 VGND.n131 VGND.n24 85.4593
R230 VGND.n113 VGND.n27 85.4593
R231 VGND.n127 VGND.n25 85.4593
R232 VGND.n97 VGND.n96 85.4593
R233 VGND.n107 VGND.n32 85.4593
R234 VGND.n89 VGND.n35 85.4593
R235 VGND.n103 VGND.n33 85.4593
R236 VGND.n145 VGND.n144 85.4593
R237 VGND.n155 VGND.n16 85.4593
R238 VGND.n137 VGND.n19 85.4593
R239 VGND.n151 VGND.n17 85.4593
R240 VGND.n170 VGND.n169 85.4593
R241 VGND.n178 VGND.n177 85.4593
R242 VGND.n162 VGND.n4 85.4593
R243 VGND.n182 VGND.n5 85.4593
R244 VGND.n73 VGND.n72 85.4593
R245 VGND.n65 VGND.n62 85.4593
R246 VGND.n83 VGND.n40 85.4593
R247 VGND.n79 VGND.n41 85.4593
R248 VGND.n159 VGND.t2 47.5227
R249 VGND.n180 VGND.t2 47.5227
R250 VGND.n147 VGND.t8 47.5227
R251 VGND.t8 VGND.n12 47.5227
R252 VGND.n75 VGND.t6 47.5227
R253 VGND.t6 VGND.n36 47.5227
R254 VGND.n99 VGND.t4 47.5227
R255 VGND.t4 VGND.n28 47.5227
R256 VGND.n123 VGND.t0 47.5227
R257 VGND.t0 VGND.n20 47.5227
R258 VGND.n121 VGND.n24 25.6005
R259 VGND.n120 VGND.n119 25.6005
R260 VGND.n119 VGND.n114 25.6005
R261 VGND.n114 VGND.n113 25.6005
R262 VGND.n131 VGND.n130 25.6005
R263 VGND.n130 VGND.n129 25.6005
R264 VGND.n129 VGND.n127 25.6005
R265 VGND.n97 VGND.n32 25.6005
R266 VGND.n96 VGND.n95 25.6005
R267 VGND.n95 VGND.n90 25.6005
R268 VGND.n90 VGND.n89 25.6005
R269 VGND.n107 VGND.n106 25.6005
R270 VGND.n106 VGND.n105 25.6005
R271 VGND.n105 VGND.n103 25.6005
R272 VGND.n145 VGND.n16 25.6005
R273 VGND.n144 VGND.n143 25.6005
R274 VGND.n143 VGND.n138 25.6005
R275 VGND.n138 VGND.n137 25.6005
R276 VGND.n155 VGND.n154 25.6005
R277 VGND.n154 VGND.n153 25.6005
R278 VGND.n153 VGND.n151 25.6005
R279 VGND.n178 VGND.n170 25.6005
R280 VGND.n169 VGND.n11 25.6005
R281 VGND.n161 VGND.n11 25.6005
R282 VGND.n162 VGND.n161 25.6005
R283 VGND.n177 VGND.n176 25.6005
R284 VGND.n176 VGND.n171 25.6005
R285 VGND.n171 VGND.n5 25.6005
R286 VGND.n72 VGND.n71 25.6005
R287 VGND.n71 VGND.n66 25.6005
R288 VGND.n66 VGND.n65 25.6005
R289 VGND.n73 VGND.n40 25.6005
R290 VGND.n83 VGND.n82 25.6005
R291 VGND.n82 VGND.n81 25.6005
R292 VGND.n81 VGND.n79 25.6005
R293 VGND.n51 VGND 18.3598
R294 VGND.n56 VGND 18.3598
R295 VGND.n46 VGND 18.3598
R296 VGND.n183 VGND 18.3598
R297 VGND VGND.n61 18.3598
R298 VGND VGND.n47 12.8005
R299 VGND.n48 VGND 12.8005
R300 VGND VGND.n52 12.8005
R301 VGND.n53 VGND 12.8005
R302 VGND VGND.n57 12.8005
R303 VGND.n58 VGND 12.8005
R304 VGND VGND.n43 12.8005
R305 VGND.n44 VGND 12.8005
R306 VGND VGND.n27 12.8005
R307 VGND VGND.n25 12.8005
R308 VGND VGND.n35 12.8005
R309 VGND VGND.n33 12.8005
R310 VGND VGND.n19 12.8005
R311 VGND VGND.n17 12.8005
R312 VGND VGND.n4 12.8005
R313 VGND VGND.n182 12.8005
R314 VGND.n62 VGND 12.8005
R315 VGND VGND.n41 12.8005
R316 VGND VGND.n0 12.8005
R317 VGND.n1 VGND 12.8005
R318 VGND.n49 VGND.n47 10.1513
R319 VGND.n49 VGND.n48 10.1513
R320 VGND.n54 VGND.n52 10.1513
R321 VGND.n54 VGND.n53 10.1513
R322 VGND.n59 VGND.n57 10.1513
R323 VGND.n59 VGND.n58 10.1513
R324 VGND.n45 VGND.n43 10.1513
R325 VGND.n45 VGND.n44 10.1513
R326 VGND.n2 VGND.n0 10.1513
R327 VGND.n2 VGND.n1 10.1513
R328 VGND.n61 VGND.n45 10.1294
R329 VGND.n50 VGND.n49 10.0354
R330 VGND.n55 VGND.n54 10.0354
R331 VGND.n60 VGND.n59 10.0354
R332 VGND.n3 VGND.n2 10.0354
R333 VGND VGND.n183 5.01712
R334 VGND.n51 VGND.n50 1.01178
R335 VGND.n46 VGND.n3 1.01178
R336 VGND.n61 VGND.n60 0.454833
R337 VGND.n56 VGND.n55 0.454833
R338 VGND.n60 VGND.n56 0.0945
R339 VGND.n55 VGND.n51 0.0945
R340 VGND.n50 VGND.n46 0.0945
R341 VGND.n183 VGND.n3 0.0945
R342 DIGITAL__OUT_y_0__N.t1 DIGITAL__OUT_y_0__N.n2 700.484
R343 DIGITAL__OUT_y_0__N.n3 DIGITAL__OUT_y_0__N.t1 700.484
R344 DIGITAL__OUT_y_0__N DIGITAL__OUT_y_0__N.t3 330.341
R345 DIGITAL__OUT_y_0__N DIGITAL__OUT_y_0__N.t2 315.88
R346 DIGITAL__OUT_y_0__N.t0 DIGITAL__OUT_y_0__N.n0 255.345
R347 DIGITAL__OUT_y_0__N.n7 DIGITAL__OUT_y_0__N.t0 255.345
R348 DIGITAL__OUT_y_0__N.n1 DIGITAL__OUT_y_0__N 30.7687
R349 DIGITAL__OUT_y_0__N.n1 DIGITAL__OUT_y_0__N 30.2004
R350 DIGITAL__OUT_y_0__N DIGITAL__OUT_y_0__N.n2 12.8005
R351 DIGITAL__OUT_y_0__N.n3 DIGITAL__OUT_y_0__N 12.8005
R352 DIGITAL__OUT_y_0__N DIGITAL__OUT_y_0__N.n0 12.8005
R353 DIGITAL__OUT_y_0__N DIGITAL__OUT_y_0__N.n7 12.8005
R354 DIGITAL__OUT_y_0__N.n5 DIGITAL__OUT_y_0__N.n4 11.4214
R355 DIGITAL__OUT_y_0__N.n6 DIGITAL__OUT_y_0__N.n5 10.8688
R356 DIGITAL__OUT_y_0__N.n4 DIGITAL__OUT_y_0__N.n2 10.1513
R357 DIGITAL__OUT_y_0__N.n4 DIGITAL__OUT_y_0__N.n3 10.1513
R358 DIGITAL__OUT_y_0__N.n6 DIGITAL__OUT_y_0__N.n0 10.1513
R359 DIGITAL__OUT_y_0__N.n7 DIGITAL__OUT_y_0__N.n6 10.1513
R360 DIGITAL__OUT_y_0__N.n5 DIGITAL__OUT_y_0__N.n1 0.789708
R361 DIGITAL_OUT.t3 DIGITAL_OUT.n9 700.484
R362 DIGITAL_OUT.n10 DIGITAL_OUT.t3 700.484
R363 DIGITAL_OUT DIGITAL_OUT.t0 315.88
R364 DIGITAL_OUT DIGITAL_OUT.t4 315.88
R365 DIGITAL_OUT.t2 DIGITAL_OUT.n5 255.345
R366 DIGITAL_OUT.n6 DIGITAL_OUT.t2 255.345
R367 DIGITAL_OUT.t1 DIGITAL_OUT.n1 255.345
R368 DIGITAL_OUT.n2 DIGITAL_OUT.t1 255.345
R369 DIGITAL_OUT.n0 DIGITAL_OUT 31.5977
R370 DIGITAL_OUT.n0 DIGITAL_OUT 31.0494
R371 DIGITAL_OUT DIGITAL_OUT.n5 12.8005
R372 DIGITAL_OUT.n6 DIGITAL_OUT 12.8005
R373 DIGITAL_OUT DIGITAL_OUT.n1 12.8005
R374 DIGITAL_OUT.n2 DIGITAL_OUT 12.8005
R375 DIGITAL_OUT DIGITAL_OUT.n9 12.8005
R376 DIGITAL_OUT.n10 DIGITAL_OUT 12.8005
R377 DIGITAL_OUT.n8 DIGITAL_OUT.n7 11.7021
R378 DIGITAL_OUT.n4 DIGITAL_OUT.n3 11.7021
R379 DIGITAL_OUT.n12 DIGITAL_OUT.n11 11.7021
R380 DIGITAL_OUT.n7 DIGITAL_OUT.n5 10.1513
R381 DIGITAL_OUT.n7 DIGITAL_OUT.n6 10.1513
R382 DIGITAL_OUT.n3 DIGITAL_OUT.n1 10.1513
R383 DIGITAL_OUT.n3 DIGITAL_OUT.n2 10.1513
R384 DIGITAL_OUT.n11 DIGITAL_OUT.n9 10.1513
R385 DIGITAL_OUT.n11 DIGITAL_OUT.n10 10.1513
R386 DIGITAL_OUT DIGITAL_OUT.n12 7.14504
R387 DIGITAL_OUT.n12 DIGITAL_OUT.n8 0.553142
R388 DIGITAL_OUT.n8 DIGITAL_OUT.n4 0.548833
R389 DIGITAL_OUT.n4 DIGITAL_OUT.n0 0.237067
R390 VPWR.n57 VPWR.n45 832.942
R391 VPWR.n68 VPWR.n46 832.942
R392 VPWR.n70 VPWR.n43 832.942
R393 VPWR.n52 VPWR.n42 832.942
R394 VPWR.n20 VPWR.n8 832.942
R395 VPWR.n31 VPWR.n9 832.942
R396 VPWR.n33 VPWR.n6 832.942
R397 VPWR.n15 VPWR.n5 832.942
R398 VPWR.n94 VPWR.n82 832.942
R399 VPWR.n105 VPWR.n83 832.942
R400 VPWR.n107 VPWR.n80 832.942
R401 VPWR.n89 VPWR.n79 832.942
R402 VPWR.t3 VPWR.n73 700.484
R403 VPWR.n74 VPWR.t3 700.484
R404 VPWR.t5 VPWR.n36 700.484
R405 VPWR.n37 VPWR.t5 700.484
R406 VPWR.t1 VPWR.n0 700.484
R407 VPWR.n1 VPWR.t1 700.484
R408 VPWR.n68 VPWR.n45 240
R409 VPWR.n64 VPWR.n62 240
R410 VPWR.n70 VPWR.n42 240
R411 VPWR.n49 VPWR.n48 240
R412 VPWR.n31 VPWR.n8 240
R413 VPWR.n27 VPWR.n25 240
R414 VPWR.n33 VPWR.n5 240
R415 VPWR.n12 VPWR.n11 240
R416 VPWR.n105 VPWR.n82 240
R417 VPWR.n101 VPWR.n99 240
R418 VPWR.n107 VPWR.n79 240
R419 VPWR.n86 VPWR.n85 240
R420 VPWR.n55 VPWR.n54 207.394
R421 VPWR.n69 VPWR.n44 207.394
R422 VPWR.n18 VPWR.n17 207.394
R423 VPWR.n32 VPWR.n7 207.394
R424 VPWR.n92 VPWR.n91 207.394
R425 VPWR.n106 VPWR.n81 207.394
R426 VPWR.n52 VPWR.n51 185
R427 VPWR.n50 VPWR.n49 185
R428 VPWR.n48 VPWR.n47 185
R429 VPWR.n58 VPWR.n57 185
R430 VPWR.n59 VPWR.n45 185
R431 VPWR.n54 VPWR.n45 185
R432 VPWR.n68 VPWR.n67 185
R433 VPWR.n69 VPWR.n68 185
R434 VPWR.n66 VPWR.n46 185
R435 VPWR.n65 VPWR.n64 185
R436 VPWR.n62 VPWR.n60 185
R437 VPWR.n43 VPWR.n41 185
R438 VPWR.n71 VPWR.n70 185
R439 VPWR.n70 VPWR.n69 185
R440 VPWR.n42 VPWR.n40 185
R441 VPWR.n54 VPWR.n42 185
R442 VPWR.n15 VPWR.n14 185
R443 VPWR.n13 VPWR.n12 185
R444 VPWR.n11 VPWR.n10 185
R445 VPWR.n21 VPWR.n20 185
R446 VPWR.n22 VPWR.n8 185
R447 VPWR.n17 VPWR.n8 185
R448 VPWR.n31 VPWR.n30 185
R449 VPWR.n32 VPWR.n31 185
R450 VPWR.n29 VPWR.n9 185
R451 VPWR.n28 VPWR.n27 185
R452 VPWR.n25 VPWR.n23 185
R453 VPWR.n6 VPWR.n4 185
R454 VPWR.n34 VPWR.n33 185
R455 VPWR.n33 VPWR.n32 185
R456 VPWR.n5 VPWR.n3 185
R457 VPWR.n17 VPWR.n5 185
R458 VPWR.n89 VPWR.n88 185
R459 VPWR.n87 VPWR.n86 185
R460 VPWR.n85 VPWR.n84 185
R461 VPWR.n95 VPWR.n94 185
R462 VPWR.n96 VPWR.n82 185
R463 VPWR.n91 VPWR.n82 185
R464 VPWR.n105 VPWR.n104 185
R465 VPWR.n106 VPWR.n105 185
R466 VPWR.n103 VPWR.n83 185
R467 VPWR.n102 VPWR.n101 185
R468 VPWR.n99 VPWR.n97 185
R469 VPWR.n80 VPWR.n78 185
R470 VPWR.n108 VPWR.n107 185
R471 VPWR.n107 VPWR.n106 185
R472 VPWR.n79 VPWR.n77 185
R473 VPWR.n91 VPWR.n79 185
R474 VPWR.n59 VPWR.n58 88.8476
R475 VPWR.n51 VPWR.n40 88.8476
R476 VPWR.n67 VPWR.n66 88.8476
R477 VPWR.n71 VPWR.n41 88.8476
R478 VPWR.n22 VPWR.n21 88.8476
R479 VPWR.n14 VPWR.n3 88.8476
R480 VPWR.n30 VPWR.n29 88.8476
R481 VPWR.n34 VPWR.n4 88.8476
R482 VPWR.n96 VPWR.n95 88.8476
R483 VPWR.n88 VPWR.n77 88.8476
R484 VPWR.n104 VPWR.n103 88.8476
R485 VPWR.n108 VPWR.n78 88.8476
R486 VPWR.n63 VPWR.n46 72.7879
R487 VPWR.n61 VPWR.n43 72.7879
R488 VPWR.n57 VPWR.n56 72.7879
R489 VPWR.n53 VPWR.n49 72.7879
R490 VPWR.n53 VPWR.n52 72.7879
R491 VPWR.n56 VPWR.n48 72.7879
R492 VPWR.n64 VPWR.n63 72.7879
R493 VPWR.n62 VPWR.n61 72.7879
R494 VPWR.n26 VPWR.n9 72.7879
R495 VPWR.n24 VPWR.n6 72.7879
R496 VPWR.n20 VPWR.n19 72.7879
R497 VPWR.n16 VPWR.n12 72.7879
R498 VPWR.n16 VPWR.n15 72.7879
R499 VPWR.n19 VPWR.n11 72.7879
R500 VPWR.n27 VPWR.n26 72.7879
R501 VPWR.n25 VPWR.n24 72.7879
R502 VPWR.n100 VPWR.n83 72.7879
R503 VPWR.n98 VPWR.n80 72.7879
R504 VPWR.n94 VPWR.n93 72.7879
R505 VPWR.n90 VPWR.n86 72.7879
R506 VPWR.n90 VPWR.n89 72.7879
R507 VPWR.n93 VPWR.n85 72.7879
R508 VPWR.n101 VPWR.n100 72.7879
R509 VPWR.n99 VPWR.n98 72.7879
R510 VPWR.n54 VPWR.t4 56.8667
R511 VPWR.n69 VPWR.t4 56.8667
R512 VPWR.n17 VPWR.t0 56.8667
R513 VPWR.n32 VPWR.t0 56.8667
R514 VPWR.n91 VPWR.t2 56.8667
R515 VPWR.n106 VPWR.t2 56.8667
R516 VPWR.n55 VPWR.n53 56.1076
R517 VPWR.n56 VPWR.n55 56.1076
R518 VPWR.n63 VPWR.n44 56.1076
R519 VPWR.n61 VPWR.n44 56.1076
R520 VPWR.n18 VPWR.n16 56.1076
R521 VPWR.n19 VPWR.n18 56.1076
R522 VPWR.n26 VPWR.n7 56.1076
R523 VPWR.n24 VPWR.n7 56.1076
R524 VPWR.n92 VPWR.n90 56.1076
R525 VPWR.n93 VPWR.n92 56.1076
R526 VPWR.n100 VPWR.n81 56.1076
R527 VPWR.n98 VPWR.n81 56.1076
R528 VPWR.n58 VPWR.n47 25.6005
R529 VPWR.n50 VPWR.n47 25.6005
R530 VPWR.n51 VPWR.n50 25.6005
R531 VPWR.n67 VPWR.n59 25.6005
R532 VPWR.n66 VPWR.n65 25.6005
R533 VPWR.n65 VPWR.n60 25.6005
R534 VPWR.n60 VPWR.n41 25.6005
R535 VPWR.n21 VPWR.n10 25.6005
R536 VPWR.n13 VPWR.n10 25.6005
R537 VPWR.n14 VPWR.n13 25.6005
R538 VPWR.n30 VPWR.n22 25.6005
R539 VPWR.n29 VPWR.n28 25.6005
R540 VPWR.n28 VPWR.n23 25.6005
R541 VPWR.n23 VPWR.n4 25.6005
R542 VPWR.n95 VPWR.n84 25.6005
R543 VPWR.n87 VPWR.n84 25.6005
R544 VPWR.n88 VPWR.n87 25.6005
R545 VPWR.n104 VPWR.n96 25.6005
R546 VPWR.n103 VPWR.n102 25.6005
R547 VPWR.n102 VPWR.n97 25.6005
R548 VPWR.n97 VPWR.n78 25.6005
R549 VPWR.n72 VPWR 18.865
R550 VPWR.n35 VPWR 18.865
R551 VPWR.n109 VPWR 18.865
R552 VPWR VPWR.n73 12.8005
R553 VPWR.n74 VPWR 12.8005
R554 VPWR VPWR.n36 12.8005
R555 VPWR.n37 VPWR 12.8005
R556 VPWR VPWR.n40 12.8005
R557 VPWR VPWR.n71 12.8005
R558 VPWR VPWR.n0 12.8005
R559 VPWR.n1 VPWR 12.8005
R560 VPWR VPWR.n3 12.8005
R561 VPWR VPWR.n34 12.8005
R562 VPWR VPWR.n77 12.8005
R563 VPWR VPWR.n108 12.8005
R564 VPWR.n35 VPWR.n2 10.6503
R565 VPWR.n76 VPWR.n75 10.5563
R566 VPWR.n39 VPWR.n38 10.5563
R567 VPWR.n75 VPWR.n73 10.1513
R568 VPWR.n75 VPWR.n74 10.1513
R569 VPWR.n38 VPWR.n36 10.1513
R570 VPWR.n38 VPWR.n37 10.1513
R571 VPWR.n2 VPWR.n0 10.1513
R572 VPWR.n2 VPWR.n1 10.1513
R573 VPWR VPWR.n109 4.32348
R574 VPWR.n39 VPWR.n35 1.01178
R575 VPWR.n76 VPWR.n72 1.01178
R576 VPWR.n72 VPWR.n39 0.0945
R577 VPWR.n109 VPWR.n76 0.0945
R578 ANALOG_OUT.t0 ANALOG_OUT.n0 255.345
R579 ANALOG_OUT.n1 ANALOG_OUT.t0 255.345
R580 ANALOG_OUT ANALOG_OUT.n2 20.2203
R581 ANALOG_OUT ANALOG_OUT.n0 12.8005
R582 ANALOG_OUT.n1 ANALOG_OUT 12.8005
R583 ANALOG_OUT.n2 ANALOG_OUT.n0 10.1513
R584 ANALOG_OUT.n2 ANALOG_OUT.n1 10.1513
C15 ANALOG_OUT VGND 8.03661f
C16 DIGITAL_OUT VGND 8.85832f
C17 IN VGND 2.35556f
C18 VPWR VGND 10.1461f
C19 DIGITAL__OUT_y_0__N VGND 4.22014f $ **FLOATING
C20 DIGITAL__N_3 VGND 3.84951f $ **FLOATING
C21 ANALOG_OUT.n0 VGND 0.01355f $ **FLOATING
C22 ANALOG_OUT.t0 VGND 0.03295f $ **FLOATING
C23 ANALOG_OUT.n1 VGND 0.01355f $ **FLOATING
C24 ANALOG_OUT.n2 VGND 3.07303f $ **FLOATING
C25 DIGITAL_OUT.t4 VGND 0.02013f $ **FLOATING
C26 DIGITAL_OUT.t0 VGND 0.02013f $ **FLOATING
C27 DIGITAL_OUT.n0 VGND 0.99053f $ **FLOATING
C28 DIGITAL_OUT.n1 VGND 0.00557f $ **FLOATING
C29 DIGITAL_OUT.t1 VGND 0.01353f $ **FLOATING
C30 DIGITAL_OUT.n2 VGND 0.00557f $ **FLOATING
C31 DIGITAL_OUT.n3 VGND 0.15919f $ **FLOATING
C32 DIGITAL_OUT.n4 VGND 0.44421f $ **FLOATING
C33 DIGITAL_OUT.n5 VGND 0.00557f $ **FLOATING
C34 DIGITAL_OUT.t2 VGND 0.01353f $ **FLOATING
C35 DIGITAL_OUT.n6 VGND 0.00557f $ **FLOATING
C36 DIGITAL_OUT.n7 VGND 0.15919f $ **FLOATING
C37 DIGITAL_OUT.n8 VGND 0.55332f $ **FLOATING
C38 DIGITAL_OUT.n9 VGND 0.00487f $ **FLOATING
C39 DIGITAL_OUT.t3 VGND 0.01492f $ **FLOATING
C40 DIGITAL_OUT.n10 VGND 0.00487f $ **FLOATING
C41 DIGITAL_OUT.n11 VGND 0.15919f $ **FLOATING
C42 DIGITAL_OUT.n12 VGND 1.97038f $ **FLOATING
C43 DIGITAL__OUT_y_0__N.n0 VGND 0.0103f $ **FLOATING
C44 DIGITAL__OUT_y_0__N.t2 VGND 0.03726f $ **FLOATING
C45 DIGITAL__OUT_y_0__N.t3 VGND 0.03872f $ **FLOATING
C46 DIGITAL__OUT_y_0__N.n1 VGND 1.95768f $ **FLOATING
C47 DIGITAL__OUT_y_0__N.n2 VGND 0.00902f $ **FLOATING
C48 DIGITAL__OUT_y_0__N.t1 VGND 0.02762f $ **FLOATING
C49 DIGITAL__OUT_y_0__N.n3 VGND 0.00902f $ **FLOATING
C50 DIGITAL__OUT_y_0__N.n4 VGND 0.36548f $ **FLOATING
C51 DIGITAL__OUT_y_0__N.n5 VGND 3.74156f $ **FLOATING
C52 DIGITAL__OUT_y_0__N.n6 VGND 0.23103f $ **FLOATING
C53 DIGITAL__OUT_y_0__N.t0 VGND 0.02505f $ **FLOATING
C54 DIGITAL__OUT_y_0__N.n7 VGND 0.0103f $ **FLOATING
C55 DIGITAL__N_3.n0 VGND 0.00629f $ **FLOATING
C56 DIGITAL__N_3.t2 VGND 0.02274f $ **FLOATING
C57 DIGITAL__N_3.t3 VGND 0.02363f $ **FLOATING
C58 DIGITAL__N_3.n1 VGND 1.1229f $ **FLOATING
C59 DIGITAL__N_3.n2 VGND 0.0055f $ **FLOATING
C60 DIGITAL__N_3.t1 VGND 0.01686f $ **FLOATING
C61 DIGITAL__N_3.n3 VGND 0.0055f $ **FLOATING
C62 DIGITAL__N_3.n4 VGND 0.16497f $ **FLOATING
C63 DIGITAL__N_3.n5 VGND 1.4596f $ **FLOATING
C64 DIGITAL__N_3.n6 VGND 0.1219f $ **FLOATING
C65 DIGITAL__N_3.t0 VGND 0.01529f $ **FLOATING
C66 DIGITAL__N_3.n7 VGND 0.00629f $ **FLOATING
.ends

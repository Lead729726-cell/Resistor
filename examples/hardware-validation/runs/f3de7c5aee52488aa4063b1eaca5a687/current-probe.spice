.subckt logic_inv a y VPWR VGND ANALOG_OUT
VHDLDRV_GND register_cf_node_c472a0816faf869a 0 0
Vregister_cf_c472a0816faf869a VGND register_cf_node_c472a0816faf869a 0
VHDLDRV_a register_cf_node_9706ba7feaa11335 VGND DC 0 PWL(0 0 5e-08 0 5.1e-08 1.8 1e-07 1.8 1.01e-07 0 1.5e-07 0 1.51e-07 1.8 2e-07 1.8 2.01e-07 0 2.5e-07 0 2.51e-07 1.8 3e-07 1.8 3.01e-07 0 3.5e-07 0 3.51e-07 1.8 4.5e-07 1.8)
Vregister_cf_9706ba7feaa11335 a register_cf_node_9706ba7feaa11335 0
VHDLDRV_VDD register_cf_node_09077c8c982fbb41 0 1.8
Vregister_cf_09077c8c982fbb41 VPWR register_cf_node_09077c8c982fbb41 0
CHDLDRV_RC_C register_cf_node_9b38a28a0461bce0 VGND 1e-12
Vregister_cf_9b38a28a0461bce0 ANALOG_OUT register_cf_node_9b38a28a0461bce0 0
XG0_MN register_cf_node_59fabd8349c1c1d6 a register_cf_node_59fabd8349c1c1d6_source VGND sky130_fd_pr__nfet_01v8 w=0.65 l=0.15 nf=1 m=1
Vregister_cf_59fabd8349c1c1d6 N_3 register_cf_node_59fabd8349c1c1d6 0
Vregister_cf_59fabd8349c1c1d6_source VGND register_cf_node_59fabd8349c1c1d6_source 0
XG0_MP register_cf_node_5ed65c4aa7499b5b a register_cf_node_5ed65c4aa7499b5b_source VPWR sky130_fd_pr__pfet_01v8_hvt w=0.65 l=0.15 nf=1 m=1
Vregister_cf_5ed65c4aa7499b5b N_3 register_cf_node_5ed65c4aa7499b5b 0
Vregister_cf_5ed65c4aa7499b5b_source VPWR register_cf_node_5ed65c4aa7499b5b_source 0
XOUT_y_0_I0_MN register_cf_node_00a1d2e98e637c0f N_3 register_cf_node_00a1d2e98e637c0f_source VGND sky130_fd_pr__nfet_01v8 w=0.65 l=0.15 nf=1 m=1
Vregister_cf_00a1d2e98e637c0f OUT_y_0__N register_cf_node_00a1d2e98e637c0f 0
Vregister_cf_00a1d2e98e637c0f_source VGND register_cf_node_00a1d2e98e637c0f_source 0
XOUT_y_0_I0_MP register_cf_node_9cbf603810715f1f N_3 register_cf_node_9cbf603810715f1f_source VPWR sky130_fd_pr__pfet_01v8_hvt w=0.65 l=0.15 nf=1 m=1
Vregister_cf_9cbf603810715f1f OUT_y_0__N register_cf_node_9cbf603810715f1f 0
Vregister_cf_9cbf603810715f1f_source VPWR register_cf_node_9cbf603810715f1f_source 0
XOUT_y_0_I1_MN register_cf_node_de0326797105363c OUT_y_0__N register_cf_node_de0326797105363c_source VGND sky130_fd_pr__nfet_01v8 w=0.65 l=0.15 nf=1 m=1
Vregister_cf_de0326797105363c y register_cf_node_de0326797105363c 0
Vregister_cf_de0326797105363c_source VGND register_cf_node_de0326797105363c_source 0
XOUT_y_0_I1_MP register_cf_node_455e42f8c4345c1c OUT_y_0__N register_cf_node_455e42f8c4345c1c_source VPWR sky130_fd_pr__pfet_01v8_hvt w=0.65 l=0.15 nf=1 m=1
Vregister_cf_455e42f8c4345c1c y register_cf_node_455e42f8c4345c1c 0
Vregister_cf_455e42f8c4345c1c_source VPWR register_cf_node_455e42f8c4345c1c_source 0
RHDLDRV_RC_R register_cf_node_ead3af34e14d53f6 ANALOG_OUT 1000
Vregister_cf_ead3af34e14d53f6 y register_cf_node_ead3af34e14d53f6 0
.ends logic_inv

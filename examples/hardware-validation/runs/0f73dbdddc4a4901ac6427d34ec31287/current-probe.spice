* NGSPICE file created from logic_inv.ext - technology: sky130A

.subckt logic_inv ANALOG_OUT VGND VPWR a y
X0 ANALOG_OUT VGND.t0 sky130_fd_pr__cap_mim_m3_1 l=22.17 w=22.17
X1 register_cf_node_6dac4b325cb22528 a.t0 register_cf_node_6dac4b325cb22528_source VGND.t1 sky130_fd_pr__nfet_01v8 ad=0.1885 pd=1.88 as=0.1885 ps=1.88 w=0.65 l=0.15
Vregister_cf_6dac4b325cb22528 VGND.t2 register_cf_node_6dac4b325cb22528 0
Vregister_cf_6dac4b325cb22528_source N_3.t1 register_cf_node_6dac4b325cb22528_source 0
X2 register_cf_node_e25bdb194a664265 N_3.t2 register_cf_node_e25bdb194a664265_source VGND.t3 sky130_fd_pr__nfet_01v8 ad=0.1885 pd=1.88 as=0.1885 ps=1.88 w=0.65 l=0.15
Vregister_cf_e25bdb194a664265 VGND.t4 register_cf_node_e25bdb194a664265 0
Vregister_cf_e25bdb194a664265_source OUT_y_0__N.t1 register_cf_node_e25bdb194a664265_source 0
X3 register_cf_node_19e8bb0acab9d6a2 OUT_y_0__N.t2 register_cf_node_19e8bb0acab9d6a2_source VGND.t6 sky130_fd_pr__nfet_01v8 ad=0.1885 pd=1.88 as=0.1885 ps=1.88 w=0.65 l=0.15
Vregister_cf_19e8bb0acab9d6a2 VGND.t7 register_cf_node_19e8bb0acab9d6a2 0
Vregister_cf_19e8bb0acab9d6a2_source y.t2 register_cf_node_19e8bb0acab9d6a2_source 0
X4 register_cf_node_aae200cba371e86d OUT_y_0__N.t3 register_cf_node_aae200cba371e86d_source VPWR.t2 sky130_fd_pr__pfet_01v8_hvt ad=0.1885 pd=1.88 as=0.1885 ps=1.88 w=0.65 l=0.15
Vregister_cf_aae200cba371e86d VPWR.t3 register_cf_node_aae200cba371e86d 0
Vregister_cf_aae200cba371e86d_source y.t1 register_cf_node_aae200cba371e86d_source 0
X5 register_cf_node_22d5bbc1cca43256 a.t1 register_cf_node_22d5bbc1cca43256_source VPWR.t4 sky130_fd_pr__pfet_01v8_hvt ad=0.1885 pd=1.88 as=0.1885 ps=1.88 w=0.65 l=0.15
Vregister_cf_22d5bbc1cca43256 VPWR.t5 register_cf_node_22d5bbc1cca43256 0
Vregister_cf_22d5bbc1cca43256_source N_3.t0 register_cf_node_22d5bbc1cca43256_source 0
X6 y.t0 ANALOG_OUT VGND.t5 sky130_fd_pr__res_xhigh_po_1p41 l=0.54
X7 register_cf_node_a5b0d3e1c66956a5 N_3.t3 register_cf_node_a5b0d3e1c66956a5_source VPWR.t0 sky130_fd_pr__pfet_01v8_hvt ad=0.1885 pd=1.88 as=0.1885 ps=1.88 w=0.65 l=0.15
Vregister_cf_a5b0d3e1c66956a5 VPWR.t1 register_cf_node_a5b0d3e1c66956a5 0
Vregister_cf_a5b0d3e1c66956a5_source OUT_y_0__N.t0 register_cf_node_a5b0d3e1c66956a5_source 0
C0 N_3 VPWR 3.19775f
C1 VPWR a 1.92848f
C2 OUT_y_0__N VPWR 3.52719f
C3 ANALOG_OUT N_3 0.02676f
C4 ANALOG_OUT a 0
C5 ANALOG_OUT OUT_y_0__N 0.15312f
C6 VPWR y 1.61017f
C7 ANALOG_OUT y 3.92215f
C8 ANALOG_OUT VPWR 0.51426f
C9 N_3 a 1.77751f
C10 N_3 OUT_y_0__N 3.06457f
C11 OUT_y_0__N a 0.17801f
C12 N_3 y 0.19444f
C13 y a 0.00116f
C14 OUT_y_0__N y 3.99622f
R0 VGND.n195 VGND.n194 6541
R1 VGND.n195 VGND.n17 3004.31
R2 VGND.n194 VGND.n9 1923.17
R3 VGND.n193 VGND.n18 1923.17
R4 VGND.n192 VGND.n17 1726.78
R5 VGND.n179 VGND.n169 1315.26
R6 VGND.n189 VGND.n22 1315.26
R7 VGND.n181 VGND.n25 1315.26
R8 VGND.n183 VGND.n182 1315.26
R9 VGND.n197 VGND.n13 1315.26
R10 VGND.n199 VGND.n15 1315.26
R11 VGND.n210 VGND.n11 1315.26
R12 VGND.n213 VGND.n212 1315.26
R13 VGND.n98 VGND.n93 1315.26
R14 VGND.n100 VGND.n95 1315.26
R15 VGND.n111 VGND.n91 1315.26
R16 VGND.n114 VGND.n113 1315.26
R17 VGND.n55 VGND.n43 1205.18
R18 VGND.n165 VGND.n36 1205.18
R19 VGND.n138 VGND.n137 1205.18
R20 VGND.n82 VGND.n45 1205.18
R21 VGND.n194 VGND.n193 941.106
R22 VGND.n193 VGND.n192 941.106
R23 VGND.n168 VGND.n167 714.654
R24 VGND.n192 VGND.n191 686.965
R25 VGND.n201 VGND.n15 585
R26 VGND.n15 VGND.n14 585
R27 VGND.n204 VGND.n203 585
R28 VGND.n205 VGND.n204 585
R29 VGND.n202 VGND.n7 585
R30 VGND.n8 VGND.n7 585
R31 VGND.n212 VGND.n5 585
R32 VGND.n212 VGND.n211 585
R33 VGND.n214 VGND.n213 585
R34 VGND.n11 VGND.n4 585
R35 VGND.n210 VGND.n209 585
R36 VGND.n211 VGND.n210 585
R37 VGND.n208 VGND.n10 585
R38 VGND.n10 VGND.n8 585
R39 VGND.n207 VGND.n206 585
R40 VGND.n206 VGND.n205 585
R41 VGND.n13 VGND.n12 585
R42 VGND.n14 VGND.n13 585
R43 VGND.n197 VGND.n16 585
R44 VGND.n200 VGND.n199 585
R45 VGND.n102 VGND.n95 585
R46 VGND.n95 VGND.n94 585
R47 VGND.n105 VGND.n104 585
R48 VGND.n106 VGND.n105 585
R49 VGND.n103 VGND.n88 585
R50 VGND.n89 VGND.n88 585
R51 VGND.n113 VGND.n86 585
R52 VGND.n113 VGND.n112 585
R53 VGND.n115 VGND.n114 585
R54 VGND.n91 VGND.n85 585
R55 VGND.n111 VGND.n110 585
R56 VGND.n112 VGND.n111 585
R57 VGND.n109 VGND.n90 585
R58 VGND.n90 VGND.n89 585
R59 VGND.n108 VGND.n107 585
R60 VGND.n107 VGND.n106 585
R61 VGND.n93 VGND.n92 585
R62 VGND.n94 VGND.n93 585
R63 VGND.n98 VGND.n96 585
R64 VGND.n101 VGND.n100 585
R65 VGND.n189 VGND.n188 585
R66 VGND.n187 VGND.n21 585
R67 VGND.n186 VGND.n185 585
R68 VGND.n184 VGND.n183 585
R69 VGND.n182 VGND.n24 585
R70 VGND.n182 VGND.n19 585
R71 VGND.n181 VGND.n26 585
R72 VGND.n181 VGND.n180 585
R73 VGND.n170 VGND.n25 585
R74 VGND.n174 VGND.n171 585
R75 VGND.n176 VGND.n175 585
R76 VGND.n177 VGND.n169 585
R77 VGND.n179 VGND.n178 585
R78 VGND.n180 VGND.n179 585
R79 VGND.n23 VGND.n22 585
R80 VGND.n22 VGND.n19 585
R81 VGND.n83 VGND.n82 585
R82 VGND.n82 VGND.n81 585
R83 VGND.n47 VGND.n46 585
R84 VGND.n79 VGND.n78 585
R85 VGND.n77 VGND.n54 585
R86 VGND.n76 VGND.n75 585
R87 VGND.n74 VGND.n73 585
R88 VGND.n72 VGND.n71 585
R89 VGND.n70 VGND.n69 585
R90 VGND.n68 VGND.n67 585
R91 VGND.n66 VGND.n65 585
R92 VGND.n64 VGND.n63 585
R93 VGND.n62 VGND.n61 585
R94 VGND.n60 VGND.n59 585
R95 VGND.n58 VGND.n57 585
R96 VGND.n56 VGND.n55 585
R97 VGND.n43 VGND.n42 585
R98 VGND.n44 VGND.n43 585
R99 VGND.n131 VGND.n130 585
R100 VGND.n130 VGND.n129 585
R101 VGND.n132 VGND.n41 585
R102 VGND.n41 VGND.t5 585
R103 VGND.n134 VGND.n133 585
R104 VGND.n135 VGND.n134 585
R105 VGND.n37 VGND.n36 585
R106 VGND.n36 VGND.n27 585
R107 VGND.n165 VGND.n164 585
R108 VGND.n163 VGND.n35 585
R109 VGND.n162 VGND.n34 585
R110 VGND.n167 VGND.n34 585
R111 VGND.n161 VGND.n160 585
R112 VGND.n159 VGND.n158 585
R113 VGND.n157 VGND.n156 585
R114 VGND.n155 VGND.n154 585
R115 VGND.n153 VGND.n152 585
R116 VGND.n151 VGND.n150 585
R117 VGND.n149 VGND.n148 585
R118 VGND.n147 VGND.n146 585
R119 VGND.n145 VGND.n144 585
R120 VGND.n143 VGND.n142 585
R121 VGND.n141 VGND.n140 585
R122 VGND.n139 VGND.n138 585
R123 VGND.n137 VGND.n38 585
R124 VGND.n137 VGND.n27 585
R125 VGND.n136 VGND.n40 585
R126 VGND.n136 VGND.n135 585
R127 VGND VGND.n39 585
R128 VGND.t5 VGND.n39 585
R129 VGND.n128 VGND.n127 585
R130 VGND.n129 VGND.n128 585
R131 VGND.n84 VGND.n45 585
R132 VGND.n45 VGND.n44 585
R133 VGND.n179 VGND.n22 394
R134 VGND.n175 VGND.n174 394
R135 VGND.n182 VGND.n181 394
R136 VGND.n185 VGND.n21 394
R137 VGND.n206 VGND.n13 394
R138 VGND.n206 VGND.n10 394
R139 VGND.n210 VGND.n10 394
R140 VGND.n204 VGND.n15 394
R141 VGND.n204 VGND.n7 394
R142 VGND.n212 VGND.n7 394
R143 VGND.n107 VGND.n93 394
R144 VGND.n107 VGND.n90 394
R145 VGND.n111 VGND.n90 394
R146 VGND.n105 VGND.n95 394
R147 VGND.n105 VGND.n88 394
R148 VGND.n113 VGND.n88 394
R149 VGND.n130 VGND.n43 394
R150 VGND.n130 VGND.n41 394
R151 VGND.n134 VGND.n41 394
R152 VGND.n134 VGND.n36 394
R153 VGND.n35 VGND.n34 394
R154 VGND.n160 VGND.n34 394
R155 VGND.n158 VGND.n157 394
R156 VGND.n154 VGND.n153 394
R157 VGND.n150 VGND.n149 394
R158 VGND.n146 VGND.n145 394
R159 VGND.n142 VGND.n141 394
R160 VGND.n128 VGND.n45 394
R161 VGND.n128 VGND.n39 394
R162 VGND.n136 VGND.n39 394
R163 VGND.n137 VGND.n136 394
R164 VGND.n59 VGND.n58 394
R165 VGND.n63 VGND.n62 394
R166 VGND.n67 VGND.n66 394
R167 VGND.n71 VGND.n70 394
R168 VGND.n75 VGND.n74 394
R169 VGND.n79 VGND.n54 394
R170 VGND.n82 VGND.n47 394
R171 VGND.t7 VGND.n122 255.345
R172 VGND.n123 VGND.t7 255.345
R173 VGND.t2 VGND.n0 255.345
R174 VGND.n1 VGND.t2 255.345
R175 VGND.t4 VGND.n117 255.345
R176 VGND.n118 VGND.t4 255.345
R177 VGND.n196 VGND.n14 220
R178 VGND.n211 VGND.n9 220
R179 VGND.n97 VGND.n94 220
R180 VGND.n112 VGND.n18 220
R181 VGND.n9 VGND.n6 218.815
R182 VGND.n198 VGND.n196 218.815
R183 VGND.n87 VGND.n18 218.815
R184 VGND.n99 VGND.n97 218.815
R185 VGND.n191 VGND.n190 218.815
R186 VGND.n191 VGND.n20 218.815
R187 VGND.n173 VGND.n168 218.815
R188 VGND.n172 VGND.n168 218.815
R189 VGND.n81 VGND.n80 218.815
R190 VGND.n81 VGND.n53 218.815
R191 VGND.n81 VGND.n52 218.815
R192 VGND.n81 VGND.n51 218.815
R193 VGND.n81 VGND.n50 218.815
R194 VGND.n81 VGND.n49 218.815
R195 VGND.n81 VGND.n48 218.815
R196 VGND.n167 VGND.n166 218.815
R197 VGND.n167 VGND.n28 218.815
R198 VGND.n167 VGND.n29 218.815
R199 VGND.n167 VGND.n30 218.815
R200 VGND.n167 VGND.n31 218.815
R201 VGND.n167 VGND.n32 218.815
R202 VGND.n167 VGND.n33 218.815
R203 VGND.n175 VGND.n172 147.374
R204 VGND.n173 VGND.n25 147.374
R205 VGND.n190 VGND.n189 147.374
R206 VGND.n183 VGND.n20 147.374
R207 VGND.n198 VGND.n197 147.374
R208 VGND.n213 VGND.n6 147.374
R209 VGND.n11 VGND.n6 147.374
R210 VGND.n199 VGND.n198 147.374
R211 VGND.n99 VGND.n98 147.374
R212 VGND.n114 VGND.n87 147.374
R213 VGND.n91 VGND.n87 147.374
R214 VGND.n100 VGND.n99 147.374
R215 VGND.n190 VGND.n21 147.374
R216 VGND.n185 VGND.n20 147.374
R217 VGND.n174 VGND.n173 147.374
R218 VGND.n172 VGND.n169 147.374
R219 VGND.n166 VGND.n165 147.374
R220 VGND.n160 VGND.n28 147.374
R221 VGND.n157 VGND.n29 147.374
R222 VGND.n153 VGND.n30 147.374
R223 VGND.n149 VGND.n31 147.374
R224 VGND.n145 VGND.n32 147.374
R225 VGND.n141 VGND.n33 147.374
R226 VGND.n55 VGND.n48 147.374
R227 VGND.n59 VGND.n49 147.374
R228 VGND.n63 VGND.n50 147.374
R229 VGND.n67 VGND.n51 147.374
R230 VGND.n71 VGND.n52 147.374
R231 VGND.n75 VGND.n53 147.374
R232 VGND.n80 VGND.n79 147.374
R233 VGND.n80 VGND.n47 147.374
R234 VGND.n54 VGND.n53 147.374
R235 VGND.n74 VGND.n52 147.374
R236 VGND.n70 VGND.n51 147.374
R237 VGND.n66 VGND.n50 147.374
R238 VGND.n62 VGND.n49 147.374
R239 VGND.n58 VGND.n48 147.374
R240 VGND.n166 VGND.n35 147.374
R241 VGND.n158 VGND.n28 147.374
R242 VGND.n154 VGND.n29 147.374
R243 VGND.n150 VGND.n30 147.374
R244 VGND.n146 VGND.n31 147.374
R245 VGND.n142 VGND.n32 147.374
R246 VGND.n138 VGND.n33 147.374
R247 VGND.n205 VGND.n14 124.668
R248 VGND.n211 VGND.n8 124.668
R249 VGND.n106 VGND.n94 124.668
R250 VGND.n112 VGND.n89 124.668
R251 VGND.n196 VGND.n195 113.668
R252 VGND.n97 VGND.n17 113.668
R253 VGND.n178 VGND.n177 85.4593
R254 VGND.n188 VGND.n23 85.4593
R255 VGND.n170 VGND.n26 85.4593
R256 VGND.n184 VGND.n24 85.4593
R257 VGND.n16 VGND.n12 85.4593
R258 VGND.n201 VGND.n200 85.4593
R259 VGND.n209 VGND.n4 85.4593
R260 VGND.n214 VGND.n5 85.4593
R261 VGND.n96 VGND.n92 85.4593
R262 VGND.n102 VGND.n101 85.4593
R263 VGND.n110 VGND.n85 85.4593
R264 VGND.n115 VGND.n86 85.4593
R265 VGND.n180 VGND.n168 81.7506
R266 VGND.n191 VGND.n19 81.7506
R267 VGND.n56 VGND.n42 78.3064
R268 VGND.n84 VGND.n83 78.3064
R269 VGND.n164 VGND.n37 78.3064
R270 VGND.n139 VGND.n38 78.3064
R271 VGND.n81 VGND.n44 77.7949
R272 VGND.n167 VGND.n27 77.7949
R273 VGND.n205 VGND.t1 62.3338
R274 VGND.t1 VGND.n8 62.3338
R275 VGND.n106 VGND.t3 62.3338
R276 VGND.t3 VGND.n89 62.3338
R277 VGND.n129 VGND.n44 44.8312
R278 VGND.n129 VGND.t5 44.8312
R279 VGND.n135 VGND.t5 44.8312
R280 VGND.n135 VGND.n27 44.8312
R281 VGND.n178 VGND.n23 25.6005
R282 VGND.n177 VGND.n176 25.6005
R283 VGND.n176 VGND.n171 25.6005
R284 VGND.n171 VGND.n170 25.6005
R285 VGND.n188 VGND.n187 25.6005
R286 VGND.n187 VGND.n186 25.6005
R287 VGND.n186 VGND.n184 25.6005
R288 VGND.n200 VGND.n16 25.6005
R289 VGND.n207 VGND.n12 25.6005
R290 VGND.n208 VGND.n207 25.6005
R291 VGND.n209 VGND.n208 25.6005
R292 VGND.n203 VGND.n201 25.6005
R293 VGND.n203 VGND.n202 25.6005
R294 VGND.n202 VGND.n5 25.6005
R295 VGND.n101 VGND.n96 25.6005
R296 VGND.n108 VGND.n92 25.6005
R297 VGND.n109 VGND.n108 25.6005
R298 VGND.n110 VGND.n109 25.6005
R299 VGND.n104 VGND.n102 25.6005
R300 VGND.n104 VGND.n103 25.6005
R301 VGND.n103 VGND.n86 25.6005
R302 VGND.n57 VGND.n56 25.6005
R303 VGND.n60 VGND.n57 25.6005
R304 VGND.n61 VGND.n60 25.6005
R305 VGND.n64 VGND.n61 25.6005
R306 VGND.n65 VGND.n64 25.6005
R307 VGND.n68 VGND.n65 25.6005
R308 VGND.n69 VGND.n68 25.6005
R309 VGND.n72 VGND.n69 25.6005
R310 VGND.n73 VGND.n72 25.6005
R311 VGND.n76 VGND.n73 25.6005
R312 VGND.n77 VGND.n76 25.6005
R313 VGND.n78 VGND.n77 25.6005
R314 VGND.n78 VGND.n46 25.6005
R315 VGND.n83 VGND.n46 25.6005
R316 VGND.n131 VGND.n42 25.6005
R317 VGND.n132 VGND.n131 25.6005
R318 VGND.n133 VGND.n132 25.6005
R319 VGND.n133 VGND.n37 25.6005
R320 VGND.n164 VGND.n163 25.6005
R321 VGND.n163 VGND.n162 25.6005
R322 VGND.n162 VGND.n161 25.6005
R323 VGND.n161 VGND.n159 25.6005
R324 VGND.n159 VGND.n156 25.6005
R325 VGND.n156 VGND.n155 25.6005
R326 VGND.n155 VGND.n152 25.6005
R327 VGND.n152 VGND.n151 25.6005
R328 VGND.n151 VGND.n148 25.6005
R329 VGND.n148 VGND.n147 25.6005
R330 VGND.n147 VGND.n144 25.6005
R331 VGND.n144 VGND.n143 25.6005
R332 VGND.n143 VGND.n140 25.6005
R333 VGND.n140 VGND.n139 25.6005
R334 VGND.n127 VGND.n84 25.6005
R335 VGND.n127 VGND 25.6005
R336 VGND VGND.n40 25.6005
R337 VGND.n40 VGND.n38 25.6005
R338 VGND VGND.n126 25.2661
R339 VGND.n121 VGND 24.6393
R340 VGND.n116 VGND 24.6393
R341 VGND.n215 VGND 24.6393
R342 VGND.n180 VGND.t6 22.4158
R343 VGND.t6 VGND.n19 22.4158
R344 VGND.n3 VGND.n2 15.5441
R345 VGND.n120 VGND.n119 15.5441
R346 VGND.n125 VGND.n124 15.5441
R347 VGND VGND.n0 12.8005
R348 VGND.n1 VGND 12.8005
R349 VGND VGND.n117 12.8005
R350 VGND.n118 VGND 12.8005
R351 VGND VGND.n26 12.8005
R352 VGND VGND.n24 12.8005
R353 VGND VGND.n4 12.8005
R354 VGND VGND.n214 12.8005
R355 VGND VGND.n85 12.8005
R356 VGND VGND.n115 12.8005
R357 VGND VGND.n122 12.8005
R358 VGND.n123 VGND 12.8005
R359 VGND.n2 VGND.n0 10.1513
R360 VGND.n2 VGND.n1 10.1513
R361 VGND.n119 VGND.n117 10.1513
R362 VGND.n119 VGND.n118 10.1513
R363 VGND.n124 VGND.n122 10.1513
R364 VGND.n124 VGND.n123 10.1513
R365 VGND.n126 VGND.t0 7.04578
R366 VGND VGND.n215 5.29912
R367 VGND.n121 VGND.n120 1.01178
R368 VGND.n116 VGND.n3 1.01178
R369 VGND.n126 VGND.n125 0.492433
R370 VGND.n125 VGND.n121 0.0945
R371 VGND.n120 VGND.n116 0.0945
R372 VGND.n215 VGND.n3 0.0945
R373 a a.t1 330.341
R374 a a.t0 315.88
R375 a.n0 a 33.3607
R376 a.n0 a 32.7924
R377 a a.n0 4.60704
R378 N_3.t0 N_3.n0 700.484
R379 N_3.n7 N_3.t0 700.484
R380 N_3 N_3.t3 330.341
R381 N_3 N_3.t2 315.88
R382 N_3.t1 N_3.n2 255.345
R383 N_3.n3 N_3.t1 255.345
R384 N_3.n1 N_3 33.7773
R385 N_3.n1 N_3 33.2091
R386 N_3.n6 N_3.n5 14.4301
R387 N_3.n5 N_3.n4 13.8775
R388 N_3 N_3.n2 12.8005
R389 N_3.n3 N_3 12.8005
R390 N_3 N_3.n0 12.8005
R391 N_3 N_3.n7 12.8005
R392 N_3.n4 N_3.n2 10.1513
R393 N_3.n4 N_3.n3 10.1513
R394 N_3.n6 N_3.n0 10.1513
R395 N_3.n7 N_3.n6 10.1513
R396 N_3.n5 N_3.n1 0.789708
R397 OUT_y_0__N.t0 OUT_y_0__N.n0 700.484
R398 OUT_y_0__N.n7 OUT_y_0__N.t0 700.484
R399 OUT_y_0__N OUT_y_0__N.t3 330.341
R400 OUT_y_0__N OUT_y_0__N.t2 315.88
R401 OUT_y_0__N.t1 OUT_y_0__N.n2 255.345
R402 OUT_y_0__N.n3 OUT_y_0__N.t1 255.345
R403 OUT_y_0__N.n1 OUT_y_0__N 34.194
R404 OUT_y_0__N.n1 OUT_y_0__N 33.6257
R405 OUT_y_0__N.n6 OUT_y_0__N.n5 14.8468
R406 OUT_y_0__N.n5 OUT_y_0__N.n4 14.2941
R407 OUT_y_0__N OUT_y_0__N.n2 12.8005
R408 OUT_y_0__N.n3 OUT_y_0__N 12.8005
R409 OUT_y_0__N OUT_y_0__N.n0 12.8005
R410 OUT_y_0__N OUT_y_0__N.n7 12.8005
R411 OUT_y_0__N.n4 OUT_y_0__N.n2 10.1513
R412 OUT_y_0__N.n4 OUT_y_0__N.n3 10.1513
R413 OUT_y_0__N.n6 OUT_y_0__N.n0 10.1513
R414 OUT_y_0__N.n7 OUT_y_0__N.n6 10.1513
R415 OUT_y_0__N.n5 OUT_y_0__N.n1 0.789708
R416 y.t1 y.n4 700.484
R417 y.n5 y.t1 700.484
R418 y.t2 y.n0 255.345
R419 y.n1 y.t2 255.345
R420 y.n3 y.t0 24.8952
R421 y.n3 y.n2 14.7108
R422 y.n7 y.n6 14.7108
R423 y y.n0 12.8005
R424 y.n1 y 12.8005
R425 y y.n4 12.8005
R426 y.n5 y 12.8005
R427 y.n2 y.n0 10.1513
R428 y.n2 y.n1 10.1513
R429 y.n6 y.n4 10.1513
R430 y.n6 y.n5 10.1513
R431 y y.n7 6.44004
R432 y.n7 y.n3 0.553142
R433 VPWR.n57 VPWR.n45 832.942
R434 VPWR.n68 VPWR.n46 832.942
R435 VPWR.n70 VPWR.n43 832.942
R436 VPWR.n52 VPWR.n42 832.942
R437 VPWR.n20 VPWR.n8 832.942
R438 VPWR.n31 VPWR.n9 832.942
R439 VPWR.n33 VPWR.n6 832.942
R440 VPWR.n15 VPWR.n5 832.942
R441 VPWR.n94 VPWR.n82 832.942
R442 VPWR.n105 VPWR.n83 832.942
R443 VPWR.n107 VPWR.n80 832.942
R444 VPWR.n89 VPWR.n79 832.942
R445 VPWR.t5 VPWR.n73 700.484
R446 VPWR.n74 VPWR.t5 700.484
R447 VPWR.t1 VPWR.n36 700.484
R448 VPWR.n37 VPWR.t1 700.484
R449 VPWR.t3 VPWR.n0 700.484
R450 VPWR.n1 VPWR.t3 700.484
R451 VPWR.n68 VPWR.n45 240
R452 VPWR.n64 VPWR.n62 240
R453 VPWR.n70 VPWR.n42 240
R454 VPWR.n49 VPWR.n48 240
R455 VPWR.n31 VPWR.n8 240
R456 VPWR.n27 VPWR.n25 240
R457 VPWR.n33 VPWR.n5 240
R458 VPWR.n12 VPWR.n11 240
R459 VPWR.n105 VPWR.n82 240
R460 VPWR.n101 VPWR.n99 240
R461 VPWR.n107 VPWR.n79 240
R462 VPWR.n86 VPWR.n85 240
R463 VPWR.n55 VPWR.n54 207.394
R464 VPWR.n69 VPWR.n44 207.394
R465 VPWR.n18 VPWR.n17 207.394
R466 VPWR.n32 VPWR.n7 207.394
R467 VPWR.n92 VPWR.n91 207.394
R468 VPWR.n106 VPWR.n81 207.394
R469 VPWR.n52 VPWR.n51 185
R470 VPWR.n50 VPWR.n49 185
R471 VPWR.n48 VPWR.n47 185
R472 VPWR.n58 VPWR.n57 185
R473 VPWR.n59 VPWR.n45 185
R474 VPWR.n54 VPWR.n45 185
R475 VPWR.n68 VPWR.n67 185
R476 VPWR.n69 VPWR.n68 185
R477 VPWR.n66 VPWR.n46 185
R478 VPWR.n65 VPWR.n64 185
R479 VPWR.n62 VPWR.n60 185
R480 VPWR.n43 VPWR.n41 185
R481 VPWR.n71 VPWR.n70 185
R482 VPWR.n70 VPWR.n69 185
R483 VPWR.n42 VPWR.n40 185
R484 VPWR.n54 VPWR.n42 185
R485 VPWR.n15 VPWR.n14 185
R486 VPWR.n13 VPWR.n12 185
R487 VPWR.n11 VPWR.n10 185
R488 VPWR.n21 VPWR.n20 185
R489 VPWR.n22 VPWR.n8 185
R490 VPWR.n17 VPWR.n8 185
R491 VPWR.n31 VPWR.n30 185
R492 VPWR.n32 VPWR.n31 185
R493 VPWR.n29 VPWR.n9 185
R494 VPWR.n28 VPWR.n27 185
R495 VPWR.n25 VPWR.n23 185
R496 VPWR.n6 VPWR.n4 185
R497 VPWR.n34 VPWR.n33 185
R498 VPWR.n33 VPWR.n32 185
R499 VPWR.n5 VPWR.n3 185
R500 VPWR.n17 VPWR.n5 185
R501 VPWR.n89 VPWR.n88 185
R502 VPWR.n87 VPWR.n86 185
R503 VPWR.n85 VPWR.n84 185
R504 VPWR.n95 VPWR.n94 185
R505 VPWR.n96 VPWR.n82 185
R506 VPWR.n91 VPWR.n82 185
R507 VPWR.n105 VPWR.n104 185
R508 VPWR.n106 VPWR.n105 185
R509 VPWR.n103 VPWR.n83 185
R510 VPWR.n102 VPWR.n101 185
R511 VPWR.n99 VPWR.n97 185
R512 VPWR.n80 VPWR.n78 185
R513 VPWR.n108 VPWR.n107 185
R514 VPWR.n107 VPWR.n106 185
R515 VPWR.n79 VPWR.n77 185
R516 VPWR.n91 VPWR.n79 185
R517 VPWR.n59 VPWR.n58 88.8476
R518 VPWR.n51 VPWR.n40 88.8476
R519 VPWR.n67 VPWR.n66 88.8476
R520 VPWR.n71 VPWR.n41 88.8476
R521 VPWR.n22 VPWR.n21 88.8476
R522 VPWR.n14 VPWR.n3 88.8476
R523 VPWR.n30 VPWR.n29 88.8476
R524 VPWR.n34 VPWR.n4 88.8476
R525 VPWR.n96 VPWR.n95 88.8476
R526 VPWR.n88 VPWR.n77 88.8476
R527 VPWR.n104 VPWR.n103 88.8476
R528 VPWR.n108 VPWR.n78 88.8476
R529 VPWR.n63 VPWR.n46 72.7879
R530 VPWR.n61 VPWR.n43 72.7879
R531 VPWR.n57 VPWR.n56 72.7879
R532 VPWR.n53 VPWR.n49 72.7879
R533 VPWR.n53 VPWR.n52 72.7879
R534 VPWR.n56 VPWR.n48 72.7879
R535 VPWR.n64 VPWR.n63 72.7879
R536 VPWR.n62 VPWR.n61 72.7879
R537 VPWR.n26 VPWR.n9 72.7879
R538 VPWR.n24 VPWR.n6 72.7879
R539 VPWR.n20 VPWR.n19 72.7879
R540 VPWR.n16 VPWR.n12 72.7879
R541 VPWR.n16 VPWR.n15 72.7879
R542 VPWR.n19 VPWR.n11 72.7879
R543 VPWR.n27 VPWR.n26 72.7879
R544 VPWR.n25 VPWR.n24 72.7879
R545 VPWR.n100 VPWR.n83 72.7879
R546 VPWR.n98 VPWR.n80 72.7879
R547 VPWR.n94 VPWR.n93 72.7879
R548 VPWR.n90 VPWR.n86 72.7879
R549 VPWR.n90 VPWR.n89 72.7879
R550 VPWR.n93 VPWR.n85 72.7879
R551 VPWR.n101 VPWR.n100 72.7879
R552 VPWR.n99 VPWR.n98 72.7879
R553 VPWR.n54 VPWR.t0 56.8667
R554 VPWR.n69 VPWR.t0 56.8667
R555 VPWR.n17 VPWR.t2 56.8667
R556 VPWR.n32 VPWR.t2 56.8667
R557 VPWR.n91 VPWR.t4 56.8667
R558 VPWR.n106 VPWR.t4 56.8667
R559 VPWR.n55 VPWR.n53 56.1076
R560 VPWR.n56 VPWR.n55 56.1076
R561 VPWR.n63 VPWR.n44 56.1076
R562 VPWR.n61 VPWR.n44 56.1076
R563 VPWR.n18 VPWR.n16 56.1076
R564 VPWR.n19 VPWR.n18 56.1076
R565 VPWR.n26 VPWR.n7 56.1076
R566 VPWR.n24 VPWR.n7 56.1076
R567 VPWR.n92 VPWR.n90 56.1076
R568 VPWR.n93 VPWR.n92 56.1076
R569 VPWR.n100 VPWR.n81 56.1076
R570 VPWR.n98 VPWR.n81 56.1076
R571 VPWR.n58 VPWR.n47 25.6005
R572 VPWR.n50 VPWR.n47 25.6005
R573 VPWR.n51 VPWR.n50 25.6005
R574 VPWR.n67 VPWR.n59 25.6005
R575 VPWR.n66 VPWR.n65 25.6005
R576 VPWR.n65 VPWR.n60 25.6005
R577 VPWR.n60 VPWR.n41 25.6005
R578 VPWR.n21 VPWR.n10 25.6005
R579 VPWR.n13 VPWR.n10 25.6005
R580 VPWR.n14 VPWR.n13 25.6005
R581 VPWR.n30 VPWR.n22 25.6005
R582 VPWR.n29 VPWR.n28 25.6005
R583 VPWR.n28 VPWR.n23 25.6005
R584 VPWR.n23 VPWR.n4 25.6005
R585 VPWR.n95 VPWR.n84 25.6005
R586 VPWR.n87 VPWR.n84 25.6005
R587 VPWR.n88 VPWR.n87 25.6005
R588 VPWR.n104 VPWR.n96 25.6005
R589 VPWR.n103 VPWR.n102 25.6005
R590 VPWR.n102 VPWR.n97 25.6005
R591 VPWR.n97 VPWR.n78 25.6005
R592 VPWR.n72 VPWR 25.1758
R593 VPWR.n35 VPWR 25.1758
R594 VPWR.n109 VPWR 25.1758
R595 VPWR.n35 VPWR.n2 16.159
R596 VPWR.n76 VPWR.n75 16.065
R597 VPWR.n39 VPWR.n38 16.065
R598 VPWR VPWR.n73 12.8005
R599 VPWR.n74 VPWR 12.8005
R600 VPWR VPWR.n40 12.8005
R601 VPWR VPWR.n71 12.8005
R602 VPWR VPWR.n36 12.8005
R603 VPWR.n37 VPWR 12.8005
R604 VPWR VPWR.n3 12.8005
R605 VPWR VPWR.n34 12.8005
R606 VPWR VPWR.n0 12.8005
R607 VPWR.n1 VPWR 12.8005
R608 VPWR VPWR.n77 12.8005
R609 VPWR VPWR.n108 12.8005
R610 VPWR.n75 VPWR.n73 10.1513
R611 VPWR.n75 VPWR.n74 10.1513
R612 VPWR.n38 VPWR.n36 10.1513
R613 VPWR.n38 VPWR.n37 10.1513
R614 VPWR.n2 VPWR.n0 10.1513
R615 VPWR.n2 VPWR.n1 10.1513
R616 VPWR VPWR.n109 4.60547
R617 VPWR.n39 VPWR.n35 1.01178
R618 VPWR.n76 VPWR.n72 1.01178
R619 VPWR.n72 VPWR.n39 0.0945
R620 VPWR.n109 VPWR.n76 0.0945
C15 ANALOG_OUT VGND 58.0477f
C16 y VGND 7.24443f
C17 a VGND 4.24665f
C18 VPWR VGND 12.69221f
C19 OUT_y_0__N VGND 8.31288f $ **FLOATING
C20 N_3 VGND 7.79107f $ **FLOATING
C21 VPWR.n0 VGND 0.00362f $ **FLOATING
C22 VPWR.t3 VGND 0.01107f $ **FLOATING
C23 VPWR.n1 VGND 0.00362f $ **FLOATING
C24 VPWR.n2 VGND 0.25933f $ **FLOATING
C25 VPWR.n3 VGND 0.00814f $ **FLOATING
C26 VPWR.n4 VGND 0.00915f $ **FLOATING
C27 VPWR.n5 VGND 0.0091f $ **FLOATING
C28 VPWR.n6 VGND 0.00915f $ **FLOATING
C29 VPWR.t2 VGND 0.0323f $ **FLOATING
C30 VPWR.n7 VGND 0.10924f $ **FLOATING
C31 VPWR.n8 VGND 0.0091f $ **FLOATING
C32 VPWR.n9 VGND 0.00915f $ **FLOATING
C33 VPWR.n10 VGND 0.00387f $ **FLOATING
C34 VPWR.n11 VGND 0.00387f $ **FLOATING
C35 VPWR.n12 VGND 0.00387f $ **FLOATING
C36 VPWR.n13 VGND 0.00387f $ **FLOATING
C37 VPWR.n14 VGND 0.00915f $ **FLOATING
C38 VPWR.n15 VGND 0.00915f $ **FLOATING
C39 VPWR.n17 VGND 0.07504f $ **FLOATING
C40 VPWR.n18 VGND 0.10924f $ **FLOATING
C41 VPWR.n20 VGND 0.00915f $ **FLOATING
C42 VPWR.n21 VGND 0.00915f $ **FLOATING
C43 VPWR.n22 VGND 0.0091f $ **FLOATING
C44 VPWR.n23 VGND 0.00387f $ **FLOATING
C45 VPWR.n25 VGND 0.00387f $ **FLOATING
C46 VPWR.n27 VGND 0.00387f $ **FLOATING
C47 VPWR.n28 VGND 0.00387f $ **FLOATING
C48 VPWR.n29 VGND 0.00915f $ **FLOATING
C49 VPWR.n30 VGND 0.0091f $ **FLOATING
C50 VPWR.n31 VGND 0.0091f $ **FLOATING
C51 VPWR.n32 VGND 0.07504f $ **FLOATING
C52 VPWR.n33 VGND 0.0091f $ **FLOATING
C53 VPWR.n34 VGND 0.00814f $ **FLOATING
C54 VPWR.n35 VGND 1.00484f $ **FLOATING
C55 VPWR.n36 VGND 0.00362f $ **FLOATING
C56 VPWR.t1 VGND 0.01107f $ **FLOATING
C57 VPWR.n37 VGND 0.00362f $ **FLOATING
C58 VPWR.n38 VGND 0.25743f $ **FLOATING
C59 VPWR.n39 VGND 0.57508f $ **FLOATING
C60 VPWR.n40 VGND 0.00814f $ **FLOATING
C61 VPWR.n41 VGND 0.00915f $ **FLOATING
C62 VPWR.n42 VGND 0.0091f $ **FLOATING
C63 VPWR.n43 VGND 0.00915f $ **FLOATING
C64 VPWR.t0 VGND 0.0323f $ **FLOATING
C65 VPWR.n44 VGND 0.10924f $ **FLOATING
C66 VPWR.n45 VGND 0.0091f $ **FLOATING
C67 VPWR.n46 VGND 0.00915f $ **FLOATING
C68 VPWR.n47 VGND 0.00387f $ **FLOATING
C69 VPWR.n48 VGND 0.00387f $ **FLOATING
C70 VPWR.n49 VGND 0.00387f $ **FLOATING
C71 VPWR.n50 VGND 0.00387f $ **FLOATING
C72 VPWR.n51 VGND 0.00915f $ **FLOATING
C73 VPWR.n52 VGND 0.00915f $ **FLOATING
C74 VPWR.n54 VGND 0.07504f $ **FLOATING
C75 VPWR.n55 VGND 0.10924f $ **FLOATING
C76 VPWR.n57 VGND 0.00915f $ **FLOATING
C77 VPWR.n58 VGND 0.00915f $ **FLOATING
C78 VPWR.n59 VGND 0.0091f $ **FLOATING
C79 VPWR.n60 VGND 0.00387f $ **FLOATING
C80 VPWR.n62 VGND 0.00387f $ **FLOATING
C81 VPWR.n64 VGND 0.00387f $ **FLOATING
C82 VPWR.n65 VGND 0.00387f $ **FLOATING
C83 VPWR.n66 VGND 0.00915f $ **FLOATING
C84 VPWR.n67 VGND 0.0091f $ **FLOATING
C85 VPWR.n68 VGND 0.0091f $ **FLOATING
C86 VPWR.n69 VGND 0.07504f $ **FLOATING
C87 VPWR.n70 VGND 0.0091f $ **FLOATING
C88 VPWR.n71 VGND 0.00814f $ **FLOATING
C89 VPWR.n72 VGND 0.67871f $ **FLOATING
C90 VPWR.n73 VGND 0.00362f $ **FLOATING
C91 VPWR.t5 VGND 0.01107f $ **FLOATING
C92 VPWR.n74 VGND 0.00362f $ **FLOATING
C93 VPWR.n75 VGND 0.25743f $ **FLOATING
C94 VPWR.n76 VGND 0.57508f $ **FLOATING
C95 VPWR.n77 VGND 0.00814f $ **FLOATING
C96 VPWR.n78 VGND 0.00915f $ **FLOATING
C97 VPWR.n79 VGND 0.0091f $ **FLOATING
C98 VPWR.n80 VGND 0.00915f $ **FLOATING
C99 VPWR.t4 VGND 0.0323f $ **FLOATING
C100 VPWR.n81 VGND 0.10924f $ **FLOATING
C101 VPWR.n82 VGND 0.0091f $ **FLOATING
C102 VPWR.n83 VGND 0.00915f $ **FLOATING
C103 VPWR.n84 VGND 0.00387f $ **FLOATING
C104 VPWR.n85 VGND 0.00387f $ **FLOATING
C105 VPWR.n86 VGND 0.00387f $ **FLOATING
C106 VPWR.n87 VGND 0.00387f $ **FLOATING
C107 VPWR.n88 VGND 0.00915f $ **FLOATING
C108 VPWR.n89 VGND 0.00915f $ **FLOATING
C109 VPWR.n91 VGND 0.07504f $ **FLOATING
C110 VPWR.n92 VGND 0.10924f $ **FLOATING
C111 VPWR.n94 VGND 0.00915f $ **FLOATING
C112 VPWR.n95 VGND 0.00915f $ **FLOATING
C113 VPWR.n96 VGND 0.0091f $ **FLOATING
C114 VPWR.n97 VGND 0.00387f $ **FLOATING
C115 VPWR.n99 VGND 0.00387f $ **FLOATING
C116 VPWR.n101 VGND 0.00387f $ **FLOATING
C117 VPWR.n102 VGND 0.00387f $ **FLOATING
C118 VPWR.n103 VGND 0.00915f $ **FLOATING
C119 VPWR.n104 VGND 0.0091f $ **FLOATING
C120 VPWR.n105 VGND 0.0091f $ **FLOATING
C121 VPWR.n106 VGND 0.07504f $ **FLOATING
C122 VPWR.n107 VGND 0.0091f $ **FLOATING
C123 VPWR.n108 VGND 0.00814f $ **FLOATING
C124 VPWR.n109 VGND 0.7293f $ **FLOATING
C125 y.t0 VGND 0.96848f $ **FLOATING
C126 y.n0 VGND 0.00832f $ **FLOATING
C127 y.t2 VGND 0.02024f $ **FLOATING
C128 y.n1 VGND 0.00832f $ **FLOATING
C129 y.n2 VGND 0.43004f $ **FLOATING
C130 y.n3 VGND 2.40742f $ **FLOATING
C131 y.n4 VGND 0.00729f $ **FLOATING
C132 y.t1 VGND 0.02231f $ **FLOATING
C133 y.n5 VGND 0.00729f $ **FLOATING
C134 y.n6 VGND 0.43004f $ **FLOATING
C135 y.n7 VGND 2.94976f $ **FLOATING
C136 OUT_y_0__N.n0 VGND 0.01045f $ **FLOATING
C137 OUT_y_0__N.t2 VGND 0.04316f $ **FLOATING
C138 OUT_y_0__N.t3 VGND 0.04485f $ **FLOATING
C139 OUT_y_0__N.n1 VGND 3.34029f $ **FLOATING
C140 OUT_y_0__N.n2 VGND 0.01193f $ **FLOATING
C141 OUT_y_0__N.t1 VGND 0.02902f $ **FLOATING
C142 OUT_y_0__N.n3 VGND 0.01193f $ **FLOATING
C143 OUT_y_0__N.n4 VGND 0.57783f $ **FLOATING
C144 OUT_y_0__N.n5 VGND 5.19809f $ **FLOATING
C145 OUT_y_0__N.n6 VGND 0.71511f $ **FLOATING
C146 OUT_y_0__N.t0 VGND 0.032f $ **FLOATING
C147 OUT_y_0__N.n7 VGND 0.01045f $ **FLOATING
C148 N_3.n0 VGND 0.00754f $ **FLOATING
C149 N_3.t2 VGND 0.03118f $ **FLOATING
C150 N_3.t3 VGND 0.0324f $ **FLOATING
C151 N_3.n1 VGND 2.32139f $ **FLOATING
C152 N_3.n2 VGND 0.00862f $ **FLOATING
C153 N_3.t1 VGND 0.02096f $ **FLOATING
C154 N_3.n3 VGND 0.00862f $ **FLOATING
C155 N_3.n4 VGND 0.38947f $ **FLOATING
C156 N_3.n5 VGND 2.61586f $ **FLOATING
C157 N_3.n6 VGND 0.44754f $ **FLOATING
C158 N_3.t0 VGND 0.02311f $ **FLOATING
C159 N_3.n7 VGND 0.00754f $ **FLOATING
.ends

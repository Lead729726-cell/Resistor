* NGSPICE file created from logic_inv.ext - technology: sky130A

.subckt logic_inv VGND VPWR a y
X0 VGND.t1 a.t0 N_3.t0 VGND.t0 sky130_fd_pr__nfet_01v8 ad=0.1885 pd=1.88 as=0.1885 ps=1.88 w=0.65 l=0.15
X1 VGND.t5 N_3.t2 OUT_y_0__N.t1 VGND.t4 sky130_fd_pr__nfet_01v8 ad=0.1885 pd=1.88 as=0.1885 ps=1.88 w=0.65 l=0.15
X2 VPWR.t5 N_3.t3 OUT_y_0__N.t0 VPWR.t4 sky130_fd_pr__pfet_01v8_hvt ad=0.1885 pd=1.88 as=0.1885 ps=1.88 w=0.65 l=0.15
X3 VGND.t3 OUT_y_0__N.t2 y.t1 VGND.t2 sky130_fd_pr__nfet_01v8 ad=0.1885 pd=1.88 as=0.1885 ps=1.88 w=0.65 l=0.15
X4 VPWR.t3 OUT_y_0__N.t3 y.t0 VPWR.t2 sky130_fd_pr__pfet_01v8_hvt ad=0.1885 pd=1.88 as=0.1885 ps=1.88 w=0.65 l=0.15
X5 VPWR.t1 a.t1 N_3.t1 VPWR.t0 sky130_fd_pr__pfet_01v8_hvt ad=0.1885 pd=1.88 as=0.1885 ps=1.88 w=0.65 l=0.15
C0 VPWR OUT_y_0__N 0.68901f
C1 a N_3 1.81487f
C2 y N_3 2.39873f
C3 VPWR N_3 0.70351f
C4 OUT_y_0__N N_3 0.68065f
C5 a y 0.00439f
C6 a VPWR 0.43984f
C7 VPWR y 0.27866f
C8 a OUT_y_0__N 0.05386f
C9 OUT_y_0__N y 3.81111f
R0 a a.t1 330.341
R1 a a.t0 315.88
R2 a.n0 a 29.9353
R3 a.n0 a 29.3671
R4 a a.n0 4.60704
R5 N_3.t1 N_3.n2 700.484
R6 N_3.n3 N_3.t1 700.484
R7 N_3 N_3.t3 330.341
R8 N_3 N_3.t2 315.88
R9 N_3.t0 N_3.n0 255.345
R10 N_3.n7 N_3.t0 255.345
R11 N_3.n1 N_3 30.352
R12 N_3.n1 N_3 29.7837
R13 N_3 N_3.n2 12.8005
R14 N_3.n3 N_3 12.8005
R15 N_3 N_3.n0 12.8005
R16 N_3 N_3.n7 12.8005
R17 N_3.n5 N_3.n4 11.0047
R18 N_3.n6 N_3.n5 10.4521
R19 N_3.n4 N_3.n2 10.1513
R20 N_3.n4 N_3.n3 10.1513
R21 N_3.n6 N_3.n0 10.1513
R22 N_3.n7 N_3.n6 10.1513
R23 N_3.n5 N_3.n1 0.789708
R24 VGND.n86 VGND.n84 3946.74
R25 VGND.n61 VGND.n60 3946.74
R26 VGND.n72 VGND.n62 1315.26
R27 VGND.n82 VGND.n15 1315.26
R28 VGND.n74 VGND.n18 1315.26
R29 VGND.n76 VGND.n75 1315.26
R30 VGND.n94 VGND.n9 1315.26
R31 VGND.n105 VGND.n10 1315.26
R32 VGND.n89 VGND.n6 1315.26
R33 VGND.n107 VGND.n7 1315.26
R34 VGND.n48 VGND.n38 1315.26
R35 VGND.n58 VGND.n23 1315.26
R36 VGND.n52 VGND.n51 1315.26
R37 VGND.n50 VGND.n26 1315.26
R38 VGND.n103 VGND.n10 585
R39 VGND.n102 VGND.n101 585
R40 VGND.n99 VGND.n97 585
R41 VGND.n7 VGND.n5 585
R42 VGND.n108 VGND.n107 585
R43 VGND.n107 VGND.n106 585
R44 VGND.n6 VGND.n4 585
R45 VGND.n85 VGND.n6 585
R46 VGND.n89 VGND.n88 585
R47 VGND.n91 VGND.n87 585
R48 VGND.n92 VGND.n11 585
R49 VGND.n95 VGND.n94 585
R50 VGND.n96 VGND.n9 585
R51 VGND.n85 VGND.n9 585
R52 VGND.n105 VGND.n104 585
R53 VGND.n106 VGND.n105 585
R54 VGND.n82 VGND.n81 585
R55 VGND.n80 VGND.n14 585
R56 VGND.n79 VGND.n78 585
R57 VGND.n77 VGND.n76 585
R58 VGND.n75 VGND.n17 585
R59 VGND.n75 VGND.n12 585
R60 VGND.n74 VGND.n19 585
R61 VGND.n74 VGND.n73 585
R62 VGND.n63 VGND.n18 585
R63 VGND.n67 VGND.n64 585
R64 VGND.n69 VGND.n68 585
R65 VGND.n70 VGND.n62 585
R66 VGND.n72 VGND.n71 585
R67 VGND.n73 VGND.n72 585
R68 VGND.n16 VGND.n15 585
R69 VGND.n15 VGND.n12 585
R70 VGND.n39 VGND.n26 585
R71 VGND.n42 VGND.n40 585
R72 VGND.n45 VGND.n44 585
R73 VGND.n46 VGND.n38 585
R74 VGND.n48 VGND.n47 585
R75 VGND.n49 VGND.n48 585
R76 VGND.n24 VGND.n23 585
R77 VGND.n23 VGND.n20 585
R78 VGND.n58 VGND.n57 585
R79 VGND.n56 VGND.n22 585
R80 VGND.n55 VGND.n54 585
R81 VGND.n53 VGND.n52 585
R82 VGND.n51 VGND.n25 585
R83 VGND.n51 VGND.n20 585
R84 VGND.n50 VGND.n36 585
R85 VGND.n50 VGND.n49 585
R86 VGND.n72 VGND.n15 394
R87 VGND.n68 VGND.n67 394
R88 VGND.n75 VGND.n74 394
R89 VGND.n78 VGND.n14 394
R90 VGND.n105 VGND.n9 394
R91 VGND.n92 VGND.n91 394
R92 VGND.n107 VGND.n6 394
R93 VGND.n101 VGND.n99 394
R94 VGND.n48 VGND.n23 394
R95 VGND.n54 VGND.n22 394
R96 VGND.n51 VGND.n50 394
R97 VGND.n44 VGND.n42 394
R98 VGND.t1 VGND.n0 255.345
R99 VGND.n1 VGND.t1 255.345
R100 VGND.t5 VGND.n31 255.345
R101 VGND.n32 VGND.t5 255.345
R102 VGND.t3 VGND.n27 255.345
R103 VGND.n28 VGND.t3 255.345
R104 VGND.n100 VGND.n8 218.815
R105 VGND.n98 VGND.n8 218.815
R106 VGND.n90 VGND.n86 218.815
R107 VGND.n93 VGND.n86 218.815
R108 VGND.n84 VGND.n83 218.815
R109 VGND.n84 VGND.n13 218.815
R110 VGND.n66 VGND.n61 218.815
R111 VGND.n65 VGND.n61 218.815
R112 VGND.n41 VGND.n37 218.815
R113 VGND.n43 VGND.n37 218.815
R114 VGND.n60 VGND.n59 218.815
R115 VGND.n60 VGND.n21 218.815
R116 VGND.n86 VGND.n85 187.62
R117 VGND.n106 VGND.n8 187.62
R118 VGND.n73 VGND.n61 187.62
R119 VGND.n84 VGND.n12 187.62
R120 VGND.n49 VGND.n37 187.62
R121 VGND.n60 VGND.n20 187.62
R122 VGND.n68 VGND.n65 147.374
R123 VGND.n66 VGND.n18 147.374
R124 VGND.n83 VGND.n82 147.374
R125 VGND.n76 VGND.n13 147.374
R126 VGND.n93 VGND.n92 147.374
R127 VGND.n90 VGND.n89 147.374
R128 VGND.n100 VGND.n10 147.374
R129 VGND.n98 VGND.n7 147.374
R130 VGND.n101 VGND.n100 147.374
R131 VGND.n99 VGND.n98 147.374
R132 VGND.n91 VGND.n90 147.374
R133 VGND.n94 VGND.n93 147.374
R134 VGND.n83 VGND.n14 147.374
R135 VGND.n78 VGND.n13 147.374
R136 VGND.n67 VGND.n66 147.374
R137 VGND.n65 VGND.n62 147.374
R138 VGND.n59 VGND.n58 147.374
R139 VGND.n52 VGND.n21 147.374
R140 VGND.n43 VGND.n38 147.374
R141 VGND.n42 VGND.n41 147.374
R142 VGND.n41 VGND.n26 147.374
R143 VGND.n44 VGND.n43 147.374
R144 VGND.n59 VGND.n22 147.374
R145 VGND.n54 VGND.n21 147.374
R146 VGND.n71 VGND.n70 85.4593
R147 VGND.n81 VGND.n16 85.4593
R148 VGND.n63 VGND.n19 85.4593
R149 VGND.n77 VGND.n17 85.4593
R150 VGND.n96 VGND.n95 85.4593
R151 VGND.n104 VGND.n103 85.4593
R152 VGND.n88 VGND.n4 85.4593
R153 VGND.n108 VGND.n5 85.4593
R154 VGND.n47 VGND.n46 85.4593
R155 VGND.n39 VGND.n36 85.4593
R156 VGND.n57 VGND.n24 85.4593
R157 VGND.n53 VGND.n25 85.4593
R158 VGND.n85 VGND.t0 51.4448
R159 VGND.n106 VGND.t0 51.4448
R160 VGND.n73 VGND.t4 51.4448
R161 VGND.t4 VGND.n12 51.4448
R162 VGND.n49 VGND.t2 51.4448
R163 VGND.t2 VGND.n20 51.4448
R164 VGND.n71 VGND.n16 25.6005
R165 VGND.n70 VGND.n69 25.6005
R166 VGND.n69 VGND.n64 25.6005
R167 VGND.n64 VGND.n63 25.6005
R168 VGND.n81 VGND.n80 25.6005
R169 VGND.n80 VGND.n79 25.6005
R170 VGND.n79 VGND.n77 25.6005
R171 VGND.n104 VGND.n96 25.6005
R172 VGND.n95 VGND.n11 25.6005
R173 VGND.n87 VGND.n11 25.6005
R174 VGND.n88 VGND.n87 25.6005
R175 VGND.n103 VGND.n102 25.6005
R176 VGND.n102 VGND.n97 25.6005
R177 VGND.n97 VGND.n5 25.6005
R178 VGND.n46 VGND.n45 25.6005
R179 VGND.n45 VGND.n40 25.6005
R180 VGND.n40 VGND.n39 25.6005
R181 VGND.n47 VGND.n24 25.6005
R182 VGND.n57 VGND.n56 25.6005
R183 VGND.n56 VGND.n55 25.6005
R184 VGND.n55 VGND.n53 25.6005
R185 VGND.n30 VGND 18.3598
R186 VGND.n109 VGND 18.3598
R187 VGND VGND.n35 18.3598
R188 VGND VGND.n31 12.8005
R189 VGND.n32 VGND 12.8005
R190 VGND VGND.n27 12.8005
R191 VGND.n28 VGND 12.8005
R192 VGND VGND.n19 12.8005
R193 VGND VGND.n17 12.8005
R194 VGND VGND.n4 12.8005
R195 VGND VGND.n108 12.8005
R196 VGND.n36 VGND 12.8005
R197 VGND VGND.n25 12.8005
R198 VGND VGND.n0 12.8005
R199 VGND.n1 VGND 12.8005
R200 VGND.n33 VGND.n31 10.1513
R201 VGND.n33 VGND.n32 10.1513
R202 VGND.n29 VGND.n27 10.1513
R203 VGND.n29 VGND.n28 10.1513
R204 VGND.n2 VGND.n0 10.1513
R205 VGND.n2 VGND.n1 10.1513
R206 VGND.n35 VGND.n29 10.1294
R207 VGND.n34 VGND.n33 10.0354
R208 VGND.n3 VGND.n2 10.0354
R209 VGND VGND.n109 5.29912
R210 VGND.n35 VGND.n34 1.01178
R211 VGND.n30 VGND.n3 1.01178
R212 VGND.n34 VGND.n30 0.0945
R213 VGND.n109 VGND.n3 0.0945
R214 OUT_y_0__N.t0 OUT_y_0__N.n0 700.484
R215 OUT_y_0__N.n7 OUT_y_0__N.t0 700.484
R216 OUT_y_0__N OUT_y_0__N.t3 330.341
R217 OUT_y_0__N OUT_y_0__N.t2 315.88
R218 OUT_y_0__N.t1 OUT_y_0__N.n2 255.345
R219 OUT_y_0__N.n3 OUT_y_0__N.t1 255.345
R220 OUT_y_0__N.n1 OUT_y_0__N 31.1853
R221 OUT_y_0__N.n1 OUT_y_0__N 30.6171
R222 OUT_y_0__N OUT_y_0__N.n2 12.8005
R223 OUT_y_0__N.n3 OUT_y_0__N 12.8005
R224 OUT_y_0__N OUT_y_0__N.n0 12.8005
R225 OUT_y_0__N OUT_y_0__N.n7 12.8005
R226 OUT_y_0__N.n6 OUT_y_0__N.n5 11.8381
R227 OUT_y_0__N.n5 OUT_y_0__N.n4 11.2854
R228 OUT_y_0__N.n4 OUT_y_0__N.n2 10.1513
R229 OUT_y_0__N.n4 OUT_y_0__N.n3 10.1513
R230 OUT_y_0__N.n6 OUT_y_0__N.n0 10.1513
R231 OUT_y_0__N.n7 OUT_y_0__N.n6 10.1513
R232 OUT_y_0__N.n5 OUT_y_0__N.n1 0.789708
R233 VPWR.n57 VPWR.n45 832.942
R234 VPWR.n68 VPWR.n46 832.942
R235 VPWR.n70 VPWR.n43 832.942
R236 VPWR.n52 VPWR.n42 832.942
R237 VPWR.n20 VPWR.n8 832.942
R238 VPWR.n31 VPWR.n9 832.942
R239 VPWR.n33 VPWR.n6 832.942
R240 VPWR.n15 VPWR.n5 832.942
R241 VPWR.n94 VPWR.n82 832.942
R242 VPWR.n105 VPWR.n83 832.942
R243 VPWR.n107 VPWR.n80 832.942
R244 VPWR.n89 VPWR.n79 832.942
R245 VPWR.t1 VPWR.n73 700.484
R246 VPWR.n74 VPWR.t1 700.484
R247 VPWR.t5 VPWR.n36 700.484
R248 VPWR.n37 VPWR.t5 700.484
R249 VPWR.t3 VPWR.n0 700.484
R250 VPWR.n1 VPWR.t3 700.484
R251 VPWR.n68 VPWR.n45 240
R252 VPWR.n64 VPWR.n62 240
R253 VPWR.n70 VPWR.n42 240
R254 VPWR.n49 VPWR.n48 240
R255 VPWR.n31 VPWR.n8 240
R256 VPWR.n27 VPWR.n25 240
R257 VPWR.n33 VPWR.n5 240
R258 VPWR.n12 VPWR.n11 240
R259 VPWR.n105 VPWR.n82 240
R260 VPWR.n101 VPWR.n99 240
R261 VPWR.n107 VPWR.n79 240
R262 VPWR.n86 VPWR.n85 240
R263 VPWR.n55 VPWR.n54 207.394
R264 VPWR.n69 VPWR.n44 207.394
R265 VPWR.n18 VPWR.n17 207.394
R266 VPWR.n32 VPWR.n7 207.394
R267 VPWR.n92 VPWR.n91 207.394
R268 VPWR.n106 VPWR.n81 207.394
R269 VPWR.n52 VPWR.n51 185
R270 VPWR.n50 VPWR.n49 185
R271 VPWR.n48 VPWR.n47 185
R272 VPWR.n58 VPWR.n57 185
R273 VPWR.n59 VPWR.n45 185
R274 VPWR.n54 VPWR.n45 185
R275 VPWR.n68 VPWR.n67 185
R276 VPWR.n69 VPWR.n68 185
R277 VPWR.n66 VPWR.n46 185
R278 VPWR.n65 VPWR.n64 185
R279 VPWR.n62 VPWR.n60 185
R280 VPWR.n43 VPWR.n41 185
R281 VPWR.n71 VPWR.n70 185
R282 VPWR.n70 VPWR.n69 185
R283 VPWR.n42 VPWR.n40 185
R284 VPWR.n54 VPWR.n42 185
R285 VPWR.n15 VPWR.n14 185
R286 VPWR.n13 VPWR.n12 185
R287 VPWR.n11 VPWR.n10 185
R288 VPWR.n21 VPWR.n20 185
R289 VPWR.n22 VPWR.n8 185
R290 VPWR.n17 VPWR.n8 185
R291 VPWR.n31 VPWR.n30 185
R292 VPWR.n32 VPWR.n31 185
R293 VPWR.n29 VPWR.n9 185
R294 VPWR.n28 VPWR.n27 185
R295 VPWR.n25 VPWR.n23 185
R296 VPWR.n6 VPWR.n4 185
R297 VPWR.n34 VPWR.n33 185
R298 VPWR.n33 VPWR.n32 185
R299 VPWR.n5 VPWR.n3 185
R300 VPWR.n17 VPWR.n5 185
R301 VPWR.n89 VPWR.n88 185
R302 VPWR.n87 VPWR.n86 185
R303 VPWR.n85 VPWR.n84 185
R304 VPWR.n95 VPWR.n94 185
R305 VPWR.n96 VPWR.n82 185
R306 VPWR.n91 VPWR.n82 185
R307 VPWR.n105 VPWR.n104 185
R308 VPWR.n106 VPWR.n105 185
R309 VPWR.n103 VPWR.n83 185
R310 VPWR.n102 VPWR.n101 185
R311 VPWR.n99 VPWR.n97 185
R312 VPWR.n80 VPWR.n78 185
R313 VPWR.n108 VPWR.n107 185
R314 VPWR.n107 VPWR.n106 185
R315 VPWR.n79 VPWR.n77 185
R316 VPWR.n91 VPWR.n79 185
R317 VPWR.n59 VPWR.n58 88.8476
R318 VPWR.n51 VPWR.n40 88.8476
R319 VPWR.n67 VPWR.n66 88.8476
R320 VPWR.n71 VPWR.n41 88.8476
R321 VPWR.n22 VPWR.n21 88.8476
R322 VPWR.n14 VPWR.n3 88.8476
R323 VPWR.n30 VPWR.n29 88.8476
R324 VPWR.n34 VPWR.n4 88.8476
R325 VPWR.n96 VPWR.n95 88.8476
R326 VPWR.n88 VPWR.n77 88.8476
R327 VPWR.n104 VPWR.n103 88.8476
R328 VPWR.n108 VPWR.n78 88.8476
R329 VPWR.n63 VPWR.n46 72.7879
R330 VPWR.n61 VPWR.n43 72.7879
R331 VPWR.n57 VPWR.n56 72.7879
R332 VPWR.n53 VPWR.n49 72.7879
R333 VPWR.n53 VPWR.n52 72.7879
R334 VPWR.n56 VPWR.n48 72.7879
R335 VPWR.n64 VPWR.n63 72.7879
R336 VPWR.n62 VPWR.n61 72.7879
R337 VPWR.n26 VPWR.n9 72.7879
R338 VPWR.n24 VPWR.n6 72.7879
R339 VPWR.n20 VPWR.n19 72.7879
R340 VPWR.n16 VPWR.n12 72.7879
R341 VPWR.n16 VPWR.n15 72.7879
R342 VPWR.n19 VPWR.n11 72.7879
R343 VPWR.n27 VPWR.n26 72.7879
R344 VPWR.n25 VPWR.n24 72.7879
R345 VPWR.n100 VPWR.n83 72.7879
R346 VPWR.n98 VPWR.n80 72.7879
R347 VPWR.n94 VPWR.n93 72.7879
R348 VPWR.n90 VPWR.n86 72.7879
R349 VPWR.n90 VPWR.n89 72.7879
R350 VPWR.n93 VPWR.n85 72.7879
R351 VPWR.n101 VPWR.n100 72.7879
R352 VPWR.n99 VPWR.n98 72.7879
R353 VPWR.n54 VPWR.t4 56.8667
R354 VPWR.n69 VPWR.t4 56.8667
R355 VPWR.n17 VPWR.t2 56.8667
R356 VPWR.n32 VPWR.t2 56.8667
R357 VPWR.n91 VPWR.t0 56.8667
R358 VPWR.n106 VPWR.t0 56.8667
R359 VPWR.n55 VPWR.n53 56.1076
R360 VPWR.n56 VPWR.n55 56.1076
R361 VPWR.n63 VPWR.n44 56.1076
R362 VPWR.n61 VPWR.n44 56.1076
R363 VPWR.n18 VPWR.n16 56.1076
R364 VPWR.n19 VPWR.n18 56.1076
R365 VPWR.n26 VPWR.n7 56.1076
R366 VPWR.n24 VPWR.n7 56.1076
R367 VPWR.n92 VPWR.n90 56.1076
R368 VPWR.n93 VPWR.n92 56.1076
R369 VPWR.n100 VPWR.n81 56.1076
R370 VPWR.n98 VPWR.n81 56.1076
R371 VPWR.n58 VPWR.n47 25.6005
R372 VPWR.n50 VPWR.n47 25.6005
R373 VPWR.n51 VPWR.n50 25.6005
R374 VPWR.n67 VPWR.n59 25.6005
R375 VPWR.n66 VPWR.n65 25.6005
R376 VPWR.n65 VPWR.n60 25.6005
R377 VPWR.n60 VPWR.n41 25.6005
R378 VPWR.n21 VPWR.n10 25.6005
R379 VPWR.n13 VPWR.n10 25.6005
R380 VPWR.n14 VPWR.n13 25.6005
R381 VPWR.n30 VPWR.n22 25.6005
R382 VPWR.n29 VPWR.n28 25.6005
R383 VPWR.n28 VPWR.n23 25.6005
R384 VPWR.n23 VPWR.n4 25.6005
R385 VPWR.n95 VPWR.n84 25.6005
R386 VPWR.n87 VPWR.n84 25.6005
R387 VPWR.n88 VPWR.n87 25.6005
R388 VPWR.n104 VPWR.n96 25.6005
R389 VPWR.n103 VPWR.n102 25.6005
R390 VPWR.n102 VPWR.n97 25.6005
R391 VPWR.n97 VPWR.n78 25.6005
R392 VPWR.n72 VPWR 18.865
R393 VPWR.n35 VPWR 18.865
R394 VPWR.n109 VPWR 18.865
R395 VPWR VPWR.n73 12.8005
R396 VPWR.n74 VPWR 12.8005
R397 VPWR VPWR.n36 12.8005
R398 VPWR.n37 VPWR 12.8005
R399 VPWR VPWR.n40 12.8005
R400 VPWR VPWR.n71 12.8005
R401 VPWR VPWR.n0 12.8005
R402 VPWR.n1 VPWR 12.8005
R403 VPWR VPWR.n3 12.8005
R404 VPWR VPWR.n34 12.8005
R405 VPWR VPWR.n77 12.8005
R406 VPWR VPWR.n108 12.8005
R407 VPWR.n35 VPWR.n2 10.6503
R408 VPWR.n76 VPWR.n75 10.5563
R409 VPWR.n39 VPWR.n38 10.5563
R410 VPWR.n75 VPWR.n73 10.1513
R411 VPWR.n75 VPWR.n74 10.1513
R412 VPWR.n38 VPWR.n36 10.1513
R413 VPWR.n38 VPWR.n37 10.1513
R414 VPWR.n2 VPWR.n0 10.1513
R415 VPWR.n2 VPWR.n1 10.1513
R416 VPWR VPWR.n109 4.60547
R417 VPWR.n39 VPWR.n35 1.01178
R418 VPWR.n76 VPWR.n72 1.01178
R419 VPWR.n72 VPWR.n39 0.0945
R420 VPWR.n109 VPWR.n76 0.0945
R421 y.t0 y.n3 700.484
R422 y.n4 y.t0 700.484
R423 y.t1 y.n0 255.345
R424 y.n1 y.t1 255.345
R425 y y.n0 12.8005
R426 y.n1 y 12.8005
R427 y y.n3 12.8005
R428 y.n4 y 12.8005
R429 y.n6 y.n2 11.4214
R430 y.n6 y.n5 10.8688
R431 y.n2 y.n0 10.1513
R432 y.n2 y.n1 10.1513
R433 y.n5 y.n3 10.1513
R434 y.n5 y.n4 10.1513
R435 y y.n6 6.44004
C10 y VGND 3.21806f
C11 a VGND 2.29465f
C12 VPWR VGND 10.3939f
C13 OUT_y_0__N VGND 6.1584f $ **FLOATING
C14 N_3 VGND 3.99269f $ **FLOATING
C15 y.n0 VGND 0.01215f $ **FLOATING
C16 y.t1 VGND 0.02954f $ **FLOATING
C17 y.n1 VGND 0.01215f $ **FLOATING
C18 y.n2 VGND 0.30803f $ **FLOATING
C19 y.n3 VGND 0.01063f $ **FLOATING
C20 y.t0 VGND 0.03257f $ **FLOATING
C21 y.n4 VGND 0.01063f $ **FLOATING
C22 y.n5 VGND 0.27247f $ **FLOATING
C23 y.n6 VGND 4.57686f $ **FLOATING
C24 OUT_y_0__N.n0 VGND 0.00485f $ **FLOATING
C25 OUT_y_0__N.t2 VGND 0.02003f $ **FLOATING
C26 OUT_y_0__N.t3 VGND 0.02082f $ **FLOATING
C27 OUT_y_0__N.n1 VGND 1.11512f $ **FLOATING
C28 OUT_y_0__N.n2 VGND 0.00554f $ **FLOATING
C29 OUT_y_0__N.t1 VGND 0.01347f $ **FLOATING
C30 OUT_y_0__N.n3 VGND 0.00554f $ **FLOATING
C31 OUT_y_0__N.n4 VGND 0.14122f $ **FLOATING
C32 OUT_y_0__N.n5 VGND 2.09753f $ **FLOATING
C33 OUT_y_0__N.n6 VGND 0.21398f $ **FLOATING
C34 OUT_y_0__N.t0 VGND 0.01485f $ **FLOATING
C35 OUT_y_0__N.n7 VGND 0.00485f $ **FLOATING
C36 N_3.n0 VGND 0.00479f $ **FLOATING
C37 N_3.t2 VGND 0.01733f $ **FLOATING
C38 N_3.t3 VGND 0.01801f $ **FLOATING
C39 N_3.n1 VGND 0.85585f $ **FLOATING
C40 N_3.n2 VGND 0.00419f $ **FLOATING
C41 N_3.t1 VGND 0.01285f $ **FLOATING
C42 N_3.n3 VGND 0.00419f $ **FLOATING
C43 N_3.n4 VGND 0.12761f $ **FLOATING
C44 N_3.n5 VGND 1.14786f $ **FLOATING
C45 N_3.n6 VGND 0.09291f $ **FLOATING
C46 N_3.t0 VGND 0.01165f $ **FLOATING
C47 N_3.n7 VGND 0.00479f $ **FLOATING
.ends

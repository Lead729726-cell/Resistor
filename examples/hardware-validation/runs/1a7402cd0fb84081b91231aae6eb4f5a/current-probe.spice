.subckt logic_inv a y VPWR VGND ANALOG_OUT
XHDLDRV_RC_R_P0 y ANALOG_OUT VGND sky130_fd_pr__res_xhigh_po_1p41 l=0.54
XHDLDRV_RC_C_P0 ANALOG_OUT VGND sky130_fd_pr__cap_mim_m3_1 w=22.17 l=22.17
XG0_MN register_cf_node_59fabd8349c1c1d6 a register_cf_node_59fabd8349c1c1d6_source VGND sky130_fd_pr__nfet_01v8 w=0.65 l=0.15 nf=1 m=1
Vregister_cf_59fabd8349c1c1d6 N_3 register_cf_node_59fabd8349c1c1d6 0
Vregister_cf_59fabd8349c1c1d6_source VGND register_cf_node_59fabd8349c1c1d6_source 0
XG0_MP register_cf_node_5ed65c4aa7499b5b a register_cf_node_5ed65c4aa7499b5b_source VPWR sky130_fd_pr__pfet_01v8_hvt w=0.65 l=0.15 nf=1 m=1
Vregister_cf_5ed65c4aa7499b5b N_3 register_cf_node_5ed65c4aa7499b5b 0
Vregister_cf_5ed65c4aa7499b5b_source VPWR register_cf_node_5ed65c4aa7499b5b_source 0
XOUT_y_0_I0_MN register_cf_node_00a1d2e98e637c0f N_3 register_cf_node_00a1d2e98e637c0f_source VGND sky130_fd_pr__nfet_01v8 w=0.65 l=0.15 nf=1 m=1
Vregister_cf_00a1d2e98e637c0f OUT_y_0__N register_cf_node_00a1d2e98e637c0f 0
Vregister_cf_00a1d2e98e637c0f_source VGND register_cf_node_00a1d2e98e637c0f_source 0
XOUT_y_0_I0_MP register_cf_node_9cbf603810715f1f N_3 register_cf_node_9cbf603810715f1f_source VPWR sky130_fd_pr__pfet_01v8_hvt w=0.65 l=0.15 nf=1 m=1
Vregister_cf_9cbf603810715f1f OUT_y_0__N register_cf_node_9cbf603810715f1f 0
Vregister_cf_9cbf603810715f1f_source VPWR register_cf_node_9cbf603810715f1f_source 0
XOUT_y_0_I1_MN register_cf_node_de0326797105363c OUT_y_0__N register_cf_node_de0326797105363c_source VGND sky130_fd_pr__nfet_01v8 w=0.65 l=0.15 nf=1 m=1
Vregister_cf_de0326797105363c y register_cf_node_de0326797105363c 0
Vregister_cf_de0326797105363c_source VGND register_cf_node_de0326797105363c_source 0
XOUT_y_0_I1_MP register_cf_node_455e42f8c4345c1c OUT_y_0__N register_cf_node_455e42f8c4345c1c_source VPWR sky130_fd_pr__pfet_01v8_hvt w=0.65 l=0.15 nf=1 m=1
Vregister_cf_455e42f8c4345c1c y register_cf_node_455e42f8c4345c1c 0
Vregister_cf_455e42f8c4345c1c_source VPWR register_cf_node_455e42f8c4345c1c_source 0
.ends logic_inv

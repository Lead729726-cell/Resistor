.subckt INV A Y VPWR VGND
XMN Y A VGND VGND sky130_fd_pr__nfet_01v8 w=0.65 l=0.15 nf=1 m=1
XMP Y A VPWR VPWR sky130_fd_pr__pfet_01v8_hvt w=0.65 l=0.15 nf=1 m=1
.ends INV
.subckt NAND2 A0 A1 Y VPWR VGND
XMN0 Y A0 N1 VGND sky130_fd_pr__nfet_01v8 w=0.65 l=0.15 nf=1 m=1
XMN1 N1 A1 VGND VGND sky130_fd_pr__nfet_01v8 w=0.65 l=0.15 nf=1 m=1
XMP0 Y A0 VPWR VPWR sky130_fd_pr__pfet_01v8_hvt w=0.65 l=0.15 nf=1 m=1
XMP1 Y A1 VPWR VPWR sky130_fd_pr__pfet_01v8_hvt w=0.65 l=0.15 nf=1 m=1
.ends NAND2
.subckt OR2 A B Y VPWR VGND
XG NA NB Y VPWR VGND NAND2
XIA A NA VPWR VGND INV
XIB B NB VPWR VGND INV
.ends OR2
.subckt AND2 A B Y VPWR VGND
XI1 N Y VPWR VGND INV
XN1 A B N VPWR VGND NAND2
.ends AND2
.subckt XOR2 A B Y VPWR VGND
XN1 A B N1 VPWR VGND NAND2
XN2 A N1 N2 VPWR VGND NAND2
XN3 B N1 N3 VPWR VGND NAND2
XN4 N2 N3 Y VPWR VGND NAND2
.ends XOR2
.subckt DFF D CLK Q VPWR VGND
XICLK CLK CLKB VPWR VGND INV
XM1 M MB VPWR VGND INV
XM2 MB MF VPWR VGND INV
XMNIN M CLKB D VGND sky130_fd_pr__nfet_01v8 w=0.65 l=0.15 nf=1 m=1
XMNMF M CLK MF VGND sky130_fd_pr__nfet_01v8 w=0.65 l=0.15 nf=1 m=1
XMNOUT T CLK MF VGND sky130_fd_pr__nfet_01v8 w=0.65 l=0.15 nf=1 m=1
XMNSF T CLKB Q VGND sky130_fd_pr__nfet_01v8 w=0.65 l=0.15 nf=1 m=1
XMPIN M CLK D VPWR sky130_fd_pr__pfet_01v8_hvt w=0.65 l=0.15 nf=1 m=1
XMPMF M CLKB MF VPWR sky130_fd_pr__pfet_01v8_hvt w=0.65 l=0.15 nf=1 m=1
XMPOUT T CLKB MF VPWR sky130_fd_pr__pfet_01v8_hvt w=0.65 l=0.15 nf=1 m=1
XMPSF T CLK Q VPWR sky130_fd_pr__pfet_01v8_hvt w=0.65 l=0.15 nf=1 m=1
XS1 T TB VPWR VGND INV
XS2 TB Q VPWR VGND INV
.ends DFF
.subckt BUF A Y VPWR VGND
XI0 A N VPWR VGND INV
XI1 N Y VPWR VGND INV
.ends BUF
.subckt counter4 clk rst q_0 q_1 q_2 q_3 VPWR VGND
XG0 rst N_8 VPWR VGND INV
XG1 rst N_4 N_9 VPWR VGND OR2
XG10 N_8 N_17 N_18 VPWR VGND AND2
XG11 N_10 clk N_4 VPWR VGND DFF
XG12 N_13 clk N_5 VPWR VGND DFF
XG13 N_16 clk N_6 VPWR VGND DFF
XG14 N_18 clk N_7 VPWR VGND DFF
XG2 N_9 N_10 VPWR VGND INV
XG3 N_4 N_5 N_11 VPWR VGND AND2
XG4 N_4 N_5 N_12 VPWR VGND XOR2
XG5 N_8 N_12 N_13 VPWR VGND AND2
XG6 N_6 N_11 N_14 VPWR VGND AND2
XG7 N_6 N_11 N_15 VPWR VGND XOR2
XG8 N_8 N_15 N_16 VPWR VGND AND2
XG9 N_7 N_14 N_17 VPWR VGND XOR2
XOUT_q_0 N_4 q_0 VPWR VGND BUF
XOUT_q_1 N_5 q_1 VPWR VGND BUF
XOUT_q_2 N_6 q_2 VPWR VGND BUF
XOUT_q_3 N_7 q_3 VPWR VGND BUF
.ends counter4

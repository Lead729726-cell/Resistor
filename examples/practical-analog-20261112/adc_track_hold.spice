.subckt SOC_OTA_FIRST INP INN BIAS OUT VPWR VGND
XN_INN0 MIR INN TAIL VGND sky130_fd_pr__nfet_01v8 w=5 l=1 nf=1 m=1
XN_INN1 MIR INN TAIL VGND sky130_fd_pr__nfet_01v8 w=5 l=1 nf=1 m=1
XN_INP0 OUT INP TAIL VGND sky130_fd_pr__nfet_01v8 w=5 l=1 nf=1 m=1
XN_INP1 OUT INP TAIL VGND sky130_fd_pr__nfet_01v8 w=5 l=1 nf=1 m=1
XN_TAIL TAIL BIAS VGND VGND sky130_fd_pr__nfet_01v8 w=2 l=1 nf=1 m=1
XP_DIODE MIR MIR VPWR VPWR sky130_fd_pr__pfet_01v8_hvt w=20 l=1 nf=1 m=1
XP_MIRROR OUT MIR VPWR VPWR sky130_fd_pr__pfet_01v8_hvt w=20 l=1 nf=1 m=1
.ends SOC_OTA_FIRST
.subckt SOC_OTA INP INN BIAS OUT VPWR VGND
CC_MILLER PRE COMP 5e-12
XFIRST INP INN BIAS PRE VPWR VGND SOC_OTA_FIRST
XN_SECOND OUT BIAS VGND VGND sky130_fd_pr__nfet_01v8 w=2 l=1 nf=1 m=1
XP_SECOND OUT PRE VPWR VPWR sky130_fd_pr__pfet_01v8_hvt w=40 l=1 nf=1 m=1
RR_ZERO COMP OUT 5000
.ends SOC_OTA
.subckt SOC_BIAS BIAS VCM VPWR VGND
CC_VCM VCM_RAW VGND 2e-11
XN_DIODE BIAS BIAS VGND VGND sky130_fd_pr__nfet_01v8 w=2 l=1 nf=1 m=1
RR_BIAS VPWR BIAS 30000
RR_VCM_BOTTOM VCM_RAW VGND 100000
RR_VCM_TOP VPWR VCM_RAW 100000
XVCM_BUFFER VCM_RAW VCM BIAS VCM VPWR VGND SOC_OTA
.ends SOC_BIAS
.subckt INV A Y VPWR VGND
XMN Y A VGND VGND sky130_fd_pr__nfet_01v8 w=0.65 l=0.15 nf=1 m=1
XMP Y A VPWR VPWR sky130_fd_pr__pfet_01v8_hvt w=0.65 l=0.15 nf=1 m=1
.ends INV
.subckt PRACTICAL_SAMPLE_SWITCH VIN CLK HOLD VCM VPWR VGND
XCLOCK_COMPLEMENT CLK CLKB VPWR VGND INV
REXPLICIT_HOLD_LEAKAGE HOLD VCM 1000000000
CHOLD_CAPACITOR HOLD VGND 1e-11
XTRACK_N VIN CLK HOLD VGND sky130_fd_pr__nfet_01v8 w=10 l=0.15 nf=1 m=1
XTRACK_P VIN CLKB HOLD VPWR sky130_fd_pr__pfet_01v8_hvt w=20 l=0.15 nf=1 m=1
.ends PRACTICAL_SAMPLE_SWITCH
.subckt adc_track_hold VIN CLK HOLD OUT VCM BIAS VPWR VGND
XHOLD_READOUT_BUFFER HOLD OUT BIAS OUT VPWR VGND SOC_OTA
XSELF_BIAS BIAS VCM VPWR VGND SOC_BIAS
XTRACK_AND_STORAGE VIN CLK HOLD VCM VPWR VGND PRACTICAL_SAMPLE_SWITCH
.ends adc_track_hold

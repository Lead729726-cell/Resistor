.subckt SOC_OTA_FIRST INP INN BIAS OUT VPWR VGND
XN_INN0 MIR INN TAIL VGND sky130_fd_pr__nfet_01v8 w=5 l=1 nf=1 m=1
XN_INN1 MIR INN TAIL VGND sky130_fd_pr__nfet_01v8 w=5 l=1 nf=1 m=1
XN_INP0 OUT INP TAIL VGND sky130_fd_pr__nfet_01v8 w=5 l=1 nf=1 m=1
XN_INP1 OUT INP TAIL VGND sky130_fd_pr__nfet_01v8 w=5 l=1 nf=1 m=1
XN_TAIL TAIL BIAS VGND VGND sky130_fd_pr__nfet_01v8 w=2 l=1 nf=1 m=1
XP_DIODE MIR MIR VPWR VPWR sky130_fd_pr__pfet_01v8_hvt w=20 l=1 nf=1 m=1
XP_MIRROR OUT MIR VPWR VPWR sky130_fd_pr__pfet_01v8_hvt w=20 l=1 nf=1 m=1
.ends SOC_OTA_FIRST
.subckt SOC_OTA INP INN BIAS OUT VPWR VGND
CC_MILLER PRE COMP 5e-12
XFIRST INP INN BIAS PRE VPWR VGND SOC_OTA_FIRST
XN_SECOND OUT BIAS VGND VGND sky130_fd_pr__nfet_01v8 w=2 l=1 nf=1 m=1
XP_SECOND OUT PRE VPWR VPWR sky130_fd_pr__pfet_01v8_hvt w=40 l=1 nf=1 m=1
RR_ZERO COMP OUT 5000
.ends SOC_OTA
.subckt SOC_BIAS BIAS VCM VPWR VGND
CC_VCM VCM_RAW VGND 2e-11
XN_DIODE BIAS BIAS VGND VGND sky130_fd_pr__nfet_01v8 w=2 l=1 nf=1 m=1
RR_BIAS VPWR BIAS 30000
RR_VCM_BOTTOM VCM_RAW VGND 100000
RR_VCM_TOP VPWR VCM_RAW 100000
XVCM_BUFFER VCM_RAW VCM BIAS VCM VPWR VGND SOC_OTA
.ends SOC_BIAS
.subckt PRACTICAL_HYSTERESIS VIN SUM OUT
RINPUT_RESISTANCE VIN SUM 100000
RPOSITIVE_FEEDBACK OUT SUM 1000000
.ends PRACTICAL_HYSTERESIS
.subckt PREAMP INP INN BIAS OUT VPWR VGND
XN_INN MIR INN TAIL VGND sky130_fd_pr__nfet_01v8 w=10 l=1 nf=1 m=1
XN_INP OUT INP TAIL VGND sky130_fd_pr__nfet_01v8 w=10 l=1 nf=1 m=1
XN_TAIL TAIL BIAS VGND VGND sky130_fd_pr__nfet_01v8 w=2 l=1 nf=1 m=1
XP_DIODE MIR MIR VPWR VPWR sky130_fd_pr__pfet_01v8_hvt w=20 l=1 nf=1 m=1
XP_MIRROR OUT MIR VPWR VPWR sky130_fd_pr__pfet_01v8_hvt w=20 l=1 nf=1 m=1
.ends PREAMP
.subckt SOC_COMPARATOR INP INN BIAS OUT VPWR VGND
XN_OUT OUT PRE VGND VGND sky130_fd_pr__nfet_01v8 w=4 l=0.15 nf=1 m=1
XPREAMP INP INN BIAS PRE VPWR VGND PREAMP
XP_OUT OUT PRE VPWR VPWR sky130_fd_pr__pfet_01v8_hvt w=8 l=0.15 nf=1 m=1
.ends SOC_COMPARATOR
.subckt sensor_schmitt VIN SUM OUT VCM BIAS VPWR VGND
XHYSTERESIS_NETWORK VIN SUM OUT PRACTICAL_HYSTERESIS
XMOS_COMPARATOR SUM VCM BIAS OUT VPWR VGND SOC_COMPARATOR
XSELF_BIAS BIAS VCM VPWR VGND SOC_BIAS
.ends sensor_schmitt

.subckt NOR2 A B Y VPWR VGND
XN0 Y A VGND VGND sky130_fd_pr__nfet_01v8 w=0.65 l=0.15 nf=1 m=1
XN1 Y B VGND VGND sky130_fd_pr__nfet_01v8 w=0.65 l=0.15 nf=1 m=1
XP0 P A VPWR VPWR sky130_fd_pr__pfet_01v8_hvt w=0.65 l=0.15 nf=1 m=1
XP1 Y B P VPWR sky130_fd_pr__pfet_01v8_hvt w=0.65 l=0.15 nf=1 m=1
.ends NOR2
.subckt INV A Y VPWR VGND
XMN Y A VGND VGND sky130_fd_pr__nfet_01v8 w=0.65 l=0.15 nf=1 m=1
XMP Y A VPWR VPWR sky130_fd_pr__pfet_01v8_hvt w=0.65 l=0.15 nf=1 m=1
.ends INV
.subckt OR2 A B Y VPWR VGND
XINV N Y VPWR VGND INV
XNOR A B N VPWR VGND NOR2
.ends OR2
.subckt sdm8_scale_saturate FILTERED0 FILTERED1 FILTERED2 FILTERED3 FILTERED4 FILTERED5 FILTERED6 FILTERED7 FILTERED8 FILTERED9 FILTERED10 FILTERED11 FILTERED12 FILTERED13 FILTERED14 FILTERED15 FILTERED16 CODE0 CODE1 CODE2 CODE3 CODE4 CODE5 CODE6 CODE7 VPWR VGND
XG0 FILTERED8 FILTERED16 CODE0 VPWR VGND OR2
XG1 FILTERED16 FILTERED9 CODE1 VPWR VGND OR2
XG2 FILTERED16 FILTERED10 CODE2 VPWR VGND OR2
XG3 FILTERED16 FILTERED11 CODE3 VPWR VGND OR2
XG4 FILTERED16 FILTERED12 CODE4 VPWR VGND OR2
XG5 FILTERED16 FILTERED13 CODE5 VPWR VGND OR2
XG6 FILTERED16 FILTERED14 CODE6 VPWR VGND OR2
XG7 FILTERED16 FILTERED15 CODE7 VPWR VGND OR2
.ends sdm8_scale_saturate

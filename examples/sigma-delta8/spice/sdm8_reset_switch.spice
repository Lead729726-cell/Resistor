.subckt sdm8_reset_switch RESET RESETB VCM SUM OUT VPWR VGND
XN_RESET0 SUM RESET VCM VGND sky130_fd_pr__nfet_01v8 w=2 l=0.15 nf=1 m=1
XN_RESET1 OUT RESET VCM VGND sky130_fd_pr__nfet_01v8 w=2 l=0.15 nf=1 m=1
XP_RESET0 SUM RESETB VCM VPWR sky130_fd_pr__pfet_01v8_hvt w=4 l=0.15 nf=1 m=1
XP_RESET1 OUT RESETB VCM VPWR sky130_fd_pr__pfet_01v8_hvt w=4 l=0.15 nf=1 m=1
.ends sdm8_reset_switch

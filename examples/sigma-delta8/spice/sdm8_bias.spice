.subckt sdm8_bias BIAS VPWR VGND
XN_DIODE BIAS BIAS VGND VGND sky130_fd_pr__nfet_01v8 w=2 l=1 nf=1 m=1
RR_BIAS VPWR BIAS 200000
.ends sdm8_bias

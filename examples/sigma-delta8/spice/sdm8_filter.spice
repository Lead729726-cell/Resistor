.subckt INV A Y VPWR VGND
XMN Y A VGND VGND sky130_fd_pr__nfet_01v8 w=0.65 l=0.15 nf=1 m=1
XMP Y A VPWR VPWR sky130_fd_pr__pfet_01v8_hvt w=0.65 l=0.15 nf=1 m=1
.ends INV
.subckt NAND2 A0 A1 Y VPWR VGND
XMN0 Y A0 N1 VGND sky130_fd_pr__nfet_01v8 w=0.65 l=0.15 nf=1 m=1
XMN1 N1 A1 VGND VGND sky130_fd_pr__nfet_01v8 w=0.65 l=0.15 nf=1 m=1
XMP0 Y A0 VPWR VPWR sky130_fd_pr__pfet_01v8_hvt w=0.65 l=0.15 nf=1 m=1
XMP1 Y A1 VPWR VPWR sky130_fd_pr__pfet_01v8_hvt w=0.65 l=0.15 nf=1 m=1
.ends NAND2
.subckt AND2 A B Y VPWR VGND
XI1 N Y VPWR VGND INV
XN1 A B N VPWR VGND NAND2
.ends AND2
.subckt NOR2 A B Y VPWR VGND
XN0 Y A VGND VGND sky130_fd_pr__nfet_01v8 w=0.65 l=0.15 nf=1 m=1
XN1 Y B VGND VGND sky130_fd_pr__nfet_01v8 w=0.65 l=0.15 nf=1 m=1
XP0 P A VPWR VPWR sky130_fd_pr__pfet_01v8_hvt w=0.65 l=0.15 nf=1 m=1
XP1 Y B P VPWR sky130_fd_pr__pfet_01v8_hvt w=0.65 l=0.15 nf=1 m=1
.ends NOR2
.subckt OR2 A B Y VPWR VGND
XINV N Y VPWR VGND INV
XNOR A B N VPWR VGND NOR2
.ends OR2
.subckt XOR2 A B Y VPWR VGND
XN1 A B N1 VPWR VGND NAND2
XN2 A N1 N2 VPWR VGND NAND2
XN3 B N1 N3 VPWR VGND NAND2
XN4 N2 N3 Y VPWR VGND NAND2
.ends XOR2
.subckt MUX2 A B S Y VPWR VGND
XIS S SB VPWR VGND INV
XMNA Y SB A VGND sky130_fd_pr__nfet_01v8 w=0.65 l=0.15 nf=1 m=1
XMNB Y S B VGND sky130_fd_pr__nfet_01v8 w=0.65 l=0.15 nf=1 m=1
XMPA Y S A VPWR sky130_fd_pr__pfet_01v8_hvt w=0.65 l=0.15 nf=1 m=1
XMPB Y SB B VPWR sky130_fd_pr__pfet_01v8_hvt w=0.65 l=0.15 nf=1 m=1
.ends MUX2
.subckt DFF D CLK Q VPWR VGND
XICLK CLK CLKB VPWR VGND INV
XM1 M MB VPWR VGND INV
XM2 MB MF VPWR VGND INV
XMNIN M CLKB D VGND sky130_fd_pr__nfet_01v8 w=0.65 l=0.15 nf=1 m=1
XMNMF M CLK MF VGND sky130_fd_pr__nfet_01v8 w=0.65 l=0.15 nf=1 m=1
XMNOUT T CLK MF VGND sky130_fd_pr__nfet_01v8 w=0.65 l=0.15 nf=1 m=1
XMNSF T CLKB Q VGND sky130_fd_pr__nfet_01v8 w=0.65 l=0.15 nf=1 m=1
XMPIN M CLK D VPWR sky130_fd_pr__pfet_01v8_hvt w=0.65 l=0.15 nf=1 m=1
XMPMF M CLKB MF VPWR sky130_fd_pr__pfet_01v8_hvt w=0.65 l=0.15 nf=1 m=1
XMPOUT T CLKB MF VPWR sky130_fd_pr__pfet_01v8_hvt w=0.65 l=0.15 nf=1 m=1
XMPSF T CLK Q VPWR sky130_fd_pr__pfet_01v8_hvt w=0.65 l=0.15 nf=1 m=1
XS1 T TB VPWR VGND INV
XS2 TB Q VPWR VGND INV
.ends DFF
.subckt DFF_N D CLK Q VPWR VGND
XCLOCK CLK CLKB VPWR VGND INV
XLATCH D CLKB Q VPWR VGND DFF
.ends DFF_N
.subckt SDM8_CIC_COMBS CLK RESET ENABLE SUM0 SUM1 SUM2 SUM3 SUM4 SUM5 SUM6 SUM7 SUM8 SUM9 SUM10 SUM11 SUM12 SUM13 SUM14 SUM15 SUM16 FILTERED0 FILTERED1 FILTERED2 FILTERED3 FILTERED4 FILTERED5 FILTERED6 FILTERED7 FILTERED8 FILTERED9 FILTERED10 FILTERED11 FILTERED12 FILTERED13 FILTERED14 FILTERED15 FILTERED16 VPWR VGND
XG0 ENABLE N39 VPWR VGND INV
XG1 SUM15 N40 VPWR VGND INV
XG10 SUM6 N49 VPWR VGND INV
XG100 N141 N144 N156 VPWR VGND OR2
XG101 N143 N156 N157 VPWR VGND AND2
XG102 N155 N157 N158 VPWR VGND OR2
XG103 N155 N157 N159 VPWR VGND XOR2
XG104 N159 N160 VPWR VGND INV
XG105 N39 N159 N161 VPWR VGND OR2
XG106 ENABLE N162 N163 VPWR VGND OR2
XG107 N60 N163 N164 VPWR VGND AND2
XG108 N161 N164 N165 VPWR VGND AND2
XG109 N154 N158 N166 VPWR VGND AND2
XG11 SUM5 N50 VPWR VGND INV
XG110 N167 N46 N168 VPWR VGND OR2
XG111 N167 N46 N169 VPWR VGND AND2
XG112 N167 SUM9 N170 VPWR VGND XOR2
XG113 N170 N171 VPWR VGND INV
XG114 N166 N171 N172 VPWR VGND XOR2
XG115 N172 N173 VPWR VGND INV
XG116 N39 N173 N174 VPWR VGND OR2
XG117 ENABLE N175 N176 VPWR VGND OR2
XG118 N60 N176 N177 VPWR VGND AND2
XG119 N174 N177 N178 VPWR VGND AND2
XG12 SUM4 N51 VPWR VGND INV
XG120 N179 N45 N180 VPWR VGND OR2
XG121 N179 SUM10 N181 VPWR VGND XOR2
XG122 N166 N169 N182 VPWR VGND OR2
XG123 N168 N182 N183 VPWR VGND AND2
XG124 N181 N183 N184 VPWR VGND OR2
XG125 N181 N183 N185 VPWR VGND XOR2
XG126 N185 N186 VPWR VGND INV
XG127 N39 N185 N187 VPWR VGND OR2
XG128 ENABLE N188 N189 VPWR VGND OR2
XG129 N60 N189 N190 VPWR VGND AND2
XG13 SUM3 N52 VPWR VGND INV
XG130 N187 N190 N191 VPWR VGND AND2
XG131 N180 N184 N192 VPWR VGND AND2
XG132 N193 N44 N194 VPWR VGND OR2
XG133 N193 N44 N195 VPWR VGND AND2
XG134 N193 SUM11 N196 VPWR VGND XOR2
XG135 N192 N196 N197 VPWR VGND XOR2
XG136 N197 N198 VPWR VGND INV
XG137 N39 N197 N199 VPWR VGND OR2
XG138 ENABLE N200 N201 VPWR VGND OR2
XG139 N60 N201 N202 VPWR VGND AND2
XG14 SUM2 N53 VPWR VGND INV
XG140 N199 N202 N203 VPWR VGND AND2
XG141 N204 N43 N205 VPWR VGND OR2
XG142 N204 SUM12 N206 VPWR VGND XOR2
XG143 N192 N195 N207 VPWR VGND OR2
XG144 N194 N207 N208 VPWR VGND AND2
XG145 N206 N208 N209 VPWR VGND OR2
XG146 N206 N208 N210 VPWR VGND XOR2
XG147 N210 N211 VPWR VGND INV
XG148 N39 N210 N212 VPWR VGND OR2
XG149 ENABLE N213 N214 VPWR VGND OR2
XG15 SUM1 N54 VPWR VGND INV
XG150 N60 N214 N215 VPWR VGND AND2
XG151 N212 N215 N216 VPWR VGND AND2
XG152 N205 N209 N217 VPWR VGND AND2
XG153 N218 N42 N219 VPWR VGND OR2
XG154 N218 N42 N220 VPWR VGND AND2
XG155 N218 SUM13 N221 VPWR VGND XOR2
XG156 N221 N222 VPWR VGND INV
XG157 N217 N222 N223 VPWR VGND XOR2
XG158 N223 N224 VPWR VGND INV
XG159 N39 N224 N225 VPWR VGND OR2
XG16 N55 N56 VPWR VGND INV
XG160 ENABLE N226 N227 VPWR VGND OR2
XG161 N60 N227 N228 VPWR VGND AND2
XG162 N225 N228 N229 VPWR VGND AND2
XG163 N230 N41 N231 VPWR VGND OR2
XG164 N230 SUM14 N232 VPWR VGND XOR2
XG165 N217 N220 N233 VPWR VGND OR2
XG166 N219 N233 N234 VPWR VGND AND2
XG167 N232 N234 N235 VPWR VGND OR2
XG168 N232 N234 N236 VPWR VGND XOR2
XG169 N236 N237 VPWR VGND INV
XG17 SUM0 N57 VPWR VGND INV
XG170 N39 N236 N238 VPWR VGND OR2
XG171 ENABLE N239 N240 VPWR VGND OR2
XG172 N60 N240 N241 VPWR VGND AND2
XG173 N238 N241 N242 VPWR VGND AND2
XG174 N231 N235 N243 VPWR VGND AND2
XG175 N244 N40 N245 VPWR VGND OR2
XG176 N244 N40 N246 VPWR VGND AND2
XG177 N244 SUM15 N247 VPWR VGND XOR2
XG178 N243 N247 N248 VPWR VGND XOR2
XG179 N248 N249 VPWR VGND INV
XG18 N58 N59 VPWR VGND INV
XG180 N39 N248 N250 VPWR VGND OR2
XG181 ENABLE N251 N252 VPWR VGND OR2
XG182 N60 N252 N253 VPWR VGND AND2
XG183 N250 N253 N254 VPWR VGND AND2
XG184 N243 N246 N255 VPWR VGND OR2
XG185 N245 N255 N256 VPWR VGND AND2
XG186 N257 SUM16 N258 VPWR VGND XOR2
XG187 N256 N258 N259 VPWR VGND XOR2
XG188 N39 N259 N260 VPWR VGND OR2
XG189 ENABLE N261 N262 VPWR VGND OR2
XG19 RESET N60 VPWR VGND INV
XG190 N60 N262 N263 VPWR VGND AND2
XG191 N260 N263 N264 VPWR VGND AND2
XG192 N55 SUM0 ENABLE N265 VPWR VGND MUX2
XG193 N60 N265 N266 VPWR VGND AND2
XG194 N70 SUM1 ENABLE N267 VPWR VGND MUX2
XG195 N60 N267 N268 VPWR VGND AND2
XG196 N81 SUM2 ENABLE N269 VPWR VGND MUX2
XG197 N60 N269 N270 VPWR VGND AND2
XG198 N93 SUM3 ENABLE N271 VPWR VGND MUX2
XG199 N60 N271 N272 VPWR VGND AND2
XG2 SUM14 N41 VPWR VGND INV
XG20 N55 N57 N61 VPWR VGND AND2
XG200 N104 SUM4 ENABLE N273 VPWR VGND MUX2
XG201 N60 N273 N274 VPWR VGND AND2
XG202 N118 SUM5 ENABLE N275 VPWR VGND MUX2
XG203 N60 N275 N276 VPWR VGND AND2
XG204 N130 SUM6 ENABLE N277 VPWR VGND MUX2
XG205 N60 N277 N278 VPWR VGND AND2
XG206 N142 SUM7 ENABLE N279 VPWR VGND MUX2
XG207 N60 N279 N280 VPWR VGND AND2
XG208 N153 SUM8 ENABLE N281 VPWR VGND MUX2
XG209 N60 N281 N282 VPWR VGND AND2
XG21 N56 SUM0 N62 VPWR VGND OR2
XG210 N167 SUM9 ENABLE N283 VPWR VGND MUX2
XG211 N60 N283 N284 VPWR VGND AND2
XG212 N179 SUM10 ENABLE N285 VPWR VGND MUX2
XG213 N60 N285 N286 VPWR VGND AND2
XG214 N193 SUM11 ENABLE N287 VPWR VGND MUX2
XG215 N60 N287 N288 VPWR VGND AND2
XG216 N204 SUM12 ENABLE N289 VPWR VGND MUX2
XG217 N60 N289 N290 VPWR VGND AND2
XG218 N218 SUM13 ENABLE N291 VPWR VGND MUX2
XG219 N60 N291 N292 VPWR VGND AND2
XG22 N55 SUM0 N63 VPWR VGND XOR2
XG220 N230 SUM14 ENABLE N293 VPWR VGND MUX2
XG221 N60 N293 N294 VPWR VGND AND2
XG222 N244 SUM15 ENABLE N295 VPWR VGND MUX2
XG223 N60 N295 N296 VPWR VGND AND2
XG224 N257 SUM16 ENABLE N297 VPWR VGND MUX2
XG225 N60 N297 N298 VPWR VGND AND2
XG226 N66 N64 N299 VPWR VGND AND2
XG227 N66 N63 FILTERED0 VPWR VGND XOR2
XG228 N58 N74 N300 VPWR VGND OR2
XG229 N59 N74 N301 VPWR VGND XOR2
XG23 N63 N64 VPWR VGND INV
XG230 N299 N301 N302 VPWR VGND OR2
XG231 N299 N301 FILTERED1 VPWR VGND XOR2
XG232 N300 N302 N303 VPWR VGND AND2
XG233 N88 N86 N304 VPWR VGND OR2
XG234 N88 N85 N305 VPWR VGND XOR2
XG235 N303 N305 N306 VPWR VGND OR2
XG236 N303 N305 FILTERED2 VPWR VGND XOR2
XG237 N304 N306 N307 VPWR VGND AND2
XG238 N100 N98 N308 VPWR VGND OR2
XG239 N100 N97 N309 VPWR VGND XOR2
XG24 N39 N63 N65 VPWR VGND OR2
XG240 N307 N309 N310 VPWR VGND OR2
XG241 N307 N309 FILTERED3 VPWR VGND XOR2
XG242 N308 N310 N311 VPWR VGND AND2
XG243 N113 N111 N312 VPWR VGND OR2
XG244 N113 N110 N313 VPWR VGND XOR2
XG245 N311 N313 N314 VPWR VGND OR2
XG246 N311 N313 FILTERED4 VPWR VGND XOR2
XG247 N312 N314 N315 VPWR VGND AND2
XG248 N125 N123 N316 VPWR VGND OR2
XG249 N125 N122 N317 VPWR VGND XOR2
XG25 ENABLE N66 N67 VPWR VGND OR2
XG250 N315 N317 N318 VPWR VGND OR2
XG251 N315 N317 FILTERED5 VPWR VGND XOR2
XG252 N316 N318 N319 VPWR VGND AND2
XG253 N137 N135 N320 VPWR VGND OR2
XG254 N137 N134 N321 VPWR VGND XOR2
XG255 N319 N321 N322 VPWR VGND OR2
XG256 N319 N321 FILTERED6 VPWR VGND XOR2
XG257 N320 N322 N323 VPWR VGND AND2
XG258 N149 N147 N324 VPWR VGND OR2
XG259 N149 N146 N325 VPWR VGND XOR2
XG26 N60 N67 N68 VPWR VGND AND2
XG260 N323 N325 N326 VPWR VGND OR2
XG261 N323 N325 FILTERED7 VPWR VGND XOR2
XG262 N324 N326 N327 VPWR VGND AND2
XG263 N162 N160 N328 VPWR VGND OR2
XG264 N162 N159 N329 VPWR VGND XOR2
XG265 N327 N329 N330 VPWR VGND OR2
XG266 N327 N329 FILTERED8 VPWR VGND XOR2
XG267 N328 N330 N331 VPWR VGND AND2
XG268 N175 N172 N332 VPWR VGND OR2
XG269 N175 N172 N333 VPWR VGND AND2
XG27 N65 N68 N69 VPWR VGND AND2
XG270 N175 N173 N334 VPWR VGND XOR2
XG271 N331 N334 FILTERED9 VPWR VGND XOR2
XG272 N188 N186 N335 VPWR VGND OR2
XG273 N188 N185 N336 VPWR VGND XOR2
XG274 N331 N332 N337 VPWR VGND AND2
XG275 N333 N337 N338 VPWR VGND OR2
XG276 N336 N338 N339 VPWR VGND OR2
XG277 N336 N338 FILTERED10 VPWR VGND XOR2
XG278 N335 N339 N340 VPWR VGND AND2
XG279 N200 N198 N341 VPWR VGND OR2
XG28 N70 N54 N71 VPWR VGND OR2
XG280 N200 N197 N342 VPWR VGND XOR2
XG281 N340 N342 N343 VPWR VGND OR2
XG282 N340 N342 FILTERED11 VPWR VGND XOR2
XG283 N341 N343 N344 VPWR VGND AND2
XG284 N213 N211 N345 VPWR VGND OR2
XG285 N213 N210 N346 VPWR VGND XOR2
XG286 N344 N346 N347 VPWR VGND OR2
XG287 N344 N346 FILTERED12 VPWR VGND XOR2
XG288 N345 N347 N348 VPWR VGND AND2
XG289 N226 N223 N349 VPWR VGND OR2
XG29 N70 SUM1 N72 VPWR VGND XOR2
XG290 N226 N223 N350 VPWR VGND AND2
XG291 N226 N224 N351 VPWR VGND XOR2
XG292 N348 N351 FILTERED13 VPWR VGND XOR2
XG293 N239 N237 N352 VPWR VGND OR2
XG294 N239 N236 N353 VPWR VGND XOR2
XG295 N348 N349 N354 VPWR VGND AND2
XG296 N350 N354 N355 VPWR VGND OR2
XG297 N353 N355 N356 VPWR VGND OR2
XG298 N353 N355 FILTERED14 VPWR VGND XOR2
XG299 N352 N356 N357 VPWR VGND AND2
XG3 SUM13 N42 VPWR VGND INV
XG30 N61 N72 N73 VPWR VGND OR2
XG300 N251 N249 N358 VPWR VGND OR2
XG301 N251 N248 N359 VPWR VGND XOR2
XG302 N357 N359 N360 VPWR VGND OR2
XG303 N357 N359 FILTERED15 VPWR VGND XOR2
XG304 N358 N360 N361 VPWR VGND AND2
XG305 N261 N259 N362 VPWR VGND XOR2
XG306 N361 N362 FILTERED16 VPWR VGND XOR2
XG307 N69 CLK N66 VPWR VGND DFF_N
XG308 N79 CLK N58 VPWR VGND DFF_N
XG309 N91 CLK N88 VPWR VGND DFF_N
XG31 N62 N72 N74 VPWR VGND XOR2
XG310 N103 CLK N100 VPWR VGND DFF_N
XG311 N116 CLK N113 VPWR VGND DFF_N
XG312 N128 CLK N125 VPWR VGND DFF_N
XG313 N140 CLK N137 VPWR VGND DFF_N
XG314 N152 CLK N149 VPWR VGND DFF_N
XG315 N165 CLK N162 VPWR VGND DFF_N
XG316 N178 CLK N175 VPWR VGND DFF_N
XG317 N191 CLK N188 VPWR VGND DFF_N
XG318 N203 CLK N200 VPWR VGND DFF_N
XG319 N216 CLK N213 VPWR VGND DFF_N
XG32 ENABLE N74 N75 VPWR VGND AND2
XG320 N229 CLK N226 VPWR VGND DFF_N
XG321 N242 CLK N239 VPWR VGND DFF_N
XG322 N254 CLK N251 VPWR VGND DFF_N
XG323 N264 CLK N261 VPWR VGND DFF_N
XG324 N266 CLK N55 VPWR VGND DFF_N
XG325 N268 CLK N70 VPWR VGND DFF_N
XG326 N270 CLK N81 VPWR VGND DFF_N
XG327 N272 CLK N93 VPWR VGND DFF_N
XG328 N274 CLK N104 VPWR VGND DFF_N
XG329 N276 CLK N118 VPWR VGND DFF_N
XG33 ENABLE N58 N76 VPWR VGND OR2
XG330 N278 CLK N130 VPWR VGND DFF_N
XG331 N280 CLK N142 VPWR VGND DFF_N
XG332 N282 CLK N153 VPWR VGND DFF_N
XG333 N284 CLK N167 VPWR VGND DFF_N
XG334 N286 CLK N179 VPWR VGND DFF_N
XG335 N288 CLK N193 VPWR VGND DFF_N
XG336 N290 CLK N204 VPWR VGND DFF_N
XG337 N292 CLK N218 VPWR VGND DFF_N
XG338 N294 CLK N230 VPWR VGND DFF_N
XG339 N296 CLK N244 VPWR VGND DFF_N
XG34 RESET N75 N77 VPWR VGND OR2
XG340 N298 CLK N257 VPWR VGND DFF_N
XG35 N77 N78 VPWR VGND INV
XG36 N76 N78 N79 VPWR VGND AND2
XG37 N71 N73 N80 VPWR VGND AND2
XG38 N81 N53 N82 VPWR VGND OR2
XG39 N81 SUM2 N83 VPWR VGND XOR2
XG4 SUM12 N43 VPWR VGND INV
XG40 N80 N83 N84 VPWR VGND OR2
XG41 N80 N83 N85 VPWR VGND XOR2
XG42 N85 N86 VPWR VGND INV
XG43 N39 N85 N87 VPWR VGND OR2
XG44 ENABLE N88 N89 VPWR VGND OR2
XG45 N60 N89 N90 VPWR VGND AND2
XG46 N87 N90 N91 VPWR VGND AND2
XG47 N82 N84 N92 VPWR VGND AND2
XG48 N93 N52 N94 VPWR VGND OR2
XG49 N93 N52 N95 VPWR VGND AND2
XG5 SUM11 N44 VPWR VGND INV
XG50 N93 SUM3 N96 VPWR VGND XOR2
XG51 N92 N96 N97 VPWR VGND XOR2
XG52 N97 N98 VPWR VGND INV
XG53 N39 N97 N99 VPWR VGND OR2
XG54 ENABLE N100 N101 VPWR VGND OR2
XG55 N60 N101 N102 VPWR VGND AND2
XG56 N99 N102 N103 VPWR VGND AND2
XG57 N104 N51 N105 VPWR VGND OR2
XG58 N104 SUM4 N106 VPWR VGND XOR2
XG59 N92 N95 N107 VPWR VGND OR2
XG6 SUM10 N45 VPWR VGND INV
XG60 N94 N107 N108 VPWR VGND AND2
XG61 N106 N108 N109 VPWR VGND OR2
XG62 N106 N108 N110 VPWR VGND XOR2
XG63 N110 N111 VPWR VGND INV
XG64 N39 N110 N112 VPWR VGND OR2
XG65 ENABLE N113 N114 VPWR VGND OR2
XG66 N60 N114 N115 VPWR VGND AND2
XG67 N112 N115 N116 VPWR VGND AND2
XG68 N105 N109 N117 VPWR VGND AND2
XG69 N118 N50 N119 VPWR VGND OR2
XG7 SUM9 N46 VPWR VGND INV
XG70 N118 SUM5 N120 VPWR VGND XOR2
XG71 N117 N120 N121 VPWR VGND OR2
XG72 N117 N120 N122 VPWR VGND XOR2
XG73 N122 N123 VPWR VGND INV
XG74 N39 N122 N124 VPWR VGND OR2
XG75 ENABLE N125 N126 VPWR VGND OR2
XG76 N60 N126 N127 VPWR VGND AND2
XG77 N124 N127 N128 VPWR VGND AND2
XG78 N119 N121 N129 VPWR VGND AND2
XG79 N130 N49 N131 VPWR VGND OR2
XG8 SUM8 N47 VPWR VGND INV
XG80 N130 SUM6 N132 VPWR VGND XOR2
XG81 N129 N132 N133 VPWR VGND OR2
XG82 N129 N132 N134 VPWR VGND XOR2
XG83 N134 N135 VPWR VGND INV
XG84 N39 N134 N136 VPWR VGND OR2
XG85 ENABLE N137 N138 VPWR VGND OR2
XG86 N60 N138 N139 VPWR VGND AND2
XG87 N136 N139 N140 VPWR VGND AND2
XG88 N131 N133 N141 VPWR VGND AND2
XG89 N142 N48 N143 VPWR VGND OR2
XG9 SUM7 N48 VPWR VGND INV
XG90 N142 N48 N144 VPWR VGND AND2
XG91 N142 SUM7 N145 VPWR VGND XOR2
XG92 N141 N145 N146 VPWR VGND XOR2
XG93 N146 N147 VPWR VGND INV
XG94 N39 N146 N148 VPWR VGND OR2
XG95 ENABLE N149 N150 VPWR VGND OR2
XG96 N60 N150 N151 VPWR VGND AND2
XG97 N148 N151 N152 VPWR VGND AND2
XG98 N153 N47 N154 VPWR VGND OR2
XG99 N153 SUM8 N155 VPWR VGND XOR2
.ends SDM8_CIC_COMBS
.subckt SDM8_RESET_SYNC CLK RESET RESET_INTERNAL VPWR VGND
XG0 N5 RESET N6 VPWR VGND OR2
XG1 RESET CLK N5 VPWR VGND DFF_N
XG2 N6 CLK RESET_INTERNAL VPWR VGND DFF_N
.ends SDM8_RESET_SYNC
.subckt SDM8_FRAME_COUNTER CLK RESET LAST_SAMPLE VPWR VGND
XG0 RESET N5 VPWR VGND INV
XG1 N6 N7 VPWR VGND INV
XG10 N6 N8 N20 VPWR VGND OR2
XG11 N5 N20 N21 VPWR VGND AND2
XG12 N19 N21 N22 VPWR VGND AND2
XG13 N10 N18 N23 VPWR VGND AND2
XG14 N11 N19 N24 VPWR VGND OR2
XG15 N10 N18 N25 VPWR VGND OR2
XG16 N5 N25 N26 VPWR VGND AND2
XG17 N24 N26 N27 VPWR VGND AND2
XG18 N12 N23 N28 VPWR VGND AND2
XG19 N13 N24 N29 VPWR VGND OR2
XG2 N8 N9 VPWR VGND INV
XG20 N12 N23 N30 VPWR VGND OR2
XG21 N5 N30 N31 VPWR VGND AND2
XG22 N29 N31 N32 VPWR VGND AND2
XG23 N14 N28 N33 VPWR VGND AND2
XG24 N15 N29 N34 VPWR VGND OR2
XG25 N14 N28 N35 VPWR VGND OR2
XG26 N5 N35 N36 VPWR VGND AND2
XG27 N34 N36 N37 VPWR VGND AND2
XG28 N38 N33 N39 VPWR VGND AND2
XG29 N39 N40 VPWR VGND INV
XG3 N10 N11 VPWR VGND INV
XG30 N38 N33 N41 VPWR VGND OR2
XG31 N5 N41 N42 VPWR VGND AND2
XG32 N40 N42 N43 VPWR VGND AND2
XG33 N44 N39 N45 VPWR VGND AND2
XG34 N45 N46 VPWR VGND INV
XG35 N44 N39 N47 VPWR VGND OR2
XG36 N5 N47 N48 VPWR VGND AND2
XG37 N46 N48 N49 VPWR VGND AND2
XG38 N50 N45 LAST_SAMPLE VPWR VGND AND2
XG39 LAST_SAMPLE N51 VPWR VGND INV
XG4 N12 N13 VPWR VGND INV
XG40 N50 N45 N52 VPWR VGND OR2
XG41 N5 N52 N53 VPWR VGND AND2
XG42 N51 N53 N54 VPWR VGND AND2
XG43 N17 CLK N6 VPWR VGND DFF_N
XG44 N22 CLK N8 VPWR VGND DFF_N
XG45 N27 CLK N10 VPWR VGND DFF_N
XG46 N32 CLK N12 VPWR VGND DFF_N
XG47 N37 CLK N14 VPWR VGND DFF_N
XG48 N43 CLK N38 VPWR VGND DFF_N
XG49 N49 CLK N44 VPWR VGND DFF_N
XG5 N14 N15 VPWR VGND INV
XG50 N54 CLK N50 VPWR VGND DFF_N
XG6 RESET N6 N16 VPWR VGND OR2
XG7 N16 N17 VPWR VGND INV
XG8 N6 N8 N18 VPWR VGND AND2
XG9 N7 N9 N19 VPWR VGND OR2
.ends SDM8_FRAME_COUNTER
.subckt SDM8_CIC_INTEGRATORS CLK RESET BIT_IN NEXT_SUM0 NEXT_SUM1 NEXT_SUM2 NEXT_SUM3 NEXT_SUM4 NEXT_SUM5 NEXT_SUM6 NEXT_SUM7 NEXT_SUM8 NEXT_SUM9 NEXT_SUM10 NEXT_SUM11 NEXT_SUM12 NEXT_SUM13 NEXT_SUM14 NEXT_SUM15 NEXT_SUM16 VPWR VGND
XG0 RESET N22 VPWR VGND INV
XG1 BIT_IN N23 N24 VPWR VGND AND2
XG10 N27 N34 N35 VPWR VGND AND2
XG100 N128 N134 NEXT_SUM12 VPWR VGND XOR2
XG101 N22 NEXT_SUM12 N136 VPWR VGND AND2
XG102 N133 N135 N137 VPWR VGND OR2
XG103 N138 N130 N139 VPWR VGND AND2
XG104 N138 N130 N140 VPWR VGND XOR2
XG105 N141 N140 N142 VPWR VGND AND2
XG106 N141 N140 N143 VPWR VGND OR2
XG107 N141 N140 N144 VPWR VGND XOR2
XG108 N137 N144 NEXT_SUM13 VPWR VGND XOR2
XG109 N22 NEXT_SUM13 N145 VPWR VGND AND2
XG11 N27 N34 NEXT_SUM1 VPWR VGND XOR2
XG110 N146 N139 N147 VPWR VGND AND2
XG111 N146 N139 N148 VPWR VGND XOR2
XG112 N149 N148 N150 VPWR VGND AND2
XG113 N149 N148 N151 VPWR VGND XOR2
XG114 N137 N142 N152 VPWR VGND OR2
XG115 N143 N152 N153 VPWR VGND AND2
XG116 N151 N153 N154 VPWR VGND AND2
XG117 N151 N153 NEXT_SUM14 VPWR VGND XOR2
XG118 N22 NEXT_SUM14 N155 VPWR VGND AND2
XG119 N150 N154 N156 VPWR VGND OR2
XG12 N22 NEXT_SUM1 N36 VPWR VGND AND2
XG120 N157 N147 N158 VPWR VGND AND2
XG121 N157 N147 N159 VPWR VGND XOR2
XG122 N160 N159 N161 VPWR VGND AND2
XG123 N160 N159 N162 VPWR VGND OR2
XG124 N160 N159 N163 VPWR VGND XOR2
XG125 N156 N163 NEXT_SUM15 VPWR VGND XOR2
XG126 N22 NEXT_SUM15 N164 VPWR VGND AND2
XG127 N156 N162 N165 VPWR VGND AND2
XG128 N161 N165 N166 VPWR VGND OR2
XG129 N167 N158 N168 VPWR VGND XOR2
XG13 N33 N35 N37 VPWR VGND OR2
XG130 N169 N168 N170 VPWR VGND XOR2
XG131 N166 N170 NEXT_SUM16 VPWR VGND XOR2
XG132 N22 NEXT_SUM16 N171 VPWR VGND AND2
XG133 N22 N25 N172 VPWR VGND AND2
XG134 N22 N31 N173 VPWR VGND AND2
XG135 N22 N40 N174 VPWR VGND AND2
XG136 N22 N49 N175 VPWR VGND AND2
XG137 N22 N57 N176 VPWR VGND AND2
XG138 N22 N68 N177 VPWR VGND AND2
XG139 N22 N77 N178 VPWR VGND AND2
XG14 N38 N30 N39 VPWR VGND AND2
XG140 N22 N86 N179 VPWR VGND AND2
XG141 N22 N95 N180 VPWR VGND AND2
XG142 N22 N104 N181 VPWR VGND AND2
XG143 N22 N113 N182 VPWR VGND AND2
XG144 N22 N122 N183 VPWR VGND AND2
XG145 N22 N131 N184 VPWR VGND AND2
XG146 N22 N140 N185 VPWR VGND AND2
XG147 N22 N148 N186 VPWR VGND AND2
XG148 N22 N159 N187 VPWR VGND AND2
XG149 N22 N168 N188 VPWR VGND AND2
XG15 N38 N30 N40 VPWR VGND XOR2
XG150 N28 CLK N26 VPWR VGND DFF_N
XG151 N36 CLK N32 VPWR VGND DFF_N
XG152 N45 CLK N41 VPWR VGND DFF_N
XG153 N54 CLK N50 VPWR VGND DFF_N
XG154 N64 CLK N58 VPWR VGND DFF_N
XG155 N73 CLK N69 VPWR VGND DFF_N
XG156 N82 CLK N78 VPWR VGND DFF_N
XG157 N91 CLK N87 VPWR VGND DFF_N
XG158 N100 CLK N96 VPWR VGND DFF_N
XG159 N109 CLK N105 VPWR VGND DFF_N
XG16 N41 N40 N42 VPWR VGND AND2
XG160 N118 CLK N114 VPWR VGND DFF_N
XG161 N127 CLK N123 VPWR VGND DFF_N
XG162 N136 CLK N132 VPWR VGND DFF_N
XG163 N145 CLK N141 VPWR VGND DFF_N
XG164 N155 CLK N149 VPWR VGND DFF_N
XG165 N164 CLK N160 VPWR VGND DFF_N
XG166 N171 CLK N169 VPWR VGND DFF_N
XG167 N172 CLK N23 VPWR VGND DFF_N
XG168 N173 CLK N29 VPWR VGND DFF_N
XG169 N174 CLK N38 VPWR VGND DFF_N
XG17 N41 N40 N43 VPWR VGND XOR2
XG170 N175 CLK N47 VPWR VGND DFF_N
XG171 N176 CLK N55 VPWR VGND DFF_N
XG172 N177 CLK N66 VPWR VGND DFF_N
XG173 N178 CLK N75 VPWR VGND DFF_N
XG174 N179 CLK N84 VPWR VGND DFF_N
XG175 N180 CLK N93 VPWR VGND DFF_N
XG176 N181 CLK N102 VPWR VGND DFF_N
XG177 N182 CLK N111 VPWR VGND DFF_N
XG178 N183 CLK N120 VPWR VGND DFF_N
XG179 N184 CLK N129 VPWR VGND DFF_N
XG18 N37 N43 N44 VPWR VGND AND2
XG180 N185 CLK N138 VPWR VGND DFF_N
XG181 N186 CLK N146 VPWR VGND DFF_N
XG182 N187 CLK N157 VPWR VGND DFF_N
XG183 N188 CLK N167 VPWR VGND DFF_N
XG19 N37 N43 NEXT_SUM2 VPWR VGND XOR2
XG2 BIT_IN N23 N25 VPWR VGND XOR2
XG20 N22 NEXT_SUM2 N45 VPWR VGND AND2
XG21 N42 N44 N46 VPWR VGND OR2
XG22 N47 N39 N48 VPWR VGND AND2
XG23 N47 N39 N49 VPWR VGND XOR2
XG24 N50 N49 N51 VPWR VGND AND2
XG25 N50 N49 N52 VPWR VGND OR2
XG26 N50 N49 N53 VPWR VGND XOR2
XG27 N46 N53 NEXT_SUM3 VPWR VGND XOR2
XG28 N22 NEXT_SUM3 N54 VPWR VGND AND2
XG29 N55 N48 N56 VPWR VGND AND2
XG3 N26 N25 N27 VPWR VGND AND2
XG30 N55 N48 N57 VPWR VGND XOR2
XG31 N58 N57 N59 VPWR VGND AND2
XG32 N58 N57 N60 VPWR VGND XOR2
XG33 N46 N52 N61 VPWR VGND AND2
XG34 N51 N61 N62 VPWR VGND OR2
XG35 N60 N62 N63 VPWR VGND AND2
XG36 N60 N62 NEXT_SUM4 VPWR VGND XOR2
XG37 N22 NEXT_SUM4 N64 VPWR VGND AND2
XG38 N59 N63 N65 VPWR VGND OR2
XG39 N66 N56 N67 VPWR VGND AND2
XG4 N26 N25 NEXT_SUM0 VPWR VGND XOR2
XG40 N66 N56 N68 VPWR VGND XOR2
XG41 N69 N68 N70 VPWR VGND AND2
XG42 N69 N68 N71 VPWR VGND XOR2
XG43 N65 N71 N72 VPWR VGND AND2
XG44 N65 N71 NEXT_SUM5 VPWR VGND XOR2
XG45 N22 NEXT_SUM5 N73 VPWR VGND AND2
XG46 N70 N72 N74 VPWR VGND OR2
XG47 N75 N67 N76 VPWR VGND AND2
XG48 N75 N67 N77 VPWR VGND XOR2
XG49 N78 N77 N79 VPWR VGND AND2
XG5 N22 NEXT_SUM0 N28 VPWR VGND AND2
XG50 N78 N77 N80 VPWR VGND XOR2
XG51 N74 N80 N81 VPWR VGND AND2
XG52 N74 N80 NEXT_SUM6 VPWR VGND XOR2
XG53 N22 NEXT_SUM6 N82 VPWR VGND AND2
XG54 N79 N81 N83 VPWR VGND OR2
XG55 N84 N76 N85 VPWR VGND AND2
XG56 N84 N76 N86 VPWR VGND XOR2
XG57 N87 N86 N88 VPWR VGND AND2
XG58 N87 N86 N89 VPWR VGND XOR2
XG59 N83 N89 N90 VPWR VGND AND2
XG6 N29 N24 N30 VPWR VGND AND2
XG60 N83 N89 NEXT_SUM7 VPWR VGND XOR2
XG61 N22 NEXT_SUM7 N91 VPWR VGND AND2
XG62 N88 N90 N92 VPWR VGND OR2
XG63 N93 N85 N94 VPWR VGND AND2
XG64 N93 N85 N95 VPWR VGND XOR2
XG65 N96 N95 N97 VPWR VGND AND2
XG66 N96 N95 N98 VPWR VGND XOR2
XG67 N92 N98 N99 VPWR VGND AND2
XG68 N92 N98 NEXT_SUM8 VPWR VGND XOR2
XG69 N22 NEXT_SUM8 N100 VPWR VGND AND2
XG7 N29 N24 N31 VPWR VGND XOR2
XG70 N97 N99 N101 VPWR VGND OR2
XG71 N102 N94 N103 VPWR VGND AND2
XG72 N102 N94 N104 VPWR VGND XOR2
XG73 N105 N104 N106 VPWR VGND AND2
XG74 N105 N104 N107 VPWR VGND XOR2
XG75 N101 N107 N108 VPWR VGND AND2
XG76 N101 N107 NEXT_SUM9 VPWR VGND XOR2
XG77 N22 NEXT_SUM9 N109 VPWR VGND AND2
XG78 N106 N108 N110 VPWR VGND OR2
XG79 N111 N103 N112 VPWR VGND AND2
XG8 N32 N31 N33 VPWR VGND AND2
XG80 N111 N103 N113 VPWR VGND XOR2
XG81 N114 N113 N115 VPWR VGND AND2
XG82 N114 N113 N116 VPWR VGND XOR2
XG83 N110 N116 N117 VPWR VGND AND2
XG84 N110 N116 NEXT_SUM10 VPWR VGND XOR2
XG85 N22 NEXT_SUM10 N118 VPWR VGND AND2
XG86 N115 N117 N119 VPWR VGND OR2
XG87 N120 N112 N121 VPWR VGND AND2
XG88 N120 N112 N122 VPWR VGND XOR2
XG89 N123 N122 N124 VPWR VGND AND2
XG9 N32 N31 N34 VPWR VGND XOR2
XG90 N123 N122 N125 VPWR VGND XOR2
XG91 N119 N125 N126 VPWR VGND AND2
XG92 N119 N125 NEXT_SUM11 VPWR VGND XOR2
XG93 N22 NEXT_SUM11 N127 VPWR VGND AND2
XG94 N124 N126 N128 VPWR VGND OR2
XG95 N129 N121 N130 VPWR VGND AND2
XG96 N129 N121 N131 VPWR VGND XOR2
XG97 N132 N131 N133 VPWR VGND AND2
XG98 N132 N131 N134 VPWR VGND XOR2
XG99 N128 N134 N135 VPWR VGND AND2
.ends SDM8_CIC_INTEGRATORS
.subckt SDM8_OUTPUT_REGISTER CLK RESET ENABLE CODE_IN0 CODE_IN1 CODE_IN2 CODE_IN3 CODE_IN4 CODE_IN5 CODE_IN6 CODE_IN7 CODE0 CODE1 CODE2 CODE3 CODE4 CODE5 CODE6 CODE7 VALID VPWR VGND
XG0 RESET N22 VPWR VGND INV
XG1 ENABLE N22 N23 VPWR VGND AND2
XG10 CODE4 CODE_IN4 ENABLE N32 VPWR VGND MUX2
XG11 N22 N32 N33 VPWR VGND AND2
XG12 CODE5 CODE_IN5 ENABLE N34 VPWR VGND MUX2
XG13 N22 N34 N35 VPWR VGND AND2
XG14 CODE6 CODE_IN6 ENABLE N36 VPWR VGND MUX2
XG15 N22 N36 N37 VPWR VGND AND2
XG16 CODE7 CODE_IN7 ENABLE N38 VPWR VGND MUX2
XG17 N22 N38 N39 VPWR VGND AND2
XG18 N23 CLK VALID VPWR VGND DFF_N
XG19 N25 CLK CODE0 VPWR VGND DFF_N
XG2 CODE0 CODE_IN0 ENABLE N24 VPWR VGND MUX2
XG20 N27 CLK CODE1 VPWR VGND DFF_N
XG21 N29 CLK CODE2 VPWR VGND DFF_N
XG22 N31 CLK CODE3 VPWR VGND DFF_N
XG23 N33 CLK CODE4 VPWR VGND DFF_N
XG24 N35 CLK CODE5 VPWR VGND DFF_N
XG25 N37 CLK CODE6 VPWR VGND DFF_N
XG26 N39 CLK CODE7 VPWR VGND DFF_N
XG3 N22 N24 N25 VPWR VGND AND2
XG4 CODE1 CODE_IN1 ENABLE N26 VPWR VGND MUX2
XG5 N22 N26 N27 VPWR VGND AND2
XG6 CODE2 CODE_IN2 ENABLE N28 VPWR VGND MUX2
XG7 N22 N28 N29 VPWR VGND AND2
XG8 CODE3 CODE_IN3 ENABLE N30 VPWR VGND MUX2
XG9 N22 N30 N31 VPWR VGND AND2
.ends SDM8_OUTPUT_REGISTER
.subckt SDM8_SCALE_SATURATE FILTERED0 FILTERED1 FILTERED2 FILTERED3 FILTERED4 FILTERED5 FILTERED6 FILTERED7 FILTERED8 FILTERED9 FILTERED10 FILTERED11 FILTERED12 FILTERED13 FILTERED14 FILTERED15 FILTERED16 CODE0 CODE1 CODE2 CODE3 CODE4 CODE5 CODE6 CODE7 VPWR VGND
XG0 FILTERED8 FILTERED16 CODE0 VPWR VGND OR2
XG1 FILTERED16 FILTERED9 CODE1 VPWR VGND OR2
XG2 FILTERED16 FILTERED10 CODE2 VPWR VGND OR2
XG3 FILTERED16 FILTERED11 CODE3 VPWR VGND OR2
XG4 FILTERED16 FILTERED12 CODE4 VPWR VGND OR2
XG5 FILTERED16 FILTERED13 CODE5 VPWR VGND OR2
XG6 FILTERED16 FILTERED14 CODE6 VPWR VGND OR2
XG7 FILTERED16 FILTERED15 CODE7 VPWR VGND OR2
.ends SDM8_SCALE_SATURATE
.subckt sdm8_filter CLK RESET BIT_IN CODE0 CODE1 CODE2 CODE3 CODE4 CODE5 CODE6 CODE7 VALID VPWR VGND
XG0 CLK N32 N14 N33 N34 N35 N36 N37 N38 N39 N40 N41 N42 N43 N44 N45 N46 N47 N48 N49 N15 N16 N17 N18 N19 N20 N21 N22 N23 N24 N25 N26 N27 N28 N29 N30 N31 VPWR VGND SDM8_CIC_COMBS
XG1 CLK RESET N32 VPWR VGND SDM8_RESET_SYNC
XG2 CLK N32 N14 VPWR VGND SDM8_FRAME_COUNTER
XG3 CLK N32 BIT_IN N33 N34 N35 N36 N37 N38 N39 N40 N41 N42 N43 N44 N45 N46 N47 N48 N49 VPWR VGND SDM8_CIC_INTEGRATORS
XG4 CLK N32 N14 N50 N51 N52 N53 N54 N55 N56 N57 CODE0 CODE1 CODE2 CODE3 CODE4 CODE5 CODE6 CODE7 VALID VPWR VGND SDM8_OUTPUT_REGISTER
XG5 N15 N16 N17 N18 N19 N20 N21 N22 N23 N24 N25 N26 N27 N28 N29 N30 N31 N50 N51 N52 N53 N54 N55 N56 N57 VPWR VGND SDM8_SCALE_SATURATE
.ends sdm8_filter

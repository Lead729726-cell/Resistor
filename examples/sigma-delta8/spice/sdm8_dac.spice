.subckt INV A Y VPWR VGND
XMN Y A VGND VGND sky130_fd_pr__nfet_01v8 w=0.65 l=0.15 nf=1 m=1
XMP Y A VPWR VPWR sky130_fd_pr__pfet_01v8_hvt w=0.65 l=0.15 nf=1 m=1
.ends INV
.subckt sdm8_dac BITSTREAM DACB VPWR VGND
XNRZ BITSTREAM DACB VPWR VGND INV
.ends sdm8_dac

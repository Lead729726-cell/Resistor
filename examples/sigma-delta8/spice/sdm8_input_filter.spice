.subckt sdm8_input_filter VIN OUT VPWR VGND
CC_AA OUT VGND 1e-10
RR_AA VIN OUT 10000
.ends sdm8_input_filter

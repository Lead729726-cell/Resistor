.subckt INV A Y VPWR VGND
XMN Y A VGND VGND sky130_fd_pr__nfet_01v8 w=0.65 l=0.15 nf=1 m=1
XMP Y A VPWR VPWR sky130_fd_pr__pfet_01v8_hvt w=0.65 l=0.15 nf=1 m=1
.ends INV
.subckt NAND2 A0 A1 Y VPWR VGND
XMN0 Y A0 N1 VGND sky130_fd_pr__nfet_01v8 w=0.65 l=0.15 nf=1 m=1
XMN1 N1 A1 VGND VGND sky130_fd_pr__nfet_01v8 w=0.65 l=0.15 nf=1 m=1
XMP0 Y A0 VPWR VPWR sky130_fd_pr__pfet_01v8_hvt w=0.65 l=0.15 nf=1 m=1
XMP1 Y A1 VPWR VPWR sky130_fd_pr__pfet_01v8_hvt w=0.65 l=0.15 nf=1 m=1
.ends NAND2
.subckt AND2 A B Y VPWR VGND
XI1 N Y VPWR VGND INV
XN1 A B N VPWR VGND NAND2
.ends AND2
.subckt XOR2 A B Y VPWR VGND
XN1 A B N1 VPWR VGND NAND2
XN2 A N1 N2 VPWR VGND NAND2
XN3 B N1 N3 VPWR VGND NAND2
XN4 N2 N3 Y VPWR VGND NAND2
.ends XOR2
.subckt NOR2 A B Y VPWR VGND
XN0 Y A VGND VGND sky130_fd_pr__nfet_01v8 w=0.65 l=0.15 nf=1 m=1
XN1 Y B VGND VGND sky130_fd_pr__nfet_01v8 w=0.65 l=0.15 nf=1 m=1
XP0 P A VPWR VPWR sky130_fd_pr__pfet_01v8_hvt w=0.65 l=0.15 nf=1 m=1
XP1 Y B P VPWR sky130_fd_pr__pfet_01v8_hvt w=0.65 l=0.15 nf=1 m=1
.ends NOR2
.subckt OR2 A B Y VPWR VGND
XINV N Y VPWR VGND INV
XNOR A B N VPWR VGND NOR2
.ends OR2
.subckt DFF D CLK Q VPWR VGND
XICLK CLK CLKB VPWR VGND INV
XM1 M MB VPWR VGND INV
XM2 MB MF VPWR VGND INV
XMNIN M CLKB D VGND sky130_fd_pr__nfet_01v8 w=0.65 l=0.15 nf=1 m=1
XMNMF M CLK MF VGND sky130_fd_pr__nfet_01v8 w=0.65 l=0.15 nf=1 m=1
XMNOUT T CLK MF VGND sky130_fd_pr__nfet_01v8 w=0.65 l=0.15 nf=1 m=1
XMNSF T CLKB Q VGND sky130_fd_pr__nfet_01v8 w=0.65 l=0.15 nf=1 m=1
XMPIN M CLK D VPWR sky130_fd_pr__pfet_01v8_hvt w=0.65 l=0.15 nf=1 m=1
XMPMF M CLKB MF VPWR sky130_fd_pr__pfet_01v8_hvt w=0.65 l=0.15 nf=1 m=1
XMPOUT T CLKB MF VPWR sky130_fd_pr__pfet_01v8_hvt w=0.65 l=0.15 nf=1 m=1
XMPSF T CLK Q VPWR sky130_fd_pr__pfet_01v8_hvt w=0.65 l=0.15 nf=1 m=1
XS1 T TB VPWR VGND INV
XS2 TB Q VPWR VGND INV
.ends DFF
.subckt DFF_N D CLK Q VPWR VGND
XCLOCK CLK CLKB VPWR VGND INV
XLATCH D CLKB Q VPWR VGND DFF
.ends DFF_N
.subckt sdm8_cic_integrators CLK RESET BIT_IN NEXT_SUM0 NEXT_SUM1 NEXT_SUM2 NEXT_SUM3 NEXT_SUM4 NEXT_SUM5 NEXT_SUM6 NEXT_SUM7 NEXT_SUM8 NEXT_SUM9 NEXT_SUM10 NEXT_SUM11 NEXT_SUM12 NEXT_SUM13 NEXT_SUM14 NEXT_SUM15 NEXT_SUM16 VPWR VGND
XG0 RESET N22 VPWR VGND INV
XG1 BIT_IN N23 N24 VPWR VGND AND2
XG10 N27 N34 N35 VPWR VGND AND2
XG100 N128 N134 NEXT_SUM12 VPWR VGND XOR2
XG101 N22 NEXT_SUM12 N136 VPWR VGND AND2
XG102 N133 N135 N137 VPWR VGND OR2
XG103 N138 N130 N139 VPWR VGND AND2
XG104 N138 N130 N140 VPWR VGND XOR2
XG105 N141 N140 N142 VPWR VGND AND2
XG106 N141 N140 N143 VPWR VGND OR2
XG107 N141 N140 N144 VPWR VGND XOR2
XG108 N137 N144 NEXT_SUM13 VPWR VGND XOR2
XG109 N22 NEXT_SUM13 N145 VPWR VGND AND2
XG11 N27 N34 NEXT_SUM1 VPWR VGND XOR2
XG110 N146 N139 N147 VPWR VGND AND2
XG111 N146 N139 N148 VPWR VGND XOR2
XG112 N149 N148 N150 VPWR VGND AND2
XG113 N149 N148 N151 VPWR VGND XOR2
XG114 N137 N142 N152 VPWR VGND OR2
XG115 N143 N152 N153 VPWR VGND AND2
XG116 N151 N153 N154 VPWR VGND AND2
XG117 N151 N153 NEXT_SUM14 VPWR VGND XOR2
XG118 N22 NEXT_SUM14 N155 VPWR VGND AND2
XG119 N150 N154 N156 VPWR VGND OR2
XG12 N22 NEXT_SUM1 N36 VPWR VGND AND2
XG120 N157 N147 N158 VPWR VGND AND2
XG121 N157 N147 N159 VPWR VGND XOR2
XG122 N160 N159 N161 VPWR VGND AND2
XG123 N160 N159 N162 VPWR VGND OR2
XG124 N160 N159 N163 VPWR VGND XOR2
XG125 N156 N163 NEXT_SUM15 VPWR VGND XOR2
XG126 N22 NEXT_SUM15 N164 VPWR VGND AND2
XG127 N156 N162 N165 VPWR VGND AND2
XG128 N161 N165 N166 VPWR VGND OR2
XG129 N167 N158 N168 VPWR VGND XOR2
XG13 N33 N35 N37 VPWR VGND OR2
XG130 N169 N168 N170 VPWR VGND XOR2
XG131 N166 N170 NEXT_SUM16 VPWR VGND XOR2
XG132 N22 NEXT_SUM16 N171 VPWR VGND AND2
XG133 N22 N25 N172 VPWR VGND AND2
XG134 N22 N31 N173 VPWR VGND AND2
XG135 N22 N40 N174 VPWR VGND AND2
XG136 N22 N49 N175 VPWR VGND AND2
XG137 N22 N57 N176 VPWR VGND AND2
XG138 N22 N68 N177 VPWR VGND AND2
XG139 N22 N77 N178 VPWR VGND AND2
XG14 N38 N30 N39 VPWR VGND AND2
XG140 N22 N86 N179 VPWR VGND AND2
XG141 N22 N95 N180 VPWR VGND AND2
XG142 N22 N104 N181 VPWR VGND AND2
XG143 N22 N113 N182 VPWR VGND AND2
XG144 N22 N122 N183 VPWR VGND AND2
XG145 N22 N131 N184 VPWR VGND AND2
XG146 N22 N140 N185 VPWR VGND AND2
XG147 N22 N148 N186 VPWR VGND AND2
XG148 N22 N159 N187 VPWR VGND AND2
XG149 N22 N168 N188 VPWR VGND AND2
XG15 N38 N30 N40 VPWR VGND XOR2
XG150 N28 CLK N26 VPWR VGND DFF_N
XG151 N36 CLK N32 VPWR VGND DFF_N
XG152 N45 CLK N41 VPWR VGND DFF_N
XG153 N54 CLK N50 VPWR VGND DFF_N
XG154 N64 CLK N58 VPWR VGND DFF_N
XG155 N73 CLK N69 VPWR VGND DFF_N
XG156 N82 CLK N78 VPWR VGND DFF_N
XG157 N91 CLK N87 VPWR VGND DFF_N
XG158 N100 CLK N96 VPWR VGND DFF_N
XG159 N109 CLK N105 VPWR VGND DFF_N
XG16 N41 N40 N42 VPWR VGND AND2
XG160 N118 CLK N114 VPWR VGND DFF_N
XG161 N127 CLK N123 VPWR VGND DFF_N
XG162 N136 CLK N132 VPWR VGND DFF_N
XG163 N145 CLK N141 VPWR VGND DFF_N
XG164 N155 CLK N149 VPWR VGND DFF_N
XG165 N164 CLK N160 VPWR VGND DFF_N
XG166 N171 CLK N169 VPWR VGND DFF_N
XG167 N172 CLK N23 VPWR VGND DFF_N
XG168 N173 CLK N29 VPWR VGND DFF_N
XG169 N174 CLK N38 VPWR VGND DFF_N
XG17 N41 N40 N43 VPWR VGND XOR2
XG170 N175 CLK N47 VPWR VGND DFF_N
XG171 N176 CLK N55 VPWR VGND DFF_N
XG172 N177 CLK N66 VPWR VGND DFF_N
XG173 N178 CLK N75 VPWR VGND DFF_N
XG174 N179 CLK N84 VPWR VGND DFF_N
XG175 N180 CLK N93 VPWR VGND DFF_N
XG176 N181 CLK N102 VPWR VGND DFF_N
XG177 N182 CLK N111 VPWR VGND DFF_N
XG178 N183 CLK N120 VPWR VGND DFF_N
XG179 N184 CLK N129 VPWR VGND DFF_N
XG18 N37 N43 N44 VPWR VGND AND2
XG180 N185 CLK N138 VPWR VGND DFF_N
XG181 N186 CLK N146 VPWR VGND DFF_N
XG182 N187 CLK N157 VPWR VGND DFF_N
XG183 N188 CLK N167 VPWR VGND DFF_N
XG19 N37 N43 NEXT_SUM2 VPWR VGND XOR2
XG2 BIT_IN N23 N25 VPWR VGND XOR2
XG20 N22 NEXT_SUM2 N45 VPWR VGND AND2
XG21 N42 N44 N46 VPWR VGND OR2
XG22 N47 N39 N48 VPWR VGND AND2
XG23 N47 N39 N49 VPWR VGND XOR2
XG24 N50 N49 N51 VPWR VGND AND2
XG25 N50 N49 N52 VPWR VGND OR2
XG26 N50 N49 N53 VPWR VGND XOR2
XG27 N46 N53 NEXT_SUM3 VPWR VGND XOR2
XG28 N22 NEXT_SUM3 N54 VPWR VGND AND2
XG29 N55 N48 N56 VPWR VGND AND2
XG3 N26 N25 N27 VPWR VGND AND2
XG30 N55 N48 N57 VPWR VGND XOR2
XG31 N58 N57 N59 VPWR VGND AND2
XG32 N58 N57 N60 VPWR VGND XOR2
XG33 N46 N52 N61 VPWR VGND AND2
XG34 N51 N61 N62 VPWR VGND OR2
XG35 N60 N62 N63 VPWR VGND AND2
XG36 N60 N62 NEXT_SUM4 VPWR VGND XOR2
XG37 N22 NEXT_SUM4 N64 VPWR VGND AND2
XG38 N59 N63 N65 VPWR VGND OR2
XG39 N66 N56 N67 VPWR VGND AND2
XG4 N26 N25 NEXT_SUM0 VPWR VGND XOR2
XG40 N66 N56 N68 VPWR VGND XOR2
XG41 N69 N68 N70 VPWR VGND AND2
XG42 N69 N68 N71 VPWR VGND XOR2
XG43 N65 N71 N72 VPWR VGND AND2
XG44 N65 N71 NEXT_SUM5 VPWR VGND XOR2
XG45 N22 NEXT_SUM5 N73 VPWR VGND AND2
XG46 N70 N72 N74 VPWR VGND OR2
XG47 N75 N67 N76 VPWR VGND AND2
XG48 N75 N67 N77 VPWR VGND XOR2
XG49 N78 N77 N79 VPWR VGND AND2
XG5 N22 NEXT_SUM0 N28 VPWR VGND AND2
XG50 N78 N77 N80 VPWR VGND XOR2
XG51 N74 N80 N81 VPWR VGND AND2
XG52 N74 N80 NEXT_SUM6 VPWR VGND XOR2
XG53 N22 NEXT_SUM6 N82 VPWR VGND AND2
XG54 N79 N81 N83 VPWR VGND OR2
XG55 N84 N76 N85 VPWR VGND AND2
XG56 N84 N76 N86 VPWR VGND XOR2
XG57 N87 N86 N88 VPWR VGND AND2
XG58 N87 N86 N89 VPWR VGND XOR2
XG59 N83 N89 N90 VPWR VGND AND2
XG6 N29 N24 N30 VPWR VGND AND2
XG60 N83 N89 NEXT_SUM7 VPWR VGND XOR2
XG61 N22 NEXT_SUM7 N91 VPWR VGND AND2
XG62 N88 N90 N92 VPWR VGND OR2
XG63 N93 N85 N94 VPWR VGND AND2
XG64 N93 N85 N95 VPWR VGND XOR2
XG65 N96 N95 N97 VPWR VGND AND2
XG66 N96 N95 N98 VPWR VGND XOR2
XG67 N92 N98 N99 VPWR VGND AND2
XG68 N92 N98 NEXT_SUM8 VPWR VGND XOR2
XG69 N22 NEXT_SUM8 N100 VPWR VGND AND2
XG7 N29 N24 N31 VPWR VGND XOR2
XG70 N97 N99 N101 VPWR VGND OR2
XG71 N102 N94 N103 VPWR VGND AND2
XG72 N102 N94 N104 VPWR VGND XOR2
XG73 N105 N104 N106 VPWR VGND AND2
XG74 N105 N104 N107 VPWR VGND XOR2
XG75 N101 N107 N108 VPWR VGND AND2
XG76 N101 N107 NEXT_SUM9 VPWR VGND XOR2
XG77 N22 NEXT_SUM9 N109 VPWR VGND AND2
XG78 N106 N108 N110 VPWR VGND OR2
XG79 N111 N103 N112 VPWR VGND AND2
XG8 N32 N31 N33 VPWR VGND AND2
XG80 N111 N103 N113 VPWR VGND XOR2
XG81 N114 N113 N115 VPWR VGND AND2
XG82 N114 N113 N116 VPWR VGND XOR2
XG83 N110 N116 N117 VPWR VGND AND2
XG84 N110 N116 NEXT_SUM10 VPWR VGND XOR2
XG85 N22 NEXT_SUM10 N118 VPWR VGND AND2
XG86 N115 N117 N119 VPWR VGND OR2
XG87 N120 N112 N121 VPWR VGND AND2
XG88 N120 N112 N122 VPWR VGND XOR2
XG89 N123 N122 N124 VPWR VGND AND2
XG9 N32 N31 N34 VPWR VGND XOR2
XG90 N123 N122 N125 VPWR VGND XOR2
XG91 N119 N125 N126 VPWR VGND AND2
XG92 N119 N125 NEXT_SUM11 VPWR VGND XOR2
XG93 N22 NEXT_SUM11 N127 VPWR VGND AND2
XG94 N124 N126 N128 VPWR VGND OR2
XG95 N129 N121 N130 VPWR VGND AND2
XG96 N129 N121 N131 VPWR VGND XOR2
XG97 N132 N131 N133 VPWR VGND AND2
XG98 N132 N131 N134 VPWR VGND XOR2
XG99 N128 N134 N135 VPWR VGND AND2
.ends sdm8_cic_integrators

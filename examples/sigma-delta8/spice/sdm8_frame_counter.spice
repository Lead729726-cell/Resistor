.subckt INV A Y VPWR VGND
XMN Y A VGND VGND sky130_fd_pr__nfet_01v8 w=0.65 l=0.15 nf=1 m=1
XMP Y A VPWR VPWR sky130_fd_pr__pfet_01v8_hvt w=0.65 l=0.15 nf=1 m=1
.ends INV
.subckt NOR2 A B Y VPWR VGND
XN0 Y A VGND VGND sky130_fd_pr__nfet_01v8 w=0.65 l=0.15 nf=1 m=1
XN1 Y B VGND VGND sky130_fd_pr__nfet_01v8 w=0.65 l=0.15 nf=1 m=1
XP0 P A VPWR VPWR sky130_fd_pr__pfet_01v8_hvt w=0.65 l=0.15 nf=1 m=1
XP1 Y B P VPWR sky130_fd_pr__pfet_01v8_hvt w=0.65 l=0.15 nf=1 m=1
.ends NOR2
.subckt OR2 A B Y VPWR VGND
XINV N Y VPWR VGND INV
XNOR A B N VPWR VGND NOR2
.ends OR2
.subckt NAND2 A0 A1 Y VPWR VGND
XMN0 Y A0 N1 VGND sky130_fd_pr__nfet_01v8 w=0.65 l=0.15 nf=1 m=1
XMN1 N1 A1 VGND VGND sky130_fd_pr__nfet_01v8 w=0.65 l=0.15 nf=1 m=1
XMP0 Y A0 VPWR VPWR sky130_fd_pr__pfet_01v8_hvt w=0.65 l=0.15 nf=1 m=1
XMP1 Y A1 VPWR VPWR sky130_fd_pr__pfet_01v8_hvt w=0.65 l=0.15 nf=1 m=1
.ends NAND2
.subckt AND2 A B Y VPWR VGND
XI1 N Y VPWR VGND INV
XN1 A B N VPWR VGND NAND2
.ends AND2
.subckt DFF D CLK Q VPWR VGND
XICLK CLK CLKB VPWR VGND INV
XM1 M MB VPWR VGND INV
XM2 MB MF VPWR VGND INV
XMNIN M CLKB D VGND sky130_fd_pr__nfet_01v8 w=0.65 l=0.15 nf=1 m=1
XMNMF M CLK MF VGND sky130_fd_pr__nfet_01v8 w=0.65 l=0.15 nf=1 m=1
XMNOUT T CLK MF VGND sky130_fd_pr__nfet_01v8 w=0.65 l=0.15 nf=1 m=1
XMNSF T CLKB Q VGND sky130_fd_pr__nfet_01v8 w=0.65 l=0.15 nf=1 m=1
XMPIN M CLK D VPWR sky130_fd_pr__pfet_01v8_hvt w=0.65 l=0.15 nf=1 m=1
XMPMF M CLKB MF VPWR sky130_fd_pr__pfet_01v8_hvt w=0.65 l=0.15 nf=1 m=1
XMPOUT T CLKB MF VPWR sky130_fd_pr__pfet_01v8_hvt w=0.65 l=0.15 nf=1 m=1
XMPSF T CLK Q VPWR sky130_fd_pr__pfet_01v8_hvt w=0.65 l=0.15 nf=1 m=1
XS1 T TB VPWR VGND INV
XS2 TB Q VPWR VGND INV
.ends DFF
.subckt DFF_N D CLK Q VPWR VGND
XCLOCK CLK CLKB VPWR VGND INV
XLATCH D CLKB Q VPWR VGND DFF
.ends DFF_N
.subckt sdm8_frame_counter CLK RESET LAST_SAMPLE VPWR VGND
XG0 RESET N5 VPWR VGND INV
XG1 N6 N7 VPWR VGND INV
XG10 N6 N8 N20 VPWR VGND OR2
XG11 N5 N20 N21 VPWR VGND AND2
XG12 N19 N21 N22 VPWR VGND AND2
XG13 N10 N18 N23 VPWR VGND AND2
XG14 N11 N19 N24 VPWR VGND OR2
XG15 N10 N18 N25 VPWR VGND OR2
XG16 N5 N25 N26 VPWR VGND AND2
XG17 N24 N26 N27 VPWR VGND AND2
XG18 N12 N23 N28 VPWR VGND AND2
XG19 N13 N24 N29 VPWR VGND OR2
XG2 N8 N9 VPWR VGND INV
XG20 N12 N23 N30 VPWR VGND OR2
XG21 N5 N30 N31 VPWR VGND AND2
XG22 N29 N31 N32 VPWR VGND AND2
XG23 N14 N28 N33 VPWR VGND AND2
XG24 N15 N29 N34 VPWR VGND OR2
XG25 N14 N28 N35 VPWR VGND OR2
XG26 N5 N35 N36 VPWR VGND AND2
XG27 N34 N36 N37 VPWR VGND AND2
XG28 N38 N33 N39 VPWR VGND AND2
XG29 N39 N40 VPWR VGND INV
XG3 N10 N11 VPWR VGND INV
XG30 N38 N33 N41 VPWR VGND OR2
XG31 N5 N41 N42 VPWR VGND AND2
XG32 N40 N42 N43 VPWR VGND AND2
XG33 N44 N39 N45 VPWR VGND AND2
XG34 N45 N46 VPWR VGND INV
XG35 N44 N39 N47 VPWR VGND OR2
XG36 N5 N47 N48 VPWR VGND AND2
XG37 N46 N48 N49 VPWR VGND AND2
XG38 N50 N45 LAST_SAMPLE VPWR VGND AND2
XG39 LAST_SAMPLE N51 VPWR VGND INV
XG4 N12 N13 VPWR VGND INV
XG40 N50 N45 N52 VPWR VGND OR2
XG41 N5 N52 N53 VPWR VGND AND2
XG42 N51 N53 N54 VPWR VGND AND2
XG43 N17 CLK N6 VPWR VGND DFF_N
XG44 N22 CLK N8 VPWR VGND DFF_N
XG45 N27 CLK N10 VPWR VGND DFF_N
XG46 N32 CLK N12 VPWR VGND DFF_N
XG47 N37 CLK N14 VPWR VGND DFF_N
XG48 N43 CLK N38 VPWR VGND DFF_N
XG49 N49 CLK N44 VPWR VGND DFF_N
XG5 N14 N15 VPWR VGND INV
XG50 N54 CLK N50 VPWR VGND DFF_N
XG6 RESET N6 N16 VPWR VGND OR2
XG7 N16 N17 VPWR VGND INV
XG8 N6 N8 N18 VPWR VGND AND2
XG9 N7 N9 N19 VPWR VGND OR2
.ends sdm8_frame_counter

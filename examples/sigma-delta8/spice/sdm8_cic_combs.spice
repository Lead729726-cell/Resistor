.subckt INV A Y VPWR VGND
XMN Y A VGND VGND sky130_fd_pr__nfet_01v8 w=0.65 l=0.15 nf=1 m=1
XMP Y A VPWR VPWR sky130_fd_pr__pfet_01v8_hvt w=0.65 l=0.15 nf=1 m=1
.ends INV
.subckt NAND2 A0 A1 Y VPWR VGND
XMN0 Y A0 N1 VGND sky130_fd_pr__nfet_01v8 w=0.65 l=0.15 nf=1 m=1
XMN1 N1 A1 VGND VGND sky130_fd_pr__nfet_01v8 w=0.65 l=0.15 nf=1 m=1
XMP0 Y A0 VPWR VPWR sky130_fd_pr__pfet_01v8_hvt w=0.65 l=0.15 nf=1 m=1
XMP1 Y A1 VPWR VPWR sky130_fd_pr__pfet_01v8_hvt w=0.65 l=0.15 nf=1 m=1
.ends NAND2
.subckt AND2 A B Y VPWR VGND
XI1 N Y VPWR VGND INV
XN1 A B N VPWR VGND NAND2
.ends AND2
.subckt NOR2 A B Y VPWR VGND
XN0 Y A VGND VGND sky130_fd_pr__nfet_01v8 w=0.65 l=0.15 nf=1 m=1
XN1 Y B VGND VGND sky130_fd_pr__nfet_01v8 w=0.65 l=0.15 nf=1 m=1
XP0 P A VPWR VPWR sky130_fd_pr__pfet_01v8_hvt w=0.65 l=0.15 nf=1 m=1
XP1 Y B P VPWR sky130_fd_pr__pfet_01v8_hvt w=0.65 l=0.15 nf=1 m=1
.ends NOR2
.subckt OR2 A B Y VPWR VGND
XINV N Y VPWR VGND INV
XNOR A B N VPWR VGND NOR2
.ends OR2
.subckt XOR2 A B Y VPWR VGND
XN1 A B N1 VPWR VGND NAND2
XN2 A N1 N2 VPWR VGND NAND2
XN3 B N1 N3 VPWR VGND NAND2
XN4 N2 N3 Y VPWR VGND NAND2
.ends XOR2
.subckt MUX2 A B S Y VPWR VGND
XIS S SB VPWR VGND INV
XMNA Y SB A VGND sky130_fd_pr__nfet_01v8 w=0.65 l=0.15 nf=1 m=1
XMNB Y S B VGND sky130_fd_pr__nfet_01v8 w=0.65 l=0.15 nf=1 m=1
XMPA Y S A VPWR sky130_fd_pr__pfet_01v8_hvt w=0.65 l=0.15 nf=1 m=1
XMPB Y SB B VPWR sky130_fd_pr__pfet_01v8_hvt w=0.65 l=0.15 nf=1 m=1
.ends MUX2
.subckt DFF D CLK Q VPWR VGND
XICLK CLK CLKB VPWR VGND INV
XM1 M MB VPWR VGND INV
XM2 MB MF VPWR VGND INV
XMNIN M CLKB D VGND sky130_fd_pr__nfet_01v8 w=0.65 l=0.15 nf=1 m=1
XMNMF M CLK MF VGND sky130_fd_pr__nfet_01v8 w=0.65 l=0.15 nf=1 m=1
XMNOUT T CLK MF VGND sky130_fd_pr__nfet_01v8 w=0.65 l=0.15 nf=1 m=1
XMNSF T CLKB Q VGND sky130_fd_pr__nfet_01v8 w=0.65 l=0.15 nf=1 m=1
XMPIN M CLK D VPWR sky130_fd_pr__pfet_01v8_hvt w=0.65 l=0.15 nf=1 m=1
XMPMF M CLKB MF VPWR sky130_fd_pr__pfet_01v8_hvt w=0.65 l=0.15 nf=1 m=1
XMPOUT T CLKB MF VPWR sky130_fd_pr__pfet_01v8_hvt w=0.65 l=0.15 nf=1 m=1
XMPSF T CLK Q VPWR sky130_fd_pr__pfet_01v8_hvt w=0.65 l=0.15 nf=1 m=1
XS1 T TB VPWR VGND INV
XS2 TB Q VPWR VGND INV
.ends DFF
.subckt DFF_N D CLK Q VPWR VGND
XCLOCK CLK CLKB VPWR VGND INV
XLATCH D CLKB Q VPWR VGND DFF
.ends DFF_N
.subckt sdm8_cic_combs CLK RESET ENABLE SUM0 SUM1 SUM2 SUM3 SUM4 SUM5 SUM6 SUM7 SUM8 SUM9 SUM10 SUM11 SUM12 SUM13 SUM14 SUM15 SUM16 FILTERED0 FILTERED1 FILTERED2 FILTERED3 FILTERED4 FILTERED5 FILTERED6 FILTERED7 FILTERED8 FILTERED9 FILTERED10 FILTERED11 FILTERED12 FILTERED13 FILTERED14 FILTERED15 FILTERED16 VPWR VGND
XG0 ENABLE N39 VPWR VGND INV
XG1 SUM15 N40 VPWR VGND INV
XG10 SUM6 N49 VPWR VGND INV
XG100 N141 N144 N156 VPWR VGND OR2
XG101 N143 N156 N157 VPWR VGND AND2
XG102 N155 N157 N158 VPWR VGND OR2
XG103 N155 N157 N159 VPWR VGND XOR2
XG104 N159 N160 VPWR VGND INV
XG105 N39 N159 N161 VPWR VGND OR2
XG106 ENABLE N162 N163 VPWR VGND OR2
XG107 N60 N163 N164 VPWR VGND AND2
XG108 N161 N164 N165 VPWR VGND AND2
XG109 N154 N158 N166 VPWR VGND AND2
XG11 SUM5 N50 VPWR VGND INV
XG110 N167 N46 N168 VPWR VGND OR2
XG111 N167 N46 N169 VPWR VGND AND2
XG112 N167 SUM9 N170 VPWR VGND XOR2
XG113 N170 N171 VPWR VGND INV
XG114 N166 N171 N172 VPWR VGND XOR2
XG115 N172 N173 VPWR VGND INV
XG116 N39 N173 N174 VPWR VGND OR2
XG117 ENABLE N175 N176 VPWR VGND OR2
XG118 N60 N176 N177 VPWR VGND AND2
XG119 N174 N177 N178 VPWR VGND AND2
XG12 SUM4 N51 VPWR VGND INV
XG120 N179 N45 N180 VPWR VGND OR2
XG121 N179 SUM10 N181 VPWR VGND XOR2
XG122 N166 N169 N182 VPWR VGND OR2
XG123 N168 N182 N183 VPWR VGND AND2
XG124 N181 N183 N184 VPWR VGND OR2
XG125 N181 N183 N185 VPWR VGND XOR2
XG126 N185 N186 VPWR VGND INV
XG127 N39 N185 N187 VPWR VGND OR2
XG128 ENABLE N188 N189 VPWR VGND OR2
XG129 N60 N189 N190 VPWR VGND AND2
XG13 SUM3 N52 VPWR VGND INV
XG130 N187 N190 N191 VPWR VGND AND2
XG131 N180 N184 N192 VPWR VGND AND2
XG132 N193 N44 N194 VPWR VGND OR2
XG133 N193 N44 N195 VPWR VGND AND2
XG134 N193 SUM11 N196 VPWR VGND XOR2
XG135 N192 N196 N197 VPWR VGND XOR2
XG136 N197 N198 VPWR VGND INV
XG137 N39 N197 N199 VPWR VGND OR2
XG138 ENABLE N200 N201 VPWR VGND OR2
XG139 N60 N201 N202 VPWR VGND AND2
XG14 SUM2 N53 VPWR VGND INV
XG140 N199 N202 N203 VPWR VGND AND2
XG141 N204 N43 N205 VPWR VGND OR2
XG142 N204 SUM12 N206 VPWR VGND XOR2
XG143 N192 N195 N207 VPWR VGND OR2
XG144 N194 N207 N208 VPWR VGND AND2
XG145 N206 N208 N209 VPWR VGND OR2
XG146 N206 N208 N210 VPWR VGND XOR2
XG147 N210 N211 VPWR VGND INV
XG148 N39 N210 N212 VPWR VGND OR2
XG149 ENABLE N213 N214 VPWR VGND OR2
XG15 SUM1 N54 VPWR VGND INV
XG150 N60 N214 N215 VPWR VGND AND2
XG151 N212 N215 N216 VPWR VGND AND2
XG152 N205 N209 N217 VPWR VGND AND2
XG153 N218 N42 N219 VPWR VGND OR2
XG154 N218 N42 N220 VPWR VGND AND2
XG155 N218 SUM13 N221 VPWR VGND XOR2
XG156 N221 N222 VPWR VGND INV
XG157 N217 N222 N223 VPWR VGND XOR2
XG158 N223 N224 VPWR VGND INV
XG159 N39 N224 N225 VPWR VGND OR2
XG16 N55 N56 VPWR VGND INV
XG160 ENABLE N226 N227 VPWR VGND OR2
XG161 N60 N227 N228 VPWR VGND AND2
XG162 N225 N228 N229 VPWR VGND AND2
XG163 N230 N41 N231 VPWR VGND OR2
XG164 N230 SUM14 N232 VPWR VGND XOR2
XG165 N217 N220 N233 VPWR VGND OR2
XG166 N219 N233 N234 VPWR VGND AND2
XG167 N232 N234 N235 VPWR VGND OR2
XG168 N232 N234 N236 VPWR VGND XOR2
XG169 N236 N237 VPWR VGND INV
XG17 SUM0 N57 VPWR VGND INV
XG170 N39 N236 N238 VPWR VGND OR2
XG171 ENABLE N239 N240 VPWR VGND OR2
XG172 N60 N240 N241 VPWR VGND AND2
XG173 N238 N241 N242 VPWR VGND AND2
XG174 N231 N235 N243 VPWR VGND AND2
XG175 N244 N40 N245 VPWR VGND OR2
XG176 N244 N40 N246 VPWR VGND AND2
XG177 N244 SUM15 N247 VPWR VGND XOR2
XG178 N243 N247 N248 VPWR VGND XOR2
XG179 N248 N249 VPWR VGND INV
XG18 N58 N59 VPWR VGND INV
XG180 N39 N248 N250 VPWR VGND OR2
XG181 ENABLE N251 N252 VPWR VGND OR2
XG182 N60 N252 N253 VPWR VGND AND2
XG183 N250 N253 N254 VPWR VGND AND2
XG184 N243 N246 N255 VPWR VGND OR2
XG185 N245 N255 N256 VPWR VGND AND2
XG186 N257 SUM16 N258 VPWR VGND XOR2
XG187 N256 N258 N259 VPWR VGND XOR2
XG188 N39 N259 N260 VPWR VGND OR2
XG189 ENABLE N261 N262 VPWR VGND OR2
XG19 RESET N60 VPWR VGND INV
XG190 N60 N262 N263 VPWR VGND AND2
XG191 N260 N263 N264 VPWR VGND AND2
XG192 N55 SUM0 ENABLE N265 VPWR VGND MUX2
XG193 N60 N265 N266 VPWR VGND AND2
XG194 N70 SUM1 ENABLE N267 VPWR VGND MUX2
XG195 N60 N267 N268 VPWR VGND AND2
XG196 N81 SUM2 ENABLE N269 VPWR VGND MUX2
XG197 N60 N269 N270 VPWR VGND AND2
XG198 N93 SUM3 ENABLE N271 VPWR VGND MUX2
XG199 N60 N271 N272 VPWR VGND AND2
XG2 SUM14 N41 VPWR VGND INV
XG20 N55 N57 N61 VPWR VGND AND2
XG200 N104 SUM4 ENABLE N273 VPWR VGND MUX2
XG201 N60 N273 N274 VPWR VGND AND2
XG202 N118 SUM5 ENABLE N275 VPWR VGND MUX2
XG203 N60 N275 N276 VPWR VGND AND2
XG204 N130 SUM6 ENABLE N277 VPWR VGND MUX2
XG205 N60 N277 N278 VPWR VGND AND2
XG206 N142 SUM7 ENABLE N279 VPWR VGND MUX2
XG207 N60 N279 N280 VPWR VGND AND2
XG208 N153 SUM8 ENABLE N281 VPWR VGND MUX2
XG209 N60 N281 N282 VPWR VGND AND2
XG21 N56 SUM0 N62 VPWR VGND OR2
XG210 N167 SUM9 ENABLE N283 VPWR VGND MUX2
XG211 N60 N283 N284 VPWR VGND AND2
XG212 N179 SUM10 ENABLE N285 VPWR VGND MUX2
XG213 N60 N285 N286 VPWR VGND AND2
XG214 N193 SUM11 ENABLE N287 VPWR VGND MUX2
XG215 N60 N287 N288 VPWR VGND AND2
XG216 N204 SUM12 ENABLE N289 VPWR VGND MUX2
XG217 N60 N289 N290 VPWR VGND AND2
XG218 N218 SUM13 ENABLE N291 VPWR VGND MUX2
XG219 N60 N291 N292 VPWR VGND AND2
XG22 N55 SUM0 N63 VPWR VGND XOR2
XG220 N230 SUM14 ENABLE N293 VPWR VGND MUX2
XG221 N60 N293 N294 VPWR VGND AND2
XG222 N244 SUM15 ENABLE N295 VPWR VGND MUX2
XG223 N60 N295 N296 VPWR VGND AND2
XG224 N257 SUM16 ENABLE N297 VPWR VGND MUX2
XG225 N60 N297 N298 VPWR VGND AND2
XG226 N66 N64 N299 VPWR VGND AND2
XG227 N66 N63 FILTERED0 VPWR VGND XOR2
XG228 N58 N74 N300 VPWR VGND OR2
XG229 N59 N74 N301 VPWR VGND XOR2
XG23 N63 N64 VPWR VGND INV
XG230 N299 N301 N302 VPWR VGND OR2
XG231 N299 N301 FILTERED1 VPWR VGND XOR2
XG232 N300 N302 N303 VPWR VGND AND2
XG233 N88 N86 N304 VPWR VGND OR2
XG234 N88 N85 N305 VPWR VGND XOR2
XG235 N303 N305 N306 VPWR VGND OR2
XG236 N303 N305 FILTERED2 VPWR VGND XOR2
XG237 N304 N306 N307 VPWR VGND AND2
XG238 N100 N98 N308 VPWR VGND OR2
XG239 N100 N97 N309 VPWR VGND XOR2
XG24 N39 N63 N65 VPWR VGND OR2
XG240 N307 N309 N310 VPWR VGND OR2
XG241 N307 N309 FILTERED3 VPWR VGND XOR2
XG242 N308 N310 N311 VPWR VGND AND2
XG243 N113 N111 N312 VPWR VGND OR2
XG244 N113 N110 N313 VPWR VGND XOR2
XG245 N311 N313 N314 VPWR VGND OR2
XG246 N311 N313 FILTERED4 VPWR VGND XOR2
XG247 N312 N314 N315 VPWR VGND AND2
XG248 N125 N123 N316 VPWR VGND OR2
XG249 N125 N122 N317 VPWR VGND XOR2
XG25 ENABLE N66 N67 VPWR VGND OR2
XG250 N315 N317 N318 VPWR VGND OR2
XG251 N315 N317 FILTERED5 VPWR VGND XOR2
XG252 N316 N318 N319 VPWR VGND AND2
XG253 N137 N135 N320 VPWR VGND OR2
XG254 N137 N134 N321 VPWR VGND XOR2
XG255 N319 N321 N322 VPWR VGND OR2
XG256 N319 N321 FILTERED6 VPWR VGND XOR2
XG257 N320 N322 N323 VPWR VGND AND2
XG258 N149 N147 N324 VPWR VGND OR2
XG259 N149 N146 N325 VPWR VGND XOR2
XG26 N60 N67 N68 VPWR VGND AND2
XG260 N323 N325 N326 VPWR VGND OR2
XG261 N323 N325 FILTERED7 VPWR VGND XOR2
XG262 N324 N326 N327 VPWR VGND AND2
XG263 N162 N160 N328 VPWR VGND OR2
XG264 N162 N159 N329 VPWR VGND XOR2
XG265 N327 N329 N330 VPWR VGND OR2
XG266 N327 N329 FILTERED8 VPWR VGND XOR2
XG267 N328 N330 N331 VPWR VGND AND2
XG268 N175 N172 N332 VPWR VGND OR2
XG269 N175 N172 N333 VPWR VGND AND2
XG27 N65 N68 N69 VPWR VGND AND2
XG270 N175 N173 N334 VPWR VGND XOR2
XG271 N331 N334 FILTERED9 VPWR VGND XOR2
XG272 N188 N186 N335 VPWR VGND OR2
XG273 N188 N185 N336 VPWR VGND XOR2
XG274 N331 N332 N337 VPWR VGND AND2
XG275 N333 N337 N338 VPWR VGND OR2
XG276 N336 N338 N339 VPWR VGND OR2
XG277 N336 N338 FILTERED10 VPWR VGND XOR2
XG278 N335 N339 N340 VPWR VGND AND2
XG279 N200 N198 N341 VPWR VGND OR2
XG28 N70 N54 N71 VPWR VGND OR2
XG280 N200 N197 N342 VPWR VGND XOR2
XG281 N340 N342 N343 VPWR VGND OR2
XG282 N340 N342 FILTERED11 VPWR VGND XOR2
XG283 N341 N343 N344 VPWR VGND AND2
XG284 N213 N211 N345 VPWR VGND OR2
XG285 N213 N210 N346 VPWR VGND XOR2
XG286 N344 N346 N347 VPWR VGND OR2
XG287 N344 N346 FILTERED12 VPWR VGND XOR2
XG288 N345 N347 N348 VPWR VGND AND2
XG289 N226 N223 N349 VPWR VGND OR2
XG29 N70 SUM1 N72 VPWR VGND XOR2
XG290 N226 N223 N350 VPWR VGND AND2
XG291 N226 N224 N351 VPWR VGND XOR2
XG292 N348 N351 FILTERED13 VPWR VGND XOR2
XG293 N239 N237 N352 VPWR VGND OR2
XG294 N239 N236 N353 VPWR VGND XOR2
XG295 N348 N349 N354 VPWR VGND AND2
XG296 N350 N354 N355 VPWR VGND OR2
XG297 N353 N355 N356 VPWR VGND OR2
XG298 N353 N355 FILTERED14 VPWR VGND XOR2
XG299 N352 N356 N357 VPWR VGND AND2
XG3 SUM13 N42 VPWR VGND INV
XG30 N61 N72 N73 VPWR VGND OR2
XG300 N251 N249 N358 VPWR VGND OR2
XG301 N251 N248 N359 VPWR VGND XOR2
XG302 N357 N359 N360 VPWR VGND OR2
XG303 N357 N359 FILTERED15 VPWR VGND XOR2
XG304 N358 N360 N361 VPWR VGND AND2
XG305 N261 N259 N362 VPWR VGND XOR2
XG306 N361 N362 FILTERED16 VPWR VGND XOR2
XG307 N69 CLK N66 VPWR VGND DFF_N
XG308 N79 CLK N58 VPWR VGND DFF_N
XG309 N91 CLK N88 VPWR VGND DFF_N
XG31 N62 N72 N74 VPWR VGND XOR2
XG310 N103 CLK N100 VPWR VGND DFF_N
XG311 N116 CLK N113 VPWR VGND DFF_N
XG312 N128 CLK N125 VPWR VGND DFF_N
XG313 N140 CLK N137 VPWR VGND DFF_N
XG314 N152 CLK N149 VPWR VGND DFF_N
XG315 N165 CLK N162 VPWR VGND DFF_N
XG316 N178 CLK N175 VPWR VGND DFF_N
XG317 N191 CLK N188 VPWR VGND DFF_N
XG318 N203 CLK N200 VPWR VGND DFF_N
XG319 N216 CLK N213 VPWR VGND DFF_N
XG32 ENABLE N74 N75 VPWR VGND AND2
XG320 N229 CLK N226 VPWR VGND DFF_N
XG321 N242 CLK N239 VPWR VGND DFF_N
XG322 N254 CLK N251 VPWR VGND DFF_N
XG323 N264 CLK N261 VPWR VGND DFF_N
XG324 N266 CLK N55 VPWR VGND DFF_N
XG325 N268 CLK N70 VPWR VGND DFF_N
XG326 N270 CLK N81 VPWR VGND DFF_N
XG327 N272 CLK N93 VPWR VGND DFF_N
XG328 N274 CLK N104 VPWR VGND DFF_N
XG329 N276 CLK N118 VPWR VGND DFF_N
XG33 ENABLE N58 N76 VPWR VGND OR2
XG330 N278 CLK N130 VPWR VGND DFF_N
XG331 N280 CLK N142 VPWR VGND DFF_N
XG332 N282 CLK N153 VPWR VGND DFF_N
XG333 N284 CLK N167 VPWR VGND DFF_N
XG334 N286 CLK N179 VPWR VGND DFF_N
XG335 N288 CLK N193 VPWR VGND DFF_N
XG336 N290 CLK N204 VPWR VGND DFF_N
XG337 N292 CLK N218 VPWR VGND DFF_N
XG338 N294 CLK N230 VPWR VGND DFF_N
XG339 N296 CLK N244 VPWR VGND DFF_N
XG34 RESET N75 N77 VPWR VGND OR2
XG340 N298 CLK N257 VPWR VGND DFF_N
XG35 N77 N78 VPWR VGND INV
XG36 N76 N78 N79 VPWR VGND AND2
XG37 N71 N73 N80 VPWR VGND AND2
XG38 N81 N53 N82 VPWR VGND OR2
XG39 N81 SUM2 N83 VPWR VGND XOR2
XG4 SUM12 N43 VPWR VGND INV
XG40 N80 N83 N84 VPWR VGND OR2
XG41 N80 N83 N85 VPWR VGND XOR2
XG42 N85 N86 VPWR VGND INV
XG43 N39 N85 N87 VPWR VGND OR2
XG44 ENABLE N88 N89 VPWR VGND OR2
XG45 N60 N89 N90 VPWR VGND AND2
XG46 N87 N90 N91 VPWR VGND AND2
XG47 N82 N84 N92 VPWR VGND AND2
XG48 N93 N52 N94 VPWR VGND OR2
XG49 N93 N52 N95 VPWR VGND AND2
XG5 SUM11 N44 VPWR VGND INV
XG50 N93 SUM3 N96 VPWR VGND XOR2
XG51 N92 N96 N97 VPWR VGND XOR2
XG52 N97 N98 VPWR VGND INV
XG53 N39 N97 N99 VPWR VGND OR2
XG54 ENABLE N100 N101 VPWR VGND OR2
XG55 N60 N101 N102 VPWR VGND AND2
XG56 N99 N102 N103 VPWR VGND AND2
XG57 N104 N51 N105 VPWR VGND OR2
XG58 N104 SUM4 N106 VPWR VGND XOR2
XG59 N92 N95 N107 VPWR VGND OR2
XG6 SUM10 N45 VPWR VGND INV
XG60 N94 N107 N108 VPWR VGND AND2
XG61 N106 N108 N109 VPWR VGND OR2
XG62 N106 N108 N110 VPWR VGND XOR2
XG63 N110 N111 VPWR VGND INV
XG64 N39 N110 N112 VPWR VGND OR2
XG65 ENABLE N113 N114 VPWR VGND OR2
XG66 N60 N114 N115 VPWR VGND AND2
XG67 N112 N115 N116 VPWR VGND AND2
XG68 N105 N109 N117 VPWR VGND AND2
XG69 N118 N50 N119 VPWR VGND OR2
XG7 SUM9 N46 VPWR VGND INV
XG70 N118 SUM5 N120 VPWR VGND XOR2
XG71 N117 N120 N121 VPWR VGND OR2
XG72 N117 N120 N122 VPWR VGND XOR2
XG73 N122 N123 VPWR VGND INV
XG74 N39 N122 N124 VPWR VGND OR2
XG75 ENABLE N125 N126 VPWR VGND OR2
XG76 N60 N126 N127 VPWR VGND AND2
XG77 N124 N127 N128 VPWR VGND AND2
XG78 N119 N121 N129 VPWR VGND AND2
XG79 N130 N49 N131 VPWR VGND OR2
XG8 SUM8 N47 VPWR VGND INV
XG80 N130 SUM6 N132 VPWR VGND XOR2
XG81 N129 N132 N133 VPWR VGND OR2
XG82 N129 N132 N134 VPWR VGND XOR2
XG83 N134 N135 VPWR VGND INV
XG84 N39 N134 N136 VPWR VGND OR2
XG85 ENABLE N137 N138 VPWR VGND OR2
XG86 N60 N138 N139 VPWR VGND AND2
XG87 N136 N139 N140 VPWR VGND AND2
XG88 N131 N133 N141 VPWR VGND AND2
XG89 N142 N48 N143 VPWR VGND OR2
XG9 SUM7 N48 VPWR VGND INV
XG90 N142 N48 N144 VPWR VGND AND2
XG91 N142 SUM7 N145 VPWR VGND XOR2
XG92 N141 N145 N146 VPWR VGND XOR2
XG93 N146 N147 VPWR VGND INV
XG94 N39 N146 N148 VPWR VGND OR2
XG95 ENABLE N149 N150 VPWR VGND OR2
XG96 N60 N150 N151 VPWR VGND AND2
XG97 N148 N151 N152 VPWR VGND AND2
XG98 N153 N47 N154 VPWR VGND OR2
XG99 N153 SUM8 N155 VPWR VGND XOR2
.ends sdm8_cic_combs

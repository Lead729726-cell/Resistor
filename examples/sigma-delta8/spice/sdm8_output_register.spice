.subckt INV A Y VPWR VGND
XMN Y A VGND VGND sky130_fd_pr__nfet_01v8 w=0.65 l=0.15 nf=1 m=1
XMP Y A VPWR VPWR sky130_fd_pr__pfet_01v8_hvt w=0.65 l=0.15 nf=1 m=1
.ends INV
.subckt NAND2 A0 A1 Y VPWR VGND
XMN0 Y A0 N1 VGND sky130_fd_pr__nfet_01v8 w=0.65 l=0.15 nf=1 m=1
XMN1 N1 A1 VGND VGND sky130_fd_pr__nfet_01v8 w=0.65 l=0.15 nf=1 m=1
XMP0 Y A0 VPWR VPWR sky130_fd_pr__pfet_01v8_hvt w=0.65 l=0.15 nf=1 m=1
XMP1 Y A1 VPWR VPWR sky130_fd_pr__pfet_01v8_hvt w=0.65 l=0.15 nf=1 m=1
.ends NAND2
.subckt AND2 A B Y VPWR VGND
XI1 N Y VPWR VGND INV
XN1 A B N VPWR VGND NAND2
.ends AND2
.subckt MUX2 A B S Y VPWR VGND
XIS S SB VPWR VGND INV
XMNA Y SB A VGND sky130_fd_pr__nfet_01v8 w=0.65 l=0.15 nf=1 m=1
XMNB Y S B VGND sky130_fd_pr__nfet_01v8 w=0.65 l=0.15 nf=1 m=1
XMPA Y S A VPWR sky130_fd_pr__pfet_01v8_hvt w=0.65 l=0.15 nf=1 m=1
XMPB Y SB B VPWR sky130_fd_pr__pfet_01v8_hvt w=0.65 l=0.15 nf=1 m=1
.ends MUX2
.subckt DFF D CLK Q VPWR VGND
XICLK CLK CLKB VPWR VGND INV
XM1 M MB VPWR VGND INV
XM2 MB MF VPWR VGND INV
XMNIN M CLKB D VGND sky130_fd_pr__nfet_01v8 w=0.65 l=0.15 nf=1 m=1
XMNMF M CLK MF VGND sky130_fd_pr__nfet_01v8 w=0.65 l=0.15 nf=1 m=1
XMNOUT T CLK MF VGND sky130_fd_pr__nfet_01v8 w=0.65 l=0.15 nf=1 m=1
XMNSF T CLKB Q VGND sky130_fd_pr__nfet_01v8 w=0.65 l=0.15 nf=1 m=1
XMPIN M CLK D VPWR sky130_fd_pr__pfet_01v8_hvt w=0.65 l=0.15 nf=1 m=1
XMPMF M CLKB MF VPWR sky130_fd_pr__pfet_01v8_hvt w=0.65 l=0.15 nf=1 m=1
XMPOUT T CLKB MF VPWR sky130_fd_pr__pfet_01v8_hvt w=0.65 l=0.15 nf=1 m=1
XMPSF T CLK Q VPWR sky130_fd_pr__pfet_01v8_hvt w=0.65 l=0.15 nf=1 m=1
XS1 T TB VPWR VGND INV
XS2 TB Q VPWR VGND INV
.ends DFF
.subckt DFF_N D CLK Q VPWR VGND
XCLOCK CLK CLKB VPWR VGND INV
XLATCH D CLKB Q VPWR VGND DFF
.ends DFF_N
.subckt sdm8_output_register CLK RESET ENABLE CODE_IN0 CODE_IN1 CODE_IN2 CODE_IN3 CODE_IN4 CODE_IN5 CODE_IN6 CODE_IN7 CODE0 CODE1 CODE2 CODE3 CODE4 CODE5 CODE6 CODE7 VALID VPWR VGND
XG0 RESET N22 VPWR VGND INV
XG1 ENABLE N22 N23 VPWR VGND AND2
XG10 CODE4 CODE_IN4 ENABLE N32 VPWR VGND MUX2
XG11 N22 N32 N33 VPWR VGND AND2
XG12 CODE5 CODE_IN5 ENABLE N34 VPWR VGND MUX2
XG13 N22 N34 N35 VPWR VGND AND2
XG14 CODE6 CODE_IN6 ENABLE N36 VPWR VGND MUX2
XG15 N22 N36 N37 VPWR VGND AND2
XG16 CODE7 CODE_IN7 ENABLE N38 VPWR VGND MUX2
XG17 N22 N38 N39 VPWR VGND AND2
XG18 N23 CLK VALID VPWR VGND DFF_N
XG19 N25 CLK CODE0 VPWR VGND DFF_N
XG2 CODE0 CODE_IN0 ENABLE N24 VPWR VGND MUX2
XG20 N27 CLK CODE1 VPWR VGND DFF_N
XG21 N29 CLK CODE2 VPWR VGND DFF_N
XG22 N31 CLK CODE3 VPWR VGND DFF_N
XG23 N33 CLK CODE4 VPWR VGND DFF_N
XG24 N35 CLK CODE5 VPWR VGND DFF_N
XG25 N37 CLK CODE6 VPWR VGND DFF_N
XG26 N39 CLK CODE7 VPWR VGND DFF_N
XG3 N22 N24 N25 VPWR VGND AND2
XG4 CODE1 CODE_IN1 ENABLE N26 VPWR VGND MUX2
XG5 N22 N26 N27 VPWR VGND AND2
XG6 CODE2 CODE_IN2 ENABLE N28 VPWR VGND MUX2
XG7 N22 N28 N29 VPWR VGND AND2
XG8 CODE3 CODE_IN3 ENABLE N30 VPWR VGND MUX2
XG9 N22 N30 N31 VPWR VGND AND2
.ends sdm8_output_register

.subckt sdm8_reference VCM VPWR VGND
CC_DECAP VCM VGND 2e-11
RR_BOTTOM VCM VGND 100000
RR_TOP VPWR VCM 100000
.ends sdm8_reference

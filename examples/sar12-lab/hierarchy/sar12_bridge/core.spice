.subckt sar12_bridge TOP FINE
CC_BRIDGE TOP FINE 4.06349206349e-13
.ends sar12_bridge

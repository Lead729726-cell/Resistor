.subckt INV A Y VPWR VGND
XMN Y A VGND VGND sky130_fd_pr__nfet_01v8 w=0.65 l=0.15 nf=1 m=1
XMP Y A VPWR VPWR sky130_fd_pr__pfet_01v8_hvt w=0.65 l=0.15 nf=1 m=1
.ends INV
.subckt SAR12_TG A Y EN ENB VPWR VGND
XN A EN Y VGND sky130_fd_pr__nfet_01v8 w=8 l=0.15 nf=1 m=1
XP A ENB Y VPWR sky130_fd_pr__pfet_01v8_hvt w=12 l=0.15 nf=1 m=1
.ends SAR12_TG
.subckt SAR12_REFMUX VIN REF SAMPLE SAMPLEB OUT VPWR VGND
XACQUIRE VIN OUT SAMPLE SAMPLEB VPWR VGND SAR12_TG
XCONVERT REF OUT SAMPLEB SAMPLE VPWR VGND SAR12_TG
.ends SAR12_REFMUX
.subckt SAR12_BRIDGE TOP FINE
CC_BRIDGE TOP FINE 4.06349206349e-13
.ends SAR12_BRIDGE
.subckt SAR12_BITMUX HI LO BIT OUT VPWR VGND
XHIGH HI OUT BIT BITB VPWR VGND SAR12_TG
XINV BIT BITB VPWR VGND INV
XLOW LO OUT BITB BIT VPWR VGND SAR12_TG
.ends SAR12_BITMUX
.subckt SAR12_UNIT TOP BOTTOM
CC_UNIT TOP BOTTOM 2e-13
.ends SAR12_UNIT
.subckt SAR12_CDAC VINP VINN VREF VCM SAMPLE TOPP TOPN B0 B1 B2 B3 B4 B5 B6 B7 B8 B9 B10 B11 VPWR VGND
XBRIDGEN TOPN FINEN SAR12_BRIDGE
XBRIDGEP TOPP FINEP SAR12_BRIDGE
XN_COARSE_B0_SW LON HIN B6 N_COARSE_B0 VPWR VGND SAR12_BITMUX
XN_COARSE_B0_U0 TOPN N_COARSE_B0 SAR12_UNIT
XN_COARSE_B0_U1 TOPN N_COARSE_B0 SAR12_UNIT
XN_COARSE_B1_SW LON HIN B7 N_COARSE_B1 VPWR VGND SAR12_BITMUX
XN_COARSE_B1_U0 TOPN N_COARSE_B1 SAR12_UNIT
XN_COARSE_B1_U1 TOPN N_COARSE_B1 SAR12_UNIT
XN_COARSE_B1_U2 TOPN N_COARSE_B1 SAR12_UNIT
XN_COARSE_B1_U3 TOPN N_COARSE_B1 SAR12_UNIT
XN_COARSE_B2_SW LON HIN B8 N_COARSE_B2 VPWR VGND SAR12_BITMUX
XN_COARSE_B2_U0 TOPN N_COARSE_B2 SAR12_UNIT
XN_COARSE_B2_U1 TOPN N_COARSE_B2 SAR12_UNIT
XN_COARSE_B2_U2 TOPN N_COARSE_B2 SAR12_UNIT
XN_COARSE_B2_U3 TOPN N_COARSE_B2 SAR12_UNIT
XN_COARSE_B2_U4 TOPN N_COARSE_B2 SAR12_UNIT
XN_COARSE_B2_U5 TOPN N_COARSE_B2 SAR12_UNIT
XN_COARSE_B2_U6 TOPN N_COARSE_B2 SAR12_UNIT
XN_COARSE_B2_U7 TOPN N_COARSE_B2 SAR12_UNIT
XN_COARSE_B3_SW LON HIN B9 N_COARSE_B3 VPWR VGND SAR12_BITMUX
XN_COARSE_B3_U0 TOPN N_COARSE_B3 SAR12_UNIT
XN_COARSE_B3_U1 TOPN N_COARSE_B3 SAR12_UNIT
XN_COARSE_B3_U10 TOPN N_COARSE_B3 SAR12_UNIT
XN_COARSE_B3_U11 TOPN N_COARSE_B3 SAR12_UNIT
XN_COARSE_B3_U12 TOPN N_COARSE_B3 SAR12_UNIT
XN_COARSE_B3_U13 TOPN N_COARSE_B3 SAR12_UNIT
XN_COARSE_B3_U14 TOPN N_COARSE_B3 SAR12_UNIT
XN_COARSE_B3_U15 TOPN N_COARSE_B3 SAR12_UNIT
XN_COARSE_B3_U2 TOPN N_COARSE_B3 SAR12_UNIT
XN_COARSE_B3_U3 TOPN N_COARSE_B3 SAR12_UNIT
XN_COARSE_B3_U4 TOPN N_COARSE_B3 SAR12_UNIT
XN_COARSE_B3_U5 TOPN N_COARSE_B3 SAR12_UNIT
XN_COARSE_B3_U6 TOPN N_COARSE_B3 SAR12_UNIT
XN_COARSE_B3_U7 TOPN N_COARSE_B3 SAR12_UNIT
XN_COARSE_B3_U8 TOPN N_COARSE_B3 SAR12_UNIT
XN_COARSE_B3_U9 TOPN N_COARSE_B3 SAR12_UNIT
XN_COARSE_B4_SW LON HIN B10 N_COARSE_B4 VPWR VGND SAR12_BITMUX
XN_COARSE_B4_U0 TOPN N_COARSE_B4 SAR12_UNIT
XN_COARSE_B4_U1 TOPN N_COARSE_B4 SAR12_UNIT
XN_COARSE_B4_U10 TOPN N_COARSE_B4 SAR12_UNIT
XN_COARSE_B4_U11 TOPN N_COARSE_B4 SAR12_UNIT
XN_COARSE_B4_U12 TOPN N_COARSE_B4 SAR12_UNIT
XN_COARSE_B4_U13 TOPN N_COARSE_B4 SAR12_UNIT
XN_COARSE_B4_U14 TOPN N_COARSE_B4 SAR12_UNIT
XN_COARSE_B4_U15 TOPN N_COARSE_B4 SAR12_UNIT
XN_COARSE_B4_U16 TOPN N_COARSE_B4 SAR12_UNIT
XN_COARSE_B4_U17 TOPN N_COARSE_B4 SAR12_UNIT
XN_COARSE_B4_U18 TOPN N_COARSE_B4 SAR12_UNIT
XN_COARSE_B4_U19 TOPN N_COARSE_B4 SAR12_UNIT
XN_COARSE_B4_U2 TOPN N_COARSE_B4 SAR12_UNIT
XN_COARSE_B4_U20 TOPN N_COARSE_B4 SAR12_UNIT
XN_COARSE_B4_U21 TOPN N_COARSE_B4 SAR12_UNIT
XN_COARSE_B4_U22 TOPN N_COARSE_B4 SAR12_UNIT
XN_COARSE_B4_U23 TOPN N_COARSE_B4 SAR12_UNIT
XN_COARSE_B4_U24 TOPN N_COARSE_B4 SAR12_UNIT
XN_COARSE_B4_U25 TOPN N_COARSE_B4 SAR12_UNIT
XN_COARSE_B4_U26 TOPN N_COARSE_B4 SAR12_UNIT
XN_COARSE_B4_U27 TOPN N_COARSE_B4 SAR12_UNIT
XN_COARSE_B4_U28 TOPN N_COARSE_B4 SAR12_UNIT
XN_COARSE_B4_U29 TOPN N_COARSE_B4 SAR12_UNIT
XN_COARSE_B4_U3 TOPN N_COARSE_B4 SAR12_UNIT
XN_COARSE_B4_U30 TOPN N_COARSE_B4 SAR12_UNIT
XN_COARSE_B4_U31 TOPN N_COARSE_B4 SAR12_UNIT
XN_COARSE_B4_U4 TOPN N_COARSE_B4 SAR12_UNIT
XN_COARSE_B4_U5 TOPN N_COARSE_B4 SAR12_UNIT
XN_COARSE_B4_U6 TOPN N_COARSE_B4 SAR12_UNIT
XN_COARSE_B4_U7 TOPN N_COARSE_B4 SAR12_UNIT
XN_COARSE_B4_U8 TOPN N_COARSE_B4 SAR12_UNIT
XN_COARSE_B4_U9 TOPN N_COARSE_B4 SAR12_UNIT
XN_COARSE_B5_SW LON HIN B11 N_COARSE_B5 VPWR VGND SAR12_BITMUX
XN_COARSE_B5_U0 TOPN N_COARSE_B5 SAR12_UNIT
XN_COARSE_B5_U1 TOPN N_COARSE_B5 SAR12_UNIT
XN_COARSE_B5_U10 TOPN N_COARSE_B5 SAR12_UNIT
XN_COARSE_B5_U11 TOPN N_COARSE_B5 SAR12_UNIT
XN_COARSE_B5_U12 TOPN N_COARSE_B5 SAR12_UNIT
XN_COARSE_B5_U13 TOPN N_COARSE_B5 SAR12_UNIT
XN_COARSE_B5_U14 TOPN N_COARSE_B5 SAR12_UNIT
XN_COARSE_B5_U15 TOPN N_COARSE_B5 SAR12_UNIT
XN_COARSE_B5_U16 TOPN N_COARSE_B5 SAR12_UNIT
XN_COARSE_B5_U17 TOPN N_COARSE_B5 SAR12_UNIT
XN_COARSE_B5_U18 TOPN N_COARSE_B5 SAR12_UNIT
XN_COARSE_B5_U19 TOPN N_COARSE_B5 SAR12_UNIT
XN_COARSE_B5_U2 TOPN N_COARSE_B5 SAR12_UNIT
XN_COARSE_B5_U20 TOPN N_COARSE_B5 SAR12_UNIT
XN_COARSE_B5_U21 TOPN N_COARSE_B5 SAR12_UNIT
XN_COARSE_B5_U22 TOPN N_COARSE_B5 SAR12_UNIT
XN_COARSE_B5_U23 TOPN N_COARSE_B5 SAR12_UNIT
XN_COARSE_B5_U24 TOPN N_COARSE_B5 SAR12_UNIT
XN_COARSE_B5_U25 TOPN N_COARSE_B5 SAR12_UNIT
XN_COARSE_B5_U26 TOPN N_COARSE_B5 SAR12_UNIT
XN_COARSE_B5_U27 TOPN N_COARSE_B5 SAR12_UNIT
XN_COARSE_B5_U28 TOPN N_COARSE_B5 SAR12_UNIT
XN_COARSE_B5_U29 TOPN N_COARSE_B5 SAR12_UNIT
XN_COARSE_B5_U3 TOPN N_COARSE_B5 SAR12_UNIT
XN_COARSE_B5_U30 TOPN N_COARSE_B5 SAR12_UNIT
XN_COARSE_B5_U31 TOPN N_COARSE_B5 SAR12_UNIT
XN_COARSE_B5_U32 TOPN N_COARSE_B5 SAR12_UNIT
XN_COARSE_B5_U33 TOPN N_COARSE_B5 SAR12_UNIT
XN_COARSE_B5_U34 TOPN N_COARSE_B5 SAR12_UNIT
XN_COARSE_B5_U35 TOPN N_COARSE_B5 SAR12_UNIT
XN_COARSE_B5_U36 TOPN N_COARSE_B5 SAR12_UNIT
XN_COARSE_B5_U37 TOPN N_COARSE_B5 SAR12_UNIT
XN_COARSE_B5_U38 TOPN N_COARSE_B5 SAR12_UNIT
XN_COARSE_B5_U39 TOPN N_COARSE_B5 SAR12_UNIT
XN_COARSE_B5_U4 TOPN N_COARSE_B5 SAR12_UNIT
XN_COARSE_B5_U40 TOPN N_COARSE_B5 SAR12_UNIT
XN_COARSE_B5_U41 TOPN N_COARSE_B5 SAR12_UNIT
XN_COARSE_B5_U42 TOPN N_COARSE_B5 SAR12_UNIT
XN_COARSE_B5_U43 TOPN N_COARSE_B5 SAR12_UNIT
XN_COARSE_B5_U44 TOPN N_COARSE_B5 SAR12_UNIT
XN_COARSE_B5_U45 TOPN N_COARSE_B5 SAR12_UNIT
XN_COARSE_B5_U46 TOPN N_COARSE_B5 SAR12_UNIT
XN_COARSE_B5_U47 TOPN N_COARSE_B5 SAR12_UNIT
XN_COARSE_B5_U48 TOPN N_COARSE_B5 SAR12_UNIT
XN_COARSE_B5_U49 TOPN N_COARSE_B5 SAR12_UNIT
XN_COARSE_B5_U5 TOPN N_COARSE_B5 SAR12_UNIT
XN_COARSE_B5_U50 TOPN N_COARSE_B5 SAR12_UNIT
XN_COARSE_B5_U51 TOPN N_COARSE_B5 SAR12_UNIT
XN_COARSE_B5_U52 TOPN N_COARSE_B5 SAR12_UNIT
XN_COARSE_B5_U53 TOPN N_COARSE_B5 SAR12_UNIT
XN_COARSE_B5_U54 TOPN N_COARSE_B5 SAR12_UNIT
XN_COARSE_B5_U55 TOPN N_COARSE_B5 SAR12_UNIT
XN_COARSE_B5_U56 TOPN N_COARSE_B5 SAR12_UNIT
XN_COARSE_B5_U57 TOPN N_COARSE_B5 SAR12_UNIT
XN_COARSE_B5_U58 TOPN N_COARSE_B5 SAR12_UNIT
XN_COARSE_B5_U59 TOPN N_COARSE_B5 SAR12_UNIT
XN_COARSE_B5_U6 TOPN N_COARSE_B5 SAR12_UNIT
XN_COARSE_B5_U60 TOPN N_COARSE_B5 SAR12_UNIT
XN_COARSE_B5_U61 TOPN N_COARSE_B5 SAR12_UNIT
XN_COARSE_B5_U62 TOPN N_COARSE_B5 SAR12_UNIT
XN_COARSE_B5_U63 TOPN N_COARSE_B5 SAR12_UNIT
XN_COARSE_B5_U7 TOPN N_COARSE_B5 SAR12_UNIT
XN_COARSE_B5_U8 TOPN N_COARSE_B5 SAR12_UNIT
XN_COARSE_B5_U9 TOPN N_COARSE_B5 SAR12_UNIT
XN_FINE_B0_SW LON HIN B0 N_FINE_B0 VPWR VGND SAR12_BITMUX
XN_FINE_B0_U0 FINEN N_FINE_B0 SAR12_UNIT
XN_FINE_B0_U1 FINEN N_FINE_B0 SAR12_UNIT
XN_FINE_B1_SW LON HIN B1 N_FINE_B1 VPWR VGND SAR12_BITMUX
XN_FINE_B1_U0 FINEN N_FINE_B1 SAR12_UNIT
XN_FINE_B1_U1 FINEN N_FINE_B1 SAR12_UNIT
XN_FINE_B1_U2 FINEN N_FINE_B1 SAR12_UNIT
XN_FINE_B1_U3 FINEN N_FINE_B1 SAR12_UNIT
XN_FINE_B2_SW LON HIN B2 N_FINE_B2 VPWR VGND SAR12_BITMUX
XN_FINE_B2_U0 FINEN N_FINE_B2 SAR12_UNIT
XN_FINE_B2_U1 FINEN N_FINE_B2 SAR12_UNIT
XN_FINE_B2_U2 FINEN N_FINE_B2 SAR12_UNIT
XN_FINE_B2_U3 FINEN N_FINE_B2 SAR12_UNIT
XN_FINE_B2_U4 FINEN N_FINE_B2 SAR12_UNIT
XN_FINE_B2_U5 FINEN N_FINE_B2 SAR12_UNIT
XN_FINE_B2_U6 FINEN N_FINE_B2 SAR12_UNIT
XN_FINE_B2_U7 FINEN N_FINE_B2 SAR12_UNIT
XN_FINE_B3_SW LON HIN B3 N_FINE_B3 VPWR VGND SAR12_BITMUX
XN_FINE_B3_U0 FINEN N_FINE_B3 SAR12_UNIT
XN_FINE_B3_U1 FINEN N_FINE_B3 SAR12_UNIT
XN_FINE_B3_U10 FINEN N_FINE_B3 SAR12_UNIT
XN_FINE_B3_U11 FINEN N_FINE_B3 SAR12_UNIT
XN_FINE_B3_U12 FINEN N_FINE_B3 SAR12_UNIT
XN_FINE_B3_U13 FINEN N_FINE_B3 SAR12_UNIT
XN_FINE_B3_U14 FINEN N_FINE_B3 SAR12_UNIT
XN_FINE_B3_U15 FINEN N_FINE_B3 SAR12_UNIT
XN_FINE_B3_U2 FINEN N_FINE_B3 SAR12_UNIT
XN_FINE_B3_U3 FINEN N_FINE_B3 SAR12_UNIT
XN_FINE_B3_U4 FINEN N_FINE_B3 SAR12_UNIT
XN_FINE_B3_U5 FINEN N_FINE_B3 SAR12_UNIT
XN_FINE_B3_U6 FINEN N_FINE_B3 SAR12_UNIT
XN_FINE_B3_U7 FINEN N_FINE_B3 SAR12_UNIT
XN_FINE_B3_U8 FINEN N_FINE_B3 SAR12_UNIT
XN_FINE_B3_U9 FINEN N_FINE_B3 SAR12_UNIT
XN_FINE_B4_SW LON HIN B4 N_FINE_B4 VPWR VGND SAR12_BITMUX
XN_FINE_B4_U0 FINEN N_FINE_B4 SAR12_UNIT
XN_FINE_B4_U1 FINEN N_FINE_B4 SAR12_UNIT
XN_FINE_B4_U10 FINEN N_FINE_B4 SAR12_UNIT
XN_FINE_B4_U11 FINEN N_FINE_B4 SAR12_UNIT
XN_FINE_B4_U12 FINEN N_FINE_B4 SAR12_UNIT
XN_FINE_B4_U13 FINEN N_FINE_B4 SAR12_UNIT
XN_FINE_B4_U14 FINEN N_FINE_B4 SAR12_UNIT
XN_FINE_B4_U15 FINEN N_FINE_B4 SAR12_UNIT
XN_FINE_B4_U16 FINEN N_FINE_B4 SAR12_UNIT
XN_FINE_B4_U17 FINEN N_FINE_B4 SAR12_UNIT
XN_FINE_B4_U18 FINEN N_FINE_B4 SAR12_UNIT
XN_FINE_B4_U19 FINEN N_FINE_B4 SAR12_UNIT
XN_FINE_B4_U2 FINEN N_FINE_B4 SAR12_UNIT
XN_FINE_B4_U20 FINEN N_FINE_B4 SAR12_UNIT
XN_FINE_B4_U21 FINEN N_FINE_B4 SAR12_UNIT
XN_FINE_B4_U22 FINEN N_FINE_B4 SAR12_UNIT
XN_FINE_B4_U23 FINEN N_FINE_B4 SAR12_UNIT
XN_FINE_B4_U24 FINEN N_FINE_B4 SAR12_UNIT
XN_FINE_B4_U25 FINEN N_FINE_B4 SAR12_UNIT
XN_FINE_B4_U26 FINEN N_FINE_B4 SAR12_UNIT
XN_FINE_B4_U27 FINEN N_FINE_B4 SAR12_UNIT
XN_FINE_B4_U28 FINEN N_FINE_B4 SAR12_UNIT
XN_FINE_B4_U29 FINEN N_FINE_B4 SAR12_UNIT
XN_FINE_B4_U3 FINEN N_FINE_B4 SAR12_UNIT
XN_FINE_B4_U30 FINEN N_FINE_B4 SAR12_UNIT
XN_FINE_B4_U31 FINEN N_FINE_B4 SAR12_UNIT
XN_FINE_B4_U4 FINEN N_FINE_B4 SAR12_UNIT
XN_FINE_B4_U5 FINEN N_FINE_B4 SAR12_UNIT
XN_FINE_B4_U6 FINEN N_FINE_B4 SAR12_UNIT
XN_FINE_B4_U7 FINEN N_FINE_B4 SAR12_UNIT
XN_FINE_B4_U8 FINEN N_FINE_B4 SAR12_UNIT
XN_FINE_B4_U9 FINEN N_FINE_B4 SAR12_UNIT
XN_FINE_B5_SW LON HIN B5 N_FINE_B5 VPWR VGND SAR12_BITMUX
XN_FINE_B5_U0 FINEN N_FINE_B5 SAR12_UNIT
XN_FINE_B5_U1 FINEN N_FINE_B5 SAR12_UNIT
XN_FINE_B5_U10 FINEN N_FINE_B5 SAR12_UNIT
XN_FINE_B5_U11 FINEN N_FINE_B5 SAR12_UNIT
XN_FINE_B5_U12 FINEN N_FINE_B5 SAR12_UNIT
XN_FINE_B5_U13 FINEN N_FINE_B5 SAR12_UNIT
XN_FINE_B5_U14 FINEN N_FINE_B5 SAR12_UNIT
XN_FINE_B5_U15 FINEN N_FINE_B5 SAR12_UNIT
XN_FINE_B5_U16 FINEN N_FINE_B5 SAR12_UNIT
XN_FINE_B5_U17 FINEN N_FINE_B5 SAR12_UNIT
XN_FINE_B5_U18 FINEN N_FINE_B5 SAR12_UNIT
XN_FINE_B5_U19 FINEN N_FINE_B5 SAR12_UNIT
XN_FINE_B5_U2 FINEN N_FINE_B5 SAR12_UNIT
XN_FINE_B5_U20 FINEN N_FINE_B5 SAR12_UNIT
XN_FINE_B5_U21 FINEN N_FINE_B5 SAR12_UNIT
XN_FINE_B5_U22 FINEN N_FINE_B5 SAR12_UNIT
XN_FINE_B5_U23 FINEN N_FINE_B5 SAR12_UNIT
XN_FINE_B5_U24 FINEN N_FINE_B5 SAR12_UNIT
XN_FINE_B5_U25 FINEN N_FINE_B5 SAR12_UNIT
XN_FINE_B5_U26 FINEN N_FINE_B5 SAR12_UNIT
XN_FINE_B5_U27 FINEN N_FINE_B5 SAR12_UNIT
XN_FINE_B5_U28 FINEN N_FINE_B5 SAR12_UNIT
XN_FINE_B5_U29 FINEN N_FINE_B5 SAR12_UNIT
XN_FINE_B5_U3 FINEN N_FINE_B5 SAR12_UNIT
XN_FINE_B5_U30 FINEN N_FINE_B5 SAR12_UNIT
XN_FINE_B5_U31 FINEN N_FINE_B5 SAR12_UNIT
XN_FINE_B5_U32 FINEN N_FINE_B5 SAR12_UNIT
XN_FINE_B5_U33 FINEN N_FINE_B5 SAR12_UNIT
XN_FINE_B5_U34 FINEN N_FINE_B5 SAR12_UNIT
XN_FINE_B5_U35 FINEN N_FINE_B5 SAR12_UNIT
XN_FINE_B5_U36 FINEN N_FINE_B5 SAR12_UNIT
XN_FINE_B5_U37 FINEN N_FINE_B5 SAR12_UNIT
XN_FINE_B5_U38 FINEN N_FINE_B5 SAR12_UNIT
XN_FINE_B5_U39 FINEN N_FINE_B5 SAR12_UNIT
XN_FINE_B5_U4 FINEN N_FINE_B5 SAR12_UNIT
XN_FINE_B5_U40 FINEN N_FINE_B5 SAR12_UNIT
XN_FINE_B5_U41 FINEN N_FINE_B5 SAR12_UNIT
XN_FINE_B5_U42 FINEN N_FINE_B5 SAR12_UNIT
XN_FINE_B5_U43 FINEN N_FINE_B5 SAR12_UNIT
XN_FINE_B5_U44 FINEN N_FINE_B5 SAR12_UNIT
XN_FINE_B5_U45 FINEN N_FINE_B5 SAR12_UNIT
XN_FINE_B5_U46 FINEN N_FINE_B5 SAR12_UNIT
XN_FINE_B5_U47 FINEN N_FINE_B5 SAR12_UNIT
XN_FINE_B5_U48 FINEN N_FINE_B5 SAR12_UNIT
XN_FINE_B5_U49 FINEN N_FINE_B5 SAR12_UNIT
XN_FINE_B5_U5 FINEN N_FINE_B5 SAR12_UNIT
XN_FINE_B5_U50 FINEN N_FINE_B5 SAR12_UNIT
XN_FINE_B5_U51 FINEN N_FINE_B5 SAR12_UNIT
XN_FINE_B5_U52 FINEN N_FINE_B5 SAR12_UNIT
XN_FINE_B5_U53 FINEN N_FINE_B5 SAR12_UNIT
XN_FINE_B5_U54 FINEN N_FINE_B5 SAR12_UNIT
XN_FINE_B5_U55 FINEN N_FINE_B5 SAR12_UNIT
XN_FINE_B5_U56 FINEN N_FINE_B5 SAR12_UNIT
XN_FINE_B5_U57 FINEN N_FINE_B5 SAR12_UNIT
XN_FINE_B5_U58 FINEN N_FINE_B5 SAR12_UNIT
XN_FINE_B5_U59 FINEN N_FINE_B5 SAR12_UNIT
XN_FINE_B5_U6 FINEN N_FINE_B5 SAR12_UNIT
XN_FINE_B5_U60 FINEN N_FINE_B5 SAR12_UNIT
XN_FINE_B5_U61 FINEN N_FINE_B5 SAR12_UNIT
XN_FINE_B5_U62 FINEN N_FINE_B5 SAR12_UNIT
XN_FINE_B5_U63 FINEN N_FINE_B5 SAR12_UNIT
XN_FINE_B5_U7 FINEN N_FINE_B5 SAR12_UNIT
XN_FINE_B5_U8 FINEN N_FINE_B5 SAR12_UNIT
XN_FINE_B5_U9 FINEN N_FINE_B5 SAR12_UNIT
XN_FINE_DUMMY_U0 FINEN HIN SAR12_UNIT
XN_FINE_DUMMY_U1 FINEN HIN SAR12_UNIT
XP_COARSE_B0_SW HIP LOP B6 P_COARSE_B0 VPWR VGND SAR12_BITMUX
XP_COARSE_B0_U0 TOPP P_COARSE_B0 SAR12_UNIT
XP_COARSE_B0_U1 TOPP P_COARSE_B0 SAR12_UNIT
XP_COARSE_B1_SW HIP LOP B7 P_COARSE_B1 VPWR VGND SAR12_BITMUX
XP_COARSE_B1_U0 TOPP P_COARSE_B1 SAR12_UNIT
XP_COARSE_B1_U1 TOPP P_COARSE_B1 SAR12_UNIT
XP_COARSE_B1_U2 TOPP P_COARSE_B1 SAR12_UNIT
XP_COARSE_B1_U3 TOPP P_COARSE_B1 SAR12_UNIT
XP_COARSE_B2_SW HIP LOP B8 P_COARSE_B2 VPWR VGND SAR12_BITMUX
XP_COARSE_B2_U0 TOPP P_COARSE_B2 SAR12_UNIT
XP_COARSE_B2_U1 TOPP P_COARSE_B2 SAR12_UNIT
XP_COARSE_B2_U2 TOPP P_COARSE_B2 SAR12_UNIT
XP_COARSE_B2_U3 TOPP P_COARSE_B2 SAR12_UNIT
XP_COARSE_B2_U4 TOPP P_COARSE_B2 SAR12_UNIT
XP_COARSE_B2_U5 TOPP P_COARSE_B2 SAR12_UNIT
XP_COARSE_B2_U6 TOPP P_COARSE_B2 SAR12_UNIT
XP_COARSE_B2_U7 TOPP P_COARSE_B2 SAR12_UNIT
XP_COARSE_B3_SW HIP LOP B9 P_COARSE_B3 VPWR VGND SAR12_BITMUX
XP_COARSE_B3_U0 TOPP P_COARSE_B3 SAR12_UNIT
XP_COARSE_B3_U1 TOPP P_COARSE_B3 SAR12_UNIT
XP_COARSE_B3_U10 TOPP P_COARSE_B3 SAR12_UNIT
XP_COARSE_B3_U11 TOPP P_COARSE_B3 SAR12_UNIT
XP_COARSE_B3_U12 TOPP P_COARSE_B3 SAR12_UNIT
XP_COARSE_B3_U13 TOPP P_COARSE_B3 SAR12_UNIT
XP_COARSE_B3_U14 TOPP P_COARSE_B3 SAR12_UNIT
XP_COARSE_B3_U15 TOPP P_COARSE_B3 SAR12_UNIT
XP_COARSE_B3_U2 TOPP P_COARSE_B3 SAR12_UNIT
XP_COARSE_B3_U3 TOPP P_COARSE_B3 SAR12_UNIT
XP_COARSE_B3_U4 TOPP P_COARSE_B3 SAR12_UNIT
XP_COARSE_B3_U5 TOPP P_COARSE_B3 SAR12_UNIT
XP_COARSE_B3_U6 TOPP P_COARSE_B3 SAR12_UNIT
XP_COARSE_B3_U7 TOPP P_COARSE_B3 SAR12_UNIT
XP_COARSE_B3_U8 TOPP P_COARSE_B3 SAR12_UNIT
XP_COARSE_B3_U9 TOPP P_COARSE_B3 SAR12_UNIT
XP_COARSE_B4_SW HIP LOP B10 P_COARSE_B4 VPWR VGND SAR12_BITMUX
XP_COARSE_B4_U0 TOPP P_COARSE_B4 SAR12_UNIT
XP_COARSE_B4_U1 TOPP P_COARSE_B4 SAR12_UNIT
XP_COARSE_B4_U10 TOPP P_COARSE_B4 SAR12_UNIT
XP_COARSE_B4_U11 TOPP P_COARSE_B4 SAR12_UNIT
XP_COARSE_B4_U12 TOPP P_COARSE_B4 SAR12_UNIT
XP_COARSE_B4_U13 TOPP P_COARSE_B4 SAR12_UNIT
XP_COARSE_B4_U14 TOPP P_COARSE_B4 SAR12_UNIT
XP_COARSE_B4_U15 TOPP P_COARSE_B4 SAR12_UNIT
XP_COARSE_B4_U16 TOPP P_COARSE_B4 SAR12_UNIT
XP_COARSE_B4_U17 TOPP P_COARSE_B4 SAR12_UNIT
XP_COARSE_B4_U18 TOPP P_COARSE_B4 SAR12_UNIT
XP_COARSE_B4_U19 TOPP P_COARSE_B4 SAR12_UNIT
XP_COARSE_B4_U2 TOPP P_COARSE_B4 SAR12_UNIT
XP_COARSE_B4_U20 TOPP P_COARSE_B4 SAR12_UNIT
XP_COARSE_B4_U21 TOPP P_COARSE_B4 SAR12_UNIT
XP_COARSE_B4_U22 TOPP P_COARSE_B4 SAR12_UNIT
XP_COARSE_B4_U23 TOPP P_COARSE_B4 SAR12_UNIT
XP_COARSE_B4_U24 TOPP P_COARSE_B4 SAR12_UNIT
XP_COARSE_B4_U25 TOPP P_COARSE_B4 SAR12_UNIT
XP_COARSE_B4_U26 TOPP P_COARSE_B4 SAR12_UNIT
XP_COARSE_B4_U27 TOPP P_COARSE_B4 SAR12_UNIT
XP_COARSE_B4_U28 TOPP P_COARSE_B4 SAR12_UNIT
XP_COARSE_B4_U29 TOPP P_COARSE_B4 SAR12_UNIT
XP_COARSE_B4_U3 TOPP P_COARSE_B4 SAR12_UNIT
XP_COARSE_B4_U30 TOPP P_COARSE_B4 SAR12_UNIT
XP_COARSE_B4_U31 TOPP P_COARSE_B4 SAR12_UNIT
XP_COARSE_B4_U4 TOPP P_COARSE_B4 SAR12_UNIT
XP_COARSE_B4_U5 TOPP P_COARSE_B4 SAR12_UNIT
XP_COARSE_B4_U6 TOPP P_COARSE_B4 SAR12_UNIT
XP_COARSE_B4_U7 TOPP P_COARSE_B4 SAR12_UNIT
XP_COARSE_B4_U8 TOPP P_COARSE_B4 SAR12_UNIT
XP_COARSE_B4_U9 TOPP P_COARSE_B4 SAR12_UNIT
XP_COARSE_B5_SW HIP LOP B11 P_COARSE_B5 VPWR VGND SAR12_BITMUX
XP_COARSE_B5_U0 TOPP P_COARSE_B5 SAR12_UNIT
XP_COARSE_B5_U1 TOPP P_COARSE_B5 SAR12_UNIT
XP_COARSE_B5_U10 TOPP P_COARSE_B5 SAR12_UNIT
XP_COARSE_B5_U11 TOPP P_COARSE_B5 SAR12_UNIT
XP_COARSE_B5_U12 TOPP P_COARSE_B5 SAR12_UNIT
XP_COARSE_B5_U13 TOPP P_COARSE_B5 SAR12_UNIT
XP_COARSE_B5_U14 TOPP P_COARSE_B5 SAR12_UNIT
XP_COARSE_B5_U15 TOPP P_COARSE_B5 SAR12_UNIT
XP_COARSE_B5_U16 TOPP P_COARSE_B5 SAR12_UNIT
XP_COARSE_B5_U17 TOPP P_COARSE_B5 SAR12_UNIT
XP_COARSE_B5_U18 TOPP P_COARSE_B5 SAR12_UNIT
XP_COARSE_B5_U19 TOPP P_COARSE_B5 SAR12_UNIT
XP_COARSE_B5_U2 TOPP P_COARSE_B5 SAR12_UNIT
XP_COARSE_B5_U20 TOPP P_COARSE_B5 SAR12_UNIT
XP_COARSE_B5_U21 TOPP P_COARSE_B5 SAR12_UNIT
XP_COARSE_B5_U22 TOPP P_COARSE_B5 SAR12_UNIT
XP_COARSE_B5_U23 TOPP P_COARSE_B5 SAR12_UNIT
XP_COARSE_B5_U24 TOPP P_COARSE_B5 SAR12_UNIT
XP_COARSE_B5_U25 TOPP P_COARSE_B5 SAR12_UNIT
XP_COARSE_B5_U26 TOPP P_COARSE_B5 SAR12_UNIT
XP_COARSE_B5_U27 TOPP P_COARSE_B5 SAR12_UNIT
XP_COARSE_B5_U28 TOPP P_COARSE_B5 SAR12_UNIT
XP_COARSE_B5_U29 TOPP P_COARSE_B5 SAR12_UNIT
XP_COARSE_B5_U3 TOPP P_COARSE_B5 SAR12_UNIT
XP_COARSE_B5_U30 TOPP P_COARSE_B5 SAR12_UNIT
XP_COARSE_B5_U31 TOPP P_COARSE_B5 SAR12_UNIT
XP_COARSE_B5_U32 TOPP P_COARSE_B5 SAR12_UNIT
XP_COARSE_B5_U33 TOPP P_COARSE_B5 SAR12_UNIT
XP_COARSE_B5_U34 TOPP P_COARSE_B5 SAR12_UNIT
XP_COARSE_B5_U35 TOPP P_COARSE_B5 SAR12_UNIT
XP_COARSE_B5_U36 TOPP P_COARSE_B5 SAR12_UNIT
XP_COARSE_B5_U37 TOPP P_COARSE_B5 SAR12_UNIT
XP_COARSE_B5_U38 TOPP P_COARSE_B5 SAR12_UNIT
XP_COARSE_B5_U39 TOPP P_COARSE_B5 SAR12_UNIT
XP_COARSE_B5_U4 TOPP P_COARSE_B5 SAR12_UNIT
XP_COARSE_B5_U40 TOPP P_COARSE_B5 SAR12_UNIT
XP_COARSE_B5_U41 TOPP P_COARSE_B5 SAR12_UNIT
XP_COARSE_B5_U42 TOPP P_COARSE_B5 SAR12_UNIT
XP_COARSE_B5_U43 TOPP P_COARSE_B5 SAR12_UNIT
XP_COARSE_B5_U44 TOPP P_COARSE_B5 SAR12_UNIT
XP_COARSE_B5_U45 TOPP P_COARSE_B5 SAR12_UNIT
XP_COARSE_B5_U46 TOPP P_COARSE_B5 SAR12_UNIT
XP_COARSE_B5_U47 TOPP P_COARSE_B5 SAR12_UNIT
XP_COARSE_B5_U48 TOPP P_COARSE_B5 SAR12_UNIT
XP_COARSE_B5_U49 TOPP P_COARSE_B5 SAR12_UNIT
XP_COARSE_B5_U5 TOPP P_COARSE_B5 SAR12_UNIT
XP_COARSE_B5_U50 TOPP P_COARSE_B5 SAR12_UNIT
XP_COARSE_B5_U51 TOPP P_COARSE_B5 SAR12_UNIT
XP_COARSE_B5_U52 TOPP P_COARSE_B5 SAR12_UNIT
XP_COARSE_B5_U53 TOPP P_COARSE_B5 SAR12_UNIT
XP_COARSE_B5_U54 TOPP P_COARSE_B5 SAR12_UNIT
XP_COARSE_B5_U55 TOPP P_COARSE_B5 SAR12_UNIT
XP_COARSE_B5_U56 TOPP P_COARSE_B5 SAR12_UNIT
XP_COARSE_B5_U57 TOPP P_COARSE_B5 SAR12_UNIT
XP_COARSE_B5_U58 TOPP P_COARSE_B5 SAR12_UNIT
XP_COARSE_B5_U59 TOPP P_COARSE_B5 SAR12_UNIT
XP_COARSE_B5_U6 TOPP P_COARSE_B5 SAR12_UNIT
XP_COARSE_B5_U60 TOPP P_COARSE_B5 SAR12_UNIT
XP_COARSE_B5_U61 TOPP P_COARSE_B5 SAR12_UNIT
XP_COARSE_B5_U62 TOPP P_COARSE_B5 SAR12_UNIT
XP_COARSE_B5_U63 TOPP P_COARSE_B5 SAR12_UNIT
XP_COARSE_B5_U7 TOPP P_COARSE_B5 SAR12_UNIT
XP_COARSE_B5_U8 TOPP P_COARSE_B5 SAR12_UNIT
XP_COARSE_B5_U9 TOPP P_COARSE_B5 SAR12_UNIT
XP_FINE_B0_SW HIP LOP B0 P_FINE_B0 VPWR VGND SAR12_BITMUX
XP_FINE_B0_U0 FINEP P_FINE_B0 SAR12_UNIT
XP_FINE_B0_U1 FINEP P_FINE_B0 SAR12_UNIT
XP_FINE_B1_SW HIP LOP B1 P_FINE_B1 VPWR VGND SAR12_BITMUX
XP_FINE_B1_U0 FINEP P_FINE_B1 SAR12_UNIT
XP_FINE_B1_U1 FINEP P_FINE_B1 SAR12_UNIT
XP_FINE_B1_U2 FINEP P_FINE_B1 SAR12_UNIT
XP_FINE_B1_U3 FINEP P_FINE_B1 SAR12_UNIT
XP_FINE_B2_SW HIP LOP B2 P_FINE_B2 VPWR VGND SAR12_BITMUX
XP_FINE_B2_U0 FINEP P_FINE_B2 SAR12_UNIT
XP_FINE_B2_U1 FINEP P_FINE_B2 SAR12_UNIT
XP_FINE_B2_U2 FINEP P_FINE_B2 SAR12_UNIT
XP_FINE_B2_U3 FINEP P_FINE_B2 SAR12_UNIT
XP_FINE_B2_U4 FINEP P_FINE_B2 SAR12_UNIT
XP_FINE_B2_U5 FINEP P_FINE_B2 SAR12_UNIT
XP_FINE_B2_U6 FINEP P_FINE_B2 SAR12_UNIT
XP_FINE_B2_U7 FINEP P_FINE_B2 SAR12_UNIT
XP_FINE_B3_SW HIP LOP B3 P_FINE_B3 VPWR VGND SAR12_BITMUX
XP_FINE_B3_U0 FINEP P_FINE_B3 SAR12_UNIT
XP_FINE_B3_U1 FINEP P_FINE_B3 SAR12_UNIT
XP_FINE_B3_U10 FINEP P_FINE_B3 SAR12_UNIT
XP_FINE_B3_U11 FINEP P_FINE_B3 SAR12_UNIT
XP_FINE_B3_U12 FINEP P_FINE_B3 SAR12_UNIT
XP_FINE_B3_U13 FINEP P_FINE_B3 SAR12_UNIT
XP_FINE_B3_U14 FINEP P_FINE_B3 SAR12_UNIT
XP_FINE_B3_U15 FINEP P_FINE_B3 SAR12_UNIT
XP_FINE_B3_U2 FINEP P_FINE_B3 SAR12_UNIT
XP_FINE_B3_U3 FINEP P_FINE_B3 SAR12_UNIT
XP_FINE_B3_U4 FINEP P_FINE_B3 SAR12_UNIT
XP_FINE_B3_U5 FINEP P_FINE_B3 SAR12_UNIT
XP_FINE_B3_U6 FINEP P_FINE_B3 SAR12_UNIT
XP_FINE_B3_U7 FINEP P_FINE_B3 SAR12_UNIT
XP_FINE_B3_U8 FINEP P_FINE_B3 SAR12_UNIT
XP_FINE_B3_U9 FINEP P_FINE_B3 SAR12_UNIT
XP_FINE_B4_SW HIP LOP B4 P_FINE_B4 VPWR VGND SAR12_BITMUX
XP_FINE_B4_U0 FINEP P_FINE_B4 SAR12_UNIT
XP_FINE_B4_U1 FINEP P_FINE_B4 SAR12_UNIT
XP_FINE_B4_U10 FINEP P_FINE_B4 SAR12_UNIT
XP_FINE_B4_U11 FINEP P_FINE_B4 SAR12_UNIT
XP_FINE_B4_U12 FINEP P_FINE_B4 SAR12_UNIT
XP_FINE_B4_U13 FINEP P_FINE_B4 SAR12_UNIT
XP_FINE_B4_U14 FINEP P_FINE_B4 SAR12_UNIT
XP_FINE_B4_U15 FINEP P_FINE_B4 SAR12_UNIT
XP_FINE_B4_U16 FINEP P_FINE_B4 SAR12_UNIT
XP_FINE_B4_U17 FINEP P_FINE_B4 SAR12_UNIT
XP_FINE_B4_U18 FINEP P_FINE_B4 SAR12_UNIT
XP_FINE_B4_U19 FINEP P_FINE_B4 SAR12_UNIT
XP_FINE_B4_U2 FINEP P_FINE_B4 SAR12_UNIT
XP_FINE_B4_U20 FINEP P_FINE_B4 SAR12_UNIT
XP_FINE_B4_U21 FINEP P_FINE_B4 SAR12_UNIT
XP_FINE_B4_U22 FINEP P_FINE_B4 SAR12_UNIT
XP_FINE_B4_U23 FINEP P_FINE_B4 SAR12_UNIT
XP_FINE_B4_U24 FINEP P_FINE_B4 SAR12_UNIT
XP_FINE_B4_U25 FINEP P_FINE_B4 SAR12_UNIT
XP_FINE_B4_U26 FINEP P_FINE_B4 SAR12_UNIT
XP_FINE_B4_U27 FINEP P_FINE_B4 SAR12_UNIT
XP_FINE_B4_U28 FINEP P_FINE_B4 SAR12_UNIT
XP_FINE_B4_U29 FINEP P_FINE_B4 SAR12_UNIT
XP_FINE_B4_U3 FINEP P_FINE_B4 SAR12_UNIT
XP_FINE_B4_U30 FINEP P_FINE_B4 SAR12_UNIT
XP_FINE_B4_U31 FINEP P_FINE_B4 SAR12_UNIT
XP_FINE_B4_U4 FINEP P_FINE_B4 SAR12_UNIT
XP_FINE_B4_U5 FINEP P_FINE_B4 SAR12_UNIT
XP_FINE_B4_U6 FINEP P_FINE_B4 SAR12_UNIT
XP_FINE_B4_U7 FINEP P_FINE_B4 SAR12_UNIT
XP_FINE_B4_U8 FINEP P_FINE_B4 SAR12_UNIT
XP_FINE_B4_U9 FINEP P_FINE_B4 SAR12_UNIT
XP_FINE_B5_SW HIP LOP B5 P_FINE_B5 VPWR VGND SAR12_BITMUX
XP_FINE_B5_U0 FINEP P_FINE_B5 SAR12_UNIT
XP_FINE_B5_U1 FINEP P_FINE_B5 SAR12_UNIT
XP_FINE_B5_U10 FINEP P_FINE_B5 SAR12_UNIT
XP_FINE_B5_U11 FINEP P_FINE_B5 SAR12_UNIT
XP_FINE_B5_U12 FINEP P_FINE_B5 SAR12_UNIT
XP_FINE_B5_U13 FINEP P_FINE_B5 SAR12_UNIT
XP_FINE_B5_U14 FINEP P_FINE_B5 SAR12_UNIT
XP_FINE_B5_U15 FINEP P_FINE_B5 SAR12_UNIT
XP_FINE_B5_U16 FINEP P_FINE_B5 SAR12_UNIT
XP_FINE_B5_U17 FINEP P_FINE_B5 SAR12_UNIT
XP_FINE_B5_U18 FINEP P_FINE_B5 SAR12_UNIT
XP_FINE_B5_U19 FINEP P_FINE_B5 SAR12_UNIT
XP_FINE_B5_U2 FINEP P_FINE_B5 SAR12_UNIT
XP_FINE_B5_U20 FINEP P_FINE_B5 SAR12_UNIT
XP_FINE_B5_U21 FINEP P_FINE_B5 SAR12_UNIT
XP_FINE_B5_U22 FINEP P_FINE_B5 SAR12_UNIT
XP_FINE_B5_U23 FINEP P_FINE_B5 SAR12_UNIT
XP_FINE_B5_U24 FINEP P_FINE_B5 SAR12_UNIT
XP_FINE_B5_U25 FINEP P_FINE_B5 SAR12_UNIT
XP_FINE_B5_U26 FINEP P_FINE_B5 SAR12_UNIT
XP_FINE_B5_U27 FINEP P_FINE_B5 SAR12_UNIT
XP_FINE_B5_U28 FINEP P_FINE_B5 SAR12_UNIT
XP_FINE_B5_U29 FINEP P_FINE_B5 SAR12_UNIT
XP_FINE_B5_U3 FINEP P_FINE_B5 SAR12_UNIT
XP_FINE_B5_U30 FINEP P_FINE_B5 SAR12_UNIT
XP_FINE_B5_U31 FINEP P_FINE_B5 SAR12_UNIT
XP_FINE_B5_U32 FINEP P_FINE_B5 SAR12_UNIT
XP_FINE_B5_U33 FINEP P_FINE_B5 SAR12_UNIT
XP_FINE_B5_U34 FINEP P_FINE_B5 SAR12_UNIT
XP_FINE_B5_U35 FINEP P_FINE_B5 SAR12_UNIT
XP_FINE_B5_U36 FINEP P_FINE_B5 SAR12_UNIT
XP_FINE_B5_U37 FINEP P_FINE_B5 SAR12_UNIT
XP_FINE_B5_U38 FINEP P_FINE_B5 SAR12_UNIT
XP_FINE_B5_U39 FINEP P_FINE_B5 SAR12_UNIT
XP_FINE_B5_U4 FINEP P_FINE_B5 SAR12_UNIT
XP_FINE_B5_U40 FINEP P_FINE_B5 SAR12_UNIT
XP_FINE_B5_U41 FINEP P_FINE_B5 SAR12_UNIT
XP_FINE_B5_U42 FINEP P_FINE_B5 SAR12_UNIT
XP_FINE_B5_U43 FINEP P_FINE_B5 SAR12_UNIT
XP_FINE_B5_U44 FINEP P_FINE_B5 SAR12_UNIT
XP_FINE_B5_U45 FINEP P_FINE_B5 SAR12_UNIT
XP_FINE_B5_U46 FINEP P_FINE_B5 SAR12_UNIT
XP_FINE_B5_U47 FINEP P_FINE_B5 SAR12_UNIT
XP_FINE_B5_U48 FINEP P_FINE_B5 SAR12_UNIT
XP_FINE_B5_U49 FINEP P_FINE_B5 SAR12_UNIT
XP_FINE_B5_U5 FINEP P_FINE_B5 SAR12_UNIT
XP_FINE_B5_U50 FINEP P_FINE_B5 SAR12_UNIT
XP_FINE_B5_U51 FINEP P_FINE_B5 SAR12_UNIT
XP_FINE_B5_U52 FINEP P_FINE_B5 SAR12_UNIT
XP_FINE_B5_U53 FINEP P_FINE_B5 SAR12_UNIT
XP_FINE_B5_U54 FINEP P_FINE_B5 SAR12_UNIT
XP_FINE_B5_U55 FINEP P_FINE_B5 SAR12_UNIT
XP_FINE_B5_U56 FINEP P_FINE_B5 SAR12_UNIT
XP_FINE_B5_U57 FINEP P_FINE_B5 SAR12_UNIT
XP_FINE_B5_U58 FINEP P_FINE_B5 SAR12_UNIT
XP_FINE_B5_U59 FINEP P_FINE_B5 SAR12_UNIT
XP_FINE_B5_U6 FINEP P_FINE_B5 SAR12_UNIT
XP_FINE_B5_U60 FINEP P_FINE_B5 SAR12_UNIT
XP_FINE_B5_U61 FINEP P_FINE_B5 SAR12_UNIT
XP_FINE_B5_U62 FINEP P_FINE_B5 SAR12_UNIT
XP_FINE_B5_U63 FINEP P_FINE_B5 SAR12_UNIT
XP_FINE_B5_U7 FINEP P_FINE_B5 SAR12_UNIT
XP_FINE_B5_U8 FINEP P_FINE_B5 SAR12_UNIT
XP_FINE_B5_U9 FINEP P_FINE_B5 SAR12_UNIT
XP_FINE_DUMMY_U0 FINEP LOP SAR12_UNIT
XP_FINE_DUMMY_U1 FINEP LOP SAR12_UNIT
XREF_HIN VINN VREF SAMPLE SAMPLEB HIN VPWR VGND SAR12_REFMUX
XREF_HIP VINP VREF SAMPLE SAMPLEB HIP VPWR VGND SAR12_REFMUX
XREF_LON VINN VGND SAMPLE SAMPLEB LON VPWR VGND SAR12_REFMUX
XREF_LOP VINP VGND SAMPLE SAMPLEB LOP VPWR VGND SAR12_REFMUX
XRESET_FINEN VCM FINEN SAMPLE SAMPLEB VPWR VGND SAR12_TG
XRESET_FINEP VCM FINEP SAMPLE SAMPLEB VPWR VGND SAR12_TG
XRESET_TOPN VCM TOPN SAMPLE SAMPLEB VPWR VGND SAR12_TG
XRESET_TOPP VCM TOPP SAMPLE SAMPLEB VPWR VGND SAR12_TG
XSAMPLE_INV SAMPLE SAMPLEB VPWR VGND INV
.ends SAR12_CDAC
.subckt SAR12_PREAMP INP INN BIAS OUTP OUTN VPWR VGND
XINPUT0 OUTN INP TAIL VGND sky130_fd_pr__nfet_01v8 w=10 l=1 nf=1 m=1
XINPUT1 OUTP INN TAIL VGND sky130_fd_pr__nfet_01v8 w=10 l=1 nf=1 m=1
XINPUT2 OUTP INN TAIL VGND sky130_fd_pr__nfet_01v8 w=10 l=1 nf=1 m=1
XINPUT3 OUTN INP TAIL VGND sky130_fd_pr__nfet_01v8 w=10 l=1 nf=1 m=1
RLOAD_OUTN VPWR OUTN 100000
RLOAD_OUTP VPWR OUTP 100000
XTAIL TAIL BIAS VGND VGND sky130_fd_pr__nfet_01v8 w=4 l=1 nf=1 m=1
.ends SAR12_PREAMP
.subckt SAR12_LATCH INP INN EVAL OUTP OUTN VPWR VGND
XBUF0_OUTN QP OUTN_B VPWR VGND INV
XBUF0_OUTP QN OUTP_B VPWR VGND INV
XBUF1_OUTN OUTN_B OUTN VPWR VGND INV
XBUF1_OUTP OUTP_B OUTP VPWR VGND INV
XINPUT0 FN INP TAIL VGND sky130_fd_pr__nfet_01v8 w=10 l=0.5 nf=1 m=1
XINPUT1 FP INN TAIL VGND sky130_fd_pr__nfet_01v8 w=10 l=0.5 nf=1 m=1
XINPUT2 FP INN TAIL VGND sky130_fd_pr__nfet_01v8 w=10 l=0.5 nf=1 m=1
XINPUT3 FN INP TAIL VGND sky130_fd_pr__nfet_01v8 w=10 l=0.5 nf=1 m=1
XLN_QN QN QP FP VGND sky130_fd_pr__nfet_01v8 w=8 l=0.15 nf=1 m=1
XLN_QP QP QN FN VGND sky130_fd_pr__nfet_01v8 w=8 l=0.15 nf=1 m=1
XLP_QN QN QP VPWR VPWR sky130_fd_pr__pfet_01v8_hvt w=4 l=0.15 nf=1 m=1
XLP_QP QP QN VPWR VPWR sky130_fd_pr__pfet_01v8_hvt w=4 l=0.15 nf=1 m=1
XPRE_FN FN EVAL VPWR VPWR sky130_fd_pr__pfet_01v8_hvt w=2 l=0.15 nf=1 m=1
XPRE_FP FP EVAL VPWR VPWR sky130_fd_pr__pfet_01v8_hvt w=2 l=0.15 nf=1 m=1
XRESET_QN QN EVAL VPWR VPWR sky130_fd_pr__pfet_01v8_hvt w=4 l=0.15 nf=1 m=1
XRESET_QP QP EVAL VPWR VPWR sky130_fd_pr__pfet_01v8_hvt w=4 l=0.15 nf=1 m=1
XTAIL TAIL EVAL VGND VGND sky130_fd_pr__nfet_01v8 w=20 l=0.15 nf=1 m=1
.ends SAR12_LATCH
.subckt SAR12_COMPARATOR INP INN EVAL OUTP OUTN VPWR VGND
XBIAS_DIODE BIAS BIAS VGND VGND sky130_fd_pr__nfet_01v8 w=4 l=1 nf=1 m=1
RBIAS_RES VPWR BIAS 100000
XLATCH PRE1P PRE1N EVAL OUTP OUTN VPWR VGND SAR12_LATCH
CLOAD_PRE1N PRE1N VGND 5e-13
CLOAD_PRE1P PRE1P VGND 5e-13
XPRE0 INP INN BIAS PRE0P PRE0N VPWR VGND SAR12_PREAMP
XPRE1 PRE0P PRE0N BIAS PRE1P PRE1N VPWR VGND SAR12_PREAMP
.ends SAR12_COMPARATOR
.subckt sar12_analog VINP VINN VREF VCM SAMPLE EVAL TOPP TOPN COMP COMPN B0 B1 B2 B3 B4 B5 B6 B7 B8 B9 B10 B11 VPWR VGND
XCOMPARE TOPN TOPP EVAL COMP COMPN VPWR VGND SAR12_COMPARATOR
XDAC VINP VINN VREF VCM SAMPLE TOPP TOPN B0 B1 B2 B3 B4 B5 B6 B7 B8 B9 B10 B11 VPWR VGND SAR12_CDAC
.ends sar12_analog

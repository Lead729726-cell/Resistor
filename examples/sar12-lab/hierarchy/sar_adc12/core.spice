.subckt INV A Y VPWR VGND
XMN Y A VGND VGND sky130_fd_pr__nfet_01v8 w=0.65 l=0.15 nf=1 m=1
XMP Y A VPWR VPWR sky130_fd_pr__pfet_01v8_hvt w=0.65 l=0.15 nf=1 m=1
.ends INV
.subckt SAR12_TG A Y EN ENB VPWR VGND
XN A EN Y VGND sky130_fd_pr__nfet_01v8 w=8 l=0.15 nf=1 m=1
XP A ENB Y VPWR sky130_fd_pr__pfet_01v8_hvt w=12 l=0.15 nf=1 m=1
.ends SAR12_TG
.subckt SAR12_REFMUX VIN REF SAMPLE SAMPLEB OUT VPWR VGND
XACQUIRE VIN OUT SAMPLE SAMPLEB VPWR VGND SAR12_TG
XCONVERT REF OUT SAMPLEB SAMPLE VPWR VGND SAR12_TG
.ends SAR12_REFMUX
.subckt SAR12_BRIDGE TOP FINE
CC_BRIDGE TOP FINE 4.06349206349e-13
.ends SAR12_BRIDGE
.subckt SAR12_BITMUX HI LO BIT OUT VPWR VGND
XHIGH HI OUT BIT BITB VPWR VGND SAR12_TG
XINV BIT BITB VPWR VGND INV
XLOW LO OUT BITB BIT VPWR VGND SAR12_TG
.ends SAR12_BITMUX
.subckt SAR12_UNIT TOP BOTTOM
CC_UNIT TOP BOTTOM 2e-13
.ends SAR12_UNIT
.subckt SAR12_CDAC VINP VINN VREF VCM SAMPLE TOPP TOPN B0 B1 B2 B3 B4 B5 B6 B7 B8 B9 B10 B11 VPWR VGND
XBRIDGEN TOPN FINEN SAR12_BRIDGE
XBRIDGEP TOPP FINEP SAR12_BRIDGE
XN_COARSE_B0_SW LON HIN B6 N_COARSE_B0 VPWR VGND SAR12_BITMUX
XN_COARSE_B0_U0 TOPN N_COARSE_B0 SAR12_UNIT
XN_COARSE_B0_U1 TOPN N_COARSE_B0 SAR12_UNIT
XN_COARSE_B1_SW LON HIN B7 N_COARSE_B1 VPWR VGND SAR12_BITMUX
XN_COARSE_B1_U0 TOPN N_COARSE_B1 SAR12_UNIT
XN_COARSE_B1_U1 TOPN N_COARSE_B1 SAR12_UNIT
XN_COARSE_B1_U2 TOPN N_COARSE_B1 SAR12_UNIT
XN_COARSE_B1_U3 TOPN N_COARSE_B1 SAR12_UNIT
XN_COARSE_B2_SW LON HIN B8 N_COARSE_B2 VPWR VGND SAR12_BITMUX
XN_COARSE_B2_U0 TOPN N_COARSE_B2 SAR12_UNIT
XN_COARSE_B2_U1 TOPN N_COARSE_B2 SAR12_UNIT
XN_COARSE_B2_U2 TOPN N_COARSE_B2 SAR12_UNIT
XN_COARSE_B2_U3 TOPN N_COARSE_B2 SAR12_UNIT
XN_COARSE_B2_U4 TOPN N_COARSE_B2 SAR12_UNIT
XN_COARSE_B2_U5 TOPN N_COARSE_B2 SAR12_UNIT
XN_COARSE_B2_U6 TOPN N_COARSE_B2 SAR12_UNIT
XN_COARSE_B2_U7 TOPN N_COARSE_B2 SAR12_UNIT
XN_COARSE_B3_SW LON HIN B9 N_COARSE_B3 VPWR VGND SAR12_BITMUX
XN_COARSE_B3_U0 TOPN N_COARSE_B3 SAR12_UNIT
XN_COARSE_B3_U1 TOPN N_COARSE_B3 SAR12_UNIT
XN_COARSE_B3_U10 TOPN N_COARSE_B3 SAR12_UNIT
XN_COARSE_B3_U11 TOPN N_COARSE_B3 SAR12_UNIT
XN_COARSE_B3_U12 TOPN N_COARSE_B3 SAR12_UNIT
XN_COARSE_B3_U13 TOPN N_COARSE_B3 SAR12_UNIT
XN_COARSE_B3_U14 TOPN N_COARSE_B3 SAR12_UNIT
XN_COARSE_B3_U15 TOPN N_COARSE_B3 SAR12_UNIT
XN_COARSE_B3_U2 TOPN N_COARSE_B3 SAR12_UNIT
XN_COARSE_B3_U3 TOPN N_COARSE_B3 SAR12_UNIT
XN_COARSE_B3_U4 TOPN N_COARSE_B3 SAR12_UNIT
XN_COARSE_B3_U5 TOPN N_COARSE_B3 SAR12_UNIT
XN_COARSE_B3_U6 TOPN N_COARSE_B3 SAR12_UNIT
XN_COARSE_B3_U7 TOPN N_COARSE_B3 SAR12_UNIT
XN_COARSE_B3_U8 TOPN N_COARSE_B3 SAR12_UNIT
XN_COARSE_B3_U9 TOPN N_COARSE_B3 SAR12_UNIT
XN_COARSE_B4_SW LON HIN B10 N_COARSE_B4 VPWR VGND SAR12_BITMUX
XN_COARSE_B4_U0 TOPN N_COARSE_B4 SAR12_UNIT
XN_COARSE_B4_U1 TOPN N_COARSE_B4 SAR12_UNIT
XN_COARSE_B4_U10 TOPN N_COARSE_B4 SAR12_UNIT
XN_COARSE_B4_U11 TOPN N_COARSE_B4 SAR12_UNIT
XN_COARSE_B4_U12 TOPN N_COARSE_B4 SAR12_UNIT
XN_COARSE_B4_U13 TOPN N_COARSE_B4 SAR12_UNIT
XN_COARSE_B4_U14 TOPN N_COARSE_B4 SAR12_UNIT
XN_COARSE_B4_U15 TOPN N_COARSE_B4 SAR12_UNIT
XN_COARSE_B4_U16 TOPN N_COARSE_B4 SAR12_UNIT
XN_COARSE_B4_U17 TOPN N_COARSE_B4 SAR12_UNIT
XN_COARSE_B4_U18 TOPN N_COARSE_B4 SAR12_UNIT
XN_COARSE_B4_U19 TOPN N_COARSE_B4 SAR12_UNIT
XN_COARSE_B4_U2 TOPN N_COARSE_B4 SAR12_UNIT
XN_COARSE_B4_U20 TOPN N_COARSE_B4 SAR12_UNIT
XN_COARSE_B4_U21 TOPN N_COARSE_B4 SAR12_UNIT
XN_COARSE_B4_U22 TOPN N_COARSE_B4 SAR12_UNIT
XN_COARSE_B4_U23 TOPN N_COARSE_B4 SAR12_UNIT
XN_COARSE_B4_U24 TOPN N_COARSE_B4 SAR12_UNIT
XN_COARSE_B4_U25 TOPN N_COARSE_B4 SAR12_UNIT
XN_COARSE_B4_U26 TOPN N_COARSE_B4 SAR12_UNIT
XN_COARSE_B4_U27 TOPN N_COARSE_B4 SAR12_UNIT
XN_COARSE_B4_U28 TOPN N_COARSE_B4 SAR12_UNIT
XN_COARSE_B4_U29 TOPN N_COARSE_B4 SAR12_UNIT
XN_COARSE_B4_U3 TOPN N_COARSE_B4 SAR12_UNIT
XN_COARSE_B4_U30 TOPN N_COARSE_B4 SAR12_UNIT
XN_COARSE_B4_U31 TOPN N_COARSE_B4 SAR12_UNIT
XN_COARSE_B4_U4 TOPN N_COARSE_B4 SAR12_UNIT
XN_COARSE_B4_U5 TOPN N_COARSE_B4 SAR12_UNIT
XN_COARSE_B4_U6 TOPN N_COARSE_B4 SAR12_UNIT
XN_COARSE_B4_U7 TOPN N_COARSE_B4 SAR12_UNIT
XN_COARSE_B4_U8 TOPN N_COARSE_B4 SAR12_UNIT
XN_COARSE_B4_U9 TOPN N_COARSE_B4 SAR12_UNIT
XN_COARSE_B5_SW LON HIN B11 N_COARSE_B5 VPWR VGND SAR12_BITMUX
XN_COARSE_B5_U0 TOPN N_COARSE_B5 SAR12_UNIT
XN_COARSE_B5_U1 TOPN N_COARSE_B5 SAR12_UNIT
XN_COARSE_B5_U10 TOPN N_COARSE_B5 SAR12_UNIT
XN_COARSE_B5_U11 TOPN N_COARSE_B5 SAR12_UNIT
XN_COARSE_B5_U12 TOPN N_COARSE_B5 SAR12_UNIT
XN_COARSE_B5_U13 TOPN N_COARSE_B5 SAR12_UNIT
XN_COARSE_B5_U14 TOPN N_COARSE_B5 SAR12_UNIT
XN_COARSE_B5_U15 TOPN N_COARSE_B5 SAR12_UNIT
XN_COARSE_B5_U16 TOPN N_COARSE_B5 SAR12_UNIT
XN_COARSE_B5_U17 TOPN N_COARSE_B5 SAR12_UNIT
XN_COARSE_B5_U18 TOPN N_COARSE_B5 SAR12_UNIT
XN_COARSE_B5_U19 TOPN N_COARSE_B5 SAR12_UNIT
XN_COARSE_B5_U2 TOPN N_COARSE_B5 SAR12_UNIT
XN_COARSE_B5_U20 TOPN N_COARSE_B5 SAR12_UNIT
XN_COARSE_B5_U21 TOPN N_COARSE_B5 SAR12_UNIT
XN_COARSE_B5_U22 TOPN N_COARSE_B5 SAR12_UNIT
XN_COARSE_B5_U23 TOPN N_COARSE_B5 SAR12_UNIT
XN_COARSE_B5_U24 TOPN N_COARSE_B5 SAR12_UNIT
XN_COARSE_B5_U25 TOPN N_COARSE_B5 SAR12_UNIT
XN_COARSE_B5_U26 TOPN N_COARSE_B5 SAR12_UNIT
XN_COARSE_B5_U27 TOPN N_COARSE_B5 SAR12_UNIT
XN_COARSE_B5_U28 TOPN N_COARSE_B5 SAR12_UNIT
XN_COARSE_B5_U29 TOPN N_COARSE_B5 SAR12_UNIT
XN_COARSE_B5_U3 TOPN N_COARSE_B5 SAR12_UNIT
XN_COARSE_B5_U30 TOPN N_COARSE_B5 SAR12_UNIT
XN_COARSE_B5_U31 TOPN N_COARSE_B5 SAR12_UNIT
XN_COARSE_B5_U32 TOPN N_COARSE_B5 SAR12_UNIT
XN_COARSE_B5_U33 TOPN N_COARSE_B5 SAR12_UNIT
XN_COARSE_B5_U34 TOPN N_COARSE_B5 SAR12_UNIT
XN_COARSE_B5_U35 TOPN N_COARSE_B5 SAR12_UNIT
XN_COARSE_B5_U36 TOPN N_COARSE_B5 SAR12_UNIT
XN_COARSE_B5_U37 TOPN N_COARSE_B5 SAR12_UNIT
XN_COARSE_B5_U38 TOPN N_COARSE_B5 SAR12_UNIT
XN_COARSE_B5_U39 TOPN N_COARSE_B5 SAR12_UNIT
XN_COARSE_B5_U4 TOPN N_COARSE_B5 SAR12_UNIT
XN_COARSE_B5_U40 TOPN N_COARSE_B5 SAR12_UNIT
XN_COARSE_B5_U41 TOPN N_COARSE_B5 SAR12_UNIT
XN_COARSE_B5_U42 TOPN N_COARSE_B5 SAR12_UNIT
XN_COARSE_B5_U43 TOPN N_COARSE_B5 SAR12_UNIT
XN_COARSE_B5_U44 TOPN N_COARSE_B5 SAR12_UNIT
XN_COARSE_B5_U45 TOPN N_COARSE_B5 SAR12_UNIT
XN_COARSE_B5_U46 TOPN N_COARSE_B5 SAR12_UNIT
XN_COARSE_B5_U47 TOPN N_COARSE_B5 SAR12_UNIT
XN_COARSE_B5_U48 TOPN N_COARSE_B5 SAR12_UNIT
XN_COARSE_B5_U49 TOPN N_COARSE_B5 SAR12_UNIT
XN_COARSE_B5_U5 TOPN N_COARSE_B5 SAR12_UNIT
XN_COARSE_B5_U50 TOPN N_COARSE_B5 SAR12_UNIT
XN_COARSE_B5_U51 TOPN N_COARSE_B5 SAR12_UNIT
XN_COARSE_B5_U52 TOPN N_COARSE_B5 SAR12_UNIT
XN_COARSE_B5_U53 TOPN N_COARSE_B5 SAR12_UNIT
XN_COARSE_B5_U54 TOPN N_COARSE_B5 SAR12_UNIT
XN_COARSE_B5_U55 TOPN N_COARSE_B5 SAR12_UNIT
XN_COARSE_B5_U56 TOPN N_COARSE_B5 SAR12_UNIT
XN_COARSE_B5_U57 TOPN N_COARSE_B5 SAR12_UNIT
XN_COARSE_B5_U58 TOPN N_COARSE_B5 SAR12_UNIT
XN_COARSE_B5_U59 TOPN N_COARSE_B5 SAR12_UNIT
XN_COARSE_B5_U6 TOPN N_COARSE_B5 SAR12_UNIT
XN_COARSE_B5_U60 TOPN N_COARSE_B5 SAR12_UNIT
XN_COARSE_B5_U61 TOPN N_COARSE_B5 SAR12_UNIT
XN_COARSE_B5_U62 TOPN N_COARSE_B5 SAR12_UNIT
XN_COARSE_B5_U63 TOPN N_COARSE_B5 SAR12_UNIT
XN_COARSE_B5_U7 TOPN N_COARSE_B5 SAR12_UNIT
XN_COARSE_B5_U8 TOPN N_COARSE_B5 SAR12_UNIT
XN_COARSE_B5_U9 TOPN N_COARSE_B5 SAR12_UNIT
XN_FINE_B0_SW LON HIN B0 N_FINE_B0 VPWR VGND SAR12_BITMUX
XN_FINE_B0_U0 FINEN N_FINE_B0 SAR12_UNIT
XN_FINE_B0_U1 FINEN N_FINE_B0 SAR12_UNIT
XN_FINE_B1_SW LON HIN B1 N_FINE_B1 VPWR VGND SAR12_BITMUX
XN_FINE_B1_U0 FINEN N_FINE_B1 SAR12_UNIT
XN_FINE_B1_U1 FINEN N_FINE_B1 SAR12_UNIT
XN_FINE_B1_U2 FINEN N_FINE_B1 SAR12_UNIT
XN_FINE_B1_U3 FINEN N_FINE_B1 SAR12_UNIT
XN_FINE_B2_SW LON HIN B2 N_FINE_B2 VPWR VGND SAR12_BITMUX
XN_FINE_B2_U0 FINEN N_FINE_B2 SAR12_UNIT
XN_FINE_B2_U1 FINEN N_FINE_B2 SAR12_UNIT
XN_FINE_B2_U2 FINEN N_FINE_B2 SAR12_UNIT
XN_FINE_B2_U3 FINEN N_FINE_B2 SAR12_UNIT
XN_FINE_B2_U4 FINEN N_FINE_B2 SAR12_UNIT
XN_FINE_B2_U5 FINEN N_FINE_B2 SAR12_UNIT
XN_FINE_B2_U6 FINEN N_FINE_B2 SAR12_UNIT
XN_FINE_B2_U7 FINEN N_FINE_B2 SAR12_UNIT
XN_FINE_B3_SW LON HIN B3 N_FINE_B3 VPWR VGND SAR12_BITMUX
XN_FINE_B3_U0 FINEN N_FINE_B3 SAR12_UNIT
XN_FINE_B3_U1 FINEN N_FINE_B3 SAR12_UNIT
XN_FINE_B3_U10 FINEN N_FINE_B3 SAR12_UNIT
XN_FINE_B3_U11 FINEN N_FINE_B3 SAR12_UNIT
XN_FINE_B3_U12 FINEN N_FINE_B3 SAR12_UNIT
XN_FINE_B3_U13 FINEN N_FINE_B3 SAR12_UNIT
XN_FINE_B3_U14 FINEN N_FINE_B3 SAR12_UNIT
XN_FINE_B3_U15 FINEN N_FINE_B3 SAR12_UNIT
XN_FINE_B3_U2 FINEN N_FINE_B3 SAR12_UNIT
XN_FINE_B3_U3 FINEN N_FINE_B3 SAR12_UNIT
XN_FINE_B3_U4 FINEN N_FINE_B3 SAR12_UNIT
XN_FINE_B3_U5 FINEN N_FINE_B3 SAR12_UNIT
XN_FINE_B3_U6 FINEN N_FINE_B3 SAR12_UNIT
XN_FINE_B3_U7 FINEN N_FINE_B3 SAR12_UNIT
XN_FINE_B3_U8 FINEN N_FINE_B3 SAR12_UNIT
XN_FINE_B3_U9 FINEN N_FINE_B3 SAR12_UNIT
XN_FINE_B4_SW LON HIN B4 N_FINE_B4 VPWR VGND SAR12_BITMUX
XN_FINE_B4_U0 FINEN N_FINE_B4 SAR12_UNIT
XN_FINE_B4_U1 FINEN N_FINE_B4 SAR12_UNIT
XN_FINE_B4_U10 FINEN N_FINE_B4 SAR12_UNIT
XN_FINE_B4_U11 FINEN N_FINE_B4 SAR12_UNIT
XN_FINE_B4_U12 FINEN N_FINE_B4 SAR12_UNIT
XN_FINE_B4_U13 FINEN N_FINE_B4 SAR12_UNIT
XN_FINE_B4_U14 FINEN N_FINE_B4 SAR12_UNIT
XN_FINE_B4_U15 FINEN N_FINE_B4 SAR12_UNIT
XN_FINE_B4_U16 FINEN N_FINE_B4 SAR12_UNIT
XN_FINE_B4_U17 FINEN N_FINE_B4 SAR12_UNIT
XN_FINE_B4_U18 FINEN N_FINE_B4 SAR12_UNIT
XN_FINE_B4_U19 FINEN N_FINE_B4 SAR12_UNIT
XN_FINE_B4_U2 FINEN N_FINE_B4 SAR12_UNIT
XN_FINE_B4_U20 FINEN N_FINE_B4 SAR12_UNIT
XN_FINE_B4_U21 FINEN N_FINE_B4 SAR12_UNIT
XN_FINE_B4_U22 FINEN N_FINE_B4 SAR12_UNIT
XN_FINE_B4_U23 FINEN N_FINE_B4 SAR12_UNIT
XN_FINE_B4_U24 FINEN N_FINE_B4 SAR12_UNIT
XN_FINE_B4_U25 FINEN N_FINE_B4 SAR12_UNIT
XN_FINE_B4_U26 FINEN N_FINE_B4 SAR12_UNIT
XN_FINE_B4_U27 FINEN N_FINE_B4 SAR12_UNIT
XN_FINE_B4_U28 FINEN N_FINE_B4 SAR12_UNIT
XN_FINE_B4_U29 FINEN N_FINE_B4 SAR12_UNIT
XN_FINE_B4_U3 FINEN N_FINE_B4 SAR12_UNIT
XN_FINE_B4_U30 FINEN N_FINE_B4 SAR12_UNIT
XN_FINE_B4_U31 FINEN N_FINE_B4 SAR12_UNIT
XN_FINE_B4_U4 FINEN N_FINE_B4 SAR12_UNIT
XN_FINE_B4_U5 FINEN N_FINE_B4 SAR12_UNIT
XN_FINE_B4_U6 FINEN N_FINE_B4 SAR12_UNIT
XN_FINE_B4_U7 FINEN N_FINE_B4 SAR12_UNIT
XN_FINE_B4_U8 FINEN N_FINE_B4 SAR12_UNIT
XN_FINE_B4_U9 FINEN N_FINE_B4 SAR12_UNIT
XN_FINE_B5_SW LON HIN B5 N_FINE_B5 VPWR VGND SAR12_BITMUX
XN_FINE_B5_U0 FINEN N_FINE_B5 SAR12_UNIT
XN_FINE_B5_U1 FINEN N_FINE_B5 SAR12_UNIT
XN_FINE_B5_U10 FINEN N_FINE_B5 SAR12_UNIT
XN_FINE_B5_U11 FINEN N_FINE_B5 SAR12_UNIT
XN_FINE_B5_U12 FINEN N_FINE_B5 SAR12_UNIT
XN_FINE_B5_U13 FINEN N_FINE_B5 SAR12_UNIT
XN_FINE_B5_U14 FINEN N_FINE_B5 SAR12_UNIT
XN_FINE_B5_U15 FINEN N_FINE_B5 SAR12_UNIT
XN_FINE_B5_U16 FINEN N_FINE_B5 SAR12_UNIT
XN_FINE_B5_U17 FINEN N_FINE_B5 SAR12_UNIT
XN_FINE_B5_U18 FINEN N_FINE_B5 SAR12_UNIT
XN_FINE_B5_U19 FINEN N_FINE_B5 SAR12_UNIT
XN_FINE_B5_U2 FINEN N_FINE_B5 SAR12_UNIT
XN_FINE_B5_U20 FINEN N_FINE_B5 SAR12_UNIT
XN_FINE_B5_U21 FINEN N_FINE_B5 SAR12_UNIT
XN_FINE_B5_U22 FINEN N_FINE_B5 SAR12_UNIT
XN_FINE_B5_U23 FINEN N_FINE_B5 SAR12_UNIT
XN_FINE_B5_U24 FINEN N_FINE_B5 SAR12_UNIT
XN_FINE_B5_U25 FINEN N_FINE_B5 SAR12_UNIT
XN_FINE_B5_U26 FINEN N_FINE_B5 SAR12_UNIT
XN_FINE_B5_U27 FINEN N_FINE_B5 SAR12_UNIT
XN_FINE_B5_U28 FINEN N_FINE_B5 SAR12_UNIT
XN_FINE_B5_U29 FINEN N_FINE_B5 SAR12_UNIT
XN_FINE_B5_U3 FINEN N_FINE_B5 SAR12_UNIT
XN_FINE_B5_U30 FINEN N_FINE_B5 SAR12_UNIT
XN_FINE_B5_U31 FINEN N_FINE_B5 SAR12_UNIT
XN_FINE_B5_U32 FINEN N_FINE_B5 SAR12_UNIT
XN_FINE_B5_U33 FINEN N_FINE_B5 SAR12_UNIT
XN_FINE_B5_U34 FINEN N_FINE_B5 SAR12_UNIT
XN_FINE_B5_U35 FINEN N_FINE_B5 SAR12_UNIT
XN_FINE_B5_U36 FINEN N_FINE_B5 SAR12_UNIT
XN_FINE_B5_U37 FINEN N_FINE_B5 SAR12_UNIT
XN_FINE_B5_U38 FINEN N_FINE_B5 SAR12_UNIT
XN_FINE_B5_U39 FINEN N_FINE_B5 SAR12_UNIT
XN_FINE_B5_U4 FINEN N_FINE_B5 SAR12_UNIT
XN_FINE_B5_U40 FINEN N_FINE_B5 SAR12_UNIT
XN_FINE_B5_U41 FINEN N_FINE_B5 SAR12_UNIT
XN_FINE_B5_U42 FINEN N_FINE_B5 SAR12_UNIT
XN_FINE_B5_U43 FINEN N_FINE_B5 SAR12_UNIT
XN_FINE_B5_U44 FINEN N_FINE_B5 SAR12_UNIT
XN_FINE_B5_U45 FINEN N_FINE_B5 SAR12_UNIT
XN_FINE_B5_U46 FINEN N_FINE_B5 SAR12_UNIT
XN_FINE_B5_U47 FINEN N_FINE_B5 SAR12_UNIT
XN_FINE_B5_U48 FINEN N_FINE_B5 SAR12_UNIT
XN_FINE_B5_U49 FINEN N_FINE_B5 SAR12_UNIT
XN_FINE_B5_U5 FINEN N_FINE_B5 SAR12_UNIT
XN_FINE_B5_U50 FINEN N_FINE_B5 SAR12_UNIT
XN_FINE_B5_U51 FINEN N_FINE_B5 SAR12_UNIT
XN_FINE_B5_U52 FINEN N_FINE_B5 SAR12_UNIT
XN_FINE_B5_U53 FINEN N_FINE_B5 SAR12_UNIT
XN_FINE_B5_U54 FINEN N_FINE_B5 SAR12_UNIT
XN_FINE_B5_U55 FINEN N_FINE_B5 SAR12_UNIT
XN_FINE_B5_U56 FINEN N_FINE_B5 SAR12_UNIT
XN_FINE_B5_U57 FINEN N_FINE_B5 SAR12_UNIT
XN_FINE_B5_U58 FINEN N_FINE_B5 SAR12_UNIT
XN_FINE_B5_U59 FINEN N_FINE_B5 SAR12_UNIT
XN_FINE_B5_U6 FINEN N_FINE_B5 SAR12_UNIT
XN_FINE_B5_U60 FINEN N_FINE_B5 SAR12_UNIT
XN_FINE_B5_U61 FINEN N_FINE_B5 SAR12_UNIT
XN_FINE_B5_U62 FINEN N_FINE_B5 SAR12_UNIT
XN_FINE_B5_U63 FINEN N_FINE_B5 SAR12_UNIT
XN_FINE_B5_U7 FINEN N_FINE_B5 SAR12_UNIT
XN_FINE_B5_U8 FINEN N_FINE_B5 SAR12_UNIT
XN_FINE_B5_U9 FINEN N_FINE_B5 SAR12_UNIT
XN_FINE_DUMMY_U0 FINEN HIN SAR12_UNIT
XN_FINE_DUMMY_U1 FINEN HIN SAR12_UNIT
XP_COARSE_B0_SW HIP LOP B6 P_COARSE_B0 VPWR VGND SAR12_BITMUX
XP_COARSE_B0_U0 TOPP P_COARSE_B0 SAR12_UNIT
XP_COARSE_B0_U1 TOPP P_COARSE_B0 SAR12_UNIT
XP_COARSE_B1_SW HIP LOP B7 P_COARSE_B1 VPWR VGND SAR12_BITMUX
XP_COARSE_B1_U0 TOPP P_COARSE_B1 SAR12_UNIT
XP_COARSE_B1_U1 TOPP P_COARSE_B1 SAR12_UNIT
XP_COARSE_B1_U2 TOPP P_COARSE_B1 SAR12_UNIT
XP_COARSE_B1_U3 TOPP P_COARSE_B1 SAR12_UNIT
XP_COARSE_B2_SW HIP LOP B8 P_COARSE_B2 VPWR VGND SAR12_BITMUX
XP_COARSE_B2_U0 TOPP P_COARSE_B2 SAR12_UNIT
XP_COARSE_B2_U1 TOPP P_COARSE_B2 SAR12_UNIT
XP_COARSE_B2_U2 TOPP P_COARSE_B2 SAR12_UNIT
XP_COARSE_B2_U3 TOPP P_COARSE_B2 SAR12_UNIT
XP_COARSE_B2_U4 TOPP P_COARSE_B2 SAR12_UNIT
XP_COARSE_B2_U5 TOPP P_COARSE_B2 SAR12_UNIT
XP_COARSE_B2_U6 TOPP P_COARSE_B2 SAR12_UNIT
XP_COARSE_B2_U7 TOPP P_COARSE_B2 SAR12_UNIT
XP_COARSE_B3_SW HIP LOP B9 P_COARSE_B3 VPWR VGND SAR12_BITMUX
XP_COARSE_B3_U0 TOPP P_COARSE_B3 SAR12_UNIT
XP_COARSE_B3_U1 TOPP P_COARSE_B3 SAR12_UNIT
XP_COARSE_B3_U10 TOPP P_COARSE_B3 SAR12_UNIT
XP_COARSE_B3_U11 TOPP P_COARSE_B3 SAR12_UNIT
XP_COARSE_B3_U12 TOPP P_COARSE_B3 SAR12_UNIT
XP_COARSE_B3_U13 TOPP P_COARSE_B3 SAR12_UNIT
XP_COARSE_B3_U14 TOPP P_COARSE_B3 SAR12_UNIT
XP_COARSE_B3_U15 TOPP P_COARSE_B3 SAR12_UNIT
XP_COARSE_B3_U2 TOPP P_COARSE_B3 SAR12_UNIT
XP_COARSE_B3_U3 TOPP P_COARSE_B3 SAR12_UNIT
XP_COARSE_B3_U4 TOPP P_COARSE_B3 SAR12_UNIT
XP_COARSE_B3_U5 TOPP P_COARSE_B3 SAR12_UNIT
XP_COARSE_B3_U6 TOPP P_COARSE_B3 SAR12_UNIT
XP_COARSE_B3_U7 TOPP P_COARSE_B3 SAR12_UNIT
XP_COARSE_B3_U8 TOPP P_COARSE_B3 SAR12_UNIT
XP_COARSE_B3_U9 TOPP P_COARSE_B3 SAR12_UNIT
XP_COARSE_B4_SW HIP LOP B10 P_COARSE_B4 VPWR VGND SAR12_BITMUX
XP_COARSE_B4_U0 TOPP P_COARSE_B4 SAR12_UNIT
XP_COARSE_B4_U1 TOPP P_COARSE_B4 SAR12_UNIT
XP_COARSE_B4_U10 TOPP P_COARSE_B4 SAR12_UNIT
XP_COARSE_B4_U11 TOPP P_COARSE_B4 SAR12_UNIT
XP_COARSE_B4_U12 TOPP P_COARSE_B4 SAR12_UNIT
XP_COARSE_B4_U13 TOPP P_COARSE_B4 SAR12_UNIT
XP_COARSE_B4_U14 TOPP P_COARSE_B4 SAR12_UNIT
XP_COARSE_B4_U15 TOPP P_COARSE_B4 SAR12_UNIT
XP_COARSE_B4_U16 TOPP P_COARSE_B4 SAR12_UNIT
XP_COARSE_B4_U17 TOPP P_COARSE_B4 SAR12_UNIT
XP_COARSE_B4_U18 TOPP P_COARSE_B4 SAR12_UNIT
XP_COARSE_B4_U19 TOPP P_COARSE_B4 SAR12_UNIT
XP_COARSE_B4_U2 TOPP P_COARSE_B4 SAR12_UNIT
XP_COARSE_B4_U20 TOPP P_COARSE_B4 SAR12_UNIT
XP_COARSE_B4_U21 TOPP P_COARSE_B4 SAR12_UNIT
XP_COARSE_B4_U22 TOPP P_COARSE_B4 SAR12_UNIT
XP_COARSE_B4_U23 TOPP P_COARSE_B4 SAR12_UNIT
XP_COARSE_B4_U24 TOPP P_COARSE_B4 SAR12_UNIT
XP_COARSE_B4_U25 TOPP P_COARSE_B4 SAR12_UNIT
XP_COARSE_B4_U26 TOPP P_COARSE_B4 SAR12_UNIT
XP_COARSE_B4_U27 TOPP P_COARSE_B4 SAR12_UNIT
XP_COARSE_B4_U28 TOPP P_COARSE_B4 SAR12_UNIT
XP_COARSE_B4_U29 TOPP P_COARSE_B4 SAR12_UNIT
XP_COARSE_B4_U3 TOPP P_COARSE_B4 SAR12_UNIT
XP_COARSE_B4_U30 TOPP P_COARSE_B4 SAR12_UNIT
XP_COARSE_B4_U31 TOPP P_COARSE_B4 SAR12_UNIT
XP_COARSE_B4_U4 TOPP P_COARSE_B4 SAR12_UNIT
XP_COARSE_B4_U5 TOPP P_COARSE_B4 SAR12_UNIT
XP_COARSE_B4_U6 TOPP P_COARSE_B4 SAR12_UNIT
XP_COARSE_B4_U7 TOPP P_COARSE_B4 SAR12_UNIT
XP_COARSE_B4_U8 TOPP P_COARSE_B4 SAR12_UNIT
XP_COARSE_B4_U9 TOPP P_COARSE_B4 SAR12_UNIT
XP_COARSE_B5_SW HIP LOP B11 P_COARSE_B5 VPWR VGND SAR12_BITMUX
XP_COARSE_B5_U0 TOPP P_COARSE_B5 SAR12_UNIT
XP_COARSE_B5_U1 TOPP P_COARSE_B5 SAR12_UNIT
XP_COARSE_B5_U10 TOPP P_COARSE_B5 SAR12_UNIT
XP_COARSE_B5_U11 TOPP P_COARSE_B5 SAR12_UNIT
XP_COARSE_B5_U12 TOPP P_COARSE_B5 SAR12_UNIT
XP_COARSE_B5_U13 TOPP P_COARSE_B5 SAR12_UNIT
XP_COARSE_B5_U14 TOPP P_COARSE_B5 SAR12_UNIT
XP_COARSE_B5_U15 TOPP P_COARSE_B5 SAR12_UNIT
XP_COARSE_B5_U16 TOPP P_COARSE_B5 SAR12_UNIT
XP_COARSE_B5_U17 TOPP P_COARSE_B5 SAR12_UNIT
XP_COARSE_B5_U18 TOPP P_COARSE_B5 SAR12_UNIT
XP_COARSE_B5_U19 TOPP P_COARSE_B5 SAR12_UNIT
XP_COARSE_B5_U2 TOPP P_COARSE_B5 SAR12_UNIT
XP_COARSE_B5_U20 TOPP P_COARSE_B5 SAR12_UNIT
XP_COARSE_B5_U21 TOPP P_COARSE_B5 SAR12_UNIT
XP_COARSE_B5_U22 TOPP P_COARSE_B5 SAR12_UNIT
XP_COARSE_B5_U23 TOPP P_COARSE_B5 SAR12_UNIT
XP_COARSE_B5_U24 TOPP P_COARSE_B5 SAR12_UNIT
XP_COARSE_B5_U25 TOPP P_COARSE_B5 SAR12_UNIT
XP_COARSE_B5_U26 TOPP P_COARSE_B5 SAR12_UNIT
XP_COARSE_B5_U27 TOPP P_COARSE_B5 SAR12_UNIT
XP_COARSE_B5_U28 TOPP P_COARSE_B5 SAR12_UNIT
XP_COARSE_B5_U29 TOPP P_COARSE_B5 SAR12_UNIT
XP_COARSE_B5_U3 TOPP P_COARSE_B5 SAR12_UNIT
XP_COARSE_B5_U30 TOPP P_COARSE_B5 SAR12_UNIT
XP_COARSE_B5_U31 TOPP P_COARSE_B5 SAR12_UNIT
XP_COARSE_B5_U32 TOPP P_COARSE_B5 SAR12_UNIT
XP_COARSE_B5_U33 TOPP P_COARSE_B5 SAR12_UNIT
XP_COARSE_B5_U34 TOPP P_COARSE_B5 SAR12_UNIT
XP_COARSE_B5_U35 TOPP P_COARSE_B5 SAR12_UNIT
XP_COARSE_B5_U36 TOPP P_COARSE_B5 SAR12_UNIT
XP_COARSE_B5_U37 TOPP P_COARSE_B5 SAR12_UNIT
XP_COARSE_B5_U38 TOPP P_COARSE_B5 SAR12_UNIT
XP_COARSE_B5_U39 TOPP P_COARSE_B5 SAR12_UNIT
XP_COARSE_B5_U4 TOPP P_COARSE_B5 SAR12_UNIT
XP_COARSE_B5_U40 TOPP P_COARSE_B5 SAR12_UNIT
XP_COARSE_B5_U41 TOPP P_COARSE_B5 SAR12_UNIT
XP_COARSE_B5_U42 TOPP P_COARSE_B5 SAR12_UNIT
XP_COARSE_B5_U43 TOPP P_COARSE_B5 SAR12_UNIT
XP_COARSE_B5_U44 TOPP P_COARSE_B5 SAR12_UNIT
XP_COARSE_B5_U45 TOPP P_COARSE_B5 SAR12_UNIT
XP_COARSE_B5_U46 TOPP P_COARSE_B5 SAR12_UNIT
XP_COARSE_B5_U47 TOPP P_COARSE_B5 SAR12_UNIT
XP_COARSE_B5_U48 TOPP P_COARSE_B5 SAR12_UNIT
XP_COARSE_B5_U49 TOPP P_COARSE_B5 SAR12_UNIT
XP_COARSE_B5_U5 TOPP P_COARSE_B5 SAR12_UNIT
XP_COARSE_B5_U50 TOPP P_COARSE_B5 SAR12_UNIT
XP_COARSE_B5_U51 TOPP P_COARSE_B5 SAR12_UNIT
XP_COARSE_B5_U52 TOPP P_COARSE_B5 SAR12_UNIT
XP_COARSE_B5_U53 TOPP P_COARSE_B5 SAR12_UNIT
XP_COARSE_B5_U54 TOPP P_COARSE_B5 SAR12_UNIT
XP_COARSE_B5_U55 TOPP P_COARSE_B5 SAR12_UNIT
XP_COARSE_B5_U56 TOPP P_COARSE_B5 SAR12_UNIT
XP_COARSE_B5_U57 TOPP P_COARSE_B5 SAR12_UNIT
XP_COARSE_B5_U58 TOPP P_COARSE_B5 SAR12_UNIT
XP_COARSE_B5_U59 TOPP P_COARSE_B5 SAR12_UNIT
XP_COARSE_B5_U6 TOPP P_COARSE_B5 SAR12_UNIT
XP_COARSE_B5_U60 TOPP P_COARSE_B5 SAR12_UNIT
XP_COARSE_B5_U61 TOPP P_COARSE_B5 SAR12_UNIT
XP_COARSE_B5_U62 TOPP P_COARSE_B5 SAR12_UNIT
XP_COARSE_B5_U63 TOPP P_COARSE_B5 SAR12_UNIT
XP_COARSE_B5_U7 TOPP P_COARSE_B5 SAR12_UNIT
XP_COARSE_B5_U8 TOPP P_COARSE_B5 SAR12_UNIT
XP_COARSE_B5_U9 TOPP P_COARSE_B5 SAR12_UNIT
XP_FINE_B0_SW HIP LOP B0 P_FINE_B0 VPWR VGND SAR12_BITMUX
XP_FINE_B0_U0 FINEP P_FINE_B0 SAR12_UNIT
XP_FINE_B0_U1 FINEP P_FINE_B0 SAR12_UNIT
XP_FINE_B1_SW HIP LOP B1 P_FINE_B1 VPWR VGND SAR12_BITMUX
XP_FINE_B1_U0 FINEP P_FINE_B1 SAR12_UNIT
XP_FINE_B1_U1 FINEP P_FINE_B1 SAR12_UNIT
XP_FINE_B1_U2 FINEP P_FINE_B1 SAR12_UNIT
XP_FINE_B1_U3 FINEP P_FINE_B1 SAR12_UNIT
XP_FINE_B2_SW HIP LOP B2 P_FINE_B2 VPWR VGND SAR12_BITMUX
XP_FINE_B2_U0 FINEP P_FINE_B2 SAR12_UNIT
XP_FINE_B2_U1 FINEP P_FINE_B2 SAR12_UNIT
XP_FINE_B2_U2 FINEP P_FINE_B2 SAR12_UNIT
XP_FINE_B2_U3 FINEP P_FINE_B2 SAR12_UNIT
XP_FINE_B2_U4 FINEP P_FINE_B2 SAR12_UNIT
XP_FINE_B2_U5 FINEP P_FINE_B2 SAR12_UNIT
XP_FINE_B2_U6 FINEP P_FINE_B2 SAR12_UNIT
XP_FINE_B2_U7 FINEP P_FINE_B2 SAR12_UNIT
XP_FINE_B3_SW HIP LOP B3 P_FINE_B3 VPWR VGND SAR12_BITMUX
XP_FINE_B3_U0 FINEP P_FINE_B3 SAR12_UNIT
XP_FINE_B3_U1 FINEP P_FINE_B3 SAR12_UNIT
XP_FINE_B3_U10 FINEP P_FINE_B3 SAR12_UNIT
XP_FINE_B3_U11 FINEP P_FINE_B3 SAR12_UNIT
XP_FINE_B3_U12 FINEP P_FINE_B3 SAR12_UNIT
XP_FINE_B3_U13 FINEP P_FINE_B3 SAR12_UNIT
XP_FINE_B3_U14 FINEP P_FINE_B3 SAR12_UNIT
XP_FINE_B3_U15 FINEP P_FINE_B3 SAR12_UNIT
XP_FINE_B3_U2 FINEP P_FINE_B3 SAR12_UNIT
XP_FINE_B3_U3 FINEP P_FINE_B3 SAR12_UNIT
XP_FINE_B3_U4 FINEP P_FINE_B3 SAR12_UNIT
XP_FINE_B3_U5 FINEP P_FINE_B3 SAR12_UNIT
XP_FINE_B3_U6 FINEP P_FINE_B3 SAR12_UNIT
XP_FINE_B3_U7 FINEP P_FINE_B3 SAR12_UNIT
XP_FINE_B3_U8 FINEP P_FINE_B3 SAR12_UNIT
XP_FINE_B3_U9 FINEP P_FINE_B3 SAR12_UNIT
XP_FINE_B4_SW HIP LOP B4 P_FINE_B4 VPWR VGND SAR12_BITMUX
XP_FINE_B4_U0 FINEP P_FINE_B4 SAR12_UNIT
XP_FINE_B4_U1 FINEP P_FINE_B4 SAR12_UNIT
XP_FINE_B4_U10 FINEP P_FINE_B4 SAR12_UNIT
XP_FINE_B4_U11 FINEP P_FINE_B4 SAR12_UNIT
XP_FINE_B4_U12 FINEP P_FINE_B4 SAR12_UNIT
XP_FINE_B4_U13 FINEP P_FINE_B4 SAR12_UNIT
XP_FINE_B4_U14 FINEP P_FINE_B4 SAR12_UNIT
XP_FINE_B4_U15 FINEP P_FINE_B4 SAR12_UNIT
XP_FINE_B4_U16 FINEP P_FINE_B4 SAR12_UNIT
XP_FINE_B4_U17 FINEP P_FINE_B4 SAR12_UNIT
XP_FINE_B4_U18 FINEP P_FINE_B4 SAR12_UNIT
XP_FINE_B4_U19 FINEP P_FINE_B4 SAR12_UNIT
XP_FINE_B4_U2 FINEP P_FINE_B4 SAR12_UNIT
XP_FINE_B4_U20 FINEP P_FINE_B4 SAR12_UNIT
XP_FINE_B4_U21 FINEP P_FINE_B4 SAR12_UNIT
XP_FINE_B4_U22 FINEP P_FINE_B4 SAR12_UNIT
XP_FINE_B4_U23 FINEP P_FINE_B4 SAR12_UNIT
XP_FINE_B4_U24 FINEP P_FINE_B4 SAR12_UNIT
XP_FINE_B4_U25 FINEP P_FINE_B4 SAR12_UNIT
XP_FINE_B4_U26 FINEP P_FINE_B4 SAR12_UNIT
XP_FINE_B4_U27 FINEP P_FINE_B4 SAR12_UNIT
XP_FINE_B4_U28 FINEP P_FINE_B4 SAR12_UNIT
XP_FINE_B4_U29 FINEP P_FINE_B4 SAR12_UNIT
XP_FINE_B4_U3 FINEP P_FINE_B4 SAR12_UNIT
XP_FINE_B4_U30 FINEP P_FINE_B4 SAR12_UNIT
XP_FINE_B4_U31 FINEP P_FINE_B4 SAR12_UNIT
XP_FINE_B4_U4 FINEP P_FINE_B4 SAR12_UNIT
XP_FINE_B4_U5 FINEP P_FINE_B4 SAR12_UNIT
XP_FINE_B4_U6 FINEP P_FINE_B4 SAR12_UNIT
XP_FINE_B4_U7 FINEP P_FINE_B4 SAR12_UNIT
XP_FINE_B4_U8 FINEP P_FINE_B4 SAR12_UNIT
XP_FINE_B4_U9 FINEP P_FINE_B4 SAR12_UNIT
XP_FINE_B5_SW HIP LOP B5 P_FINE_B5 VPWR VGND SAR12_BITMUX
XP_FINE_B5_U0 FINEP P_FINE_B5 SAR12_UNIT
XP_FINE_B5_U1 FINEP P_FINE_B5 SAR12_UNIT
XP_FINE_B5_U10 FINEP P_FINE_B5 SAR12_UNIT
XP_FINE_B5_U11 FINEP P_FINE_B5 SAR12_UNIT
XP_FINE_B5_U12 FINEP P_FINE_B5 SAR12_UNIT
XP_FINE_B5_U13 FINEP P_FINE_B5 SAR12_UNIT
XP_FINE_B5_U14 FINEP P_FINE_B5 SAR12_UNIT
XP_FINE_B5_U15 FINEP P_FINE_B5 SAR12_UNIT
XP_FINE_B5_U16 FINEP P_FINE_B5 SAR12_UNIT
XP_FINE_B5_U17 FINEP P_FINE_B5 SAR12_UNIT
XP_FINE_B5_U18 FINEP P_FINE_B5 SAR12_UNIT
XP_FINE_B5_U19 FINEP P_FINE_B5 SAR12_UNIT
XP_FINE_B5_U2 FINEP P_FINE_B5 SAR12_UNIT
XP_FINE_B5_U20 FINEP P_FINE_B5 SAR12_UNIT
XP_FINE_B5_U21 FINEP P_FINE_B5 SAR12_UNIT
XP_FINE_B5_U22 FINEP P_FINE_B5 SAR12_UNIT
XP_FINE_B5_U23 FINEP P_FINE_B5 SAR12_UNIT
XP_FINE_B5_U24 FINEP P_FINE_B5 SAR12_UNIT
XP_FINE_B5_U25 FINEP P_FINE_B5 SAR12_UNIT
XP_FINE_B5_U26 FINEP P_FINE_B5 SAR12_UNIT
XP_FINE_B5_U27 FINEP P_FINE_B5 SAR12_UNIT
XP_FINE_B5_U28 FINEP P_FINE_B5 SAR12_UNIT
XP_FINE_B5_U29 FINEP P_FINE_B5 SAR12_UNIT
XP_FINE_B5_U3 FINEP P_FINE_B5 SAR12_UNIT
XP_FINE_B5_U30 FINEP P_FINE_B5 SAR12_UNIT
XP_FINE_B5_U31 FINEP P_FINE_B5 SAR12_UNIT
XP_FINE_B5_U32 FINEP P_FINE_B5 SAR12_UNIT
XP_FINE_B5_U33 FINEP P_FINE_B5 SAR12_UNIT
XP_FINE_B5_U34 FINEP P_FINE_B5 SAR12_UNIT
XP_FINE_B5_U35 FINEP P_FINE_B5 SAR12_UNIT
XP_FINE_B5_U36 FINEP P_FINE_B5 SAR12_UNIT
XP_FINE_B5_U37 FINEP P_FINE_B5 SAR12_UNIT
XP_FINE_B5_U38 FINEP P_FINE_B5 SAR12_UNIT
XP_FINE_B5_U39 FINEP P_FINE_B5 SAR12_UNIT
XP_FINE_B5_U4 FINEP P_FINE_B5 SAR12_UNIT
XP_FINE_B5_U40 FINEP P_FINE_B5 SAR12_UNIT
XP_FINE_B5_U41 FINEP P_FINE_B5 SAR12_UNIT
XP_FINE_B5_U42 FINEP P_FINE_B5 SAR12_UNIT
XP_FINE_B5_U43 FINEP P_FINE_B5 SAR12_UNIT
XP_FINE_B5_U44 FINEP P_FINE_B5 SAR12_UNIT
XP_FINE_B5_U45 FINEP P_FINE_B5 SAR12_UNIT
XP_FINE_B5_U46 FINEP P_FINE_B5 SAR12_UNIT
XP_FINE_B5_U47 FINEP P_FINE_B5 SAR12_UNIT
XP_FINE_B5_U48 FINEP P_FINE_B5 SAR12_UNIT
XP_FINE_B5_U49 FINEP P_FINE_B5 SAR12_UNIT
XP_FINE_B5_U5 FINEP P_FINE_B5 SAR12_UNIT
XP_FINE_B5_U50 FINEP P_FINE_B5 SAR12_UNIT
XP_FINE_B5_U51 FINEP P_FINE_B5 SAR12_UNIT
XP_FINE_B5_U52 FINEP P_FINE_B5 SAR12_UNIT
XP_FINE_B5_U53 FINEP P_FINE_B5 SAR12_UNIT
XP_FINE_B5_U54 FINEP P_FINE_B5 SAR12_UNIT
XP_FINE_B5_U55 FINEP P_FINE_B5 SAR12_UNIT
XP_FINE_B5_U56 FINEP P_FINE_B5 SAR12_UNIT
XP_FINE_B5_U57 FINEP P_FINE_B5 SAR12_UNIT
XP_FINE_B5_U58 FINEP P_FINE_B5 SAR12_UNIT
XP_FINE_B5_U59 FINEP P_FINE_B5 SAR12_UNIT
XP_FINE_B5_U6 FINEP P_FINE_B5 SAR12_UNIT
XP_FINE_B5_U60 FINEP P_FINE_B5 SAR12_UNIT
XP_FINE_B5_U61 FINEP P_FINE_B5 SAR12_UNIT
XP_FINE_B5_U62 FINEP P_FINE_B5 SAR12_UNIT
XP_FINE_B5_U63 FINEP P_FINE_B5 SAR12_UNIT
XP_FINE_B5_U7 FINEP P_FINE_B5 SAR12_UNIT
XP_FINE_B5_U8 FINEP P_FINE_B5 SAR12_UNIT
XP_FINE_B5_U9 FINEP P_FINE_B5 SAR12_UNIT
XP_FINE_DUMMY_U0 FINEP LOP SAR12_UNIT
XP_FINE_DUMMY_U1 FINEP LOP SAR12_UNIT
XREF_HIN VINN VREF SAMPLE SAMPLEB HIN VPWR VGND SAR12_REFMUX
XREF_HIP VINP VREF SAMPLE SAMPLEB HIP VPWR VGND SAR12_REFMUX
XREF_LON VINN VGND SAMPLE SAMPLEB LON VPWR VGND SAR12_REFMUX
XREF_LOP VINP VGND SAMPLE SAMPLEB LOP VPWR VGND SAR12_REFMUX
XRESET_FINEN VCM FINEN SAMPLE SAMPLEB VPWR VGND SAR12_TG
XRESET_FINEP VCM FINEP SAMPLE SAMPLEB VPWR VGND SAR12_TG
XRESET_TOPN VCM TOPN SAMPLE SAMPLEB VPWR VGND SAR12_TG
XRESET_TOPP VCM TOPP SAMPLE SAMPLEB VPWR VGND SAR12_TG
XSAMPLE_INV SAMPLE SAMPLEB VPWR VGND INV
.ends SAR12_CDAC
.subckt SAR12_PREAMP INP INN BIAS OUTP OUTN VPWR VGND
XINPUT0 OUTN INP TAIL VGND sky130_fd_pr__nfet_01v8 w=10 l=1 nf=1 m=1
XINPUT1 OUTP INN TAIL VGND sky130_fd_pr__nfet_01v8 w=10 l=1 nf=1 m=1
XINPUT2 OUTP INN TAIL VGND sky130_fd_pr__nfet_01v8 w=10 l=1 nf=1 m=1
XINPUT3 OUTN INP TAIL VGND sky130_fd_pr__nfet_01v8 w=10 l=1 nf=1 m=1
RLOAD_OUTN VPWR OUTN 100000
RLOAD_OUTP VPWR OUTP 100000
XTAIL TAIL BIAS VGND VGND sky130_fd_pr__nfet_01v8 w=4 l=1 nf=1 m=1
.ends SAR12_PREAMP
.subckt SAR12_LATCH INP INN EVAL OUTP OUTN VPWR VGND
XBUF0_OUTN QP OUTN_B VPWR VGND INV
XBUF0_OUTP QN OUTP_B VPWR VGND INV
XBUF1_OUTN OUTN_B OUTN VPWR VGND INV
XBUF1_OUTP OUTP_B OUTP VPWR VGND INV
XINPUT0 FN INP TAIL VGND sky130_fd_pr__nfet_01v8 w=10 l=0.5 nf=1 m=1
XINPUT1 FP INN TAIL VGND sky130_fd_pr__nfet_01v8 w=10 l=0.5 nf=1 m=1
XINPUT2 FP INN TAIL VGND sky130_fd_pr__nfet_01v8 w=10 l=0.5 nf=1 m=1
XINPUT3 FN INP TAIL VGND sky130_fd_pr__nfet_01v8 w=10 l=0.5 nf=1 m=1
XLN_QN QN QP FP VGND sky130_fd_pr__nfet_01v8 w=8 l=0.15 nf=1 m=1
XLN_QP QP QN FN VGND sky130_fd_pr__nfet_01v8 w=8 l=0.15 nf=1 m=1
XLP_QN QN QP VPWR VPWR sky130_fd_pr__pfet_01v8_hvt w=4 l=0.15 nf=1 m=1
XLP_QP QP QN VPWR VPWR sky130_fd_pr__pfet_01v8_hvt w=4 l=0.15 nf=1 m=1
XPRE_FN FN EVAL VPWR VPWR sky130_fd_pr__pfet_01v8_hvt w=2 l=0.15 nf=1 m=1
XPRE_FP FP EVAL VPWR VPWR sky130_fd_pr__pfet_01v8_hvt w=2 l=0.15 nf=1 m=1
XRESET_QN QN EVAL VPWR VPWR sky130_fd_pr__pfet_01v8_hvt w=4 l=0.15 nf=1 m=1
XRESET_QP QP EVAL VPWR VPWR sky130_fd_pr__pfet_01v8_hvt w=4 l=0.15 nf=1 m=1
XTAIL TAIL EVAL VGND VGND sky130_fd_pr__nfet_01v8 w=20 l=0.15 nf=1 m=1
.ends SAR12_LATCH
.subckt SAR12_COMPARATOR INP INN EVAL OUTP OUTN VPWR VGND
XBIAS_DIODE BIAS BIAS VGND VGND sky130_fd_pr__nfet_01v8 w=4 l=1 nf=1 m=1
RBIAS_RES VPWR BIAS 100000
XLATCH PRE1P PRE1N EVAL OUTP OUTN VPWR VGND SAR12_LATCH
CLOAD_PRE1N PRE1N VGND 5e-13
CLOAD_PRE1P PRE1P VGND 5e-13
XPRE0 INP INN BIAS PRE0P PRE0N VPWR VGND SAR12_PREAMP
XPRE1 PRE0P PRE0N BIAS PRE1P PRE1N VPWR VGND SAR12_PREAMP
.ends SAR12_COMPARATOR
.subckt SAR12_ANALOG VINP VINN VREF VCM SAMPLE EVAL TOPP TOPN COMP COMPN B0 B1 B2 B3 B4 B5 B6 B7 B8 B9 B10 B11 VPWR VGND
XCOMPARE TOPN TOPP EVAL COMP COMPN VPWR VGND SAR12_COMPARATOR
XDAC VINP VINN VREF VCM SAMPLE TOPP TOPN B0 B1 B2 B3 B4 B5 B6 B7 B8 B9 B10 B11 VPWR VGND SAR12_CDAC
.ends SAR12_ANALOG
.subckt NAND2 A0 A1 Y VPWR VGND
XMN0 Y A0 N1 VGND sky130_fd_pr__nfet_01v8 w=0.65 l=0.15 nf=1 m=1
XMN1 N1 A1 VGND VGND sky130_fd_pr__nfet_01v8 w=0.65 l=0.15 nf=1 m=1
XMP0 Y A0 VPWR VPWR sky130_fd_pr__pfet_01v8_hvt w=0.65 l=0.15 nf=1 m=1
XMP1 Y A1 VPWR VPWR sky130_fd_pr__pfet_01v8_hvt w=0.65 l=0.15 nf=1 m=1
.ends NAND2
.subckt AND2 A B Y VPWR VGND
XI1 N Y VPWR VGND INV
XN1 A B N VPWR VGND NAND2
.ends AND2
.subckt NOR2 A B Y VPWR VGND
XN0 Y A VGND VGND sky130_fd_pr__nfet_01v8 w=0.65 l=0.15 nf=1 m=1
XN1 Y B VGND VGND sky130_fd_pr__nfet_01v8 w=0.65 l=0.15 nf=1 m=1
XP0 P A VPWR VPWR sky130_fd_pr__pfet_01v8_hvt w=0.65 l=0.15 nf=1 m=1
XP1 Y B P VPWR sky130_fd_pr__pfet_01v8_hvt w=0.65 l=0.15 nf=1 m=1
.ends NOR2
.subckt OR2 A B Y VPWR VGND
XINV N Y VPWR VGND INV
XNOR A B N VPWR VGND NOR2
.ends OR2
.subckt MUX2 A B S Y VPWR VGND
XIS S SB VPWR VGND INV
XMNA Y SB A VGND sky130_fd_pr__nfet_01v8 w=0.65 l=0.15 nf=1 m=1
XMNB Y S B VGND sky130_fd_pr__nfet_01v8 w=0.65 l=0.15 nf=1 m=1
XMPA Y S A VPWR sky130_fd_pr__pfet_01v8_hvt w=0.65 l=0.15 nf=1 m=1
XMPB Y SB B VPWR sky130_fd_pr__pfet_01v8_hvt w=0.65 l=0.15 nf=1 m=1
.ends MUX2
.subckt XOR2 A B Y VPWR VGND
XN1 A B N1 VPWR VGND NAND2
XN2 A N1 N2 VPWR VGND NAND2
XN3 B N1 N3 VPWR VGND NAND2
XN4 N2 N3 Y VPWR VGND NAND2
.ends XOR2
.subckt DFF D CLK Q VPWR VGND
XICLK CLK CLKB VPWR VGND INV
XM1 M MB VPWR VGND INV
XM2 MB MF VPWR VGND INV
XMNIN M CLKB D VGND sky130_fd_pr__nfet_01v8 w=0.65 l=0.15 nf=1 m=1
XMNMF M CLK MF VGND sky130_fd_pr__nfet_01v8 w=0.65 l=0.15 nf=1 m=1
XMNOUT T CLK MF VGND sky130_fd_pr__nfet_01v8 w=0.65 l=0.15 nf=1 m=1
XMNSF T CLKB Q VGND sky130_fd_pr__nfet_01v8 w=0.65 l=0.15 nf=1 m=1
XMPIN M CLK D VPWR sky130_fd_pr__pfet_01v8_hvt w=0.65 l=0.15 nf=1 m=1
XMPMF M CLKB MF VPWR sky130_fd_pr__pfet_01v8_hvt w=0.65 l=0.15 nf=1 m=1
XMPOUT T CLKB MF VPWR sky130_fd_pr__pfet_01v8_hvt w=0.65 l=0.15 nf=1 m=1
XMPSF T CLK Q VPWR sky130_fd_pr__pfet_01v8_hvt w=0.65 l=0.15 nf=1 m=1
XS1 T TB VPWR VGND INV
XS2 TB Q VPWR VGND INV
.ends DFF
.subckt SAR12_CONTROLLER CLK RESET START COMPARATOR SAMPLE EVAL BUSY VALID TRIAL0 TRIAL1 TRIAL2 TRIAL3 TRIAL4 TRIAL5 TRIAL6 TRIAL7 TRIAL8 TRIAL9 TRIAL10 TRIAL11 CODE0 CODE1 CODE2 CODE3 CODE4 CODE5 CODE6 CODE7 CODE8 CODE9 CODE10 CODE11 VPWR VGND
XG0 TRIAL10 N34 N35 VPWR VGND AND2
XG1 N36 N35 N37 VPWR VGND OR2
XG10 N50 N51 N52 VPWR VGND AND2
XG100 N105 N158 N53 VPWR VGND OR2
XG101 TRIAL0 N53 N159 VPWR VGND AND2
XG102 N122 N119 N160 VPWR VGND AND2
XG103 N141 N142 N161 VPWR VGND OR2
XG104 N148 N160 N124 VPWR VGND OR2
XG105 N141 N119 N162 VPWR VGND AND2
XG106 N122 N142 N163 VPWR VGND OR2
XG107 N128 N147 N164 VPWR VGND XOR2
XG108 N128 N148 N130 VPWR VGND XOR2
XG109 N162 N164 N165 VPWR VGND AND2
XG11 TRIAL11 N53 N54 VPWR VGND AND2
XG110 N163 N130 N166 VPWR VGND OR2
XG111 N134 N149 N136 VPWR VGND AND2
XG112 N134 N149 N167 VPWR VGND XOR2
XG113 N140 N149 N44 VPWR VGND XOR2
XG114 N165 N167 N168 VPWR VGND AND2
XG115 N166 N44 N169 VPWR VGND OR2
XG116 COMPARATOR N115 N170 VPWR VGND OR2
XG117 TRIAL0 N170 N62 VPWR VGND AND2
XG118 N168 N62 N171 VPWR VGND OR2
XG119 N38 N171 N172 VPWR VGND AND2
XG12 N55 N54 N56 VPWR VGND OR2
XG120 N159 N172 N173 VPWR VGND OR2
XG121 N42 N173 N174 VPWR VGND AND2
XG122 TRIAL1 N53 N175 VPWR VGND AND2
XG123 N122 N142 N176 VPWR VGND AND2
XG124 N141 N119 N177 VPWR VGND OR2
XG125 N164 N176 N178 VPWR VGND AND2
XG126 N130 N177 N179 VPWR VGND OR2
XG127 N167 N178 N180 VPWR VGND AND2
XG128 N44 N179 N181 VPWR VGND OR2
XG129 COMPARATOR N169 N182 VPWR VGND OR2
XG13 N52 N56 N57 VPWR VGND OR2
XG130 TRIAL1 N182 N66 VPWR VGND AND2
XG131 N180 N66 N183 VPWR VGND OR2
XG132 N38 N183 N184 VPWR VGND AND2
XG133 N175 N184 N185 VPWR VGND OR2
XG134 N42 N185 N186 VPWR VGND AND2
XG135 TRIAL2 N53 N187 VPWR VGND AND2
XG136 N160 N164 N188 VPWR VGND AND2
XG137 N161 N130 N189 VPWR VGND OR2
XG138 N167 N188 N190 VPWR VGND AND2
XG139 N44 N189 N191 VPWR VGND OR2
XG14 N42 N57 N58 VPWR VGND AND2
XG140 COMPARATOR N181 N192 VPWR VGND OR2
XG141 TRIAL2 N192 N70 VPWR VGND AND2
XG142 N190 N70 N193 VPWR VGND OR2
XG143 N38 N193 N194 VPWR VGND AND2
XG144 N187 N194 N195 VPWR VGND OR2
XG145 N42 N195 N196 VPWR VGND AND2
XG146 TRIAL3 N53 N197 VPWR VGND AND2
XG147 N128 N148 N45 VPWR VGND AND2
XG148 N167 N45 N198 VPWR VGND AND2
XG149 N198 N199 VPWR VGND INV
XG15 CODE0 N59 N60 VPWR VGND AND2
XG150 COMPARATOR N191 N200 VPWR VGND OR2
XG151 TRIAL3 N200 N74 VPWR VGND AND2
XG152 N198 N74 N201 VPWR VGND OR2
XG153 N38 N201 N202 VPWR VGND AND2
XG154 N197 N202 N203 VPWR VGND OR2
XG155 N42 N203 N204 VPWR VGND AND2
XG156 TRIAL4 N53 N205 VPWR VGND AND2
XG157 N130 N167 N206 VPWR VGND AND2
XG158 N164 N44 N207 VPWR VGND OR2
XG159 N162 N206 N208 VPWR VGND AND2
XG16 N61 N62 N63 VPWR VGND AND2
XG160 N163 N207 N209 VPWR VGND OR2
XG161 COMPARATOR N199 N210 VPWR VGND OR2
XG162 TRIAL4 N210 N78 VPWR VGND AND2
XG163 N208 N78 N211 VPWR VGND OR2
XG164 N38 N211 N212 VPWR VGND AND2
XG165 N205 N212 N213 VPWR VGND OR2
XG166 N42 N213 N214 VPWR VGND AND2
XG167 TRIAL5 N53 N215 VPWR VGND AND2
XG168 N176 N206 N216 VPWR VGND AND2
XG169 N177 N207 N217 VPWR VGND OR2
XG17 N60 N63 N64 VPWR VGND OR2
XG170 COMPARATOR N209 N218 VPWR VGND OR2
XG171 TRIAL5 N218 N82 VPWR VGND AND2
XG172 N216 N82 N219 VPWR VGND OR2
XG173 N38 N219 N220 VPWR VGND AND2
XG174 N215 N220 N221 VPWR VGND OR2
XG175 N42 N221 N222 VPWR VGND AND2
XG176 TRIAL6 N53 N223 VPWR VGND AND2
XG177 N160 N206 N224 VPWR VGND AND2
XG178 N161 N207 N225 VPWR VGND OR2
XG179 COMPARATOR N217 N226 VPWR VGND OR2
XG18 CODE1 N59 N65 VPWR VGND AND2
XG180 TRIAL6 N226 N86 VPWR VGND AND2
XG181 N224 N86 N227 VPWR VGND OR2
XG182 N38 N227 N228 VPWR VGND AND2
XG183 N223 N228 N229 VPWR VGND OR2
XG184 N42 N229 N230 VPWR VGND AND2
XG185 TRIAL7 N53 N231 VPWR VGND AND2
XG186 N134 N150 N232 VPWR VGND AND2
XG187 N140 N149 N233 VPWR VGND OR2
XG188 COMPARATOR N225 N234 VPWR VGND OR2
XG189 TRIAL7 N234 N89 VPWR VGND AND2
XG19 N61 N66 N67 VPWR VGND AND2
XG190 N232 N89 N235 VPWR VGND OR2
XG191 N38 N235 N236 VPWR VGND AND2
XG192 N231 N236 N237 VPWR VGND OR2
XG193 N42 N237 N238 VPWR VGND AND2
XG194 TRIAL8 N53 N239 VPWR VGND AND2
XG195 N165 N44 N240 VPWR VGND AND2
XG196 N166 N167 N241 VPWR VGND OR2
XG197 COMPARATOR N233 N242 VPWR VGND OR2
XG198 TRIAL8 N242 N94 VPWR VGND AND2
XG199 N240 N94 N243 VPWR VGND OR2
XG2 N38 N37 N39 VPWR VGND AND2
XG20 N65 N67 N68 VPWR VGND OR2
XG200 N38 N243 N244 VPWR VGND AND2
XG201 N239 N244 N245 VPWR VGND OR2
XG202 N42 N245 N246 VPWR VGND AND2
XG203 TRIAL9 N53 N247 VPWR VGND AND2
XG204 N44 N178 N248 VPWR VGND AND2
XG205 N167 N179 N249 VPWR VGND OR2
XG206 COMPARATOR N241 N250 VPWR VGND OR2
XG207 TRIAL9 N250 N97 VPWR VGND AND2
XG208 N248 N97 N251 VPWR VGND OR2
XG209 N38 N251 N252 VPWR VGND AND2
XG21 CODE2 N59 N69 VPWR VGND AND2
XG210 N247 N252 N253 VPWR VGND OR2
XG211 N42 N253 N254 VPWR VGND AND2
XG212 TRIAL10 N53 N40 VPWR VGND AND2
XG213 N44 N188 N36 VPWR VGND AND2
XG214 N167 N189 N47 VPWR VGND OR2
XG215 COMPARATOR N249 N34 VPWR VGND OR2
XG216 N153 CLK BUSY VPWR VGND DFF
XG217 N157 CLK SAMPLE VPWR VGND DFF
XG218 N61 CLK VALID VPWR VGND DFF
XG219 N174 CLK TRIAL0 VPWR VGND DFF
XG22 N61 N70 N71 VPWR VGND AND2
XG220 N186 CLK TRIAL1 VPWR VGND DFF
XG221 N196 CLK TRIAL2 VPWR VGND DFF
XG222 N204 CLK TRIAL3 VPWR VGND DFF
XG223 N214 CLK TRIAL4 VPWR VGND DFF
XG224 N222 CLK TRIAL5 VPWR VGND DFF
XG225 N230 CLK TRIAL6 VPWR VGND DFF
XG226 N238 CLK TRIAL7 VPWR VGND DFF
XG227 N246 CLK TRIAL8 VPWR VGND DFF
XG228 N254 CLK TRIAL9 VPWR VGND DFF
XG229 N43 CLK TRIAL10 VPWR VGND DFF
XG23 N69 N71 N72 VPWR VGND OR2
XG230 N58 CLK TRIAL11 VPWR VGND DFF
XG231 N64 CLK CODE0 VPWR VGND DFF
XG232 N68 CLK CODE1 VPWR VGND DFF
XG233 N72 CLK CODE2 VPWR VGND DFF
XG234 N76 CLK CODE3 VPWR VGND DFF
XG235 N80 CLK CODE4 VPWR VGND DFF
XG236 N84 CLK CODE5 VPWR VGND DFF
XG237 N88 CLK CODE6 VPWR VGND DFF
XG238 N92 CLK CODE7 VPWR VGND DFF
XG239 N96 CLK CODE8 VPWR VGND DFF
XG24 CODE3 N59 N73 VPWR VGND AND2
XG240 N99 CLK CODE9 VPWR VGND DFF
XG241 N101 CLK CODE10 VPWR VGND DFF
XG242 N103 CLK CODE11 VPWR VGND DFF
XG243 N109 CLK N104 VPWR VGND DFF
XG244 N113 CLK EVAL VPWR VGND DFF
XG245 N121 CLK N119 VPWR VGND DFF
XG246 N127 CLK N122 VPWR VGND DFF
XG247 N133 CLK N128 VPWR VGND DFF
XG248 N139 CLK N134 VPWR VGND DFF
XG25 N61 N74 N75 VPWR VGND AND2
XG26 N73 N75 N76 VPWR VGND OR2
XG27 CODE4 N59 N77 VPWR VGND AND2
XG28 N61 N78 N79 VPWR VGND AND2
XG29 N77 N79 N80 VPWR VGND OR2
XG3 N40 N39 N41 VPWR VGND OR2
XG30 CODE5 N59 N81 VPWR VGND AND2
XG31 N61 N82 N83 VPWR VGND AND2
XG32 N81 N83 N84 VPWR VGND OR2
XG33 CODE6 N59 N85 VPWR VGND AND2
XG34 N61 N86 N87 VPWR VGND AND2
XG35 N85 N87 N88 VPWR VGND OR2
XG36 CODE7 N89 N90 N91 VPWR VGND MUX2
XG37 N42 N91 N92 VPWR VGND AND2
XG38 CODE8 N59 N93 VPWR VGND AND2
XG39 N61 N94 N95 VPWR VGND AND2
XG4 N42 N41 N43 VPWR VGND AND2
XG40 N93 N95 N96 VPWR VGND OR2
XG41 CODE9 N97 N90 N98 VPWR VGND MUX2
XG42 N42 N98 N99 VPWR VGND AND2
XG43 CODE10 N35 N90 N100 VPWR VGND MUX2
XG44 N42 N100 N101 VPWR VGND AND2
XG45 CODE11 N49 N90 N102 VPWR VGND MUX2
XG46 N42 N102 N103 VPWR VGND AND2
XG47 N104 N105 N106 VPWR VGND AND2
XG48 N107 N106 N108 VPWR VGND OR2
XG49 N42 N108 N109 VPWR VGND AND2
XG5 N44 N45 N46 VPWR VGND AND2
XG50 N105 N110 N111 N112 VPWR VGND MUX2
XG51 N42 N112 N113 VPWR VGND AND2
XG52 RESET N107 N114 VPWR VGND OR2
XG53 N115 N38 N116 VPWR VGND AND2
XG54 N55 N53 N117 VPWR VGND OR2
XG55 N90 N117 N118 VPWR VGND OR2
XG56 N116 N118 N119 N120 VPWR VGND MUX2
XG57 N114 N120 N121 VPWR VGND OR2
XG58 N122 N118 N123 VPWR VGND AND2
XG59 N124 N116 N125 VPWR VGND AND2
XG6 COMPARATOR N47 N48 VPWR VGND OR2
XG60 N114 N125 N126 VPWR VGND OR2
XG61 N123 N126 N127 VPWR VGND OR2
XG62 N128 N118 N129 VPWR VGND AND2
XG63 N130 N116 N131 VPWR VGND AND2
XG64 N129 N131 N132 VPWR VGND OR2
XG65 N42 N132 N133 VPWR VGND AND2
XG66 N134 N117 N135 VPWR VGND AND2
XG67 N38 N136 N137 VPWR VGND AND2
XG68 N114 N137 N138 VPWR VGND OR2
XG69 N135 N138 N139 VPWR VGND OR2
XG7 TRIAL11 N48 N49 VPWR VGND AND2
XG70 N134 N140 VPWR VGND INV
XG71 N122 N141 VPWR VGND INV
XG72 N119 N142 VPWR VGND INV
XG73 EVAL N111 VPWR VGND INV
XG74 N104 N143 VPWR VGND INV
XG75 RESET N42 VPWR VGND INV
XG76 BUSY N144 VPWR VGND INV
XG77 START N145 VPWR VGND INV
XG78 N144 N145 N105 VPWR VGND AND2
XG79 BUSY START N146 VPWR VGND OR2
XG8 N46 N49 N50 VPWR VGND OR2
XG80 N122 N119 N147 VPWR VGND OR2
XG81 N147 N148 VPWR VGND INV
XG82 N128 N147 N149 VPWR VGND OR2
XG83 N149 N150 VPWR VGND INV
XG84 N134 N149 N115 VPWR VGND OR2
XG85 N143 BUSY N110 VPWR VGND AND2
XG86 EVAL N110 N38 VPWR VGND AND2
XG87 N38 N151 VPWR VGND INV
XG88 N115 N151 N152 VPWR VGND OR2
XG89 N152 N90 VPWR VGND INV
XG9 EVAL BUSY N51 VPWR VGND AND2
XG90 N42 N152 N59 VPWR VGND AND2
XG91 N146 N59 N153 VPWR VGND AND2
XG92 N144 START N107 VPWR VGND AND2
XG93 N104 BUSY N55 VPWR VGND AND2
XG94 N55 N154 VPWR VGND INV
XG95 SAMPLE N154 N155 VPWR VGND AND2
XG96 N107 N155 N156 VPWR VGND OR2
XG97 N42 N156 N157 VPWR VGND AND2
XG98 N42 N90 N61 VPWR VGND AND2
XG99 N111 N110 N158 VPWR VGND AND2
.ends SAR12_CONTROLLER
.subckt sar_adc12 VINP VINN VREF VCM CLK RESET START TOPP TOPN COMP COMPN SAMPLE EVAL BUSY VALID CODE0 CODE1 CODE2 CODE3 CODE4 CODE5 CODE6 CODE7 CODE8 CODE9 CODE10 CODE11 VPWR VGND
XANALOG VINP VINN VREF VCM SAMPLE EVAL TOPP TOPN COMP COMPN B0 B1 B2 B3 B4 B5 B6 B7 B8 B9 B10 B11 VPWR VGND SAR12_ANALOG
XCONTROL CLK RESET START COMP SAMPLE EVAL BUSY VALID B0 B1 B2 B3 B4 B5 B6 B7 B8 B9 B10 B11 CODE0 CODE1 CODE2 CODE3 CODE4 CODE5 CODE6 CODE7 CODE8 CODE9 CODE10 CODE11 VPWR VGND SAR12_CONTROLLER
.ends sar_adc12

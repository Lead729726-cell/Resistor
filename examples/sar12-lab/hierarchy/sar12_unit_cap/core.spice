.subckt sar12_unit_cap TOP BOTTOM
CC_UNIT TOP BOTTOM 2e-13
.ends sar12_unit_cap

.subckt INV A Y VPWR VGND
XMN Y A VGND VGND sky130_fd_pr__nfet_01v8 w=0.65 l=0.15 nf=1 m=1
XMP Y A VPWR VPWR sky130_fd_pr__pfet_01v8_hvt w=0.65 l=0.15 nf=1 m=1
.ends INV
.subckt sar12_latch INP INN EVAL OUTP OUTN VPWR VGND
XBUF0_OUTN QP OUTN_B VPWR VGND INV
XBUF0_OUTP QN OUTP_B VPWR VGND INV
XBUF1_OUTN OUTN_B OUTN VPWR VGND INV
XBUF1_OUTP OUTP_B OUTP VPWR VGND INV
XINPUT0 FN INP TAIL VGND sky130_fd_pr__nfet_01v8 w=10 l=0.5 nf=1 m=1
XINPUT1 FP INN TAIL VGND sky130_fd_pr__nfet_01v8 w=10 l=0.5 nf=1 m=1
XINPUT2 FP INN TAIL VGND sky130_fd_pr__nfet_01v8 w=10 l=0.5 nf=1 m=1
XINPUT3 FN INP TAIL VGND sky130_fd_pr__nfet_01v8 w=10 l=0.5 nf=1 m=1
XLN_QN QN QP FP VGND sky130_fd_pr__nfet_01v8 w=8 l=0.15 nf=1 m=1
XLN_QP QP QN FN VGND sky130_fd_pr__nfet_01v8 w=8 l=0.15 nf=1 m=1
XLP_QN QN QP VPWR VPWR sky130_fd_pr__pfet_01v8_hvt w=4 l=0.15 nf=1 m=1
XLP_QP QP QN VPWR VPWR sky130_fd_pr__pfet_01v8_hvt w=4 l=0.15 nf=1 m=1
XPRE_FN FN EVAL VPWR VPWR sky130_fd_pr__pfet_01v8_hvt w=2 l=0.15 nf=1 m=1
XPRE_FP FP EVAL VPWR VPWR sky130_fd_pr__pfet_01v8_hvt w=2 l=0.15 nf=1 m=1
XRESET_QN QN EVAL VPWR VPWR sky130_fd_pr__pfet_01v8_hvt w=4 l=0.15 nf=1 m=1
XRESET_QP QP EVAL VPWR VPWR sky130_fd_pr__pfet_01v8_hvt w=4 l=0.15 nf=1 m=1
XTAIL TAIL EVAL VGND VGND sky130_fd_pr__nfet_01v8 w=20 l=0.15 nf=1 m=1
.ends sar12_latch

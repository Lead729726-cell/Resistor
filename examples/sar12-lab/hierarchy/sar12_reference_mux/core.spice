.subckt SAR12_TG A Y EN ENB VPWR VGND
XN A EN Y VGND sky130_fd_pr__nfet_01v8 w=8 l=0.15 nf=1 m=1
XP A ENB Y VPWR sky130_fd_pr__pfet_01v8_hvt w=12 l=0.15 nf=1 m=1
.ends SAR12_TG
.subckt sar12_reference_mux VIN REF SAMPLE SAMPLEB OUT VPWR VGND
XACQUIRE VIN OUT SAMPLE SAMPLEB VPWR VGND SAR12_TG
XCONVERT REF OUT SAMPLEB SAMPLE VPWR VGND SAR12_TG
.ends sar12_reference_mux

.subckt sar12_analog VINP VINN VREF VCM SAMPLE EVAL TOPP TOPN COMP COMPN B0 B1 B2 B3 B4 B5 B6 B7 B8 B9 B10 B11 VPWR VGND
XCOMPARE_BIAS_DIODE COMPARE__BIAS COMPARE__BIAS VGND VGND sky130_fd_pr__nfet_01v8 w=4 l=1 nf=1 m=1
XCOMPARE_BIAS_RES_P0 VPWR COMPARE_BIAS_RES_R0_N0 VGND sky130_fd_pr__res_xhigh_po_1p41 l=23.335
XCOMPARE_BIAS_RES_P1 COMPARE_BIAS_RES_R0_N0 COMPARE_BIAS_RES_R0_N1 VGND sky130_fd_pr__res_xhigh_po_1p41 l=23.335
XCOMPARE_BIAS_RES_P2 COMPARE_BIAS_RES_R0_N1 COMPARE__BIAS VGND sky130_fd_pr__res_xhigh_po_1p41 l=23.335
XCOMPARE_LATCH_BUF0_OUTN_MN COMPARE__LATCH__OUTN_B COMPARE__LATCH__QP VGND VGND sky130_fd_pr__nfet_01v8 w=0.65 l=0.15 nf=1 m=1
XCOMPARE_LATCH_BUF0_OUTN_MP COMPARE__LATCH__OUTN_B COMPARE__LATCH__QP VPWR VPWR sky130_fd_pr__pfet_01v8_hvt w=0.65 l=0.15 nf=1 m=1
XCOMPARE_LATCH_BUF0_OUTP_MN COMPARE__LATCH__OUTP_B COMPARE__LATCH__QN VGND VGND sky130_fd_pr__nfet_01v8 w=0.65 l=0.15 nf=1 m=1
XCOMPARE_LATCH_BUF0_OUTP_MP COMPARE__LATCH__OUTP_B COMPARE__LATCH__QN VPWR VPWR sky130_fd_pr__pfet_01v8_hvt w=0.65 l=0.15 nf=1 m=1
XCOMPARE_LATCH_BUF1_OUTN_MN COMPN COMPARE__LATCH__OUTN_B VGND VGND sky130_fd_pr__nfet_01v8 w=0.65 l=0.15 nf=1 m=1
XCOMPARE_LATCH_BUF1_OUTN_MP COMPN COMPARE__LATCH__OUTN_B VPWR VPWR sky130_fd_pr__pfet_01v8_hvt w=0.65 l=0.15 nf=1 m=1
XCOMPARE_LATCH_BUF1_OUTP_MN COMP COMPARE__LATCH__OUTP_B VGND VGND sky130_fd_pr__nfet_01v8 w=0.65 l=0.15 nf=1 m=1
XCOMPARE_LATCH_BUF1_OUTP_MP COMP COMPARE__LATCH__OUTP_B VPWR VPWR sky130_fd_pr__pfet_01v8_hvt w=0.65 l=0.15 nf=1 m=1
XCOMPARE_LATCH_INPUT0 COMPARE__LATCH__FN COMPARE__PRE1P COMPARE__LATCH__TAIL VGND sky130_fd_pr__nfet_01v8 w=10 l=0.5 nf=1 m=1
XCOMPARE_LATCH_INPUT1 COMPARE__LATCH__FP COMPARE__PRE1N COMPARE__LATCH__TAIL VGND sky130_fd_pr__nfet_01v8 w=10 l=0.5 nf=1 m=1
XCOMPARE_LATCH_INPUT2 COMPARE__LATCH__FP COMPARE__PRE1N COMPARE__LATCH__TAIL VGND sky130_fd_pr__nfet_01v8 w=10 l=0.5 nf=1 m=1
XCOMPARE_LATCH_INPUT3 COMPARE__LATCH__FN COMPARE__PRE1P COMPARE__LATCH__TAIL VGND sky130_fd_pr__nfet_01v8 w=10 l=0.5 nf=1 m=1
XCOMPARE_LATCH_LN_QN COMPARE__LATCH__QN COMPARE__LATCH__QP COMPARE__LATCH__FP VGND sky130_fd_pr__nfet_01v8 w=8 l=0.15 nf=1 m=1
XCOMPARE_LATCH_LN_QP COMPARE__LATCH__QP COMPARE__LATCH__QN COMPARE__LATCH__FN VGND sky130_fd_pr__nfet_01v8 w=8 l=0.15 nf=1 m=1
XCOMPARE_LATCH_LP_QN COMPARE__LATCH__QN COMPARE__LATCH__QP VPWR VPWR sky130_fd_pr__pfet_01v8_hvt w=4 l=0.15 nf=1 m=1
XCOMPARE_LATCH_LP_QP COMPARE__LATCH__QP COMPARE__LATCH__QN VPWR VPWR sky130_fd_pr__pfet_01v8_hvt w=4 l=0.15 nf=1 m=1
XCOMPARE_LATCH_PRE_FN COMPARE__LATCH__FN EVAL VPWR VPWR sky130_fd_pr__pfet_01v8_hvt w=2 l=0.15 nf=1 m=1
XCOMPARE_LATCH_PRE_FP COMPARE__LATCH__FP EVAL VPWR VPWR sky130_fd_pr__pfet_01v8_hvt w=2 l=0.15 nf=1 m=1
XCOMPARE_LATCH_RESET_QN COMPARE__LATCH__QN EVAL VPWR VPWR sky130_fd_pr__pfet_01v8_hvt w=4 l=0.15 nf=1 m=1
XCOMPARE_LATCH_RESET_QP COMPARE__LATCH__QP EVAL VPWR VPWR sky130_fd_pr__pfet_01v8_hvt w=4 l=0.15 nf=1 m=1
XCOMPARE_LATCH_TAIL COMPARE__LATCH__TAIL EVAL VGND VGND sky130_fd_pr__nfet_01v8 w=20 l=0.15 nf=1 m=1
XCOMPARE_LOAD_PRE1N_P0 COMPARE__PRE1N VGND sky130_fd_pr__cap_mim_m3_1 w=15.625 l=15.625
XCOMPARE_LOAD_PRE1P_P0 COMPARE__PRE1P VGND sky130_fd_pr__cap_mim_m3_1 w=15.625 l=15.625
XCOMPARE_PRE0_INPUT0 COMPARE__PRE0N TOPN COMPARE__PRE0__TAIL VGND sky130_fd_pr__nfet_01v8 w=10 l=1 nf=1 m=1
XCOMPARE_PRE0_INPUT1 COMPARE__PRE0P TOPP COMPARE__PRE0__TAIL VGND sky130_fd_pr__nfet_01v8 w=10 l=1 nf=1 m=1
XCOMPARE_PRE0_INPUT2 COMPARE__PRE0P TOPP COMPARE__PRE0__TAIL VGND sky130_fd_pr__nfet_01v8 w=10 l=1 nf=1 m=1
XCOMPARE_PRE0_INPUT3 COMPARE__PRE0N TOPN COMPARE__PRE0__TAIL VGND sky130_fd_pr__nfet_01v8 w=10 l=1 nf=1 m=1
XCOMPARE_PRE0_LOAD_OUTN_P0 VPWR COMPARE_PRE0_LOAD_OUTN_R0_N0 VGND sky130_fd_pr__res_xhigh_po_1p41 l=23.335
XCOMPARE_PRE0_LOAD_OUTN_P1 COMPARE_PRE0_LOAD_OUTN_R0_N0 COMPARE_PRE0_LOAD_OUTN_R0_N1 VGND sky130_fd_pr__res_xhigh_po_1p41 l=23.335
XCOMPARE_PRE0_LOAD_OUTN_P2 COMPARE_PRE0_LOAD_OUTN_R0_N1 COMPARE__PRE0N VGND sky130_fd_pr__res_xhigh_po_1p41 l=23.335
XCOMPARE_PRE0_LOAD_OUTP_P0 VPWR COMPARE_PRE0_LOAD_OUTP_R0_N0 VGND sky130_fd_pr__res_xhigh_po_1p41 l=23.335
XCOMPARE_PRE0_LOAD_OUTP_P1 COMPARE_PRE0_LOAD_OUTP_R0_N0 COMPARE_PRE0_LOAD_OUTP_R0_N1 VGND sky130_fd_pr__res_xhigh_po_1p41 l=23.335
XCOMPARE_PRE0_LOAD_OUTP_P2 COMPARE_PRE0_LOAD_OUTP_R0_N1 COMPARE__PRE0P VGND sky130_fd_pr__res_xhigh_po_1p41 l=23.335
XCOMPARE_PRE0_TAIL COMPARE__PRE0__TAIL COMPARE__BIAS VGND VGND sky130_fd_pr__nfet_01v8 w=4 l=1 nf=1 m=1
XCOMPARE_PRE1_INPUT0 COMPARE__PRE1N COMPARE__PRE0P COMPARE__PRE1__TAIL VGND sky130_fd_pr__nfet_01v8 w=10 l=1 nf=1 m=1
XCOMPARE_PRE1_INPUT1 COMPARE__PRE1P COMPARE__PRE0N COMPARE__PRE1__TAIL VGND sky130_fd_pr__nfet_01v8 w=10 l=1 nf=1 m=1
XCOMPARE_PRE1_INPUT2 COMPARE__PRE1P COMPARE__PRE0N COMPARE__PRE1__TAIL VGND sky130_fd_pr__nfet_01v8 w=10 l=1 nf=1 m=1
XCOMPARE_PRE1_INPUT3 COMPARE__PRE1N COMPARE__PRE0P COMPARE__PRE1__TAIL VGND sky130_fd_pr__nfet_01v8 w=10 l=1 nf=1 m=1
XCOMPARE_PRE1_LOAD_OUTN_P0 VPWR COMPARE_PRE1_LOAD_OUTN_R0_N0 VGND sky130_fd_pr__res_xhigh_po_1p41 l=23.335
XCOMPARE_PRE1_LOAD_OUTN_P1 COMPARE_PRE1_LOAD_OUTN_R0_N0 COMPARE_PRE1_LOAD_OUTN_R0_N1 VGND sky130_fd_pr__res_xhigh_po_1p41 l=23.335
XCOMPARE_PRE1_LOAD_OUTN_P2 COMPARE_PRE1_LOAD_OUTN_R0_N1 COMPARE__PRE1N VGND sky130_fd_pr__res_xhigh_po_1p41 l=23.335
XCOMPARE_PRE1_LOAD_OUTP_P0 VPWR COMPARE_PRE1_LOAD_OUTP_R0_N0 VGND sky130_fd_pr__res_xhigh_po_1p41 l=23.335
XCOMPARE_PRE1_LOAD_OUTP_P1 COMPARE_PRE1_LOAD_OUTP_R0_N0 COMPARE_PRE1_LOAD_OUTP_R0_N1 VGND sky130_fd_pr__res_xhigh_po_1p41 l=23.335
XCOMPARE_PRE1_LOAD_OUTP_P2 COMPARE_PRE1_LOAD_OUTP_R0_N1 COMPARE__PRE1P VGND sky130_fd_pr__res_xhigh_po_1p41 l=23.335
XCOMPARE_PRE1_TAIL COMPARE__PRE1__TAIL COMPARE__BIAS VGND VGND sky130_fd_pr__nfet_01v8 w=4 l=1 nf=1 m=1
XDAC_BRIDGEN_C_BRIDGE_P0 TOPN DAC__FINEN sky130_fd_pr__cap_mim_m3_1 w=14.065 l=14.065
XDAC_BRIDGEP_C_BRIDGE_P0 TOPP DAC__FINEP sky130_fd_pr__cap_mim_m3_1 w=14.065 l=14.065
XDAC_N_COARSE_B0_SW_HIGH_N DAC__LON B6 DAC__N_COARSE_B0 VGND sky130_fd_pr__nfet_01v8 w=8 l=0.15 nf=1 m=1
XDAC_N_COARSE_B0_SW_HIGH_P DAC__LON DAC__N_COARSE_B0_SW__BITB DAC__N_COARSE_B0 VPWR sky130_fd_pr__pfet_01v8_hvt w=12 l=0.15 nf=1 m=1
XDAC_N_COARSE_B0_SW_INV_MN DAC__N_COARSE_B0_SW__BITB B6 VGND VGND sky130_fd_pr__nfet_01v8 w=0.65 l=0.15 nf=1 m=1
XDAC_N_COARSE_B0_SW_INV_MP DAC__N_COARSE_B0_SW__BITB B6 VPWR VPWR sky130_fd_pr__pfet_01v8_hvt w=0.65 l=0.15 nf=1 m=1
XDAC_N_COARSE_B0_SW_LOW_N DAC__HIN DAC__N_COARSE_B0_SW__BITB DAC__N_COARSE_B0 VGND sky130_fd_pr__nfet_01v8 w=8 l=0.15 nf=1 m=1
XDAC_N_COARSE_B0_SW_LOW_P DAC__HIN B6 DAC__N_COARSE_B0 VPWR sky130_fd_pr__pfet_01v8_hvt w=12 l=0.15 nf=1 m=1
XDAC_N_COARSE_B0_U0_C_UNIT_P0 TOPN DAC__N_COARSE_B0 sky130_fd_pr__cap_mim_m3_1 w=9.81 l=9.81
XDAC_N_COARSE_B0_U1_C_UNIT_P0 TOPN DAC__N_COARSE_B0 sky130_fd_pr__cap_mim_m3_1 w=9.81 l=9.81
XDAC_N_COARSE_B1_SW_HIGH_N DAC__LON B7 DAC__N_COARSE_B1 VGND sky130_fd_pr__nfet_01v8 w=8 l=0.15 nf=1 m=1
XDAC_N_COARSE_B1_SW_HIGH_P DAC__LON DAC__N_COARSE_B1_SW__BITB DAC__N_COARSE_B1 VPWR sky130_fd_pr__pfet_01v8_hvt w=12 l=0.15 nf=1 m=1
XDAC_N_COARSE_B1_SW_INV_MN DAC__N_COARSE_B1_SW__BITB B7 VGND VGND sky130_fd_pr__nfet_01v8 w=0.65 l=0.15 nf=1 m=1
XDAC_N_COARSE_B1_SW_INV_MP DAC__N_COARSE_B1_SW__BITB B7 VPWR VPWR sky130_fd_pr__pfet_01v8_hvt w=0.65 l=0.15 nf=1 m=1
XDAC_N_COARSE_B1_SW_LOW_N DAC__HIN DAC__N_COARSE_B1_SW__BITB DAC__N_COARSE_B1 VGND sky130_fd_pr__nfet_01v8 w=8 l=0.15 nf=1 m=1
XDAC_N_COARSE_B1_SW_LOW_P DAC__HIN B7 DAC__N_COARSE_B1 VPWR sky130_fd_pr__pfet_01v8_hvt w=12 l=0.15 nf=1 m=1
XDAC_N_COARSE_B1_U0_C_UNIT_P0 TOPN DAC__N_COARSE_B1 sky130_fd_pr__cap_mim_m3_1 w=9.81 l=9.81
XDAC_N_COARSE_B1_U1_C_UNIT_P0 TOPN DAC__N_COARSE_B1 sky130_fd_pr__cap_mim_m3_1 w=9.81 l=9.81
XDAC_N_COARSE_B1_U2_C_UNIT_P0 TOPN DAC__N_COARSE_B1 sky130_fd_pr__cap_mim_m3_1 w=9.81 l=9.81
XDAC_N_COARSE_B1_U3_C_UNIT_P0 TOPN DAC__N_COARSE_B1 sky130_fd_pr__cap_mim_m3_1 w=9.81 l=9.81
XDAC_N_COARSE_B2_SW_HIGH_N DAC__LON B8 DAC__N_COARSE_B2 VGND sky130_fd_pr__nfet_01v8 w=8 l=0.15 nf=1 m=1
XDAC_N_COARSE_B2_SW_HIGH_P DAC__LON DAC__N_COARSE_B2_SW__BITB DAC__N_COARSE_B2 VPWR sky130_fd_pr__pfet_01v8_hvt w=12 l=0.15 nf=1 m=1
XDAC_N_COARSE_B2_SW_INV_MN DAC__N_COARSE_B2_SW__BITB B8 VGND VGND sky130_fd_pr__nfet_01v8 w=0.65 l=0.15 nf=1 m=1
XDAC_N_COARSE_B2_SW_INV_MP DAC__N_COARSE_B2_SW__BITB B8 VPWR VPWR sky130_fd_pr__pfet_01v8_hvt w=0.65 l=0.15 nf=1 m=1
XDAC_N_COARSE_B2_SW_LOW_N DAC__HIN DAC__N_COARSE_B2_SW__BITB DAC__N_COARSE_B2 VGND sky130_fd_pr__nfet_01v8 w=8 l=0.15 nf=1 m=1
XDAC_N_COARSE_B2_SW_LOW_P DAC__HIN B8 DAC__N_COARSE_B2 VPWR sky130_fd_pr__pfet_01v8_hvt w=12 l=0.15 nf=1 m=1
XDAC_N_COARSE_B2_U0_C_UNIT_P0 TOPN DAC__N_COARSE_B2 sky130_fd_pr__cap_mim_m3_1 w=9.81 l=9.81
XDAC_N_COARSE_B2_U1_C_UNIT_P0 TOPN DAC__N_COARSE_B2 sky130_fd_pr__cap_mim_m3_1 w=9.81 l=9.81
XDAC_N_COARSE_B2_U2_C_UNIT_P0 TOPN DAC__N_COARSE_B2 sky130_fd_pr__cap_mim_m3_1 w=9.81 l=9.81
XDAC_N_COARSE_B2_U3_C_UNIT_P0 TOPN DAC__N_COARSE_B2 sky130_fd_pr__cap_mim_m3_1 w=9.81 l=9.81
XDAC_N_COARSE_B2_U4_C_UNIT_P0 TOPN DAC__N_COARSE_B2 sky130_fd_pr__cap_mim_m3_1 w=9.81 l=9.81
XDAC_N_COARSE_B2_U5_C_UNIT_P0 TOPN DAC__N_COARSE_B2 sky130_fd_pr__cap_mim_m3_1 w=9.81 l=9.81
XDAC_N_COARSE_B2_U6_C_UNIT_P0 TOPN DAC__N_COARSE_B2 sky130_fd_pr__cap_mim_m3_1 w=9.81 l=9.81
XDAC_N_COARSE_B2_U7_C_UNIT_P0 TOPN DAC__N_COARSE_B2 sky130_fd_pr__cap_mim_m3_1 w=9.81 l=9.81
XDAC_N_COARSE_B3_SW_HIGH_N DAC__LON B9 DAC__N_COARSE_B3 VGND sky130_fd_pr__nfet_01v8 w=8 l=0.15 nf=1 m=1
XDAC_N_COARSE_B3_SW_HIGH_P DAC__LON DAC__N_COARSE_B3_SW__BITB DAC__N_COARSE_B3 VPWR sky130_fd_pr__pfet_01v8_hvt w=12 l=0.15 nf=1 m=1
XDAC_N_COARSE_B3_SW_INV_MN DAC__N_COARSE_B3_SW__BITB B9 VGND VGND sky130_fd_pr__nfet_01v8 w=0.65 l=0.15 nf=1 m=1
XDAC_N_COARSE_B3_SW_INV_MP DAC__N_COARSE_B3_SW__BITB B9 VPWR VPWR sky130_fd_pr__pfet_01v8_hvt w=0.65 l=0.15 nf=1 m=1
XDAC_N_COARSE_B3_SW_LOW_N DAC__HIN DAC__N_COARSE_B3_SW__BITB DAC__N_COARSE_B3 VGND sky130_fd_pr__nfet_01v8 w=8 l=0.15 nf=1 m=1
XDAC_N_COARSE_B3_SW_LOW_P DAC__HIN B9 DAC__N_COARSE_B3 VPWR sky130_fd_pr__pfet_01v8_hvt w=12 l=0.15 nf=1 m=1
XDAC_N_COARSE_B3_U0_C_UNIT_P0 TOPN DAC__N_COARSE_B3 sky130_fd_pr__cap_mim_m3_1 w=9.81 l=9.81
XDAC_N_COARSE_B3_U1_C_UNIT_P0 TOPN DAC__N_COARSE_B3 sky130_fd_pr__cap_mim_m3_1 w=9.81 l=9.81
XDAC_N_COARSE_B3_U10_C_UNIT_P0 TOPN DAC__N_COARSE_B3 sky130_fd_pr__cap_mim_m3_1 w=9.81 l=9.81
XDAC_N_COARSE_B3_U11_C_UNIT_P0 TOPN DAC__N_COARSE_B3 sky130_fd_pr__cap_mim_m3_1 w=9.81 l=9.81
XDAC_N_COARSE_B3_U12_C_UNIT_P0 TOPN DAC__N_COARSE_B3 sky130_fd_pr__cap_mim_m3_1 w=9.81 l=9.81
XDAC_N_COARSE_B3_U13_C_UNIT_P0 TOPN DAC__N_COARSE_B3 sky130_fd_pr__cap_mim_m3_1 w=9.81 l=9.81
XDAC_N_COARSE_B3_U14_C_UNIT_P0 TOPN DAC__N_COARSE_B3 sky130_fd_pr__cap_mim_m3_1 w=9.81 l=9.81
XDAC_N_COARSE_B3_U15_C_UNIT_P0 TOPN DAC__N_COARSE_B3 sky130_fd_pr__cap_mim_m3_1 w=9.81 l=9.81
XDAC_N_COARSE_B3_U2_C_UNIT_P0 TOPN DAC__N_COARSE_B3 sky130_fd_pr__cap_mim_m3_1 w=9.81 l=9.81
XDAC_N_COARSE_B3_U3_C_UNIT_P0 TOPN DAC__N_COARSE_B3 sky130_fd_pr__cap_mim_m3_1 w=9.81 l=9.81
XDAC_N_COARSE_B3_U4_C_UNIT_P0 TOPN DAC__N_COARSE_B3 sky130_fd_pr__cap_mim_m3_1 w=9.81 l=9.81
XDAC_N_COARSE_B3_U5_C_UNIT_P0 TOPN DAC__N_COARSE_B3 sky130_fd_pr__cap_mim_m3_1 w=9.81 l=9.81
XDAC_N_COARSE_B3_U6_C_UNIT_P0 TOPN DAC__N_COARSE_B3 sky130_fd_pr__cap_mim_m3_1 w=9.81 l=9.81
XDAC_N_COARSE_B3_U7_C_UNIT_P0 TOPN DAC__N_COARSE_B3 sky130_fd_pr__cap_mim_m3_1 w=9.81 l=9.81
XDAC_N_COARSE_B3_U8_C_UNIT_P0 TOPN DAC__N_COARSE_B3 sky130_fd_pr__cap_mim_m3_1 w=9.81 l=9.81
XDAC_N_COARSE_B3_U9_C_UNIT_P0 TOPN DAC__N_COARSE_B3 sky130_fd_pr__cap_mim_m3_1 w=9.81 l=9.81
XDAC_N_COARSE_B4_SW_HIGH_N DAC__LON B10 DAC__N_COARSE_B4 VGND sky130_fd_pr__nfet_01v8 w=8 l=0.15 nf=1 m=1
XDAC_N_COARSE_B4_SW_HIGH_P DAC__LON DAC__N_COARSE_B4_SW__BITB DAC__N_COARSE_B4 VPWR sky130_fd_pr__pfet_01v8_hvt w=12 l=0.15 nf=1 m=1
XDAC_N_COARSE_B4_SW_INV_MN DAC__N_COARSE_B4_SW__BITB B10 VGND VGND sky130_fd_pr__nfet_01v8 w=0.65 l=0.15 nf=1 m=1
XDAC_N_COARSE_B4_SW_INV_MP DAC__N_COARSE_B4_SW__BITB B10 VPWR VPWR sky130_fd_pr__pfet_01v8_hvt w=0.65 l=0.15 nf=1 m=1
XDAC_N_COARSE_B4_SW_LOW_N DAC__HIN DAC__N_COARSE_B4_SW__BITB DAC__N_COARSE_B4 VGND sky130_fd_pr__nfet_01v8 w=8 l=0.15 nf=1 m=1
XDAC_N_COARSE_B4_SW_LOW_P DAC__HIN B10 DAC__N_COARSE_B4 VPWR sky130_fd_pr__pfet_01v8_hvt w=12 l=0.15 nf=1 m=1
XDAC_N_COARSE_B4_U0_C_UNIT_P0 TOPN DAC__N_COARSE_B4 sky130_fd_pr__cap_mim_m3_1 w=9.81 l=9.81
XDAC_N_COARSE_B4_U1_C_UNIT_P0 TOPN DAC__N_COARSE_B4 sky130_fd_pr__cap_mim_m3_1 w=9.81 l=9.81
XDAC_N_COARSE_B4_U10_C_UNIT_P0 TOPN DAC__N_COARSE_B4 sky130_fd_pr__cap_mim_m3_1 w=9.81 l=9.81
XDAC_N_COARSE_B4_U11_C_UNIT_P0 TOPN DAC__N_COARSE_B4 sky130_fd_pr__cap_mim_m3_1 w=9.81 l=9.81
XDAC_N_COARSE_B4_U12_C_UNIT_P0 TOPN DAC__N_COARSE_B4 sky130_fd_pr__cap_mim_m3_1 w=9.81 l=9.81
XDAC_N_COARSE_B4_U13_C_UNIT_P0 TOPN DAC__N_COARSE_B4 sky130_fd_pr__cap_mim_m3_1 w=9.81 l=9.81
XDAC_N_COARSE_B4_U14_C_UNIT_P0 TOPN DAC__N_COARSE_B4 sky130_fd_pr__cap_mim_m3_1 w=9.81 l=9.81
XDAC_N_COARSE_B4_U15_C_UNIT_P0 TOPN DAC__N_COARSE_B4 sky130_fd_pr__cap_mim_m3_1 w=9.81 l=9.81
XDAC_N_COARSE_B4_U16_C_UNIT_P0 TOPN DAC__N_COARSE_B4 sky130_fd_pr__cap_mim_m3_1 w=9.81 l=9.81
XDAC_N_COARSE_B4_U17_C_UNIT_P0 TOPN DAC__N_COARSE_B4 sky130_fd_pr__cap_mim_m3_1 w=9.81 l=9.81
XDAC_N_COARSE_B4_U18_C_UNIT_P0 TOPN DAC__N_COARSE_B4 sky130_fd_pr__cap_mim_m3_1 w=9.81 l=9.81
XDAC_N_COARSE_B4_U19_C_UNIT_P0 TOPN DAC__N_COARSE_B4 sky130_fd_pr__cap_mim_m3_1 w=9.81 l=9.81
XDAC_N_COARSE_B4_U2_C_UNIT_P0 TOPN DAC__N_COARSE_B4 sky130_fd_pr__cap_mim_m3_1 w=9.81 l=9.81
XDAC_N_COARSE_B4_U20_C_UNIT_P0 TOPN DAC__N_COARSE_B4 sky130_fd_pr__cap_mim_m3_1 w=9.81 l=9.81
XDAC_N_COARSE_B4_U21_C_UNIT_P0 TOPN DAC__N_COARSE_B4 sky130_fd_pr__cap_mim_m3_1 w=9.81 l=9.81
XDAC_N_COARSE_B4_U22_C_UNIT_P0 TOPN DAC__N_COARSE_B4 sky130_fd_pr__cap_mim_m3_1 w=9.81 l=9.81
XDAC_N_COARSE_B4_U23_C_UNIT_P0 TOPN DAC__N_COARSE_B4 sky130_fd_pr__cap_mim_m3_1 w=9.81 l=9.81
XDAC_N_COARSE_B4_U24_C_UNIT_P0 TOPN DAC__N_COARSE_B4 sky130_fd_pr__cap_mim_m3_1 w=9.81 l=9.81
XDAC_N_COARSE_B4_U25_C_UNIT_P0 TOPN DAC__N_COARSE_B4 sky130_fd_pr__cap_mim_m3_1 w=9.81 l=9.81
XDAC_N_COARSE_B4_U26_C_UNIT_P0 TOPN DAC__N_COARSE_B4 sky130_fd_pr__cap_mim_m3_1 w=9.81 l=9.81
XDAC_N_COARSE_B4_U27_C_UNIT_P0 TOPN DAC__N_COARSE_B4 sky130_fd_pr__cap_mim_m3_1 w=9.81 l=9.81
XDAC_N_COARSE_B4_U28_C_UNIT_P0 TOPN DAC__N_COARSE_B4 sky130_fd_pr__cap_mim_m3_1 w=9.81 l=9.81
XDAC_N_COARSE_B4_U29_C_UNIT_P0 TOPN DAC__N_COARSE_B4 sky130_fd_pr__cap_mim_m3_1 w=9.81 l=9.81
XDAC_N_COARSE_B4_U3_C_UNIT_P0 TOPN DAC__N_COARSE_B4 sky130_fd_pr__cap_mim_m3_1 w=9.81 l=9.81
XDAC_N_COARSE_B4_U30_C_UNIT_P0 TOPN DAC__N_COARSE_B4 sky130_fd_pr__cap_mim_m3_1 w=9.81 l=9.81
XDAC_N_COARSE_B4_U31_C_UNIT_P0 TOPN DAC__N_COARSE_B4 sky130_fd_pr__cap_mim_m3_1 w=9.81 l=9.81
XDAC_N_COARSE_B4_U4_C_UNIT_P0 TOPN DAC__N_COARSE_B4 sky130_fd_pr__cap_mim_m3_1 w=9.81 l=9.81
XDAC_N_COARSE_B4_U5_C_UNIT_P0 TOPN DAC__N_COARSE_B4 sky130_fd_pr__cap_mim_m3_1 w=9.81 l=9.81
XDAC_N_COARSE_B4_U6_C_UNIT_P0 TOPN DAC__N_COARSE_B4 sky130_fd_pr__cap_mim_m3_1 w=9.81 l=9.81
XDAC_N_COARSE_B4_U7_C_UNIT_P0 TOPN DAC__N_COARSE_B4 sky130_fd_pr__cap_mim_m3_1 w=9.81 l=9.81
XDAC_N_COARSE_B4_U8_C_UNIT_P0 TOPN DAC__N_COARSE_B4 sky130_fd_pr__cap_mim_m3_1 w=9.81 l=9.81
XDAC_N_COARSE_B4_U9_C_UNIT_P0 TOPN DAC__N_COARSE_B4 sky130_fd_pr__cap_mim_m3_1 w=9.81 l=9.81
XDAC_N_COARSE_B5_SW_HIGH_N DAC__LON B11 DAC__N_COARSE_B5 VGND sky130_fd_pr__nfet_01v8 w=8 l=0.15 nf=1 m=1
XDAC_N_COARSE_B5_SW_HIGH_P DAC__LON DAC__N_COARSE_B5_SW__BITB DAC__N_COARSE_B5 VPWR sky130_fd_pr__pfet_01v8_hvt w=12 l=0.15 nf=1 m=1
XDAC_N_COARSE_B5_SW_INV_MN DAC__N_COARSE_B5_SW__BITB B11 VGND VGND sky130_fd_pr__nfet_01v8 w=0.65 l=0.15 nf=1 m=1
XDAC_N_COARSE_B5_SW_INV_MP DAC__N_COARSE_B5_SW__BITB B11 VPWR VPWR sky130_fd_pr__pfet_01v8_hvt w=0.65 l=0.15 nf=1 m=1
XDAC_N_COARSE_B5_SW_LOW_N DAC__HIN DAC__N_COARSE_B5_SW__BITB DAC__N_COARSE_B5 VGND sky130_fd_pr__nfet_01v8 w=8 l=0.15 nf=1 m=1
XDAC_N_COARSE_B5_SW_LOW_P DAC__HIN B11 DAC__N_COARSE_B5 VPWR sky130_fd_pr__pfet_01v8_hvt w=12 l=0.15 nf=1 m=1
XDAC_N_COARSE_B5_U0_C_UNIT_P0 TOPN DAC__N_COARSE_B5 sky130_fd_pr__cap_mim_m3_1 w=9.81 l=9.81
XDAC_N_COARSE_B5_U1_C_UNIT_P0 TOPN DAC__N_COARSE_B5 sky130_fd_pr__cap_mim_m3_1 w=9.81 l=9.81
XDAC_N_COARSE_B5_U10_C_UNIT_P0 TOPN DAC__N_COARSE_B5 sky130_fd_pr__cap_mim_m3_1 w=9.81 l=9.81
XDAC_N_COARSE_B5_U11_C_UNIT_P0 TOPN DAC__N_COARSE_B5 sky130_fd_pr__cap_mim_m3_1 w=9.81 l=9.81
XDAC_N_COARSE_B5_U12_C_UNIT_P0 TOPN DAC__N_COARSE_B5 sky130_fd_pr__cap_mim_m3_1 w=9.81 l=9.81
XDAC_N_COARSE_B5_U13_C_UNIT_P0 TOPN DAC__N_COARSE_B5 sky130_fd_pr__cap_mim_m3_1 w=9.81 l=9.81
XDAC_N_COARSE_B5_U14_C_UNIT_P0 TOPN DAC__N_COARSE_B5 sky130_fd_pr__cap_mim_m3_1 w=9.81 l=9.81
XDAC_N_COARSE_B5_U15_C_UNIT_P0 TOPN DAC__N_COARSE_B5 sky130_fd_pr__cap_mim_m3_1 w=9.81 l=9.81
XDAC_N_COARSE_B5_U16_C_UNIT_P0 TOPN DAC__N_COARSE_B5 sky130_fd_pr__cap_mim_m3_1 w=9.81 l=9.81
XDAC_N_COARSE_B5_U17_C_UNIT_P0 TOPN DAC__N_COARSE_B5 sky130_fd_pr__cap_mim_m3_1 w=9.81 l=9.81
XDAC_N_COARSE_B5_U18_C_UNIT_P0 TOPN DAC__N_COARSE_B5 sky130_fd_pr__cap_mim_m3_1 w=9.81 l=9.81
XDAC_N_COARSE_B5_U19_C_UNIT_P0 TOPN DAC__N_COARSE_B5 sky130_fd_pr__cap_mim_m3_1 w=9.81 l=9.81
XDAC_N_COARSE_B5_U2_C_UNIT_P0 TOPN DAC__N_COARSE_B5 sky130_fd_pr__cap_mim_m3_1 w=9.81 l=9.81
XDAC_N_COARSE_B5_U20_C_UNIT_P0 TOPN DAC__N_COARSE_B5 sky130_fd_pr__cap_mim_m3_1 w=9.81 l=9.81
XDAC_N_COARSE_B5_U21_C_UNIT_P0 TOPN DAC__N_COARSE_B5 sky130_fd_pr__cap_mim_m3_1 w=9.81 l=9.81
XDAC_N_COARSE_B5_U22_C_UNIT_P0 TOPN DAC__N_COARSE_B5 sky130_fd_pr__cap_mim_m3_1 w=9.81 l=9.81
XDAC_N_COARSE_B5_U23_C_UNIT_P0 TOPN DAC__N_COARSE_B5 sky130_fd_pr__cap_mim_m3_1 w=9.81 l=9.81
XDAC_N_COARSE_B5_U24_C_UNIT_P0 TOPN DAC__N_COARSE_B5 sky130_fd_pr__cap_mim_m3_1 w=9.81 l=9.81
XDAC_N_COARSE_B5_U25_C_UNIT_P0 TOPN DAC__N_COARSE_B5 sky130_fd_pr__cap_mim_m3_1 w=9.81 l=9.81
XDAC_N_COARSE_B5_U26_C_UNIT_P0 TOPN DAC__N_COARSE_B5 sky130_fd_pr__cap_mim_m3_1 w=9.81 l=9.81
XDAC_N_COARSE_B5_U27_C_UNIT_P0 TOPN DAC__N_COARSE_B5 sky130_fd_pr__cap_mim_m3_1 w=9.81 l=9.81
XDAC_N_COARSE_B5_U28_C_UNIT_P0 TOPN DAC__N_COARSE_B5 sky130_fd_pr__cap_mim_m3_1 w=9.81 l=9.81
XDAC_N_COARSE_B5_U29_C_UNIT_P0 TOPN DAC__N_COARSE_B5 sky130_fd_pr__cap_mim_m3_1 w=9.81 l=9.81
XDAC_N_COARSE_B5_U3_C_UNIT_P0 TOPN DAC__N_COARSE_B5 sky130_fd_pr__cap_mim_m3_1 w=9.81 l=9.81
XDAC_N_COARSE_B5_U30_C_UNIT_P0 TOPN DAC__N_COARSE_B5 sky130_fd_pr__cap_mim_m3_1 w=9.81 l=9.81
XDAC_N_COARSE_B5_U31_C_UNIT_P0 TOPN DAC__N_COARSE_B5 sky130_fd_pr__cap_mim_m3_1 w=9.81 l=9.81
XDAC_N_COARSE_B5_U32_C_UNIT_P0 TOPN DAC__N_COARSE_B5 sky130_fd_pr__cap_mim_m3_1 w=9.81 l=9.81
XDAC_N_COARSE_B5_U33_C_UNIT_P0 TOPN DAC__N_COARSE_B5 sky130_fd_pr__cap_mim_m3_1 w=9.81 l=9.81
XDAC_N_COARSE_B5_U34_C_UNIT_P0 TOPN DAC__N_COARSE_B5 sky130_fd_pr__cap_mim_m3_1 w=9.81 l=9.81
XDAC_N_COARSE_B5_U35_C_UNIT_P0 TOPN DAC__N_COARSE_B5 sky130_fd_pr__cap_mim_m3_1 w=9.81 l=9.81
XDAC_N_COARSE_B5_U36_C_UNIT_P0 TOPN DAC__N_COARSE_B5 sky130_fd_pr__cap_mim_m3_1 w=9.81 l=9.81
XDAC_N_COARSE_B5_U37_C_UNIT_P0 TOPN DAC__N_COARSE_B5 sky130_fd_pr__cap_mim_m3_1 w=9.81 l=9.81
XDAC_N_COARSE_B5_U38_C_UNIT_P0 TOPN DAC__N_COARSE_B5 sky130_fd_pr__cap_mim_m3_1 w=9.81 l=9.81
XDAC_N_COARSE_B5_U39_C_UNIT_P0 TOPN DAC__N_COARSE_B5 sky130_fd_pr__cap_mim_m3_1 w=9.81 l=9.81
XDAC_N_COARSE_B5_U4_C_UNIT_P0 TOPN DAC__N_COARSE_B5 sky130_fd_pr__cap_mim_m3_1 w=9.81 l=9.81
XDAC_N_COARSE_B5_U40_C_UNIT_P0 TOPN DAC__N_COARSE_B5 sky130_fd_pr__cap_mim_m3_1 w=9.81 l=9.81
XDAC_N_COARSE_B5_U41_C_UNIT_P0 TOPN DAC__N_COARSE_B5 sky130_fd_pr__cap_mim_m3_1 w=9.81 l=9.81
XDAC_N_COARSE_B5_U42_C_UNIT_P0 TOPN DAC__N_COARSE_B5 sky130_fd_pr__cap_mim_m3_1 w=9.81 l=9.81
XDAC_N_COARSE_B5_U43_C_UNIT_P0 TOPN DAC__N_COARSE_B5 sky130_fd_pr__cap_mim_m3_1 w=9.81 l=9.81
XDAC_N_COARSE_B5_U44_C_UNIT_P0 TOPN DAC__N_COARSE_B5 sky130_fd_pr__cap_mim_m3_1 w=9.81 l=9.81
XDAC_N_COARSE_B5_U45_C_UNIT_P0 TOPN DAC__N_COARSE_B5 sky130_fd_pr__cap_mim_m3_1 w=9.81 l=9.81
XDAC_N_COARSE_B5_U46_C_UNIT_P0 TOPN DAC__N_COARSE_B5 sky130_fd_pr__cap_mim_m3_1 w=9.81 l=9.81
XDAC_N_COARSE_B5_U47_C_UNIT_P0 TOPN DAC__N_COARSE_B5 sky130_fd_pr__cap_mim_m3_1 w=9.81 l=9.81
XDAC_N_COARSE_B5_U48_C_UNIT_P0 TOPN DAC__N_COARSE_B5 sky130_fd_pr__cap_mim_m3_1 w=9.81 l=9.81
XDAC_N_COARSE_B5_U49_C_UNIT_P0 TOPN DAC__N_COARSE_B5 sky130_fd_pr__cap_mim_m3_1 w=9.81 l=9.81
XDAC_N_COARSE_B5_U5_C_UNIT_P0 TOPN DAC__N_COARSE_B5 sky130_fd_pr__cap_mim_m3_1 w=9.81 l=9.81
XDAC_N_COARSE_B5_U50_C_UNIT_P0 TOPN DAC__N_COARSE_B5 sky130_fd_pr__cap_mim_m3_1 w=9.81 l=9.81
XDAC_N_COARSE_B5_U51_C_UNIT_P0 TOPN DAC__N_COARSE_B5 sky130_fd_pr__cap_mim_m3_1 w=9.81 l=9.81
XDAC_N_COARSE_B5_U52_C_UNIT_P0 TOPN DAC__N_COARSE_B5 sky130_fd_pr__cap_mim_m3_1 w=9.81 l=9.81
XDAC_N_COARSE_B5_U53_C_UNIT_P0 TOPN DAC__N_COARSE_B5 sky130_fd_pr__cap_mim_m3_1 w=9.81 l=9.81
XDAC_N_COARSE_B5_U54_C_UNIT_P0 TOPN DAC__N_COARSE_B5 sky130_fd_pr__cap_mim_m3_1 w=9.81 l=9.81
XDAC_N_COARSE_B5_U55_C_UNIT_P0 TOPN DAC__N_COARSE_B5 sky130_fd_pr__cap_mim_m3_1 w=9.81 l=9.81
XDAC_N_COARSE_B5_U56_C_UNIT_P0 TOPN DAC__N_COARSE_B5 sky130_fd_pr__cap_mim_m3_1 w=9.81 l=9.81
XDAC_N_COARSE_B5_U57_C_UNIT_P0 TOPN DAC__N_COARSE_B5 sky130_fd_pr__cap_mim_m3_1 w=9.81 l=9.81
XDAC_N_COARSE_B5_U58_C_UNIT_P0 TOPN DAC__N_COARSE_B5 sky130_fd_pr__cap_mim_m3_1 w=9.81 l=9.81
XDAC_N_COARSE_B5_U59_C_UNIT_P0 TOPN DAC__N_COARSE_B5 sky130_fd_pr__cap_mim_m3_1 w=9.81 l=9.81
XDAC_N_COARSE_B5_U6_C_UNIT_P0 TOPN DAC__N_COARSE_B5 sky130_fd_pr__cap_mim_m3_1 w=9.81 l=9.81
XDAC_N_COARSE_B5_U60_C_UNIT_P0 TOPN DAC__N_COARSE_B5 sky130_fd_pr__cap_mim_m3_1 w=9.81 l=9.81
XDAC_N_COARSE_B5_U61_C_UNIT_P0 TOPN DAC__N_COARSE_B5 sky130_fd_pr__cap_mim_m3_1 w=9.81 l=9.81
XDAC_N_COARSE_B5_U62_C_UNIT_P0 TOPN DAC__N_COARSE_B5 sky130_fd_pr__cap_mim_m3_1 w=9.81 l=9.81
XDAC_N_COARSE_B5_U63_C_UNIT_P0 TOPN DAC__N_COARSE_B5 sky130_fd_pr__cap_mim_m3_1 w=9.81 l=9.81
XDAC_N_COARSE_B5_U7_C_UNIT_P0 TOPN DAC__N_COARSE_B5 sky130_fd_pr__cap_mim_m3_1 w=9.81 l=9.81
XDAC_N_COARSE_B5_U8_C_UNIT_P0 TOPN DAC__N_COARSE_B5 sky130_fd_pr__cap_mim_m3_1 w=9.81 l=9.81
XDAC_N_COARSE_B5_U9_C_UNIT_P0 TOPN DAC__N_COARSE_B5 sky130_fd_pr__cap_mim_m3_1 w=9.81 l=9.81
XDAC_N_FINE_B0_SW_HIGH_N DAC__LON B0 DAC__N_FINE_B0 VGND sky130_fd_pr__nfet_01v8 w=8 l=0.15 nf=1 m=1
XDAC_N_FINE_B0_SW_HIGH_P DAC__LON DAC__N_FINE_B0_SW__BITB DAC__N_FINE_B0 VPWR sky130_fd_pr__pfet_01v8_hvt w=12 l=0.15 nf=1 m=1
XDAC_N_FINE_B0_SW_INV_MN DAC__N_FINE_B0_SW__BITB B0 VGND VGND sky130_fd_pr__nfet_01v8 w=0.65 l=0.15 nf=1 m=1
XDAC_N_FINE_B0_SW_INV_MP DAC__N_FINE_B0_SW__BITB B0 VPWR VPWR sky130_fd_pr__pfet_01v8_hvt w=0.65 l=0.15 nf=1 m=1
XDAC_N_FINE_B0_SW_LOW_N DAC__HIN DAC__N_FINE_B0_SW__BITB DAC__N_FINE_B0 VGND sky130_fd_pr__nfet_01v8 w=8 l=0.15 nf=1 m=1
XDAC_N_FINE_B0_SW_LOW_P DAC__HIN B0 DAC__N_FINE_B0 VPWR sky130_fd_pr__pfet_01v8_hvt w=12 l=0.15 nf=1 m=1
XDAC_N_FINE_B0_U0_C_UNIT_P0 DAC__FINEN DAC__N_FINE_B0 sky130_fd_pr__cap_mim_m3_1 w=9.81 l=9.81
XDAC_N_FINE_B0_U1_C_UNIT_P0 DAC__FINEN DAC__N_FINE_B0 sky130_fd_pr__cap_mim_m3_1 w=9.81 l=9.81
XDAC_N_FINE_B1_SW_HIGH_N DAC__LON B1 DAC__N_FINE_B1 VGND sky130_fd_pr__nfet_01v8 w=8 l=0.15 nf=1 m=1
XDAC_N_FINE_B1_SW_HIGH_P DAC__LON DAC__N_FINE_B1_SW__BITB DAC__N_FINE_B1 VPWR sky130_fd_pr__pfet_01v8_hvt w=12 l=0.15 nf=1 m=1
XDAC_N_FINE_B1_SW_INV_MN DAC__N_FINE_B1_SW__BITB B1 VGND VGND sky130_fd_pr__nfet_01v8 w=0.65 l=0.15 nf=1 m=1
XDAC_N_FINE_B1_SW_INV_MP DAC__N_FINE_B1_SW__BITB B1 VPWR VPWR sky130_fd_pr__pfet_01v8_hvt w=0.65 l=0.15 nf=1 m=1
XDAC_N_FINE_B1_SW_LOW_N DAC__HIN DAC__N_FINE_B1_SW__BITB DAC__N_FINE_B1 VGND sky130_fd_pr__nfet_01v8 w=8 l=0.15 nf=1 m=1
XDAC_N_FINE_B1_SW_LOW_P DAC__HIN B1 DAC__N_FINE_B1 VPWR sky130_fd_pr__pfet_01v8_hvt w=12 l=0.15 nf=1 m=1
XDAC_N_FINE_B1_U0_C_UNIT_P0 DAC__FINEN DAC__N_FINE_B1 sky130_fd_pr__cap_mim_m3_1 w=9.81 l=9.81
XDAC_N_FINE_B1_U1_C_UNIT_P0 DAC__FINEN DAC__N_FINE_B1 sky130_fd_pr__cap_mim_m3_1 w=9.81 l=9.81
XDAC_N_FINE_B1_U2_C_UNIT_P0 DAC__FINEN DAC__N_FINE_B1 sky130_fd_pr__cap_mim_m3_1 w=9.81 l=9.81
XDAC_N_FINE_B1_U3_C_UNIT_P0 DAC__FINEN DAC__N_FINE_B1 sky130_fd_pr__cap_mim_m3_1 w=9.81 l=9.81
XDAC_N_FINE_B2_SW_HIGH_N DAC__LON B2 DAC__N_FINE_B2 VGND sky130_fd_pr__nfet_01v8 w=8 l=0.15 nf=1 m=1
XDAC_N_FINE_B2_SW_HIGH_P DAC__LON DAC__N_FINE_B2_SW__BITB DAC__N_FINE_B2 VPWR sky130_fd_pr__pfet_01v8_hvt w=12 l=0.15 nf=1 m=1
XDAC_N_FINE_B2_SW_INV_MN DAC__N_FINE_B2_SW__BITB B2 VGND VGND sky130_fd_pr__nfet_01v8 w=0.65 l=0.15 nf=1 m=1
XDAC_N_FINE_B2_SW_INV_MP DAC__N_FINE_B2_SW__BITB B2 VPWR VPWR sky130_fd_pr__pfet_01v8_hvt w=0.65 l=0.15 nf=1 m=1
XDAC_N_FINE_B2_SW_LOW_N DAC__HIN DAC__N_FINE_B2_SW__BITB DAC__N_FINE_B2 VGND sky130_fd_pr__nfet_01v8 w=8 l=0.15 nf=1 m=1
XDAC_N_FINE_B2_SW_LOW_P DAC__HIN B2 DAC__N_FINE_B2 VPWR sky130_fd_pr__pfet_01v8_hvt w=12 l=0.15 nf=1 m=1
XDAC_N_FINE_B2_U0_C_UNIT_P0 DAC__FINEN DAC__N_FINE_B2 sky130_fd_pr__cap_mim_m3_1 w=9.81 l=9.81
XDAC_N_FINE_B2_U1_C_UNIT_P0 DAC__FINEN DAC__N_FINE_B2 sky130_fd_pr__cap_mim_m3_1 w=9.81 l=9.81
XDAC_N_FINE_B2_U2_C_UNIT_P0 DAC__FINEN DAC__N_FINE_B2 sky130_fd_pr__cap_mim_m3_1 w=9.81 l=9.81
XDAC_N_FINE_B2_U3_C_UNIT_P0 DAC__FINEN DAC__N_FINE_B2 sky130_fd_pr__cap_mim_m3_1 w=9.81 l=9.81
XDAC_N_FINE_B2_U4_C_UNIT_P0 DAC__FINEN DAC__N_FINE_B2 sky130_fd_pr__cap_mim_m3_1 w=9.81 l=9.81
XDAC_N_FINE_B2_U5_C_UNIT_P0 DAC__FINEN DAC__N_FINE_B2 sky130_fd_pr__cap_mim_m3_1 w=9.81 l=9.81
XDAC_N_FINE_B2_U6_C_UNIT_P0 DAC__FINEN DAC__N_FINE_B2 sky130_fd_pr__cap_mim_m3_1 w=9.81 l=9.81
XDAC_N_FINE_B2_U7_C_UNIT_P0 DAC__FINEN DAC__N_FINE_B2 sky130_fd_pr__cap_mim_m3_1 w=9.81 l=9.81
XDAC_N_FINE_B3_SW_HIGH_N DAC__LON B3 DAC__N_FINE_B3 VGND sky130_fd_pr__nfet_01v8 w=8 l=0.15 nf=1 m=1
XDAC_N_FINE_B3_SW_HIGH_P DAC__LON DAC__N_FINE_B3_SW__BITB DAC__N_FINE_B3 VPWR sky130_fd_pr__pfet_01v8_hvt w=12 l=0.15 nf=1 m=1
XDAC_N_FINE_B3_SW_INV_MN DAC__N_FINE_B3_SW__BITB B3 VGND VGND sky130_fd_pr__nfet_01v8 w=0.65 l=0.15 nf=1 m=1
XDAC_N_FINE_B3_SW_INV_MP DAC__N_FINE_B3_SW__BITB B3 VPWR VPWR sky130_fd_pr__pfet_01v8_hvt w=0.65 l=0.15 nf=1 m=1
XDAC_N_FINE_B3_SW_LOW_N DAC__HIN DAC__N_FINE_B3_SW__BITB DAC__N_FINE_B3 VGND sky130_fd_pr__nfet_01v8 w=8 l=0.15 nf=1 m=1
XDAC_N_FINE_B3_SW_LOW_P DAC__HIN B3 DAC__N_FINE_B3 VPWR sky130_fd_pr__pfet_01v8_hvt w=12 l=0.15 nf=1 m=1
XDAC_N_FINE_B3_U0_C_UNIT_P0 DAC__FINEN DAC__N_FINE_B3 sky130_fd_pr__cap_mim_m3_1 w=9.81 l=9.81
XDAC_N_FINE_B3_U1_C_UNIT_P0 DAC__FINEN DAC__N_FINE_B3 sky130_fd_pr__cap_mim_m3_1 w=9.81 l=9.81
XDAC_N_FINE_B3_U10_C_UNIT_P0 DAC__FINEN DAC__N_FINE_B3 sky130_fd_pr__cap_mim_m3_1 w=9.81 l=9.81
XDAC_N_FINE_B3_U11_C_UNIT_P0 DAC__FINEN DAC__N_FINE_B3 sky130_fd_pr__cap_mim_m3_1 w=9.81 l=9.81
XDAC_N_FINE_B3_U12_C_UNIT_P0 DAC__FINEN DAC__N_FINE_B3 sky130_fd_pr__cap_mim_m3_1 w=9.81 l=9.81
XDAC_N_FINE_B3_U13_C_UNIT_P0 DAC__FINEN DAC__N_FINE_B3 sky130_fd_pr__cap_mim_m3_1 w=9.81 l=9.81
XDAC_N_FINE_B3_U14_C_UNIT_P0 DAC__FINEN DAC__N_FINE_B3 sky130_fd_pr__cap_mim_m3_1 w=9.81 l=9.81
XDAC_N_FINE_B3_U15_C_UNIT_P0 DAC__FINEN DAC__N_FINE_B3 sky130_fd_pr__cap_mim_m3_1 w=9.81 l=9.81
XDAC_N_FINE_B3_U2_C_UNIT_P0 DAC__FINEN DAC__N_FINE_B3 sky130_fd_pr__cap_mim_m3_1 w=9.81 l=9.81
XDAC_N_FINE_B3_U3_C_UNIT_P0 DAC__FINEN DAC__N_FINE_B3 sky130_fd_pr__cap_mim_m3_1 w=9.81 l=9.81
XDAC_N_FINE_B3_U4_C_UNIT_P0 DAC__FINEN DAC__N_FINE_B3 sky130_fd_pr__cap_mim_m3_1 w=9.81 l=9.81
XDAC_N_FINE_B3_U5_C_UNIT_P0 DAC__FINEN DAC__N_FINE_B3 sky130_fd_pr__cap_mim_m3_1 w=9.81 l=9.81
XDAC_N_FINE_B3_U6_C_UNIT_P0 DAC__FINEN DAC__N_FINE_B3 sky130_fd_pr__cap_mim_m3_1 w=9.81 l=9.81
XDAC_N_FINE_B3_U7_C_UNIT_P0 DAC__FINEN DAC__N_FINE_B3 sky130_fd_pr__cap_mim_m3_1 w=9.81 l=9.81
XDAC_N_FINE_B3_U8_C_UNIT_P0 DAC__FINEN DAC__N_FINE_B3 sky130_fd_pr__cap_mim_m3_1 w=9.81 l=9.81
XDAC_N_FINE_B3_U9_C_UNIT_P0 DAC__FINEN DAC__N_FINE_B3 sky130_fd_pr__cap_mim_m3_1 w=9.81 l=9.81
XDAC_N_FINE_B4_SW_HIGH_N DAC__LON B4 DAC__N_FINE_B4 VGND sky130_fd_pr__nfet_01v8 w=8 l=0.15 nf=1 m=1
XDAC_N_FINE_B4_SW_HIGH_P DAC__LON DAC__N_FINE_B4_SW__BITB DAC__N_FINE_B4 VPWR sky130_fd_pr__pfet_01v8_hvt w=12 l=0.15 nf=1 m=1
XDAC_N_FINE_B4_SW_INV_MN DAC__N_FINE_B4_SW__BITB B4 VGND VGND sky130_fd_pr__nfet_01v8 w=0.65 l=0.15 nf=1 m=1
XDAC_N_FINE_B4_SW_INV_MP DAC__N_FINE_B4_SW__BITB B4 VPWR VPWR sky130_fd_pr__pfet_01v8_hvt w=0.65 l=0.15 nf=1 m=1
XDAC_N_FINE_B4_SW_LOW_N DAC__HIN DAC__N_FINE_B4_SW__BITB DAC__N_FINE_B4 VGND sky130_fd_pr__nfet_01v8 w=8 l=0.15 nf=1 m=1
XDAC_N_FINE_B4_SW_LOW_P DAC__HIN B4 DAC__N_FINE_B4 VPWR sky130_fd_pr__pfet_01v8_hvt w=12 l=0.15 nf=1 m=1
XDAC_N_FINE_B4_U0_C_UNIT_P0 DAC__FINEN DAC__N_FINE_B4 sky130_fd_pr__cap_mim_m3_1 w=9.81 l=9.81
XDAC_N_FINE_B4_U1_C_UNIT_P0 DAC__FINEN DAC__N_FINE_B4 sky130_fd_pr__cap_mim_m3_1 w=9.81 l=9.81
XDAC_N_FINE_B4_U10_C_UNIT_P0 DAC__FINEN DAC__N_FINE_B4 sky130_fd_pr__cap_mim_m3_1 w=9.81 l=9.81
XDAC_N_FINE_B4_U11_C_UNIT_P0 DAC__FINEN DAC__N_FINE_B4 sky130_fd_pr__cap_mim_m3_1 w=9.81 l=9.81
XDAC_N_FINE_B4_U12_C_UNIT_P0 DAC__FINEN DAC__N_FINE_B4 sky130_fd_pr__cap_mim_m3_1 w=9.81 l=9.81
XDAC_N_FINE_B4_U13_C_UNIT_P0 DAC__FINEN DAC__N_FINE_B4 sky130_fd_pr__cap_mim_m3_1 w=9.81 l=9.81
XDAC_N_FINE_B4_U14_C_UNIT_P0 DAC__FINEN DAC__N_FINE_B4 sky130_fd_pr__cap_mim_m3_1 w=9.81 l=9.81
XDAC_N_FINE_B4_U15_C_UNIT_P0 DAC__FINEN DAC__N_FINE_B4 sky130_fd_pr__cap_mim_m3_1 w=9.81 l=9.81
XDAC_N_FINE_B4_U16_C_UNIT_P0 DAC__FINEN DAC__N_FINE_B4 sky130_fd_pr__cap_mim_m3_1 w=9.81 l=9.81
XDAC_N_FINE_B4_U17_C_UNIT_P0 DAC__FINEN DAC__N_FINE_B4 sky130_fd_pr__cap_mim_m3_1 w=9.81 l=9.81
XDAC_N_FINE_B4_U18_C_UNIT_P0 DAC__FINEN DAC__N_FINE_B4 sky130_fd_pr__cap_mim_m3_1 w=9.81 l=9.81
XDAC_N_FINE_B4_U19_C_UNIT_P0 DAC__FINEN DAC__N_FINE_B4 sky130_fd_pr__cap_mim_m3_1 w=9.81 l=9.81
XDAC_N_FINE_B4_U2_C_UNIT_P0 DAC__FINEN DAC__N_FINE_B4 sky130_fd_pr__cap_mim_m3_1 w=9.81 l=9.81
XDAC_N_FINE_B4_U20_C_UNIT_P0 DAC__FINEN DAC__N_FINE_B4 sky130_fd_pr__cap_mim_m3_1 w=9.81 l=9.81
XDAC_N_FINE_B4_U21_C_UNIT_P0 DAC__FINEN DAC__N_FINE_B4 sky130_fd_pr__cap_mim_m3_1 w=9.81 l=9.81
XDAC_N_FINE_B4_U22_C_UNIT_P0 DAC__FINEN DAC__N_FINE_B4 sky130_fd_pr__cap_mim_m3_1 w=9.81 l=9.81
XDAC_N_FINE_B4_U23_C_UNIT_P0 DAC__FINEN DAC__N_FINE_B4 sky130_fd_pr__cap_mim_m3_1 w=9.81 l=9.81
XDAC_N_FINE_B4_U24_C_UNIT_P0 DAC__FINEN DAC__N_FINE_B4 sky130_fd_pr__cap_mim_m3_1 w=9.81 l=9.81
XDAC_N_FINE_B4_U25_C_UNIT_P0 DAC__FINEN DAC__N_FINE_B4 sky130_fd_pr__cap_mim_m3_1 w=9.81 l=9.81
XDAC_N_FINE_B4_U26_C_UNIT_P0 DAC__FINEN DAC__N_FINE_B4 sky130_fd_pr__cap_mim_m3_1 w=9.81 l=9.81
XDAC_N_FINE_B4_U27_C_UNIT_P0 DAC__FINEN DAC__N_FINE_B4 sky130_fd_pr__cap_mim_m3_1 w=9.81 l=9.81
XDAC_N_FINE_B4_U28_C_UNIT_P0 DAC__FINEN DAC__N_FINE_B4 sky130_fd_pr__cap_mim_m3_1 w=9.81 l=9.81
XDAC_N_FINE_B4_U29_C_UNIT_P0 DAC__FINEN DAC__N_FINE_B4 sky130_fd_pr__cap_mim_m3_1 w=9.81 l=9.81
XDAC_N_FINE_B4_U3_C_UNIT_P0 DAC__FINEN DAC__N_FINE_B4 sky130_fd_pr__cap_mim_m3_1 w=9.81 l=9.81
XDAC_N_FINE_B4_U30_C_UNIT_P0 DAC__FINEN DAC__N_FINE_B4 sky130_fd_pr__cap_mim_m3_1 w=9.81 l=9.81
XDAC_N_FINE_B4_U31_C_UNIT_P0 DAC__FINEN DAC__N_FINE_B4 sky130_fd_pr__cap_mim_m3_1 w=9.81 l=9.81
XDAC_N_FINE_B4_U4_C_UNIT_P0 DAC__FINEN DAC__N_FINE_B4 sky130_fd_pr__cap_mim_m3_1 w=9.81 l=9.81
XDAC_N_FINE_B4_U5_C_UNIT_P0 DAC__FINEN DAC__N_FINE_B4 sky130_fd_pr__cap_mim_m3_1 w=9.81 l=9.81
XDAC_N_FINE_B4_U6_C_UNIT_P0 DAC__FINEN DAC__N_FINE_B4 sky130_fd_pr__cap_mim_m3_1 w=9.81 l=9.81
XDAC_N_FINE_B4_U7_C_UNIT_P0 DAC__FINEN DAC__N_FINE_B4 sky130_fd_pr__cap_mim_m3_1 w=9.81 l=9.81
XDAC_N_FINE_B4_U8_C_UNIT_P0 DAC__FINEN DAC__N_FINE_B4 sky130_fd_pr__cap_mim_m3_1 w=9.81 l=9.81
XDAC_N_FINE_B4_U9_C_UNIT_P0 DAC__FINEN DAC__N_FINE_B4 sky130_fd_pr__cap_mim_m3_1 w=9.81 l=9.81
XDAC_N_FINE_B5_SW_HIGH_N DAC__LON B5 DAC__N_FINE_B5 VGND sky130_fd_pr__nfet_01v8 w=8 l=0.15 nf=1 m=1
XDAC_N_FINE_B5_SW_HIGH_P DAC__LON DAC__N_FINE_B5_SW__BITB DAC__N_FINE_B5 VPWR sky130_fd_pr__pfet_01v8_hvt w=12 l=0.15 nf=1 m=1
XDAC_N_FINE_B5_SW_INV_MN DAC__N_FINE_B5_SW__BITB B5 VGND VGND sky130_fd_pr__nfet_01v8 w=0.65 l=0.15 nf=1 m=1
XDAC_N_FINE_B5_SW_INV_MP DAC__N_FINE_B5_SW__BITB B5 VPWR VPWR sky130_fd_pr__pfet_01v8_hvt w=0.65 l=0.15 nf=1 m=1
XDAC_N_FINE_B5_SW_LOW_N DAC__HIN DAC__N_FINE_B5_SW__BITB DAC__N_FINE_B5 VGND sky130_fd_pr__nfet_01v8 w=8 l=0.15 nf=1 m=1
XDAC_N_FINE_B5_SW_LOW_P DAC__HIN B5 DAC__N_FINE_B5 VPWR sky130_fd_pr__pfet_01v8_hvt w=12 l=0.15 nf=1 m=1
XDAC_N_FINE_B5_U0_C_UNIT_P0 DAC__FINEN DAC__N_FINE_B5 sky130_fd_pr__cap_mim_m3_1 w=9.81 l=9.81
XDAC_N_FINE_B5_U1_C_UNIT_P0 DAC__FINEN DAC__N_FINE_B5 sky130_fd_pr__cap_mim_m3_1 w=9.81 l=9.81
XDAC_N_FINE_B5_U10_C_UNIT_P0 DAC__FINEN DAC__N_FINE_B5 sky130_fd_pr__cap_mim_m3_1 w=9.81 l=9.81
XDAC_N_FINE_B5_U11_C_UNIT_P0 DAC__FINEN DAC__N_FINE_B5 sky130_fd_pr__cap_mim_m3_1 w=9.81 l=9.81
XDAC_N_FINE_B5_U12_C_UNIT_P0 DAC__FINEN DAC__N_FINE_B5 sky130_fd_pr__cap_mim_m3_1 w=9.81 l=9.81
XDAC_N_FINE_B5_U13_C_UNIT_P0 DAC__FINEN DAC__N_FINE_B5 sky130_fd_pr__cap_mim_m3_1 w=9.81 l=9.81
XDAC_N_FINE_B5_U14_C_UNIT_P0 DAC__FINEN DAC__N_FINE_B5 sky130_fd_pr__cap_mim_m3_1 w=9.81 l=9.81
XDAC_N_FINE_B5_U15_C_UNIT_P0 DAC__FINEN DAC__N_FINE_B5 sky130_fd_pr__cap_mim_m3_1 w=9.81 l=9.81
XDAC_N_FINE_B5_U16_C_UNIT_P0 DAC__FINEN DAC__N_FINE_B5 sky130_fd_pr__cap_mim_m3_1 w=9.81 l=9.81
XDAC_N_FINE_B5_U17_C_UNIT_P0 DAC__FINEN DAC__N_FINE_B5 sky130_fd_pr__cap_mim_m3_1 w=9.81 l=9.81
XDAC_N_FINE_B5_U18_C_UNIT_P0 DAC__FINEN DAC__N_FINE_B5 sky130_fd_pr__cap_mim_m3_1 w=9.81 l=9.81
XDAC_N_FINE_B5_U19_C_UNIT_P0 DAC__FINEN DAC__N_FINE_B5 sky130_fd_pr__cap_mim_m3_1 w=9.81 l=9.81
XDAC_N_FINE_B5_U2_C_UNIT_P0 DAC__FINEN DAC__N_FINE_B5 sky130_fd_pr__cap_mim_m3_1 w=9.81 l=9.81
XDAC_N_FINE_B5_U20_C_UNIT_P0 DAC__FINEN DAC__N_FINE_B5 sky130_fd_pr__cap_mim_m3_1 w=9.81 l=9.81
XDAC_N_FINE_B5_U21_C_UNIT_P0 DAC__FINEN DAC__N_FINE_B5 sky130_fd_pr__cap_mim_m3_1 w=9.81 l=9.81
XDAC_N_FINE_B5_U22_C_UNIT_P0 DAC__FINEN DAC__N_FINE_B5 sky130_fd_pr__cap_mim_m3_1 w=9.81 l=9.81
XDAC_N_FINE_B5_U23_C_UNIT_P0 DAC__FINEN DAC__N_FINE_B5 sky130_fd_pr__cap_mim_m3_1 w=9.81 l=9.81
XDAC_N_FINE_B5_U24_C_UNIT_P0 DAC__FINEN DAC__N_FINE_B5 sky130_fd_pr__cap_mim_m3_1 w=9.81 l=9.81
XDAC_N_FINE_B5_U25_C_UNIT_P0 DAC__FINEN DAC__N_FINE_B5 sky130_fd_pr__cap_mim_m3_1 w=9.81 l=9.81
XDAC_N_FINE_B5_U26_C_UNIT_P0 DAC__FINEN DAC__N_FINE_B5 sky130_fd_pr__cap_mim_m3_1 w=9.81 l=9.81
XDAC_N_FINE_B5_U27_C_UNIT_P0 DAC__FINEN DAC__N_FINE_B5 sky130_fd_pr__cap_mim_m3_1 w=9.81 l=9.81
XDAC_N_FINE_B5_U28_C_UNIT_P0 DAC__FINEN DAC__N_FINE_B5 sky130_fd_pr__cap_mim_m3_1 w=9.81 l=9.81
XDAC_N_FINE_B5_U29_C_UNIT_P0 DAC__FINEN DAC__N_FINE_B5 sky130_fd_pr__cap_mim_m3_1 w=9.81 l=9.81
XDAC_N_FINE_B5_U3_C_UNIT_P0 DAC__FINEN DAC__N_FINE_B5 sky130_fd_pr__cap_mim_m3_1 w=9.81 l=9.81
XDAC_N_FINE_B5_U30_C_UNIT_P0 DAC__FINEN DAC__N_FINE_B5 sky130_fd_pr__cap_mim_m3_1 w=9.81 l=9.81
XDAC_N_FINE_B5_U31_C_UNIT_P0 DAC__FINEN DAC__N_FINE_B5 sky130_fd_pr__cap_mim_m3_1 w=9.81 l=9.81
XDAC_N_FINE_B5_U32_C_UNIT_P0 DAC__FINEN DAC__N_FINE_B5 sky130_fd_pr__cap_mim_m3_1 w=9.81 l=9.81
XDAC_N_FINE_B5_U33_C_UNIT_P0 DAC__FINEN DAC__N_FINE_B5 sky130_fd_pr__cap_mim_m3_1 w=9.81 l=9.81
XDAC_N_FINE_B5_U34_C_UNIT_P0 DAC__FINEN DAC__N_FINE_B5 sky130_fd_pr__cap_mim_m3_1 w=9.81 l=9.81
XDAC_N_FINE_B5_U35_C_UNIT_P0 DAC__FINEN DAC__N_FINE_B5 sky130_fd_pr__cap_mim_m3_1 w=9.81 l=9.81
XDAC_N_FINE_B5_U36_C_UNIT_P0 DAC__FINEN DAC__N_FINE_B5 sky130_fd_pr__cap_mim_m3_1 w=9.81 l=9.81
XDAC_N_FINE_B5_U37_C_UNIT_P0 DAC__FINEN DAC__N_FINE_B5 sky130_fd_pr__cap_mim_m3_1 w=9.81 l=9.81
XDAC_N_FINE_B5_U38_C_UNIT_P0 DAC__FINEN DAC__N_FINE_B5 sky130_fd_pr__cap_mim_m3_1 w=9.81 l=9.81
XDAC_N_FINE_B5_U39_C_UNIT_P0 DAC__FINEN DAC__N_FINE_B5 sky130_fd_pr__cap_mim_m3_1 w=9.81 l=9.81
XDAC_N_FINE_B5_U4_C_UNIT_P0 DAC__FINEN DAC__N_FINE_B5 sky130_fd_pr__cap_mim_m3_1 w=9.81 l=9.81
XDAC_N_FINE_B5_U40_C_UNIT_P0 DAC__FINEN DAC__N_FINE_B5 sky130_fd_pr__cap_mim_m3_1 w=9.81 l=9.81
XDAC_N_FINE_B5_U41_C_UNIT_P0 DAC__FINEN DAC__N_FINE_B5 sky130_fd_pr__cap_mim_m3_1 w=9.81 l=9.81
XDAC_N_FINE_B5_U42_C_UNIT_P0 DAC__FINEN DAC__N_FINE_B5 sky130_fd_pr__cap_mim_m3_1 w=9.81 l=9.81
XDAC_N_FINE_B5_U43_C_UNIT_P0 DAC__FINEN DAC__N_FINE_B5 sky130_fd_pr__cap_mim_m3_1 w=9.81 l=9.81
XDAC_N_FINE_B5_U44_C_UNIT_P0 DAC__FINEN DAC__N_FINE_B5 sky130_fd_pr__cap_mim_m3_1 w=9.81 l=9.81
XDAC_N_FINE_B5_U45_C_UNIT_P0 DAC__FINEN DAC__N_FINE_B5 sky130_fd_pr__cap_mim_m3_1 w=9.81 l=9.81
XDAC_N_FINE_B5_U46_C_UNIT_P0 DAC__FINEN DAC__N_FINE_B5 sky130_fd_pr__cap_mim_m3_1 w=9.81 l=9.81
XDAC_N_FINE_B5_U47_C_UNIT_P0 DAC__FINEN DAC__N_FINE_B5 sky130_fd_pr__cap_mim_m3_1 w=9.81 l=9.81
XDAC_N_FINE_B5_U48_C_UNIT_P0 DAC__FINEN DAC__N_FINE_B5 sky130_fd_pr__cap_mim_m3_1 w=9.81 l=9.81
XDAC_N_FINE_B5_U49_C_UNIT_P0 DAC__FINEN DAC__N_FINE_B5 sky130_fd_pr__cap_mim_m3_1 w=9.81 l=9.81
XDAC_N_FINE_B5_U5_C_UNIT_P0 DAC__FINEN DAC__N_FINE_B5 sky130_fd_pr__cap_mim_m3_1 w=9.81 l=9.81
XDAC_N_FINE_B5_U50_C_UNIT_P0 DAC__FINEN DAC__N_FINE_B5 sky130_fd_pr__cap_mim_m3_1 w=9.81 l=9.81
XDAC_N_FINE_B5_U51_C_UNIT_P0 DAC__FINEN DAC__N_FINE_B5 sky130_fd_pr__cap_mim_m3_1 w=9.81 l=9.81
XDAC_N_FINE_B5_U52_C_UNIT_P0 DAC__FINEN DAC__N_FINE_B5 sky130_fd_pr__cap_mim_m3_1 w=9.81 l=9.81
XDAC_N_FINE_B5_U53_C_UNIT_P0 DAC__FINEN DAC__N_FINE_B5 sky130_fd_pr__cap_mim_m3_1 w=9.81 l=9.81
XDAC_N_FINE_B5_U54_C_UNIT_P0 DAC__FINEN DAC__N_FINE_B5 sky130_fd_pr__cap_mim_m3_1 w=9.81 l=9.81
XDAC_N_FINE_B5_U55_C_UNIT_P0 DAC__FINEN DAC__N_FINE_B5 sky130_fd_pr__cap_mim_m3_1 w=9.81 l=9.81
XDAC_N_FINE_B5_U56_C_UNIT_P0 DAC__FINEN DAC__N_FINE_B5 sky130_fd_pr__cap_mim_m3_1 w=9.81 l=9.81
XDAC_N_FINE_B5_U57_C_UNIT_P0 DAC__FINEN DAC__N_FINE_B5 sky130_fd_pr__cap_mim_m3_1 w=9.81 l=9.81
XDAC_N_FINE_B5_U58_C_UNIT_P0 DAC__FINEN DAC__N_FINE_B5 sky130_fd_pr__cap_mim_m3_1 w=9.81 l=9.81
XDAC_N_FINE_B5_U59_C_UNIT_P0 DAC__FINEN DAC__N_FINE_B5 sky130_fd_pr__cap_mim_m3_1 w=9.81 l=9.81
XDAC_N_FINE_B5_U6_C_UNIT_P0 DAC__FINEN DAC__N_FINE_B5 sky130_fd_pr__cap_mim_m3_1 w=9.81 l=9.81
XDAC_N_FINE_B5_U60_C_UNIT_P0 DAC__FINEN DAC__N_FINE_B5 sky130_fd_pr__cap_mim_m3_1 w=9.81 l=9.81
XDAC_N_FINE_B5_U61_C_UNIT_P0 DAC__FINEN DAC__N_FINE_B5 sky130_fd_pr__cap_mim_m3_1 w=9.81 l=9.81
XDAC_N_FINE_B5_U62_C_UNIT_P0 DAC__FINEN DAC__N_FINE_B5 sky130_fd_pr__cap_mim_m3_1 w=9.81 l=9.81
XDAC_N_FINE_B5_U63_C_UNIT_P0 DAC__FINEN DAC__N_FINE_B5 sky130_fd_pr__cap_mim_m3_1 w=9.81 l=9.81
XDAC_N_FINE_B5_U7_C_UNIT_P0 DAC__FINEN DAC__N_FINE_B5 sky130_fd_pr__cap_mim_m3_1 w=9.81 l=9.81
XDAC_N_FINE_B5_U8_C_UNIT_P0 DAC__FINEN DAC__N_FINE_B5 sky130_fd_pr__cap_mim_m3_1 w=9.81 l=9.81
XDAC_N_FINE_B5_U9_C_UNIT_P0 DAC__FINEN DAC__N_FINE_B5 sky130_fd_pr__cap_mim_m3_1 w=9.81 l=9.81
XDAC_N_FINE_DUMMY_U0_C_UNIT_P0 DAC__FINEN DAC__HIN sky130_fd_pr__cap_mim_m3_1 w=9.81 l=9.81
XDAC_N_FINE_DUMMY_U1_C_UNIT_P0 DAC__FINEN DAC__HIN sky130_fd_pr__cap_mim_m3_1 w=9.81 l=9.81
XDAC_P_COARSE_B0_SW_HIGH_N DAC__HIP B6 DAC__P_COARSE_B0 VGND sky130_fd_pr__nfet_01v8 w=8 l=0.15 nf=1 m=1
XDAC_P_COARSE_B0_SW_HIGH_P DAC__HIP DAC__P_COARSE_B0_SW__BITB DAC__P_COARSE_B0 VPWR sky130_fd_pr__pfet_01v8_hvt w=12 l=0.15 nf=1 m=1
XDAC_P_COARSE_B0_SW_INV_MN DAC__P_COARSE_B0_SW__BITB B6 VGND VGND sky130_fd_pr__nfet_01v8 w=0.65 l=0.15 nf=1 m=1
XDAC_P_COARSE_B0_SW_INV_MP DAC__P_COARSE_B0_SW__BITB B6 VPWR VPWR sky130_fd_pr__pfet_01v8_hvt w=0.65 l=0.15 nf=1 m=1
XDAC_P_COARSE_B0_SW_LOW_N DAC__LOP DAC__P_COARSE_B0_SW__BITB DAC__P_COARSE_B0 VGND sky130_fd_pr__nfet_01v8 w=8 l=0.15 nf=1 m=1
XDAC_P_COARSE_B0_SW_LOW_P DAC__LOP B6 DAC__P_COARSE_B0 VPWR sky130_fd_pr__pfet_01v8_hvt w=12 l=0.15 nf=1 m=1
XDAC_P_COARSE_B0_U0_C_UNIT_P0 TOPP DAC__P_COARSE_B0 sky130_fd_pr__cap_mim_m3_1 w=9.81 l=9.81
XDAC_P_COARSE_B0_U1_C_UNIT_P0 TOPP DAC__P_COARSE_B0 sky130_fd_pr__cap_mim_m3_1 w=9.81 l=9.81
XDAC_P_COARSE_B1_SW_HIGH_N DAC__HIP B7 DAC__P_COARSE_B1 VGND sky130_fd_pr__nfet_01v8 w=8 l=0.15 nf=1 m=1
XDAC_P_COARSE_B1_SW_HIGH_P DAC__HIP DAC__P_COARSE_B1_SW__BITB DAC__P_COARSE_B1 VPWR sky130_fd_pr__pfet_01v8_hvt w=12 l=0.15 nf=1 m=1
XDAC_P_COARSE_B1_SW_INV_MN DAC__P_COARSE_B1_SW__BITB B7 VGND VGND sky130_fd_pr__nfet_01v8 w=0.65 l=0.15 nf=1 m=1
XDAC_P_COARSE_B1_SW_INV_MP DAC__P_COARSE_B1_SW__BITB B7 VPWR VPWR sky130_fd_pr__pfet_01v8_hvt w=0.65 l=0.15 nf=1 m=1
XDAC_P_COARSE_B1_SW_LOW_N DAC__LOP DAC__P_COARSE_B1_SW__BITB DAC__P_COARSE_B1 VGND sky130_fd_pr__nfet_01v8 w=8 l=0.15 nf=1 m=1
XDAC_P_COARSE_B1_SW_LOW_P DAC__LOP B7 DAC__P_COARSE_B1 VPWR sky130_fd_pr__pfet_01v8_hvt w=12 l=0.15 nf=1 m=1
XDAC_P_COARSE_B1_U0_C_UNIT_P0 TOPP DAC__P_COARSE_B1 sky130_fd_pr__cap_mim_m3_1 w=9.81 l=9.81
XDAC_P_COARSE_B1_U1_C_UNIT_P0 TOPP DAC__P_COARSE_B1 sky130_fd_pr__cap_mim_m3_1 w=9.81 l=9.81
XDAC_P_COARSE_B1_U2_C_UNIT_P0 TOPP DAC__P_COARSE_B1 sky130_fd_pr__cap_mim_m3_1 w=9.81 l=9.81
XDAC_P_COARSE_B1_U3_C_UNIT_P0 TOPP DAC__P_COARSE_B1 sky130_fd_pr__cap_mim_m3_1 w=9.81 l=9.81
XDAC_P_COARSE_B2_SW_HIGH_N DAC__HIP B8 DAC__P_COARSE_B2 VGND sky130_fd_pr__nfet_01v8 w=8 l=0.15 nf=1 m=1
XDAC_P_COARSE_B2_SW_HIGH_P DAC__HIP DAC__P_COARSE_B2_SW__BITB DAC__P_COARSE_B2 VPWR sky130_fd_pr__pfet_01v8_hvt w=12 l=0.15 nf=1 m=1
XDAC_P_COARSE_B2_SW_INV_MN DAC__P_COARSE_B2_SW__BITB B8 VGND VGND sky130_fd_pr__nfet_01v8 w=0.65 l=0.15 nf=1 m=1
XDAC_P_COARSE_B2_SW_INV_MP DAC__P_COARSE_B2_SW__BITB B8 VPWR VPWR sky130_fd_pr__pfet_01v8_hvt w=0.65 l=0.15 nf=1 m=1
XDAC_P_COARSE_B2_SW_LOW_N DAC__LOP DAC__P_COARSE_B2_SW__BITB DAC__P_COARSE_B2 VGND sky130_fd_pr__nfet_01v8 w=8 l=0.15 nf=1 m=1
XDAC_P_COARSE_B2_SW_LOW_P DAC__LOP B8 DAC__P_COARSE_B2 VPWR sky130_fd_pr__pfet_01v8_hvt w=12 l=0.15 nf=1 m=1
XDAC_P_COARSE_B2_U0_C_UNIT_P0 TOPP DAC__P_COARSE_B2 sky130_fd_pr__cap_mim_m3_1 w=9.81 l=9.81
XDAC_P_COARSE_B2_U1_C_UNIT_P0 TOPP DAC__P_COARSE_B2 sky130_fd_pr__cap_mim_m3_1 w=9.81 l=9.81
XDAC_P_COARSE_B2_U2_C_UNIT_P0 TOPP DAC__P_COARSE_B2 sky130_fd_pr__cap_mim_m3_1 w=9.81 l=9.81
XDAC_P_COARSE_B2_U3_C_UNIT_P0 TOPP DAC__P_COARSE_B2 sky130_fd_pr__cap_mim_m3_1 w=9.81 l=9.81
XDAC_P_COARSE_B2_U4_C_UNIT_P0 TOPP DAC__P_COARSE_B2 sky130_fd_pr__cap_mim_m3_1 w=9.81 l=9.81
XDAC_P_COARSE_B2_U5_C_UNIT_P0 TOPP DAC__P_COARSE_B2 sky130_fd_pr__cap_mim_m3_1 w=9.81 l=9.81
XDAC_P_COARSE_B2_U6_C_UNIT_P0 TOPP DAC__P_COARSE_B2 sky130_fd_pr__cap_mim_m3_1 w=9.81 l=9.81
XDAC_P_COARSE_B2_U7_C_UNIT_P0 TOPP DAC__P_COARSE_B2 sky130_fd_pr__cap_mim_m3_1 w=9.81 l=9.81
XDAC_P_COARSE_B3_SW_HIGH_N DAC__HIP B9 DAC__P_COARSE_B3 VGND sky130_fd_pr__nfet_01v8 w=8 l=0.15 nf=1 m=1
XDAC_P_COARSE_B3_SW_HIGH_P DAC__HIP DAC__P_COARSE_B3_SW__BITB DAC__P_COARSE_B3 VPWR sky130_fd_pr__pfet_01v8_hvt w=12 l=0.15 nf=1 m=1
XDAC_P_COARSE_B3_SW_INV_MN DAC__P_COARSE_B3_SW__BITB B9 VGND VGND sky130_fd_pr__nfet_01v8 w=0.65 l=0.15 nf=1 m=1
XDAC_P_COARSE_B3_SW_INV_MP DAC__P_COARSE_B3_SW__BITB B9 VPWR VPWR sky130_fd_pr__pfet_01v8_hvt w=0.65 l=0.15 nf=1 m=1
XDAC_P_COARSE_B3_SW_LOW_N DAC__LOP DAC__P_COARSE_B3_SW__BITB DAC__P_COARSE_B3 VGND sky130_fd_pr__nfet_01v8 w=8 l=0.15 nf=1 m=1
XDAC_P_COARSE_B3_SW_LOW_P DAC__LOP B9 DAC__P_COARSE_B3 VPWR sky130_fd_pr__pfet_01v8_hvt w=12 l=0.15 nf=1 m=1
XDAC_P_COARSE_B3_U0_C_UNIT_P0 TOPP DAC__P_COARSE_B3 sky130_fd_pr__cap_mim_m3_1 w=9.81 l=9.81
XDAC_P_COARSE_B3_U1_C_UNIT_P0 TOPP DAC__P_COARSE_B3 sky130_fd_pr__cap_mim_m3_1 w=9.81 l=9.81
XDAC_P_COARSE_B3_U10_C_UNIT_P0 TOPP DAC__P_COARSE_B3 sky130_fd_pr__cap_mim_m3_1 w=9.81 l=9.81
XDAC_P_COARSE_B3_U11_C_UNIT_P0 TOPP DAC__P_COARSE_B3 sky130_fd_pr__cap_mim_m3_1 w=9.81 l=9.81
XDAC_P_COARSE_B3_U12_C_UNIT_P0 TOPP DAC__P_COARSE_B3 sky130_fd_pr__cap_mim_m3_1 w=9.81 l=9.81
XDAC_P_COARSE_B3_U13_C_UNIT_P0 TOPP DAC__P_COARSE_B3 sky130_fd_pr__cap_mim_m3_1 w=9.81 l=9.81
XDAC_P_COARSE_B3_U14_C_UNIT_P0 TOPP DAC__P_COARSE_B3 sky130_fd_pr__cap_mim_m3_1 w=9.81 l=9.81
XDAC_P_COARSE_B3_U15_C_UNIT_P0 TOPP DAC__P_COARSE_B3 sky130_fd_pr__cap_mim_m3_1 w=9.81 l=9.81
XDAC_P_COARSE_B3_U2_C_UNIT_P0 TOPP DAC__P_COARSE_B3 sky130_fd_pr__cap_mim_m3_1 w=9.81 l=9.81
XDAC_P_COARSE_B3_U3_C_UNIT_P0 TOPP DAC__P_COARSE_B3 sky130_fd_pr__cap_mim_m3_1 w=9.81 l=9.81
XDAC_P_COARSE_B3_U4_C_UNIT_P0 TOPP DAC__P_COARSE_B3 sky130_fd_pr__cap_mim_m3_1 w=9.81 l=9.81
XDAC_P_COARSE_B3_U5_C_UNIT_P0 TOPP DAC__P_COARSE_B3 sky130_fd_pr__cap_mim_m3_1 w=9.81 l=9.81
XDAC_P_COARSE_B3_U6_C_UNIT_P0 TOPP DAC__P_COARSE_B3 sky130_fd_pr__cap_mim_m3_1 w=9.81 l=9.81
XDAC_P_COARSE_B3_U7_C_UNIT_P0 TOPP DAC__P_COARSE_B3 sky130_fd_pr__cap_mim_m3_1 w=9.81 l=9.81
XDAC_P_COARSE_B3_U8_C_UNIT_P0 TOPP DAC__P_COARSE_B3 sky130_fd_pr__cap_mim_m3_1 w=9.81 l=9.81
XDAC_P_COARSE_B3_U9_C_UNIT_P0 TOPP DAC__P_COARSE_B3 sky130_fd_pr__cap_mim_m3_1 w=9.81 l=9.81
XDAC_P_COARSE_B4_SW_HIGH_N DAC__HIP B10 DAC__P_COARSE_B4 VGND sky130_fd_pr__nfet_01v8 w=8 l=0.15 nf=1 m=1
XDAC_P_COARSE_B4_SW_HIGH_P DAC__HIP DAC__P_COARSE_B4_SW__BITB DAC__P_COARSE_B4 VPWR sky130_fd_pr__pfet_01v8_hvt w=12 l=0.15 nf=1 m=1
XDAC_P_COARSE_B4_SW_INV_MN DAC__P_COARSE_B4_SW__BITB B10 VGND VGND sky130_fd_pr__nfet_01v8 w=0.65 l=0.15 nf=1 m=1
XDAC_P_COARSE_B4_SW_INV_MP DAC__P_COARSE_B4_SW__BITB B10 VPWR VPWR sky130_fd_pr__pfet_01v8_hvt w=0.65 l=0.15 nf=1 m=1
XDAC_P_COARSE_B4_SW_LOW_N DAC__LOP DAC__P_COARSE_B4_SW__BITB DAC__P_COARSE_B4 VGND sky130_fd_pr__nfet_01v8 w=8 l=0.15 nf=1 m=1
XDAC_P_COARSE_B4_SW_LOW_P DAC__LOP B10 DAC__P_COARSE_B4 VPWR sky130_fd_pr__pfet_01v8_hvt w=12 l=0.15 nf=1 m=1
XDAC_P_COARSE_B4_U0_C_UNIT_P0 TOPP DAC__P_COARSE_B4 sky130_fd_pr__cap_mim_m3_1 w=9.81 l=9.81
XDAC_P_COARSE_B4_U1_C_UNIT_P0 TOPP DAC__P_COARSE_B4 sky130_fd_pr__cap_mim_m3_1 w=9.81 l=9.81
XDAC_P_COARSE_B4_U10_C_UNIT_P0 TOPP DAC__P_COARSE_B4 sky130_fd_pr__cap_mim_m3_1 w=9.81 l=9.81
XDAC_P_COARSE_B4_U11_C_UNIT_P0 TOPP DAC__P_COARSE_B4 sky130_fd_pr__cap_mim_m3_1 w=9.81 l=9.81
XDAC_P_COARSE_B4_U12_C_UNIT_P0 TOPP DAC__P_COARSE_B4 sky130_fd_pr__cap_mim_m3_1 w=9.81 l=9.81
XDAC_P_COARSE_B4_U13_C_UNIT_P0 TOPP DAC__P_COARSE_B4 sky130_fd_pr__cap_mim_m3_1 w=9.81 l=9.81
XDAC_P_COARSE_B4_U14_C_UNIT_P0 TOPP DAC__P_COARSE_B4 sky130_fd_pr__cap_mim_m3_1 w=9.81 l=9.81
XDAC_P_COARSE_B4_U15_C_UNIT_P0 TOPP DAC__P_COARSE_B4 sky130_fd_pr__cap_mim_m3_1 w=9.81 l=9.81
XDAC_P_COARSE_B4_U16_C_UNIT_P0 TOPP DAC__P_COARSE_B4 sky130_fd_pr__cap_mim_m3_1 w=9.81 l=9.81
XDAC_P_COARSE_B4_U17_C_UNIT_P0 TOPP DAC__P_COARSE_B4 sky130_fd_pr__cap_mim_m3_1 w=9.81 l=9.81
XDAC_P_COARSE_B4_U18_C_UNIT_P0 TOPP DAC__P_COARSE_B4 sky130_fd_pr__cap_mim_m3_1 w=9.81 l=9.81
XDAC_P_COARSE_B4_U19_C_UNIT_P0 TOPP DAC__P_COARSE_B4 sky130_fd_pr__cap_mim_m3_1 w=9.81 l=9.81
XDAC_P_COARSE_B4_U2_C_UNIT_P0 TOPP DAC__P_COARSE_B4 sky130_fd_pr__cap_mim_m3_1 w=9.81 l=9.81
XDAC_P_COARSE_B4_U20_C_UNIT_P0 TOPP DAC__P_COARSE_B4 sky130_fd_pr__cap_mim_m3_1 w=9.81 l=9.81
XDAC_P_COARSE_B4_U21_C_UNIT_P0 TOPP DAC__P_COARSE_B4 sky130_fd_pr__cap_mim_m3_1 w=9.81 l=9.81
XDAC_P_COARSE_B4_U22_C_UNIT_P0 TOPP DAC__P_COARSE_B4 sky130_fd_pr__cap_mim_m3_1 w=9.81 l=9.81
XDAC_P_COARSE_B4_U23_C_UNIT_P0 TOPP DAC__P_COARSE_B4 sky130_fd_pr__cap_mim_m3_1 w=9.81 l=9.81
XDAC_P_COARSE_B4_U24_C_UNIT_P0 TOPP DAC__P_COARSE_B4 sky130_fd_pr__cap_mim_m3_1 w=9.81 l=9.81
XDAC_P_COARSE_B4_U25_C_UNIT_P0 TOPP DAC__P_COARSE_B4 sky130_fd_pr__cap_mim_m3_1 w=9.81 l=9.81
XDAC_P_COARSE_B4_U26_C_UNIT_P0 TOPP DAC__P_COARSE_B4 sky130_fd_pr__cap_mim_m3_1 w=9.81 l=9.81
XDAC_P_COARSE_B4_U27_C_UNIT_P0 TOPP DAC__P_COARSE_B4 sky130_fd_pr__cap_mim_m3_1 w=9.81 l=9.81
XDAC_P_COARSE_B4_U28_C_UNIT_P0 TOPP DAC__P_COARSE_B4 sky130_fd_pr__cap_mim_m3_1 w=9.81 l=9.81
XDAC_P_COARSE_B4_U29_C_UNIT_P0 TOPP DAC__P_COARSE_B4 sky130_fd_pr__cap_mim_m3_1 w=9.81 l=9.81
XDAC_P_COARSE_B4_U3_C_UNIT_P0 TOPP DAC__P_COARSE_B4 sky130_fd_pr__cap_mim_m3_1 w=9.81 l=9.81
XDAC_P_COARSE_B4_U30_C_UNIT_P0 TOPP DAC__P_COARSE_B4 sky130_fd_pr__cap_mim_m3_1 w=9.81 l=9.81
XDAC_P_COARSE_B4_U31_C_UNIT_P0 TOPP DAC__P_COARSE_B4 sky130_fd_pr__cap_mim_m3_1 w=9.81 l=9.81
XDAC_P_COARSE_B4_U4_C_UNIT_P0 TOPP DAC__P_COARSE_B4 sky130_fd_pr__cap_mim_m3_1 w=9.81 l=9.81
XDAC_P_COARSE_B4_U5_C_UNIT_P0 TOPP DAC__P_COARSE_B4 sky130_fd_pr__cap_mim_m3_1 w=9.81 l=9.81
XDAC_P_COARSE_B4_U6_C_UNIT_P0 TOPP DAC__P_COARSE_B4 sky130_fd_pr__cap_mim_m3_1 w=9.81 l=9.81
XDAC_P_COARSE_B4_U7_C_UNIT_P0 TOPP DAC__P_COARSE_B4 sky130_fd_pr__cap_mim_m3_1 w=9.81 l=9.81
XDAC_P_COARSE_B4_U8_C_UNIT_P0 TOPP DAC__P_COARSE_B4 sky130_fd_pr__cap_mim_m3_1 w=9.81 l=9.81
XDAC_P_COARSE_B4_U9_C_UNIT_P0 TOPP DAC__P_COARSE_B4 sky130_fd_pr__cap_mim_m3_1 w=9.81 l=9.81
XDAC_P_COARSE_B5_SW_HIGH_N DAC__HIP B11 DAC__P_COARSE_B5 VGND sky130_fd_pr__nfet_01v8 w=8 l=0.15 nf=1 m=1
XDAC_P_COARSE_B5_SW_HIGH_P DAC__HIP DAC__P_COARSE_B5_SW__BITB DAC__P_COARSE_B5 VPWR sky130_fd_pr__pfet_01v8_hvt w=12 l=0.15 nf=1 m=1
XDAC_P_COARSE_B5_SW_INV_MN DAC__P_COARSE_B5_SW__BITB B11 VGND VGND sky130_fd_pr__nfet_01v8 w=0.65 l=0.15 nf=1 m=1
XDAC_P_COARSE_B5_SW_INV_MP DAC__P_COARSE_B5_SW__BITB B11 VPWR VPWR sky130_fd_pr__pfet_01v8_hvt w=0.65 l=0.15 nf=1 m=1
XDAC_P_COARSE_B5_SW_LOW_N DAC__LOP DAC__P_COARSE_B5_SW__BITB DAC__P_COARSE_B5 VGND sky130_fd_pr__nfet_01v8 w=8 l=0.15 nf=1 m=1
XDAC_P_COARSE_B5_SW_LOW_P DAC__LOP B11 DAC__P_COARSE_B5 VPWR sky130_fd_pr__pfet_01v8_hvt w=12 l=0.15 nf=1 m=1
XDAC_P_COARSE_B5_U0_C_UNIT_P0 TOPP DAC__P_COARSE_B5 sky130_fd_pr__cap_mim_m3_1 w=9.81 l=9.81
XDAC_P_COARSE_B5_U1_C_UNIT_P0 TOPP DAC__P_COARSE_B5 sky130_fd_pr__cap_mim_m3_1 w=9.81 l=9.81
XDAC_P_COARSE_B5_U10_C_UNIT_P0 TOPP DAC__P_COARSE_B5 sky130_fd_pr__cap_mim_m3_1 w=9.81 l=9.81
XDAC_P_COARSE_B5_U11_C_UNIT_P0 TOPP DAC__P_COARSE_B5 sky130_fd_pr__cap_mim_m3_1 w=9.81 l=9.81
XDAC_P_COARSE_B5_U12_C_UNIT_P0 TOPP DAC__P_COARSE_B5 sky130_fd_pr__cap_mim_m3_1 w=9.81 l=9.81
XDAC_P_COARSE_B5_U13_C_UNIT_P0 TOPP DAC__P_COARSE_B5 sky130_fd_pr__cap_mim_m3_1 w=9.81 l=9.81
XDAC_P_COARSE_B5_U14_C_UNIT_P0 TOPP DAC__P_COARSE_B5 sky130_fd_pr__cap_mim_m3_1 w=9.81 l=9.81
XDAC_P_COARSE_B5_U15_C_UNIT_P0 TOPP DAC__P_COARSE_B5 sky130_fd_pr__cap_mim_m3_1 w=9.81 l=9.81
XDAC_P_COARSE_B5_U16_C_UNIT_P0 TOPP DAC__P_COARSE_B5 sky130_fd_pr__cap_mim_m3_1 w=9.81 l=9.81
XDAC_P_COARSE_B5_U17_C_UNIT_P0 TOPP DAC__P_COARSE_B5 sky130_fd_pr__cap_mim_m3_1 w=9.81 l=9.81
XDAC_P_COARSE_B5_U18_C_UNIT_P0 TOPP DAC__P_COARSE_B5 sky130_fd_pr__cap_mim_m3_1 w=9.81 l=9.81
XDAC_P_COARSE_B5_U19_C_UNIT_P0 TOPP DAC__P_COARSE_B5 sky130_fd_pr__cap_mim_m3_1 w=9.81 l=9.81
XDAC_P_COARSE_B5_U2_C_UNIT_P0 TOPP DAC__P_COARSE_B5 sky130_fd_pr__cap_mim_m3_1 w=9.81 l=9.81
XDAC_P_COARSE_B5_U20_C_UNIT_P0 TOPP DAC__P_COARSE_B5 sky130_fd_pr__cap_mim_m3_1 w=9.81 l=9.81
XDAC_P_COARSE_B5_U21_C_UNIT_P0 TOPP DAC__P_COARSE_B5 sky130_fd_pr__cap_mim_m3_1 w=9.81 l=9.81
XDAC_P_COARSE_B5_U22_C_UNIT_P0 TOPP DAC__P_COARSE_B5 sky130_fd_pr__cap_mim_m3_1 w=9.81 l=9.81
XDAC_P_COARSE_B5_U23_C_UNIT_P0 TOPP DAC__P_COARSE_B5 sky130_fd_pr__cap_mim_m3_1 w=9.81 l=9.81
XDAC_P_COARSE_B5_U24_C_UNIT_P0 TOPP DAC__P_COARSE_B5 sky130_fd_pr__cap_mim_m3_1 w=9.81 l=9.81
XDAC_P_COARSE_B5_U25_C_UNIT_P0 TOPP DAC__P_COARSE_B5 sky130_fd_pr__cap_mim_m3_1 w=9.81 l=9.81
XDAC_P_COARSE_B5_U26_C_UNIT_P0 TOPP DAC__P_COARSE_B5 sky130_fd_pr__cap_mim_m3_1 w=9.81 l=9.81
XDAC_P_COARSE_B5_U27_C_UNIT_P0 TOPP DAC__P_COARSE_B5 sky130_fd_pr__cap_mim_m3_1 w=9.81 l=9.81
XDAC_P_COARSE_B5_U28_C_UNIT_P0 TOPP DAC__P_COARSE_B5 sky130_fd_pr__cap_mim_m3_1 w=9.81 l=9.81
XDAC_P_COARSE_B5_U29_C_UNIT_P0 TOPP DAC__P_COARSE_B5 sky130_fd_pr__cap_mim_m3_1 w=9.81 l=9.81
XDAC_P_COARSE_B5_U3_C_UNIT_P0 TOPP DAC__P_COARSE_B5 sky130_fd_pr__cap_mim_m3_1 w=9.81 l=9.81
XDAC_P_COARSE_B5_U30_C_UNIT_P0 TOPP DAC__P_COARSE_B5 sky130_fd_pr__cap_mim_m3_1 w=9.81 l=9.81
XDAC_P_COARSE_B5_U31_C_UNIT_P0 TOPP DAC__P_COARSE_B5 sky130_fd_pr__cap_mim_m3_1 w=9.81 l=9.81
XDAC_P_COARSE_B5_U32_C_UNIT_P0 TOPP DAC__P_COARSE_B5 sky130_fd_pr__cap_mim_m3_1 w=9.81 l=9.81
XDAC_P_COARSE_B5_U33_C_UNIT_P0 TOPP DAC__P_COARSE_B5 sky130_fd_pr__cap_mim_m3_1 w=9.81 l=9.81
XDAC_P_COARSE_B5_U34_C_UNIT_P0 TOPP DAC__P_COARSE_B5 sky130_fd_pr__cap_mim_m3_1 w=9.81 l=9.81
XDAC_P_COARSE_B5_U35_C_UNIT_P0 TOPP DAC__P_COARSE_B5 sky130_fd_pr__cap_mim_m3_1 w=9.81 l=9.81
XDAC_P_COARSE_B5_U36_C_UNIT_P0 TOPP DAC__P_COARSE_B5 sky130_fd_pr__cap_mim_m3_1 w=9.81 l=9.81
XDAC_P_COARSE_B5_U37_C_UNIT_P0 TOPP DAC__P_COARSE_B5 sky130_fd_pr__cap_mim_m3_1 w=9.81 l=9.81
XDAC_P_COARSE_B5_U38_C_UNIT_P0 TOPP DAC__P_COARSE_B5 sky130_fd_pr__cap_mim_m3_1 w=9.81 l=9.81
XDAC_P_COARSE_B5_U39_C_UNIT_P0 TOPP DAC__P_COARSE_B5 sky130_fd_pr__cap_mim_m3_1 w=9.81 l=9.81
XDAC_P_COARSE_B5_U4_C_UNIT_P0 TOPP DAC__P_COARSE_B5 sky130_fd_pr__cap_mim_m3_1 w=9.81 l=9.81
XDAC_P_COARSE_B5_U40_C_UNIT_P0 TOPP DAC__P_COARSE_B5 sky130_fd_pr__cap_mim_m3_1 w=9.81 l=9.81
XDAC_P_COARSE_B5_U41_C_UNIT_P0 TOPP DAC__P_COARSE_B5 sky130_fd_pr__cap_mim_m3_1 w=9.81 l=9.81
XDAC_P_COARSE_B5_U42_C_UNIT_P0 TOPP DAC__P_COARSE_B5 sky130_fd_pr__cap_mim_m3_1 w=9.81 l=9.81
XDAC_P_COARSE_B5_U43_C_UNIT_P0 TOPP DAC__P_COARSE_B5 sky130_fd_pr__cap_mim_m3_1 w=9.81 l=9.81
XDAC_P_COARSE_B5_U44_C_UNIT_P0 TOPP DAC__P_COARSE_B5 sky130_fd_pr__cap_mim_m3_1 w=9.81 l=9.81
XDAC_P_COARSE_B5_U45_C_UNIT_P0 TOPP DAC__P_COARSE_B5 sky130_fd_pr__cap_mim_m3_1 w=9.81 l=9.81
XDAC_P_COARSE_B5_U46_C_UNIT_P0 TOPP DAC__P_COARSE_B5 sky130_fd_pr__cap_mim_m3_1 w=9.81 l=9.81
XDAC_P_COARSE_B5_U47_C_UNIT_P0 TOPP DAC__P_COARSE_B5 sky130_fd_pr__cap_mim_m3_1 w=9.81 l=9.81
XDAC_P_COARSE_B5_U48_C_UNIT_P0 TOPP DAC__P_COARSE_B5 sky130_fd_pr__cap_mim_m3_1 w=9.81 l=9.81
XDAC_P_COARSE_B5_U49_C_UNIT_P0 TOPP DAC__P_COARSE_B5 sky130_fd_pr__cap_mim_m3_1 w=9.81 l=9.81
XDAC_P_COARSE_B5_U5_C_UNIT_P0 TOPP DAC__P_COARSE_B5 sky130_fd_pr__cap_mim_m3_1 w=9.81 l=9.81
XDAC_P_COARSE_B5_U50_C_UNIT_P0 TOPP DAC__P_COARSE_B5 sky130_fd_pr__cap_mim_m3_1 w=9.81 l=9.81
XDAC_P_COARSE_B5_U51_C_UNIT_P0 TOPP DAC__P_COARSE_B5 sky130_fd_pr__cap_mim_m3_1 w=9.81 l=9.81
XDAC_P_COARSE_B5_U52_C_UNIT_P0 TOPP DAC__P_COARSE_B5 sky130_fd_pr__cap_mim_m3_1 w=9.81 l=9.81
XDAC_P_COARSE_B5_U53_C_UNIT_P0 TOPP DAC__P_COARSE_B5 sky130_fd_pr__cap_mim_m3_1 w=9.81 l=9.81
XDAC_P_COARSE_B5_U54_C_UNIT_P0 TOPP DAC__P_COARSE_B5 sky130_fd_pr__cap_mim_m3_1 w=9.81 l=9.81
XDAC_P_COARSE_B5_U55_C_UNIT_P0 TOPP DAC__P_COARSE_B5 sky130_fd_pr__cap_mim_m3_1 w=9.81 l=9.81
XDAC_P_COARSE_B5_U56_C_UNIT_P0 TOPP DAC__P_COARSE_B5 sky130_fd_pr__cap_mim_m3_1 w=9.81 l=9.81
XDAC_P_COARSE_B5_U57_C_UNIT_P0 TOPP DAC__P_COARSE_B5 sky130_fd_pr__cap_mim_m3_1 w=9.81 l=9.81
XDAC_P_COARSE_B5_U58_C_UNIT_P0 TOPP DAC__P_COARSE_B5 sky130_fd_pr__cap_mim_m3_1 w=9.81 l=9.81
XDAC_P_COARSE_B5_U59_C_UNIT_P0 TOPP DAC__P_COARSE_B5 sky130_fd_pr__cap_mim_m3_1 w=9.81 l=9.81
XDAC_P_COARSE_B5_U6_C_UNIT_P0 TOPP DAC__P_COARSE_B5 sky130_fd_pr__cap_mim_m3_1 w=9.81 l=9.81
XDAC_P_COARSE_B5_U60_C_UNIT_P0 TOPP DAC__P_COARSE_B5 sky130_fd_pr__cap_mim_m3_1 w=9.81 l=9.81
XDAC_P_COARSE_B5_U61_C_UNIT_P0 TOPP DAC__P_COARSE_B5 sky130_fd_pr__cap_mim_m3_1 w=9.81 l=9.81
XDAC_P_COARSE_B5_U62_C_UNIT_P0 TOPP DAC__P_COARSE_B5 sky130_fd_pr__cap_mim_m3_1 w=9.81 l=9.81
XDAC_P_COARSE_B5_U63_C_UNIT_P0 TOPP DAC__P_COARSE_B5 sky130_fd_pr__cap_mim_m3_1 w=9.81 l=9.81
XDAC_P_COARSE_B5_U7_C_UNIT_P0 TOPP DAC__P_COARSE_B5 sky130_fd_pr__cap_mim_m3_1 w=9.81 l=9.81
XDAC_P_COARSE_B5_U8_C_UNIT_P0 TOPP DAC__P_COARSE_B5 sky130_fd_pr__cap_mim_m3_1 w=9.81 l=9.81
XDAC_P_COARSE_B5_U9_C_UNIT_P0 TOPP DAC__P_COARSE_B5 sky130_fd_pr__cap_mim_m3_1 w=9.81 l=9.81
XDAC_P_FINE_B0_SW_HIGH_N DAC__HIP B0 DAC__P_FINE_B0 VGND sky130_fd_pr__nfet_01v8 w=8 l=0.15 nf=1 m=1
XDAC_P_FINE_B0_SW_HIGH_P DAC__HIP DAC__P_FINE_B0_SW__BITB DAC__P_FINE_B0 VPWR sky130_fd_pr__pfet_01v8_hvt w=12 l=0.15 nf=1 m=1
XDAC_P_FINE_B0_SW_INV_MN DAC__P_FINE_B0_SW__BITB B0 VGND VGND sky130_fd_pr__nfet_01v8 w=0.65 l=0.15 nf=1 m=1
XDAC_P_FINE_B0_SW_INV_MP DAC__P_FINE_B0_SW__BITB B0 VPWR VPWR sky130_fd_pr__pfet_01v8_hvt w=0.65 l=0.15 nf=1 m=1
XDAC_P_FINE_B0_SW_LOW_N DAC__LOP DAC__P_FINE_B0_SW__BITB DAC__P_FINE_B0 VGND sky130_fd_pr__nfet_01v8 w=8 l=0.15 nf=1 m=1
XDAC_P_FINE_B0_SW_LOW_P DAC__LOP B0 DAC__P_FINE_B0 VPWR sky130_fd_pr__pfet_01v8_hvt w=12 l=0.15 nf=1 m=1
XDAC_P_FINE_B0_U0_C_UNIT_P0 DAC__FINEP DAC__P_FINE_B0 sky130_fd_pr__cap_mim_m3_1 w=9.81 l=9.81
XDAC_P_FINE_B0_U1_C_UNIT_P0 DAC__FINEP DAC__P_FINE_B0 sky130_fd_pr__cap_mim_m3_1 w=9.81 l=9.81
XDAC_P_FINE_B1_SW_HIGH_N DAC__HIP B1 DAC__P_FINE_B1 VGND sky130_fd_pr__nfet_01v8 w=8 l=0.15 nf=1 m=1
XDAC_P_FINE_B1_SW_HIGH_P DAC__HIP DAC__P_FINE_B1_SW__BITB DAC__P_FINE_B1 VPWR sky130_fd_pr__pfet_01v8_hvt w=12 l=0.15 nf=1 m=1
XDAC_P_FINE_B1_SW_INV_MN DAC__P_FINE_B1_SW__BITB B1 VGND VGND sky130_fd_pr__nfet_01v8 w=0.65 l=0.15 nf=1 m=1
XDAC_P_FINE_B1_SW_INV_MP DAC__P_FINE_B1_SW__BITB B1 VPWR VPWR sky130_fd_pr__pfet_01v8_hvt w=0.65 l=0.15 nf=1 m=1
XDAC_P_FINE_B1_SW_LOW_N DAC__LOP DAC__P_FINE_B1_SW__BITB DAC__P_FINE_B1 VGND sky130_fd_pr__nfet_01v8 w=8 l=0.15 nf=1 m=1
XDAC_P_FINE_B1_SW_LOW_P DAC__LOP B1 DAC__P_FINE_B1 VPWR sky130_fd_pr__pfet_01v8_hvt w=12 l=0.15 nf=1 m=1
XDAC_P_FINE_B1_U0_C_UNIT_P0 DAC__FINEP DAC__P_FINE_B1 sky130_fd_pr__cap_mim_m3_1 w=9.81 l=9.81
XDAC_P_FINE_B1_U1_C_UNIT_P0 DAC__FINEP DAC__P_FINE_B1 sky130_fd_pr__cap_mim_m3_1 w=9.81 l=9.81
XDAC_P_FINE_B1_U2_C_UNIT_P0 DAC__FINEP DAC__P_FINE_B1 sky130_fd_pr__cap_mim_m3_1 w=9.81 l=9.81
XDAC_P_FINE_B1_U3_C_UNIT_P0 DAC__FINEP DAC__P_FINE_B1 sky130_fd_pr__cap_mim_m3_1 w=9.81 l=9.81
XDAC_P_FINE_B2_SW_HIGH_N DAC__HIP B2 DAC__P_FINE_B2 VGND sky130_fd_pr__nfet_01v8 w=8 l=0.15 nf=1 m=1
XDAC_P_FINE_B2_SW_HIGH_P DAC__HIP DAC__P_FINE_B2_SW__BITB DAC__P_FINE_B2 VPWR sky130_fd_pr__pfet_01v8_hvt w=12 l=0.15 nf=1 m=1
XDAC_P_FINE_B2_SW_INV_MN DAC__P_FINE_B2_SW__BITB B2 VGND VGND sky130_fd_pr__nfet_01v8 w=0.65 l=0.15 nf=1 m=1
XDAC_P_FINE_B2_SW_INV_MP DAC__P_FINE_B2_SW__BITB B2 VPWR VPWR sky130_fd_pr__pfet_01v8_hvt w=0.65 l=0.15 nf=1 m=1
XDAC_P_FINE_B2_SW_LOW_N DAC__LOP DAC__P_FINE_B2_SW__BITB DAC__P_FINE_B2 VGND sky130_fd_pr__nfet_01v8 w=8 l=0.15 nf=1 m=1
XDAC_P_FINE_B2_SW_LOW_P DAC__LOP B2 DAC__P_FINE_B2 VPWR sky130_fd_pr__pfet_01v8_hvt w=12 l=0.15 nf=1 m=1
XDAC_P_FINE_B2_U0_C_UNIT_P0 DAC__FINEP DAC__P_FINE_B2 sky130_fd_pr__cap_mim_m3_1 w=9.81 l=9.81
XDAC_P_FINE_B2_U1_C_UNIT_P0 DAC__FINEP DAC__P_FINE_B2 sky130_fd_pr__cap_mim_m3_1 w=9.81 l=9.81
XDAC_P_FINE_B2_U2_C_UNIT_P0 DAC__FINEP DAC__P_FINE_B2 sky130_fd_pr__cap_mim_m3_1 w=9.81 l=9.81
XDAC_P_FINE_B2_U3_C_UNIT_P0 DAC__FINEP DAC__P_FINE_B2 sky130_fd_pr__cap_mim_m3_1 w=9.81 l=9.81
XDAC_P_FINE_B2_U4_C_UNIT_P0 DAC__FINEP DAC__P_FINE_B2 sky130_fd_pr__cap_mim_m3_1 w=9.81 l=9.81
XDAC_P_FINE_B2_U5_C_UNIT_P0 DAC__FINEP DAC__P_FINE_B2 sky130_fd_pr__cap_mim_m3_1 w=9.81 l=9.81
XDAC_P_FINE_B2_U6_C_UNIT_P0 DAC__FINEP DAC__P_FINE_B2 sky130_fd_pr__cap_mim_m3_1 w=9.81 l=9.81
XDAC_P_FINE_B2_U7_C_UNIT_P0 DAC__FINEP DAC__P_FINE_B2 sky130_fd_pr__cap_mim_m3_1 w=9.81 l=9.81
XDAC_P_FINE_B3_SW_HIGH_N DAC__HIP B3 DAC__P_FINE_B3 VGND sky130_fd_pr__nfet_01v8 w=8 l=0.15 nf=1 m=1
XDAC_P_FINE_B3_SW_HIGH_P DAC__HIP DAC__P_FINE_B3_SW__BITB DAC__P_FINE_B3 VPWR sky130_fd_pr__pfet_01v8_hvt w=12 l=0.15 nf=1 m=1
XDAC_P_FINE_B3_SW_INV_MN DAC__P_FINE_B3_SW__BITB B3 VGND VGND sky130_fd_pr__nfet_01v8 w=0.65 l=0.15 nf=1 m=1
XDAC_P_FINE_B3_SW_INV_MP DAC__P_FINE_B3_SW__BITB B3 VPWR VPWR sky130_fd_pr__pfet_01v8_hvt w=0.65 l=0.15 nf=1 m=1
XDAC_P_FINE_B3_SW_LOW_N DAC__LOP DAC__P_FINE_B3_SW__BITB DAC__P_FINE_B3 VGND sky130_fd_pr__nfet_01v8 w=8 l=0.15 nf=1 m=1
XDAC_P_FINE_B3_SW_LOW_P DAC__LOP B3 DAC__P_FINE_B3 VPWR sky130_fd_pr__pfet_01v8_hvt w=12 l=0.15 nf=1 m=1
XDAC_P_FINE_B3_U0_C_UNIT_P0 DAC__FINEP DAC__P_FINE_B3 sky130_fd_pr__cap_mim_m3_1 w=9.81 l=9.81
XDAC_P_FINE_B3_U1_C_UNIT_P0 DAC__FINEP DAC__P_FINE_B3 sky130_fd_pr__cap_mim_m3_1 w=9.81 l=9.81
XDAC_P_FINE_B3_U10_C_UNIT_P0 DAC__FINEP DAC__P_FINE_B3 sky130_fd_pr__cap_mim_m3_1 w=9.81 l=9.81
XDAC_P_FINE_B3_U11_C_UNIT_P0 DAC__FINEP DAC__P_FINE_B3 sky130_fd_pr__cap_mim_m3_1 w=9.81 l=9.81
XDAC_P_FINE_B3_U12_C_UNIT_P0 DAC__FINEP DAC__P_FINE_B3 sky130_fd_pr__cap_mim_m3_1 w=9.81 l=9.81
XDAC_P_FINE_B3_U13_C_UNIT_P0 DAC__FINEP DAC__P_FINE_B3 sky130_fd_pr__cap_mim_m3_1 w=9.81 l=9.81
XDAC_P_FINE_B3_U14_C_UNIT_P0 DAC__FINEP DAC__P_FINE_B3 sky130_fd_pr__cap_mim_m3_1 w=9.81 l=9.81
XDAC_P_FINE_B3_U15_C_UNIT_P0 DAC__FINEP DAC__P_FINE_B3 sky130_fd_pr__cap_mim_m3_1 w=9.81 l=9.81
XDAC_P_FINE_B3_U2_C_UNIT_P0 DAC__FINEP DAC__P_FINE_B3 sky130_fd_pr__cap_mim_m3_1 w=9.81 l=9.81
XDAC_P_FINE_B3_U3_C_UNIT_P0 DAC__FINEP DAC__P_FINE_B3 sky130_fd_pr__cap_mim_m3_1 w=9.81 l=9.81
XDAC_P_FINE_B3_U4_C_UNIT_P0 DAC__FINEP DAC__P_FINE_B3 sky130_fd_pr__cap_mim_m3_1 w=9.81 l=9.81
XDAC_P_FINE_B3_U5_C_UNIT_P0 DAC__FINEP DAC__P_FINE_B3 sky130_fd_pr__cap_mim_m3_1 w=9.81 l=9.81
XDAC_P_FINE_B3_U6_C_UNIT_P0 DAC__FINEP DAC__P_FINE_B3 sky130_fd_pr__cap_mim_m3_1 w=9.81 l=9.81
XDAC_P_FINE_B3_U7_C_UNIT_P0 DAC__FINEP DAC__P_FINE_B3 sky130_fd_pr__cap_mim_m3_1 w=9.81 l=9.81
XDAC_P_FINE_B3_U8_C_UNIT_P0 DAC__FINEP DAC__P_FINE_B3 sky130_fd_pr__cap_mim_m3_1 w=9.81 l=9.81
XDAC_P_FINE_B3_U9_C_UNIT_P0 DAC__FINEP DAC__P_FINE_B3 sky130_fd_pr__cap_mim_m3_1 w=9.81 l=9.81
XDAC_P_FINE_B4_SW_HIGH_N DAC__HIP B4 DAC__P_FINE_B4 VGND sky130_fd_pr__nfet_01v8 w=8 l=0.15 nf=1 m=1
XDAC_P_FINE_B4_SW_HIGH_P DAC__HIP DAC__P_FINE_B4_SW__BITB DAC__P_FINE_B4 VPWR sky130_fd_pr__pfet_01v8_hvt w=12 l=0.15 nf=1 m=1
XDAC_P_FINE_B4_SW_INV_MN DAC__P_FINE_B4_SW__BITB B4 VGND VGND sky130_fd_pr__nfet_01v8 w=0.65 l=0.15 nf=1 m=1
XDAC_P_FINE_B4_SW_INV_MP DAC__P_FINE_B4_SW__BITB B4 VPWR VPWR sky130_fd_pr__pfet_01v8_hvt w=0.65 l=0.15 nf=1 m=1
XDAC_P_FINE_B4_SW_LOW_N DAC__LOP DAC__P_FINE_B4_SW__BITB DAC__P_FINE_B4 VGND sky130_fd_pr__nfet_01v8 w=8 l=0.15 nf=1 m=1
XDAC_P_FINE_B4_SW_LOW_P DAC__LOP B4 DAC__P_FINE_B4 VPWR sky130_fd_pr__pfet_01v8_hvt w=12 l=0.15 nf=1 m=1
XDAC_P_FINE_B4_U0_C_UNIT_P0 DAC__FINEP DAC__P_FINE_B4 sky130_fd_pr__cap_mim_m3_1 w=9.81 l=9.81
XDAC_P_FINE_B4_U1_C_UNIT_P0 DAC__FINEP DAC__P_FINE_B4 sky130_fd_pr__cap_mim_m3_1 w=9.81 l=9.81
XDAC_P_FINE_B4_U10_C_UNIT_P0 DAC__FINEP DAC__P_FINE_B4 sky130_fd_pr__cap_mim_m3_1 w=9.81 l=9.81
XDAC_P_FINE_B4_U11_C_UNIT_P0 DAC__FINEP DAC__P_FINE_B4 sky130_fd_pr__cap_mim_m3_1 w=9.81 l=9.81
XDAC_P_FINE_B4_U12_C_UNIT_P0 DAC__FINEP DAC__P_FINE_B4 sky130_fd_pr__cap_mim_m3_1 w=9.81 l=9.81
XDAC_P_FINE_B4_U13_C_UNIT_P0 DAC__FINEP DAC__P_FINE_B4 sky130_fd_pr__cap_mim_m3_1 w=9.81 l=9.81
XDAC_P_FINE_B4_U14_C_UNIT_P0 DAC__FINEP DAC__P_FINE_B4 sky130_fd_pr__cap_mim_m3_1 w=9.81 l=9.81
XDAC_P_FINE_B4_U15_C_UNIT_P0 DAC__FINEP DAC__P_FINE_B4 sky130_fd_pr__cap_mim_m3_1 w=9.81 l=9.81
XDAC_P_FINE_B4_U16_C_UNIT_P0 DAC__FINEP DAC__P_FINE_B4 sky130_fd_pr__cap_mim_m3_1 w=9.81 l=9.81
XDAC_P_FINE_B4_U17_C_UNIT_P0 DAC__FINEP DAC__P_FINE_B4 sky130_fd_pr__cap_mim_m3_1 w=9.81 l=9.81
XDAC_P_FINE_B4_U18_C_UNIT_P0 DAC__FINEP DAC__P_FINE_B4 sky130_fd_pr__cap_mim_m3_1 w=9.81 l=9.81
XDAC_P_FINE_B4_U19_C_UNIT_P0 DAC__FINEP DAC__P_FINE_B4 sky130_fd_pr__cap_mim_m3_1 w=9.81 l=9.81
XDAC_P_FINE_B4_U2_C_UNIT_P0 DAC__FINEP DAC__P_FINE_B4 sky130_fd_pr__cap_mim_m3_1 w=9.81 l=9.81
XDAC_P_FINE_B4_U20_C_UNIT_P0 DAC__FINEP DAC__P_FINE_B4 sky130_fd_pr__cap_mim_m3_1 w=9.81 l=9.81
XDAC_P_FINE_B4_U21_C_UNIT_P0 DAC__FINEP DAC__P_FINE_B4 sky130_fd_pr__cap_mim_m3_1 w=9.81 l=9.81
XDAC_P_FINE_B4_U22_C_UNIT_P0 DAC__FINEP DAC__P_FINE_B4 sky130_fd_pr__cap_mim_m3_1 w=9.81 l=9.81
XDAC_P_FINE_B4_U23_C_UNIT_P0 DAC__FINEP DAC__P_FINE_B4 sky130_fd_pr__cap_mim_m3_1 w=9.81 l=9.81
XDAC_P_FINE_B4_U24_C_UNIT_P0 DAC__FINEP DAC__P_FINE_B4 sky130_fd_pr__cap_mim_m3_1 w=9.81 l=9.81
XDAC_P_FINE_B4_U25_C_UNIT_P0 DAC__FINEP DAC__P_FINE_B4 sky130_fd_pr__cap_mim_m3_1 w=9.81 l=9.81
XDAC_P_FINE_B4_U26_C_UNIT_P0 DAC__FINEP DAC__P_FINE_B4 sky130_fd_pr__cap_mim_m3_1 w=9.81 l=9.81
XDAC_P_FINE_B4_U27_C_UNIT_P0 DAC__FINEP DAC__P_FINE_B4 sky130_fd_pr__cap_mim_m3_1 w=9.81 l=9.81
XDAC_P_FINE_B4_U28_C_UNIT_P0 DAC__FINEP DAC__P_FINE_B4 sky130_fd_pr__cap_mim_m3_1 w=9.81 l=9.81
XDAC_P_FINE_B4_U29_C_UNIT_P0 DAC__FINEP DAC__P_FINE_B4 sky130_fd_pr__cap_mim_m3_1 w=9.81 l=9.81
XDAC_P_FINE_B4_U3_C_UNIT_P0 DAC__FINEP DAC__P_FINE_B4 sky130_fd_pr__cap_mim_m3_1 w=9.81 l=9.81
XDAC_P_FINE_B4_U30_C_UNIT_P0 DAC__FINEP DAC__P_FINE_B4 sky130_fd_pr__cap_mim_m3_1 w=9.81 l=9.81
XDAC_P_FINE_B4_U31_C_UNIT_P0 DAC__FINEP DAC__P_FINE_B4 sky130_fd_pr__cap_mim_m3_1 w=9.81 l=9.81
XDAC_P_FINE_B4_U4_C_UNIT_P0 DAC__FINEP DAC__P_FINE_B4 sky130_fd_pr__cap_mim_m3_1 w=9.81 l=9.81
XDAC_P_FINE_B4_U5_C_UNIT_P0 DAC__FINEP DAC__P_FINE_B4 sky130_fd_pr__cap_mim_m3_1 w=9.81 l=9.81
XDAC_P_FINE_B4_U6_C_UNIT_P0 DAC__FINEP DAC__P_FINE_B4 sky130_fd_pr__cap_mim_m3_1 w=9.81 l=9.81
XDAC_P_FINE_B4_U7_C_UNIT_P0 DAC__FINEP DAC__P_FINE_B4 sky130_fd_pr__cap_mim_m3_1 w=9.81 l=9.81
XDAC_P_FINE_B4_U8_C_UNIT_P0 DAC__FINEP DAC__P_FINE_B4 sky130_fd_pr__cap_mim_m3_1 w=9.81 l=9.81
XDAC_P_FINE_B4_U9_C_UNIT_P0 DAC__FINEP DAC__P_FINE_B4 sky130_fd_pr__cap_mim_m3_1 w=9.81 l=9.81
XDAC_P_FINE_B5_SW_HIGH_N DAC__HIP B5 DAC__P_FINE_B5 VGND sky130_fd_pr__nfet_01v8 w=8 l=0.15 nf=1 m=1
XDAC_P_FINE_B5_SW_HIGH_P DAC__HIP DAC__P_FINE_B5_SW__BITB DAC__P_FINE_B5 VPWR sky130_fd_pr__pfet_01v8_hvt w=12 l=0.15 nf=1 m=1
XDAC_P_FINE_B5_SW_INV_MN DAC__P_FINE_B5_SW__BITB B5 VGND VGND sky130_fd_pr__nfet_01v8 w=0.65 l=0.15 nf=1 m=1
XDAC_P_FINE_B5_SW_INV_MP DAC__P_FINE_B5_SW__BITB B5 VPWR VPWR sky130_fd_pr__pfet_01v8_hvt w=0.65 l=0.15 nf=1 m=1
XDAC_P_FINE_B5_SW_LOW_N DAC__LOP DAC__P_FINE_B5_SW__BITB DAC__P_FINE_B5 VGND sky130_fd_pr__nfet_01v8 w=8 l=0.15 nf=1 m=1
XDAC_P_FINE_B5_SW_LOW_P DAC__LOP B5 DAC__P_FINE_B5 VPWR sky130_fd_pr__pfet_01v8_hvt w=12 l=0.15 nf=1 m=1
XDAC_P_FINE_B5_U0_C_UNIT_P0 DAC__FINEP DAC__P_FINE_B5 sky130_fd_pr__cap_mim_m3_1 w=9.81 l=9.81
XDAC_P_FINE_B5_U1_C_UNIT_P0 DAC__FINEP DAC__P_FINE_B5 sky130_fd_pr__cap_mim_m3_1 w=9.81 l=9.81
XDAC_P_FINE_B5_U10_C_UNIT_P0 DAC__FINEP DAC__P_FINE_B5 sky130_fd_pr__cap_mim_m3_1 w=9.81 l=9.81
XDAC_P_FINE_B5_U11_C_UNIT_P0 DAC__FINEP DAC__P_FINE_B5 sky130_fd_pr__cap_mim_m3_1 w=9.81 l=9.81
XDAC_P_FINE_B5_U12_C_UNIT_P0 DAC__FINEP DAC__P_FINE_B5 sky130_fd_pr__cap_mim_m3_1 w=9.81 l=9.81
XDAC_P_FINE_B5_U13_C_UNIT_P0 DAC__FINEP DAC__P_FINE_B5 sky130_fd_pr__cap_mim_m3_1 w=9.81 l=9.81
XDAC_P_FINE_B5_U14_C_UNIT_P0 DAC__FINEP DAC__P_FINE_B5 sky130_fd_pr__cap_mim_m3_1 w=9.81 l=9.81
XDAC_P_FINE_B5_U15_C_UNIT_P0 DAC__FINEP DAC__P_FINE_B5 sky130_fd_pr__cap_mim_m3_1 w=9.81 l=9.81
XDAC_P_FINE_B5_U16_C_UNIT_P0 DAC__FINEP DAC__P_FINE_B5 sky130_fd_pr__cap_mim_m3_1 w=9.81 l=9.81
XDAC_P_FINE_B5_U17_C_UNIT_P0 DAC__FINEP DAC__P_FINE_B5 sky130_fd_pr__cap_mim_m3_1 w=9.81 l=9.81
XDAC_P_FINE_B5_U18_C_UNIT_P0 DAC__FINEP DAC__P_FINE_B5 sky130_fd_pr__cap_mim_m3_1 w=9.81 l=9.81
XDAC_P_FINE_B5_U19_C_UNIT_P0 DAC__FINEP DAC__P_FINE_B5 sky130_fd_pr__cap_mim_m3_1 w=9.81 l=9.81
XDAC_P_FINE_B5_U2_C_UNIT_P0 DAC__FINEP DAC__P_FINE_B5 sky130_fd_pr__cap_mim_m3_1 w=9.81 l=9.81
XDAC_P_FINE_B5_U20_C_UNIT_P0 DAC__FINEP DAC__P_FINE_B5 sky130_fd_pr__cap_mim_m3_1 w=9.81 l=9.81
XDAC_P_FINE_B5_U21_C_UNIT_P0 DAC__FINEP DAC__P_FINE_B5 sky130_fd_pr__cap_mim_m3_1 w=9.81 l=9.81
XDAC_P_FINE_B5_U22_C_UNIT_P0 DAC__FINEP DAC__P_FINE_B5 sky130_fd_pr__cap_mim_m3_1 w=9.81 l=9.81
XDAC_P_FINE_B5_U23_C_UNIT_P0 DAC__FINEP DAC__P_FINE_B5 sky130_fd_pr__cap_mim_m3_1 w=9.81 l=9.81
XDAC_P_FINE_B5_U24_C_UNIT_P0 DAC__FINEP DAC__P_FINE_B5 sky130_fd_pr__cap_mim_m3_1 w=9.81 l=9.81
XDAC_P_FINE_B5_U25_C_UNIT_P0 DAC__FINEP DAC__P_FINE_B5 sky130_fd_pr__cap_mim_m3_1 w=9.81 l=9.81
XDAC_P_FINE_B5_U26_C_UNIT_P0 DAC__FINEP DAC__P_FINE_B5 sky130_fd_pr__cap_mim_m3_1 w=9.81 l=9.81
XDAC_P_FINE_B5_U27_C_UNIT_P0 DAC__FINEP DAC__P_FINE_B5 sky130_fd_pr__cap_mim_m3_1 w=9.81 l=9.81
XDAC_P_FINE_B5_U28_C_UNIT_P0 DAC__FINEP DAC__P_FINE_B5 sky130_fd_pr__cap_mim_m3_1 w=9.81 l=9.81
XDAC_P_FINE_B5_U29_C_UNIT_P0 DAC__FINEP DAC__P_FINE_B5 sky130_fd_pr__cap_mim_m3_1 w=9.81 l=9.81
XDAC_P_FINE_B5_U3_C_UNIT_P0 DAC__FINEP DAC__P_FINE_B5 sky130_fd_pr__cap_mim_m3_1 w=9.81 l=9.81
XDAC_P_FINE_B5_U30_C_UNIT_P0 DAC__FINEP DAC__P_FINE_B5 sky130_fd_pr__cap_mim_m3_1 w=9.81 l=9.81
XDAC_P_FINE_B5_U31_C_UNIT_P0 DAC__FINEP DAC__P_FINE_B5 sky130_fd_pr__cap_mim_m3_1 w=9.81 l=9.81
XDAC_P_FINE_B5_U32_C_UNIT_P0 DAC__FINEP DAC__P_FINE_B5 sky130_fd_pr__cap_mim_m3_1 w=9.81 l=9.81
XDAC_P_FINE_B5_U33_C_UNIT_P0 DAC__FINEP DAC__P_FINE_B5 sky130_fd_pr__cap_mim_m3_1 w=9.81 l=9.81
XDAC_P_FINE_B5_U34_C_UNIT_P0 DAC__FINEP DAC__P_FINE_B5 sky130_fd_pr__cap_mim_m3_1 w=9.81 l=9.81
XDAC_P_FINE_B5_U35_C_UNIT_P0 DAC__FINEP DAC__P_FINE_B5 sky130_fd_pr__cap_mim_m3_1 w=9.81 l=9.81
XDAC_P_FINE_B5_U36_C_UNIT_P0 DAC__FINEP DAC__P_FINE_B5 sky130_fd_pr__cap_mim_m3_1 w=9.81 l=9.81
XDAC_P_FINE_B5_U37_C_UNIT_P0 DAC__FINEP DAC__P_FINE_B5 sky130_fd_pr__cap_mim_m3_1 w=9.81 l=9.81
XDAC_P_FINE_B5_U38_C_UNIT_P0 DAC__FINEP DAC__P_FINE_B5 sky130_fd_pr__cap_mim_m3_1 w=9.81 l=9.81
XDAC_P_FINE_B5_U39_C_UNIT_P0 DAC__FINEP DAC__P_FINE_B5 sky130_fd_pr__cap_mim_m3_1 w=9.81 l=9.81
XDAC_P_FINE_B5_U4_C_UNIT_P0 DAC__FINEP DAC__P_FINE_B5 sky130_fd_pr__cap_mim_m3_1 w=9.81 l=9.81
XDAC_P_FINE_B5_U40_C_UNIT_P0 DAC__FINEP DAC__P_FINE_B5 sky130_fd_pr__cap_mim_m3_1 w=9.81 l=9.81
XDAC_P_FINE_B5_U41_C_UNIT_P0 DAC__FINEP DAC__P_FINE_B5 sky130_fd_pr__cap_mim_m3_1 w=9.81 l=9.81
XDAC_P_FINE_B5_U42_C_UNIT_P0 DAC__FINEP DAC__P_FINE_B5 sky130_fd_pr__cap_mim_m3_1 w=9.81 l=9.81
XDAC_P_FINE_B5_U43_C_UNIT_P0 DAC__FINEP DAC__P_FINE_B5 sky130_fd_pr__cap_mim_m3_1 w=9.81 l=9.81
XDAC_P_FINE_B5_U44_C_UNIT_P0 DAC__FINEP DAC__P_FINE_B5 sky130_fd_pr__cap_mim_m3_1 w=9.81 l=9.81
XDAC_P_FINE_B5_U45_C_UNIT_P0 DAC__FINEP DAC__P_FINE_B5 sky130_fd_pr__cap_mim_m3_1 w=9.81 l=9.81
XDAC_P_FINE_B5_U46_C_UNIT_P0 DAC__FINEP DAC__P_FINE_B5 sky130_fd_pr__cap_mim_m3_1 w=9.81 l=9.81
XDAC_P_FINE_B5_U47_C_UNIT_P0 DAC__FINEP DAC__P_FINE_B5 sky130_fd_pr__cap_mim_m3_1 w=9.81 l=9.81
XDAC_P_FINE_B5_U48_C_UNIT_P0 DAC__FINEP DAC__P_FINE_B5 sky130_fd_pr__cap_mim_m3_1 w=9.81 l=9.81
XDAC_P_FINE_B5_U49_C_UNIT_P0 DAC__FINEP DAC__P_FINE_B5 sky130_fd_pr__cap_mim_m3_1 w=9.81 l=9.81
XDAC_P_FINE_B5_U5_C_UNIT_P0 DAC__FINEP DAC__P_FINE_B5 sky130_fd_pr__cap_mim_m3_1 w=9.81 l=9.81
XDAC_P_FINE_B5_U50_C_UNIT_P0 DAC__FINEP DAC__P_FINE_B5 sky130_fd_pr__cap_mim_m3_1 w=9.81 l=9.81
XDAC_P_FINE_B5_U51_C_UNIT_P0 DAC__FINEP DAC__P_FINE_B5 sky130_fd_pr__cap_mim_m3_1 w=9.81 l=9.81
XDAC_P_FINE_B5_U52_C_UNIT_P0 DAC__FINEP DAC__P_FINE_B5 sky130_fd_pr__cap_mim_m3_1 w=9.81 l=9.81
XDAC_P_FINE_B5_U53_C_UNIT_P0 DAC__FINEP DAC__P_FINE_B5 sky130_fd_pr__cap_mim_m3_1 w=9.81 l=9.81
XDAC_P_FINE_B5_U54_C_UNIT_P0 DAC__FINEP DAC__P_FINE_B5 sky130_fd_pr__cap_mim_m3_1 w=9.81 l=9.81
XDAC_P_FINE_B5_U55_C_UNIT_P0 DAC__FINEP DAC__P_FINE_B5 sky130_fd_pr__cap_mim_m3_1 w=9.81 l=9.81
XDAC_P_FINE_B5_U56_C_UNIT_P0 DAC__FINEP DAC__P_FINE_B5 sky130_fd_pr__cap_mim_m3_1 w=9.81 l=9.81
XDAC_P_FINE_B5_U57_C_UNIT_P0 DAC__FINEP DAC__P_FINE_B5 sky130_fd_pr__cap_mim_m3_1 w=9.81 l=9.81
XDAC_P_FINE_B5_U58_C_UNIT_P0 DAC__FINEP DAC__P_FINE_B5 sky130_fd_pr__cap_mim_m3_1 w=9.81 l=9.81
XDAC_P_FINE_B5_U59_C_UNIT_P0 DAC__FINEP DAC__P_FINE_B5 sky130_fd_pr__cap_mim_m3_1 w=9.81 l=9.81
XDAC_P_FINE_B5_U6_C_UNIT_P0 DAC__FINEP DAC__P_FINE_B5 sky130_fd_pr__cap_mim_m3_1 w=9.81 l=9.81
XDAC_P_FINE_B5_U60_C_UNIT_P0 DAC__FINEP DAC__P_FINE_B5 sky130_fd_pr__cap_mim_m3_1 w=9.81 l=9.81
XDAC_P_FINE_B5_U61_C_UNIT_P0 DAC__FINEP DAC__P_FINE_B5 sky130_fd_pr__cap_mim_m3_1 w=9.81 l=9.81
XDAC_P_FINE_B5_U62_C_UNIT_P0 DAC__FINEP DAC__P_FINE_B5 sky130_fd_pr__cap_mim_m3_1 w=9.81 l=9.81
XDAC_P_FINE_B5_U63_C_UNIT_P0 DAC__FINEP DAC__P_FINE_B5 sky130_fd_pr__cap_mim_m3_1 w=9.81 l=9.81
XDAC_P_FINE_B5_U7_C_UNIT_P0 DAC__FINEP DAC__P_FINE_B5 sky130_fd_pr__cap_mim_m3_1 w=9.81 l=9.81
XDAC_P_FINE_B5_U8_C_UNIT_P0 DAC__FINEP DAC__P_FINE_B5 sky130_fd_pr__cap_mim_m3_1 w=9.81 l=9.81
XDAC_P_FINE_B5_U9_C_UNIT_P0 DAC__FINEP DAC__P_FINE_B5 sky130_fd_pr__cap_mim_m3_1 w=9.81 l=9.81
XDAC_P_FINE_DUMMY_U0_C_UNIT_P0 DAC__FINEP DAC__LOP sky130_fd_pr__cap_mim_m3_1 w=9.81 l=9.81
XDAC_P_FINE_DUMMY_U1_C_UNIT_P0 DAC__FINEP DAC__LOP sky130_fd_pr__cap_mim_m3_1 w=9.81 l=9.81
XDAC_REF_HIN_ACQUIRE_N VINN SAMPLE DAC__HIN VGND sky130_fd_pr__nfet_01v8 w=8 l=0.15 nf=1 m=1
XDAC_REF_HIN_ACQUIRE_P VINN DAC__SAMPLEB DAC__HIN VPWR sky130_fd_pr__pfet_01v8_hvt w=12 l=0.15 nf=1 m=1
XDAC_REF_HIN_CONVERT_N VREF DAC__SAMPLEB DAC__HIN VGND sky130_fd_pr__nfet_01v8 w=8 l=0.15 nf=1 m=1
XDAC_REF_HIN_CONVERT_P VREF SAMPLE DAC__HIN VPWR sky130_fd_pr__pfet_01v8_hvt w=12 l=0.15 nf=1 m=1
XDAC_REF_HIP_ACQUIRE_N VINP SAMPLE DAC__HIP VGND sky130_fd_pr__nfet_01v8 w=8 l=0.15 nf=1 m=1
XDAC_REF_HIP_ACQUIRE_P VINP DAC__SAMPLEB DAC__HIP VPWR sky130_fd_pr__pfet_01v8_hvt w=12 l=0.15 nf=1 m=1
XDAC_REF_HIP_CONVERT_N VREF DAC__SAMPLEB DAC__HIP VGND sky130_fd_pr__nfet_01v8 w=8 l=0.15 nf=1 m=1
XDAC_REF_HIP_CONVERT_P VREF SAMPLE DAC__HIP VPWR sky130_fd_pr__pfet_01v8_hvt w=12 l=0.15 nf=1 m=1
XDAC_REF_LON_ACQUIRE_N VINN SAMPLE DAC__LON VGND sky130_fd_pr__nfet_01v8 w=8 l=0.15 nf=1 m=1
XDAC_REF_LON_ACQUIRE_P VINN DAC__SAMPLEB DAC__LON VPWR sky130_fd_pr__pfet_01v8_hvt w=12 l=0.15 nf=1 m=1
XDAC_REF_LON_CONVERT_N VGND DAC__SAMPLEB DAC__LON VGND sky130_fd_pr__nfet_01v8 w=8 l=0.15 nf=1 m=1
XDAC_REF_LON_CONVERT_P VGND SAMPLE DAC__LON VPWR sky130_fd_pr__pfet_01v8_hvt w=12 l=0.15 nf=1 m=1
XDAC_REF_LOP_ACQUIRE_N VINP SAMPLE DAC__LOP VGND sky130_fd_pr__nfet_01v8 w=8 l=0.15 nf=1 m=1
XDAC_REF_LOP_ACQUIRE_P VINP DAC__SAMPLEB DAC__LOP VPWR sky130_fd_pr__pfet_01v8_hvt w=12 l=0.15 nf=1 m=1
XDAC_REF_LOP_CONVERT_N VGND DAC__SAMPLEB DAC__LOP VGND sky130_fd_pr__nfet_01v8 w=8 l=0.15 nf=1 m=1
XDAC_REF_LOP_CONVERT_P VGND SAMPLE DAC__LOP VPWR sky130_fd_pr__pfet_01v8_hvt w=12 l=0.15 nf=1 m=1
XDAC_RESET_FINEN_N VCM SAMPLE DAC__FINEN VGND sky130_fd_pr__nfet_01v8 w=8 l=0.15 nf=1 m=1
XDAC_RESET_FINEN_P VCM DAC__SAMPLEB DAC__FINEN VPWR sky130_fd_pr__pfet_01v8_hvt w=12 l=0.15 nf=1 m=1
XDAC_RESET_FINEP_N VCM SAMPLE DAC__FINEP VGND sky130_fd_pr__nfet_01v8 w=8 l=0.15 nf=1 m=1
XDAC_RESET_FINEP_P VCM DAC__SAMPLEB DAC__FINEP VPWR sky130_fd_pr__pfet_01v8_hvt w=12 l=0.15 nf=1 m=1
XDAC_RESET_TOPN_N VCM SAMPLE TOPN VGND sky130_fd_pr__nfet_01v8 w=8 l=0.15 nf=1 m=1
XDAC_RESET_TOPN_P VCM DAC__SAMPLEB TOPN VPWR sky130_fd_pr__pfet_01v8_hvt w=12 l=0.15 nf=1 m=1
XDAC_RESET_TOPP_N VCM SAMPLE TOPP VGND sky130_fd_pr__nfet_01v8 w=8 l=0.15 nf=1 m=1
XDAC_RESET_TOPP_P VCM DAC__SAMPLEB TOPP VPWR sky130_fd_pr__pfet_01v8_hvt w=12 l=0.15 nf=1 m=1
XDAC_SAMPLE_INV_MN DAC__SAMPLEB SAMPLE VGND VGND sky130_fd_pr__nfet_01v8 w=0.65 l=0.15 nf=1 m=1
XDAC_SAMPLE_INV_MP DAC__SAMPLEB SAMPLE VPWR VPWR sky130_fd_pr__pfet_01v8_hvt w=0.65 l=0.15 nf=1 m=1
.ends sar12_analog

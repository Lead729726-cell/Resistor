Differential twelve-bit SAR with actual retained charge and dynamic MOS latch
.include "/mnt/d/Coldbrew/Resistor/.runtime/sar12/lab/.runtime/eda/runs/d2937073af124a519ebaa3fb05b03260/supported-tt.spice"
.option scale=1e-6 method=gear maxord=2 reltol=1e-5 vntol=1e-6 abstol=1e-12 chgtol=1e-16
.include "/mnt/d/Coldbrew/Resistor/.runtime/sar12/lab/.runtime/eda/runs/d2937073af124a519ebaa3fb05b03260/analog.spice"
.temp 27.0
VGND VGND 0 0
VDD VPWR VGND 1.8
VINP VINP_DRV VGND 0.900146484375
R_VINP VINP_DRV VINP 50
VINN VINN_DRV VGND 0.899853515625
R_VINN VINN_DRV VINN 50
VREF VREF_DRV VGND 1.2
RREF VREF_DRV VREF 2
CREF VREF VGND 1n
VCM VCM_DRV VGND 1.2
RVCM VCM_DRV VCM 10
CVCM VCM VGND 100p
VD_SAMPLE DRV_SAMPLE VGND 1.8
RD_SAMPLE DRV_SAMPLE SAMPLE 2000
CD_SAMPLE SAMPLE VGND 2p
VD_EVAL DRV_EVAL VGND 0
RD_EVAL DRV_EVAL EVAL 2000
CD_EVAL EVAL VGND 2p
VD_B0 DRV_B0 VGND 0
RD_B0 DRV_B0 B0 2000
CD_B0 B0 VGND 2p
VD_B1 DRV_B1 VGND 0
RD_B1 DRV_B1 B1 2000
CD_B1 B1 VGND 2p
VD_B2 DRV_B2 VGND 0
RD_B2 DRV_B2 B2 2000
CD_B2 B2 VGND 2p
VD_B3 DRV_B3 VGND 0
RD_B3 DRV_B3 B3 2000
CD_B3 B3 VGND 2p
VD_B4 DRV_B4 VGND 0
RD_B4 DRV_B4 B4 2000
CD_B4 B4 VGND 2p
VD_B5 DRV_B5 VGND 0
RD_B5 DRV_B5 B5 2000
CD_B5 B5 VGND 2p
VD_B6 DRV_B6 VGND 0
RD_B6 DRV_B6 B6 2000
CD_B6 B6 VGND 2p
VD_B7 DRV_B7 VGND 0
RD_B7 DRV_B7 B7 2000
CD_B7 B7 VGND 2p
VD_B8 DRV_B8 VGND 0
RD_B8 DRV_B8 B8 2000
CD_B8 B8 VGND 2p
VD_B9 DRV_B9 VGND 0
RD_B9 DRV_B9 B9 2000
CD_B9 B9 VGND 2p
VD_B10 DRV_B10 VGND 0
RD_B10 DRV_B10 B10 2000
CD_B10 B10 VGND 2p
VD_B11 DRV_B11 VGND 0
RD_B11 DRV_B11 B11 2000
CD_B11 B11 VGND 2p
XU VINP VINN VREF VCM SAMPLE EVAL TOPP TOPN COMP COMPN B0 B1 B2 B3 B4 B5 B6 B7 B8 B9 B10 B11 VPWR VGND sar12_analog
.tran 1e-08 0.0001412 0 1e-08
VMARK SAR12_TIMING_MARK VGND PWL(0 0 4e-06 1 4.05e-06 0 4.375e-06 1 4.55e-06 0 4.875e-06 1 5.05e-06 0 5.375e-06 1 5.55e-06 0 5.875e-06 1 6.05e-06 0 6.375e-06 1 6.55e-06 0 6.875e-06 1 7.05e-06 0 7.375e-06 1 7.55e-06 0 7.875e-06 1 8.05e-06 0 8.375e-06 1 8.55e-06 0 8.875e-06 1 9.05e-06 0 9.375e-06 1 9.55e-06 0 9.875e-06 1 1.005e-05 0 1.405e-05 1 1.41e-05 0 1.4425e-05 1 1.46e-05 0 1.4925e-05 1 1.51e-05 0 1.5425e-05 1 1.56e-05 0 1.5925e-05 1 1.61e-05 0 1.6425e-05 1 1.66e-05 0 1.6925e-05 1 1.71e-05 0 1.7425e-05 1 1.76e-05 0 1.7925e-05 1 1.81e-05 0 1.8425e-05 1 1.86e-05 0 1.8925e-05 1 1.91e-05 0 1.9425e-05 1 1.96e-05 0 1.9925e-05 1 2.01e-05 0 2.41e-05 1 2.415e-05 0 2.4475e-05 1 2.465e-05 0 2.4975e-05 1 2.515e-05 0 2.5475e-05 1 2.565e-05 0 2.5975e-05 1 2.615e-05 0 2.6475e-05 1 2.665e-05 0 2.6975e-05 1 2.715e-05 0 2.7475e-05 1 2.765e-05 0 2.7975e-05 1 2.815e-05 0 2.8475e-05 1 2.865e-05 0 2.8975e-05 1 2.915e-05 0 2.9475e-05 1 2.965e-05 0 2.9975e-05 1 3.015e-05 0 3.415e-05 1 3.42e-05 0 3.4525e-05 1 3.47e-05 0 3.5025e-05 1 3.52e-05 0 3.5525e-05 1 3.57e-05 0 3.6025e-05 1 3.62e-05 0 3.6525e-05 1 3.67e-05 0 3.7025e-05 1 3.72e-05 0 3.7525e-05 1 3.77e-05 0 3.8025e-05 1 3.82e-05 0 3.8525e-05 1 3.87e-05 0 3.9025e-05 1 3.92e-05 0 3.9525e-05 1 3.97e-05 0 4.0025e-05 1 4.02e-05 0 4.42e-05 1 4.425e-05 0 4.4575e-05 1 4.475e-05 0 4.5075e-05 1 4.525e-05 0 4.5575e-05 1 4.575e-05 0 4.6075e-05 1 4.625e-05 0 4.6575e-05 1 4.675e-05 0 4.7075e-05 1 4.725e-05 0 4.7575e-05 1 4.775e-05 0 4.8075e-05 1 4.825e-05 0 4.8575e-05 1 4.875e-05 0 4.9075e-05 1 4.925e-05 0 4.9575e-05 1 4.975e-05 0 5.0075e-05 1 5.025e-05 0 5.425e-05 1 5.43e-05 0 5.4625e-05 1 5.48e-05 0 5.5125e-05 1 5.53e-05 0 5.5625e-05 1 5.58e-05 0 5.6125e-05 1 5.63e-05 0 5.6625e-05 1 5.68e-05 0 5.7125e-05 1 5.73e-05 0 5.7625e-05 1 5.78e-05 0 5.8125e-05 1 5.83e-05 0 5.8625e-05 1 5.88e-05 0 5.9125e-05 1 5.93e-05 0 5.9625e-05 1 5.98e-05 0 6.0125e-05 1 6.03e-05 0 6.43e-05 1 6.435e-05 0 6.4675e-05 1 6.485e-05 0 6.5175e-05 1 6.535e-05 0 6.5675e-05 1 6.585e-05 0 6.6175e-05 1 6.635e-05 0 6.6675e-05 1 6.685e-05 0 6.7175e-05 1 6.735e-05 0 6.7675e-05 1 6.785e-05 0 6.8175e-05 1 6.835e-05 0 6.8675e-05 1 6.885e-05 0 6.9175e-05 1 6.935e-05 0 6.9675e-05 1 6.985e-05 0 7.0175e-05 1 7.035e-05 0 7.435e-05 1 7.44e-05 0 7.4725e-05 1 7.49e-05 0 7.5225e-05 1 7.54e-05 0 7.5725e-05 1 7.59e-05 0 7.6225e-05 1 7.64e-05 0 7.6725e-05 1 7.69e-05 0 7.7225e-05 1 7.74e-05 0 7.7725e-05 1 7.79e-05 0 7.8225e-05 1 7.84e-05 0 7.8725e-05 1 7.89e-05 0 7.9225e-05 1 7.94e-05 0 7.9725e-05 1 7.99e-05 0 8.0225e-05 1 8.04e-05 0 8.44e-05 1 8.445e-05 0 8.4775e-05 1 8.495e-05 0 8.5275e-05 1 8.545e-05 0 8.5775e-05 1 8.595e-05 0 8.6275e-05 1 8.645e-05 0 8.6775e-05 1 8.695e-05 0 8.7275e-05 1 8.745e-05 0 8.7775e-05 1 8.795e-05 0 8.8275e-05 1 8.845e-05 0 8.87749999999999e-05 1 8.895e-05 0 8.92749999999999e-05 1 8.945e-05 0 8.97749999999999e-05 1 8.995e-05 0 9.02749999999999e-05 1 9.04499999999999e-05 0 9.445e-05 1 9.45e-05 0 9.48249999999999e-05 1 9.5e-05 0 9.53249999999999e-05 1 9.54999999999999e-05 0 9.58249999999999e-05 1 9.59999999999999e-05 0 9.63249999999999e-05 1 9.64999999999999e-05 0 9.68249999999999e-05 1 9.69999999999999e-05 0 9.73249999999999e-05 1 9.74999999999999e-05 0 9.78249999999999e-05 1 9.79999999999999e-05 0 9.83249999999999e-05 1 9.84999999999999e-05 0 9.88249999999999e-05 1 9.89999999999999e-05 0 9.93249999999999e-05 1 9.94999999999999e-05 0 9.98249999999999e-05 1 9.99999999999999e-05 0 0.000100325 1 0.0001005 0 0.0001045 1 0.00010455 0 0.000104875 1 0.00010505 0 0.000105375 1 0.00010555 0 0.000105875 1 0.00010605 0 0.000106375 1 0.00010655 0 0.000106875 1 0.00010705 0 0.000107375 1 0.00010755 0 0.000107875 1 0.00010805 0 0.000108375 1 0.00010855 0 0.000108875 1 0.00010905 0 0.000109375 1 0.00010955 0 0.000109875 1 0.00011005 0 0.000110375 1 0.00011055 0 0.00011455 1 0.0001146 0 0.000114925 1 0.0001151 0 0.000115425 1 0.0001156 0 0.000115925 1 0.0001161 0 0.000116425 1 0.0001166 0 0.000116925 1 0.0001171 0 0.000117425 1 0.0001176 0 0.000117925 1 0.0001181 0 0.000118425 1 0.0001186 0 0.000118925 1 0.0001191 0 0.000119425 1 0.0001196 0 0.000119925 1 0.0001201 0 0.000120425 1 0.0001206 0 0.0001246 1 0.00012465 0 0.000124975 1 0.00012515 0 0.000125475 1 0.00012565 0 0.000125975 1 0.00012615 0 0.000126475 1 0.00012665 0 0.000126975 1 0.00012715 0 0.000127475 1 0.00012765 0 0.000127975 1 0.00012815 0 0.000128475 1 0.00012865 0 0.000128975 1 0.00012915 0 0.000129475 1 0.00012965 0 0.000129975 1 0.00013015 0 0.000130475 1 0.00013065 0 0.00013465 1 0.0001347 0 0.000135025 1 0.0001352 0 0.000135525 1 0.0001357 0 0.000136025 1 0.0001362 0 0.000136525 1 0.0001367 0 0.000137025 1 0.0001372 0 0.000137525 1 0.0001377 0 0.000138025 1 0.0001382 0 0.000138525 1 0.0001387 0 0.000139025 1 0.0001392 0 0.000139525 1 0.0001397 0 0.000140025 1 0.0001402 0 0.000140525 1 0.0001407 0 0.0001412 0)
RMARK SAR12_TIMING_MARK VGND 1Meg
.control
set num_threads=1
set numdgt=17
set wr_singlescale
set wr_vecnames
save v(VINP) v(VINN) v(SAMPLE) v(EVAL) v(TOPP) v(TOPN) v(COMP) v(COMPN) v(B0) v(B1) v(B2) v(B3) v(B4) v(B5) v(B6) v(B7) v(B8) v(B9) v(B10) v(B11) i(VDD) i(VREF)
echo frame bit trial comp compn topp topn vin decision > decisions.csv
alter VINP = 0.900146484375
alter VINN = 0.899853515625
alter VD_SAMPLE = 1.8
alter VD_EVAL = 0
alter VD_B0 = 0
alter VD_B1 = 0
alter VD_B2 = 0
alter VD_B3 = 0
alter VD_B4 = 0
alter VD_B5 = 0
alter VD_B6 = 0
alter VD_B7 = 0
alter VD_B8 = 0
alter VD_B9 = 0
alter VD_B10 = 0
alter VD_B11 = 0
let sar12_code = 0
stop when time ge 3.999999999e-06
echo actual_pause_time_s > pause-times.txt
run
let sar12_k = length(time)-1
if abs(time[sar12_k] - 4e-06) > 1e-12
print time[sar12_k]
echo expected_pause_time_s 4e-06
echo SAR12_PAUSE_FAILED
quit 1
end
print time[sar12_k] >> pause-times.txt
delete all
alter VD_SAMPLE = 0
stop when time ge 4.049999999e-06
resume
let sar12_k = length(time)-1
if abs(time[sar12_k] - 4.05e-06) > 1e-12
print time[sar12_k]
echo expected_pause_time_s 4.05e-06
echo SAR12_PAUSE_FAILED
quit 1
end
print time[sar12_k] >> pause-times.txt
delete all
alter VD_EVAL = 0
let sar12_trial = sar12_code + 2048
let sar12_drive = (floor(sar12_trial / 1) - 2*floor(sar12_trial / 2))*1.8
alter VD_B0 = $&sar12_drive
let sar12_drive = (floor(sar12_trial / 2) - 2*floor(sar12_trial / 4))*1.8
alter VD_B1 = $&sar12_drive
let sar12_drive = (floor(sar12_trial / 4) - 2*floor(sar12_trial / 8))*1.8
alter VD_B2 = $&sar12_drive
let sar12_drive = (floor(sar12_trial / 8) - 2*floor(sar12_trial / 16))*1.8
alter VD_B3 = $&sar12_drive
let sar12_drive = (floor(sar12_trial / 16) - 2*floor(sar12_trial / 32))*1.8
alter VD_B4 = $&sar12_drive
let sar12_drive = (floor(sar12_trial / 32) - 2*floor(sar12_trial / 64))*1.8
alter VD_B5 = $&sar12_drive
let sar12_drive = (floor(sar12_trial / 64) - 2*floor(sar12_trial / 128))*1.8
alter VD_B6 = $&sar12_drive
let sar12_drive = (floor(sar12_trial / 128) - 2*floor(sar12_trial / 256))*1.8
alter VD_B7 = $&sar12_drive
let sar12_drive = (floor(sar12_trial / 256) - 2*floor(sar12_trial / 512))*1.8
alter VD_B8 = $&sar12_drive
let sar12_drive = (floor(sar12_trial / 512) - 2*floor(sar12_trial / 1024))*1.8
alter VD_B9 = $&sar12_drive
let sar12_drive = (floor(sar12_trial / 1024) - 2*floor(sar12_trial / 2048))*1.8
alter VD_B10 = $&sar12_drive
let sar12_drive = (floor(sar12_trial / 2048) - 2*floor(sar12_trial / 4096))*1.8
alter VD_B11 = $&sar12_drive
stop when time ge 4.374999999e-06
resume
let sar12_k = length(time)-1
if abs(time[sar12_k] - 4.375e-06) > 1e-12
print time[sar12_k]
echo expected_pause_time_s 4.375e-06
echo SAR12_PAUSE_FAILED
quit 1
end
print time[sar12_k] >> pause-times.txt
delete all
alter VD_EVAL = 1.8
stop when time ge 4.549999999e-06
resume
let sar12_k = length(time)-1
if abs(time[sar12_k] - 4.55e-06) > 1e-12
print time[sar12_k]
echo expected_pause_time_s 4.55e-06
echo SAR12_PAUSE_FAILED
quit 1
end
print time[sar12_k] >> pause-times.txt
delete all
let sar12_k = length(time)-1
let sar12_cmp = v(COMP)[sar12_k]
let sar12_cmpn = v(COMPN)[sar12_k]
let sar12_p = v(TOPP)[sar12_k]
let sar12_n = v(TOPN)[sar12_k]
let sar12_decision = 0
if sar12_cmp >= 0.9
let sar12_code = sar12_trial
let sar12_decision = 1
end
echo 0 11 $&sar12_trial $&sar12_cmp $&sar12_cmpn $&sar12_p $&sar12_n 0.00029296875 $&sar12_decision >> decisions.csv
alter VD_EVAL = 0
let sar12_trial = sar12_code + 1024
let sar12_drive = (floor(sar12_trial / 1) - 2*floor(sar12_trial / 2))*1.8
alter VD_B0 = $&sar12_drive
let sar12_drive = (floor(sar12_trial / 2) - 2*floor(sar12_trial / 4))*1.8
alter VD_B1 = $&sar12_drive
let sar12_drive = (floor(sar12_trial / 4) - 2*floor(sar12_trial / 8))*1.8
alter VD_B2 = $&sar12_drive
let sar12_drive = (floor(sar12_trial / 8) - 2*floor(sar12_trial / 16))*1.8
alter VD_B3 = $&sar12_drive
let sar12_drive = (floor(sar12_trial / 16) - 2*floor(sar12_trial / 32))*1.8
alter VD_B4 = $&sar12_drive
let sar12_drive = (floor(sar12_trial / 32) - 2*floor(sar12_trial / 64))*1.8
alter VD_B5 = $&sar12_drive
let sar12_drive = (floor(sar12_trial / 64) - 2*floor(sar12_trial / 128))*1.8
alter VD_B6 = $&sar12_drive
let sar12_drive = (floor(sar12_trial / 128) - 2*floor(sar12_trial / 256))*1.8
alter VD_B7 = $&sar12_drive
let sar12_drive = (floor(sar12_trial / 256) - 2*floor(sar12_trial / 512))*1.8
alter VD_B8 = $&sar12_drive
let sar12_drive = (floor(sar12_trial / 512) - 2*floor(sar12_trial / 1024))*1.8
alter VD_B9 = $&sar12_drive
let sar12_drive = (floor(sar12_trial / 1024) - 2*floor(sar12_trial / 2048))*1.8
alter VD_B10 = $&sar12_drive
let sar12_drive = (floor(sar12_trial / 2048) - 2*floor(sar12_trial / 4096))*1.8
alter VD_B11 = $&sar12_drive
stop when time ge 4.874999999e-06
resume
let sar12_k = length(time)-1
if abs(time[sar12_k] - 4.875e-06) > 1e-12
print time[sar12_k]
echo expected_pause_time_s 4.875e-06
echo SAR12_PAUSE_FAILED
quit 1
end
print time[sar12_k] >> pause-times.txt
delete all
alter VD_EVAL = 1.8
stop when time ge 5.049999999e-06
resume
let sar12_k = length(time)-1
if abs(time[sar12_k] - 5.05e-06) > 1e-12
print time[sar12_k]
echo expected_pause_time_s 5.05e-06
echo SAR12_PAUSE_FAILED
quit 1
end
print time[sar12_k] >> pause-times.txt
delete all
let sar12_k = length(time)-1
let sar12_cmp = v(COMP)[sar12_k]
let sar12_cmpn = v(COMPN)[sar12_k]
let sar12_p = v(TOPP)[sar12_k]
let sar12_n = v(TOPN)[sar12_k]
let sar12_decision = 0
if sar12_cmp >= 0.9
let sar12_code = sar12_trial
let sar12_decision = 1
end
echo 0 10 $&sar12_trial $&sar12_cmp $&sar12_cmpn $&sar12_p $&sar12_n 0.00029296875 $&sar12_decision >> decisions.csv
alter VD_EVAL = 0
let sar12_trial = sar12_code + 512
let sar12_drive = (floor(sar12_trial / 1) - 2*floor(sar12_trial / 2))*1.8
alter VD_B0 = $&sar12_drive
let sar12_drive = (floor(sar12_trial / 2) - 2*floor(sar12_trial / 4))*1.8
alter VD_B1 = $&sar12_drive
let sar12_drive = (floor(sar12_trial / 4) - 2*floor(sar12_trial / 8))*1.8
alter VD_B2 = $&sar12_drive
let sar12_drive = (floor(sar12_trial / 8) - 2*floor(sar12_trial / 16))*1.8
alter VD_B3 = $&sar12_drive
let sar12_drive = (floor(sar12_trial / 16) - 2*floor(sar12_trial / 32))*1.8
alter VD_B4 = $&sar12_drive
let sar12_drive = (floor(sar12_trial / 32) - 2*floor(sar12_trial / 64))*1.8
alter VD_B5 = $&sar12_drive
let sar12_drive = (floor(sar12_trial / 64) - 2*floor(sar12_trial / 128))*1.8
alter VD_B6 = $&sar12_drive
let sar12_drive = (floor(sar12_trial / 128) - 2*floor(sar12_trial / 256))*1.8
alter VD_B7 = $&sar12_drive
let sar12_drive = (floor(sar12_trial / 256) - 2*floor(sar12_trial / 512))*1.8
alter VD_B8 = $&sar12_drive
let sar12_drive = (floor(sar12_trial / 512) - 2*floor(sar12_trial / 1024))*1.8
alter VD_B9 = $&sar12_drive
let sar12_drive = (floor(sar12_trial / 1024) - 2*floor(sar12_trial / 2048))*1.8
alter VD_B10 = $&sar12_drive
let sar12_drive = (floor(sar12_trial / 2048) - 2*floor(sar12_trial / 4096))*1.8
alter VD_B11 = $&sar12_drive
stop when time ge 5.374999999e-06
resume
let sar12_k = length(time)-1
if abs(time[sar12_k] - 5.375e-06) > 1e-12
print time[sar12_k]
echo expected_pause_time_s 5.375e-06
echo SAR12_PAUSE_FAILED
quit 1
end
print time[sar12_k] >> pause-times.txt
delete all
alter VD_EVAL = 1.8
stop when time ge 5.549999999e-06
resume
let sar12_k = length(time)-1
if abs(time[sar12_k] - 5.55e-06) > 1e-12
print time[sar12_k]
echo expected_pause_time_s 5.55e-06
echo SAR12_PAUSE_FAILED
quit 1
end
print time[sar12_k] >> pause-times.txt
delete all
let sar12_k = length(time)-1
let sar12_cmp = v(COMP)[sar12_k]
let sar12_cmpn = v(COMPN)[sar12_k]
let sar12_p = v(TOPP)[sar12_k]
let sar12_n = v(TOPN)[sar12_k]
let sar12_decision = 0
if sar12_cmp >= 0.9
let sar12_code = sar12_trial
let sar12_decision = 1
end
echo 0 9 $&sar12_trial $&sar12_cmp $&sar12_cmpn $&sar12_p $&sar12_n 0.00029296875 $&sar12_decision >> decisions.csv
alter VD_EVAL = 0
let sar12_trial = sar12_code + 256
let sar12_drive = (floor(sar12_trial / 1) - 2*floor(sar12_trial / 2))*1.8
alter VD_B0 = $&sar12_drive
let sar12_drive = (floor(sar12_trial / 2) - 2*floor(sar12_trial / 4))*1.8
alter VD_B1 = $&sar12_drive
let sar12_drive = (floor(sar12_trial / 4) - 2*floor(sar12_trial / 8))*1.8
alter VD_B2 = $&sar12_drive
let sar12_drive = (floor(sar12_trial / 8) - 2*floor(sar12_trial / 16))*1.8
alter VD_B3 = $&sar12_drive
let sar12_drive = (floor(sar12_trial / 16) - 2*floor(sar12_trial / 32))*1.8
alter VD_B4 = $&sar12_drive
let sar12_drive = (floor(sar12_trial / 32) - 2*floor(sar12_trial / 64))*1.8
alter VD_B5 = $&sar12_drive
let sar12_drive = (floor(sar12_trial / 64) - 2*floor(sar12_trial / 128))*1.8
alter VD_B6 = $&sar12_drive
let sar12_drive = (floor(sar12_trial / 128) - 2*floor(sar12_trial / 256))*1.8
alter VD_B7 = $&sar12_drive
let sar12_drive = (floor(sar12_trial / 256) - 2*floor(sar12_trial / 512))*1.8
alter VD_B8 = $&sar12_drive
let sar12_drive = (floor(sar12_trial / 512) - 2*floor(sar12_trial / 1024))*1.8
alter VD_B9 = $&sar12_drive
let sar12_drive = (floor(sar12_trial / 1024) - 2*floor(sar12_trial / 2048))*1.8
alter VD_B10 = $&sar12_drive
let sar12_drive = (floor(sar12_trial / 2048) - 2*floor(sar12_trial / 4096))*1.8
alter VD_B11 = $&sar12_drive
stop when time ge 5.874999999e-06
resume
let sar12_k = length(time)-1
if abs(time[sar12_k] - 5.875e-06) > 1e-12
print time[sar12_k]
echo expected_pause_time_s 5.875e-06
echo SAR12_PAUSE_FAILED
quit 1
end
print time[sar12_k] >> pause-times.txt
delete all
alter VD_EVAL = 1.8
stop when time ge 6.049999999e-06
resume
let sar12_k = length(time)-1
if abs(time[sar12_k] - 6.05e-06) > 1e-12
print time[sar12_k]
echo expected_pause_time_s 6.05e-06
echo SAR12_PAUSE_FAILED
quit 1
end
print time[sar12_k] >> pause-times.txt
delete all
let sar12_k = length(time)-1
let sar12_cmp = v(COMP)[sar12_k]
let sar12_cmpn = v(COMPN)[sar12_k]
let sar12_p = v(TOPP)[sar12_k]
let sar12_n = v(TOPN)[sar12_k]
let sar12_decision = 0
if sar12_cmp >= 0.9
let sar12_code = sar12_trial
let sar12_decision = 1
end
echo 0 8 $&sar12_trial $&sar12_cmp $&sar12_cmpn $&sar12_p $&sar12_n 0.00029296875 $&sar12_decision >> decisions.csv
alter VD_EVAL = 0
let sar12_trial = sar12_code + 128
let sar12_drive = (floor(sar12_trial / 1) - 2*floor(sar12_trial / 2))*1.8
alter VD_B0 = $&sar12_drive
let sar12_drive = (floor(sar12_trial / 2) - 2*floor(sar12_trial / 4))*1.8
alter VD_B1 = $&sar12_drive
let sar12_drive = (floor(sar12_trial / 4) - 2*floor(sar12_trial / 8))*1.8
alter VD_B2 = $&sar12_drive
let sar12_drive = (floor(sar12_trial / 8) - 2*floor(sar12_trial / 16))*1.8
alter VD_B3 = $&sar12_drive
let sar12_drive = (floor(sar12_trial / 16) - 2*floor(sar12_trial / 32))*1.8
alter VD_B4 = $&sar12_drive
let sar12_drive = (floor(sar12_trial / 32) - 2*floor(sar12_trial / 64))*1.8
alter VD_B5 = $&sar12_drive
let sar12_drive = (floor(sar12_trial / 64) - 2*floor(sar12_trial / 128))*1.8
alter VD_B6 = $&sar12_drive
let sar12_drive = (floor(sar12_trial / 128) - 2*floor(sar12_trial / 256))*1.8
alter VD_B7 = $&sar12_drive
let sar12_drive = (floor(sar12_trial / 256) - 2*floor(sar12_trial / 512))*1.8
alter VD_B8 = $&sar12_drive
let sar12_drive = (floor(sar12_trial / 512) - 2*floor(sar12_trial / 1024))*1.8
alter VD_B9 = $&sar12_drive
let sar12_drive = (floor(sar12_trial / 1024) - 2*floor(sar12_trial / 2048))*1.8
alter VD_B10 = $&sar12_drive
let sar12_drive = (floor(sar12_trial / 2048) - 2*floor(sar12_trial / 4096))*1.8
alter VD_B11 = $&sar12_drive
stop when time ge 6.374999999e-06
resume
let sar12_k = length(time)-1
if abs(time[sar12_k] - 6.375e-06) > 1e-12
print time[sar12_k]
echo expected_pause_time_s 6.375e-06
echo SAR12_PAUSE_FAILED
quit 1
end
print time[sar12_k] >> pause-times.txt
delete all
alter VD_EVAL = 1.8
stop when time ge 6.549999999e-06
resume
let sar12_k = length(time)-1
if abs(time[sar12_k] - 6.55e-06) > 1e-12
print time[sar12_k]
echo expected_pause_time_s 6.55e-06
echo SAR12_PAUSE_FAILED
quit 1
end
print time[sar12_k] >> pause-times.txt
delete all
let sar12_k = length(time)-1
let sar12_cmp = v(COMP)[sar12_k]
let sar12_cmpn = v(COMPN)[sar12_k]
let sar12_p = v(TOPP)[sar12_k]
let sar12_n = v(TOPN)[sar12_k]
let sar12_decision = 0
if sar12_cmp >= 0.9
let sar12_code = sar12_trial
let sar12_decision = 1
end
echo 0 7 $&sar12_trial $&sar12_cmp $&sar12_cmpn $&sar12_p $&sar12_n 0.00029296875 $&sar12_decision >> decisions.csv
alter VD_EVAL = 0
let sar12_trial = sar12_code + 64
let sar12_drive = (floor(sar12_trial / 1) - 2*floor(sar12_trial / 2))*1.8
alter VD_B0 = $&sar12_drive
let sar12_drive = (floor(sar12_trial / 2) - 2*floor(sar12_trial / 4))*1.8
alter VD_B1 = $&sar12_drive
let sar12_drive = (floor(sar12_trial / 4) - 2*floor(sar12_trial / 8))*1.8
alter VD_B2 = $&sar12_drive
let sar12_drive = (floor(sar12_trial / 8) - 2*floor(sar12_trial / 16))*1.8
alter VD_B3 = $&sar12_drive
let sar12_drive = (floor(sar12_trial / 16) - 2*floor(sar12_trial / 32))*1.8
alter VD_B4 = $&sar12_drive
let sar12_drive = (floor(sar12_trial / 32) - 2*floor(sar12_trial / 64))*1.8
alter VD_B5 = $&sar12_drive
let sar12_drive = (floor(sar12_trial / 64) - 2*floor(sar12_trial / 128))*1.8
alter VD_B6 = $&sar12_drive
let sar12_drive = (floor(sar12_trial / 128) - 2*floor(sar12_trial / 256))*1.8
alter VD_B7 = $&sar12_drive
let sar12_drive = (floor(sar12_trial / 256) - 2*floor(sar12_trial / 512))*1.8
alter VD_B8 = $&sar12_drive
let sar12_drive = (floor(sar12_trial / 512) - 2*floor(sar12_trial / 1024))*1.8
alter VD_B9 = $&sar12_drive
let sar12_drive = (floor(sar12_trial / 1024) - 2*floor(sar12_trial / 2048))*1.8
alter VD_B10 = $&sar12_drive
let sar12_drive = (floor(sar12_trial / 2048) - 2*floor(sar12_trial / 4096))*1.8
alter VD_B11 = $&sar12_drive
stop when time ge 6.874999999e-06
resume
let sar12_k = length(time)-1
if abs(time[sar12_k] - 6.875e-06) > 1e-12
print time[sar12_k]
echo expected_pause_time_s 6.875e-06
echo SAR12_PAUSE_FAILED
quit 1
end
print time[sar12_k] >> pause-times.txt
delete all
alter VD_EVAL = 1.8
stop when time ge 7.049999999e-06
resume
let sar12_k = length(time)-1
if abs(time[sar12_k] - 7.05e-06) > 1e-12
print time[sar12_k]
echo expected_pause_time_s 7.05e-06
echo SAR12_PAUSE_FAILED
quit 1
end
print time[sar12_k] >> pause-times.txt
delete all
let sar12_k = length(time)-1
let sar12_cmp = v(COMP)[sar12_k]
let sar12_cmpn = v(COMPN)[sar12_k]
let sar12_p = v(TOPP)[sar12_k]
let sar12_n = v(TOPN)[sar12_k]
let sar12_decision = 0
if sar12_cmp >= 0.9
let sar12_code = sar12_trial
let sar12_decision = 1
end
echo 0 6 $&sar12_trial $&sar12_cmp $&sar12_cmpn $&sar12_p $&sar12_n 0.00029296875 $&sar12_decision >> decisions.csv
alter VD_EVAL = 0
let sar12_trial = sar12_code + 32
let sar12_drive = (floor(sar12_trial / 1) - 2*floor(sar12_trial / 2))*1.8
alter VD_B0 = $&sar12_drive
let sar12_drive = (floor(sar12_trial / 2) - 2*floor(sar12_trial / 4))*1.8
alter VD_B1 = $&sar12_drive
let sar12_drive = (floor(sar12_trial / 4) - 2*floor(sar12_trial / 8))*1.8
alter VD_B2 = $&sar12_drive
let sar12_drive = (floor(sar12_trial / 8) - 2*floor(sar12_trial / 16))*1.8
alter VD_B3 = $&sar12_drive
let sar12_drive = (floor(sar12_trial / 16) - 2*floor(sar12_trial / 32))*1.8
alter VD_B4 = $&sar12_drive
let sar12_drive = (floor(sar12_trial / 32) - 2*floor(sar12_trial / 64))*1.8
alter VD_B5 = $&sar12_drive
let sar12_drive = (floor(sar12_trial / 64) - 2*floor(sar12_trial / 128))*1.8
alter VD_B6 = $&sar12_drive
let sar12_drive = (floor(sar12_trial / 128) - 2*floor(sar12_trial / 256))*1.8
alter VD_B7 = $&sar12_drive
let sar12_drive = (floor(sar12_trial / 256) - 2*floor(sar12_trial / 512))*1.8
alter VD_B8 = $&sar12_drive
let sar12_drive = (floor(sar12_trial / 512) - 2*floor(sar12_trial / 1024))*1.8
alter VD_B9 = $&sar12_drive
let sar12_drive = (floor(sar12_trial / 1024) - 2*floor(sar12_trial / 2048))*1.8
alter VD_B10 = $&sar12_drive
let sar12_drive = (floor(sar12_trial / 2048) - 2*floor(sar12_trial / 4096))*1.8
alter VD_B11 = $&sar12_drive
stop when time ge 7.374999999e-06
resume
let sar12_k = length(time)-1
if abs(time[sar12_k] - 7.375e-06) > 1e-12
print time[sar12_k]
echo expected_pause_time_s 7.375e-06
echo SAR12_PAUSE_FAILED
quit 1
end
print time[sar12_k] >> pause-times.txt
delete all
alter VD_EVAL = 1.8
stop when time ge 7.549999999e-06
resume
let sar12_k = length(time)-1
if abs(time[sar12_k] - 7.55e-06) > 1e-12
print time[sar12_k]
echo expected_pause_time_s 7.55e-06
echo SAR12_PAUSE_FAILED
quit 1
end
print time[sar12_k] >> pause-times.txt
delete all
let sar12_k = length(time)-1
let sar12_cmp = v(COMP)[sar12_k]
let sar12_cmpn = v(COMPN)[sar12_k]
let sar12_p = v(TOPP)[sar12_k]
let sar12_n = v(TOPN)[sar12_k]
let sar12_decision = 0
if sar12_cmp >= 0.9
let sar12_code = sar12_trial
let sar12_decision = 1
end
echo 0 5 $&sar12_trial $&sar12_cmp $&sar12_cmpn $&sar12_p $&sar12_n 0.00029296875 $&sar12_decision >> decisions.csv
alter VD_EVAL = 0
let sar12_trial = sar12_code + 16
let sar12_drive = (floor(sar12_trial / 1) - 2*floor(sar12_trial / 2))*1.8
alter VD_B0 = $&sar12_drive
let sar12_drive = (floor(sar12_trial / 2) - 2*floor(sar12_trial / 4))*1.8
alter VD_B1 = $&sar12_drive
let sar12_drive = (floor(sar12_trial / 4) - 2*floor(sar12_trial / 8))*1.8
alter VD_B2 = $&sar12_drive
let sar12_drive = (floor(sar12_trial / 8) - 2*floor(sar12_trial / 16))*1.8
alter VD_B3 = $&sar12_drive
let sar12_drive = (floor(sar12_trial / 16) - 2*floor(sar12_trial / 32))*1.8
alter VD_B4 = $&sar12_drive
let sar12_drive = (floor(sar12_trial / 32) - 2*floor(sar12_trial / 64))*1.8
alter VD_B5 = $&sar12_drive
let sar12_drive = (floor(sar12_trial / 64) - 2*floor(sar12_trial / 128))*1.8
alter VD_B6 = $&sar12_drive
let sar12_drive = (floor(sar12_trial / 128) - 2*floor(sar12_trial / 256))*1.8
alter VD_B7 = $&sar12_drive
let sar12_drive = (floor(sar12_trial / 256) - 2*floor(sar12_trial / 512))*1.8
alter VD_B8 = $&sar12_drive
let sar12_drive = (floor(sar12_trial / 512) - 2*floor(sar12_trial / 1024))*1.8
alter VD_B9 = $&sar12_drive
let sar12_drive = (floor(sar12_trial / 1024) - 2*floor(sar12_trial / 2048))*1.8
alter VD_B10 = $&sar12_drive
let sar12_drive = (floor(sar12_trial / 2048) - 2*floor(sar12_trial / 4096))*1.8
alter VD_B11 = $&sar12_drive
stop when time ge 7.874999999e-06
resume
let sar12_k = length(time)-1
if abs(time[sar12_k] - 7.875e-06) > 1e-12
print time[sar12_k]
echo expected_pause_time_s 7.875e-06
echo SAR12_PAUSE_FAILED
quit 1
end
print time[sar12_k] >> pause-times.txt
delete all
alter VD_EVAL = 1.8
stop when time ge 8.049999999e-06
resume
let sar12_k = length(time)-1
if abs(time[sar12_k] - 8.05e-06) > 1e-12
print time[sar12_k]
echo expected_pause_time_s 8.05e-06
echo SAR12_PAUSE_FAILED
quit 1
end
print time[sar12_k] >> pause-times.txt
delete all
let sar12_k = length(time)-1
let sar12_cmp = v(COMP)[sar12_k]
let sar12_cmpn = v(COMPN)[sar12_k]
let sar12_p = v(TOPP)[sar12_k]
let sar12_n = v(TOPN)[sar12_k]
let sar12_decision = 0
if sar12_cmp >= 0.9
let sar12_code = sar12_trial
let sar12_decision = 1
end
echo 0 4 $&sar12_trial $&sar12_cmp $&sar12_cmpn $&sar12_p $&sar12_n 0.00029296875 $&sar12_decision >> decisions.csv
alter VD_EVAL = 0
let sar12_trial = sar12_code + 8
let sar12_drive = (floor(sar12_trial / 1) - 2*floor(sar12_trial / 2))*1.8
alter VD_B0 = $&sar12_drive
let sar12_drive = (floor(sar12_trial / 2) - 2*floor(sar12_trial / 4))*1.8
alter VD_B1 = $&sar12_drive
let sar12_drive = (floor(sar12_trial / 4) - 2*floor(sar12_trial / 8))*1.8
alter VD_B2 = $&sar12_drive
let sar12_drive = (floor(sar12_trial / 8) - 2*floor(sar12_trial / 16))*1.8
alter VD_B3 = $&sar12_drive
let sar12_drive = (floor(sar12_trial / 16) - 2*floor(sar12_trial / 32))*1.8
alter VD_B4 = $&sar12_drive
let sar12_drive = (floor(sar12_trial / 32) - 2*floor(sar12_trial / 64))*1.8
alter VD_B5 = $&sar12_drive
let sar12_drive = (floor(sar12_trial / 64) - 2*floor(sar12_trial / 128))*1.8
alter VD_B6 = $&sar12_drive
let sar12_drive = (floor(sar12_trial / 128) - 2*floor(sar12_trial / 256))*1.8
alter VD_B7 = $&sar12_drive
let sar12_drive = (floor(sar12_trial / 256) - 2*floor(sar12_trial / 512))*1.8
alter VD_B8 = $&sar12_drive
let sar12_drive = (floor(sar12_trial / 512) - 2*floor(sar12_trial / 1024))*1.8
alter VD_B9 = $&sar12_drive
let sar12_drive = (floor(sar12_trial / 1024) - 2*floor(sar12_trial / 2048))*1.8
alter VD_B10 = $&sar12_drive
let sar12_drive = (floor(sar12_trial / 2048) - 2*floor(sar12_trial / 4096))*1.8
alter VD_B11 = $&sar12_drive
stop when time ge 8.374999999e-06
resume
let sar12_k = length(time)-1
if abs(time[sar12_k] - 8.375e-06) > 1e-12
print time[sar12_k]
echo expected_pause_time_s 8.375e-06
echo SAR12_PAUSE_FAILED
quit 1
end
print time[sar12_k] >> pause-times.txt
delete all
alter VD_EVAL = 1.8
stop when time ge 8.549999999e-06
resume
let sar12_k = length(time)-1
if abs(time[sar12_k] - 8.55e-06) > 1e-12
print time[sar12_k]
echo expected_pause_time_s 8.55e-06
echo SAR12_PAUSE_FAILED
quit 1
end
print time[sar12_k] >> pause-times.txt
delete all
let sar12_k = length(time)-1
let sar12_cmp = v(COMP)[sar12_k]
let sar12_cmpn = v(COMPN)[sar12_k]
let sar12_p = v(TOPP)[sar12_k]
let sar12_n = v(TOPN)[sar12_k]
let sar12_decision = 0
if sar12_cmp >= 0.9
let sar12_code = sar12_trial
let sar12_decision = 1
end
echo 0 3 $&sar12_trial $&sar12_cmp $&sar12_cmpn $&sar12_p $&sar12_n 0.00029296875 $&sar12_decision >> decisions.csv
alter VD_EVAL = 0
let sar12_trial = sar12_code + 4
let sar12_drive = (floor(sar12_trial / 1) - 2*floor(sar12_trial / 2))*1.8
alter VD_B0 = $&sar12_drive
let sar12_drive = (floor(sar12_trial / 2) - 2*floor(sar12_trial / 4))*1.8
alter VD_B1 = $&sar12_drive
let sar12_drive = (floor(sar12_trial / 4) - 2*floor(sar12_trial / 8))*1.8
alter VD_B2 = $&sar12_drive
let sar12_drive = (floor(sar12_trial / 8) - 2*floor(sar12_trial / 16))*1.8
alter VD_B3 = $&sar12_drive
let sar12_drive = (floor(sar12_trial / 16) - 2*floor(sar12_trial / 32))*1.8
alter VD_B4 = $&sar12_drive
let sar12_drive = (floor(sar12_trial / 32) - 2*floor(sar12_trial / 64))*1.8
alter VD_B5 = $&sar12_drive
let sar12_drive = (floor(sar12_trial / 64) - 2*floor(sar12_trial / 128))*1.8
alter VD_B6 = $&sar12_drive
let sar12_drive = (floor(sar12_trial / 128) - 2*floor(sar12_trial / 256))*1.8
alter VD_B7 = $&sar12_drive
let sar12_drive = (floor(sar12_trial / 256) - 2*floor(sar12_trial / 512))*1.8
alter VD_B8 = $&sar12_drive
let sar12_drive = (floor(sar12_trial / 512) - 2*floor(sar12_trial / 1024))*1.8
alter VD_B9 = $&sar12_drive
let sar12_drive = (floor(sar12_trial / 1024) - 2*floor(sar12_trial / 2048))*1.8
alter VD_B10 = $&sar12_drive
let sar12_drive = (floor(sar12_trial / 2048) - 2*floor(sar12_trial / 4096))*1.8
alter VD_B11 = $&sar12_drive
stop when time ge 8.874999999e-06
resume
let sar12_k = length(time)-1
if abs(time[sar12_k] - 8.875e-06) > 1e-12
print time[sar12_k]
echo expected_pause_time_s 8.875e-06
echo SAR12_PAUSE_FAILED
quit 1
end
print time[sar12_k] >> pause-times.txt
delete all
alter VD_EVAL = 1.8
stop when time ge 9.049999999e-06
resume
let sar12_k = length(time)-1
if abs(time[sar12_k] - 9.05e-06) > 1e-12
print time[sar12_k]
echo expected_pause_time_s 9.05e-06
echo SAR12_PAUSE_FAILED
quit 1
end
print time[sar12_k] >> pause-times.txt
delete all
let sar12_k = length(time)-1
let sar12_cmp = v(COMP)[sar12_k]
let sar12_cmpn = v(COMPN)[sar12_k]
let sar12_p = v(TOPP)[sar12_k]
let sar12_n = v(TOPN)[sar12_k]
let sar12_decision = 0
if sar12_cmp >= 0.9
let sar12_code = sar12_trial
let sar12_decision = 1
end
echo 0 2 $&sar12_trial $&sar12_cmp $&sar12_cmpn $&sar12_p $&sar12_n 0.00029296875 $&sar12_decision >> decisions.csv
alter VD_EVAL = 0
let sar12_trial = sar12_code + 2
let sar12_drive = (floor(sar12_trial / 1) - 2*floor(sar12_trial / 2))*1.8
alter VD_B0 = $&sar12_drive
let sar12_drive = (floor(sar12_trial / 2) - 2*floor(sar12_trial / 4))*1.8
alter VD_B1 = $&sar12_drive
let sar12_drive = (floor(sar12_trial / 4) - 2*floor(sar12_trial / 8))*1.8
alter VD_B2 = $&sar12_drive
let sar12_drive = (floor(sar12_trial / 8) - 2*floor(sar12_trial / 16))*1.8
alter VD_B3 = $&sar12_drive
let sar12_drive = (floor(sar12_trial / 16) - 2*floor(sar12_trial / 32))*1.8
alter VD_B4 = $&sar12_drive
let sar12_drive = (floor(sar12_trial / 32) - 2*floor(sar12_trial / 64))*1.8
alter VD_B5 = $&sar12_drive
let sar12_drive = (floor(sar12_trial / 64) - 2*floor(sar12_trial / 128))*1.8
alter VD_B6 = $&sar12_drive
let sar12_drive = (floor(sar12_trial / 128) - 2*floor(sar12_trial / 256))*1.8
alter VD_B7 = $&sar12_drive
let sar12_drive = (floor(sar12_trial / 256) - 2*floor(sar12_trial / 512))*1.8
alter VD_B8 = $&sar12_drive
let sar12_drive = (floor(sar12_trial / 512) - 2*floor(sar12_trial / 1024))*1.8
alter VD_B9 = $&sar12_drive
let sar12_drive = (floor(sar12_trial / 1024) - 2*floor(sar12_trial / 2048))*1.8
alter VD_B10 = $&sar12_drive
let sar12_drive = (floor(sar12_trial / 2048) - 2*floor(sar12_trial / 4096))*1.8
alter VD_B11 = $&sar12_drive
stop when time ge 9.374999999e-06
resume
let sar12_k = length(time)-1
if abs(time[sar12_k] - 9.375e-06) > 1e-12
print time[sar12_k]
echo expected_pause_time_s 9.375e-06
echo SAR12_PAUSE_FAILED
quit 1
end
print time[sar12_k] >> pause-times.txt
delete all
alter VD_EVAL = 1.8
stop when time ge 9.549999999e-06
resume
let sar12_k = length(time)-1
if abs(time[sar12_k] - 9.55e-06) > 1e-12
print time[sar12_k]
echo expected_pause_time_s 9.55e-06
echo SAR12_PAUSE_FAILED
quit 1
end
print time[sar12_k] >> pause-times.txt
delete all
let sar12_k = length(time)-1
let sar12_cmp = v(COMP)[sar12_k]
let sar12_cmpn = v(COMPN)[sar12_k]
let sar12_p = v(TOPP)[sar12_k]
let sar12_n = v(TOPN)[sar12_k]
let sar12_decision = 0
if sar12_cmp >= 0.9
let sar12_code = sar12_trial
let sar12_decision = 1
end
echo 0 1 $&sar12_trial $&sar12_cmp $&sar12_cmpn $&sar12_p $&sar12_n 0.00029296875 $&sar12_decision >> decisions.csv
alter VD_EVAL = 0
let sar12_trial = sar12_code + 1
let sar12_drive = (floor(sar12_trial / 1) - 2*floor(sar12_trial / 2))*1.8
alter VD_B0 = $&sar12_drive
let sar12_drive = (floor(sar12_trial / 2) - 2*floor(sar12_trial / 4))*1.8
alter VD_B1 = $&sar12_drive
let sar12_drive = (floor(sar12_trial / 4) - 2*floor(sar12_trial / 8))*1.8
alter VD_B2 = $&sar12_drive
let sar12_drive = (floor(sar12_trial / 8) - 2*floor(sar12_trial / 16))*1.8
alter VD_B3 = $&sar12_drive
let sar12_drive = (floor(sar12_trial / 16) - 2*floor(sar12_trial / 32))*1.8
alter VD_B4 = $&sar12_drive
let sar12_drive = (floor(sar12_trial / 32) - 2*floor(sar12_trial / 64))*1.8
alter VD_B5 = $&sar12_drive
let sar12_drive = (floor(sar12_trial / 64) - 2*floor(sar12_trial / 128))*1.8
alter VD_B6 = $&sar12_drive
let sar12_drive = (floor(sar12_trial / 128) - 2*floor(sar12_trial / 256))*1.8
alter VD_B7 = $&sar12_drive
let sar12_drive = (floor(sar12_trial / 256) - 2*floor(sar12_trial / 512))*1.8
alter VD_B8 = $&sar12_drive
let sar12_drive = (floor(sar12_trial / 512) - 2*floor(sar12_trial / 1024))*1.8
alter VD_B9 = $&sar12_drive
let sar12_drive = (floor(sar12_trial / 1024) - 2*floor(sar12_trial / 2048))*1.8
alter VD_B10 = $&sar12_drive
let sar12_drive = (floor(sar12_trial / 2048) - 2*floor(sar12_trial / 4096))*1.8
alter VD_B11 = $&sar12_drive
stop when time ge 9.874999999e-06
resume
let sar12_k = length(time)-1
if abs(time[sar12_k] - 9.875e-06) > 1e-12
print time[sar12_k]
echo expected_pause_time_s 9.875e-06
echo SAR12_PAUSE_FAILED
quit 1
end
print time[sar12_k] >> pause-times.txt
delete all
alter VD_EVAL = 1.8
stop when time ge 1.0049999999e-05
resume
let sar12_k = length(time)-1
if abs(time[sar12_k] - 1.005e-05) > 1e-12
print time[sar12_k]
echo expected_pause_time_s 1.005e-05
echo SAR12_PAUSE_FAILED
quit 1
end
print time[sar12_k] >> pause-times.txt
delete all
let sar12_k = length(time)-1
let sar12_cmp = v(COMP)[sar12_k]
let sar12_cmpn = v(COMPN)[sar12_k]
let sar12_p = v(TOPP)[sar12_k]
let sar12_n = v(TOPN)[sar12_k]
let sar12_decision = 0
if sar12_cmp >= 0.9
let sar12_code = sar12_trial
let sar12_decision = 1
end
echo 0 0 $&sar12_trial $&sar12_cmp $&sar12_cmpn $&sar12_p $&sar12_n 0.00029296875 $&sar12_decision >> decisions.csv
alter VD_EVAL = 0
alter VINP = 0.300146484375
alter VINN = 1.49985351562
alter VD_SAMPLE = 1.8
alter VD_EVAL = 0
alter VD_B0 = 0
alter VD_B1 = 0
alter VD_B2 = 0
alter VD_B3 = 0
alter VD_B4 = 0
alter VD_B5 = 0
alter VD_B6 = 0
alter VD_B7 = 0
alter VD_B8 = 0
alter VD_B9 = 0
alter VD_B10 = 0
alter VD_B11 = 0
let sar12_code = 0
stop when time ge 1.4049999999e-05
resume
let sar12_k = length(time)-1
if abs(time[sar12_k] - 1.405e-05) > 1e-12
print time[sar12_k]
echo expected_pause_time_s 1.405e-05
echo SAR12_PAUSE_FAILED
quit 1
end
print time[sar12_k] >> pause-times.txt
delete all
alter VD_SAMPLE = 0
stop when time ge 1.4099999999e-05
resume
let sar12_k = length(time)-1
if abs(time[sar12_k] - 1.41e-05) > 1e-12
print time[sar12_k]
echo expected_pause_time_s 1.41e-05
echo SAR12_PAUSE_FAILED
quit 1
end
print time[sar12_k] >> pause-times.txt
delete all
alter VD_EVAL = 0
let sar12_trial = sar12_code + 2048
let sar12_drive = (floor(sar12_trial / 1) - 2*floor(sar12_trial / 2))*1.8
alter VD_B0 = $&sar12_drive
let sar12_drive = (floor(sar12_trial / 2) - 2*floor(sar12_trial / 4))*1.8
alter VD_B1 = $&sar12_drive
let sar12_drive = (floor(sar12_trial / 4) - 2*floor(sar12_trial / 8))*1.8
alter VD_B2 = $&sar12_drive
let sar12_drive = (floor(sar12_trial / 8) - 2*floor(sar12_trial / 16))*1.8
alter VD_B3 = $&sar12_drive
let sar12_drive = (floor(sar12_trial / 16) - 2*floor(sar12_trial / 32))*1.8
alter VD_B4 = $&sar12_drive
let sar12_drive = (floor(sar12_trial / 32) - 2*floor(sar12_trial / 64))*1.8
alter VD_B5 = $&sar12_drive
let sar12_drive = (floor(sar12_trial / 64) - 2*floor(sar12_trial / 128))*1.8
alter VD_B6 = $&sar12_drive
let sar12_drive = (floor(sar12_trial / 128) - 2*floor(sar12_trial / 256))*1.8
alter VD_B7 = $&sar12_drive
let sar12_drive = (floor(sar12_trial / 256) - 2*floor(sar12_trial / 512))*1.8
alter VD_B8 = $&sar12_drive
let sar12_drive = (floor(sar12_trial / 512) - 2*floor(sar12_trial / 1024))*1.8
alter VD_B9 = $&sar12_drive
let sar12_drive = (floor(sar12_trial / 1024) - 2*floor(sar12_trial / 2048))*1.8
alter VD_B10 = $&sar12_drive
let sar12_drive = (floor(sar12_trial / 2048) - 2*floor(sar12_trial / 4096))*1.8
alter VD_B11 = $&sar12_drive
stop when time ge 1.4424999999e-05
resume
let sar12_k = length(time)-1
if abs(time[sar12_k] - 1.4425e-05) > 1e-12
print time[sar12_k]
echo expected_pause_time_s 1.4425e-05
echo SAR12_PAUSE_FAILED
quit 1
end
print time[sar12_k] >> pause-times.txt
delete all
alter VD_EVAL = 1.8
stop when time ge 1.4599999999e-05
resume
let sar12_k = length(time)-1
if abs(time[sar12_k] - 1.46e-05) > 1e-12
print time[sar12_k]
echo expected_pause_time_s 1.46e-05
echo SAR12_PAUSE_FAILED
quit 1
end
print time[sar12_k] >> pause-times.txt
delete all
let sar12_k = length(time)-1
let sar12_cmp = v(COMP)[sar12_k]
let sar12_cmpn = v(COMPN)[sar12_k]
let sar12_p = v(TOPP)[sar12_k]
let sar12_n = v(TOPN)[sar12_k]
let sar12_decision = 0
if sar12_cmp >= 0.9
let sar12_code = sar12_trial
let sar12_decision = 1
end
echo 1 11 $&sar12_trial $&sar12_cmp $&sar12_cmpn $&sar12_p $&sar12_n -1.19970703125 $&sar12_decision >> decisions.csv
alter VD_EVAL = 0
let sar12_trial = sar12_code + 1024
let sar12_drive = (floor(sar12_trial / 1) - 2*floor(sar12_trial / 2))*1.8
alter VD_B0 = $&sar12_drive
let sar12_drive = (floor(sar12_trial / 2) - 2*floor(sar12_trial / 4))*1.8
alter VD_B1 = $&sar12_drive
let sar12_drive = (floor(sar12_trial / 4) - 2*floor(sar12_trial / 8))*1.8
alter VD_B2 = $&sar12_drive
let sar12_drive = (floor(sar12_trial / 8) - 2*floor(sar12_trial / 16))*1.8
alter VD_B3 = $&sar12_drive
let sar12_drive = (floor(sar12_trial / 16) - 2*floor(sar12_trial / 32))*1.8
alter VD_B4 = $&sar12_drive
let sar12_drive = (floor(sar12_trial / 32) - 2*floor(sar12_trial / 64))*1.8
alter VD_B5 = $&sar12_drive
let sar12_drive = (floor(sar12_trial / 64) - 2*floor(sar12_trial / 128))*1.8
alter VD_B6 = $&sar12_drive
let sar12_drive = (floor(sar12_trial / 128) - 2*floor(sar12_trial / 256))*1.8
alter VD_B7 = $&sar12_drive
let sar12_drive = (floor(sar12_trial / 256) - 2*floor(sar12_trial / 512))*1.8
alter VD_B8 = $&sar12_drive
let sar12_drive = (floor(sar12_trial / 512) - 2*floor(sar12_trial / 1024))*1.8
alter VD_B9 = $&sar12_drive
let sar12_drive = (floor(sar12_trial / 1024) - 2*floor(sar12_trial / 2048))*1.8
alter VD_B10 = $&sar12_drive
let sar12_drive = (floor(sar12_trial / 2048) - 2*floor(sar12_trial / 4096))*1.8
alter VD_B11 = $&sar12_drive
stop when time ge 1.4924999999e-05
resume
let sar12_k = length(time)-1
if abs(time[sar12_k] - 1.4925e-05) > 1e-12
print time[sar12_k]
echo expected_pause_time_s 1.4925e-05
echo SAR12_PAUSE_FAILED
quit 1
end
print time[sar12_k] >> pause-times.txt
delete all
alter VD_EVAL = 1.8
stop when time ge 1.5099999999e-05
resume
let sar12_k = length(time)-1
if abs(time[sar12_k] - 1.51e-05) > 1e-12
print time[sar12_k]
echo expected_pause_time_s 1.51e-05
echo SAR12_PAUSE_FAILED
quit 1
end
print time[sar12_k] >> pause-times.txt
delete all
let sar12_k = length(time)-1
let sar12_cmp = v(COMP)[sar12_k]
let sar12_cmpn = v(COMPN)[sar12_k]
let sar12_p = v(TOPP)[sar12_k]
let sar12_n = v(TOPN)[sar12_k]
let sar12_decision = 0
if sar12_cmp >= 0.9
let sar12_code = sar12_trial
let sar12_decision = 1
end
echo 1 10 $&sar12_trial $&sar12_cmp $&sar12_cmpn $&sar12_p $&sar12_n -1.19970703125 $&sar12_decision >> decisions.csv
alter VD_EVAL = 0
let sar12_trial = sar12_code + 512
let sar12_drive = (floor(sar12_trial / 1) - 2*floor(sar12_trial / 2))*1.8
alter VD_B0 = $&sar12_drive
let sar12_drive = (floor(sar12_trial / 2) - 2*floor(sar12_trial / 4))*1.8
alter VD_B1 = $&sar12_drive
let sar12_drive = (floor(sar12_trial / 4) - 2*floor(sar12_trial / 8))*1.8
alter VD_B2 = $&sar12_drive
let sar12_drive = (floor(sar12_trial / 8) - 2*floor(sar12_trial / 16))*1.8
alter VD_B3 = $&sar12_drive
let sar12_drive = (floor(sar12_trial / 16) - 2*floor(sar12_trial / 32))*1.8
alter VD_B4 = $&sar12_drive
let sar12_drive = (floor(sar12_trial / 32) - 2*floor(sar12_trial / 64))*1.8
alter VD_B5 = $&sar12_drive
let sar12_drive = (floor(sar12_trial / 64) - 2*floor(sar12_trial / 128))*1.8
alter VD_B6 = $&sar12_drive
let sar12_drive = (floor(sar12_trial / 128) - 2*floor(sar12_trial / 256))*1.8
alter VD_B7 = $&sar12_drive
let sar12_drive = (floor(sar12_trial / 256) - 2*floor(sar12_trial / 512))*1.8
alter VD_B8 = $&sar12_drive
let sar12_drive = (floor(sar12_trial / 512) - 2*floor(sar12_trial / 1024))*1.8
alter VD_B9 = $&sar12_drive
let sar12_drive = (floor(sar12_trial / 1024) - 2*floor(sar12_trial / 2048))*1.8
alter VD_B10 = $&sar12_drive
let sar12_drive = (floor(sar12_trial / 2048) - 2*floor(sar12_trial / 4096))*1.8
alter VD_B11 = $&sar12_drive
stop when time ge 1.5424999999e-05
resume
let sar12_k = length(time)-1
if abs(time[sar12_k] - 1.5425e-05) > 1e-12
print time[sar12_k]
echo expected_pause_time_s 1.5425e-05
echo SAR12_PAUSE_FAILED
quit 1
end
print time[sar12_k] >> pause-times.txt
delete all
alter VD_EVAL = 1.8
stop when time ge 1.5599999999e-05
resume
let sar12_k = length(time)-1
if abs(time[sar12_k] - 1.56e-05) > 1e-12
print time[sar12_k]
echo expected_pause_time_s 1.56e-05
echo SAR12_PAUSE_FAILED
quit 1
end
print time[sar12_k] >> pause-times.txt
delete all
let sar12_k = length(time)-1
let sar12_cmp = v(COMP)[sar12_k]
let sar12_cmpn = v(COMPN)[sar12_k]
let sar12_p = v(TOPP)[sar12_k]
let sar12_n = v(TOPN)[sar12_k]
let sar12_decision = 0
if sar12_cmp >= 0.9
let sar12_code = sar12_trial
let sar12_decision = 1
end
echo 1 9 $&sar12_trial $&sar12_cmp $&sar12_cmpn $&sar12_p $&sar12_n -1.19970703125 $&sar12_decision >> decisions.csv
alter VD_EVAL = 0
let sar12_trial = sar12_code + 256
let sar12_drive = (floor(sar12_trial / 1) - 2*floor(sar12_trial / 2))*1.8
alter VD_B0 = $&sar12_drive
let sar12_drive = (floor(sar12_trial / 2) - 2*floor(sar12_trial / 4))*1.8
alter VD_B1 = $&sar12_drive
let sar12_drive = (floor(sar12_trial / 4) - 2*floor(sar12_trial / 8))*1.8
alter VD_B2 = $&sar12_drive
let sar12_drive = (floor(sar12_trial / 8) - 2*floor(sar12_trial / 16))*1.8
alter VD_B3 = $&sar12_drive
let sar12_drive = (floor(sar12_trial / 16) - 2*floor(sar12_trial / 32))*1.8
alter VD_B4 = $&sar12_drive
let sar12_drive = (floor(sar12_trial / 32) - 2*floor(sar12_trial / 64))*1.8
alter VD_B5 = $&sar12_drive
let sar12_drive = (floor(sar12_trial / 64) - 2*floor(sar12_trial / 128))*1.8
alter VD_B6 = $&sar12_drive
let sar12_drive = (floor(sar12_trial / 128) - 2*floor(sar12_trial / 256))*1.8
alter VD_B7 = $&sar12_drive
let sar12_drive = (floor(sar12_trial / 256) - 2*floor(sar12_trial / 512))*1.8
alter VD_B8 = $&sar12_drive
let sar12_drive = (floor(sar12_trial / 512) - 2*floor(sar12_trial / 1024))*1.8
alter VD_B9 = $&sar12_drive
let sar12_drive = (floor(sar12_trial / 1024) - 2*floor(sar12_trial / 2048))*1.8
alter VD_B10 = $&sar12_drive
let sar12_drive = (floor(sar12_trial / 2048) - 2*floor(sar12_trial / 4096))*1.8
alter VD_B11 = $&sar12_drive
stop when time ge 1.5924999999e-05
resume
let sar12_k = length(time)-1
if abs(time[sar12_k] - 1.5925e-05) > 1e-12
print time[sar12_k]
echo expected_pause_time_s 1.5925e-05
echo SAR12_PAUSE_FAILED
quit 1
end
print time[sar12_k] >> pause-times.txt
delete all
alter VD_EVAL = 1.8
stop when time ge 1.6099999999e-05
resume
let sar12_k = length(time)-1
if abs(time[sar12_k] - 1.61e-05) > 1e-12
print time[sar12_k]
echo expected_pause_time_s 1.61e-05
echo SAR12_PAUSE_FAILED
quit 1
end
print time[sar12_k] >> pause-times.txt
delete all
let sar12_k = length(time)-1
let sar12_cmp = v(COMP)[sar12_k]
let sar12_cmpn = v(COMPN)[sar12_k]
let sar12_p = v(TOPP)[sar12_k]
let sar12_n = v(TOPN)[sar12_k]
let sar12_decision = 0
if sar12_cmp >= 0.9
let sar12_code = sar12_trial
let sar12_decision = 1
end
echo 1 8 $&sar12_trial $&sar12_cmp $&sar12_cmpn $&sar12_p $&sar12_n -1.19970703125 $&sar12_decision >> decisions.csv
alter VD_EVAL = 0
let sar12_trial = sar12_code + 128
let sar12_drive = (floor(sar12_trial / 1) - 2*floor(sar12_trial / 2))*1.8
alter VD_B0 = $&sar12_drive
let sar12_drive = (floor(sar12_trial / 2) - 2*floor(sar12_trial / 4))*1.8
alter VD_B1 = $&sar12_drive
let sar12_drive = (floor(sar12_trial / 4) - 2*floor(sar12_trial / 8))*1.8
alter VD_B2 = $&sar12_drive
let sar12_drive = (floor(sar12_trial / 8) - 2*floor(sar12_trial / 16))*1.8
alter VD_B3 = $&sar12_drive
let sar12_drive = (floor(sar12_trial / 16) - 2*floor(sar12_trial / 32))*1.8
alter VD_B4 = $&sar12_drive
let sar12_drive = (floor(sar12_trial / 32) - 2*floor(sar12_trial / 64))*1.8
alter VD_B5 = $&sar12_drive
let sar12_drive = (floor(sar12_trial / 64) - 2*floor(sar12_trial / 128))*1.8
alter VD_B6 = $&sar12_drive
let sar12_drive = (floor(sar12_trial / 128) - 2*floor(sar12_trial / 256))*1.8
alter VD_B7 = $&sar12_drive
let sar12_drive = (floor(sar12_trial / 256) - 2*floor(sar12_trial / 512))*1.8
alter VD_B8 = $&sar12_drive
let sar12_drive = (floor(sar12_trial / 512) - 2*floor(sar12_trial / 1024))*1.8
alter VD_B9 = $&sar12_drive
let sar12_drive = (floor(sar12_trial / 1024) - 2*floor(sar12_trial / 2048))*1.8
alter VD_B10 = $&sar12_drive
let sar12_drive = (floor(sar12_trial / 2048) - 2*floor(sar12_trial / 4096))*1.8
alter VD_B11 = $&sar12_drive
stop when time ge 1.6424999999e-05
resume
let sar12_k = length(time)-1
if abs(time[sar12_k] - 1.6425e-05) > 1e-12
print time[sar12_k]
echo expected_pause_time_s 1.6425e-05
echo SAR12_PAUSE_FAILED
quit 1
end
print time[sar12_k] >> pause-times.txt
delete all
alter VD_EVAL = 1.8
stop when time ge 1.6599999999e-05
resume
let sar12_k = length(time)-1
if abs(time[sar12_k] - 1.66e-05) > 1e-12
print time[sar12_k]
echo expected_pause_time_s 1.66e-05
echo SAR12_PAUSE_FAILED
quit 1
end
print time[sar12_k] >> pause-times.txt
delete all
let sar12_k = length(time)-1
let sar12_cmp = v(COMP)[sar12_k]
let sar12_cmpn = v(COMPN)[sar12_k]
let sar12_p = v(TOPP)[sar12_k]
let sar12_n = v(TOPN)[sar12_k]
let sar12_decision = 0
if sar12_cmp >= 0.9
let sar12_code = sar12_trial
let sar12_decision = 1
end
echo 1 7 $&sar12_trial $&sar12_cmp $&sar12_cmpn $&sar12_p $&sar12_n -1.19970703125 $&sar12_decision >> decisions.csv
alter VD_EVAL = 0
let sar12_trial = sar12_code + 64
let sar12_drive = (floor(sar12_trial / 1) - 2*floor(sar12_trial / 2))*1.8
alter VD_B0 = $&sar12_drive
let sar12_drive = (floor(sar12_trial / 2) - 2*floor(sar12_trial / 4))*1.8
alter VD_B1 = $&sar12_drive
let sar12_drive = (floor(sar12_trial / 4) - 2*floor(sar12_trial / 8))*1.8
alter VD_B2 = $&sar12_drive
let sar12_drive = (floor(sar12_trial / 8) - 2*floor(sar12_trial / 16))*1.8
alter VD_B3 = $&sar12_drive
let sar12_drive = (floor(sar12_trial / 16) - 2*floor(sar12_trial / 32))*1.8
alter VD_B4 = $&sar12_drive
let sar12_drive = (floor(sar12_trial / 32) - 2*floor(sar12_trial / 64))*1.8
alter VD_B5 = $&sar12_drive
let sar12_drive = (floor(sar12_trial / 64) - 2*floor(sar12_trial / 128))*1.8
alter VD_B6 = $&sar12_drive
let sar12_drive = (floor(sar12_trial / 128) - 2*floor(sar12_trial / 256))*1.8
alter VD_B7 = $&sar12_drive
let sar12_drive = (floor(sar12_trial / 256) - 2*floor(sar12_trial / 512))*1.8
alter VD_B8 = $&sar12_drive
let sar12_drive = (floor(sar12_trial / 512) - 2*floor(sar12_trial / 1024))*1.8
alter VD_B9 = $&sar12_drive
let sar12_drive = (floor(sar12_trial / 1024) - 2*floor(sar12_trial / 2048))*1.8
alter VD_B10 = $&sar12_drive
let sar12_drive = (floor(sar12_trial / 2048) - 2*floor(sar12_trial / 4096))*1.8
alter VD_B11 = $&sar12_drive
stop when time ge 1.6924999999e-05
resume
let sar12_k = length(time)-1
if abs(time[sar12_k] - 1.6925e-05) > 1e-12
print time[sar12_k]
echo expected_pause_time_s 1.6925e-05
echo SAR12_PAUSE_FAILED
quit 1
end
print time[sar12_k] >> pause-times.txt
delete all
alter VD_EVAL = 1.8
stop when time ge 1.7099999999e-05
resume
let sar12_k = length(time)-1
if abs(time[sar12_k] - 1.71e-05) > 1e-12
print time[sar12_k]
echo expected_pause_time_s 1.71e-05
echo SAR12_PAUSE_FAILED
quit 1
end
print time[sar12_k] >> pause-times.txt
delete all
let sar12_k = length(time)-1
let sar12_cmp = v(COMP)[sar12_k]
let sar12_cmpn = v(COMPN)[sar12_k]
let sar12_p = v(TOPP)[sar12_k]
let sar12_n = v(TOPN)[sar12_k]
let sar12_decision = 0
if sar12_cmp >= 0.9
let sar12_code = sar12_trial
let sar12_decision = 1
end
echo 1 6 $&sar12_trial $&sar12_cmp $&sar12_cmpn $&sar12_p $&sar12_n -1.19970703125 $&sar12_decision >> decisions.csv
alter VD_EVAL = 0
let sar12_trial = sar12_code + 32
let sar12_drive = (floor(sar12_trial / 1) - 2*floor(sar12_trial / 2))*1.8
alter VD_B0 = $&sar12_drive
let sar12_drive = (floor(sar12_trial / 2) - 2*floor(sar12_trial / 4))*1.8
alter VD_B1 = $&sar12_drive
let sar12_drive = (floor(sar12_trial / 4) - 2*floor(sar12_trial / 8))*1.8
alter VD_B2 = $&sar12_drive
let sar12_drive = (floor(sar12_trial / 8) - 2*floor(sar12_trial / 16))*1.8
alter VD_B3 = $&sar12_drive
let sar12_drive = (floor(sar12_trial / 16) - 2*floor(sar12_trial / 32))*1.8
alter VD_B4 = $&sar12_drive
let sar12_drive = (floor(sar12_trial / 32) - 2*floor(sar12_trial / 64))*1.8
alter VD_B5 = $&sar12_drive
let sar12_drive = (floor(sar12_trial / 64) - 2*floor(sar12_trial / 128))*1.8
alter VD_B6 = $&sar12_drive
let sar12_drive = (floor(sar12_trial / 128) - 2*floor(sar12_trial / 256))*1.8
alter VD_B7 = $&sar12_drive
let sar12_drive = (floor(sar12_trial / 256) - 2*floor(sar12_trial / 512))*1.8
alter VD_B8 = $&sar12_drive
let sar12_drive = (floor(sar12_trial / 512) - 2*floor(sar12_trial / 1024))*1.8
alter VD_B9 = $&sar12_drive
let sar12_drive = (floor(sar12_trial / 1024) - 2*floor(sar12_trial / 2048))*1.8
alter VD_B10 = $&sar12_drive
let sar12_drive = (floor(sar12_trial / 2048) - 2*floor(sar12_trial / 4096))*1.8
alter VD_B11 = $&sar12_drive
stop when time ge 1.7424999999e-05
resume
let sar12_k = length(time)-1
if abs(time[sar12_k] - 1.7425e-05) > 1e-12
print time[sar12_k]
echo expected_pause_time_s 1.7425e-05
echo SAR12_PAUSE_FAILED
quit 1
end
print time[sar12_k] >> pause-times.txt
delete all
alter VD_EVAL = 1.8
stop when time ge 1.7599999999e-05
resume
let sar12_k = length(time)-1
if abs(time[sar12_k] - 1.76e-05) > 1e-12
print time[sar12_k]
echo expected_pause_time_s 1.76e-05
echo SAR12_PAUSE_FAILED
quit 1
end
print time[sar12_k] >> pause-times.txt
delete all
let sar12_k = length(time)-1
let sar12_cmp = v(COMP)[sar12_k]
let sar12_cmpn = v(COMPN)[sar12_k]
let sar12_p = v(TOPP)[sar12_k]
let sar12_n = v(TOPN)[sar12_k]
let sar12_decision = 0
if sar12_cmp >= 0.9
let sar12_code = sar12_trial
let sar12_decision = 1
end
echo 1 5 $&sar12_trial $&sar12_cmp $&sar12_cmpn $&sar12_p $&sar12_n -1.19970703125 $&sar12_decision >> decisions.csv
alter VD_EVAL = 0
let sar12_trial = sar12_code + 16
let sar12_drive = (floor(sar12_trial / 1) - 2*floor(sar12_trial / 2))*1.8
alter VD_B0 = $&sar12_drive
let sar12_drive = (floor(sar12_trial / 2) - 2*floor(sar12_trial / 4))*1.8
alter VD_B1 = $&sar12_drive
let sar12_drive = (floor(sar12_trial / 4) - 2*floor(sar12_trial / 8))*1.8
alter VD_B2 = $&sar12_drive
let sar12_drive = (floor(sar12_trial / 8) - 2*floor(sar12_trial / 16))*1.8
alter VD_B3 = $&sar12_drive
let sar12_drive = (floor(sar12_trial / 16) - 2*floor(sar12_trial / 32))*1.8
alter VD_B4 = $&sar12_drive
let sar12_drive = (floor(sar12_trial / 32) - 2*floor(sar12_trial / 64))*1.8
alter VD_B5 = $&sar12_drive
let sar12_drive = (floor(sar12_trial / 64) - 2*floor(sar12_trial / 128))*1.8
alter VD_B6 = $&sar12_drive
let sar12_drive = (floor(sar12_trial / 128) - 2*floor(sar12_trial / 256))*1.8
alter VD_B7 = $&sar12_drive
let sar12_drive = (floor(sar12_trial / 256) - 2*floor(sar12_trial / 512))*1.8
alter VD_B8 = $&sar12_drive
let sar12_drive = (floor(sar12_trial / 512) - 2*floor(sar12_trial / 1024))*1.8
alter VD_B9 = $&sar12_drive
let sar12_drive = (floor(sar12_trial / 1024) - 2*floor(sar12_trial / 2048))*1.8
alter VD_B10 = $&sar12_drive
let sar12_drive = (floor(sar12_trial / 2048) - 2*floor(sar12_trial / 4096))*1.8
alter VD_B11 = $&sar12_drive
stop when time ge 1.7924999999e-05
resume
let sar12_k = length(time)-1
if abs(time[sar12_k] - 1.7925e-05) > 1e-12
print time[sar12_k]
echo expected_pause_time_s 1.7925e-05
echo SAR12_PAUSE_FAILED
quit 1
end
print time[sar12_k] >> pause-times.txt
delete all
alter VD_EVAL = 1.8
stop when time ge 1.8099999999e-05
resume
let sar12_k = length(time)-1
if abs(time[sar12_k] - 1.81e-05) > 1e-12
print time[sar12_k]
echo expected_pause_time_s 1.81e-05
echo SAR12_PAUSE_FAILED
quit 1
end
print time[sar12_k] >> pause-times.txt
delete all
let sar12_k = length(time)-1
let sar12_cmp = v(COMP)[sar12_k]
let sar12_cmpn = v(COMPN)[sar12_k]
let sar12_p = v(TOPP)[sar12_k]
let sar12_n = v(TOPN)[sar12_k]
let sar12_decision = 0
if sar12_cmp >= 0.9
let sar12_code = sar12_trial
let sar12_decision = 1
end
echo 1 4 $&sar12_trial $&sar12_cmp $&sar12_cmpn $&sar12_p $&sar12_n -1.19970703125 $&sar12_decision >> decisions.csv
alter VD_EVAL = 0
let sar12_trial = sar12_code + 8
let sar12_drive = (floor(sar12_trial / 1) - 2*floor(sar12_trial / 2))*1.8
alter VD_B0 = $&sar12_drive
let sar12_drive = (floor(sar12_trial / 2) - 2*floor(sar12_trial / 4))*1.8
alter VD_B1 = $&sar12_drive
let sar12_drive = (floor(sar12_trial / 4) - 2*floor(sar12_trial / 8))*1.8
alter VD_B2 = $&sar12_drive
let sar12_drive = (floor(sar12_trial / 8) - 2*floor(sar12_trial / 16))*1.8
alter VD_B3 = $&sar12_drive
let sar12_drive = (floor(sar12_trial / 16) - 2*floor(sar12_trial / 32))*1.8
alter VD_B4 = $&sar12_drive
let sar12_drive = (floor(sar12_trial / 32) - 2*floor(sar12_trial / 64))*1.8
alter VD_B5 = $&sar12_drive
let sar12_drive = (floor(sar12_trial / 64) - 2*floor(sar12_trial / 128))*1.8
alter VD_B6 = $&sar12_drive
let sar12_drive = (floor(sar12_trial / 128) - 2*floor(sar12_trial / 256))*1.8
alter VD_B7 = $&sar12_drive
let sar12_drive = (floor(sar12_trial / 256) - 2*floor(sar12_trial / 512))*1.8
alter VD_B8 = $&sar12_drive
let sar12_drive = (floor(sar12_trial / 512) - 2*floor(sar12_trial / 1024))*1.8
alter VD_B9 = $&sar12_drive
let sar12_drive = (floor(sar12_trial / 1024) - 2*floor(sar12_trial / 2048))*1.8
alter VD_B10 = $&sar12_drive
let sar12_drive = (floor(sar12_trial / 2048) - 2*floor(sar12_trial / 4096))*1.8
alter VD_B11 = $&sar12_drive
stop when time ge 1.8424999999e-05
resume
let sar12_k = length(time)-1
if abs(time[sar12_k] - 1.8425e-05) > 1e-12
print time[sar12_k]
echo expected_pause_time_s 1.8425e-05
echo SAR12_PAUSE_FAILED
quit 1
end
print time[sar12_k] >> pause-times.txt
delete all
alter VD_EVAL = 1.8
stop when time ge 1.8599999999e-05
resume
let sar12_k = length(time)-1
if abs(time[sar12_k] - 1.86e-05) > 1e-12
print time[sar12_k]
echo expected_pause_time_s 1.86e-05
echo SAR12_PAUSE_FAILED
quit 1
end
print time[sar12_k] >> pause-times.txt
delete all
let sar12_k = length(time)-1
let sar12_cmp = v(COMP)[sar12_k]
let sar12_cmpn = v(COMPN)[sar12_k]
let sar12_p = v(TOPP)[sar12_k]
let sar12_n = v(TOPN)[sar12_k]
let sar12_decision = 0
if sar12_cmp >= 0.9
let sar12_code = sar12_trial
let sar12_decision = 1
end
echo 1 3 $&sar12_trial $&sar12_cmp $&sar12_cmpn $&sar12_p $&sar12_n -1.19970703125 $&sar12_decision >> decisions.csv
alter VD_EVAL = 0
let sar12_trial = sar12_code + 4
let sar12_drive = (floor(sar12_trial / 1) - 2*floor(sar12_trial / 2))*1.8
alter VD_B0 = $&sar12_drive
let sar12_drive = (floor(sar12_trial / 2) - 2*floor(sar12_trial / 4))*1.8
alter VD_B1 = $&sar12_drive
let sar12_drive = (floor(sar12_trial / 4) - 2*floor(sar12_trial / 8))*1.8
alter VD_B2 = $&sar12_drive
let sar12_drive = (floor(sar12_trial / 8) - 2*floor(sar12_trial / 16))*1.8
alter VD_B3 = $&sar12_drive
let sar12_drive = (floor(sar12_trial / 16) - 2*floor(sar12_trial / 32))*1.8
alter VD_B4 = $&sar12_drive
let sar12_drive = (floor(sar12_trial / 32) - 2*floor(sar12_trial / 64))*1.8
alter VD_B5 = $&sar12_drive
let sar12_drive = (floor(sar12_trial / 64) - 2*floor(sar12_trial / 128))*1.8
alter VD_B6 = $&sar12_drive
let sar12_drive = (floor(sar12_trial / 128) - 2*floor(sar12_trial / 256))*1.8
alter VD_B7 = $&sar12_drive
let sar12_drive = (floor(sar12_trial / 256) - 2*floor(sar12_trial / 512))*1.8
alter VD_B8 = $&sar12_drive
let sar12_drive = (floor(sar12_trial / 512) - 2*floor(sar12_trial / 1024))*1.8
alter VD_B9 = $&sar12_drive
let sar12_drive = (floor(sar12_trial / 1024) - 2*floor(sar12_trial / 2048))*1.8
alter VD_B10 = $&sar12_drive
let sar12_drive = (floor(sar12_trial / 2048) - 2*floor(sar12_trial / 4096))*1.8
alter VD_B11 = $&sar12_drive
stop when time ge 1.8924999999e-05
resume
let sar12_k = length(time)-1
if abs(time[sar12_k] - 1.8925e-05) > 1e-12
print time[sar12_k]
echo expected_pause_time_s 1.8925e-05
echo SAR12_PAUSE_FAILED
quit 1
end
print time[sar12_k] >> pause-times.txt
delete all
alter VD_EVAL = 1.8
stop when time ge 1.9099999999e-05
resume
let sar12_k = length(time)-1
if abs(time[sar12_k] - 1.91e-05) > 1e-12
print time[sar12_k]
echo expected_pause_time_s 1.91e-05
echo SAR12_PAUSE_FAILED
quit 1
end
print time[sar12_k] >> pause-times.txt
delete all
let sar12_k = length(time)-1
let sar12_cmp = v(COMP)[sar12_k]
let sar12_cmpn = v(COMPN)[sar12_k]
let sar12_p = v(TOPP)[sar12_k]
let sar12_n = v(TOPN)[sar12_k]
let sar12_decision = 0
if sar12_cmp >= 0.9
let sar12_code = sar12_trial
let sar12_decision = 1
end
echo 1 2 $&sar12_trial $&sar12_cmp $&sar12_cmpn $&sar12_p $&sar12_n -1.19970703125 $&sar12_decision >> decisions.csv
alter VD_EVAL = 0
let sar12_trial = sar12_code + 2
let sar12_drive = (floor(sar12_trial / 1) - 2*floor(sar12_trial / 2))*1.8
alter VD_B0 = $&sar12_drive
let sar12_drive = (floor(sar12_trial / 2) - 2*floor(sar12_trial / 4))*1.8
alter VD_B1 = $&sar12_drive
let sar12_drive = (floor(sar12_trial / 4) - 2*floor(sar12_trial / 8))*1.8
alter VD_B2 = $&sar12_drive
let sar12_drive = (floor(sar12_trial / 8) - 2*floor(sar12_trial / 16))*1.8
alter VD_B3 = $&sar12_drive
let sar12_drive = (floor(sar12_trial / 16) - 2*floor(sar12_trial / 32))*1.8
alter VD_B4 = $&sar12_drive
let sar12_drive = (floor(sar12_trial / 32) - 2*floor(sar12_trial / 64))*1.8
alter VD_B5 = $&sar12_drive
let sar12_drive = (floor(sar12_trial / 64) - 2*floor(sar12_trial / 128))*1.8
alter VD_B6 = $&sar12_drive
let sar12_drive = (floor(sar12_trial / 128) - 2*floor(sar12_trial / 256))*1.8
alter VD_B7 = $&sar12_drive
let sar12_drive = (floor(sar12_trial / 256) - 2*floor(sar12_trial / 512))*1.8
alter VD_B8 = $&sar12_drive
let sar12_drive = (floor(sar12_trial / 512) - 2*floor(sar12_trial / 1024))*1.8
alter VD_B9 = $&sar12_drive
let sar12_drive = (floor(sar12_trial / 1024) - 2*floor(sar12_trial / 2048))*1.8
alter VD_B10 = $&sar12_drive
let sar12_drive = (floor(sar12_trial / 2048) - 2*floor(sar12_trial / 4096))*1.8
alter VD_B11 = $&sar12_drive
stop when time ge 1.9424999999e-05
resume
let sar12_k = length(time)-1
if abs(time[sar12_k] - 1.9425e-05) > 1e-12
print time[sar12_k]
echo expected_pause_time_s 1.9425e-05
echo SAR12_PAUSE_FAILED
quit 1
end
print time[sar12_k] >> pause-times.txt
delete all
alter VD_EVAL = 1.8
stop when time ge 1.9599999999e-05
resume
let sar12_k = length(time)-1
if abs(time[sar12_k] - 1.96e-05) > 1e-12
print time[sar12_k]
echo expected_pause_time_s 1.96e-05
echo SAR12_PAUSE_FAILED
quit 1
end
print time[sar12_k] >> pause-times.txt
delete all
let sar12_k = length(time)-1
let sar12_cmp = v(COMP)[sar12_k]
let sar12_cmpn = v(COMPN)[sar12_k]
let sar12_p = v(TOPP)[sar12_k]
let sar12_n = v(TOPN)[sar12_k]
let sar12_decision = 0
if sar12_cmp >= 0.9
let sar12_code = sar12_trial
let sar12_decision = 1
end
echo 1 1 $&sar12_trial $&sar12_cmp $&sar12_cmpn $&sar12_p $&sar12_n -1.19970703125 $&sar12_decision >> decisions.csv
alter VD_EVAL = 0
let sar12_trial = sar12_code + 1
let sar12_drive = (floor(sar12_trial / 1) - 2*floor(sar12_trial / 2))*1.8
alter VD_B0 = $&sar12_drive
let sar12_drive = (floor(sar12_trial / 2) - 2*floor(sar12_trial / 4))*1.8
alter VD_B1 = $&sar12_drive
let sar12_drive = (floor(sar12_trial / 4) - 2*floor(sar12_trial / 8))*1.8
alter VD_B2 = $&sar12_drive
let sar12_drive = (floor(sar12_trial / 8) - 2*floor(sar12_trial / 16))*1.8
alter VD_B3 = $&sar12_drive
let sar12_drive = (floor(sar12_trial / 16) - 2*floor(sar12_trial / 32))*1.8
alter VD_B4 = $&sar12_drive
let sar12_drive = (floor(sar12_trial / 32) - 2*floor(sar12_trial / 64))*1.8
alter VD_B5 = $&sar12_drive
let sar12_drive = (floor(sar12_trial / 64) - 2*floor(sar12_trial / 128))*1.8
alter VD_B6 = $&sar12_drive
let sar12_drive = (floor(sar12_trial / 128) - 2*floor(sar12_trial / 256))*1.8
alter VD_B7 = $&sar12_drive
let sar12_drive = (floor(sar12_trial / 256) - 2*floor(sar12_trial / 512))*1.8
alter VD_B8 = $&sar12_drive
let sar12_drive = (floor(sar12_trial / 512) - 2*floor(sar12_trial / 1024))*1.8
alter VD_B9 = $&sar12_drive
let sar12_drive = (floor(sar12_trial / 1024) - 2*floor(sar12_trial / 2048))*1.8
alter VD_B10 = $&sar12_drive
let sar12_drive = (floor(sar12_trial / 2048) - 2*floor(sar12_trial / 4096))*1.8
alter VD_B11 = $&sar12_drive
stop when time ge 1.9924999999e-05
resume
let sar12_k = length(time)-1
if abs(time[sar12_k] - 1.9925e-05) > 1e-12
print time[sar12_k]
echo expected_pause_time_s 1.9925e-05
echo SAR12_PAUSE_FAILED
quit 1
end
print time[sar12_k] >> pause-times.txt
delete all
alter VD_EVAL = 1.8
stop when time ge 2.0099999999e-05
resume
let sar12_k = length(time)-1
if abs(time[sar12_k] - 2.01e-05) > 1e-12
print time[sar12_k]
echo expected_pause_time_s 2.01e-05
echo SAR12_PAUSE_FAILED
quit 1
end
print time[sar12_k] >> pause-times.txt
delete all
let sar12_k = length(time)-1
let sar12_cmp = v(COMP)[sar12_k]
let sar12_cmpn = v(COMPN)[sar12_k]
let sar12_p = v(TOPP)[sar12_k]
let sar12_n = v(TOPN)[sar12_k]
let sar12_decision = 0
if sar12_cmp >= 0.9
let sar12_code = sar12_trial
let sar12_decision = 1
end
echo 1 0 $&sar12_trial $&sar12_cmp $&sar12_cmpn $&sar12_p $&sar12_n -1.19970703125 $&sar12_decision >> decisions.csv
alter VD_EVAL = 0
alter VINP = 0.300439453125
alter VINN = 1.49956054687
alter VD_SAMPLE = 1.8
alter VD_EVAL = 0
alter VD_B0 = 0
alter VD_B1 = 0
alter VD_B2 = 0
alter VD_B3 = 0
alter VD_B4 = 0
alter VD_B5 = 0
alter VD_B6 = 0
alter VD_B7 = 0
alter VD_B8 = 0
alter VD_B9 = 0
alter VD_B10 = 0
alter VD_B11 = 0
let sar12_code = 0
stop when time ge 2.4099999999e-05
resume
let sar12_k = length(time)-1
if abs(time[sar12_k] - 2.41e-05) > 1e-12
print time[sar12_k]
echo expected_pause_time_s 2.41e-05
echo SAR12_PAUSE_FAILED
quit 1
end
print time[sar12_k] >> pause-times.txt
delete all
alter VD_SAMPLE = 0
stop when time ge 2.4149999999e-05
resume
let sar12_k = length(time)-1
if abs(time[sar12_k] - 2.415e-05) > 1e-12
print time[sar12_k]
echo expected_pause_time_s 2.415e-05
echo SAR12_PAUSE_FAILED
quit 1
end
print time[sar12_k] >> pause-times.txt
delete all
alter VD_EVAL = 0
let sar12_trial = sar12_code + 2048
let sar12_drive = (floor(sar12_trial / 1) - 2*floor(sar12_trial / 2))*1.8
alter VD_B0 = $&sar12_drive
let sar12_drive = (floor(sar12_trial / 2) - 2*floor(sar12_trial / 4))*1.8
alter VD_B1 = $&sar12_drive
let sar12_drive = (floor(sar12_trial / 4) - 2*floor(sar12_trial / 8))*1.8
alter VD_B2 = $&sar12_drive
let sar12_drive = (floor(sar12_trial / 8) - 2*floor(sar12_trial / 16))*1.8
alter VD_B3 = $&sar12_drive
let sar12_drive = (floor(sar12_trial / 16) - 2*floor(sar12_trial / 32))*1.8
alter VD_B4 = $&sar12_drive
let sar12_drive = (floor(sar12_trial / 32) - 2*floor(sar12_trial / 64))*1.8
alter VD_B5 = $&sar12_drive
let sar12_drive = (floor(sar12_trial / 64) - 2*floor(sar12_trial / 128))*1.8
alter VD_B6 = $&sar12_drive
let sar12_drive = (floor(sar12_trial / 128) - 2*floor(sar12_trial / 256))*1.8
alter VD_B7 = $&sar12_drive
let sar12_drive = (floor(sar12_trial / 256) - 2*floor(sar12_trial / 512))*1.8
alter VD_B8 = $&sar12_drive
let sar12_drive = (floor(sar12_trial / 512) - 2*floor(sar12_trial / 1024))*1.8
alter VD_B9 = $&sar12_drive
let sar12_drive = (floor(sar12_trial / 1024) - 2*floor(sar12_trial / 2048))*1.8
alter VD_B10 = $&sar12_drive
let sar12_drive = (floor(sar12_trial / 2048) - 2*floor(sar12_trial / 4096))*1.8
alter VD_B11 = $&sar12_drive
stop when time ge 2.4474999999e-05
resume
let sar12_k = length(time)-1
if abs(time[sar12_k] - 2.4475e-05) > 1e-12
print time[sar12_k]
echo expected_pause_time_s 2.4475e-05
echo SAR12_PAUSE_FAILED
quit 1
end
print time[sar12_k] >> pause-times.txt
delete all
alter VD_EVAL = 1.8
stop when time ge 2.4649999999e-05
resume
let sar12_k = length(time)-1
if abs(time[sar12_k] - 2.465e-05) > 1e-12
print time[sar12_k]
echo expected_pause_time_s 2.465e-05
echo SAR12_PAUSE_FAILED
quit 1
end
print time[sar12_k] >> pause-times.txt
delete all
let sar12_k = length(time)-1
let sar12_cmp = v(COMP)[sar12_k]
let sar12_cmpn = v(COMPN)[sar12_k]
let sar12_p = v(TOPP)[sar12_k]
let sar12_n = v(TOPN)[sar12_k]
let sar12_decision = 0
if sar12_cmp >= 0.9
let sar12_code = sar12_trial
let sar12_decision = 1
end
echo 2 11 $&sar12_trial $&sar12_cmp $&sar12_cmpn $&sar12_p $&sar12_n -1.19912109375 $&sar12_decision >> decisions.csv
alter VD_EVAL = 0
let sar12_trial = sar12_code + 1024
let sar12_drive = (floor(sar12_trial / 1) - 2*floor(sar12_trial / 2))*1.8
alter VD_B0 = $&sar12_drive
let sar12_drive = (floor(sar12_trial / 2) - 2*floor(sar12_trial / 4))*1.8
alter VD_B1 = $&sar12_drive
let sar12_drive = (floor(sar12_trial / 4) - 2*floor(sar12_trial / 8))*1.8
alter VD_B2 = $&sar12_drive
let sar12_drive = (floor(sar12_trial / 8) - 2*floor(sar12_trial / 16))*1.8
alter VD_B3 = $&sar12_drive
let sar12_drive = (floor(sar12_trial / 16) - 2*floor(sar12_trial / 32))*1.8
alter VD_B4 = $&sar12_drive
let sar12_drive = (floor(sar12_trial / 32) - 2*floor(sar12_trial / 64))*1.8
alter VD_B5 = $&sar12_drive
let sar12_drive = (floor(sar12_trial / 64) - 2*floor(sar12_trial / 128))*1.8
alter VD_B6 = $&sar12_drive
let sar12_drive = (floor(sar12_trial / 128) - 2*floor(sar12_trial / 256))*1.8
alter VD_B7 = $&sar12_drive
let sar12_drive = (floor(sar12_trial / 256) - 2*floor(sar12_trial / 512))*1.8
alter VD_B8 = $&sar12_drive
let sar12_drive = (floor(sar12_trial / 512) - 2*floor(sar12_trial / 1024))*1.8
alter VD_B9 = $&sar12_drive
let sar12_drive = (floor(sar12_trial / 1024) - 2*floor(sar12_trial / 2048))*1.8
alter VD_B10 = $&sar12_drive
let sar12_drive = (floor(sar12_trial / 2048) - 2*floor(sar12_trial / 4096))*1.8
alter VD_B11 = $&sar12_drive
stop when time ge 2.4974999999e-05
resume
let sar12_k = length(time)-1
if abs(time[sar12_k] - 2.4975e-05) > 1e-12
print time[sar12_k]
echo expected_pause_time_s 2.4975e-05
echo SAR12_PAUSE_FAILED
quit 1
end
print time[sar12_k] >> pause-times.txt
delete all
alter VD_EVAL = 1.8
stop when time ge 2.5149999999e-05
resume
let sar12_k = length(time)-1
if abs(time[sar12_k] - 2.515e-05) > 1e-12
print time[sar12_k]
echo expected_pause_time_s 2.515e-05
echo SAR12_PAUSE_FAILED
quit 1
end
print time[sar12_k] >> pause-times.txt
delete all
let sar12_k = length(time)-1
let sar12_cmp = v(COMP)[sar12_k]
let sar12_cmpn = v(COMPN)[sar12_k]
let sar12_p = v(TOPP)[sar12_k]
let sar12_n = v(TOPN)[sar12_k]
let sar12_decision = 0
if sar12_cmp >= 0.9
let sar12_code = sar12_trial
let sar12_decision = 1
end
echo 2 10 $&sar12_trial $&sar12_cmp $&sar12_cmpn $&sar12_p $&sar12_n -1.19912109375 $&sar12_decision >> decisions.csv
alter VD_EVAL = 0
let sar12_trial = sar12_code + 512
let sar12_drive = (floor(sar12_trial / 1) - 2*floor(sar12_trial / 2))*1.8
alter VD_B0 = $&sar12_drive
let sar12_drive = (floor(sar12_trial / 2) - 2*floor(sar12_trial / 4))*1.8
alter VD_B1 = $&sar12_drive
let sar12_drive = (floor(sar12_trial / 4) - 2*floor(sar12_trial / 8))*1.8
alter VD_B2 = $&sar12_drive
let sar12_drive = (floor(sar12_trial / 8) - 2*floor(sar12_trial / 16))*1.8
alter VD_B3 = $&sar12_drive
let sar12_drive = (floor(sar12_trial / 16) - 2*floor(sar12_trial / 32))*1.8
alter VD_B4 = $&sar12_drive
let sar12_drive = (floor(sar12_trial / 32) - 2*floor(sar12_trial / 64))*1.8
alter VD_B5 = $&sar12_drive
let sar12_drive = (floor(sar12_trial / 64) - 2*floor(sar12_trial / 128))*1.8
alter VD_B6 = $&sar12_drive
let sar12_drive = (floor(sar12_trial / 128) - 2*floor(sar12_trial / 256))*1.8
alter VD_B7 = $&sar12_drive
let sar12_drive = (floor(sar12_trial / 256) - 2*floor(sar12_trial / 512))*1.8
alter VD_B8 = $&sar12_drive
let sar12_drive = (floor(sar12_trial / 512) - 2*floor(sar12_trial / 1024))*1.8
alter VD_B9 = $&sar12_drive
let sar12_drive = (floor(sar12_trial / 1024) - 2*floor(sar12_trial / 2048))*1.8
alter VD_B10 = $&sar12_drive
let sar12_drive = (floor(sar12_trial / 2048) - 2*floor(sar12_trial / 4096))*1.8
alter VD_B11 = $&sar12_drive
stop when time ge 2.5474999999e-05
resume
let sar12_k = length(time)-1
if abs(time[sar12_k] - 2.5475e-05) > 1e-12
print time[sar12_k]
echo expected_pause_time_s 2.5475e-05
echo SAR12_PAUSE_FAILED
quit 1
end
print time[sar12_k] >> pause-times.txt
delete all
alter VD_EVAL = 1.8
stop when time ge 2.5649999999e-05
resume
let sar12_k = length(time)-1
if abs(time[sar12_k] - 2.565e-05) > 1e-12
print time[sar12_k]
echo expected_pause_time_s 2.565e-05
echo SAR12_PAUSE_FAILED
quit 1
end
print time[sar12_k] >> pause-times.txt
delete all
let sar12_k = length(time)-1
let sar12_cmp = v(COMP)[sar12_k]
let sar12_cmpn = v(COMPN)[sar12_k]
let sar12_p = v(TOPP)[sar12_k]
let sar12_n = v(TOPN)[sar12_k]
let sar12_decision = 0
if sar12_cmp >= 0.9
let sar12_code = sar12_trial
let sar12_decision = 1
end
echo 2 9 $&sar12_trial $&sar12_cmp $&sar12_cmpn $&sar12_p $&sar12_n -1.19912109375 $&sar12_decision >> decisions.csv
alter VD_EVAL = 0
let sar12_trial = sar12_code + 256
let sar12_drive = (floor(sar12_trial / 1) - 2*floor(sar12_trial / 2))*1.8
alter VD_B0 = $&sar12_drive
let sar12_drive = (floor(sar12_trial / 2) - 2*floor(sar12_trial / 4))*1.8
alter VD_B1 = $&sar12_drive
let sar12_drive = (floor(sar12_trial / 4) - 2*floor(sar12_trial / 8))*1.8
alter VD_B2 = $&sar12_drive
let sar12_drive = (floor(sar12_trial / 8) - 2*floor(sar12_trial / 16))*1.8
alter VD_B3 = $&sar12_drive
let sar12_drive = (floor(sar12_trial / 16) - 2*floor(sar12_trial / 32))*1.8
alter VD_B4 = $&sar12_drive
let sar12_drive = (floor(sar12_trial / 32) - 2*floor(sar12_trial / 64))*1.8
alter VD_B5 = $&sar12_drive
let sar12_drive = (floor(sar12_trial / 64) - 2*floor(sar12_trial / 128))*1.8
alter VD_B6 = $&sar12_drive
let sar12_drive = (floor(sar12_trial / 128) - 2*floor(sar12_trial / 256))*1.8
alter VD_B7 = $&sar12_drive
let sar12_drive = (floor(sar12_trial / 256) - 2*floor(sar12_trial / 512))*1.8
alter VD_B8 = $&sar12_drive
let sar12_drive = (floor(sar12_trial / 512) - 2*floor(sar12_trial / 1024))*1.8
alter VD_B9 = $&sar12_drive
let sar12_drive = (floor(sar12_trial / 1024) - 2*floor(sar12_trial / 2048))*1.8
alter VD_B10 = $&sar12_drive
let sar12_drive = (floor(sar12_trial / 2048) - 2*floor(sar12_trial / 4096))*1.8
alter VD_B11 = $&sar12_drive
stop when time ge 2.5974999999e-05
resume
let sar12_k = length(time)-1
if abs(time[sar12_k] - 2.5975e-05) > 1e-12
print time[sar12_k]
echo expected_pause_time_s 2.5975e-05
echo SAR12_PAUSE_FAILED
quit 1
end
print time[sar12_k] >> pause-times.txt
delete all
alter VD_EVAL = 1.8
stop when time ge 2.6149999999e-05
resume
let sar12_k = length(time)-1
if abs(time[sar12_k] - 2.615e-05) > 1e-12
print time[sar12_k]
echo expected_pause_time_s 2.615e-05
echo SAR12_PAUSE_FAILED
quit 1
end
print time[sar12_k] >> pause-times.txt
delete all
let sar12_k = length(time)-1
let sar12_cmp = v(COMP)[sar12_k]
let sar12_cmpn = v(COMPN)[sar12_k]
let sar12_p = v(TOPP)[sar12_k]
let sar12_n = v(TOPN)[sar12_k]
let sar12_decision = 0
if sar12_cmp >= 0.9
let sar12_code = sar12_trial
let sar12_decision = 1
end
echo 2 8 $&sar12_trial $&sar12_cmp $&sar12_cmpn $&sar12_p $&sar12_n -1.19912109375 $&sar12_decision >> decisions.csv
alter VD_EVAL = 0
let sar12_trial = sar12_code + 128
let sar12_drive = (floor(sar12_trial / 1) - 2*floor(sar12_trial / 2))*1.8
alter VD_B0 = $&sar12_drive
let sar12_drive = (floor(sar12_trial / 2) - 2*floor(sar12_trial / 4))*1.8
alter VD_B1 = $&sar12_drive
let sar12_drive = (floor(sar12_trial / 4) - 2*floor(sar12_trial / 8))*1.8
alter VD_B2 = $&sar12_drive
let sar12_drive = (floor(sar12_trial / 8) - 2*floor(sar12_trial / 16))*1.8
alter VD_B3 = $&sar12_drive
let sar12_drive = (floor(sar12_trial / 16) - 2*floor(sar12_trial / 32))*1.8
alter VD_B4 = $&sar12_drive
let sar12_drive = (floor(sar12_trial / 32) - 2*floor(sar12_trial / 64))*1.8
alter VD_B5 = $&sar12_drive
let sar12_drive = (floor(sar12_trial / 64) - 2*floor(sar12_trial / 128))*1.8
alter VD_B6 = $&sar12_drive
let sar12_drive = (floor(sar12_trial / 128) - 2*floor(sar12_trial / 256))*1.8
alter VD_B7 = $&sar12_drive
let sar12_drive = (floor(sar12_trial / 256) - 2*floor(sar12_trial / 512))*1.8
alter VD_B8 = $&sar12_drive
let sar12_drive = (floor(sar12_trial / 512) - 2*floor(sar12_trial / 1024))*1.8
alter VD_B9 = $&sar12_drive
let sar12_drive = (floor(sar12_trial / 1024) - 2*floor(sar12_trial / 2048))*1.8
alter VD_B10 = $&sar12_drive
let sar12_drive = (floor(sar12_trial / 2048) - 2*floor(sar12_trial / 4096))*1.8
alter VD_B11 = $&sar12_drive
stop when time ge 2.6474999999e-05
resume
let sar12_k = length(time)-1
if abs(time[sar12_k] - 2.6475e-05) > 1e-12
print time[sar12_k]
echo expected_pause_time_s 2.6475e-05
echo SAR12_PAUSE_FAILED
quit 1
end
print time[sar12_k] >> pause-times.txt
delete all
alter VD_EVAL = 1.8
stop when time ge 2.6649999999e-05
resume
let sar12_k = length(time)-1
if abs(time[sar12_k] - 2.665e-05) > 1e-12
print time[sar12_k]
echo expected_pause_time_s 2.665e-05
echo SAR12_PAUSE_FAILED
quit 1
end
print time[sar12_k] >> pause-times.txt
delete all
let sar12_k = length(time)-1
let sar12_cmp = v(COMP)[sar12_k]
let sar12_cmpn = v(COMPN)[sar12_k]
let sar12_p = v(TOPP)[sar12_k]
let sar12_n = v(TOPN)[sar12_k]
let sar12_decision = 0
if sar12_cmp >= 0.9
let sar12_code = sar12_trial
let sar12_decision = 1
end
echo 2 7 $&sar12_trial $&sar12_cmp $&sar12_cmpn $&sar12_p $&sar12_n -1.19912109375 $&sar12_decision >> decisions.csv
alter VD_EVAL = 0
let sar12_trial = sar12_code + 64
let sar12_drive = (floor(sar12_trial / 1) - 2*floor(sar12_trial / 2))*1.8
alter VD_B0 = $&sar12_drive
let sar12_drive = (floor(sar12_trial / 2) - 2*floor(sar12_trial / 4))*1.8
alter VD_B1 = $&sar12_drive
let sar12_drive = (floor(sar12_trial / 4) - 2*floor(sar12_trial / 8))*1.8
alter VD_B2 = $&sar12_drive
let sar12_drive = (floor(sar12_trial / 8) - 2*floor(sar12_trial / 16))*1.8
alter VD_B3 = $&sar12_drive
let sar12_drive = (floor(sar12_trial / 16) - 2*floor(sar12_trial / 32))*1.8
alter VD_B4 = $&sar12_drive
let sar12_drive = (floor(sar12_trial / 32) - 2*floor(sar12_trial / 64))*1.8
alter VD_B5 = $&sar12_drive
let sar12_drive = (floor(sar12_trial / 64) - 2*floor(sar12_trial / 128))*1.8
alter VD_B6 = $&sar12_drive
let sar12_drive = (floor(sar12_trial / 128) - 2*floor(sar12_trial / 256))*1.8
alter VD_B7 = $&sar12_drive
let sar12_drive = (floor(sar12_trial / 256) - 2*floor(sar12_trial / 512))*1.8
alter VD_B8 = $&sar12_drive
let sar12_drive = (floor(sar12_trial / 512) - 2*floor(sar12_trial / 1024))*1.8
alter VD_B9 = $&sar12_drive
let sar12_drive = (floor(sar12_trial / 1024) - 2*floor(sar12_trial / 2048))*1.8
alter VD_B10 = $&sar12_drive
let sar12_drive = (floor(sar12_trial / 2048) - 2*floor(sar12_trial / 4096))*1.8
alter VD_B11 = $&sar12_drive
stop when time ge 2.6974999999e-05
resume
let sar12_k = length(time)-1
if abs(time[sar12_k] - 2.6975e-05) > 1e-12
print time[sar12_k]
echo expected_pause_time_s 2.6975e-05
echo SAR12_PAUSE_FAILED
quit 1
end
print time[sar12_k] >> pause-times.txt
delete all
alter VD_EVAL = 1.8
stop when time ge 2.7149999999e-05
resume
let sar12_k = length(time)-1
if abs(time[sar12_k] - 2.715e-05) > 1e-12
print time[sar12_k]
echo expected_pause_time_s 2.715e-05
echo SAR12_PAUSE_FAILED
quit 1
end
print time[sar12_k] >> pause-times.txt
delete all
let sar12_k = length(time)-1
let sar12_cmp = v(COMP)[sar12_k]
let sar12_cmpn = v(COMPN)[sar12_k]
let sar12_p = v(TOPP)[sar12_k]
let sar12_n = v(TOPN)[sar12_k]
let sar12_decision = 0
if sar12_cmp >= 0.9
let sar12_code = sar12_trial
let sar12_decision = 1
end
echo 2 6 $&sar12_trial $&sar12_cmp $&sar12_cmpn $&sar12_p $&sar12_n -1.19912109375 $&sar12_decision >> decisions.csv
alter VD_EVAL = 0
let sar12_trial = sar12_code + 32
let sar12_drive = (floor(sar12_trial / 1) - 2*floor(sar12_trial / 2))*1.8
alter VD_B0 = $&sar12_drive
let sar12_drive = (floor(sar12_trial / 2) - 2*floor(sar12_trial / 4))*1.8
alter VD_B1 = $&sar12_drive
let sar12_drive = (floor(sar12_trial / 4) - 2*floor(sar12_trial / 8))*1.8
alter VD_B2 = $&sar12_drive
let sar12_drive = (floor(sar12_trial / 8) - 2*floor(sar12_trial / 16))*1.8
alter VD_B3 = $&sar12_drive
let sar12_drive = (floor(sar12_trial / 16) - 2*floor(sar12_trial / 32))*1.8
alter VD_B4 = $&sar12_drive
let sar12_drive = (floor(sar12_trial / 32) - 2*floor(sar12_trial / 64))*1.8
alter VD_B5 = $&sar12_drive
let sar12_drive = (floor(sar12_trial / 64) - 2*floor(sar12_trial / 128))*1.8
alter VD_B6 = $&sar12_drive
let sar12_drive = (floor(sar12_trial / 128) - 2*floor(sar12_trial / 256))*1.8
alter VD_B7 = $&sar12_drive
let sar12_drive = (floor(sar12_trial / 256) - 2*floor(sar12_trial / 512))*1.8
alter VD_B8 = $&sar12_drive
let sar12_drive = (floor(sar12_trial / 512) - 2*floor(sar12_trial / 1024))*1.8
alter VD_B9 = $&sar12_drive
let sar12_drive = (floor(sar12_trial / 1024) - 2*floor(sar12_trial / 2048))*1.8
alter VD_B10 = $&sar12_drive
let sar12_drive = (floor(sar12_trial / 2048) - 2*floor(sar12_trial / 4096))*1.8
alter VD_B11 = $&sar12_drive
stop when time ge 2.7474999999e-05
resume
let sar12_k = length(time)-1
if abs(time[sar12_k] - 2.7475e-05) > 1e-12
print time[sar12_k]
echo expected_pause_time_s 2.7475e-05
echo SAR12_PAUSE_FAILED
quit 1
end
print time[sar12_k] >> pause-times.txt
delete all
alter VD_EVAL = 1.8
stop when time ge 2.7649999999e-05
resume
let sar12_k = length(time)-1
if abs(time[sar12_k] - 2.765e-05) > 1e-12
print time[sar12_k]
echo expected_pause_time_s 2.765e-05
echo SAR12_PAUSE_FAILED
quit 1
end
print time[sar12_k] >> pause-times.txt
delete all
let sar12_k = length(time)-1
let sar12_cmp = v(COMP)[sar12_k]
let sar12_cmpn = v(COMPN)[sar12_k]
let sar12_p = v(TOPP)[sar12_k]
let sar12_n = v(TOPN)[sar12_k]
let sar12_decision = 0
if sar12_cmp >= 0.9
let sar12_code = sar12_trial
let sar12_decision = 1
end
echo 2 5 $&sar12_trial $&sar12_cmp $&sar12_cmpn $&sar12_p $&sar12_n -1.19912109375 $&sar12_decision >> decisions.csv
alter VD_EVAL = 0
let sar12_trial = sar12_code + 16
let sar12_drive = (floor(sar12_trial / 1) - 2*floor(sar12_trial / 2))*1.8
alter VD_B0 = $&sar12_drive
let sar12_drive = (floor(sar12_trial / 2) - 2*floor(sar12_trial / 4))*1.8
alter VD_B1 = $&sar12_drive
let sar12_drive = (floor(sar12_trial / 4) - 2*floor(sar12_trial / 8))*1.8
alter VD_B2 = $&sar12_drive
let sar12_drive = (floor(sar12_trial / 8) - 2*floor(sar12_trial / 16))*1.8
alter VD_B3 = $&sar12_drive
let sar12_drive = (floor(sar12_trial / 16) - 2*floor(sar12_trial / 32))*1.8
alter VD_B4 = $&sar12_drive
let sar12_drive = (floor(sar12_trial / 32) - 2*floor(sar12_trial / 64))*1.8
alter VD_B5 = $&sar12_drive
let sar12_drive = (floor(sar12_trial / 64) - 2*floor(sar12_trial / 128))*1.8
alter VD_B6 = $&sar12_drive
let sar12_drive = (floor(sar12_trial / 128) - 2*floor(sar12_trial / 256))*1.8
alter VD_B7 = $&sar12_drive
let sar12_drive = (floor(sar12_trial / 256) - 2*floor(sar12_trial / 512))*1.8
alter VD_B8 = $&sar12_drive
let sar12_drive = (floor(sar12_trial / 512) - 2*floor(sar12_trial / 1024))*1.8
alter VD_B9 = $&sar12_drive
let sar12_drive = (floor(sar12_trial / 1024) - 2*floor(sar12_trial / 2048))*1.8
alter VD_B10 = $&sar12_drive
let sar12_drive = (floor(sar12_trial / 2048) - 2*floor(sar12_trial / 4096))*1.8
alter VD_B11 = $&sar12_drive
stop when time ge 2.7974999999e-05
resume
let sar12_k = length(time)-1
if abs(time[sar12_k] - 2.7975e-05) > 1e-12
print time[sar12_k]
echo expected_pause_time_s 2.7975e-05
echo SAR12_PAUSE_FAILED
quit 1
end
print time[sar12_k] >> pause-times.txt
delete all
alter VD_EVAL = 1.8
stop when time ge 2.8149999999e-05
resume
let sar12_k = length(time)-1
if abs(time[sar12_k] - 2.815e-05) > 1e-12
print time[sar12_k]
echo expected_pause_time_s 2.815e-05
echo SAR12_PAUSE_FAILED
quit 1
end
print time[sar12_k] >> pause-times.txt
delete all
let sar12_k = length(time)-1
let sar12_cmp = v(COMP)[sar12_k]
let sar12_cmpn = v(COMPN)[sar12_k]
let sar12_p = v(TOPP)[sar12_k]
let sar12_n = v(TOPN)[sar12_k]
let sar12_decision = 0
if sar12_cmp >= 0.9
let sar12_code = sar12_trial
let sar12_decision = 1
end
echo 2 4 $&sar12_trial $&sar12_cmp $&sar12_cmpn $&sar12_p $&sar12_n -1.19912109375 $&sar12_decision >> decisions.csv
alter VD_EVAL = 0
let sar12_trial = sar12_code + 8
let sar12_drive = (floor(sar12_trial / 1) - 2*floor(sar12_trial / 2))*1.8
alter VD_B0 = $&sar12_drive
let sar12_drive = (floor(sar12_trial / 2) - 2*floor(sar12_trial / 4))*1.8
alter VD_B1 = $&sar12_drive
let sar12_drive = (floor(sar12_trial / 4) - 2*floor(sar12_trial / 8))*1.8
alter VD_B2 = $&sar12_drive
let sar12_drive = (floor(sar12_trial / 8) - 2*floor(sar12_trial / 16))*1.8
alter VD_B3 = $&sar12_drive
let sar12_drive = (floor(sar12_trial / 16) - 2*floor(sar12_trial / 32))*1.8
alter VD_B4 = $&sar12_drive
let sar12_drive = (floor(sar12_trial / 32) - 2*floor(sar12_trial / 64))*1.8
alter VD_B5 = $&sar12_drive
let sar12_drive = (floor(sar12_trial / 64) - 2*floor(sar12_trial / 128))*1.8
alter VD_B6 = $&sar12_drive
let sar12_drive = (floor(sar12_trial / 128) - 2*floor(sar12_trial / 256))*1.8
alter VD_B7 = $&sar12_drive
let sar12_drive = (floor(sar12_trial / 256) - 2*floor(sar12_trial / 512))*1.8
alter VD_B8 = $&sar12_drive
let sar12_drive = (floor(sar12_trial / 512) - 2*floor(sar12_trial / 1024))*1.8
alter VD_B9 = $&sar12_drive
let sar12_drive = (floor(sar12_trial / 1024) - 2*floor(sar12_trial / 2048))*1.8
alter VD_B10 = $&sar12_drive
let sar12_drive = (floor(sar12_trial / 2048) - 2*floor(sar12_trial / 4096))*1.8
alter VD_B11 = $&sar12_drive
stop when time ge 2.8474999999e-05
resume
let sar12_k = length(time)-1
if abs(time[sar12_k] - 2.8475e-05) > 1e-12
print time[sar12_k]
echo expected_pause_time_s 2.8475e-05
echo SAR12_PAUSE_FAILED
quit 1
end
print time[sar12_k] >> pause-times.txt
delete all
alter VD_EVAL = 1.8
stop when time ge 2.8649999999e-05
resume
let sar12_k = length(time)-1
if abs(time[sar12_k] - 2.865e-05) > 1e-12
print time[sar12_k]
echo expected_pause_time_s 2.865e-05
echo SAR12_PAUSE_FAILED
quit 1
end
print time[sar12_k] >> pause-times.txt
delete all
let sar12_k = length(time)-1
let sar12_cmp = v(COMP)[sar12_k]
let sar12_cmpn = v(COMPN)[sar12_k]
let sar12_p = v(TOPP)[sar12_k]
let sar12_n = v(TOPN)[sar12_k]
let sar12_decision = 0
if sar12_cmp >= 0.9
let sar12_code = sar12_trial
let sar12_decision = 1
end
echo 2 3 $&sar12_trial $&sar12_cmp $&sar12_cmpn $&sar12_p $&sar12_n -1.19912109375 $&sar12_decision >> decisions.csv
alter VD_EVAL = 0
let sar12_trial = sar12_code + 4
let sar12_drive = (floor(sar12_trial / 1) - 2*floor(sar12_trial / 2))*1.8
alter VD_B0 = $&sar12_drive
let sar12_drive = (floor(sar12_trial / 2) - 2*floor(sar12_trial / 4))*1.8
alter VD_B1 = $&sar12_drive
let sar12_drive = (floor(sar12_trial / 4) - 2*floor(sar12_trial / 8))*1.8
alter VD_B2 = $&sar12_drive
let sar12_drive = (floor(sar12_trial / 8) - 2*floor(sar12_trial / 16))*1.8
alter VD_B3 = $&sar12_drive
let sar12_drive = (floor(sar12_trial / 16) - 2*floor(sar12_trial / 32))*1.8
alter VD_B4 = $&sar12_drive
let sar12_drive = (floor(sar12_trial / 32) - 2*floor(sar12_trial / 64))*1.8
alter VD_B5 = $&sar12_drive
let sar12_drive = (floor(sar12_trial / 64) - 2*floor(sar12_trial / 128))*1.8
alter VD_B6 = $&sar12_drive
let sar12_drive = (floor(sar12_trial / 128) - 2*floor(sar12_trial / 256))*1.8
alter VD_B7 = $&sar12_drive
let sar12_drive = (floor(sar12_trial / 256) - 2*floor(sar12_trial / 512))*1.8
alter VD_B8 = $&sar12_drive
let sar12_drive = (floor(sar12_trial / 512) - 2*floor(sar12_trial / 1024))*1.8
alter VD_B9 = $&sar12_drive
let sar12_drive = (floor(sar12_trial / 1024) - 2*floor(sar12_trial / 2048))*1.8
alter VD_B10 = $&sar12_drive
let sar12_drive = (floor(sar12_trial / 2048) - 2*floor(sar12_trial / 4096))*1.8
alter VD_B11 = $&sar12_drive
stop when time ge 2.8974999999e-05
resume
let sar12_k = length(time)-1
if abs(time[sar12_k] - 2.8975e-05) > 1e-12
print time[sar12_k]
echo expected_pause_time_s 2.8975e-05
echo SAR12_PAUSE_FAILED
quit 1
end
print time[sar12_k] >> pause-times.txt
delete all
alter VD_EVAL = 1.8
stop when time ge 2.9149999999e-05
resume
let sar12_k = length(time)-1
if abs(time[sar12_k] - 2.915e-05) > 1e-12
print time[sar12_k]
echo expected_pause_time_s 2.915e-05
echo SAR12_PAUSE_FAILED
quit 1
end
print time[sar12_k] >> pause-times.txt
delete all
let sar12_k = length(time)-1
let sar12_cmp = v(COMP)[sar12_k]
let sar12_cmpn = v(COMPN)[sar12_k]
let sar12_p = v(TOPP)[sar12_k]
let sar12_n = v(TOPN)[sar12_k]
let sar12_decision = 0
if sar12_cmp >= 0.9
let sar12_code = sar12_trial
let sar12_decision = 1
end
echo 2 2 $&sar12_trial $&sar12_cmp $&sar12_cmpn $&sar12_p $&sar12_n -1.19912109375 $&sar12_decision >> decisions.csv
alter VD_EVAL = 0
let sar12_trial = sar12_code + 2
let sar12_drive = (floor(sar12_trial / 1) - 2*floor(sar12_trial / 2))*1.8
alter VD_B0 = $&sar12_drive
let sar12_drive = (floor(sar12_trial / 2) - 2*floor(sar12_trial / 4))*1.8
alter VD_B1 = $&sar12_drive
let sar12_drive = (floor(sar12_trial / 4) - 2*floor(sar12_trial / 8))*1.8
alter VD_B2 = $&sar12_drive
let sar12_drive = (floor(sar12_trial / 8) - 2*floor(sar12_trial / 16))*1.8
alter VD_B3 = $&sar12_drive
let sar12_drive = (floor(sar12_trial / 16) - 2*floor(sar12_trial / 32))*1.8
alter VD_B4 = $&sar12_drive
let sar12_drive = (floor(sar12_trial / 32) - 2*floor(sar12_trial / 64))*1.8
alter VD_B5 = $&sar12_drive
let sar12_drive = (floor(sar12_trial / 64) - 2*floor(sar12_trial / 128))*1.8
alter VD_B6 = $&sar12_drive
let sar12_drive = (floor(sar12_trial / 128) - 2*floor(sar12_trial / 256))*1.8
alter VD_B7 = $&sar12_drive
let sar12_drive = (floor(sar12_trial / 256) - 2*floor(sar12_trial / 512))*1.8
alter VD_B8 = $&sar12_drive
let sar12_drive = (floor(sar12_trial / 512) - 2*floor(sar12_trial / 1024))*1.8
alter VD_B9 = $&sar12_drive
let sar12_drive = (floor(sar12_trial / 1024) - 2*floor(sar12_trial / 2048))*1.8
alter VD_B10 = $&sar12_drive
let sar12_drive = (floor(sar12_trial / 2048) - 2*floor(sar12_trial / 4096))*1.8
alter VD_B11 = $&sar12_drive
stop when time ge 2.9474999999e-05
resume
let sar12_k = length(time)-1
if abs(time[sar12_k] - 2.9475e-05) > 1e-12
print time[sar12_k]
echo expected_pause_time_s 2.9475e-05
echo SAR12_PAUSE_FAILED
quit 1
end
print time[sar12_k] >> pause-times.txt
delete all
alter VD_EVAL = 1.8
stop when time ge 2.9649999999e-05
resume
let sar12_k = length(time)-1
if abs(time[sar12_k] - 2.965e-05) > 1e-12
print time[sar12_k]
echo expected_pause_time_s 2.965e-05
echo SAR12_PAUSE_FAILED
quit 1
end
print time[sar12_k] >> pause-times.txt
delete all
let sar12_k = length(time)-1
let sar12_cmp = v(COMP)[sar12_k]
let sar12_cmpn = v(COMPN)[sar12_k]
let sar12_p = v(TOPP)[sar12_k]
let sar12_n = v(TOPN)[sar12_k]
let sar12_decision = 0
if sar12_cmp >= 0.9
let sar12_code = sar12_trial
let sar12_decision = 1
end
echo 2 1 $&sar12_trial $&sar12_cmp $&sar12_cmpn $&sar12_p $&sar12_n -1.19912109375 $&sar12_decision >> decisions.csv
alter VD_EVAL = 0
let sar12_trial = sar12_code + 1
let sar12_drive = (floor(sar12_trial / 1) - 2*floor(sar12_trial / 2))*1.8
alter VD_B0 = $&sar12_drive
let sar12_drive = (floor(sar12_trial / 2) - 2*floor(sar12_trial / 4))*1.8
alter VD_B1 = $&sar12_drive
let sar12_drive = (floor(sar12_trial / 4) - 2*floor(sar12_trial / 8))*1.8
alter VD_B2 = $&sar12_drive
let sar12_drive = (floor(sar12_trial / 8) - 2*floor(sar12_trial / 16))*1.8
alter VD_B3 = $&sar12_drive
let sar12_drive = (floor(sar12_trial / 16) - 2*floor(sar12_trial / 32))*1.8
alter VD_B4 = $&sar12_drive
let sar12_drive = (floor(sar12_trial / 32) - 2*floor(sar12_trial / 64))*1.8
alter VD_B5 = $&sar12_drive
let sar12_drive = (floor(sar12_trial / 64) - 2*floor(sar12_trial / 128))*1.8
alter VD_B6 = $&sar12_drive
let sar12_drive = (floor(sar12_trial / 128) - 2*floor(sar12_trial / 256))*1.8
alter VD_B7 = $&sar12_drive
let sar12_drive = (floor(sar12_trial / 256) - 2*floor(sar12_trial / 512))*1.8
alter VD_B8 = $&sar12_drive
let sar12_drive = (floor(sar12_trial / 512) - 2*floor(sar12_trial / 1024))*1.8
alter VD_B9 = $&sar12_drive
let sar12_drive = (floor(sar12_trial / 1024) - 2*floor(sar12_trial / 2048))*1.8
alter VD_B10 = $&sar12_drive
let sar12_drive = (floor(sar12_trial / 2048) - 2*floor(sar12_trial / 4096))*1.8
alter VD_B11 = $&sar12_drive
stop when time ge 2.9974999999e-05
resume
let sar12_k = length(time)-1
if abs(time[sar12_k] - 2.9975e-05) > 1e-12
print time[sar12_k]
echo expected_pause_time_s 2.9975e-05
echo SAR12_PAUSE_FAILED
quit 1
end
print time[sar12_k] >> pause-times.txt
delete all
alter VD_EVAL = 1.8
stop when time ge 3.0149999999e-05
resume
let sar12_k = length(time)-1
if abs(time[sar12_k] - 3.015e-05) > 1e-12
print time[sar12_k]
echo expected_pause_time_s 3.015e-05
echo SAR12_PAUSE_FAILED
quit 1
end
print time[sar12_k] >> pause-times.txt
delete all
let sar12_k = length(time)-1
let sar12_cmp = v(COMP)[sar12_k]
let sar12_cmpn = v(COMPN)[sar12_k]
let sar12_p = v(TOPP)[sar12_k]
let sar12_n = v(TOPN)[sar12_k]
let sar12_decision = 0
if sar12_cmp >= 0.9
let sar12_code = sar12_trial
let sar12_decision = 1
end
echo 2 0 $&sar12_trial $&sar12_cmp $&sar12_cmpn $&sar12_p $&sar12_n -1.19912109375 $&sar12_decision >> decisions.csv
alter VD_EVAL = 0
alter VINP = 0.309228515625
alter VINN = 1.49077148437
alter VD_SAMPLE = 1.8
alter VD_EVAL = 0
alter VD_B0 = 0
alter VD_B1 = 0
alter VD_B2 = 0
alter VD_B3 = 0
alter VD_B4 = 0
alter VD_B5 = 0
alter VD_B6 = 0
alter VD_B7 = 0
alter VD_B8 = 0
alter VD_B9 = 0
alter VD_B10 = 0
alter VD_B11 = 0
let sar12_code = 0
stop when time ge 3.4149999999e-05
resume
let sar12_k = length(time)-1
if abs(time[sar12_k] - 3.415e-05) > 1e-12
print time[sar12_k]
echo expected_pause_time_s 3.415e-05
echo SAR12_PAUSE_FAILED
quit 1
end
print time[sar12_k] >> pause-times.txt
delete all
alter VD_SAMPLE = 0
stop when time ge 3.4199999999e-05
resume
let sar12_k = length(time)-1
if abs(time[sar12_k] - 3.42e-05) > 1e-12
print time[sar12_k]
echo expected_pause_time_s 3.42e-05
echo SAR12_PAUSE_FAILED
quit 1
end
print time[sar12_k] >> pause-times.txt
delete all
alter VD_EVAL = 0
let sar12_trial = sar12_code + 2048
let sar12_drive = (floor(sar12_trial / 1) - 2*floor(sar12_trial / 2))*1.8
alter VD_B0 = $&sar12_drive
let sar12_drive = (floor(sar12_trial / 2) - 2*floor(sar12_trial / 4))*1.8
alter VD_B1 = $&sar12_drive
let sar12_drive = (floor(sar12_trial / 4) - 2*floor(sar12_trial / 8))*1.8
alter VD_B2 = $&sar12_drive
let sar12_drive = (floor(sar12_trial / 8) - 2*floor(sar12_trial / 16))*1.8
alter VD_B3 = $&sar12_drive
let sar12_drive = (floor(sar12_trial / 16) - 2*floor(sar12_trial / 32))*1.8
alter VD_B4 = $&sar12_drive
let sar12_drive = (floor(sar12_trial / 32) - 2*floor(sar12_trial / 64))*1.8
alter VD_B5 = $&sar12_drive
let sar12_drive = (floor(sar12_trial / 64) - 2*floor(sar12_trial / 128))*1.8
alter VD_B6 = $&sar12_drive
let sar12_drive = (floor(sar12_trial / 128) - 2*floor(sar12_trial / 256))*1.8
alter VD_B7 = $&sar12_drive
let sar12_drive = (floor(sar12_trial / 256) - 2*floor(sar12_trial / 512))*1.8
alter VD_B8 = $&sar12_drive
let sar12_drive = (floor(sar12_trial / 512) - 2*floor(sar12_trial / 1024))*1.8
alter VD_B9 = $&sar12_drive
let sar12_drive = (floor(sar12_trial / 1024) - 2*floor(sar12_trial / 2048))*1.8
alter VD_B10 = $&sar12_drive
let sar12_drive = (floor(sar12_trial / 2048) - 2*floor(sar12_trial / 4096))*1.8
alter VD_B11 = $&sar12_drive
stop when time ge 3.4524999999e-05
resume
let sar12_k = length(time)-1
if abs(time[sar12_k] - 3.4525e-05) > 1e-12
print time[sar12_k]
echo expected_pause_time_s 3.4525e-05
echo SAR12_PAUSE_FAILED
quit 1
end
print time[sar12_k] >> pause-times.txt
delete all
alter VD_EVAL = 1.8
stop when time ge 3.4699999999e-05
resume
let sar12_k = length(time)-1
if abs(time[sar12_k] - 3.47e-05) > 1e-12
print time[sar12_k]
echo expected_pause_time_s 3.47e-05
echo SAR12_PAUSE_FAILED
quit 1
end
print time[sar12_k] >> pause-times.txt
delete all
let sar12_k = length(time)-1
let sar12_cmp = v(COMP)[sar12_k]
let sar12_cmpn = v(COMPN)[sar12_k]
let sar12_p = v(TOPP)[sar12_k]
let sar12_n = v(TOPN)[sar12_k]
let sar12_decision = 0
if sar12_cmp >= 0.9
let sar12_code = sar12_trial
let sar12_decision = 1
end
echo 3 11 $&sar12_trial $&sar12_cmp $&sar12_cmpn $&sar12_p $&sar12_n -1.18154296875 $&sar12_decision >> decisions.csv
alter VD_EVAL = 0
let sar12_trial = sar12_code + 1024
let sar12_drive = (floor(sar12_trial / 1) - 2*floor(sar12_trial / 2))*1.8
alter VD_B0 = $&sar12_drive
let sar12_drive = (floor(sar12_trial / 2) - 2*floor(sar12_trial / 4))*1.8
alter VD_B1 = $&sar12_drive
let sar12_drive = (floor(sar12_trial / 4) - 2*floor(sar12_trial / 8))*1.8
alter VD_B2 = $&sar12_drive
let sar12_drive = (floor(sar12_trial / 8) - 2*floor(sar12_trial / 16))*1.8
alter VD_B3 = $&sar12_drive
let sar12_drive = (floor(sar12_trial / 16) - 2*floor(sar12_trial / 32))*1.8
alter VD_B4 = $&sar12_drive
let sar12_drive = (floor(sar12_trial / 32) - 2*floor(sar12_trial / 64))*1.8
alter VD_B5 = $&sar12_drive
let sar12_drive = (floor(sar12_trial / 64) - 2*floor(sar12_trial / 128))*1.8
alter VD_B6 = $&sar12_drive
let sar12_drive = (floor(sar12_trial / 128) - 2*floor(sar12_trial / 256))*1.8
alter VD_B7 = $&sar12_drive
let sar12_drive = (floor(sar12_trial / 256) - 2*floor(sar12_trial / 512))*1.8
alter VD_B8 = $&sar12_drive
let sar12_drive = (floor(sar12_trial / 512) - 2*floor(sar12_trial / 1024))*1.8
alter VD_B9 = $&sar12_drive
let sar12_drive = (floor(sar12_trial / 1024) - 2*floor(sar12_trial / 2048))*1.8
alter VD_B10 = $&sar12_drive
let sar12_drive = (floor(sar12_trial / 2048) - 2*floor(sar12_trial / 4096))*1.8
alter VD_B11 = $&sar12_drive
stop when time ge 3.5024999999e-05
resume
let sar12_k = length(time)-1
if abs(time[sar12_k] - 3.5025e-05) > 1e-12
print time[sar12_k]
echo expected_pause_time_s 3.5025e-05
echo SAR12_PAUSE_FAILED
quit 1
end
print time[sar12_k] >> pause-times.txt
delete all
alter VD_EVAL = 1.8
stop when time ge 3.5199999999e-05
resume
let sar12_k = length(time)-1
if abs(time[sar12_k] - 3.52e-05) > 1e-12
print time[sar12_k]
echo expected_pause_time_s 3.52e-05
echo SAR12_PAUSE_FAILED
quit 1
end
print time[sar12_k] >> pause-times.txt
delete all
let sar12_k = length(time)-1
let sar12_cmp = v(COMP)[sar12_k]
let sar12_cmpn = v(COMPN)[sar12_k]
let sar12_p = v(TOPP)[sar12_k]
let sar12_n = v(TOPN)[sar12_k]
let sar12_decision = 0
if sar12_cmp >= 0.9
let sar12_code = sar12_trial
let sar12_decision = 1
end
echo 3 10 $&sar12_trial $&sar12_cmp $&sar12_cmpn $&sar12_p $&sar12_n -1.18154296875 $&sar12_decision >> decisions.csv
alter VD_EVAL = 0
let sar12_trial = sar12_code + 512
let sar12_drive = (floor(sar12_trial / 1) - 2*floor(sar12_trial / 2))*1.8
alter VD_B0 = $&sar12_drive
let sar12_drive = (floor(sar12_trial / 2) - 2*floor(sar12_trial / 4))*1.8
alter VD_B1 = $&sar12_drive
let sar12_drive = (floor(sar12_trial / 4) - 2*floor(sar12_trial / 8))*1.8
alter VD_B2 = $&sar12_drive
let sar12_drive = (floor(sar12_trial / 8) - 2*floor(sar12_trial / 16))*1.8
alter VD_B3 = $&sar12_drive
let sar12_drive = (floor(sar12_trial / 16) - 2*floor(sar12_trial / 32))*1.8
alter VD_B4 = $&sar12_drive
let sar12_drive = (floor(sar12_trial / 32) - 2*floor(sar12_trial / 64))*1.8
alter VD_B5 = $&sar12_drive
let sar12_drive = (floor(sar12_trial / 64) - 2*floor(sar12_trial / 128))*1.8
alter VD_B6 = $&sar12_drive
let sar12_drive = (floor(sar12_trial / 128) - 2*floor(sar12_trial / 256))*1.8
alter VD_B7 = $&sar12_drive
let sar12_drive = (floor(sar12_trial / 256) - 2*floor(sar12_trial / 512))*1.8
alter VD_B8 = $&sar12_drive
let sar12_drive = (floor(sar12_trial / 512) - 2*floor(sar12_trial / 1024))*1.8
alter VD_B9 = $&sar12_drive
let sar12_drive = (floor(sar12_trial / 1024) - 2*floor(sar12_trial / 2048))*1.8
alter VD_B10 = $&sar12_drive
let sar12_drive = (floor(sar12_trial / 2048) - 2*floor(sar12_trial / 4096))*1.8
alter VD_B11 = $&sar12_drive
stop when time ge 3.5524999999e-05
resume
let sar12_k = length(time)-1
if abs(time[sar12_k] - 3.5525e-05) > 1e-12
print time[sar12_k]
echo expected_pause_time_s 3.5525e-05
echo SAR12_PAUSE_FAILED
quit 1
end
print time[sar12_k] >> pause-times.txt
delete all
alter VD_EVAL = 1.8
stop when time ge 3.5699999999e-05
resume
let sar12_k = length(time)-1
if abs(time[sar12_k] - 3.57e-05) > 1e-12
print time[sar12_k]
echo expected_pause_time_s 3.57e-05
echo SAR12_PAUSE_FAILED
quit 1
end
print time[sar12_k] >> pause-times.txt
delete all
let sar12_k = length(time)-1
let sar12_cmp = v(COMP)[sar12_k]
let sar12_cmpn = v(COMPN)[sar12_k]
let sar12_p = v(TOPP)[sar12_k]
let sar12_n = v(TOPN)[sar12_k]
let sar12_decision = 0
if sar12_cmp >= 0.9
let sar12_code = sar12_trial
let sar12_decision = 1
end
echo 3 9 $&sar12_trial $&sar12_cmp $&sar12_cmpn $&sar12_p $&sar12_n -1.18154296875 $&sar12_decision >> decisions.csv
alter VD_EVAL = 0
let sar12_trial = sar12_code + 256
let sar12_drive = (floor(sar12_trial / 1) - 2*floor(sar12_trial / 2))*1.8
alter VD_B0 = $&sar12_drive
let sar12_drive = (floor(sar12_trial / 2) - 2*floor(sar12_trial / 4))*1.8
alter VD_B1 = $&sar12_drive
let sar12_drive = (floor(sar12_trial / 4) - 2*floor(sar12_trial / 8))*1.8
alter VD_B2 = $&sar12_drive
let sar12_drive = (floor(sar12_trial / 8) - 2*floor(sar12_trial / 16))*1.8
alter VD_B3 = $&sar12_drive
let sar12_drive = (floor(sar12_trial / 16) - 2*floor(sar12_trial / 32))*1.8
alter VD_B4 = $&sar12_drive
let sar12_drive = (floor(sar12_trial / 32) - 2*floor(sar12_trial / 64))*1.8
alter VD_B5 = $&sar12_drive
let sar12_drive = (floor(sar12_trial / 64) - 2*floor(sar12_trial / 128))*1.8
alter VD_B6 = $&sar12_drive
let sar12_drive = (floor(sar12_trial / 128) - 2*floor(sar12_trial / 256))*1.8
alter VD_B7 = $&sar12_drive
let sar12_drive = (floor(sar12_trial / 256) - 2*floor(sar12_trial / 512))*1.8
alter VD_B8 = $&sar12_drive
let sar12_drive = (floor(sar12_trial / 512) - 2*floor(sar12_trial / 1024))*1.8
alter VD_B9 = $&sar12_drive
let sar12_drive = (floor(sar12_trial / 1024) - 2*floor(sar12_trial / 2048))*1.8
alter VD_B10 = $&sar12_drive
let sar12_drive = (floor(sar12_trial / 2048) - 2*floor(sar12_trial / 4096))*1.8
alter VD_B11 = $&sar12_drive
stop when time ge 3.6024999999e-05
resume
let sar12_k = length(time)-1
if abs(time[sar12_k] - 3.6025e-05) > 1e-12
print time[sar12_k]
echo expected_pause_time_s 3.6025e-05
echo SAR12_PAUSE_FAILED
quit 1
end
print time[sar12_k] >> pause-times.txt
delete all
alter VD_EVAL = 1.8
stop when time ge 3.6199999999e-05
resume
let sar12_k = length(time)-1
if abs(time[sar12_k] - 3.62e-05) > 1e-12
print time[sar12_k]
echo expected_pause_time_s 3.62e-05
echo SAR12_PAUSE_FAILED
quit 1
end
print time[sar12_k] >> pause-times.txt
delete all
let sar12_k = length(time)-1
let sar12_cmp = v(COMP)[sar12_k]
let sar12_cmpn = v(COMPN)[sar12_k]
let sar12_p = v(TOPP)[sar12_k]
let sar12_n = v(TOPN)[sar12_k]
let sar12_decision = 0
if sar12_cmp >= 0.9
let sar12_code = sar12_trial
let sar12_decision = 1
end
echo 3 8 $&sar12_trial $&sar12_cmp $&sar12_cmpn $&sar12_p $&sar12_n -1.18154296875 $&sar12_decision >> decisions.csv
alter VD_EVAL = 0
let sar12_trial = sar12_code + 128
let sar12_drive = (floor(sar12_trial / 1) - 2*floor(sar12_trial / 2))*1.8
alter VD_B0 = $&sar12_drive
let sar12_drive = (floor(sar12_trial / 2) - 2*floor(sar12_trial / 4))*1.8
alter VD_B1 = $&sar12_drive
let sar12_drive = (floor(sar12_trial / 4) - 2*floor(sar12_trial / 8))*1.8
alter VD_B2 = $&sar12_drive
let sar12_drive = (floor(sar12_trial / 8) - 2*floor(sar12_trial / 16))*1.8
alter VD_B3 = $&sar12_drive
let sar12_drive = (floor(sar12_trial / 16) - 2*floor(sar12_trial / 32))*1.8
alter VD_B4 = $&sar12_drive
let sar12_drive = (floor(sar12_trial / 32) - 2*floor(sar12_trial / 64))*1.8
alter VD_B5 = $&sar12_drive
let sar12_drive = (floor(sar12_trial / 64) - 2*floor(sar12_trial / 128))*1.8
alter VD_B6 = $&sar12_drive
let sar12_drive = (floor(sar12_trial / 128) - 2*floor(sar12_trial / 256))*1.8
alter VD_B7 = $&sar12_drive
let sar12_drive = (floor(sar12_trial / 256) - 2*floor(sar12_trial / 512))*1.8
alter VD_B8 = $&sar12_drive
let sar12_drive = (floor(sar12_trial / 512) - 2*floor(sar12_trial / 1024))*1.8
alter VD_B9 = $&sar12_drive
let sar12_drive = (floor(sar12_trial / 1024) - 2*floor(sar12_trial / 2048))*1.8
alter VD_B10 = $&sar12_drive
let sar12_drive = (floor(sar12_trial / 2048) - 2*floor(sar12_trial / 4096))*1.8
alter VD_B11 = $&sar12_drive
stop when time ge 3.6524999999e-05
resume
let sar12_k = length(time)-1
if abs(time[sar12_k] - 3.6525e-05) > 1e-12
print time[sar12_k]
echo expected_pause_time_s 3.6525e-05
echo SAR12_PAUSE_FAILED
quit 1
end
print time[sar12_k] >> pause-times.txt
delete all
alter VD_EVAL = 1.8
stop when time ge 3.6699999999e-05
resume
let sar12_k = length(time)-1
if abs(time[sar12_k] - 3.67e-05) > 1e-12
print time[sar12_k]
echo expected_pause_time_s 3.67e-05
echo SAR12_PAUSE_FAILED
quit 1
end
print time[sar12_k] >> pause-times.txt
delete all
let sar12_k = length(time)-1
let sar12_cmp = v(COMP)[sar12_k]
let sar12_cmpn = v(COMPN)[sar12_k]
let sar12_p = v(TOPP)[sar12_k]
let sar12_n = v(TOPN)[sar12_k]
let sar12_decision = 0
if sar12_cmp >= 0.9
let sar12_code = sar12_trial
let sar12_decision = 1
end
echo 3 7 $&sar12_trial $&sar12_cmp $&sar12_cmpn $&sar12_p $&sar12_n -1.18154296875 $&sar12_decision >> decisions.csv
alter VD_EVAL = 0
let sar12_trial = sar12_code + 64
let sar12_drive = (floor(sar12_trial / 1) - 2*floor(sar12_trial / 2))*1.8
alter VD_B0 = $&sar12_drive
let sar12_drive = (floor(sar12_trial / 2) - 2*floor(sar12_trial / 4))*1.8
alter VD_B1 = $&sar12_drive
let sar12_drive = (floor(sar12_trial / 4) - 2*floor(sar12_trial / 8))*1.8
alter VD_B2 = $&sar12_drive
let sar12_drive = (floor(sar12_trial / 8) - 2*floor(sar12_trial / 16))*1.8
alter VD_B3 = $&sar12_drive
let sar12_drive = (floor(sar12_trial / 16) - 2*floor(sar12_trial / 32))*1.8
alter VD_B4 = $&sar12_drive
let sar12_drive = (floor(sar12_trial / 32) - 2*floor(sar12_trial / 64))*1.8
alter VD_B5 = $&sar12_drive
let sar12_drive = (floor(sar12_trial / 64) - 2*floor(sar12_trial / 128))*1.8
alter VD_B6 = $&sar12_drive
let sar12_drive = (floor(sar12_trial / 128) - 2*floor(sar12_trial / 256))*1.8
alter VD_B7 = $&sar12_drive
let sar12_drive = (floor(sar12_trial / 256) - 2*floor(sar12_trial / 512))*1.8
alter VD_B8 = $&sar12_drive
let sar12_drive = (floor(sar12_trial / 512) - 2*floor(sar12_trial / 1024))*1.8
alter VD_B9 = $&sar12_drive
let sar12_drive = (floor(sar12_trial / 1024) - 2*floor(sar12_trial / 2048))*1.8
alter VD_B10 = $&sar12_drive
let sar12_drive = (floor(sar12_trial / 2048) - 2*floor(sar12_trial / 4096))*1.8
alter VD_B11 = $&sar12_drive
stop when time ge 3.7024999999e-05
resume
let sar12_k = length(time)-1
if abs(time[sar12_k] - 3.7025e-05) > 1e-12
print time[sar12_k]
echo expected_pause_time_s 3.7025e-05
echo SAR12_PAUSE_FAILED
quit 1
end
print time[sar12_k] >> pause-times.txt
delete all
alter VD_EVAL = 1.8
stop when time ge 3.7199999999e-05
resume
let sar12_k = length(time)-1
if abs(time[sar12_k] - 3.72e-05) > 1e-12
print time[sar12_k]
echo expected_pause_time_s 3.72e-05
echo SAR12_PAUSE_FAILED
quit 1
end
print time[sar12_k] >> pause-times.txt
delete all
let sar12_k = length(time)-1
let sar12_cmp = v(COMP)[sar12_k]
let sar12_cmpn = v(COMPN)[sar12_k]
let sar12_p = v(TOPP)[sar12_k]
let sar12_n = v(TOPN)[sar12_k]
let sar12_decision = 0
if sar12_cmp >= 0.9
let sar12_code = sar12_trial
let sar12_decision = 1
end
echo 3 6 $&sar12_trial $&sar12_cmp $&sar12_cmpn $&sar12_p $&sar12_n -1.18154296875 $&sar12_decision >> decisions.csv
alter VD_EVAL = 0
let sar12_trial = sar12_code + 32
let sar12_drive = (floor(sar12_trial / 1) - 2*floor(sar12_trial / 2))*1.8
alter VD_B0 = $&sar12_drive
let sar12_drive = (floor(sar12_trial / 2) - 2*floor(sar12_trial / 4))*1.8
alter VD_B1 = $&sar12_drive
let sar12_drive = (floor(sar12_trial / 4) - 2*floor(sar12_trial / 8))*1.8
alter VD_B2 = $&sar12_drive
let sar12_drive = (floor(sar12_trial / 8) - 2*floor(sar12_trial / 16))*1.8
alter VD_B3 = $&sar12_drive
let sar12_drive = (floor(sar12_trial / 16) - 2*floor(sar12_trial / 32))*1.8
alter VD_B4 = $&sar12_drive
let sar12_drive = (floor(sar12_trial / 32) - 2*floor(sar12_trial / 64))*1.8
alter VD_B5 = $&sar12_drive
let sar12_drive = (floor(sar12_trial / 64) - 2*floor(sar12_trial / 128))*1.8
alter VD_B6 = $&sar12_drive
let sar12_drive = (floor(sar12_trial / 128) - 2*floor(sar12_trial / 256))*1.8
alter VD_B7 = $&sar12_drive
let sar12_drive = (floor(sar12_trial / 256) - 2*floor(sar12_trial / 512))*1.8
alter VD_B8 = $&sar12_drive
let sar12_drive = (floor(sar12_trial / 512) - 2*floor(sar12_trial / 1024))*1.8
alter VD_B9 = $&sar12_drive
let sar12_drive = (floor(sar12_trial / 1024) - 2*floor(sar12_trial / 2048))*1.8
alter VD_B10 = $&sar12_drive
let sar12_drive = (floor(sar12_trial / 2048) - 2*floor(sar12_trial / 4096))*1.8
alter VD_B11 = $&sar12_drive
stop when time ge 3.7524999999e-05
resume
let sar12_k = length(time)-1
if abs(time[sar12_k] - 3.7525e-05) > 1e-12
print time[sar12_k]
echo expected_pause_time_s 3.7525e-05
echo SAR12_PAUSE_FAILED
quit 1
end
print time[sar12_k] >> pause-times.txt
delete all
alter VD_EVAL = 1.8
stop when time ge 3.7699999999e-05
resume
let sar12_k = length(time)-1
if abs(time[sar12_k] - 3.77e-05) > 1e-12
print time[sar12_k]
echo expected_pause_time_s 3.77e-05
echo SAR12_PAUSE_FAILED
quit 1
end
print time[sar12_k] >> pause-times.txt
delete all
let sar12_k = length(time)-1
let sar12_cmp = v(COMP)[sar12_k]
let sar12_cmpn = v(COMPN)[sar12_k]
let sar12_p = v(TOPP)[sar12_k]
let sar12_n = v(TOPN)[sar12_k]
let sar12_decision = 0
if sar12_cmp >= 0.9
let sar12_code = sar12_trial
let sar12_decision = 1
end
echo 3 5 $&sar12_trial $&sar12_cmp $&sar12_cmpn $&sar12_p $&sar12_n -1.18154296875 $&sar12_decision >> decisions.csv
alter VD_EVAL = 0
let sar12_trial = sar12_code + 16
let sar12_drive = (floor(sar12_trial / 1) - 2*floor(sar12_trial / 2))*1.8
alter VD_B0 = $&sar12_drive
let sar12_drive = (floor(sar12_trial / 2) - 2*floor(sar12_trial / 4))*1.8
alter VD_B1 = $&sar12_drive
let sar12_drive = (floor(sar12_trial / 4) - 2*floor(sar12_trial / 8))*1.8
alter VD_B2 = $&sar12_drive
let sar12_drive = (floor(sar12_trial / 8) - 2*floor(sar12_trial / 16))*1.8
alter VD_B3 = $&sar12_drive
let sar12_drive = (floor(sar12_trial / 16) - 2*floor(sar12_trial / 32))*1.8
alter VD_B4 = $&sar12_drive
let sar12_drive = (floor(sar12_trial / 32) - 2*floor(sar12_trial / 64))*1.8
alter VD_B5 = $&sar12_drive
let sar12_drive = (floor(sar12_trial / 64) - 2*floor(sar12_trial / 128))*1.8
alter VD_B6 = $&sar12_drive
let sar12_drive = (floor(sar12_trial / 128) - 2*floor(sar12_trial / 256))*1.8
alter VD_B7 = $&sar12_drive
let sar12_drive = (floor(sar12_trial / 256) - 2*floor(sar12_trial / 512))*1.8
alter VD_B8 = $&sar12_drive
let sar12_drive = (floor(sar12_trial / 512) - 2*floor(sar12_trial / 1024))*1.8
alter VD_B9 = $&sar12_drive
let sar12_drive = (floor(sar12_trial / 1024) - 2*floor(sar12_trial / 2048))*1.8
alter VD_B10 = $&sar12_drive
let sar12_drive = (floor(sar12_trial / 2048) - 2*floor(sar12_trial / 4096))*1.8
alter VD_B11 = $&sar12_drive
stop when time ge 3.8024999999e-05
resume
let sar12_k = length(time)-1
if abs(time[sar12_k] - 3.8025e-05) > 1e-12
print time[sar12_k]
echo expected_pause_time_s 3.8025e-05
echo SAR12_PAUSE_FAILED
quit 1
end
print time[sar12_k] >> pause-times.txt
delete all
alter VD_EVAL = 1.8
stop when time ge 3.8199999999e-05
resume
let sar12_k = length(time)-1
if abs(time[sar12_k] - 3.82e-05) > 1e-12
print time[sar12_k]
echo expected_pause_time_s 3.82e-05
echo SAR12_PAUSE_FAILED
quit 1
end
print time[sar12_k] >> pause-times.txt
delete all
let sar12_k = length(time)-1
let sar12_cmp = v(COMP)[sar12_k]
let sar12_cmpn = v(COMPN)[sar12_k]
let sar12_p = v(TOPP)[sar12_k]
let sar12_n = v(TOPN)[sar12_k]
let sar12_decision = 0
if sar12_cmp >= 0.9
let sar12_code = sar12_trial
let sar12_decision = 1
end
echo 3 4 $&sar12_trial $&sar12_cmp $&sar12_cmpn $&sar12_p $&sar12_n -1.18154296875 $&sar12_decision >> decisions.csv
alter VD_EVAL = 0
let sar12_trial = sar12_code + 8
let sar12_drive = (floor(sar12_trial / 1) - 2*floor(sar12_trial / 2))*1.8
alter VD_B0 = $&sar12_drive
let sar12_drive = (floor(sar12_trial / 2) - 2*floor(sar12_trial / 4))*1.8
alter VD_B1 = $&sar12_drive
let sar12_drive = (floor(sar12_trial / 4) - 2*floor(sar12_trial / 8))*1.8
alter VD_B2 = $&sar12_drive
let sar12_drive = (floor(sar12_trial / 8) - 2*floor(sar12_trial / 16))*1.8
alter VD_B3 = $&sar12_drive
let sar12_drive = (floor(sar12_trial / 16) - 2*floor(sar12_trial / 32))*1.8
alter VD_B4 = $&sar12_drive
let sar12_drive = (floor(sar12_trial / 32) - 2*floor(sar12_trial / 64))*1.8
alter VD_B5 = $&sar12_drive
let sar12_drive = (floor(sar12_trial / 64) - 2*floor(sar12_trial / 128))*1.8
alter VD_B6 = $&sar12_drive
let sar12_drive = (floor(sar12_trial / 128) - 2*floor(sar12_trial / 256))*1.8
alter VD_B7 = $&sar12_drive
let sar12_drive = (floor(sar12_trial / 256) - 2*floor(sar12_trial / 512))*1.8
alter VD_B8 = $&sar12_drive
let sar12_drive = (floor(sar12_trial / 512) - 2*floor(sar12_trial / 1024))*1.8
alter VD_B9 = $&sar12_drive
let sar12_drive = (floor(sar12_trial / 1024) - 2*floor(sar12_trial / 2048))*1.8
alter VD_B10 = $&sar12_drive
let sar12_drive = (floor(sar12_trial / 2048) - 2*floor(sar12_trial / 4096))*1.8
alter VD_B11 = $&sar12_drive
stop when time ge 3.8524999999e-05
resume
let sar12_k = length(time)-1
if abs(time[sar12_k] - 3.8525e-05) > 1e-12
print time[sar12_k]
echo expected_pause_time_s 3.8525e-05
echo SAR12_PAUSE_FAILED
quit 1
end
print time[sar12_k] >> pause-times.txt
delete all
alter VD_EVAL = 1.8
stop when time ge 3.8699999999e-05
resume
let sar12_k = length(time)-1
if abs(time[sar12_k] - 3.87e-05) > 1e-12
print time[sar12_k]
echo expected_pause_time_s 3.87e-05
echo SAR12_PAUSE_FAILED
quit 1
end
print time[sar12_k] >> pause-times.txt
delete all
let sar12_k = length(time)-1
let sar12_cmp = v(COMP)[sar12_k]
let sar12_cmpn = v(COMPN)[sar12_k]
let sar12_p = v(TOPP)[sar12_k]
let sar12_n = v(TOPN)[sar12_k]
let sar12_decision = 0
if sar12_cmp >= 0.9
let sar12_code = sar12_trial
let sar12_decision = 1
end
echo 3 3 $&sar12_trial $&sar12_cmp $&sar12_cmpn $&sar12_p $&sar12_n -1.18154296875 $&sar12_decision >> decisions.csv
alter VD_EVAL = 0
let sar12_trial = sar12_code + 4
let sar12_drive = (floor(sar12_trial / 1) - 2*floor(sar12_trial / 2))*1.8
alter VD_B0 = $&sar12_drive
let sar12_drive = (floor(sar12_trial / 2) - 2*floor(sar12_trial / 4))*1.8
alter VD_B1 = $&sar12_drive
let sar12_drive = (floor(sar12_trial / 4) - 2*floor(sar12_trial / 8))*1.8
alter VD_B2 = $&sar12_drive
let sar12_drive = (floor(sar12_trial / 8) - 2*floor(sar12_trial / 16))*1.8
alter VD_B3 = $&sar12_drive
let sar12_drive = (floor(sar12_trial / 16) - 2*floor(sar12_trial / 32))*1.8
alter VD_B4 = $&sar12_drive
let sar12_drive = (floor(sar12_trial / 32) - 2*floor(sar12_trial / 64))*1.8
alter VD_B5 = $&sar12_drive
let sar12_drive = (floor(sar12_trial / 64) - 2*floor(sar12_trial / 128))*1.8
alter VD_B6 = $&sar12_drive
let sar12_drive = (floor(sar12_trial / 128) - 2*floor(sar12_trial / 256))*1.8
alter VD_B7 = $&sar12_drive
let sar12_drive = (floor(sar12_trial / 256) - 2*floor(sar12_trial / 512))*1.8
alter VD_B8 = $&sar12_drive
let sar12_drive = (floor(sar12_trial / 512) - 2*floor(sar12_trial / 1024))*1.8
alter VD_B9 = $&sar12_drive
let sar12_drive = (floor(sar12_trial / 1024) - 2*floor(sar12_trial / 2048))*1.8
alter VD_B10 = $&sar12_drive
let sar12_drive = (floor(sar12_trial / 2048) - 2*floor(sar12_trial / 4096))*1.8
alter VD_B11 = $&sar12_drive
stop when time ge 3.9024999999e-05
resume
let sar12_k = length(time)-1
if abs(time[sar12_k] - 3.9025e-05) > 1e-12
print time[sar12_k]
echo expected_pause_time_s 3.9025e-05
echo SAR12_PAUSE_FAILED
quit 1
end
print time[sar12_k] >> pause-times.txt
delete all
alter VD_EVAL = 1.8
stop when time ge 3.9199999999e-05
resume
let sar12_k = length(time)-1
if abs(time[sar12_k] - 3.92e-05) > 1e-12
print time[sar12_k]
echo expected_pause_time_s 3.92e-05
echo SAR12_PAUSE_FAILED
quit 1
end
print time[sar12_k] >> pause-times.txt
delete all
let sar12_k = length(time)-1
let sar12_cmp = v(COMP)[sar12_k]
let sar12_cmpn = v(COMPN)[sar12_k]
let sar12_p = v(TOPP)[sar12_k]
let sar12_n = v(TOPN)[sar12_k]
let sar12_decision = 0
if sar12_cmp >= 0.9
let sar12_code = sar12_trial
let sar12_decision = 1
end
echo 3 2 $&sar12_trial $&sar12_cmp $&sar12_cmpn $&sar12_p $&sar12_n -1.18154296875 $&sar12_decision >> decisions.csv
alter VD_EVAL = 0
let sar12_trial = sar12_code + 2
let sar12_drive = (floor(sar12_trial / 1) - 2*floor(sar12_trial / 2))*1.8
alter VD_B0 = $&sar12_drive
let sar12_drive = (floor(sar12_trial / 2) - 2*floor(sar12_trial / 4))*1.8
alter VD_B1 = $&sar12_drive
let sar12_drive = (floor(sar12_trial / 4) - 2*floor(sar12_trial / 8))*1.8
alter VD_B2 = $&sar12_drive
let sar12_drive = (floor(sar12_trial / 8) - 2*floor(sar12_trial / 16))*1.8
alter VD_B3 = $&sar12_drive
let sar12_drive = (floor(sar12_trial / 16) - 2*floor(sar12_trial / 32))*1.8
alter VD_B4 = $&sar12_drive
let sar12_drive = (floor(sar12_trial / 32) - 2*floor(sar12_trial / 64))*1.8
alter VD_B5 = $&sar12_drive
let sar12_drive = (floor(sar12_trial / 64) - 2*floor(sar12_trial / 128))*1.8
alter VD_B6 = $&sar12_drive
let sar12_drive = (floor(sar12_trial / 128) - 2*floor(sar12_trial / 256))*1.8
alter VD_B7 = $&sar12_drive
let sar12_drive = (floor(sar12_trial / 256) - 2*floor(sar12_trial / 512))*1.8
alter VD_B8 = $&sar12_drive
let sar12_drive = (floor(sar12_trial / 512) - 2*floor(sar12_trial / 1024))*1.8
alter VD_B9 = $&sar12_drive
let sar12_drive = (floor(sar12_trial / 1024) - 2*floor(sar12_trial / 2048))*1.8
alter VD_B10 = $&sar12_drive
let sar12_drive = (floor(sar12_trial / 2048) - 2*floor(sar12_trial / 4096))*1.8
alter VD_B11 = $&sar12_drive
stop when time ge 3.9524999999e-05
resume
let sar12_k = length(time)-1
if abs(time[sar12_k] - 3.9525e-05) > 1e-12
print time[sar12_k]
echo expected_pause_time_s 3.9525e-05
echo SAR12_PAUSE_FAILED
quit 1
end
print time[sar12_k] >> pause-times.txt
delete all
alter VD_EVAL = 1.8
stop when time ge 3.9699999999e-05
resume
let sar12_k = length(time)-1
if abs(time[sar12_k] - 3.97e-05) > 1e-12
print time[sar12_k]
echo expected_pause_time_s 3.97e-05
echo SAR12_PAUSE_FAILED
quit 1
end
print time[sar12_k] >> pause-times.txt
delete all
let sar12_k = length(time)-1
let sar12_cmp = v(COMP)[sar12_k]
let sar12_cmpn = v(COMPN)[sar12_k]
let sar12_p = v(TOPP)[sar12_k]
let sar12_n = v(TOPN)[sar12_k]
let sar12_decision = 0
if sar12_cmp >= 0.9
let sar12_code = sar12_trial
let sar12_decision = 1
end
echo 3 1 $&sar12_trial $&sar12_cmp $&sar12_cmpn $&sar12_p $&sar12_n -1.18154296875 $&sar12_decision >> decisions.csv
alter VD_EVAL = 0
let sar12_trial = sar12_code + 1
let sar12_drive = (floor(sar12_trial / 1) - 2*floor(sar12_trial / 2))*1.8
alter VD_B0 = $&sar12_drive
let sar12_drive = (floor(sar12_trial / 2) - 2*floor(sar12_trial / 4))*1.8
alter VD_B1 = $&sar12_drive
let sar12_drive = (floor(sar12_trial / 4) - 2*floor(sar12_trial / 8))*1.8
alter VD_B2 = $&sar12_drive
let sar12_drive = (floor(sar12_trial / 8) - 2*floor(sar12_trial / 16))*1.8
alter VD_B3 = $&sar12_drive
let sar12_drive = (floor(sar12_trial / 16) - 2*floor(sar12_trial / 32))*1.8
alter VD_B4 = $&sar12_drive
let sar12_drive = (floor(sar12_trial / 32) - 2*floor(sar12_trial / 64))*1.8
alter VD_B5 = $&sar12_drive
let sar12_drive = (floor(sar12_trial / 64) - 2*floor(sar12_trial / 128))*1.8
alter VD_B6 = $&sar12_drive
let sar12_drive = (floor(sar12_trial / 128) - 2*floor(sar12_trial / 256))*1.8
alter VD_B7 = $&sar12_drive
let sar12_drive = (floor(sar12_trial / 256) - 2*floor(sar12_trial / 512))*1.8
alter VD_B8 = $&sar12_drive
let sar12_drive = (floor(sar12_trial / 512) - 2*floor(sar12_trial / 1024))*1.8
alter VD_B9 = $&sar12_drive
let sar12_drive = (floor(sar12_trial / 1024) - 2*floor(sar12_trial / 2048))*1.8
alter VD_B10 = $&sar12_drive
let sar12_drive = (floor(sar12_trial / 2048) - 2*floor(sar12_trial / 4096))*1.8
alter VD_B11 = $&sar12_drive
stop when time ge 4.0024999999e-05
resume
let sar12_k = length(time)-1
if abs(time[sar12_k] - 4.0025e-05) > 1e-12
print time[sar12_k]
echo expected_pause_time_s 4.0025e-05
echo SAR12_PAUSE_FAILED
quit 1
end
print time[sar12_k] >> pause-times.txt
delete all
alter VD_EVAL = 1.8
stop when time ge 4.0199999999e-05
resume
let sar12_k = length(time)-1
if abs(time[sar12_k] - 4.02e-05) > 1e-12
print time[sar12_k]
echo expected_pause_time_s 4.02e-05
echo SAR12_PAUSE_FAILED
quit 1
end
print time[sar12_k] >> pause-times.txt
delete all
let sar12_k = length(time)-1
let sar12_cmp = v(COMP)[sar12_k]
let sar12_cmpn = v(COMPN)[sar12_k]
let sar12_p = v(TOPP)[sar12_k]
let sar12_n = v(TOPN)[sar12_k]
let sar12_decision = 0
if sar12_cmp >= 0.9
let sar12_code = sar12_trial
let sar12_decision = 1
end
echo 3 0 $&sar12_trial $&sar12_cmp $&sar12_cmpn $&sar12_p $&sar12_n -1.18154296875 $&sar12_decision >> decisions.csv
alter VD_EVAL = 0
alter VINP = 0.318603515625
alter VINN = 1.48139648438
alter VD_SAMPLE = 1.8
alter VD_EVAL = 0
alter VD_B0 = 0
alter VD_B1 = 0
alter VD_B2 = 0
alter VD_B3 = 0
alter VD_B4 = 0
alter VD_B5 = 0
alter VD_B6 = 0
alter VD_B7 = 0
alter VD_B8 = 0
alter VD_B9 = 0
alter VD_B10 = 0
alter VD_B11 = 0
let sar12_code = 0
stop when time ge 4.4199999999e-05
resume
let sar12_k = length(time)-1
if abs(time[sar12_k] - 4.42e-05) > 1e-12
print time[sar12_k]
echo expected_pause_time_s 4.42e-05
echo SAR12_PAUSE_FAILED
quit 1
end
print time[sar12_k] >> pause-times.txt
delete all
alter VD_SAMPLE = 0
stop when time ge 4.4249999999e-05
resume
let sar12_k = length(time)-1
if abs(time[sar12_k] - 4.425e-05) > 1e-12
print time[sar12_k]
echo expected_pause_time_s 4.425e-05
echo SAR12_PAUSE_FAILED
quit 1
end
print time[sar12_k] >> pause-times.txt
delete all
alter VD_EVAL = 0
let sar12_trial = sar12_code + 2048
let sar12_drive = (floor(sar12_trial / 1) - 2*floor(sar12_trial / 2))*1.8
alter VD_B0 = $&sar12_drive
let sar12_drive = (floor(sar12_trial / 2) - 2*floor(sar12_trial / 4))*1.8
alter VD_B1 = $&sar12_drive
let sar12_drive = (floor(sar12_trial / 4) - 2*floor(sar12_trial / 8))*1.8
alter VD_B2 = $&sar12_drive
let sar12_drive = (floor(sar12_trial / 8) - 2*floor(sar12_trial / 16))*1.8
alter VD_B3 = $&sar12_drive
let sar12_drive = (floor(sar12_trial / 16) - 2*floor(sar12_trial / 32))*1.8
alter VD_B4 = $&sar12_drive
let sar12_drive = (floor(sar12_trial / 32) - 2*floor(sar12_trial / 64))*1.8
alter VD_B5 = $&sar12_drive
let sar12_drive = (floor(sar12_trial / 64) - 2*floor(sar12_trial / 128))*1.8
alter VD_B6 = $&sar12_drive
let sar12_drive = (floor(sar12_trial / 128) - 2*floor(sar12_trial / 256))*1.8
alter VD_B7 = $&sar12_drive
let sar12_drive = (floor(sar12_trial / 256) - 2*floor(sar12_trial / 512))*1.8
alter VD_B8 = $&sar12_drive
let sar12_drive = (floor(sar12_trial / 512) - 2*floor(sar12_trial / 1024))*1.8
alter VD_B9 = $&sar12_drive
let sar12_drive = (floor(sar12_trial / 1024) - 2*floor(sar12_trial / 2048))*1.8
alter VD_B10 = $&sar12_drive
let sar12_drive = (floor(sar12_trial / 2048) - 2*floor(sar12_trial / 4096))*1.8
alter VD_B11 = $&sar12_drive
stop when time ge 4.4574999999e-05
resume
let sar12_k = length(time)-1
if abs(time[sar12_k] - 4.4575e-05) > 1e-12
print time[sar12_k]
echo expected_pause_time_s 4.4575e-05
echo SAR12_PAUSE_FAILED
quit 1
end
print time[sar12_k] >> pause-times.txt
delete all
alter VD_EVAL = 1.8
stop when time ge 4.4749999999e-05
resume
let sar12_k = length(time)-1
if abs(time[sar12_k] - 4.475e-05) > 1e-12
print time[sar12_k]
echo expected_pause_time_s 4.475e-05
echo SAR12_PAUSE_FAILED
quit 1
end
print time[sar12_k] >> pause-times.txt
delete all
let sar12_k = length(time)-1
let sar12_cmp = v(COMP)[sar12_k]
let sar12_cmpn = v(COMPN)[sar12_k]
let sar12_p = v(TOPP)[sar12_k]
let sar12_n = v(TOPN)[sar12_k]
let sar12_decision = 0
if sar12_cmp >= 0.9
let sar12_code = sar12_trial
let sar12_decision = 1
end
echo 4 11 $&sar12_trial $&sar12_cmp $&sar12_cmpn $&sar12_p $&sar12_n -1.16279296875 $&sar12_decision >> decisions.csv
alter VD_EVAL = 0
let sar12_trial = sar12_code + 1024
let sar12_drive = (floor(sar12_trial / 1) - 2*floor(sar12_trial / 2))*1.8
alter VD_B0 = $&sar12_drive
let sar12_drive = (floor(sar12_trial / 2) - 2*floor(sar12_trial / 4))*1.8
alter VD_B1 = $&sar12_drive
let sar12_drive = (floor(sar12_trial / 4) - 2*floor(sar12_trial / 8))*1.8
alter VD_B2 = $&sar12_drive
let sar12_drive = (floor(sar12_trial / 8) - 2*floor(sar12_trial / 16))*1.8
alter VD_B3 = $&sar12_drive
let sar12_drive = (floor(sar12_trial / 16) - 2*floor(sar12_trial / 32))*1.8
alter VD_B4 = $&sar12_drive
let sar12_drive = (floor(sar12_trial / 32) - 2*floor(sar12_trial / 64))*1.8
alter VD_B5 = $&sar12_drive
let sar12_drive = (floor(sar12_trial / 64) - 2*floor(sar12_trial / 128))*1.8
alter VD_B6 = $&sar12_drive
let sar12_drive = (floor(sar12_trial / 128) - 2*floor(sar12_trial / 256))*1.8
alter VD_B7 = $&sar12_drive
let sar12_drive = (floor(sar12_trial / 256) - 2*floor(sar12_trial / 512))*1.8
alter VD_B8 = $&sar12_drive
let sar12_drive = (floor(sar12_trial / 512) - 2*floor(sar12_trial / 1024))*1.8
alter VD_B9 = $&sar12_drive
let sar12_drive = (floor(sar12_trial / 1024) - 2*floor(sar12_trial / 2048))*1.8
alter VD_B10 = $&sar12_drive
let sar12_drive = (floor(sar12_trial / 2048) - 2*floor(sar12_trial / 4096))*1.8
alter VD_B11 = $&sar12_drive
stop when time ge 4.5074999999e-05
resume
let sar12_k = length(time)-1
if abs(time[sar12_k] - 4.5075e-05) > 1e-12
print time[sar12_k]
echo expected_pause_time_s 4.5075e-05
echo SAR12_PAUSE_FAILED
quit 1
end
print time[sar12_k] >> pause-times.txt
delete all
alter VD_EVAL = 1.8
stop when time ge 4.5249999999e-05
resume
let sar12_k = length(time)-1
if abs(time[sar12_k] - 4.525e-05) > 1e-12
print time[sar12_k]
echo expected_pause_time_s 4.525e-05
echo SAR12_PAUSE_FAILED
quit 1
end
print time[sar12_k] >> pause-times.txt
delete all
let sar12_k = length(time)-1
let sar12_cmp = v(COMP)[sar12_k]
let sar12_cmpn = v(COMPN)[sar12_k]
let sar12_p = v(TOPP)[sar12_k]
let sar12_n = v(TOPN)[sar12_k]
let sar12_decision = 0
if sar12_cmp >= 0.9
let sar12_code = sar12_trial
let sar12_decision = 1
end
echo 4 10 $&sar12_trial $&sar12_cmp $&sar12_cmpn $&sar12_p $&sar12_n -1.16279296875 $&sar12_decision >> decisions.csv
alter VD_EVAL = 0
let sar12_trial = sar12_code + 512
let sar12_drive = (floor(sar12_trial / 1) - 2*floor(sar12_trial / 2))*1.8
alter VD_B0 = $&sar12_drive
let sar12_drive = (floor(sar12_trial / 2) - 2*floor(sar12_trial / 4))*1.8
alter VD_B1 = $&sar12_drive
let sar12_drive = (floor(sar12_trial / 4) - 2*floor(sar12_trial / 8))*1.8
alter VD_B2 = $&sar12_drive
let sar12_drive = (floor(sar12_trial / 8) - 2*floor(sar12_trial / 16))*1.8
alter VD_B3 = $&sar12_drive
let sar12_drive = (floor(sar12_trial / 16) - 2*floor(sar12_trial / 32))*1.8
alter VD_B4 = $&sar12_drive
let sar12_drive = (floor(sar12_trial / 32) - 2*floor(sar12_trial / 64))*1.8
alter VD_B5 = $&sar12_drive
let sar12_drive = (floor(sar12_trial / 64) - 2*floor(sar12_trial / 128))*1.8
alter VD_B6 = $&sar12_drive
let sar12_drive = (floor(sar12_trial / 128) - 2*floor(sar12_trial / 256))*1.8
alter VD_B7 = $&sar12_drive
let sar12_drive = (floor(sar12_trial / 256) - 2*floor(sar12_trial / 512))*1.8
alter VD_B8 = $&sar12_drive
let sar12_drive = (floor(sar12_trial / 512) - 2*floor(sar12_trial / 1024))*1.8
alter VD_B9 = $&sar12_drive
let sar12_drive = (floor(sar12_trial / 1024) - 2*floor(sar12_trial / 2048))*1.8
alter VD_B10 = $&sar12_drive
let sar12_drive = (floor(sar12_trial / 2048) - 2*floor(sar12_trial / 4096))*1.8
alter VD_B11 = $&sar12_drive
stop when time ge 4.5574999999e-05
resume
let sar12_k = length(time)-1
if abs(time[sar12_k] - 4.5575e-05) > 1e-12
print time[sar12_k]
echo expected_pause_time_s 4.5575e-05
echo SAR12_PAUSE_FAILED
quit 1
end
print time[sar12_k] >> pause-times.txt
delete all
alter VD_EVAL = 1.8
stop when time ge 4.5749999999e-05
resume
let sar12_k = length(time)-1
if abs(time[sar12_k] - 4.575e-05) > 1e-12
print time[sar12_k]
echo expected_pause_time_s 4.575e-05
echo SAR12_PAUSE_FAILED
quit 1
end
print time[sar12_k] >> pause-times.txt
delete all
let sar12_k = length(time)-1
let sar12_cmp = v(COMP)[sar12_k]
let sar12_cmpn = v(COMPN)[sar12_k]
let sar12_p = v(TOPP)[sar12_k]
let sar12_n = v(TOPN)[sar12_k]
let sar12_decision = 0
if sar12_cmp >= 0.9
let sar12_code = sar12_trial
let sar12_decision = 1
end
echo 4 9 $&sar12_trial $&sar12_cmp $&sar12_cmpn $&sar12_p $&sar12_n -1.16279296875 $&sar12_decision >> decisions.csv
alter VD_EVAL = 0
let sar12_trial = sar12_code + 256
let sar12_drive = (floor(sar12_trial / 1) - 2*floor(sar12_trial / 2))*1.8
alter VD_B0 = $&sar12_drive
let sar12_drive = (floor(sar12_trial / 2) - 2*floor(sar12_trial / 4))*1.8
alter VD_B1 = $&sar12_drive
let sar12_drive = (floor(sar12_trial / 4) - 2*floor(sar12_trial / 8))*1.8
alter VD_B2 = $&sar12_drive
let sar12_drive = (floor(sar12_trial / 8) - 2*floor(sar12_trial / 16))*1.8
alter VD_B3 = $&sar12_drive
let sar12_drive = (floor(sar12_trial / 16) - 2*floor(sar12_trial / 32))*1.8
alter VD_B4 = $&sar12_drive
let sar12_drive = (floor(sar12_trial / 32) - 2*floor(sar12_trial / 64))*1.8
alter VD_B5 = $&sar12_drive
let sar12_drive = (floor(sar12_trial / 64) - 2*floor(sar12_trial / 128))*1.8
alter VD_B6 = $&sar12_drive
let sar12_drive = (floor(sar12_trial / 128) - 2*floor(sar12_trial / 256))*1.8
alter VD_B7 = $&sar12_drive
let sar12_drive = (floor(sar12_trial / 256) - 2*floor(sar12_trial / 512))*1.8
alter VD_B8 = $&sar12_drive
let sar12_drive = (floor(sar12_trial / 512) - 2*floor(sar12_trial / 1024))*1.8
alter VD_B9 = $&sar12_drive
let sar12_drive = (floor(sar12_trial / 1024) - 2*floor(sar12_trial / 2048))*1.8
alter VD_B10 = $&sar12_drive
let sar12_drive = (floor(sar12_trial / 2048) - 2*floor(sar12_trial / 4096))*1.8
alter VD_B11 = $&sar12_drive
stop when time ge 4.6074999999e-05
resume
let sar12_k = length(time)-1
if abs(time[sar12_k] - 4.6075e-05) > 1e-12
print time[sar12_k]
echo expected_pause_time_s 4.6075e-05
echo SAR12_PAUSE_FAILED
quit 1
end
print time[sar12_k] >> pause-times.txt
delete all
alter VD_EVAL = 1.8
stop when time ge 4.6249999999e-05
resume
let sar12_k = length(time)-1
if abs(time[sar12_k] - 4.625e-05) > 1e-12
print time[sar12_k]
echo expected_pause_time_s 4.625e-05
echo SAR12_PAUSE_FAILED
quit 1
end
print time[sar12_k] >> pause-times.txt
delete all
let sar12_k = length(time)-1
let sar12_cmp = v(COMP)[sar12_k]
let sar12_cmpn = v(COMPN)[sar12_k]
let sar12_p = v(TOPP)[sar12_k]
let sar12_n = v(TOPN)[sar12_k]
let sar12_decision = 0
if sar12_cmp >= 0.9
let sar12_code = sar12_trial
let sar12_decision = 1
end
echo 4 8 $&sar12_trial $&sar12_cmp $&sar12_cmpn $&sar12_p $&sar12_n -1.16279296875 $&sar12_decision >> decisions.csv
alter VD_EVAL = 0
let sar12_trial = sar12_code + 128
let sar12_drive = (floor(sar12_trial / 1) - 2*floor(sar12_trial / 2))*1.8
alter VD_B0 = $&sar12_drive
let sar12_drive = (floor(sar12_trial / 2) - 2*floor(sar12_trial / 4))*1.8
alter VD_B1 = $&sar12_drive
let sar12_drive = (floor(sar12_trial / 4) - 2*floor(sar12_trial / 8))*1.8
alter VD_B2 = $&sar12_drive
let sar12_drive = (floor(sar12_trial / 8) - 2*floor(sar12_trial / 16))*1.8
alter VD_B3 = $&sar12_drive
let sar12_drive = (floor(sar12_trial / 16) - 2*floor(sar12_trial / 32))*1.8
alter VD_B4 = $&sar12_drive
let sar12_drive = (floor(sar12_trial / 32) - 2*floor(sar12_trial / 64))*1.8
alter VD_B5 = $&sar12_drive
let sar12_drive = (floor(sar12_trial / 64) - 2*floor(sar12_trial / 128))*1.8
alter VD_B6 = $&sar12_drive
let sar12_drive = (floor(sar12_trial / 128) - 2*floor(sar12_trial / 256))*1.8
alter VD_B7 = $&sar12_drive
let sar12_drive = (floor(sar12_trial / 256) - 2*floor(sar12_trial / 512))*1.8
alter VD_B8 = $&sar12_drive
let sar12_drive = (floor(sar12_trial / 512) - 2*floor(sar12_trial / 1024))*1.8
alter VD_B9 = $&sar12_drive
let sar12_drive = (floor(sar12_trial / 1024) - 2*floor(sar12_trial / 2048))*1.8
alter VD_B10 = $&sar12_drive
let sar12_drive = (floor(sar12_trial / 2048) - 2*floor(sar12_trial / 4096))*1.8
alter VD_B11 = $&sar12_drive
stop when time ge 4.6574999999e-05
resume
let sar12_k = length(time)-1
if abs(time[sar12_k] - 4.6575e-05) > 1e-12
print time[sar12_k]
echo expected_pause_time_s 4.6575e-05
echo SAR12_PAUSE_FAILED
quit 1
end
print time[sar12_k] >> pause-times.txt
delete all
alter VD_EVAL = 1.8
stop when time ge 4.6749999999e-05
resume
let sar12_k = length(time)-1
if abs(time[sar12_k] - 4.675e-05) > 1e-12
print time[sar12_k]
echo expected_pause_time_s 4.675e-05
echo SAR12_PAUSE_FAILED
quit 1
end
print time[sar12_k] >> pause-times.txt
delete all
let sar12_k = length(time)-1
let sar12_cmp = v(COMP)[sar12_k]
let sar12_cmpn = v(COMPN)[sar12_k]
let sar12_p = v(TOPP)[sar12_k]
let sar12_n = v(TOPN)[sar12_k]
let sar12_decision = 0
if sar12_cmp >= 0.9
let sar12_code = sar12_trial
let sar12_decision = 1
end
echo 4 7 $&sar12_trial $&sar12_cmp $&sar12_cmpn $&sar12_p $&sar12_n -1.16279296875 $&sar12_decision >> decisions.csv
alter VD_EVAL = 0
let sar12_trial = sar12_code + 64
let sar12_drive = (floor(sar12_trial / 1) - 2*floor(sar12_trial / 2))*1.8
alter VD_B0 = $&sar12_drive
let sar12_drive = (floor(sar12_trial / 2) - 2*floor(sar12_trial / 4))*1.8
alter VD_B1 = $&sar12_drive
let sar12_drive = (floor(sar12_trial / 4) - 2*floor(sar12_trial / 8))*1.8
alter VD_B2 = $&sar12_drive
let sar12_drive = (floor(sar12_trial / 8) - 2*floor(sar12_trial / 16))*1.8
alter VD_B3 = $&sar12_drive
let sar12_drive = (floor(sar12_trial / 16) - 2*floor(sar12_trial / 32))*1.8
alter VD_B4 = $&sar12_drive
let sar12_drive = (floor(sar12_trial / 32) - 2*floor(sar12_trial / 64))*1.8
alter VD_B5 = $&sar12_drive
let sar12_drive = (floor(sar12_trial / 64) - 2*floor(sar12_trial / 128))*1.8
alter VD_B6 = $&sar12_drive
let sar12_drive = (floor(sar12_trial / 128) - 2*floor(sar12_trial / 256))*1.8
alter VD_B7 = $&sar12_drive
let sar12_drive = (floor(sar12_trial / 256) - 2*floor(sar12_trial / 512))*1.8
alter VD_B8 = $&sar12_drive
let sar12_drive = (floor(sar12_trial / 512) - 2*floor(sar12_trial / 1024))*1.8
alter VD_B9 = $&sar12_drive
let sar12_drive = (floor(sar12_trial / 1024) - 2*floor(sar12_trial / 2048))*1.8
alter VD_B10 = $&sar12_drive
let sar12_drive = (floor(sar12_trial / 2048) - 2*floor(sar12_trial / 4096))*1.8
alter VD_B11 = $&sar12_drive
stop when time ge 4.7074999999e-05
resume
let sar12_k = length(time)-1
if abs(time[sar12_k] - 4.7075e-05) > 1e-12
print time[sar12_k]
echo expected_pause_time_s 4.7075e-05
echo SAR12_PAUSE_FAILED
quit 1
end
print time[sar12_k] >> pause-times.txt
delete all
alter VD_EVAL = 1.8
stop when time ge 4.7249999999e-05
resume
let sar12_k = length(time)-1
if abs(time[sar12_k] - 4.725e-05) > 1e-12
print time[sar12_k]
echo expected_pause_time_s 4.725e-05
echo SAR12_PAUSE_FAILED
quit 1
end
print time[sar12_k] >> pause-times.txt
delete all
let sar12_k = length(time)-1
let sar12_cmp = v(COMP)[sar12_k]
let sar12_cmpn = v(COMPN)[sar12_k]
let sar12_p = v(TOPP)[sar12_k]
let sar12_n = v(TOPN)[sar12_k]
let sar12_decision = 0
if sar12_cmp >= 0.9
let sar12_code = sar12_trial
let sar12_decision = 1
end
echo 4 6 $&sar12_trial $&sar12_cmp $&sar12_cmpn $&sar12_p $&sar12_n -1.16279296875 $&sar12_decision >> decisions.csv
alter VD_EVAL = 0
let sar12_trial = sar12_code + 32
let sar12_drive = (floor(sar12_trial / 1) - 2*floor(sar12_trial / 2))*1.8
alter VD_B0 = $&sar12_drive
let sar12_drive = (floor(sar12_trial / 2) - 2*floor(sar12_trial / 4))*1.8
alter VD_B1 = $&sar12_drive
let sar12_drive = (floor(sar12_trial / 4) - 2*floor(sar12_trial / 8))*1.8
alter VD_B2 = $&sar12_drive
let sar12_drive = (floor(sar12_trial / 8) - 2*floor(sar12_trial / 16))*1.8
alter VD_B3 = $&sar12_drive
let sar12_drive = (floor(sar12_trial / 16) - 2*floor(sar12_trial / 32))*1.8
alter VD_B4 = $&sar12_drive
let sar12_drive = (floor(sar12_trial / 32) - 2*floor(sar12_trial / 64))*1.8
alter VD_B5 = $&sar12_drive
let sar12_drive = (floor(sar12_trial / 64) - 2*floor(sar12_trial / 128))*1.8
alter VD_B6 = $&sar12_drive
let sar12_drive = (floor(sar12_trial / 128) - 2*floor(sar12_trial / 256))*1.8
alter VD_B7 = $&sar12_drive
let sar12_drive = (floor(sar12_trial / 256) - 2*floor(sar12_trial / 512))*1.8
alter VD_B8 = $&sar12_drive
let sar12_drive = (floor(sar12_trial / 512) - 2*floor(sar12_trial / 1024))*1.8
alter VD_B9 = $&sar12_drive
let sar12_drive = (floor(sar12_trial / 1024) - 2*floor(sar12_trial / 2048))*1.8
alter VD_B10 = $&sar12_drive
let sar12_drive = (floor(sar12_trial / 2048) - 2*floor(sar12_trial / 4096))*1.8
alter VD_B11 = $&sar12_drive
stop when time ge 4.7574999999e-05
resume
let sar12_k = length(time)-1
if abs(time[sar12_k] - 4.7575e-05) > 1e-12
print time[sar12_k]
echo expected_pause_time_s 4.7575e-05
echo SAR12_PAUSE_FAILED
quit 1
end
print time[sar12_k] >> pause-times.txt
delete all
alter VD_EVAL = 1.8
stop when time ge 4.7749999999e-05
resume
let sar12_k = length(time)-1
if abs(time[sar12_k] - 4.775e-05) > 1e-12
print time[sar12_k]
echo expected_pause_time_s 4.775e-05
echo SAR12_PAUSE_FAILED
quit 1
end
print time[sar12_k] >> pause-times.txt
delete all
let sar12_k = length(time)-1
let sar12_cmp = v(COMP)[sar12_k]
let sar12_cmpn = v(COMPN)[sar12_k]
let sar12_p = v(TOPP)[sar12_k]
let sar12_n = v(TOPN)[sar12_k]
let sar12_decision = 0
if sar12_cmp >= 0.9
let sar12_code = sar12_trial
let sar12_decision = 1
end
echo 4 5 $&sar12_trial $&sar12_cmp $&sar12_cmpn $&sar12_p $&sar12_n -1.16279296875 $&sar12_decision >> decisions.csv
alter VD_EVAL = 0
let sar12_trial = sar12_code + 16
let sar12_drive = (floor(sar12_trial / 1) - 2*floor(sar12_trial / 2))*1.8
alter VD_B0 = $&sar12_drive
let sar12_drive = (floor(sar12_trial / 2) - 2*floor(sar12_trial / 4))*1.8
alter VD_B1 = $&sar12_drive
let sar12_drive = (floor(sar12_trial / 4) - 2*floor(sar12_trial / 8))*1.8
alter VD_B2 = $&sar12_drive
let sar12_drive = (floor(sar12_trial / 8) - 2*floor(sar12_trial / 16))*1.8
alter VD_B3 = $&sar12_drive
let sar12_drive = (floor(sar12_trial / 16) - 2*floor(sar12_trial / 32))*1.8
alter VD_B4 = $&sar12_drive
let sar12_drive = (floor(sar12_trial / 32) - 2*floor(sar12_trial / 64))*1.8
alter VD_B5 = $&sar12_drive
let sar12_drive = (floor(sar12_trial / 64) - 2*floor(sar12_trial / 128))*1.8
alter VD_B6 = $&sar12_drive
let sar12_drive = (floor(sar12_trial / 128) - 2*floor(sar12_trial / 256))*1.8
alter VD_B7 = $&sar12_drive
let sar12_drive = (floor(sar12_trial / 256) - 2*floor(sar12_trial / 512))*1.8
alter VD_B8 = $&sar12_drive
let sar12_drive = (floor(sar12_trial / 512) - 2*floor(sar12_trial / 1024))*1.8
alter VD_B9 = $&sar12_drive
let sar12_drive = (floor(sar12_trial / 1024) - 2*floor(sar12_trial / 2048))*1.8
alter VD_B10 = $&sar12_drive
let sar12_drive = (floor(sar12_trial / 2048) - 2*floor(sar12_trial / 4096))*1.8
alter VD_B11 = $&sar12_drive
stop when time ge 4.8074999999e-05
resume
let sar12_k = length(time)-1
if abs(time[sar12_k] - 4.8075e-05) > 1e-12
print time[sar12_k]
echo expected_pause_time_s 4.8075e-05
echo SAR12_PAUSE_FAILED
quit 1
end
print time[sar12_k] >> pause-times.txt
delete all
alter VD_EVAL = 1.8
stop when time ge 4.8249999999e-05
resume
let sar12_k = length(time)-1
if abs(time[sar12_k] - 4.825e-05) > 1e-12
print time[sar12_k]
echo expected_pause_time_s 4.825e-05
echo SAR12_PAUSE_FAILED
quit 1
end
print time[sar12_k] >> pause-times.txt
delete all
let sar12_k = length(time)-1
let sar12_cmp = v(COMP)[sar12_k]
let sar12_cmpn = v(COMPN)[sar12_k]
let sar12_p = v(TOPP)[sar12_k]
let sar12_n = v(TOPN)[sar12_k]
let sar12_decision = 0
if sar12_cmp >= 0.9
let sar12_code = sar12_trial
let sar12_decision = 1
end
echo 4 4 $&sar12_trial $&sar12_cmp $&sar12_cmpn $&sar12_p $&sar12_n -1.16279296875 $&sar12_decision >> decisions.csv
alter VD_EVAL = 0
let sar12_trial = sar12_code + 8
let sar12_drive = (floor(sar12_trial / 1) - 2*floor(sar12_trial / 2))*1.8
alter VD_B0 = $&sar12_drive
let sar12_drive = (floor(sar12_trial / 2) - 2*floor(sar12_trial / 4))*1.8
alter VD_B1 = $&sar12_drive
let sar12_drive = (floor(sar12_trial / 4) - 2*floor(sar12_trial / 8))*1.8
alter VD_B2 = $&sar12_drive
let sar12_drive = (floor(sar12_trial / 8) - 2*floor(sar12_trial / 16))*1.8
alter VD_B3 = $&sar12_drive
let sar12_drive = (floor(sar12_trial / 16) - 2*floor(sar12_trial / 32))*1.8
alter VD_B4 = $&sar12_drive
let sar12_drive = (floor(sar12_trial / 32) - 2*floor(sar12_trial / 64))*1.8
alter VD_B5 = $&sar12_drive
let sar12_drive = (floor(sar12_trial / 64) - 2*floor(sar12_trial / 128))*1.8
alter VD_B6 = $&sar12_drive
let sar12_drive = (floor(sar12_trial / 128) - 2*floor(sar12_trial / 256))*1.8
alter VD_B7 = $&sar12_drive
let sar12_drive = (floor(sar12_trial / 256) - 2*floor(sar12_trial / 512))*1.8
alter VD_B8 = $&sar12_drive
let sar12_drive = (floor(sar12_trial / 512) - 2*floor(sar12_trial / 1024))*1.8
alter VD_B9 = $&sar12_drive
let sar12_drive = (floor(sar12_trial / 1024) - 2*floor(sar12_trial / 2048))*1.8
alter VD_B10 = $&sar12_drive
let sar12_drive = (floor(sar12_trial / 2048) - 2*floor(sar12_trial / 4096))*1.8
alter VD_B11 = $&sar12_drive
stop when time ge 4.8574999999e-05
resume
let sar12_k = length(time)-1
if abs(time[sar12_k] - 4.8575e-05) > 1e-12
print time[sar12_k]
echo expected_pause_time_s 4.8575e-05
echo SAR12_PAUSE_FAILED
quit 1
end
print time[sar12_k] >> pause-times.txt
delete all
alter VD_EVAL = 1.8
stop when time ge 4.8749999999e-05
resume
let sar12_k = length(time)-1
if abs(time[sar12_k] - 4.875e-05) > 1e-12
print time[sar12_k]
echo expected_pause_time_s 4.875e-05
echo SAR12_PAUSE_FAILED
quit 1
end
print time[sar12_k] >> pause-times.txt
delete all
let sar12_k = length(time)-1
let sar12_cmp = v(COMP)[sar12_k]
let sar12_cmpn = v(COMPN)[sar12_k]
let sar12_p = v(TOPP)[sar12_k]
let sar12_n = v(TOPN)[sar12_k]
let sar12_decision = 0
if sar12_cmp >= 0.9
let sar12_code = sar12_trial
let sar12_decision = 1
end
echo 4 3 $&sar12_trial $&sar12_cmp $&sar12_cmpn $&sar12_p $&sar12_n -1.16279296875 $&sar12_decision >> decisions.csv
alter VD_EVAL = 0
let sar12_trial = sar12_code + 4
let sar12_drive = (floor(sar12_trial / 1) - 2*floor(sar12_trial / 2))*1.8
alter VD_B0 = $&sar12_drive
let sar12_drive = (floor(sar12_trial / 2) - 2*floor(sar12_trial / 4))*1.8
alter VD_B1 = $&sar12_drive
let sar12_drive = (floor(sar12_trial / 4) - 2*floor(sar12_trial / 8))*1.8
alter VD_B2 = $&sar12_drive
let sar12_drive = (floor(sar12_trial / 8) - 2*floor(sar12_trial / 16))*1.8
alter VD_B3 = $&sar12_drive
let sar12_drive = (floor(sar12_trial / 16) - 2*floor(sar12_trial / 32))*1.8
alter VD_B4 = $&sar12_drive
let sar12_drive = (floor(sar12_trial / 32) - 2*floor(sar12_trial / 64))*1.8
alter VD_B5 = $&sar12_drive
let sar12_drive = (floor(sar12_trial / 64) - 2*floor(sar12_trial / 128))*1.8
alter VD_B6 = $&sar12_drive
let sar12_drive = (floor(sar12_trial / 128) - 2*floor(sar12_trial / 256))*1.8
alter VD_B7 = $&sar12_drive
let sar12_drive = (floor(sar12_trial / 256) - 2*floor(sar12_trial / 512))*1.8
alter VD_B8 = $&sar12_drive
let sar12_drive = (floor(sar12_trial / 512) - 2*floor(sar12_trial / 1024))*1.8
alter VD_B9 = $&sar12_drive
let sar12_drive = (floor(sar12_trial / 1024) - 2*floor(sar12_trial / 2048))*1.8
alter VD_B10 = $&sar12_drive
let sar12_drive = (floor(sar12_trial / 2048) - 2*floor(sar12_trial / 4096))*1.8
alter VD_B11 = $&sar12_drive
stop when time ge 4.9074999999e-05
resume
let sar12_k = length(time)-1
if abs(time[sar12_k] - 4.9075e-05) > 1e-12
print time[sar12_k]
echo expected_pause_time_s 4.9075e-05
echo SAR12_PAUSE_FAILED
quit 1
end
print time[sar12_k] >> pause-times.txt
delete all
alter VD_EVAL = 1.8
stop when time ge 4.9249999999e-05
resume
let sar12_k = length(time)-1
if abs(time[sar12_k] - 4.925e-05) > 1e-12
print time[sar12_k]
echo expected_pause_time_s 4.925e-05
echo SAR12_PAUSE_FAILED
quit 1
end
print time[sar12_k] >> pause-times.txt
delete all
let sar12_k = length(time)-1
let sar12_cmp = v(COMP)[sar12_k]
let sar12_cmpn = v(COMPN)[sar12_k]
let sar12_p = v(TOPP)[sar12_k]
let sar12_n = v(TOPN)[sar12_k]
let sar12_decision = 0
if sar12_cmp >= 0.9
let sar12_code = sar12_trial
let sar12_decision = 1
end
echo 4 2 $&sar12_trial $&sar12_cmp $&sar12_cmpn $&sar12_p $&sar12_n -1.16279296875 $&sar12_decision >> decisions.csv
alter VD_EVAL = 0
let sar12_trial = sar12_code + 2
let sar12_drive = (floor(sar12_trial / 1) - 2*floor(sar12_trial / 2))*1.8
alter VD_B0 = $&sar12_drive
let sar12_drive = (floor(sar12_trial / 2) - 2*floor(sar12_trial / 4))*1.8
alter VD_B1 = $&sar12_drive
let sar12_drive = (floor(sar12_trial / 4) - 2*floor(sar12_trial / 8))*1.8
alter VD_B2 = $&sar12_drive
let sar12_drive = (floor(sar12_trial / 8) - 2*floor(sar12_trial / 16))*1.8
alter VD_B3 = $&sar12_drive
let sar12_drive = (floor(sar12_trial / 16) - 2*floor(sar12_trial / 32))*1.8
alter VD_B4 = $&sar12_drive
let sar12_drive = (floor(sar12_trial / 32) - 2*floor(sar12_trial / 64))*1.8
alter VD_B5 = $&sar12_drive
let sar12_drive = (floor(sar12_trial / 64) - 2*floor(sar12_trial / 128))*1.8
alter VD_B6 = $&sar12_drive
let sar12_drive = (floor(sar12_trial / 128) - 2*floor(sar12_trial / 256))*1.8
alter VD_B7 = $&sar12_drive
let sar12_drive = (floor(sar12_trial / 256) - 2*floor(sar12_trial / 512))*1.8
alter VD_B8 = $&sar12_drive
let sar12_drive = (floor(sar12_trial / 512) - 2*floor(sar12_trial / 1024))*1.8
alter VD_B9 = $&sar12_drive
let sar12_drive = (floor(sar12_trial / 1024) - 2*floor(sar12_trial / 2048))*1.8
alter VD_B10 = $&sar12_drive
let sar12_drive = (floor(sar12_trial / 2048) - 2*floor(sar12_trial / 4096))*1.8
alter VD_B11 = $&sar12_drive
stop when time ge 4.9574999999e-05
resume
let sar12_k = length(time)-1
if abs(time[sar12_k] - 4.9575e-05) > 1e-12
print time[sar12_k]
echo expected_pause_time_s 4.9575e-05
echo SAR12_PAUSE_FAILED
quit 1
end
print time[sar12_k] >> pause-times.txt
delete all
alter VD_EVAL = 1.8
stop when time ge 4.9749999999e-05
resume
let sar12_k = length(time)-1
if abs(time[sar12_k] - 4.975e-05) > 1e-12
print time[sar12_k]
echo expected_pause_time_s 4.975e-05
echo SAR12_PAUSE_FAILED
quit 1
end
print time[sar12_k] >> pause-times.txt
delete all
let sar12_k = length(time)-1
let sar12_cmp = v(COMP)[sar12_k]
let sar12_cmpn = v(COMPN)[sar12_k]
let sar12_p = v(TOPP)[sar12_k]
let sar12_n = v(TOPN)[sar12_k]
let sar12_decision = 0
if sar12_cmp >= 0.9
let sar12_code = sar12_trial
let sar12_decision = 1
end
echo 4 1 $&sar12_trial $&sar12_cmp $&sar12_cmpn $&sar12_p $&sar12_n -1.16279296875 $&sar12_decision >> decisions.csv
alter VD_EVAL = 0
let sar12_trial = sar12_code + 1
let sar12_drive = (floor(sar12_trial / 1) - 2*floor(sar12_trial / 2))*1.8
alter VD_B0 = $&sar12_drive
let sar12_drive = (floor(sar12_trial / 2) - 2*floor(sar12_trial / 4))*1.8
alter VD_B1 = $&sar12_drive
let sar12_drive = (floor(sar12_trial / 4) - 2*floor(sar12_trial / 8))*1.8
alter VD_B2 = $&sar12_drive
let sar12_drive = (floor(sar12_trial / 8) - 2*floor(sar12_trial / 16))*1.8
alter VD_B3 = $&sar12_drive
let sar12_drive = (floor(sar12_trial / 16) - 2*floor(sar12_trial / 32))*1.8
alter VD_B4 = $&sar12_drive
let sar12_drive = (floor(sar12_trial / 32) - 2*floor(sar12_trial / 64))*1.8
alter VD_B5 = $&sar12_drive
let sar12_drive = (floor(sar12_trial / 64) - 2*floor(sar12_trial / 128))*1.8
alter VD_B6 = $&sar12_drive
let sar12_drive = (floor(sar12_trial / 128) - 2*floor(sar12_trial / 256))*1.8
alter VD_B7 = $&sar12_drive
let sar12_drive = (floor(sar12_trial / 256) - 2*floor(sar12_trial / 512))*1.8
alter VD_B8 = $&sar12_drive
let sar12_drive = (floor(sar12_trial / 512) - 2*floor(sar12_trial / 1024))*1.8
alter VD_B9 = $&sar12_drive
let sar12_drive = (floor(sar12_trial / 1024) - 2*floor(sar12_trial / 2048))*1.8
alter VD_B10 = $&sar12_drive
let sar12_drive = (floor(sar12_trial / 2048) - 2*floor(sar12_trial / 4096))*1.8
alter VD_B11 = $&sar12_drive
stop when time ge 5.0074999999e-05
resume
let sar12_k = length(time)-1
if abs(time[sar12_k] - 5.0075e-05) > 1e-12
print time[sar12_k]
echo expected_pause_time_s 5.0075e-05
echo SAR12_PAUSE_FAILED
quit 1
end
print time[sar12_k] >> pause-times.txt
delete all
alter VD_EVAL = 1.8
stop when time ge 5.0249999999e-05
resume
let sar12_k = length(time)-1
if abs(time[sar12_k] - 5.025e-05) > 1e-12
print time[sar12_k]
echo expected_pause_time_s 5.025e-05
echo SAR12_PAUSE_FAILED
quit 1
end
print time[sar12_k] >> pause-times.txt
delete all
let sar12_k = length(time)-1
let sar12_cmp = v(COMP)[sar12_k]
let sar12_cmpn = v(COMPN)[sar12_k]
let sar12_p = v(TOPP)[sar12_k]
let sar12_n = v(TOPN)[sar12_k]
let sar12_decision = 0
if sar12_cmp >= 0.9
let sar12_code = sar12_trial
let sar12_decision = 1
end
echo 4 0 $&sar12_trial $&sar12_cmp $&sar12_cmpn $&sar12_p $&sar12_n -1.16279296875 $&sar12_decision >> decisions.csv
alter VD_EVAL = 0
alter VINP = 0.318896484375
alter VINN = 1.48110351563
alter VD_SAMPLE = 1.8
alter VD_EVAL = 0
alter VD_B0 = 0
alter VD_B1 = 0
alter VD_B2 = 0
alter VD_B3 = 0
alter VD_B4 = 0
alter VD_B5 = 0
alter VD_B6 = 0
alter VD_B7 = 0
alter VD_B8 = 0
alter VD_B9 = 0
alter VD_B10 = 0
alter VD_B11 = 0
let sar12_code = 0
stop when time ge 5.4249999999e-05
resume
let sar12_k = length(time)-1
if abs(time[sar12_k] - 5.425e-05) > 1e-12
print time[sar12_k]
echo expected_pause_time_s 5.425e-05
echo SAR12_PAUSE_FAILED
quit 1
end
print time[sar12_k] >> pause-times.txt
delete all
alter VD_SAMPLE = 0
stop when time ge 5.4299999999e-05
resume
let sar12_k = length(time)-1
if abs(time[sar12_k] - 5.43e-05) > 1e-12
print time[sar12_k]
echo expected_pause_time_s 5.43e-05
echo SAR12_PAUSE_FAILED
quit 1
end
print time[sar12_k] >> pause-times.txt
delete all
alter VD_EVAL = 0
let sar12_trial = sar12_code + 2048
let sar12_drive = (floor(sar12_trial / 1) - 2*floor(sar12_trial / 2))*1.8
alter VD_B0 = $&sar12_drive
let sar12_drive = (floor(sar12_trial / 2) - 2*floor(sar12_trial / 4))*1.8
alter VD_B1 = $&sar12_drive
let sar12_drive = (floor(sar12_trial / 4) - 2*floor(sar12_trial / 8))*1.8
alter VD_B2 = $&sar12_drive
let sar12_drive = (floor(sar12_trial / 8) - 2*floor(sar12_trial / 16))*1.8
alter VD_B3 = $&sar12_drive
let sar12_drive = (floor(sar12_trial / 16) - 2*floor(sar12_trial / 32))*1.8
alter VD_B4 = $&sar12_drive
let sar12_drive = (floor(sar12_trial / 32) - 2*floor(sar12_trial / 64))*1.8
alter VD_B5 = $&sar12_drive
let sar12_drive = (floor(sar12_trial / 64) - 2*floor(sar12_trial / 128))*1.8
alter VD_B6 = $&sar12_drive
let sar12_drive = (floor(sar12_trial / 128) - 2*floor(sar12_trial / 256))*1.8
alter VD_B7 = $&sar12_drive
let sar12_drive = (floor(sar12_trial / 256) - 2*floor(sar12_trial / 512))*1.8
alter VD_B8 = $&sar12_drive
let sar12_drive = (floor(sar12_trial / 512) - 2*floor(sar12_trial / 1024))*1.8
alter VD_B9 = $&sar12_drive
let sar12_drive = (floor(sar12_trial / 1024) - 2*floor(sar12_trial / 2048))*1.8
alter VD_B10 = $&sar12_drive
let sar12_drive = (floor(sar12_trial / 2048) - 2*floor(sar12_trial / 4096))*1.8
alter VD_B11 = $&sar12_drive
stop when time ge 5.4624999999e-05
resume
let sar12_k = length(time)-1
if abs(time[sar12_k] - 5.4625e-05) > 1e-12
print time[sar12_k]
echo expected_pause_time_s 5.4625e-05
echo SAR12_PAUSE_FAILED
quit 1
end
print time[sar12_k] >> pause-times.txt
delete all
alter VD_EVAL = 1.8
stop when time ge 5.4799999999e-05
resume
let sar12_k = length(time)-1
if abs(time[sar12_k] - 5.48e-05) > 1e-12
print time[sar12_k]
echo expected_pause_time_s 5.48e-05
echo SAR12_PAUSE_FAILED
quit 1
end
print time[sar12_k] >> pause-times.txt
delete all
let sar12_k = length(time)-1
let sar12_cmp = v(COMP)[sar12_k]
let sar12_cmpn = v(COMPN)[sar12_k]
let sar12_p = v(TOPP)[sar12_k]
let sar12_n = v(TOPN)[sar12_k]
let sar12_decision = 0
if sar12_cmp >= 0.9
let sar12_code = sar12_trial
let sar12_decision = 1
end
echo 5 11 $&sar12_trial $&sar12_cmp $&sar12_cmpn $&sar12_p $&sar12_n -1.16220703125 $&sar12_decision >> decisions.csv
alter VD_EVAL = 0
let sar12_trial = sar12_code + 1024
let sar12_drive = (floor(sar12_trial / 1) - 2*floor(sar12_trial / 2))*1.8
alter VD_B0 = $&sar12_drive
let sar12_drive = (floor(sar12_trial / 2) - 2*floor(sar12_trial / 4))*1.8
alter VD_B1 = $&sar12_drive
let sar12_drive = (floor(sar12_trial / 4) - 2*floor(sar12_trial / 8))*1.8
alter VD_B2 = $&sar12_drive
let sar12_drive = (floor(sar12_trial / 8) - 2*floor(sar12_trial / 16))*1.8
alter VD_B3 = $&sar12_drive
let sar12_drive = (floor(sar12_trial / 16) - 2*floor(sar12_trial / 32))*1.8
alter VD_B4 = $&sar12_drive
let sar12_drive = (floor(sar12_trial / 32) - 2*floor(sar12_trial / 64))*1.8
alter VD_B5 = $&sar12_drive
let sar12_drive = (floor(sar12_trial / 64) - 2*floor(sar12_trial / 128))*1.8
alter VD_B6 = $&sar12_drive
let sar12_drive = (floor(sar12_trial / 128) - 2*floor(sar12_trial / 256))*1.8
alter VD_B7 = $&sar12_drive
let sar12_drive = (floor(sar12_trial / 256) - 2*floor(sar12_trial / 512))*1.8
alter VD_B8 = $&sar12_drive
let sar12_drive = (floor(sar12_trial / 512) - 2*floor(sar12_trial / 1024))*1.8
alter VD_B9 = $&sar12_drive
let sar12_drive = (floor(sar12_trial / 1024) - 2*floor(sar12_trial / 2048))*1.8
alter VD_B10 = $&sar12_drive
let sar12_drive = (floor(sar12_trial / 2048) - 2*floor(sar12_trial / 4096))*1.8
alter VD_B11 = $&sar12_drive
stop when time ge 5.5124999999e-05
resume
let sar12_k = length(time)-1
if abs(time[sar12_k] - 5.5125e-05) > 1e-12
print time[sar12_k]
echo expected_pause_time_s 5.5125e-05
echo SAR12_PAUSE_FAILED
quit 1
end
print time[sar12_k] >> pause-times.txt
delete all
alter VD_EVAL = 1.8
stop when time ge 5.5299999999e-05
resume
let sar12_k = length(time)-1
if abs(time[sar12_k] - 5.53e-05) > 1e-12
print time[sar12_k]
echo expected_pause_time_s 5.53e-05
echo SAR12_PAUSE_FAILED
quit 1
end
print time[sar12_k] >> pause-times.txt
delete all
let sar12_k = length(time)-1
let sar12_cmp = v(COMP)[sar12_k]
let sar12_cmpn = v(COMPN)[sar12_k]
let sar12_p = v(TOPP)[sar12_k]
let sar12_n = v(TOPN)[sar12_k]
let sar12_decision = 0
if sar12_cmp >= 0.9
let sar12_code = sar12_trial
let sar12_decision = 1
end
echo 5 10 $&sar12_trial $&sar12_cmp $&sar12_cmpn $&sar12_p $&sar12_n -1.16220703125 $&sar12_decision >> decisions.csv
alter VD_EVAL = 0
let sar12_trial = sar12_code + 512
let sar12_drive = (floor(sar12_trial / 1) - 2*floor(sar12_trial / 2))*1.8
alter VD_B0 = $&sar12_drive
let sar12_drive = (floor(sar12_trial / 2) - 2*floor(sar12_trial / 4))*1.8
alter VD_B1 = $&sar12_drive
let sar12_drive = (floor(sar12_trial / 4) - 2*floor(sar12_trial / 8))*1.8
alter VD_B2 = $&sar12_drive
let sar12_drive = (floor(sar12_trial / 8) - 2*floor(sar12_trial / 16))*1.8
alter VD_B3 = $&sar12_drive
let sar12_drive = (floor(sar12_trial / 16) - 2*floor(sar12_trial / 32))*1.8
alter VD_B4 = $&sar12_drive
let sar12_drive = (floor(sar12_trial / 32) - 2*floor(sar12_trial / 64))*1.8
alter VD_B5 = $&sar12_drive
let sar12_drive = (floor(sar12_trial / 64) - 2*floor(sar12_trial / 128))*1.8
alter VD_B6 = $&sar12_drive
let sar12_drive = (floor(sar12_trial / 128) - 2*floor(sar12_trial / 256))*1.8
alter VD_B7 = $&sar12_drive
let sar12_drive = (floor(sar12_trial / 256) - 2*floor(sar12_trial / 512))*1.8
alter VD_B8 = $&sar12_drive
let sar12_drive = (floor(sar12_trial / 512) - 2*floor(sar12_trial / 1024))*1.8
alter VD_B9 = $&sar12_drive
let sar12_drive = (floor(sar12_trial / 1024) - 2*floor(sar12_trial / 2048))*1.8
alter VD_B10 = $&sar12_drive
let sar12_drive = (floor(sar12_trial / 2048) - 2*floor(sar12_trial / 4096))*1.8
alter VD_B11 = $&sar12_drive
stop when time ge 5.5624999999e-05
resume
let sar12_k = length(time)-1
if abs(time[sar12_k] - 5.5625e-05) > 1e-12
print time[sar12_k]
echo expected_pause_time_s 5.5625e-05
echo SAR12_PAUSE_FAILED
quit 1
end
print time[sar12_k] >> pause-times.txt
delete all
alter VD_EVAL = 1.8
stop when time ge 5.5799999999e-05
resume
let sar12_k = length(time)-1
if abs(time[sar12_k] - 5.58e-05) > 1e-12
print time[sar12_k]
echo expected_pause_time_s 5.58e-05
echo SAR12_PAUSE_FAILED
quit 1
end
print time[sar12_k] >> pause-times.txt
delete all
let sar12_k = length(time)-1
let sar12_cmp = v(COMP)[sar12_k]
let sar12_cmpn = v(COMPN)[sar12_k]
let sar12_p = v(TOPP)[sar12_k]
let sar12_n = v(TOPN)[sar12_k]
let sar12_decision = 0
if sar12_cmp >= 0.9
let sar12_code = sar12_trial
let sar12_decision = 1
end
echo 5 9 $&sar12_trial $&sar12_cmp $&sar12_cmpn $&sar12_p $&sar12_n -1.16220703125 $&sar12_decision >> decisions.csv
alter VD_EVAL = 0
let sar12_trial = sar12_code + 256
let sar12_drive = (floor(sar12_trial / 1) - 2*floor(sar12_trial / 2))*1.8
alter VD_B0 = $&sar12_drive
let sar12_drive = (floor(sar12_trial / 2) - 2*floor(sar12_trial / 4))*1.8
alter VD_B1 = $&sar12_drive
let sar12_drive = (floor(sar12_trial / 4) - 2*floor(sar12_trial / 8))*1.8
alter VD_B2 = $&sar12_drive
let sar12_drive = (floor(sar12_trial / 8) - 2*floor(sar12_trial / 16))*1.8
alter VD_B3 = $&sar12_drive
let sar12_drive = (floor(sar12_trial / 16) - 2*floor(sar12_trial / 32))*1.8
alter VD_B4 = $&sar12_drive
let sar12_drive = (floor(sar12_trial / 32) - 2*floor(sar12_trial / 64))*1.8
alter VD_B5 = $&sar12_drive
let sar12_drive = (floor(sar12_trial / 64) - 2*floor(sar12_trial / 128))*1.8
alter VD_B6 = $&sar12_drive
let sar12_drive = (floor(sar12_trial / 128) - 2*floor(sar12_trial / 256))*1.8
alter VD_B7 = $&sar12_drive
let sar12_drive = (floor(sar12_trial / 256) - 2*floor(sar12_trial / 512))*1.8
alter VD_B8 = $&sar12_drive
let sar12_drive = (floor(sar12_trial / 512) - 2*floor(sar12_trial / 1024))*1.8
alter VD_B9 = $&sar12_drive
let sar12_drive = (floor(sar12_trial / 1024) - 2*floor(sar12_trial / 2048))*1.8
alter VD_B10 = $&sar12_drive
let sar12_drive = (floor(sar12_trial / 2048) - 2*floor(sar12_trial / 4096))*1.8
alter VD_B11 = $&sar12_drive
stop when time ge 5.6124999999e-05
resume
let sar12_k = length(time)-1
if abs(time[sar12_k] - 5.6125e-05) > 1e-12
print time[sar12_k]
echo expected_pause_time_s 5.6125e-05
echo SAR12_PAUSE_FAILED
quit 1
end
print time[sar12_k] >> pause-times.txt
delete all
alter VD_EVAL = 1.8
stop when time ge 5.6299999999e-05
resume
let sar12_k = length(time)-1
if abs(time[sar12_k] - 5.63e-05) > 1e-12
print time[sar12_k]
echo expected_pause_time_s 5.63e-05
echo SAR12_PAUSE_FAILED
quit 1
end
print time[sar12_k] >> pause-times.txt
delete all
let sar12_k = length(time)-1
let sar12_cmp = v(COMP)[sar12_k]
let sar12_cmpn = v(COMPN)[sar12_k]
let sar12_p = v(TOPP)[sar12_k]
let sar12_n = v(TOPN)[sar12_k]
let sar12_decision = 0
if sar12_cmp >= 0.9
let sar12_code = sar12_trial
let sar12_decision = 1
end
echo 5 8 $&sar12_trial $&sar12_cmp $&sar12_cmpn $&sar12_p $&sar12_n -1.16220703125 $&sar12_decision >> decisions.csv
alter VD_EVAL = 0
let sar12_trial = sar12_code + 128
let sar12_drive = (floor(sar12_trial / 1) - 2*floor(sar12_trial / 2))*1.8
alter VD_B0 = $&sar12_drive
let sar12_drive = (floor(sar12_trial / 2) - 2*floor(sar12_trial / 4))*1.8
alter VD_B1 = $&sar12_drive
let sar12_drive = (floor(sar12_trial / 4) - 2*floor(sar12_trial / 8))*1.8
alter VD_B2 = $&sar12_drive
let sar12_drive = (floor(sar12_trial / 8) - 2*floor(sar12_trial / 16))*1.8
alter VD_B3 = $&sar12_drive
let sar12_drive = (floor(sar12_trial / 16) - 2*floor(sar12_trial / 32))*1.8
alter VD_B4 = $&sar12_drive
let sar12_drive = (floor(sar12_trial / 32) - 2*floor(sar12_trial / 64))*1.8
alter VD_B5 = $&sar12_drive
let sar12_drive = (floor(sar12_trial / 64) - 2*floor(sar12_trial / 128))*1.8
alter VD_B6 = $&sar12_drive
let sar12_drive = (floor(sar12_trial / 128) - 2*floor(sar12_trial / 256))*1.8
alter VD_B7 = $&sar12_drive
let sar12_drive = (floor(sar12_trial / 256) - 2*floor(sar12_trial / 512))*1.8
alter VD_B8 = $&sar12_drive
let sar12_drive = (floor(sar12_trial / 512) - 2*floor(sar12_trial / 1024))*1.8
alter VD_B9 = $&sar12_drive
let sar12_drive = (floor(sar12_trial / 1024) - 2*floor(sar12_trial / 2048))*1.8
alter VD_B10 = $&sar12_drive
let sar12_drive = (floor(sar12_trial / 2048) - 2*floor(sar12_trial / 4096))*1.8
alter VD_B11 = $&sar12_drive
stop when time ge 5.6624999999e-05
resume
let sar12_k = length(time)-1
if abs(time[sar12_k] - 5.6625e-05) > 1e-12
print time[sar12_k]
echo expected_pause_time_s 5.6625e-05
echo SAR12_PAUSE_FAILED
quit 1
end
print time[sar12_k] >> pause-times.txt
delete all
alter VD_EVAL = 1.8
stop when time ge 5.6799999999e-05
resume
let sar12_k = length(time)-1
if abs(time[sar12_k] - 5.68e-05) > 1e-12
print time[sar12_k]
echo expected_pause_time_s 5.68e-05
echo SAR12_PAUSE_FAILED
quit 1
end
print time[sar12_k] >> pause-times.txt
delete all
let sar12_k = length(time)-1
let sar12_cmp = v(COMP)[sar12_k]
let sar12_cmpn = v(COMPN)[sar12_k]
let sar12_p = v(TOPP)[sar12_k]
let sar12_n = v(TOPN)[sar12_k]
let sar12_decision = 0
if sar12_cmp >= 0.9
let sar12_code = sar12_trial
let sar12_decision = 1
end
echo 5 7 $&sar12_trial $&sar12_cmp $&sar12_cmpn $&sar12_p $&sar12_n -1.16220703125 $&sar12_decision >> decisions.csv
alter VD_EVAL = 0
let sar12_trial = sar12_code + 64
let sar12_drive = (floor(sar12_trial / 1) - 2*floor(sar12_trial / 2))*1.8
alter VD_B0 = $&sar12_drive
let sar12_drive = (floor(sar12_trial / 2) - 2*floor(sar12_trial / 4))*1.8
alter VD_B1 = $&sar12_drive
let sar12_drive = (floor(sar12_trial / 4) - 2*floor(sar12_trial / 8))*1.8
alter VD_B2 = $&sar12_drive
let sar12_drive = (floor(sar12_trial / 8) - 2*floor(sar12_trial / 16))*1.8
alter VD_B3 = $&sar12_drive
let sar12_drive = (floor(sar12_trial / 16) - 2*floor(sar12_trial / 32))*1.8
alter VD_B4 = $&sar12_drive
let sar12_drive = (floor(sar12_trial / 32) - 2*floor(sar12_trial / 64))*1.8
alter VD_B5 = $&sar12_drive
let sar12_drive = (floor(sar12_trial / 64) - 2*floor(sar12_trial / 128))*1.8
alter VD_B6 = $&sar12_drive
let sar12_drive = (floor(sar12_trial / 128) - 2*floor(sar12_trial / 256))*1.8
alter VD_B7 = $&sar12_drive
let sar12_drive = (floor(sar12_trial / 256) - 2*floor(sar12_trial / 512))*1.8
alter VD_B8 = $&sar12_drive
let sar12_drive = (floor(sar12_trial / 512) - 2*floor(sar12_trial / 1024))*1.8
alter VD_B9 = $&sar12_drive
let sar12_drive = (floor(sar12_trial / 1024) - 2*floor(sar12_trial / 2048))*1.8
alter VD_B10 = $&sar12_drive
let sar12_drive = (floor(sar12_trial / 2048) - 2*floor(sar12_trial / 4096))*1.8
alter VD_B11 = $&sar12_drive
stop when time ge 5.7124999999e-05
resume
let sar12_k = length(time)-1
if abs(time[sar12_k] - 5.7125e-05) > 1e-12
print time[sar12_k]
echo expected_pause_time_s 5.7125e-05
echo SAR12_PAUSE_FAILED
quit 1
end
print time[sar12_k] >> pause-times.txt
delete all
alter VD_EVAL = 1.8
stop when time ge 5.7299999999e-05
resume
let sar12_k = length(time)-1
if abs(time[sar12_k] - 5.73e-05) > 1e-12
print time[sar12_k]
echo expected_pause_time_s 5.73e-05
echo SAR12_PAUSE_FAILED
quit 1
end
print time[sar12_k] >> pause-times.txt
delete all
let sar12_k = length(time)-1
let sar12_cmp = v(COMP)[sar12_k]
let sar12_cmpn = v(COMPN)[sar12_k]
let sar12_p = v(TOPP)[sar12_k]
let sar12_n = v(TOPN)[sar12_k]
let sar12_decision = 0
if sar12_cmp >= 0.9
let sar12_code = sar12_trial
let sar12_decision = 1
end
echo 5 6 $&sar12_trial $&sar12_cmp $&sar12_cmpn $&sar12_p $&sar12_n -1.16220703125 $&sar12_decision >> decisions.csv
alter VD_EVAL = 0
let sar12_trial = sar12_code + 32
let sar12_drive = (floor(sar12_trial / 1) - 2*floor(sar12_trial / 2))*1.8
alter VD_B0 = $&sar12_drive
let sar12_drive = (floor(sar12_trial / 2) - 2*floor(sar12_trial / 4))*1.8
alter VD_B1 = $&sar12_drive
let sar12_drive = (floor(sar12_trial / 4) - 2*floor(sar12_trial / 8))*1.8
alter VD_B2 = $&sar12_drive
let sar12_drive = (floor(sar12_trial / 8) - 2*floor(sar12_trial / 16))*1.8
alter VD_B3 = $&sar12_drive
let sar12_drive = (floor(sar12_trial / 16) - 2*floor(sar12_trial / 32))*1.8
alter VD_B4 = $&sar12_drive
let sar12_drive = (floor(sar12_trial / 32) - 2*floor(sar12_trial / 64))*1.8
alter VD_B5 = $&sar12_drive
let sar12_drive = (floor(sar12_trial / 64) - 2*floor(sar12_trial / 128))*1.8
alter VD_B6 = $&sar12_drive
let sar12_drive = (floor(sar12_trial / 128) - 2*floor(sar12_trial / 256))*1.8
alter VD_B7 = $&sar12_drive
let sar12_drive = (floor(sar12_trial / 256) - 2*floor(sar12_trial / 512))*1.8
alter VD_B8 = $&sar12_drive
let sar12_drive = (floor(sar12_trial / 512) - 2*floor(sar12_trial / 1024))*1.8
alter VD_B9 = $&sar12_drive
let sar12_drive = (floor(sar12_trial / 1024) - 2*floor(sar12_trial / 2048))*1.8
alter VD_B10 = $&sar12_drive
let sar12_drive = (floor(sar12_trial / 2048) - 2*floor(sar12_trial / 4096))*1.8
alter VD_B11 = $&sar12_drive
stop when time ge 5.7624999999e-05
resume
let sar12_k = length(time)-1
if abs(time[sar12_k] - 5.7625e-05) > 1e-12
print time[sar12_k]
echo expected_pause_time_s 5.7625e-05
echo SAR12_PAUSE_FAILED
quit 1
end
print time[sar12_k] >> pause-times.txt
delete all
alter VD_EVAL = 1.8
stop when time ge 5.7799999999e-05
resume
let sar12_k = length(time)-1
if abs(time[sar12_k] - 5.78e-05) > 1e-12
print time[sar12_k]
echo expected_pause_time_s 5.78e-05
echo SAR12_PAUSE_FAILED
quit 1
end
print time[sar12_k] >> pause-times.txt
delete all
let sar12_k = length(time)-1
let sar12_cmp = v(COMP)[sar12_k]
let sar12_cmpn = v(COMPN)[sar12_k]
let sar12_p = v(TOPP)[sar12_k]
let sar12_n = v(TOPN)[sar12_k]
let sar12_decision = 0
if sar12_cmp >= 0.9
let sar12_code = sar12_trial
let sar12_decision = 1
end
echo 5 5 $&sar12_trial $&sar12_cmp $&sar12_cmpn $&sar12_p $&sar12_n -1.16220703125 $&sar12_decision >> decisions.csv
alter VD_EVAL = 0
let sar12_trial = sar12_code + 16
let sar12_drive = (floor(sar12_trial / 1) - 2*floor(sar12_trial / 2))*1.8
alter VD_B0 = $&sar12_drive
let sar12_drive = (floor(sar12_trial / 2) - 2*floor(sar12_trial / 4))*1.8
alter VD_B1 = $&sar12_drive
let sar12_drive = (floor(sar12_trial / 4) - 2*floor(sar12_trial / 8))*1.8
alter VD_B2 = $&sar12_drive
let sar12_drive = (floor(sar12_trial / 8) - 2*floor(sar12_trial / 16))*1.8
alter VD_B3 = $&sar12_drive
let sar12_drive = (floor(sar12_trial / 16) - 2*floor(sar12_trial / 32))*1.8
alter VD_B4 = $&sar12_drive
let sar12_drive = (floor(sar12_trial / 32) - 2*floor(sar12_trial / 64))*1.8
alter VD_B5 = $&sar12_drive
let sar12_drive = (floor(sar12_trial / 64) - 2*floor(sar12_trial / 128))*1.8
alter VD_B6 = $&sar12_drive
let sar12_drive = (floor(sar12_trial / 128) - 2*floor(sar12_trial / 256))*1.8
alter VD_B7 = $&sar12_drive
let sar12_drive = (floor(sar12_trial / 256) - 2*floor(sar12_trial / 512))*1.8
alter VD_B8 = $&sar12_drive
let sar12_drive = (floor(sar12_trial / 512) - 2*floor(sar12_trial / 1024))*1.8
alter VD_B9 = $&sar12_drive
let sar12_drive = (floor(sar12_trial / 1024) - 2*floor(sar12_trial / 2048))*1.8
alter VD_B10 = $&sar12_drive
let sar12_drive = (floor(sar12_trial / 2048) - 2*floor(sar12_trial / 4096))*1.8
alter VD_B11 = $&sar12_drive
stop when time ge 5.8124999999e-05
resume
let sar12_k = length(time)-1
if abs(time[sar12_k] - 5.8125e-05) > 1e-12
print time[sar12_k]
echo expected_pause_time_s 5.8125e-05
echo SAR12_PAUSE_FAILED
quit 1
end
print time[sar12_k] >> pause-times.txt
delete all
alter VD_EVAL = 1.8
stop when time ge 5.8299999999e-05
resume
let sar12_k = length(time)-1
if abs(time[sar12_k] - 5.83e-05) > 1e-12
print time[sar12_k]
echo expected_pause_time_s 5.83e-05
echo SAR12_PAUSE_FAILED
quit 1
end
print time[sar12_k] >> pause-times.txt
delete all
let sar12_k = length(time)-1
let sar12_cmp = v(COMP)[sar12_k]
let sar12_cmpn = v(COMPN)[sar12_k]
let sar12_p = v(TOPP)[sar12_k]
let sar12_n = v(TOPN)[sar12_k]
let sar12_decision = 0
if sar12_cmp >= 0.9
let sar12_code = sar12_trial
let sar12_decision = 1
end
echo 5 4 $&sar12_trial $&sar12_cmp $&sar12_cmpn $&sar12_p $&sar12_n -1.16220703125 $&sar12_decision >> decisions.csv
alter VD_EVAL = 0
let sar12_trial = sar12_code + 8
let sar12_drive = (floor(sar12_trial / 1) - 2*floor(sar12_trial / 2))*1.8
alter VD_B0 = $&sar12_drive
let sar12_drive = (floor(sar12_trial / 2) - 2*floor(sar12_trial / 4))*1.8
alter VD_B1 = $&sar12_drive
let sar12_drive = (floor(sar12_trial / 4) - 2*floor(sar12_trial / 8))*1.8
alter VD_B2 = $&sar12_drive
let sar12_drive = (floor(sar12_trial / 8) - 2*floor(sar12_trial / 16))*1.8
alter VD_B3 = $&sar12_drive
let sar12_drive = (floor(sar12_trial / 16) - 2*floor(sar12_trial / 32))*1.8
alter VD_B4 = $&sar12_drive
let sar12_drive = (floor(sar12_trial / 32) - 2*floor(sar12_trial / 64))*1.8
alter VD_B5 = $&sar12_drive
let sar12_drive = (floor(sar12_trial / 64) - 2*floor(sar12_trial / 128))*1.8
alter VD_B6 = $&sar12_drive
let sar12_drive = (floor(sar12_trial / 128) - 2*floor(sar12_trial / 256))*1.8
alter VD_B7 = $&sar12_drive
let sar12_drive = (floor(sar12_trial / 256) - 2*floor(sar12_trial / 512))*1.8
alter VD_B8 = $&sar12_drive
let sar12_drive = (floor(sar12_trial / 512) - 2*floor(sar12_trial / 1024))*1.8
alter VD_B9 = $&sar12_drive
let sar12_drive = (floor(sar12_trial / 1024) - 2*floor(sar12_trial / 2048))*1.8
alter VD_B10 = $&sar12_drive
let sar12_drive = (floor(sar12_trial / 2048) - 2*floor(sar12_trial / 4096))*1.8
alter VD_B11 = $&sar12_drive
stop when time ge 5.8624999999e-05
resume
let sar12_k = length(time)-1
if abs(time[sar12_k] - 5.8625e-05) > 1e-12
print time[sar12_k]
echo expected_pause_time_s 5.8625e-05
echo SAR12_PAUSE_FAILED
quit 1
end
print time[sar12_k] >> pause-times.txt
delete all
alter VD_EVAL = 1.8
stop when time ge 5.8799999999e-05
resume
let sar12_k = length(time)-1
if abs(time[sar12_k] - 5.88e-05) > 1e-12
print time[sar12_k]
echo expected_pause_time_s 5.88e-05
echo SAR12_PAUSE_FAILED
quit 1
end
print time[sar12_k] >> pause-times.txt
delete all
let sar12_k = length(time)-1
let sar12_cmp = v(COMP)[sar12_k]
let sar12_cmpn = v(COMPN)[sar12_k]
let sar12_p = v(TOPP)[sar12_k]
let sar12_n = v(TOPN)[sar12_k]
let sar12_decision = 0
if sar12_cmp >= 0.9
let sar12_code = sar12_trial
let sar12_decision = 1
end
echo 5 3 $&sar12_trial $&sar12_cmp $&sar12_cmpn $&sar12_p $&sar12_n -1.16220703125 $&sar12_decision >> decisions.csv
alter VD_EVAL = 0
let sar12_trial = sar12_code + 4
let sar12_drive = (floor(sar12_trial / 1) - 2*floor(sar12_trial / 2))*1.8
alter VD_B0 = $&sar12_drive
let sar12_drive = (floor(sar12_trial / 2) - 2*floor(sar12_trial / 4))*1.8
alter VD_B1 = $&sar12_drive
let sar12_drive = (floor(sar12_trial / 4) - 2*floor(sar12_trial / 8))*1.8
alter VD_B2 = $&sar12_drive
let sar12_drive = (floor(sar12_trial / 8) - 2*floor(sar12_trial / 16))*1.8
alter VD_B3 = $&sar12_drive
let sar12_drive = (floor(sar12_trial / 16) - 2*floor(sar12_trial / 32))*1.8
alter VD_B4 = $&sar12_drive
let sar12_drive = (floor(sar12_trial / 32) - 2*floor(sar12_trial / 64))*1.8
alter VD_B5 = $&sar12_drive
let sar12_drive = (floor(sar12_trial / 64) - 2*floor(sar12_trial / 128))*1.8
alter VD_B6 = $&sar12_drive
let sar12_drive = (floor(sar12_trial / 128) - 2*floor(sar12_trial / 256))*1.8
alter VD_B7 = $&sar12_drive
let sar12_drive = (floor(sar12_trial / 256) - 2*floor(sar12_trial / 512))*1.8
alter VD_B8 = $&sar12_drive
let sar12_drive = (floor(sar12_trial / 512) - 2*floor(sar12_trial / 1024))*1.8
alter VD_B9 = $&sar12_drive
let sar12_drive = (floor(sar12_trial / 1024) - 2*floor(sar12_trial / 2048))*1.8
alter VD_B10 = $&sar12_drive
let sar12_drive = (floor(sar12_trial / 2048) - 2*floor(sar12_trial / 4096))*1.8
alter VD_B11 = $&sar12_drive
stop when time ge 5.9124999999e-05
resume
let sar12_k = length(time)-1
if abs(time[sar12_k] - 5.9125e-05) > 1e-12
print time[sar12_k]
echo expected_pause_time_s 5.9125e-05
echo SAR12_PAUSE_FAILED
quit 1
end
print time[sar12_k] >> pause-times.txt
delete all
alter VD_EVAL = 1.8
stop when time ge 5.9299999999e-05
resume
let sar12_k = length(time)-1
if abs(time[sar12_k] - 5.93e-05) > 1e-12
print time[sar12_k]
echo expected_pause_time_s 5.93e-05
echo SAR12_PAUSE_FAILED
quit 1
end
print time[sar12_k] >> pause-times.txt
delete all
let sar12_k = length(time)-1
let sar12_cmp = v(COMP)[sar12_k]
let sar12_cmpn = v(COMPN)[sar12_k]
let sar12_p = v(TOPP)[sar12_k]
let sar12_n = v(TOPN)[sar12_k]
let sar12_decision = 0
if sar12_cmp >= 0.9
let sar12_code = sar12_trial
let sar12_decision = 1
end
echo 5 2 $&sar12_trial $&sar12_cmp $&sar12_cmpn $&sar12_p $&sar12_n -1.16220703125 $&sar12_decision >> decisions.csv
alter VD_EVAL = 0
let sar12_trial = sar12_code + 2
let sar12_drive = (floor(sar12_trial / 1) - 2*floor(sar12_trial / 2))*1.8
alter VD_B0 = $&sar12_drive
let sar12_drive = (floor(sar12_trial / 2) - 2*floor(sar12_trial / 4))*1.8
alter VD_B1 = $&sar12_drive
let sar12_drive = (floor(sar12_trial / 4) - 2*floor(sar12_trial / 8))*1.8
alter VD_B2 = $&sar12_drive
let sar12_drive = (floor(sar12_trial / 8) - 2*floor(sar12_trial / 16))*1.8
alter VD_B3 = $&sar12_drive
let sar12_drive = (floor(sar12_trial / 16) - 2*floor(sar12_trial / 32))*1.8
alter VD_B4 = $&sar12_drive
let sar12_drive = (floor(sar12_trial / 32) - 2*floor(sar12_trial / 64))*1.8
alter VD_B5 = $&sar12_drive
let sar12_drive = (floor(sar12_trial / 64) - 2*floor(sar12_trial / 128))*1.8
alter VD_B6 = $&sar12_drive
let sar12_drive = (floor(sar12_trial / 128) - 2*floor(sar12_trial / 256))*1.8
alter VD_B7 = $&sar12_drive
let sar12_drive = (floor(sar12_trial / 256) - 2*floor(sar12_trial / 512))*1.8
alter VD_B8 = $&sar12_drive
let sar12_drive = (floor(sar12_trial / 512) - 2*floor(sar12_trial / 1024))*1.8
alter VD_B9 = $&sar12_drive
let sar12_drive = (floor(sar12_trial / 1024) - 2*floor(sar12_trial / 2048))*1.8
alter VD_B10 = $&sar12_drive
let sar12_drive = (floor(sar12_trial / 2048) - 2*floor(sar12_trial / 4096))*1.8
alter VD_B11 = $&sar12_drive
stop when time ge 5.9624999999e-05
resume
let sar12_k = length(time)-1
if abs(time[sar12_k] - 5.9625e-05) > 1e-12
print time[sar12_k]
echo expected_pause_time_s 5.9625e-05
echo SAR12_PAUSE_FAILED
quit 1
end
print time[sar12_k] >> pause-times.txt
delete all
alter VD_EVAL = 1.8
stop when time ge 5.9799999999e-05
resume
let sar12_k = length(time)-1
if abs(time[sar12_k] - 5.98e-05) > 1e-12
print time[sar12_k]
echo expected_pause_time_s 5.98e-05
echo SAR12_PAUSE_FAILED
quit 1
end
print time[sar12_k] >> pause-times.txt
delete all
let sar12_k = length(time)-1
let sar12_cmp = v(COMP)[sar12_k]
let sar12_cmpn = v(COMPN)[sar12_k]
let sar12_p = v(TOPP)[sar12_k]
let sar12_n = v(TOPN)[sar12_k]
let sar12_decision = 0
if sar12_cmp >= 0.9
let sar12_code = sar12_trial
let sar12_decision = 1
end
echo 5 1 $&sar12_trial $&sar12_cmp $&sar12_cmpn $&sar12_p $&sar12_n -1.16220703125 $&sar12_decision >> decisions.csv
alter VD_EVAL = 0
let sar12_trial = sar12_code + 1
let sar12_drive = (floor(sar12_trial / 1) - 2*floor(sar12_trial / 2))*1.8
alter VD_B0 = $&sar12_drive
let sar12_drive = (floor(sar12_trial / 2) - 2*floor(sar12_trial / 4))*1.8
alter VD_B1 = $&sar12_drive
let sar12_drive = (floor(sar12_trial / 4) - 2*floor(sar12_trial / 8))*1.8
alter VD_B2 = $&sar12_drive
let sar12_drive = (floor(sar12_trial / 8) - 2*floor(sar12_trial / 16))*1.8
alter VD_B3 = $&sar12_drive
let sar12_drive = (floor(sar12_trial / 16) - 2*floor(sar12_trial / 32))*1.8
alter VD_B4 = $&sar12_drive
let sar12_drive = (floor(sar12_trial / 32) - 2*floor(sar12_trial / 64))*1.8
alter VD_B5 = $&sar12_drive
let sar12_drive = (floor(sar12_trial / 64) - 2*floor(sar12_trial / 128))*1.8
alter VD_B6 = $&sar12_drive
let sar12_drive = (floor(sar12_trial / 128) - 2*floor(sar12_trial / 256))*1.8
alter VD_B7 = $&sar12_drive
let sar12_drive = (floor(sar12_trial / 256) - 2*floor(sar12_trial / 512))*1.8
alter VD_B8 = $&sar12_drive
let sar12_drive = (floor(sar12_trial / 512) - 2*floor(sar12_trial / 1024))*1.8
alter VD_B9 = $&sar12_drive
let sar12_drive = (floor(sar12_trial / 1024) - 2*floor(sar12_trial / 2048))*1.8
alter VD_B10 = $&sar12_drive
let sar12_drive = (floor(sar12_trial / 2048) - 2*floor(sar12_trial / 4096))*1.8
alter VD_B11 = $&sar12_drive
stop when time ge 6.0124999999e-05
resume
let sar12_k = length(time)-1
if abs(time[sar12_k] - 6.0125e-05) > 1e-12
print time[sar12_k]
echo expected_pause_time_s 6.0125e-05
echo SAR12_PAUSE_FAILED
quit 1
end
print time[sar12_k] >> pause-times.txt
delete all
alter VD_EVAL = 1.8
stop when time ge 6.0299999999e-05
resume
let sar12_k = length(time)-1
if abs(time[sar12_k] - 6.03e-05) > 1e-12
print time[sar12_k]
echo expected_pause_time_s 6.03e-05
echo SAR12_PAUSE_FAILED
quit 1
end
print time[sar12_k] >> pause-times.txt
delete all
let sar12_k = length(time)-1
let sar12_cmp = v(COMP)[sar12_k]
let sar12_cmpn = v(COMPN)[sar12_k]
let sar12_p = v(TOPP)[sar12_k]
let sar12_n = v(TOPN)[sar12_k]
let sar12_decision = 0
if sar12_cmp >= 0.9
let sar12_code = sar12_trial
let sar12_decision = 1
end
echo 5 0 $&sar12_trial $&sar12_cmp $&sar12_cmpn $&sar12_p $&sar12_n -1.16220703125 $&sar12_decision >> decisions.csv
alter VD_EVAL = 0
alter VINP = 0.319189453125
alter VINN = 1.48081054687
alter VD_SAMPLE = 1.8
alter VD_EVAL = 0
alter VD_B0 = 0
alter VD_B1 = 0
alter VD_B2 = 0
alter VD_B3 = 0
alter VD_B4 = 0
alter VD_B5 = 0
alter VD_B6 = 0
alter VD_B7 = 0
alter VD_B8 = 0
alter VD_B9 = 0
alter VD_B10 = 0
alter VD_B11 = 0
let sar12_code = 0
stop when time ge 6.4299999999e-05
resume
let sar12_k = length(time)-1
if abs(time[sar12_k] - 6.43e-05) > 1e-12
print time[sar12_k]
echo expected_pause_time_s 6.43e-05
echo SAR12_PAUSE_FAILED
quit 1
end
print time[sar12_k] >> pause-times.txt
delete all
alter VD_SAMPLE = 0
stop when time ge 6.4349999999e-05
resume
let sar12_k = length(time)-1
if abs(time[sar12_k] - 6.435e-05) > 1e-12
print time[sar12_k]
echo expected_pause_time_s 6.435e-05
echo SAR12_PAUSE_FAILED
quit 1
end
print time[sar12_k] >> pause-times.txt
delete all
alter VD_EVAL = 0
let sar12_trial = sar12_code + 2048
let sar12_drive = (floor(sar12_trial / 1) - 2*floor(sar12_trial / 2))*1.8
alter VD_B0 = $&sar12_drive
let sar12_drive = (floor(sar12_trial / 2) - 2*floor(sar12_trial / 4))*1.8
alter VD_B1 = $&sar12_drive
let sar12_drive = (floor(sar12_trial / 4) - 2*floor(sar12_trial / 8))*1.8
alter VD_B2 = $&sar12_drive
let sar12_drive = (floor(sar12_trial / 8) - 2*floor(sar12_trial / 16))*1.8
alter VD_B3 = $&sar12_drive
let sar12_drive = (floor(sar12_trial / 16) - 2*floor(sar12_trial / 32))*1.8
alter VD_B4 = $&sar12_drive
let sar12_drive = (floor(sar12_trial / 32) - 2*floor(sar12_trial / 64))*1.8
alter VD_B5 = $&sar12_drive
let sar12_drive = (floor(sar12_trial / 64) - 2*floor(sar12_trial / 128))*1.8
alter VD_B6 = $&sar12_drive
let sar12_drive = (floor(sar12_trial / 128) - 2*floor(sar12_trial / 256))*1.8
alter VD_B7 = $&sar12_drive
let sar12_drive = (floor(sar12_trial / 256) - 2*floor(sar12_trial / 512))*1.8
alter VD_B8 = $&sar12_drive
let sar12_drive = (floor(sar12_trial / 512) - 2*floor(sar12_trial / 1024))*1.8
alter VD_B9 = $&sar12_drive
let sar12_drive = (floor(sar12_trial / 1024) - 2*floor(sar12_trial / 2048))*1.8
alter VD_B10 = $&sar12_drive
let sar12_drive = (floor(sar12_trial / 2048) - 2*floor(sar12_trial / 4096))*1.8
alter VD_B11 = $&sar12_drive
stop when time ge 6.4674999999e-05
resume
let sar12_k = length(time)-1
if abs(time[sar12_k] - 6.4675e-05) > 1e-12
print time[sar12_k]
echo expected_pause_time_s 6.4675e-05
echo SAR12_PAUSE_FAILED
quit 1
end
print time[sar12_k] >> pause-times.txt
delete all
alter VD_EVAL = 1.8
stop when time ge 6.4849999999e-05
resume
let sar12_k = length(time)-1
if abs(time[sar12_k] - 6.485e-05) > 1e-12
print time[sar12_k]
echo expected_pause_time_s 6.485e-05
echo SAR12_PAUSE_FAILED
quit 1
end
print time[sar12_k] >> pause-times.txt
delete all
let sar12_k = length(time)-1
let sar12_cmp = v(COMP)[sar12_k]
let sar12_cmpn = v(COMPN)[sar12_k]
let sar12_p = v(TOPP)[sar12_k]
let sar12_n = v(TOPN)[sar12_k]
let sar12_decision = 0
if sar12_cmp >= 0.9
let sar12_code = sar12_trial
let sar12_decision = 1
end
echo 6 11 $&sar12_trial $&sar12_cmp $&sar12_cmpn $&sar12_p $&sar12_n -1.16162109375 $&sar12_decision >> decisions.csv
alter VD_EVAL = 0
let sar12_trial = sar12_code + 1024
let sar12_drive = (floor(sar12_trial / 1) - 2*floor(sar12_trial / 2))*1.8
alter VD_B0 = $&sar12_drive
let sar12_drive = (floor(sar12_trial / 2) - 2*floor(sar12_trial / 4))*1.8
alter VD_B1 = $&sar12_drive
let sar12_drive = (floor(sar12_trial / 4) - 2*floor(sar12_trial / 8))*1.8
alter VD_B2 = $&sar12_drive
let sar12_drive = (floor(sar12_trial / 8) - 2*floor(sar12_trial / 16))*1.8
alter VD_B3 = $&sar12_drive
let sar12_drive = (floor(sar12_trial / 16) - 2*floor(sar12_trial / 32))*1.8
alter VD_B4 = $&sar12_drive
let sar12_drive = (floor(sar12_trial / 32) - 2*floor(sar12_trial / 64))*1.8
alter VD_B5 = $&sar12_drive
let sar12_drive = (floor(sar12_trial / 64) - 2*floor(sar12_trial / 128))*1.8
alter VD_B6 = $&sar12_drive
let sar12_drive = (floor(sar12_trial / 128) - 2*floor(sar12_trial / 256))*1.8
alter VD_B7 = $&sar12_drive
let sar12_drive = (floor(sar12_trial / 256) - 2*floor(sar12_trial / 512))*1.8
alter VD_B8 = $&sar12_drive
let sar12_drive = (floor(sar12_trial / 512) - 2*floor(sar12_trial / 1024))*1.8
alter VD_B9 = $&sar12_drive
let sar12_drive = (floor(sar12_trial / 1024) - 2*floor(sar12_trial / 2048))*1.8
alter VD_B10 = $&sar12_drive
let sar12_drive = (floor(sar12_trial / 2048) - 2*floor(sar12_trial / 4096))*1.8
alter VD_B11 = $&sar12_drive
stop when time ge 6.5174999999e-05
resume
let sar12_k = length(time)-1
if abs(time[sar12_k] - 6.5175e-05) > 1e-12
print time[sar12_k]
echo expected_pause_time_s 6.5175e-05
echo SAR12_PAUSE_FAILED
quit 1
end
print time[sar12_k] >> pause-times.txt
delete all
alter VD_EVAL = 1.8
stop when time ge 6.5349999999e-05
resume
let sar12_k = length(time)-1
if abs(time[sar12_k] - 6.535e-05) > 1e-12
print time[sar12_k]
echo expected_pause_time_s 6.535e-05
echo SAR12_PAUSE_FAILED
quit 1
end
print time[sar12_k] >> pause-times.txt
delete all
let sar12_k = length(time)-1
let sar12_cmp = v(COMP)[sar12_k]
let sar12_cmpn = v(COMPN)[sar12_k]
let sar12_p = v(TOPP)[sar12_k]
let sar12_n = v(TOPN)[sar12_k]
let sar12_decision = 0
if sar12_cmp >= 0.9
let sar12_code = sar12_trial
let sar12_decision = 1
end
echo 6 10 $&sar12_trial $&sar12_cmp $&sar12_cmpn $&sar12_p $&sar12_n -1.16162109375 $&sar12_decision >> decisions.csv
alter VD_EVAL = 0
let sar12_trial = sar12_code + 512
let sar12_drive = (floor(sar12_trial / 1) - 2*floor(sar12_trial / 2))*1.8
alter VD_B0 = $&sar12_drive
let sar12_drive = (floor(sar12_trial / 2) - 2*floor(sar12_trial / 4))*1.8
alter VD_B1 = $&sar12_drive
let sar12_drive = (floor(sar12_trial / 4) - 2*floor(sar12_trial / 8))*1.8
alter VD_B2 = $&sar12_drive
let sar12_drive = (floor(sar12_trial / 8) - 2*floor(sar12_trial / 16))*1.8
alter VD_B3 = $&sar12_drive
let sar12_drive = (floor(sar12_trial / 16) - 2*floor(sar12_trial / 32))*1.8
alter VD_B4 = $&sar12_drive
let sar12_drive = (floor(sar12_trial / 32) - 2*floor(sar12_trial / 64))*1.8
alter VD_B5 = $&sar12_drive
let sar12_drive = (floor(sar12_trial / 64) - 2*floor(sar12_trial / 128))*1.8
alter VD_B6 = $&sar12_drive
let sar12_drive = (floor(sar12_trial / 128) - 2*floor(sar12_trial / 256))*1.8
alter VD_B7 = $&sar12_drive
let sar12_drive = (floor(sar12_trial / 256) - 2*floor(sar12_trial / 512))*1.8
alter VD_B8 = $&sar12_drive
let sar12_drive = (floor(sar12_trial / 512) - 2*floor(sar12_trial / 1024))*1.8
alter VD_B9 = $&sar12_drive
let sar12_drive = (floor(sar12_trial / 1024) - 2*floor(sar12_trial / 2048))*1.8
alter VD_B10 = $&sar12_drive
let sar12_drive = (floor(sar12_trial / 2048) - 2*floor(sar12_trial / 4096))*1.8
alter VD_B11 = $&sar12_drive
stop when time ge 6.5674999999e-05
resume
let sar12_k = length(time)-1
if abs(time[sar12_k] - 6.5675e-05) > 1e-12
print time[sar12_k]
echo expected_pause_time_s 6.5675e-05
echo SAR12_PAUSE_FAILED
quit 1
end
print time[sar12_k] >> pause-times.txt
delete all
alter VD_EVAL = 1.8
stop when time ge 6.5849999999e-05
resume
let sar12_k = length(time)-1
if abs(time[sar12_k] - 6.585e-05) > 1e-12
print time[sar12_k]
echo expected_pause_time_s 6.585e-05
echo SAR12_PAUSE_FAILED
quit 1
end
print time[sar12_k] >> pause-times.txt
delete all
let sar12_k = length(time)-1
let sar12_cmp = v(COMP)[sar12_k]
let sar12_cmpn = v(COMPN)[sar12_k]
let sar12_p = v(TOPP)[sar12_k]
let sar12_n = v(TOPN)[sar12_k]
let sar12_decision = 0
if sar12_cmp >= 0.9
let sar12_code = sar12_trial
let sar12_decision = 1
end
echo 6 9 $&sar12_trial $&sar12_cmp $&sar12_cmpn $&sar12_p $&sar12_n -1.16162109375 $&sar12_decision >> decisions.csv
alter VD_EVAL = 0
let sar12_trial = sar12_code + 256
let sar12_drive = (floor(sar12_trial / 1) - 2*floor(sar12_trial / 2))*1.8
alter VD_B0 = $&sar12_drive
let sar12_drive = (floor(sar12_trial / 2) - 2*floor(sar12_trial / 4))*1.8
alter VD_B1 = $&sar12_drive
let sar12_drive = (floor(sar12_trial / 4) - 2*floor(sar12_trial / 8))*1.8
alter VD_B2 = $&sar12_drive
let sar12_drive = (floor(sar12_trial / 8) - 2*floor(sar12_trial / 16))*1.8
alter VD_B3 = $&sar12_drive
let sar12_drive = (floor(sar12_trial / 16) - 2*floor(sar12_trial / 32))*1.8
alter VD_B4 = $&sar12_drive
let sar12_drive = (floor(sar12_trial / 32) - 2*floor(sar12_trial / 64))*1.8
alter VD_B5 = $&sar12_drive
let sar12_drive = (floor(sar12_trial / 64) - 2*floor(sar12_trial / 128))*1.8
alter VD_B6 = $&sar12_drive
let sar12_drive = (floor(sar12_trial / 128) - 2*floor(sar12_trial / 256))*1.8
alter VD_B7 = $&sar12_drive
let sar12_drive = (floor(sar12_trial / 256) - 2*floor(sar12_trial / 512))*1.8
alter VD_B8 = $&sar12_drive
let sar12_drive = (floor(sar12_trial / 512) - 2*floor(sar12_trial / 1024))*1.8
alter VD_B9 = $&sar12_drive
let sar12_drive = (floor(sar12_trial / 1024) - 2*floor(sar12_trial / 2048))*1.8
alter VD_B10 = $&sar12_drive
let sar12_drive = (floor(sar12_trial / 2048) - 2*floor(sar12_trial / 4096))*1.8
alter VD_B11 = $&sar12_drive
stop when time ge 6.6174999999e-05
resume
let sar12_k = length(time)-1
if abs(time[sar12_k] - 6.6175e-05) > 1e-12
print time[sar12_k]
echo expected_pause_time_s 6.6175e-05
echo SAR12_PAUSE_FAILED
quit 1
end
print time[sar12_k] >> pause-times.txt
delete all
alter VD_EVAL = 1.8
stop when time ge 6.6349999999e-05
resume
let sar12_k = length(time)-1
if abs(time[sar12_k] - 6.635e-05) > 1e-12
print time[sar12_k]
echo expected_pause_time_s 6.635e-05
echo SAR12_PAUSE_FAILED
quit 1
end
print time[sar12_k] >> pause-times.txt
delete all
let sar12_k = length(time)-1
let sar12_cmp = v(COMP)[sar12_k]
let sar12_cmpn = v(COMPN)[sar12_k]
let sar12_p = v(TOPP)[sar12_k]
let sar12_n = v(TOPN)[sar12_k]
let sar12_decision = 0
if sar12_cmp >= 0.9
let sar12_code = sar12_trial
let sar12_decision = 1
end
echo 6 8 $&sar12_trial $&sar12_cmp $&sar12_cmpn $&sar12_p $&sar12_n -1.16162109375 $&sar12_decision >> decisions.csv
alter VD_EVAL = 0
let sar12_trial = sar12_code + 128
let sar12_drive = (floor(sar12_trial / 1) - 2*floor(sar12_trial / 2))*1.8
alter VD_B0 = $&sar12_drive
let sar12_drive = (floor(sar12_trial / 2) - 2*floor(sar12_trial / 4))*1.8
alter VD_B1 = $&sar12_drive
let sar12_drive = (floor(sar12_trial / 4) - 2*floor(sar12_trial / 8))*1.8
alter VD_B2 = $&sar12_drive
let sar12_drive = (floor(sar12_trial / 8) - 2*floor(sar12_trial / 16))*1.8
alter VD_B3 = $&sar12_drive
let sar12_drive = (floor(sar12_trial / 16) - 2*floor(sar12_trial / 32))*1.8
alter VD_B4 = $&sar12_drive
let sar12_drive = (floor(sar12_trial / 32) - 2*floor(sar12_trial / 64))*1.8
alter VD_B5 = $&sar12_drive
let sar12_drive = (floor(sar12_trial / 64) - 2*floor(sar12_trial / 128))*1.8
alter VD_B6 = $&sar12_drive
let sar12_drive = (floor(sar12_trial / 128) - 2*floor(sar12_trial / 256))*1.8
alter VD_B7 = $&sar12_drive
let sar12_drive = (floor(sar12_trial / 256) - 2*floor(sar12_trial / 512))*1.8
alter VD_B8 = $&sar12_drive
let sar12_drive = (floor(sar12_trial / 512) - 2*floor(sar12_trial / 1024))*1.8
alter VD_B9 = $&sar12_drive
let sar12_drive = (floor(sar12_trial / 1024) - 2*floor(sar12_trial / 2048))*1.8
alter VD_B10 = $&sar12_drive
let sar12_drive = (floor(sar12_trial / 2048) - 2*floor(sar12_trial / 4096))*1.8
alter VD_B11 = $&sar12_drive
stop when time ge 6.6674999999e-05
resume
let sar12_k = length(time)-1
if abs(time[sar12_k] - 6.6675e-05) > 1e-12
print time[sar12_k]
echo expected_pause_time_s 6.6675e-05
echo SAR12_PAUSE_FAILED
quit 1
end
print time[sar12_k] >> pause-times.txt
delete all
alter VD_EVAL = 1.8
stop when time ge 6.6849999999e-05
resume
let sar12_k = length(time)-1
if abs(time[sar12_k] - 6.685e-05) > 1e-12
print time[sar12_k]
echo expected_pause_time_s 6.685e-05
echo SAR12_PAUSE_FAILED
quit 1
end
print time[sar12_k] >> pause-times.txt
delete all
let sar12_k = length(time)-1
let sar12_cmp = v(COMP)[sar12_k]
let sar12_cmpn = v(COMPN)[sar12_k]
let sar12_p = v(TOPP)[sar12_k]
let sar12_n = v(TOPN)[sar12_k]
let sar12_decision = 0
if sar12_cmp >= 0.9
let sar12_code = sar12_trial
let sar12_decision = 1
end
echo 6 7 $&sar12_trial $&sar12_cmp $&sar12_cmpn $&sar12_p $&sar12_n -1.16162109375 $&sar12_decision >> decisions.csv
alter VD_EVAL = 0
let sar12_trial = sar12_code + 64
let sar12_drive = (floor(sar12_trial / 1) - 2*floor(sar12_trial / 2))*1.8
alter VD_B0 = $&sar12_drive
let sar12_drive = (floor(sar12_trial / 2) - 2*floor(sar12_trial / 4))*1.8
alter VD_B1 = $&sar12_drive
let sar12_drive = (floor(sar12_trial / 4) - 2*floor(sar12_trial / 8))*1.8
alter VD_B2 = $&sar12_drive
let sar12_drive = (floor(sar12_trial / 8) - 2*floor(sar12_trial / 16))*1.8
alter VD_B3 = $&sar12_drive
let sar12_drive = (floor(sar12_trial / 16) - 2*floor(sar12_trial / 32))*1.8
alter VD_B4 = $&sar12_drive
let sar12_drive = (floor(sar12_trial / 32) - 2*floor(sar12_trial / 64))*1.8
alter VD_B5 = $&sar12_drive
let sar12_drive = (floor(sar12_trial / 64) - 2*floor(sar12_trial / 128))*1.8
alter VD_B6 = $&sar12_drive
let sar12_drive = (floor(sar12_trial / 128) - 2*floor(sar12_trial / 256))*1.8
alter VD_B7 = $&sar12_drive
let sar12_drive = (floor(sar12_trial / 256) - 2*floor(sar12_trial / 512))*1.8
alter VD_B8 = $&sar12_drive
let sar12_drive = (floor(sar12_trial / 512) - 2*floor(sar12_trial / 1024))*1.8
alter VD_B9 = $&sar12_drive
let sar12_drive = (floor(sar12_trial / 1024) - 2*floor(sar12_trial / 2048))*1.8
alter VD_B10 = $&sar12_drive
let sar12_drive = (floor(sar12_trial / 2048) - 2*floor(sar12_trial / 4096))*1.8
alter VD_B11 = $&sar12_drive
stop when time ge 6.7174999999e-05
resume
let sar12_k = length(time)-1
if abs(time[sar12_k] - 6.7175e-05) > 1e-12
print time[sar12_k]
echo expected_pause_time_s 6.7175e-05
echo SAR12_PAUSE_FAILED
quit 1
end
print time[sar12_k] >> pause-times.txt
delete all
alter VD_EVAL = 1.8
stop when time ge 6.7349999999e-05
resume
let sar12_k = length(time)-1
if abs(time[sar12_k] - 6.735e-05) > 1e-12
print time[sar12_k]
echo expected_pause_time_s 6.735e-05
echo SAR12_PAUSE_FAILED
quit 1
end
print time[sar12_k] >> pause-times.txt
delete all
let sar12_k = length(time)-1
let sar12_cmp = v(COMP)[sar12_k]
let sar12_cmpn = v(COMPN)[sar12_k]
let sar12_p = v(TOPP)[sar12_k]
let sar12_n = v(TOPN)[sar12_k]
let sar12_decision = 0
if sar12_cmp >= 0.9
let sar12_code = sar12_trial
let sar12_decision = 1
end
echo 6 6 $&sar12_trial $&sar12_cmp $&sar12_cmpn $&sar12_p $&sar12_n -1.16162109375 $&sar12_decision >> decisions.csv
alter VD_EVAL = 0
let sar12_trial = sar12_code + 32
let sar12_drive = (floor(sar12_trial / 1) - 2*floor(sar12_trial / 2))*1.8
alter VD_B0 = $&sar12_drive
let sar12_drive = (floor(sar12_trial / 2) - 2*floor(sar12_trial / 4))*1.8
alter VD_B1 = $&sar12_drive
let sar12_drive = (floor(sar12_trial / 4) - 2*floor(sar12_trial / 8))*1.8
alter VD_B2 = $&sar12_drive
let sar12_drive = (floor(sar12_trial / 8) - 2*floor(sar12_trial / 16))*1.8
alter VD_B3 = $&sar12_drive
let sar12_drive = (floor(sar12_trial / 16) - 2*floor(sar12_trial / 32))*1.8
alter VD_B4 = $&sar12_drive
let sar12_drive = (floor(sar12_trial / 32) - 2*floor(sar12_trial / 64))*1.8
alter VD_B5 = $&sar12_drive
let sar12_drive = (floor(sar12_trial / 64) - 2*floor(sar12_trial / 128))*1.8
alter VD_B6 = $&sar12_drive
let sar12_drive = (floor(sar12_trial / 128) - 2*floor(sar12_trial / 256))*1.8
alter VD_B7 = $&sar12_drive
let sar12_drive = (floor(sar12_trial / 256) - 2*floor(sar12_trial / 512))*1.8
alter VD_B8 = $&sar12_drive
let sar12_drive = (floor(sar12_trial / 512) - 2*floor(sar12_trial / 1024))*1.8
alter VD_B9 = $&sar12_drive
let sar12_drive = (floor(sar12_trial / 1024) - 2*floor(sar12_trial / 2048))*1.8
alter VD_B10 = $&sar12_drive
let sar12_drive = (floor(sar12_trial / 2048) - 2*floor(sar12_trial / 4096))*1.8
alter VD_B11 = $&sar12_drive
stop when time ge 6.7674999999e-05
resume
let sar12_k = length(time)-1
if abs(time[sar12_k] - 6.7675e-05) > 1e-12
print time[sar12_k]
echo expected_pause_time_s 6.7675e-05
echo SAR12_PAUSE_FAILED
quit 1
end
print time[sar12_k] >> pause-times.txt
delete all
alter VD_EVAL = 1.8
stop when time ge 6.7849999999e-05
resume
let sar12_k = length(time)-1
if abs(time[sar12_k] - 6.785e-05) > 1e-12
print time[sar12_k]
echo expected_pause_time_s 6.785e-05
echo SAR12_PAUSE_FAILED
quit 1
end
print time[sar12_k] >> pause-times.txt
delete all
let sar12_k = length(time)-1
let sar12_cmp = v(COMP)[sar12_k]
let sar12_cmpn = v(COMPN)[sar12_k]
let sar12_p = v(TOPP)[sar12_k]
let sar12_n = v(TOPN)[sar12_k]
let sar12_decision = 0
if sar12_cmp >= 0.9
let sar12_code = sar12_trial
let sar12_decision = 1
end
echo 6 5 $&sar12_trial $&sar12_cmp $&sar12_cmpn $&sar12_p $&sar12_n -1.16162109375 $&sar12_decision >> decisions.csv
alter VD_EVAL = 0
let sar12_trial = sar12_code + 16
let sar12_drive = (floor(sar12_trial / 1) - 2*floor(sar12_trial / 2))*1.8
alter VD_B0 = $&sar12_drive
let sar12_drive = (floor(sar12_trial / 2) - 2*floor(sar12_trial / 4))*1.8
alter VD_B1 = $&sar12_drive
let sar12_drive = (floor(sar12_trial / 4) - 2*floor(sar12_trial / 8))*1.8
alter VD_B2 = $&sar12_drive
let sar12_drive = (floor(sar12_trial / 8) - 2*floor(sar12_trial / 16))*1.8
alter VD_B3 = $&sar12_drive
let sar12_drive = (floor(sar12_trial / 16) - 2*floor(sar12_trial / 32))*1.8
alter VD_B4 = $&sar12_drive
let sar12_drive = (floor(sar12_trial / 32) - 2*floor(sar12_trial / 64))*1.8
alter VD_B5 = $&sar12_drive
let sar12_drive = (floor(sar12_trial / 64) - 2*floor(sar12_trial / 128))*1.8
alter VD_B6 = $&sar12_drive
let sar12_drive = (floor(sar12_trial / 128) - 2*floor(sar12_trial / 256))*1.8
alter VD_B7 = $&sar12_drive
let sar12_drive = (floor(sar12_trial / 256) - 2*floor(sar12_trial / 512))*1.8
alter VD_B8 = $&sar12_drive
let sar12_drive = (floor(sar12_trial / 512) - 2*floor(sar12_trial / 1024))*1.8
alter VD_B9 = $&sar12_drive
let sar12_drive = (floor(sar12_trial / 1024) - 2*floor(sar12_trial / 2048))*1.8
alter VD_B10 = $&sar12_drive
let sar12_drive = (floor(sar12_trial / 2048) - 2*floor(sar12_trial / 4096))*1.8
alter VD_B11 = $&sar12_drive
stop when time ge 6.8174999999e-05
resume
let sar12_k = length(time)-1
if abs(time[sar12_k] - 6.8175e-05) > 1e-12
print time[sar12_k]
echo expected_pause_time_s 6.8175e-05
echo SAR12_PAUSE_FAILED
quit 1
end
print time[sar12_k] >> pause-times.txt
delete all
alter VD_EVAL = 1.8
stop when time ge 6.8349999999e-05
resume
let sar12_k = length(time)-1
if abs(time[sar12_k] - 6.835e-05) > 1e-12
print time[sar12_k]
echo expected_pause_time_s 6.835e-05
echo SAR12_PAUSE_FAILED
quit 1
end
print time[sar12_k] >> pause-times.txt
delete all
let sar12_k = length(time)-1
let sar12_cmp = v(COMP)[sar12_k]
let sar12_cmpn = v(COMPN)[sar12_k]
let sar12_p = v(TOPP)[sar12_k]
let sar12_n = v(TOPN)[sar12_k]
let sar12_decision = 0
if sar12_cmp >= 0.9
let sar12_code = sar12_trial
let sar12_decision = 1
end
echo 6 4 $&sar12_trial $&sar12_cmp $&sar12_cmpn $&sar12_p $&sar12_n -1.16162109375 $&sar12_decision >> decisions.csv
alter VD_EVAL = 0
let sar12_trial = sar12_code + 8
let sar12_drive = (floor(sar12_trial / 1) - 2*floor(sar12_trial / 2))*1.8
alter VD_B0 = $&sar12_drive
let sar12_drive = (floor(sar12_trial / 2) - 2*floor(sar12_trial / 4))*1.8
alter VD_B1 = $&sar12_drive
let sar12_drive = (floor(sar12_trial / 4) - 2*floor(sar12_trial / 8))*1.8
alter VD_B2 = $&sar12_drive
let sar12_drive = (floor(sar12_trial / 8) - 2*floor(sar12_trial / 16))*1.8
alter VD_B3 = $&sar12_drive
let sar12_drive = (floor(sar12_trial / 16) - 2*floor(sar12_trial / 32))*1.8
alter VD_B4 = $&sar12_drive
let sar12_drive = (floor(sar12_trial / 32) - 2*floor(sar12_trial / 64))*1.8
alter VD_B5 = $&sar12_drive
let sar12_drive = (floor(sar12_trial / 64) - 2*floor(sar12_trial / 128))*1.8
alter VD_B6 = $&sar12_drive
let sar12_drive = (floor(sar12_trial / 128) - 2*floor(sar12_trial / 256))*1.8
alter VD_B7 = $&sar12_drive
let sar12_drive = (floor(sar12_trial / 256) - 2*floor(sar12_trial / 512))*1.8
alter VD_B8 = $&sar12_drive
let sar12_drive = (floor(sar12_trial / 512) - 2*floor(sar12_trial / 1024))*1.8
alter VD_B9 = $&sar12_drive
let sar12_drive = (floor(sar12_trial / 1024) - 2*floor(sar12_trial / 2048))*1.8
alter VD_B10 = $&sar12_drive
let sar12_drive = (floor(sar12_trial / 2048) - 2*floor(sar12_trial / 4096))*1.8
alter VD_B11 = $&sar12_drive
stop when time ge 6.8674999999e-05
resume
let sar12_k = length(time)-1
if abs(time[sar12_k] - 6.8675e-05) > 1e-12
print time[sar12_k]
echo expected_pause_time_s 6.8675e-05
echo SAR12_PAUSE_FAILED
quit 1
end
print time[sar12_k] >> pause-times.txt
delete all
alter VD_EVAL = 1.8
stop when time ge 6.8849999999e-05
resume
let sar12_k = length(time)-1
if abs(time[sar12_k] - 6.885e-05) > 1e-12
print time[sar12_k]
echo expected_pause_time_s 6.885e-05
echo SAR12_PAUSE_FAILED
quit 1
end
print time[sar12_k] >> pause-times.txt
delete all
let sar12_k = length(time)-1
let sar12_cmp = v(COMP)[sar12_k]
let sar12_cmpn = v(COMPN)[sar12_k]
let sar12_p = v(TOPP)[sar12_k]
let sar12_n = v(TOPN)[sar12_k]
let sar12_decision = 0
if sar12_cmp >= 0.9
let sar12_code = sar12_trial
let sar12_decision = 1
end
echo 6 3 $&sar12_trial $&sar12_cmp $&sar12_cmpn $&sar12_p $&sar12_n -1.16162109375 $&sar12_decision >> decisions.csv
alter VD_EVAL = 0
let sar12_trial = sar12_code + 4
let sar12_drive = (floor(sar12_trial / 1) - 2*floor(sar12_trial / 2))*1.8
alter VD_B0 = $&sar12_drive
let sar12_drive = (floor(sar12_trial / 2) - 2*floor(sar12_trial / 4))*1.8
alter VD_B1 = $&sar12_drive
let sar12_drive = (floor(sar12_trial / 4) - 2*floor(sar12_trial / 8))*1.8
alter VD_B2 = $&sar12_drive
let sar12_drive = (floor(sar12_trial / 8) - 2*floor(sar12_trial / 16))*1.8
alter VD_B3 = $&sar12_drive
let sar12_drive = (floor(sar12_trial / 16) - 2*floor(sar12_trial / 32))*1.8
alter VD_B4 = $&sar12_drive
let sar12_drive = (floor(sar12_trial / 32) - 2*floor(sar12_trial / 64))*1.8
alter VD_B5 = $&sar12_drive
let sar12_drive = (floor(sar12_trial / 64) - 2*floor(sar12_trial / 128))*1.8
alter VD_B6 = $&sar12_drive
let sar12_drive = (floor(sar12_trial / 128) - 2*floor(sar12_trial / 256))*1.8
alter VD_B7 = $&sar12_drive
let sar12_drive = (floor(sar12_trial / 256) - 2*floor(sar12_trial / 512))*1.8
alter VD_B8 = $&sar12_drive
let sar12_drive = (floor(sar12_trial / 512) - 2*floor(sar12_trial / 1024))*1.8
alter VD_B9 = $&sar12_drive
let sar12_drive = (floor(sar12_trial / 1024) - 2*floor(sar12_trial / 2048))*1.8
alter VD_B10 = $&sar12_drive
let sar12_drive = (floor(sar12_trial / 2048) - 2*floor(sar12_trial / 4096))*1.8
alter VD_B11 = $&sar12_drive
stop when time ge 6.9174999999e-05
resume
let sar12_k = length(time)-1
if abs(time[sar12_k] - 6.9175e-05) > 1e-12
print time[sar12_k]
echo expected_pause_time_s 6.9175e-05
echo SAR12_PAUSE_FAILED
quit 1
end
print time[sar12_k] >> pause-times.txt
delete all
alter VD_EVAL = 1.8
stop when time ge 6.9349999999e-05
resume
let sar12_k = length(time)-1
if abs(time[sar12_k] - 6.935e-05) > 1e-12
print time[sar12_k]
echo expected_pause_time_s 6.935e-05
echo SAR12_PAUSE_FAILED
quit 1
end
print time[sar12_k] >> pause-times.txt
delete all
let sar12_k = length(time)-1
let sar12_cmp = v(COMP)[sar12_k]
let sar12_cmpn = v(COMPN)[sar12_k]
let sar12_p = v(TOPP)[sar12_k]
let sar12_n = v(TOPN)[sar12_k]
let sar12_decision = 0
if sar12_cmp >= 0.9
let sar12_code = sar12_trial
let sar12_decision = 1
end
echo 6 2 $&sar12_trial $&sar12_cmp $&sar12_cmpn $&sar12_p $&sar12_n -1.16162109375 $&sar12_decision >> decisions.csv
alter VD_EVAL = 0
let sar12_trial = sar12_code + 2
let sar12_drive = (floor(sar12_trial / 1) - 2*floor(sar12_trial / 2))*1.8
alter VD_B0 = $&sar12_drive
let sar12_drive = (floor(sar12_trial / 2) - 2*floor(sar12_trial / 4))*1.8
alter VD_B1 = $&sar12_drive
let sar12_drive = (floor(sar12_trial / 4) - 2*floor(sar12_trial / 8))*1.8
alter VD_B2 = $&sar12_drive
let sar12_drive = (floor(sar12_trial / 8) - 2*floor(sar12_trial / 16))*1.8
alter VD_B3 = $&sar12_drive
let sar12_drive = (floor(sar12_trial / 16) - 2*floor(sar12_trial / 32))*1.8
alter VD_B4 = $&sar12_drive
let sar12_drive = (floor(sar12_trial / 32) - 2*floor(sar12_trial / 64))*1.8
alter VD_B5 = $&sar12_drive
let sar12_drive = (floor(sar12_trial / 64) - 2*floor(sar12_trial / 128))*1.8
alter VD_B6 = $&sar12_drive
let sar12_drive = (floor(sar12_trial / 128) - 2*floor(sar12_trial / 256))*1.8
alter VD_B7 = $&sar12_drive
let sar12_drive = (floor(sar12_trial / 256) - 2*floor(sar12_trial / 512))*1.8
alter VD_B8 = $&sar12_drive
let sar12_drive = (floor(sar12_trial / 512) - 2*floor(sar12_trial / 1024))*1.8
alter VD_B9 = $&sar12_drive
let sar12_drive = (floor(sar12_trial / 1024) - 2*floor(sar12_trial / 2048))*1.8
alter VD_B10 = $&sar12_drive
let sar12_drive = (floor(sar12_trial / 2048) - 2*floor(sar12_trial / 4096))*1.8
alter VD_B11 = $&sar12_drive
stop when time ge 6.9674999999e-05
resume
let sar12_k = length(time)-1
if abs(time[sar12_k] - 6.9675e-05) > 1e-12
print time[sar12_k]
echo expected_pause_time_s 6.9675e-05
echo SAR12_PAUSE_FAILED
quit 1
end
print time[sar12_k] >> pause-times.txt
delete all
alter VD_EVAL = 1.8
stop when time ge 6.9849999999e-05
resume
let sar12_k = length(time)-1
if abs(time[sar12_k] - 6.985e-05) > 1e-12
print time[sar12_k]
echo expected_pause_time_s 6.985e-05
echo SAR12_PAUSE_FAILED
quit 1
end
print time[sar12_k] >> pause-times.txt
delete all
let sar12_k = length(time)-1
let sar12_cmp = v(COMP)[sar12_k]
let sar12_cmpn = v(COMPN)[sar12_k]
let sar12_p = v(TOPP)[sar12_k]
let sar12_n = v(TOPN)[sar12_k]
let sar12_decision = 0
if sar12_cmp >= 0.9
let sar12_code = sar12_trial
let sar12_decision = 1
end
echo 6 1 $&sar12_trial $&sar12_cmp $&sar12_cmpn $&sar12_p $&sar12_n -1.16162109375 $&sar12_decision >> decisions.csv
alter VD_EVAL = 0
let sar12_trial = sar12_code + 1
let sar12_drive = (floor(sar12_trial / 1) - 2*floor(sar12_trial / 2))*1.8
alter VD_B0 = $&sar12_drive
let sar12_drive = (floor(sar12_trial / 2) - 2*floor(sar12_trial / 4))*1.8
alter VD_B1 = $&sar12_drive
let sar12_drive = (floor(sar12_trial / 4) - 2*floor(sar12_trial / 8))*1.8
alter VD_B2 = $&sar12_drive
let sar12_drive = (floor(sar12_trial / 8) - 2*floor(sar12_trial / 16))*1.8
alter VD_B3 = $&sar12_drive
let sar12_drive = (floor(sar12_trial / 16) - 2*floor(sar12_trial / 32))*1.8
alter VD_B4 = $&sar12_drive
let sar12_drive = (floor(sar12_trial / 32) - 2*floor(sar12_trial / 64))*1.8
alter VD_B5 = $&sar12_drive
let sar12_drive = (floor(sar12_trial / 64) - 2*floor(sar12_trial / 128))*1.8
alter VD_B6 = $&sar12_drive
let sar12_drive = (floor(sar12_trial / 128) - 2*floor(sar12_trial / 256))*1.8
alter VD_B7 = $&sar12_drive
let sar12_drive = (floor(sar12_trial / 256) - 2*floor(sar12_trial / 512))*1.8
alter VD_B8 = $&sar12_drive
let sar12_drive = (floor(sar12_trial / 512) - 2*floor(sar12_trial / 1024))*1.8
alter VD_B9 = $&sar12_drive
let sar12_drive = (floor(sar12_trial / 1024) - 2*floor(sar12_trial / 2048))*1.8
alter VD_B10 = $&sar12_drive
let sar12_drive = (floor(sar12_trial / 2048) - 2*floor(sar12_trial / 4096))*1.8
alter VD_B11 = $&sar12_drive
stop when time ge 7.0174999999e-05
resume
let sar12_k = length(time)-1
if abs(time[sar12_k] - 7.0175e-05) > 1e-12
print time[sar12_k]
echo expected_pause_time_s 7.0175e-05
echo SAR12_PAUSE_FAILED
quit 1
end
print time[sar12_k] >> pause-times.txt
delete all
alter VD_EVAL = 1.8
stop when time ge 7.0349999999e-05
resume
let sar12_k = length(time)-1
if abs(time[sar12_k] - 7.035e-05) > 1e-12
print time[sar12_k]
echo expected_pause_time_s 7.035e-05
echo SAR12_PAUSE_FAILED
quit 1
end
print time[sar12_k] >> pause-times.txt
delete all
let sar12_k = length(time)-1
let sar12_cmp = v(COMP)[sar12_k]
let sar12_cmpn = v(COMPN)[sar12_k]
let sar12_p = v(TOPP)[sar12_k]
let sar12_n = v(TOPN)[sar12_k]
let sar12_decision = 0
if sar12_cmp >= 0.9
let sar12_code = sar12_trial
let sar12_decision = 1
end
echo 6 0 $&sar12_trial $&sar12_cmp $&sar12_cmpn $&sar12_p $&sar12_n -1.16162109375 $&sar12_decision >> decisions.csv
alter VD_EVAL = 0
alter VINP = 0.599853515625
alter VINN = 1.20014648438
alter VD_SAMPLE = 1.8
alter VD_EVAL = 0
alter VD_B0 = 0
alter VD_B1 = 0
alter VD_B2 = 0
alter VD_B3 = 0
alter VD_B4 = 0
alter VD_B5 = 0
alter VD_B6 = 0
alter VD_B7 = 0
alter VD_B8 = 0
alter VD_B9 = 0
alter VD_B10 = 0
alter VD_B11 = 0
let sar12_code = 0
stop when time ge 7.4349999999e-05
resume
let sar12_k = length(time)-1
if abs(time[sar12_k] - 7.435e-05) > 1e-12
print time[sar12_k]
echo expected_pause_time_s 7.435e-05
echo SAR12_PAUSE_FAILED
quit 1
end
print time[sar12_k] >> pause-times.txt
delete all
alter VD_SAMPLE = 0
stop when time ge 7.4399999999e-05
resume
let sar12_k = length(time)-1
if abs(time[sar12_k] - 7.44e-05) > 1e-12
print time[sar12_k]
echo expected_pause_time_s 7.44e-05
echo SAR12_PAUSE_FAILED
quit 1
end
print time[sar12_k] >> pause-times.txt
delete all
alter VD_EVAL = 0
let sar12_trial = sar12_code + 2048
let sar12_drive = (floor(sar12_trial / 1) - 2*floor(sar12_trial / 2))*1.8
alter VD_B0 = $&sar12_drive
let sar12_drive = (floor(sar12_trial / 2) - 2*floor(sar12_trial / 4))*1.8
alter VD_B1 = $&sar12_drive
let sar12_drive = (floor(sar12_trial / 4) - 2*floor(sar12_trial / 8))*1.8
alter VD_B2 = $&sar12_drive
let sar12_drive = (floor(sar12_trial / 8) - 2*floor(sar12_trial / 16))*1.8
alter VD_B3 = $&sar12_drive
let sar12_drive = (floor(sar12_trial / 16) - 2*floor(sar12_trial / 32))*1.8
alter VD_B4 = $&sar12_drive
let sar12_drive = (floor(sar12_trial / 32) - 2*floor(sar12_trial / 64))*1.8
alter VD_B5 = $&sar12_drive
let sar12_drive = (floor(sar12_trial / 64) - 2*floor(sar12_trial / 128))*1.8
alter VD_B6 = $&sar12_drive
let sar12_drive = (floor(sar12_trial / 128) - 2*floor(sar12_trial / 256))*1.8
alter VD_B7 = $&sar12_drive
let sar12_drive = (floor(sar12_trial / 256) - 2*floor(sar12_trial / 512))*1.8
alter VD_B8 = $&sar12_drive
let sar12_drive = (floor(sar12_trial / 512) - 2*floor(sar12_trial / 1024))*1.8
alter VD_B9 = $&sar12_drive
let sar12_drive = (floor(sar12_trial / 1024) - 2*floor(sar12_trial / 2048))*1.8
alter VD_B10 = $&sar12_drive
let sar12_drive = (floor(sar12_trial / 2048) - 2*floor(sar12_trial / 4096))*1.8
alter VD_B11 = $&sar12_drive
stop when time ge 7.4724999999e-05
resume
let sar12_k = length(time)-1
if abs(time[sar12_k] - 7.4725e-05) > 1e-12
print time[sar12_k]
echo expected_pause_time_s 7.4725e-05
echo SAR12_PAUSE_FAILED
quit 1
end
print time[sar12_k] >> pause-times.txt
delete all
alter VD_EVAL = 1.8
stop when time ge 7.4899999999e-05
resume
let sar12_k = length(time)-1
if abs(time[sar12_k] - 7.49e-05) > 1e-12
print time[sar12_k]
echo expected_pause_time_s 7.49e-05
echo SAR12_PAUSE_FAILED
quit 1
end
print time[sar12_k] >> pause-times.txt
delete all
let sar12_k = length(time)-1
let sar12_cmp = v(COMP)[sar12_k]
let sar12_cmpn = v(COMPN)[sar12_k]
let sar12_p = v(TOPP)[sar12_k]
let sar12_n = v(TOPN)[sar12_k]
let sar12_decision = 0
if sar12_cmp >= 0.9
let sar12_code = sar12_trial
let sar12_decision = 1
end
echo 7 11 $&sar12_trial $&sar12_cmp $&sar12_cmpn $&sar12_p $&sar12_n -0.60029296875 $&sar12_decision >> decisions.csv
alter VD_EVAL = 0
let sar12_trial = sar12_code + 1024
let sar12_drive = (floor(sar12_trial / 1) - 2*floor(sar12_trial / 2))*1.8
alter VD_B0 = $&sar12_drive
let sar12_drive = (floor(sar12_trial / 2) - 2*floor(sar12_trial / 4))*1.8
alter VD_B1 = $&sar12_drive
let sar12_drive = (floor(sar12_trial / 4) - 2*floor(sar12_trial / 8))*1.8
alter VD_B2 = $&sar12_drive
let sar12_drive = (floor(sar12_trial / 8) - 2*floor(sar12_trial / 16))*1.8
alter VD_B3 = $&sar12_drive
let sar12_drive = (floor(sar12_trial / 16) - 2*floor(sar12_trial / 32))*1.8
alter VD_B4 = $&sar12_drive
let sar12_drive = (floor(sar12_trial / 32) - 2*floor(sar12_trial / 64))*1.8
alter VD_B5 = $&sar12_drive
let sar12_drive = (floor(sar12_trial / 64) - 2*floor(sar12_trial / 128))*1.8
alter VD_B6 = $&sar12_drive
let sar12_drive = (floor(sar12_trial / 128) - 2*floor(sar12_trial / 256))*1.8
alter VD_B7 = $&sar12_drive
let sar12_drive = (floor(sar12_trial / 256) - 2*floor(sar12_trial / 512))*1.8
alter VD_B8 = $&sar12_drive
let sar12_drive = (floor(sar12_trial / 512) - 2*floor(sar12_trial / 1024))*1.8
alter VD_B9 = $&sar12_drive
let sar12_drive = (floor(sar12_trial / 1024) - 2*floor(sar12_trial / 2048))*1.8
alter VD_B10 = $&sar12_drive
let sar12_drive = (floor(sar12_trial / 2048) - 2*floor(sar12_trial / 4096))*1.8
alter VD_B11 = $&sar12_drive
stop when time ge 7.5224999999e-05
resume
let sar12_k = length(time)-1
if abs(time[sar12_k] - 7.5225e-05) > 1e-12
print time[sar12_k]
echo expected_pause_time_s 7.5225e-05
echo SAR12_PAUSE_FAILED
quit 1
end
print time[sar12_k] >> pause-times.txt
delete all
alter VD_EVAL = 1.8
stop when time ge 7.5399999999e-05
resume
let sar12_k = length(time)-1
if abs(time[sar12_k] - 7.54e-05) > 1e-12
print time[sar12_k]
echo expected_pause_time_s 7.54e-05
echo SAR12_PAUSE_FAILED
quit 1
end
print time[sar12_k] >> pause-times.txt
delete all
let sar12_k = length(time)-1
let sar12_cmp = v(COMP)[sar12_k]
let sar12_cmpn = v(COMPN)[sar12_k]
let sar12_p = v(TOPP)[sar12_k]
let sar12_n = v(TOPN)[sar12_k]
let sar12_decision = 0
if sar12_cmp >= 0.9
let sar12_code = sar12_trial
let sar12_decision = 1
end
echo 7 10 $&sar12_trial $&sar12_cmp $&sar12_cmpn $&sar12_p $&sar12_n -0.60029296875 $&sar12_decision >> decisions.csv
alter VD_EVAL = 0
let sar12_trial = sar12_code + 512
let sar12_drive = (floor(sar12_trial / 1) - 2*floor(sar12_trial / 2))*1.8
alter VD_B0 = $&sar12_drive
let sar12_drive = (floor(sar12_trial / 2) - 2*floor(sar12_trial / 4))*1.8
alter VD_B1 = $&sar12_drive
let sar12_drive = (floor(sar12_trial / 4) - 2*floor(sar12_trial / 8))*1.8
alter VD_B2 = $&sar12_drive
let sar12_drive = (floor(sar12_trial / 8) - 2*floor(sar12_trial / 16))*1.8
alter VD_B3 = $&sar12_drive
let sar12_drive = (floor(sar12_trial / 16) - 2*floor(sar12_trial / 32))*1.8
alter VD_B4 = $&sar12_drive
let sar12_drive = (floor(sar12_trial / 32) - 2*floor(sar12_trial / 64))*1.8
alter VD_B5 = $&sar12_drive
let sar12_drive = (floor(sar12_trial / 64) - 2*floor(sar12_trial / 128))*1.8
alter VD_B6 = $&sar12_drive
let sar12_drive = (floor(sar12_trial / 128) - 2*floor(sar12_trial / 256))*1.8
alter VD_B7 = $&sar12_drive
let sar12_drive = (floor(sar12_trial / 256) - 2*floor(sar12_trial / 512))*1.8
alter VD_B8 = $&sar12_drive
let sar12_drive = (floor(sar12_trial / 512) - 2*floor(sar12_trial / 1024))*1.8
alter VD_B9 = $&sar12_drive
let sar12_drive = (floor(sar12_trial / 1024) - 2*floor(sar12_trial / 2048))*1.8
alter VD_B10 = $&sar12_drive
let sar12_drive = (floor(sar12_trial / 2048) - 2*floor(sar12_trial / 4096))*1.8
alter VD_B11 = $&sar12_drive
stop when time ge 7.5724999999e-05
resume
let sar12_k = length(time)-1
if abs(time[sar12_k] - 7.5725e-05) > 1e-12
print time[sar12_k]
echo expected_pause_time_s 7.5725e-05
echo SAR12_PAUSE_FAILED
quit 1
end
print time[sar12_k] >> pause-times.txt
delete all
alter VD_EVAL = 1.8
stop when time ge 7.5899999999e-05
resume
let sar12_k = length(time)-1
if abs(time[sar12_k] - 7.59e-05) > 1e-12
print time[sar12_k]
echo expected_pause_time_s 7.59e-05
echo SAR12_PAUSE_FAILED
quit 1
end
print time[sar12_k] >> pause-times.txt
delete all
let sar12_k = length(time)-1
let sar12_cmp = v(COMP)[sar12_k]
let sar12_cmpn = v(COMPN)[sar12_k]
let sar12_p = v(TOPP)[sar12_k]
let sar12_n = v(TOPN)[sar12_k]
let sar12_decision = 0
if sar12_cmp >= 0.9
let sar12_code = sar12_trial
let sar12_decision = 1
end
echo 7 9 $&sar12_trial $&sar12_cmp $&sar12_cmpn $&sar12_p $&sar12_n -0.60029296875 $&sar12_decision >> decisions.csv
alter VD_EVAL = 0
let sar12_trial = sar12_code + 256
let sar12_drive = (floor(sar12_trial / 1) - 2*floor(sar12_trial / 2))*1.8
alter VD_B0 = $&sar12_drive
let sar12_drive = (floor(sar12_trial / 2) - 2*floor(sar12_trial / 4))*1.8
alter VD_B1 = $&sar12_drive
let sar12_drive = (floor(sar12_trial / 4) - 2*floor(sar12_trial / 8))*1.8
alter VD_B2 = $&sar12_drive
let sar12_drive = (floor(sar12_trial / 8) - 2*floor(sar12_trial / 16))*1.8
alter VD_B3 = $&sar12_drive
let sar12_drive = (floor(sar12_trial / 16) - 2*floor(sar12_trial / 32))*1.8
alter VD_B4 = $&sar12_drive
let sar12_drive = (floor(sar12_trial / 32) - 2*floor(sar12_trial / 64))*1.8
alter VD_B5 = $&sar12_drive
let sar12_drive = (floor(sar12_trial / 64) - 2*floor(sar12_trial / 128))*1.8
alter VD_B6 = $&sar12_drive
let sar12_drive = (floor(sar12_trial / 128) - 2*floor(sar12_trial / 256))*1.8
alter VD_B7 = $&sar12_drive
let sar12_drive = (floor(sar12_trial / 256) - 2*floor(sar12_trial / 512))*1.8
alter VD_B8 = $&sar12_drive
let sar12_drive = (floor(sar12_trial / 512) - 2*floor(sar12_trial / 1024))*1.8
alter VD_B9 = $&sar12_drive
let sar12_drive = (floor(sar12_trial / 1024) - 2*floor(sar12_trial / 2048))*1.8
alter VD_B10 = $&sar12_drive
let sar12_drive = (floor(sar12_trial / 2048) - 2*floor(sar12_trial / 4096))*1.8
alter VD_B11 = $&sar12_drive
stop when time ge 7.6224999999e-05
resume
let sar12_k = length(time)-1
if abs(time[sar12_k] - 7.6225e-05) > 1e-12
print time[sar12_k]
echo expected_pause_time_s 7.6225e-05
echo SAR12_PAUSE_FAILED
quit 1
end
print time[sar12_k] >> pause-times.txt
delete all
alter VD_EVAL = 1.8
stop when time ge 7.6399999999e-05
resume
let sar12_k = length(time)-1
if abs(time[sar12_k] - 7.64e-05) > 1e-12
print time[sar12_k]
echo expected_pause_time_s 7.64e-05
echo SAR12_PAUSE_FAILED
quit 1
end
print time[sar12_k] >> pause-times.txt
delete all
let sar12_k = length(time)-1
let sar12_cmp = v(COMP)[sar12_k]
let sar12_cmpn = v(COMPN)[sar12_k]
let sar12_p = v(TOPP)[sar12_k]
let sar12_n = v(TOPN)[sar12_k]
let sar12_decision = 0
if sar12_cmp >= 0.9
let sar12_code = sar12_trial
let sar12_decision = 1
end
echo 7 8 $&sar12_trial $&sar12_cmp $&sar12_cmpn $&sar12_p $&sar12_n -0.60029296875 $&sar12_decision >> decisions.csv
alter VD_EVAL = 0
let sar12_trial = sar12_code + 128
let sar12_drive = (floor(sar12_trial / 1) - 2*floor(sar12_trial / 2))*1.8
alter VD_B0 = $&sar12_drive
let sar12_drive = (floor(sar12_trial / 2) - 2*floor(sar12_trial / 4))*1.8
alter VD_B1 = $&sar12_drive
let sar12_drive = (floor(sar12_trial / 4) - 2*floor(sar12_trial / 8))*1.8
alter VD_B2 = $&sar12_drive
let sar12_drive = (floor(sar12_trial / 8) - 2*floor(sar12_trial / 16))*1.8
alter VD_B3 = $&sar12_drive
let sar12_drive = (floor(sar12_trial / 16) - 2*floor(sar12_trial / 32))*1.8
alter VD_B4 = $&sar12_drive
let sar12_drive = (floor(sar12_trial / 32) - 2*floor(sar12_trial / 64))*1.8
alter VD_B5 = $&sar12_drive
let sar12_drive = (floor(sar12_trial / 64) - 2*floor(sar12_trial / 128))*1.8
alter VD_B6 = $&sar12_drive
let sar12_drive = (floor(sar12_trial / 128) - 2*floor(sar12_trial / 256))*1.8
alter VD_B7 = $&sar12_drive
let sar12_drive = (floor(sar12_trial / 256) - 2*floor(sar12_trial / 512))*1.8
alter VD_B8 = $&sar12_drive
let sar12_drive = (floor(sar12_trial / 512) - 2*floor(sar12_trial / 1024))*1.8
alter VD_B9 = $&sar12_drive
let sar12_drive = (floor(sar12_trial / 1024) - 2*floor(sar12_trial / 2048))*1.8
alter VD_B10 = $&sar12_drive
let sar12_drive = (floor(sar12_trial / 2048) - 2*floor(sar12_trial / 4096))*1.8
alter VD_B11 = $&sar12_drive
stop when time ge 7.6724999999e-05
resume
let sar12_k = length(time)-1
if abs(time[sar12_k] - 7.6725e-05) > 1e-12
print time[sar12_k]
echo expected_pause_time_s 7.6725e-05
echo SAR12_PAUSE_FAILED
quit 1
end
print time[sar12_k] >> pause-times.txt
delete all
alter VD_EVAL = 1.8
stop when time ge 7.6899999999e-05
resume
let sar12_k = length(time)-1
if abs(time[sar12_k] - 7.69e-05) > 1e-12
print time[sar12_k]
echo expected_pause_time_s 7.69e-05
echo SAR12_PAUSE_FAILED
quit 1
end
print time[sar12_k] >> pause-times.txt
delete all
let sar12_k = length(time)-1
let sar12_cmp = v(COMP)[sar12_k]
let sar12_cmpn = v(COMPN)[sar12_k]
let sar12_p = v(TOPP)[sar12_k]
let sar12_n = v(TOPN)[sar12_k]
let sar12_decision = 0
if sar12_cmp >= 0.9
let sar12_code = sar12_trial
let sar12_decision = 1
end
echo 7 7 $&sar12_trial $&sar12_cmp $&sar12_cmpn $&sar12_p $&sar12_n -0.60029296875 $&sar12_decision >> decisions.csv
alter VD_EVAL = 0
let sar12_trial = sar12_code + 64
let sar12_drive = (floor(sar12_trial / 1) - 2*floor(sar12_trial / 2))*1.8
alter VD_B0 = $&sar12_drive
let sar12_drive = (floor(sar12_trial / 2) - 2*floor(sar12_trial / 4))*1.8
alter VD_B1 = $&sar12_drive
let sar12_drive = (floor(sar12_trial / 4) - 2*floor(sar12_trial / 8))*1.8
alter VD_B2 = $&sar12_drive
let sar12_drive = (floor(sar12_trial / 8) - 2*floor(sar12_trial / 16))*1.8
alter VD_B3 = $&sar12_drive
let sar12_drive = (floor(sar12_trial / 16) - 2*floor(sar12_trial / 32))*1.8
alter VD_B4 = $&sar12_drive
let sar12_drive = (floor(sar12_trial / 32) - 2*floor(sar12_trial / 64))*1.8
alter VD_B5 = $&sar12_drive
let sar12_drive = (floor(sar12_trial / 64) - 2*floor(sar12_trial / 128))*1.8
alter VD_B6 = $&sar12_drive
let sar12_drive = (floor(sar12_trial / 128) - 2*floor(sar12_trial / 256))*1.8
alter VD_B7 = $&sar12_drive
let sar12_drive = (floor(sar12_trial / 256) - 2*floor(sar12_trial / 512))*1.8
alter VD_B8 = $&sar12_drive
let sar12_drive = (floor(sar12_trial / 512) - 2*floor(sar12_trial / 1024))*1.8
alter VD_B9 = $&sar12_drive
let sar12_drive = (floor(sar12_trial / 1024) - 2*floor(sar12_trial / 2048))*1.8
alter VD_B10 = $&sar12_drive
let sar12_drive = (floor(sar12_trial / 2048) - 2*floor(sar12_trial / 4096))*1.8
alter VD_B11 = $&sar12_drive
stop when time ge 7.7224999999e-05
resume
let sar12_k = length(time)-1
if abs(time[sar12_k] - 7.7225e-05) > 1e-12
print time[sar12_k]
echo expected_pause_time_s 7.7225e-05
echo SAR12_PAUSE_FAILED
quit 1
end
print time[sar12_k] >> pause-times.txt
delete all
alter VD_EVAL = 1.8
stop when time ge 7.7399999999e-05
resume
let sar12_k = length(time)-1
if abs(time[sar12_k] - 7.74e-05) > 1e-12
print time[sar12_k]
echo expected_pause_time_s 7.74e-05
echo SAR12_PAUSE_FAILED
quit 1
end
print time[sar12_k] >> pause-times.txt
delete all
let sar12_k = length(time)-1
let sar12_cmp = v(COMP)[sar12_k]
let sar12_cmpn = v(COMPN)[sar12_k]
let sar12_p = v(TOPP)[sar12_k]
let sar12_n = v(TOPN)[sar12_k]
let sar12_decision = 0
if sar12_cmp >= 0.9
let sar12_code = sar12_trial
let sar12_decision = 1
end
echo 7 6 $&sar12_trial $&sar12_cmp $&sar12_cmpn $&sar12_p $&sar12_n -0.60029296875 $&sar12_decision >> decisions.csv
alter VD_EVAL = 0
let sar12_trial = sar12_code + 32
let sar12_drive = (floor(sar12_trial / 1) - 2*floor(sar12_trial / 2))*1.8
alter VD_B0 = $&sar12_drive
let sar12_drive = (floor(sar12_trial / 2) - 2*floor(sar12_trial / 4))*1.8
alter VD_B1 = $&sar12_drive
let sar12_drive = (floor(sar12_trial / 4) - 2*floor(sar12_trial / 8))*1.8
alter VD_B2 = $&sar12_drive
let sar12_drive = (floor(sar12_trial / 8) - 2*floor(sar12_trial / 16))*1.8
alter VD_B3 = $&sar12_drive
let sar12_drive = (floor(sar12_trial / 16) - 2*floor(sar12_trial / 32))*1.8
alter VD_B4 = $&sar12_drive
let sar12_drive = (floor(sar12_trial / 32) - 2*floor(sar12_trial / 64))*1.8
alter VD_B5 = $&sar12_drive
let sar12_drive = (floor(sar12_trial / 64) - 2*floor(sar12_trial / 128))*1.8
alter VD_B6 = $&sar12_drive
let sar12_drive = (floor(sar12_trial / 128) - 2*floor(sar12_trial / 256))*1.8
alter VD_B7 = $&sar12_drive
let sar12_drive = (floor(sar12_trial / 256) - 2*floor(sar12_trial / 512))*1.8
alter VD_B8 = $&sar12_drive
let sar12_drive = (floor(sar12_trial / 512) - 2*floor(sar12_trial / 1024))*1.8
alter VD_B9 = $&sar12_drive
let sar12_drive = (floor(sar12_trial / 1024) - 2*floor(sar12_trial / 2048))*1.8
alter VD_B10 = $&sar12_drive
let sar12_drive = (floor(sar12_trial / 2048) - 2*floor(sar12_trial / 4096))*1.8
alter VD_B11 = $&sar12_drive
stop when time ge 7.7724999999e-05
resume
let sar12_k = length(time)-1
if abs(time[sar12_k] - 7.7725e-05) > 1e-12
print time[sar12_k]
echo expected_pause_time_s 7.7725e-05
echo SAR12_PAUSE_FAILED
quit 1
end
print time[sar12_k] >> pause-times.txt
delete all
alter VD_EVAL = 1.8
stop when time ge 7.7899999999e-05
resume
let sar12_k = length(time)-1
if abs(time[sar12_k] - 7.79e-05) > 1e-12
print time[sar12_k]
echo expected_pause_time_s 7.79e-05
echo SAR12_PAUSE_FAILED
quit 1
end
print time[sar12_k] >> pause-times.txt
delete all
let sar12_k = length(time)-1
let sar12_cmp = v(COMP)[sar12_k]
let sar12_cmpn = v(COMPN)[sar12_k]
let sar12_p = v(TOPP)[sar12_k]
let sar12_n = v(TOPN)[sar12_k]
let sar12_decision = 0
if sar12_cmp >= 0.9
let sar12_code = sar12_trial
let sar12_decision = 1
end
echo 7 5 $&sar12_trial $&sar12_cmp $&sar12_cmpn $&sar12_p $&sar12_n -0.60029296875 $&sar12_decision >> decisions.csv
alter VD_EVAL = 0
let sar12_trial = sar12_code + 16
let sar12_drive = (floor(sar12_trial / 1) - 2*floor(sar12_trial / 2))*1.8
alter VD_B0 = $&sar12_drive
let sar12_drive = (floor(sar12_trial / 2) - 2*floor(sar12_trial / 4))*1.8
alter VD_B1 = $&sar12_drive
let sar12_drive = (floor(sar12_trial / 4) - 2*floor(sar12_trial / 8))*1.8
alter VD_B2 = $&sar12_drive
let sar12_drive = (floor(sar12_trial / 8) - 2*floor(sar12_trial / 16))*1.8
alter VD_B3 = $&sar12_drive
let sar12_drive = (floor(sar12_trial / 16) - 2*floor(sar12_trial / 32))*1.8
alter VD_B4 = $&sar12_drive
let sar12_drive = (floor(sar12_trial / 32) - 2*floor(sar12_trial / 64))*1.8
alter VD_B5 = $&sar12_drive
let sar12_drive = (floor(sar12_trial / 64) - 2*floor(sar12_trial / 128))*1.8
alter VD_B6 = $&sar12_drive
let sar12_drive = (floor(sar12_trial / 128) - 2*floor(sar12_trial / 256))*1.8
alter VD_B7 = $&sar12_drive
let sar12_drive = (floor(sar12_trial / 256) - 2*floor(sar12_trial / 512))*1.8
alter VD_B8 = $&sar12_drive
let sar12_drive = (floor(sar12_trial / 512) - 2*floor(sar12_trial / 1024))*1.8
alter VD_B9 = $&sar12_drive
let sar12_drive = (floor(sar12_trial / 1024) - 2*floor(sar12_trial / 2048))*1.8
alter VD_B10 = $&sar12_drive
let sar12_drive = (floor(sar12_trial / 2048) - 2*floor(sar12_trial / 4096))*1.8
alter VD_B11 = $&sar12_drive
stop when time ge 7.8224999999e-05
resume
let sar12_k = length(time)-1
if abs(time[sar12_k] - 7.8225e-05) > 1e-12
print time[sar12_k]
echo expected_pause_time_s 7.8225e-05
echo SAR12_PAUSE_FAILED
quit 1
end
print time[sar12_k] >> pause-times.txt
delete all
alter VD_EVAL = 1.8
stop when time ge 7.8399999999e-05
resume
let sar12_k = length(time)-1
if abs(time[sar12_k] - 7.84e-05) > 1e-12
print time[sar12_k]
echo expected_pause_time_s 7.84e-05
echo SAR12_PAUSE_FAILED
quit 1
end
print time[sar12_k] >> pause-times.txt
delete all
let sar12_k = length(time)-1
let sar12_cmp = v(COMP)[sar12_k]
let sar12_cmpn = v(COMPN)[sar12_k]
let sar12_p = v(TOPP)[sar12_k]
let sar12_n = v(TOPN)[sar12_k]
let sar12_decision = 0
if sar12_cmp >= 0.9
let sar12_code = sar12_trial
let sar12_decision = 1
end
echo 7 4 $&sar12_trial $&sar12_cmp $&sar12_cmpn $&sar12_p $&sar12_n -0.60029296875 $&sar12_decision >> decisions.csv
alter VD_EVAL = 0
let sar12_trial = sar12_code + 8
let sar12_drive = (floor(sar12_trial / 1) - 2*floor(sar12_trial / 2))*1.8
alter VD_B0 = $&sar12_drive
let sar12_drive = (floor(sar12_trial / 2) - 2*floor(sar12_trial / 4))*1.8
alter VD_B1 = $&sar12_drive
let sar12_drive = (floor(sar12_trial / 4) - 2*floor(sar12_trial / 8))*1.8
alter VD_B2 = $&sar12_drive
let sar12_drive = (floor(sar12_trial / 8) - 2*floor(sar12_trial / 16))*1.8
alter VD_B3 = $&sar12_drive
let sar12_drive = (floor(sar12_trial / 16) - 2*floor(sar12_trial / 32))*1.8
alter VD_B4 = $&sar12_drive
let sar12_drive = (floor(sar12_trial / 32) - 2*floor(sar12_trial / 64))*1.8
alter VD_B5 = $&sar12_drive
let sar12_drive = (floor(sar12_trial / 64) - 2*floor(sar12_trial / 128))*1.8
alter VD_B6 = $&sar12_drive
let sar12_drive = (floor(sar12_trial / 128) - 2*floor(sar12_trial / 256))*1.8
alter VD_B7 = $&sar12_drive
let sar12_drive = (floor(sar12_trial / 256) - 2*floor(sar12_trial / 512))*1.8
alter VD_B8 = $&sar12_drive
let sar12_drive = (floor(sar12_trial / 512) - 2*floor(sar12_trial / 1024))*1.8
alter VD_B9 = $&sar12_drive
let sar12_drive = (floor(sar12_trial / 1024) - 2*floor(sar12_trial / 2048))*1.8
alter VD_B10 = $&sar12_drive
let sar12_drive = (floor(sar12_trial / 2048) - 2*floor(sar12_trial / 4096))*1.8
alter VD_B11 = $&sar12_drive
stop when time ge 7.8724999999e-05
resume
let sar12_k = length(time)-1
if abs(time[sar12_k] - 7.8725e-05) > 1e-12
print time[sar12_k]
echo expected_pause_time_s 7.8725e-05
echo SAR12_PAUSE_FAILED
quit 1
end
print time[sar12_k] >> pause-times.txt
delete all
alter VD_EVAL = 1.8
stop when time ge 7.8899999999e-05
resume
let sar12_k = length(time)-1
if abs(time[sar12_k] - 7.89e-05) > 1e-12
print time[sar12_k]
echo expected_pause_time_s 7.89e-05
echo SAR12_PAUSE_FAILED
quit 1
end
print time[sar12_k] >> pause-times.txt
delete all
let sar12_k = length(time)-1
let sar12_cmp = v(COMP)[sar12_k]
let sar12_cmpn = v(COMPN)[sar12_k]
let sar12_p = v(TOPP)[sar12_k]
let sar12_n = v(TOPN)[sar12_k]
let sar12_decision = 0
if sar12_cmp >= 0.9
let sar12_code = sar12_trial
let sar12_decision = 1
end
echo 7 3 $&sar12_trial $&sar12_cmp $&sar12_cmpn $&sar12_p $&sar12_n -0.60029296875 $&sar12_decision >> decisions.csv
alter VD_EVAL = 0
let sar12_trial = sar12_code + 4
let sar12_drive = (floor(sar12_trial / 1) - 2*floor(sar12_trial / 2))*1.8
alter VD_B0 = $&sar12_drive
let sar12_drive = (floor(sar12_trial / 2) - 2*floor(sar12_trial / 4))*1.8
alter VD_B1 = $&sar12_drive
let sar12_drive = (floor(sar12_trial / 4) - 2*floor(sar12_trial / 8))*1.8
alter VD_B2 = $&sar12_drive
let sar12_drive = (floor(sar12_trial / 8) - 2*floor(sar12_trial / 16))*1.8
alter VD_B3 = $&sar12_drive
let sar12_drive = (floor(sar12_trial / 16) - 2*floor(sar12_trial / 32))*1.8
alter VD_B4 = $&sar12_drive
let sar12_drive = (floor(sar12_trial / 32) - 2*floor(sar12_trial / 64))*1.8
alter VD_B5 = $&sar12_drive
let sar12_drive = (floor(sar12_trial / 64) - 2*floor(sar12_trial / 128))*1.8
alter VD_B6 = $&sar12_drive
let sar12_drive = (floor(sar12_trial / 128) - 2*floor(sar12_trial / 256))*1.8
alter VD_B7 = $&sar12_drive
let sar12_drive = (floor(sar12_trial / 256) - 2*floor(sar12_trial / 512))*1.8
alter VD_B8 = $&sar12_drive
let sar12_drive = (floor(sar12_trial / 512) - 2*floor(sar12_trial / 1024))*1.8
alter VD_B9 = $&sar12_drive
let sar12_drive = (floor(sar12_trial / 1024) - 2*floor(sar12_trial / 2048))*1.8
alter VD_B10 = $&sar12_drive
let sar12_drive = (floor(sar12_trial / 2048) - 2*floor(sar12_trial / 4096))*1.8
alter VD_B11 = $&sar12_drive
stop when time ge 7.9224999999e-05
resume
let sar12_k = length(time)-1
if abs(time[sar12_k] - 7.9225e-05) > 1e-12
print time[sar12_k]
echo expected_pause_time_s 7.9225e-05
echo SAR12_PAUSE_FAILED
quit 1
end
print time[sar12_k] >> pause-times.txt
delete all
alter VD_EVAL = 1.8
stop when time ge 7.9399999999e-05
resume
let sar12_k = length(time)-1
if abs(time[sar12_k] - 7.94e-05) > 1e-12
print time[sar12_k]
echo expected_pause_time_s 7.94e-05
echo SAR12_PAUSE_FAILED
quit 1
end
print time[sar12_k] >> pause-times.txt
delete all
let sar12_k = length(time)-1
let sar12_cmp = v(COMP)[sar12_k]
let sar12_cmpn = v(COMPN)[sar12_k]
let sar12_p = v(TOPP)[sar12_k]
let sar12_n = v(TOPN)[sar12_k]
let sar12_decision = 0
if sar12_cmp >= 0.9
let sar12_code = sar12_trial
let sar12_decision = 1
end
echo 7 2 $&sar12_trial $&sar12_cmp $&sar12_cmpn $&sar12_p $&sar12_n -0.60029296875 $&sar12_decision >> decisions.csv
alter VD_EVAL = 0
let sar12_trial = sar12_code + 2
let sar12_drive = (floor(sar12_trial / 1) - 2*floor(sar12_trial / 2))*1.8
alter VD_B0 = $&sar12_drive
let sar12_drive = (floor(sar12_trial / 2) - 2*floor(sar12_trial / 4))*1.8
alter VD_B1 = $&sar12_drive
let sar12_drive = (floor(sar12_trial / 4) - 2*floor(sar12_trial / 8))*1.8
alter VD_B2 = $&sar12_drive
let sar12_drive = (floor(sar12_trial / 8) - 2*floor(sar12_trial / 16))*1.8
alter VD_B3 = $&sar12_drive
let sar12_drive = (floor(sar12_trial / 16) - 2*floor(sar12_trial / 32))*1.8
alter VD_B4 = $&sar12_drive
let sar12_drive = (floor(sar12_trial / 32) - 2*floor(sar12_trial / 64))*1.8
alter VD_B5 = $&sar12_drive
let sar12_drive = (floor(sar12_trial / 64) - 2*floor(sar12_trial / 128))*1.8
alter VD_B6 = $&sar12_drive
let sar12_drive = (floor(sar12_trial / 128) - 2*floor(sar12_trial / 256))*1.8
alter VD_B7 = $&sar12_drive
let sar12_drive = (floor(sar12_trial / 256) - 2*floor(sar12_trial / 512))*1.8
alter VD_B8 = $&sar12_drive
let sar12_drive = (floor(sar12_trial / 512) - 2*floor(sar12_trial / 1024))*1.8
alter VD_B9 = $&sar12_drive
let sar12_drive = (floor(sar12_trial / 1024) - 2*floor(sar12_trial / 2048))*1.8
alter VD_B10 = $&sar12_drive
let sar12_drive = (floor(sar12_trial / 2048) - 2*floor(sar12_trial / 4096))*1.8
alter VD_B11 = $&sar12_drive
stop when time ge 7.9724999999e-05
resume
let sar12_k = length(time)-1
if abs(time[sar12_k] - 7.9725e-05) > 1e-12
print time[sar12_k]
echo expected_pause_time_s 7.9725e-05
echo SAR12_PAUSE_FAILED
quit 1
end
print time[sar12_k] >> pause-times.txt
delete all
alter VD_EVAL = 1.8
stop when time ge 7.9899999999e-05
resume
let sar12_k = length(time)-1
if abs(time[sar12_k] - 7.99e-05) > 1e-12
print time[sar12_k]
echo expected_pause_time_s 7.99e-05
echo SAR12_PAUSE_FAILED
quit 1
end
print time[sar12_k] >> pause-times.txt
delete all
let sar12_k = length(time)-1
let sar12_cmp = v(COMP)[sar12_k]
let sar12_cmpn = v(COMPN)[sar12_k]
let sar12_p = v(TOPP)[sar12_k]
let sar12_n = v(TOPN)[sar12_k]
let sar12_decision = 0
if sar12_cmp >= 0.9
let sar12_code = sar12_trial
let sar12_decision = 1
end
echo 7 1 $&sar12_trial $&sar12_cmp $&sar12_cmpn $&sar12_p $&sar12_n -0.60029296875 $&sar12_decision >> decisions.csv
alter VD_EVAL = 0
let sar12_trial = sar12_code + 1
let sar12_drive = (floor(sar12_trial / 1) - 2*floor(sar12_trial / 2))*1.8
alter VD_B0 = $&sar12_drive
let sar12_drive = (floor(sar12_trial / 2) - 2*floor(sar12_trial / 4))*1.8
alter VD_B1 = $&sar12_drive
let sar12_drive = (floor(sar12_trial / 4) - 2*floor(sar12_trial / 8))*1.8
alter VD_B2 = $&sar12_drive
let sar12_drive = (floor(sar12_trial / 8) - 2*floor(sar12_trial / 16))*1.8
alter VD_B3 = $&sar12_drive
let sar12_drive = (floor(sar12_trial / 16) - 2*floor(sar12_trial / 32))*1.8
alter VD_B4 = $&sar12_drive
let sar12_drive = (floor(sar12_trial / 32) - 2*floor(sar12_trial / 64))*1.8
alter VD_B5 = $&sar12_drive
let sar12_drive = (floor(sar12_trial / 64) - 2*floor(sar12_trial / 128))*1.8
alter VD_B6 = $&sar12_drive
let sar12_drive = (floor(sar12_trial / 128) - 2*floor(sar12_trial / 256))*1.8
alter VD_B7 = $&sar12_drive
let sar12_drive = (floor(sar12_trial / 256) - 2*floor(sar12_trial / 512))*1.8
alter VD_B8 = $&sar12_drive
let sar12_drive = (floor(sar12_trial / 512) - 2*floor(sar12_trial / 1024))*1.8
alter VD_B9 = $&sar12_drive
let sar12_drive = (floor(sar12_trial / 1024) - 2*floor(sar12_trial / 2048))*1.8
alter VD_B10 = $&sar12_drive
let sar12_drive = (floor(sar12_trial / 2048) - 2*floor(sar12_trial / 4096))*1.8
alter VD_B11 = $&sar12_drive
stop when time ge 8.0224999999e-05
resume
let sar12_k = length(time)-1
if abs(time[sar12_k] - 8.0225e-05) > 1e-12
print time[sar12_k]
echo expected_pause_time_s 8.0225e-05
echo SAR12_PAUSE_FAILED
quit 1
end
print time[sar12_k] >> pause-times.txt
delete all
alter VD_EVAL = 1.8
stop when time ge 8.0399999999e-05
resume
let sar12_k = length(time)-1
if abs(time[sar12_k] - 8.04e-05) > 1e-12
print time[sar12_k]
echo expected_pause_time_s 8.04e-05
echo SAR12_PAUSE_FAILED
quit 1
end
print time[sar12_k] >> pause-times.txt
delete all
let sar12_k = length(time)-1
let sar12_cmp = v(COMP)[sar12_k]
let sar12_cmpn = v(COMPN)[sar12_k]
let sar12_p = v(TOPP)[sar12_k]
let sar12_n = v(TOPN)[sar12_k]
let sar12_decision = 0
if sar12_cmp >= 0.9
let sar12_code = sar12_trial
let sar12_decision = 1
end
echo 7 0 $&sar12_trial $&sar12_cmp $&sar12_cmpn $&sar12_p $&sar12_n -0.60029296875 $&sar12_decision >> decisions.csv
alter VD_EVAL = 0
alter VINP = 0.899853515625
alter VINN = 0.900146484375
alter VD_SAMPLE = 1.8
alter VD_EVAL = 0
alter VD_B0 = 0
alter VD_B1 = 0
alter VD_B2 = 0
alter VD_B3 = 0
alter VD_B4 = 0
alter VD_B5 = 0
alter VD_B6 = 0
alter VD_B7 = 0
alter VD_B8 = 0
alter VD_B9 = 0
alter VD_B10 = 0
alter VD_B11 = 0
let sar12_code = 0
stop when time ge 8.4399999999e-05
resume
let sar12_k = length(time)-1
if abs(time[sar12_k] - 8.44e-05) > 1e-12
print time[sar12_k]
echo expected_pause_time_s 8.44e-05
echo SAR12_PAUSE_FAILED
quit 1
end
print time[sar12_k] >> pause-times.txt
delete all
alter VD_SAMPLE = 0
stop when time ge 8.4449999999e-05
resume
let sar12_k = length(time)-1
if abs(time[sar12_k] - 8.445e-05) > 1e-12
print time[sar12_k]
echo expected_pause_time_s 8.445e-05
echo SAR12_PAUSE_FAILED
quit 1
end
print time[sar12_k] >> pause-times.txt
delete all
alter VD_EVAL = 0
let sar12_trial = sar12_code + 2048
let sar12_drive = (floor(sar12_trial / 1) - 2*floor(sar12_trial / 2))*1.8
alter VD_B0 = $&sar12_drive
let sar12_drive = (floor(sar12_trial / 2) - 2*floor(sar12_trial / 4))*1.8
alter VD_B1 = $&sar12_drive
let sar12_drive = (floor(sar12_trial / 4) - 2*floor(sar12_trial / 8))*1.8
alter VD_B2 = $&sar12_drive
let sar12_drive = (floor(sar12_trial / 8) - 2*floor(sar12_trial / 16))*1.8
alter VD_B3 = $&sar12_drive
let sar12_drive = (floor(sar12_trial / 16) - 2*floor(sar12_trial / 32))*1.8
alter VD_B4 = $&sar12_drive
let sar12_drive = (floor(sar12_trial / 32) - 2*floor(sar12_trial / 64))*1.8
alter VD_B5 = $&sar12_drive
let sar12_drive = (floor(sar12_trial / 64) - 2*floor(sar12_trial / 128))*1.8
alter VD_B6 = $&sar12_drive
let sar12_drive = (floor(sar12_trial / 128) - 2*floor(sar12_trial / 256))*1.8
alter VD_B7 = $&sar12_drive
let sar12_drive = (floor(sar12_trial / 256) - 2*floor(sar12_trial / 512))*1.8
alter VD_B8 = $&sar12_drive
let sar12_drive = (floor(sar12_trial / 512) - 2*floor(sar12_trial / 1024))*1.8
alter VD_B9 = $&sar12_drive
let sar12_drive = (floor(sar12_trial / 1024) - 2*floor(sar12_trial / 2048))*1.8
alter VD_B10 = $&sar12_drive
let sar12_drive = (floor(sar12_trial / 2048) - 2*floor(sar12_trial / 4096))*1.8
alter VD_B11 = $&sar12_drive
stop when time ge 8.4774999999e-05
resume
let sar12_k = length(time)-1
if abs(time[sar12_k] - 8.4775e-05) > 1e-12
print time[sar12_k]
echo expected_pause_time_s 8.4775e-05
echo SAR12_PAUSE_FAILED
quit 1
end
print time[sar12_k] >> pause-times.txt
delete all
alter VD_EVAL = 1.8
stop when time ge 8.4949999999e-05
resume
let sar12_k = length(time)-1
if abs(time[sar12_k] - 8.495e-05) > 1e-12
print time[sar12_k]
echo expected_pause_time_s 8.495e-05
echo SAR12_PAUSE_FAILED
quit 1
end
print time[sar12_k] >> pause-times.txt
delete all
let sar12_k = length(time)-1
let sar12_cmp = v(COMP)[sar12_k]
let sar12_cmpn = v(COMPN)[sar12_k]
let sar12_p = v(TOPP)[sar12_k]
let sar12_n = v(TOPN)[sar12_k]
let sar12_decision = 0
if sar12_cmp >= 0.9
let sar12_code = sar12_trial
let sar12_decision = 1
end
echo 8 11 $&sar12_trial $&sar12_cmp $&sar12_cmpn $&sar12_p $&sar12_n -0.00029296875 $&sar12_decision >> decisions.csv
alter VD_EVAL = 0
let sar12_trial = sar12_code + 1024
let sar12_drive = (floor(sar12_trial / 1) - 2*floor(sar12_trial / 2))*1.8
alter VD_B0 = $&sar12_drive
let sar12_drive = (floor(sar12_trial / 2) - 2*floor(sar12_trial / 4))*1.8
alter VD_B1 = $&sar12_drive
let sar12_drive = (floor(sar12_trial / 4) - 2*floor(sar12_trial / 8))*1.8
alter VD_B2 = $&sar12_drive
let sar12_drive = (floor(sar12_trial / 8) - 2*floor(sar12_trial / 16))*1.8
alter VD_B3 = $&sar12_drive
let sar12_drive = (floor(sar12_trial / 16) - 2*floor(sar12_trial / 32))*1.8
alter VD_B4 = $&sar12_drive
let sar12_drive = (floor(sar12_trial / 32) - 2*floor(sar12_trial / 64))*1.8
alter VD_B5 = $&sar12_drive
let sar12_drive = (floor(sar12_trial / 64) - 2*floor(sar12_trial / 128))*1.8
alter VD_B6 = $&sar12_drive
let sar12_drive = (floor(sar12_trial / 128) - 2*floor(sar12_trial / 256))*1.8
alter VD_B7 = $&sar12_drive
let sar12_drive = (floor(sar12_trial / 256) - 2*floor(sar12_trial / 512))*1.8
alter VD_B8 = $&sar12_drive
let sar12_drive = (floor(sar12_trial / 512) - 2*floor(sar12_trial / 1024))*1.8
alter VD_B9 = $&sar12_drive
let sar12_drive = (floor(sar12_trial / 1024) - 2*floor(sar12_trial / 2048))*1.8
alter VD_B10 = $&sar12_drive
let sar12_drive = (floor(sar12_trial / 2048) - 2*floor(sar12_trial / 4096))*1.8
alter VD_B11 = $&sar12_drive
stop when time ge 8.5274999999e-05
resume
let sar12_k = length(time)-1
if abs(time[sar12_k] - 8.5275e-05) > 1e-12
print time[sar12_k]
echo expected_pause_time_s 8.5275e-05
echo SAR12_PAUSE_FAILED
quit 1
end
print time[sar12_k] >> pause-times.txt
delete all
alter VD_EVAL = 1.8
stop when time ge 8.5449999999e-05
resume
let sar12_k = length(time)-1
if abs(time[sar12_k] - 8.545e-05) > 1e-12
print time[sar12_k]
echo expected_pause_time_s 8.545e-05
echo SAR12_PAUSE_FAILED
quit 1
end
print time[sar12_k] >> pause-times.txt
delete all
let sar12_k = length(time)-1
let sar12_cmp = v(COMP)[sar12_k]
let sar12_cmpn = v(COMPN)[sar12_k]
let sar12_p = v(TOPP)[sar12_k]
let sar12_n = v(TOPN)[sar12_k]
let sar12_decision = 0
if sar12_cmp >= 0.9
let sar12_code = sar12_trial
let sar12_decision = 1
end
echo 8 10 $&sar12_trial $&sar12_cmp $&sar12_cmpn $&sar12_p $&sar12_n -0.00029296875 $&sar12_decision >> decisions.csv
alter VD_EVAL = 0
let sar12_trial = sar12_code + 512
let sar12_drive = (floor(sar12_trial / 1) - 2*floor(sar12_trial / 2))*1.8
alter VD_B0 = $&sar12_drive
let sar12_drive = (floor(sar12_trial / 2) - 2*floor(sar12_trial / 4))*1.8
alter VD_B1 = $&sar12_drive
let sar12_drive = (floor(sar12_trial / 4) - 2*floor(sar12_trial / 8))*1.8
alter VD_B2 = $&sar12_drive
let sar12_drive = (floor(sar12_trial / 8) - 2*floor(sar12_trial / 16))*1.8
alter VD_B3 = $&sar12_drive
let sar12_drive = (floor(sar12_trial / 16) - 2*floor(sar12_trial / 32))*1.8
alter VD_B4 = $&sar12_drive
let sar12_drive = (floor(sar12_trial / 32) - 2*floor(sar12_trial / 64))*1.8
alter VD_B5 = $&sar12_drive
let sar12_drive = (floor(sar12_trial / 64) - 2*floor(sar12_trial / 128))*1.8
alter VD_B6 = $&sar12_drive
let sar12_drive = (floor(sar12_trial / 128) - 2*floor(sar12_trial / 256))*1.8
alter VD_B7 = $&sar12_drive
let sar12_drive = (floor(sar12_trial / 256) - 2*floor(sar12_trial / 512))*1.8
alter VD_B8 = $&sar12_drive
let sar12_drive = (floor(sar12_trial / 512) - 2*floor(sar12_trial / 1024))*1.8
alter VD_B9 = $&sar12_drive
let sar12_drive = (floor(sar12_trial / 1024) - 2*floor(sar12_trial / 2048))*1.8
alter VD_B10 = $&sar12_drive
let sar12_drive = (floor(sar12_trial / 2048) - 2*floor(sar12_trial / 4096))*1.8
alter VD_B11 = $&sar12_drive
stop when time ge 8.5774999999e-05
resume
let sar12_k = length(time)-1
if abs(time[sar12_k] - 8.5775e-05) > 1e-12
print time[sar12_k]
echo expected_pause_time_s 8.5775e-05
echo SAR12_PAUSE_FAILED
quit 1
end
print time[sar12_k] >> pause-times.txt
delete all
alter VD_EVAL = 1.8
stop when time ge 8.5949999999e-05
resume
let sar12_k = length(time)-1
if abs(time[sar12_k] - 8.595e-05) > 1e-12
print time[sar12_k]
echo expected_pause_time_s 8.595e-05
echo SAR12_PAUSE_FAILED
quit 1
end
print time[sar12_k] >> pause-times.txt
delete all
let sar12_k = length(time)-1
let sar12_cmp = v(COMP)[sar12_k]
let sar12_cmpn = v(COMPN)[sar12_k]
let sar12_p = v(TOPP)[sar12_k]
let sar12_n = v(TOPN)[sar12_k]
let sar12_decision = 0
if sar12_cmp >= 0.9
let sar12_code = sar12_trial
let sar12_decision = 1
end
echo 8 9 $&sar12_trial $&sar12_cmp $&sar12_cmpn $&sar12_p $&sar12_n -0.00029296875 $&sar12_decision >> decisions.csv
alter VD_EVAL = 0
let sar12_trial = sar12_code + 256
let sar12_drive = (floor(sar12_trial / 1) - 2*floor(sar12_trial / 2))*1.8
alter VD_B0 = $&sar12_drive
let sar12_drive = (floor(sar12_trial / 2) - 2*floor(sar12_trial / 4))*1.8
alter VD_B1 = $&sar12_drive
let sar12_drive = (floor(sar12_trial / 4) - 2*floor(sar12_trial / 8))*1.8
alter VD_B2 = $&sar12_drive
let sar12_drive = (floor(sar12_trial / 8) - 2*floor(sar12_trial / 16))*1.8
alter VD_B3 = $&sar12_drive
let sar12_drive = (floor(sar12_trial / 16) - 2*floor(sar12_trial / 32))*1.8
alter VD_B4 = $&sar12_drive
let sar12_drive = (floor(sar12_trial / 32) - 2*floor(sar12_trial / 64))*1.8
alter VD_B5 = $&sar12_drive
let sar12_drive = (floor(sar12_trial / 64) - 2*floor(sar12_trial / 128))*1.8
alter VD_B6 = $&sar12_drive
let sar12_drive = (floor(sar12_trial / 128) - 2*floor(sar12_trial / 256))*1.8
alter VD_B7 = $&sar12_drive
let sar12_drive = (floor(sar12_trial / 256) - 2*floor(sar12_trial / 512))*1.8
alter VD_B8 = $&sar12_drive
let sar12_drive = (floor(sar12_trial / 512) - 2*floor(sar12_trial / 1024))*1.8
alter VD_B9 = $&sar12_drive
let sar12_drive = (floor(sar12_trial / 1024) - 2*floor(sar12_trial / 2048))*1.8
alter VD_B10 = $&sar12_drive
let sar12_drive = (floor(sar12_trial / 2048) - 2*floor(sar12_trial / 4096))*1.8
alter VD_B11 = $&sar12_drive
stop when time ge 8.6274999999e-05
resume
let sar12_k = length(time)-1
if abs(time[sar12_k] - 8.6275e-05) > 1e-12
print time[sar12_k]
echo expected_pause_time_s 8.6275e-05
echo SAR12_PAUSE_FAILED
quit 1
end
print time[sar12_k] >> pause-times.txt
delete all
alter VD_EVAL = 1.8
stop when time ge 8.6449999999e-05
resume
let sar12_k = length(time)-1
if abs(time[sar12_k] - 8.645e-05) > 1e-12
print time[sar12_k]
echo expected_pause_time_s 8.645e-05
echo SAR12_PAUSE_FAILED
quit 1
end
print time[sar12_k] >> pause-times.txt
delete all
let sar12_k = length(time)-1
let sar12_cmp = v(COMP)[sar12_k]
let sar12_cmpn = v(COMPN)[sar12_k]
let sar12_p = v(TOPP)[sar12_k]
let sar12_n = v(TOPN)[sar12_k]
let sar12_decision = 0
if sar12_cmp >= 0.9
let sar12_code = sar12_trial
let sar12_decision = 1
end
echo 8 8 $&sar12_trial $&sar12_cmp $&sar12_cmpn $&sar12_p $&sar12_n -0.00029296875 $&sar12_decision >> decisions.csv
alter VD_EVAL = 0
let sar12_trial = sar12_code + 128
let sar12_drive = (floor(sar12_trial / 1) - 2*floor(sar12_trial / 2))*1.8
alter VD_B0 = $&sar12_drive
let sar12_drive = (floor(sar12_trial / 2) - 2*floor(sar12_trial / 4))*1.8
alter VD_B1 = $&sar12_drive
let sar12_drive = (floor(sar12_trial / 4) - 2*floor(sar12_trial / 8))*1.8
alter VD_B2 = $&sar12_drive
let sar12_drive = (floor(sar12_trial / 8) - 2*floor(sar12_trial / 16))*1.8
alter VD_B3 = $&sar12_drive
let sar12_drive = (floor(sar12_trial / 16) - 2*floor(sar12_trial / 32))*1.8
alter VD_B4 = $&sar12_drive
let sar12_drive = (floor(sar12_trial / 32) - 2*floor(sar12_trial / 64))*1.8
alter VD_B5 = $&sar12_drive
let sar12_drive = (floor(sar12_trial / 64) - 2*floor(sar12_trial / 128))*1.8
alter VD_B6 = $&sar12_drive
let sar12_drive = (floor(sar12_trial / 128) - 2*floor(sar12_trial / 256))*1.8
alter VD_B7 = $&sar12_drive
let sar12_drive = (floor(sar12_trial / 256) - 2*floor(sar12_trial / 512))*1.8
alter VD_B8 = $&sar12_drive
let sar12_drive = (floor(sar12_trial / 512) - 2*floor(sar12_trial / 1024))*1.8
alter VD_B9 = $&sar12_drive
let sar12_drive = (floor(sar12_trial / 1024) - 2*floor(sar12_trial / 2048))*1.8
alter VD_B10 = $&sar12_drive
let sar12_drive = (floor(sar12_trial / 2048) - 2*floor(sar12_trial / 4096))*1.8
alter VD_B11 = $&sar12_drive
stop when time ge 8.6774999999e-05
resume
let sar12_k = length(time)-1
if abs(time[sar12_k] - 8.6775e-05) > 1e-12
print time[sar12_k]
echo expected_pause_time_s 8.6775e-05
echo SAR12_PAUSE_FAILED
quit 1
end
print time[sar12_k] >> pause-times.txt
delete all
alter VD_EVAL = 1.8
stop when time ge 8.6949999999e-05
resume
let sar12_k = length(time)-1
if abs(time[sar12_k] - 8.695e-05) > 1e-12
print time[sar12_k]
echo expected_pause_time_s 8.695e-05
echo SAR12_PAUSE_FAILED
quit 1
end
print time[sar12_k] >> pause-times.txt
delete all
let sar12_k = length(time)-1
let sar12_cmp = v(COMP)[sar12_k]
let sar12_cmpn = v(COMPN)[sar12_k]
let sar12_p = v(TOPP)[sar12_k]
let sar12_n = v(TOPN)[sar12_k]
let sar12_decision = 0
if sar12_cmp >= 0.9
let sar12_code = sar12_trial
let sar12_decision = 1
end
echo 8 7 $&sar12_trial $&sar12_cmp $&sar12_cmpn $&sar12_p $&sar12_n -0.00029296875 $&sar12_decision >> decisions.csv
alter VD_EVAL = 0
let sar12_trial = sar12_code + 64
let sar12_drive = (floor(sar12_trial / 1) - 2*floor(sar12_trial / 2))*1.8
alter VD_B0 = $&sar12_drive
let sar12_drive = (floor(sar12_trial / 2) - 2*floor(sar12_trial / 4))*1.8
alter VD_B1 = $&sar12_drive
let sar12_drive = (floor(sar12_trial / 4) - 2*floor(sar12_trial / 8))*1.8
alter VD_B2 = $&sar12_drive
let sar12_drive = (floor(sar12_trial / 8) - 2*floor(sar12_trial / 16))*1.8
alter VD_B3 = $&sar12_drive
let sar12_drive = (floor(sar12_trial / 16) - 2*floor(sar12_trial / 32))*1.8
alter VD_B4 = $&sar12_drive
let sar12_drive = (floor(sar12_trial / 32) - 2*floor(sar12_trial / 64))*1.8
alter VD_B5 = $&sar12_drive
let sar12_drive = (floor(sar12_trial / 64) - 2*floor(sar12_trial / 128))*1.8
alter VD_B6 = $&sar12_drive
let sar12_drive = (floor(sar12_trial / 128) - 2*floor(sar12_trial / 256))*1.8
alter VD_B7 = $&sar12_drive
let sar12_drive = (floor(sar12_trial / 256) - 2*floor(sar12_trial / 512))*1.8
alter VD_B8 = $&sar12_drive
let sar12_drive = (floor(sar12_trial / 512) - 2*floor(sar12_trial / 1024))*1.8
alter VD_B9 = $&sar12_drive
let sar12_drive = (floor(sar12_trial / 1024) - 2*floor(sar12_trial / 2048))*1.8
alter VD_B10 = $&sar12_drive
let sar12_drive = (floor(sar12_trial / 2048) - 2*floor(sar12_trial / 4096))*1.8
alter VD_B11 = $&sar12_drive
stop when time ge 8.7274999999e-05
resume
let sar12_k = length(time)-1
if abs(time[sar12_k] - 8.7275e-05) > 1e-12
print time[sar12_k]
echo expected_pause_time_s 8.7275e-05
echo SAR12_PAUSE_FAILED
quit 1
end
print time[sar12_k] >> pause-times.txt
delete all
alter VD_EVAL = 1.8
stop when time ge 8.7449999999e-05
resume
let sar12_k = length(time)-1
if abs(time[sar12_k] - 8.745e-05) > 1e-12
print time[sar12_k]
echo expected_pause_time_s 8.745e-05
echo SAR12_PAUSE_FAILED
quit 1
end
print time[sar12_k] >> pause-times.txt
delete all
let sar12_k = length(time)-1
let sar12_cmp = v(COMP)[sar12_k]
let sar12_cmpn = v(COMPN)[sar12_k]
let sar12_p = v(TOPP)[sar12_k]
let sar12_n = v(TOPN)[sar12_k]
let sar12_decision = 0
if sar12_cmp >= 0.9
let sar12_code = sar12_trial
let sar12_decision = 1
end
echo 8 6 $&sar12_trial $&sar12_cmp $&sar12_cmpn $&sar12_p $&sar12_n -0.00029296875 $&sar12_decision >> decisions.csv
alter VD_EVAL = 0
let sar12_trial = sar12_code + 32
let sar12_drive = (floor(sar12_trial / 1) - 2*floor(sar12_trial / 2))*1.8
alter VD_B0 = $&sar12_drive
let sar12_drive = (floor(sar12_trial / 2) - 2*floor(sar12_trial / 4))*1.8
alter VD_B1 = $&sar12_drive
let sar12_drive = (floor(sar12_trial / 4) - 2*floor(sar12_trial / 8))*1.8
alter VD_B2 = $&sar12_drive
let sar12_drive = (floor(sar12_trial / 8) - 2*floor(sar12_trial / 16))*1.8
alter VD_B3 = $&sar12_drive
let sar12_drive = (floor(sar12_trial / 16) - 2*floor(sar12_trial / 32))*1.8
alter VD_B4 = $&sar12_drive
let sar12_drive = (floor(sar12_trial / 32) - 2*floor(sar12_trial / 64))*1.8
alter VD_B5 = $&sar12_drive
let sar12_drive = (floor(sar12_trial / 64) - 2*floor(sar12_trial / 128))*1.8
alter VD_B6 = $&sar12_drive
let sar12_drive = (floor(sar12_trial / 128) - 2*floor(sar12_trial / 256))*1.8
alter VD_B7 = $&sar12_drive
let sar12_drive = (floor(sar12_trial / 256) - 2*floor(sar12_trial / 512))*1.8
alter VD_B8 = $&sar12_drive
let sar12_drive = (floor(sar12_trial / 512) - 2*floor(sar12_trial / 1024))*1.8
alter VD_B9 = $&sar12_drive
let sar12_drive = (floor(sar12_trial / 1024) - 2*floor(sar12_trial / 2048))*1.8
alter VD_B10 = $&sar12_drive
let sar12_drive = (floor(sar12_trial / 2048) - 2*floor(sar12_trial / 4096))*1.8
alter VD_B11 = $&sar12_drive
stop when time ge 8.7774999999e-05
resume
let sar12_k = length(time)-1
if abs(time[sar12_k] - 8.7775e-05) > 1e-12
print time[sar12_k]
echo expected_pause_time_s 8.7775e-05
echo SAR12_PAUSE_FAILED
quit 1
end
print time[sar12_k] >> pause-times.txt
delete all
alter VD_EVAL = 1.8
stop when time ge 8.7949999999e-05
resume
let sar12_k = length(time)-1
if abs(time[sar12_k] - 8.795e-05) > 1e-12
print time[sar12_k]
echo expected_pause_time_s 8.795e-05
echo SAR12_PAUSE_FAILED
quit 1
end
print time[sar12_k] >> pause-times.txt
delete all
let sar12_k = length(time)-1
let sar12_cmp = v(COMP)[sar12_k]
let sar12_cmpn = v(COMPN)[sar12_k]
let sar12_p = v(TOPP)[sar12_k]
let sar12_n = v(TOPN)[sar12_k]
let sar12_decision = 0
if sar12_cmp >= 0.9
let sar12_code = sar12_trial
let sar12_decision = 1
end
echo 8 5 $&sar12_trial $&sar12_cmp $&sar12_cmpn $&sar12_p $&sar12_n -0.00029296875 $&sar12_decision >> decisions.csv
alter VD_EVAL = 0
let sar12_trial = sar12_code + 16
let sar12_drive = (floor(sar12_trial / 1) - 2*floor(sar12_trial / 2))*1.8
alter VD_B0 = $&sar12_drive
let sar12_drive = (floor(sar12_trial / 2) - 2*floor(sar12_trial / 4))*1.8
alter VD_B1 = $&sar12_drive
let sar12_drive = (floor(sar12_trial / 4) - 2*floor(sar12_trial / 8))*1.8
alter VD_B2 = $&sar12_drive
let sar12_drive = (floor(sar12_trial / 8) - 2*floor(sar12_trial / 16))*1.8
alter VD_B3 = $&sar12_drive
let sar12_drive = (floor(sar12_trial / 16) - 2*floor(sar12_trial / 32))*1.8
alter VD_B4 = $&sar12_drive
let sar12_drive = (floor(sar12_trial / 32) - 2*floor(sar12_trial / 64))*1.8
alter VD_B5 = $&sar12_drive
let sar12_drive = (floor(sar12_trial / 64) - 2*floor(sar12_trial / 128))*1.8
alter VD_B6 = $&sar12_drive
let sar12_drive = (floor(sar12_trial / 128) - 2*floor(sar12_trial / 256))*1.8
alter VD_B7 = $&sar12_drive
let sar12_drive = (floor(sar12_trial / 256) - 2*floor(sar12_trial / 512))*1.8
alter VD_B8 = $&sar12_drive
let sar12_drive = (floor(sar12_trial / 512) - 2*floor(sar12_trial / 1024))*1.8
alter VD_B9 = $&sar12_drive
let sar12_drive = (floor(sar12_trial / 1024) - 2*floor(sar12_trial / 2048))*1.8
alter VD_B10 = $&sar12_drive
let sar12_drive = (floor(sar12_trial / 2048) - 2*floor(sar12_trial / 4096))*1.8
alter VD_B11 = $&sar12_drive
stop when time ge 8.82749999989999e-05
resume
let sar12_k = length(time)-1
if abs(time[sar12_k] - 8.8275e-05) > 1e-12
print time[sar12_k]
echo expected_pause_time_s 8.8275e-05
echo SAR12_PAUSE_FAILED
quit 1
end
print time[sar12_k] >> pause-times.txt
delete all
alter VD_EVAL = 1.8
stop when time ge 8.8449999999e-05
resume
let sar12_k = length(time)-1
if abs(time[sar12_k] - 8.845e-05) > 1e-12
print time[sar12_k]
echo expected_pause_time_s 8.845e-05
echo SAR12_PAUSE_FAILED
quit 1
end
print time[sar12_k] >> pause-times.txt
delete all
let sar12_k = length(time)-1
let sar12_cmp = v(COMP)[sar12_k]
let sar12_cmpn = v(COMPN)[sar12_k]
let sar12_p = v(TOPP)[sar12_k]
let sar12_n = v(TOPN)[sar12_k]
let sar12_decision = 0
if sar12_cmp >= 0.9
let sar12_code = sar12_trial
let sar12_decision = 1
end
echo 8 4 $&sar12_trial $&sar12_cmp $&sar12_cmpn $&sar12_p $&sar12_n -0.00029296875 $&sar12_decision >> decisions.csv
alter VD_EVAL = 0
let sar12_trial = sar12_code + 8
let sar12_drive = (floor(sar12_trial / 1) - 2*floor(sar12_trial / 2))*1.8
alter VD_B0 = $&sar12_drive
let sar12_drive = (floor(sar12_trial / 2) - 2*floor(sar12_trial / 4))*1.8
alter VD_B1 = $&sar12_drive
let sar12_drive = (floor(sar12_trial / 4) - 2*floor(sar12_trial / 8))*1.8
alter VD_B2 = $&sar12_drive
let sar12_drive = (floor(sar12_trial / 8) - 2*floor(sar12_trial / 16))*1.8
alter VD_B3 = $&sar12_drive
let sar12_drive = (floor(sar12_trial / 16) - 2*floor(sar12_trial / 32))*1.8
alter VD_B4 = $&sar12_drive
let sar12_drive = (floor(sar12_trial / 32) - 2*floor(sar12_trial / 64))*1.8
alter VD_B5 = $&sar12_drive
let sar12_drive = (floor(sar12_trial / 64) - 2*floor(sar12_trial / 128))*1.8
alter VD_B6 = $&sar12_drive
let sar12_drive = (floor(sar12_trial / 128) - 2*floor(sar12_trial / 256))*1.8
alter VD_B7 = $&sar12_drive
let sar12_drive = (floor(sar12_trial / 256) - 2*floor(sar12_trial / 512))*1.8
alter VD_B8 = $&sar12_drive
let sar12_drive = (floor(sar12_trial / 512) - 2*floor(sar12_trial / 1024))*1.8
alter VD_B9 = $&sar12_drive
let sar12_drive = (floor(sar12_trial / 1024) - 2*floor(sar12_trial / 2048))*1.8
alter VD_B10 = $&sar12_drive
let sar12_drive = (floor(sar12_trial / 2048) - 2*floor(sar12_trial / 4096))*1.8
alter VD_B11 = $&sar12_drive
stop when time ge 8.87749999989999e-05
resume
let sar12_k = length(time)-1
if abs(time[sar12_k] - 8.87749999999999e-05) > 1e-12
print time[sar12_k]
echo expected_pause_time_s 8.87749999999999e-05
echo SAR12_PAUSE_FAILED
quit 1
end
print time[sar12_k] >> pause-times.txt
delete all
alter VD_EVAL = 1.8
stop when time ge 8.8949999999e-05
resume
let sar12_k = length(time)-1
if abs(time[sar12_k] - 8.895e-05) > 1e-12
print time[sar12_k]
echo expected_pause_time_s 8.895e-05
echo SAR12_PAUSE_FAILED
quit 1
end
print time[sar12_k] >> pause-times.txt
delete all
let sar12_k = length(time)-1
let sar12_cmp = v(COMP)[sar12_k]
let sar12_cmpn = v(COMPN)[sar12_k]
let sar12_p = v(TOPP)[sar12_k]
let sar12_n = v(TOPN)[sar12_k]
let sar12_decision = 0
if sar12_cmp >= 0.9
let sar12_code = sar12_trial
let sar12_decision = 1
end
echo 8 3 $&sar12_trial $&sar12_cmp $&sar12_cmpn $&sar12_p $&sar12_n -0.00029296875 $&sar12_decision >> decisions.csv
alter VD_EVAL = 0
let sar12_trial = sar12_code + 4
let sar12_drive = (floor(sar12_trial / 1) - 2*floor(sar12_trial / 2))*1.8
alter VD_B0 = $&sar12_drive
let sar12_drive = (floor(sar12_trial / 2) - 2*floor(sar12_trial / 4))*1.8
alter VD_B1 = $&sar12_drive
let sar12_drive = (floor(sar12_trial / 4) - 2*floor(sar12_trial / 8))*1.8
alter VD_B2 = $&sar12_drive
let sar12_drive = (floor(sar12_trial / 8) - 2*floor(sar12_trial / 16))*1.8
alter VD_B3 = $&sar12_drive
let sar12_drive = (floor(sar12_trial / 16) - 2*floor(sar12_trial / 32))*1.8
alter VD_B4 = $&sar12_drive
let sar12_drive = (floor(sar12_trial / 32) - 2*floor(sar12_trial / 64))*1.8
alter VD_B5 = $&sar12_drive
let sar12_drive = (floor(sar12_trial / 64) - 2*floor(sar12_trial / 128))*1.8
alter VD_B6 = $&sar12_drive
let sar12_drive = (floor(sar12_trial / 128) - 2*floor(sar12_trial / 256))*1.8
alter VD_B7 = $&sar12_drive
let sar12_drive = (floor(sar12_trial / 256) - 2*floor(sar12_trial / 512))*1.8
alter VD_B8 = $&sar12_drive
let sar12_drive = (floor(sar12_trial / 512) - 2*floor(sar12_trial / 1024))*1.8
alter VD_B9 = $&sar12_drive
let sar12_drive = (floor(sar12_trial / 1024) - 2*floor(sar12_trial / 2048))*1.8
alter VD_B10 = $&sar12_drive
let sar12_drive = (floor(sar12_trial / 2048) - 2*floor(sar12_trial / 4096))*1.8
alter VD_B11 = $&sar12_drive
stop when time ge 8.92749999989999e-05
resume
let sar12_k = length(time)-1
if abs(time[sar12_k] - 8.92749999999999e-05) > 1e-12
print time[sar12_k]
echo expected_pause_time_s 8.92749999999999e-05
echo SAR12_PAUSE_FAILED
quit 1
end
print time[sar12_k] >> pause-times.txt
delete all
alter VD_EVAL = 1.8
stop when time ge 8.9449999999e-05
resume
let sar12_k = length(time)-1
if abs(time[sar12_k] - 8.945e-05) > 1e-12
print time[sar12_k]
echo expected_pause_time_s 8.945e-05
echo SAR12_PAUSE_FAILED
quit 1
end
print time[sar12_k] >> pause-times.txt
delete all
let sar12_k = length(time)-1
let sar12_cmp = v(COMP)[sar12_k]
let sar12_cmpn = v(COMPN)[sar12_k]
let sar12_p = v(TOPP)[sar12_k]
let sar12_n = v(TOPN)[sar12_k]
let sar12_decision = 0
if sar12_cmp >= 0.9
let sar12_code = sar12_trial
let sar12_decision = 1
end
echo 8 2 $&sar12_trial $&sar12_cmp $&sar12_cmpn $&sar12_p $&sar12_n -0.00029296875 $&sar12_decision >> decisions.csv
alter VD_EVAL = 0
let sar12_trial = sar12_code + 2
let sar12_drive = (floor(sar12_trial / 1) - 2*floor(sar12_trial / 2))*1.8
alter VD_B0 = $&sar12_drive
let sar12_drive = (floor(sar12_trial / 2) - 2*floor(sar12_trial / 4))*1.8
alter VD_B1 = $&sar12_drive
let sar12_drive = (floor(sar12_trial / 4) - 2*floor(sar12_trial / 8))*1.8
alter VD_B2 = $&sar12_drive
let sar12_drive = (floor(sar12_trial / 8) - 2*floor(sar12_trial / 16))*1.8
alter VD_B3 = $&sar12_drive
let sar12_drive = (floor(sar12_trial / 16) - 2*floor(sar12_trial / 32))*1.8
alter VD_B4 = $&sar12_drive
let sar12_drive = (floor(sar12_trial / 32) - 2*floor(sar12_trial / 64))*1.8
alter VD_B5 = $&sar12_drive
let sar12_drive = (floor(sar12_trial / 64) - 2*floor(sar12_trial / 128))*1.8
alter VD_B6 = $&sar12_drive
let sar12_drive = (floor(sar12_trial / 128) - 2*floor(sar12_trial / 256))*1.8
alter VD_B7 = $&sar12_drive
let sar12_drive = (floor(sar12_trial / 256) - 2*floor(sar12_trial / 512))*1.8
alter VD_B8 = $&sar12_drive
let sar12_drive = (floor(sar12_trial / 512) - 2*floor(sar12_trial / 1024))*1.8
alter VD_B9 = $&sar12_drive
let sar12_drive = (floor(sar12_trial / 1024) - 2*floor(sar12_trial / 2048))*1.8
alter VD_B10 = $&sar12_drive
let sar12_drive = (floor(sar12_trial / 2048) - 2*floor(sar12_trial / 4096))*1.8
alter VD_B11 = $&sar12_drive
stop when time ge 8.97749999989999e-05
resume
let sar12_k = length(time)-1
if abs(time[sar12_k] - 8.97749999999999e-05) > 1e-12
print time[sar12_k]
echo expected_pause_time_s 8.97749999999999e-05
echo SAR12_PAUSE_FAILED
quit 1
end
print time[sar12_k] >> pause-times.txt
delete all
alter VD_EVAL = 1.8
stop when time ge 8.99499999989999e-05
resume
let sar12_k = length(time)-1
if abs(time[sar12_k] - 8.995e-05) > 1e-12
print time[sar12_k]
echo expected_pause_time_s 8.995e-05
echo SAR12_PAUSE_FAILED
quit 1
end
print time[sar12_k] >> pause-times.txt
delete all
let sar12_k = length(time)-1
let sar12_cmp = v(COMP)[sar12_k]
let sar12_cmpn = v(COMPN)[sar12_k]
let sar12_p = v(TOPP)[sar12_k]
let sar12_n = v(TOPN)[sar12_k]
let sar12_decision = 0
if sar12_cmp >= 0.9
let sar12_code = sar12_trial
let sar12_decision = 1
end
echo 8 1 $&sar12_trial $&sar12_cmp $&sar12_cmpn $&sar12_p $&sar12_n -0.00029296875 $&sar12_decision >> decisions.csv
alter VD_EVAL = 0
let sar12_trial = sar12_code + 1
let sar12_drive = (floor(sar12_trial / 1) - 2*floor(sar12_trial / 2))*1.8
alter VD_B0 = $&sar12_drive
let sar12_drive = (floor(sar12_trial / 2) - 2*floor(sar12_trial / 4))*1.8
alter VD_B1 = $&sar12_drive
let sar12_drive = (floor(sar12_trial / 4) - 2*floor(sar12_trial / 8))*1.8
alter VD_B2 = $&sar12_drive
let sar12_drive = (floor(sar12_trial / 8) - 2*floor(sar12_trial / 16))*1.8
alter VD_B3 = $&sar12_drive
let sar12_drive = (floor(sar12_trial / 16) - 2*floor(sar12_trial / 32))*1.8
alter VD_B4 = $&sar12_drive
let sar12_drive = (floor(sar12_trial / 32) - 2*floor(sar12_trial / 64))*1.8
alter VD_B5 = $&sar12_drive
let sar12_drive = (floor(sar12_trial / 64) - 2*floor(sar12_trial / 128))*1.8
alter VD_B6 = $&sar12_drive
let sar12_drive = (floor(sar12_trial / 128) - 2*floor(sar12_trial / 256))*1.8
alter VD_B7 = $&sar12_drive
let sar12_drive = (floor(sar12_trial / 256) - 2*floor(sar12_trial / 512))*1.8
alter VD_B8 = $&sar12_drive
let sar12_drive = (floor(sar12_trial / 512) - 2*floor(sar12_trial / 1024))*1.8
alter VD_B9 = $&sar12_drive
let sar12_drive = (floor(sar12_trial / 1024) - 2*floor(sar12_trial / 2048))*1.8
alter VD_B10 = $&sar12_drive
let sar12_drive = (floor(sar12_trial / 2048) - 2*floor(sar12_trial / 4096))*1.8
alter VD_B11 = $&sar12_drive
stop when time ge 9.02749999989999e-05
resume
let sar12_k = length(time)-1
if abs(time[sar12_k] - 9.02749999999999e-05) > 1e-12
print time[sar12_k]
echo expected_pause_time_s 9.02749999999999e-05
echo SAR12_PAUSE_FAILED
quit 1
end
print time[sar12_k] >> pause-times.txt
delete all
alter VD_EVAL = 1.8
stop when time ge 9.04499999989999e-05
resume
let sar12_k = length(time)-1
if abs(time[sar12_k] - 9.04499999999999e-05) > 1e-12
print time[sar12_k]
echo expected_pause_time_s 9.04499999999999e-05
echo SAR12_PAUSE_FAILED
quit 1
end
print time[sar12_k] >> pause-times.txt
delete all
let sar12_k = length(time)-1
let sar12_cmp = v(COMP)[sar12_k]
let sar12_cmpn = v(COMPN)[sar12_k]
let sar12_p = v(TOPP)[sar12_k]
let sar12_n = v(TOPN)[sar12_k]
let sar12_decision = 0
if sar12_cmp >= 0.9
let sar12_code = sar12_trial
let sar12_decision = 1
end
echo 8 0 $&sar12_trial $&sar12_cmp $&sar12_cmpn $&sar12_p $&sar12_n -0.00029296875 $&sar12_decision >> decisions.csv
alter VD_EVAL = 0
alter VINP = 0.900439453125
alter VINN = 0.899560546875
alter VD_SAMPLE = 1.8
alter VD_EVAL = 0
alter VD_B0 = 0
alter VD_B1 = 0
alter VD_B2 = 0
alter VD_B3 = 0
alter VD_B4 = 0
alter VD_B5 = 0
alter VD_B6 = 0
alter VD_B7 = 0
alter VD_B8 = 0
alter VD_B9 = 0
alter VD_B10 = 0
alter VD_B11 = 0
let sar12_code = 0
stop when time ge 9.4449999999e-05
resume
let sar12_k = length(time)-1
if abs(time[sar12_k] - 9.445e-05) > 1e-12
print time[sar12_k]
echo expected_pause_time_s 9.445e-05
echo SAR12_PAUSE_FAILED
quit 1
end
print time[sar12_k] >> pause-times.txt
delete all
alter VD_SAMPLE = 0
stop when time ge 9.4499999999e-05
resume
let sar12_k = length(time)-1
if abs(time[sar12_k] - 9.45e-05) > 1e-12
print time[sar12_k]
echo expected_pause_time_s 9.45e-05
echo SAR12_PAUSE_FAILED
quit 1
end
print time[sar12_k] >> pause-times.txt
delete all
alter VD_EVAL = 0
let sar12_trial = sar12_code + 2048
let sar12_drive = (floor(sar12_trial / 1) - 2*floor(sar12_trial / 2))*1.8
alter VD_B0 = $&sar12_drive
let sar12_drive = (floor(sar12_trial / 2) - 2*floor(sar12_trial / 4))*1.8
alter VD_B1 = $&sar12_drive
let sar12_drive = (floor(sar12_trial / 4) - 2*floor(sar12_trial / 8))*1.8
alter VD_B2 = $&sar12_drive
let sar12_drive = (floor(sar12_trial / 8) - 2*floor(sar12_trial / 16))*1.8
alter VD_B3 = $&sar12_drive
let sar12_drive = (floor(sar12_trial / 16) - 2*floor(sar12_trial / 32))*1.8
alter VD_B4 = $&sar12_drive
let sar12_drive = (floor(sar12_trial / 32) - 2*floor(sar12_trial / 64))*1.8
alter VD_B5 = $&sar12_drive
let sar12_drive = (floor(sar12_trial / 64) - 2*floor(sar12_trial / 128))*1.8
alter VD_B6 = $&sar12_drive
let sar12_drive = (floor(sar12_trial / 128) - 2*floor(sar12_trial / 256))*1.8
alter VD_B7 = $&sar12_drive
let sar12_drive = (floor(sar12_trial / 256) - 2*floor(sar12_trial / 512))*1.8
alter VD_B8 = $&sar12_drive
let sar12_drive = (floor(sar12_trial / 512) - 2*floor(sar12_trial / 1024))*1.8
alter VD_B9 = $&sar12_drive
let sar12_drive = (floor(sar12_trial / 1024) - 2*floor(sar12_trial / 2048))*1.8
alter VD_B10 = $&sar12_drive
let sar12_drive = (floor(sar12_trial / 2048) - 2*floor(sar12_trial / 4096))*1.8
alter VD_B11 = $&sar12_drive
stop when time ge 9.48249999989999e-05
resume
let sar12_k = length(time)-1
if abs(time[sar12_k] - 9.48249999999999e-05) > 1e-12
print time[sar12_k]
echo expected_pause_time_s 9.48249999999999e-05
echo SAR12_PAUSE_FAILED
quit 1
end
print time[sar12_k] >> pause-times.txt
delete all
alter VD_EVAL = 1.8
stop when time ge 9.4999999999e-05
resume
let sar12_k = length(time)-1
if abs(time[sar12_k] - 9.5e-05) > 1e-12
print time[sar12_k]
echo expected_pause_time_s 9.5e-05
echo SAR12_PAUSE_FAILED
quit 1
end
print time[sar12_k] >> pause-times.txt
delete all
let sar12_k = length(time)-1
let sar12_cmp = v(COMP)[sar12_k]
let sar12_cmpn = v(COMPN)[sar12_k]
let sar12_p = v(TOPP)[sar12_k]
let sar12_n = v(TOPN)[sar12_k]
let sar12_decision = 0
if sar12_cmp >= 0.9
let sar12_code = sar12_trial
let sar12_decision = 1
end
echo 9 11 $&sar12_trial $&sar12_cmp $&sar12_cmpn $&sar12_p $&sar12_n 0.00087890625 $&sar12_decision >> decisions.csv
alter VD_EVAL = 0
let sar12_trial = sar12_code + 1024
let sar12_drive = (floor(sar12_trial / 1) - 2*floor(sar12_trial / 2))*1.8
alter VD_B0 = $&sar12_drive
let sar12_drive = (floor(sar12_trial / 2) - 2*floor(sar12_trial / 4))*1.8
alter VD_B1 = $&sar12_drive
let sar12_drive = (floor(sar12_trial / 4) - 2*floor(sar12_trial / 8))*1.8
alter VD_B2 = $&sar12_drive
let sar12_drive = (floor(sar12_trial / 8) - 2*floor(sar12_trial / 16))*1.8
alter VD_B3 = $&sar12_drive
let sar12_drive = (floor(sar12_trial / 16) - 2*floor(sar12_trial / 32))*1.8
alter VD_B4 = $&sar12_drive
let sar12_drive = (floor(sar12_trial / 32) - 2*floor(sar12_trial / 64))*1.8
alter VD_B5 = $&sar12_drive
let sar12_drive = (floor(sar12_trial / 64) - 2*floor(sar12_trial / 128))*1.8
alter VD_B6 = $&sar12_drive
let sar12_drive = (floor(sar12_trial / 128) - 2*floor(sar12_trial / 256))*1.8
alter VD_B7 = $&sar12_drive
let sar12_drive = (floor(sar12_trial / 256) - 2*floor(sar12_trial / 512))*1.8
alter VD_B8 = $&sar12_drive
let sar12_drive = (floor(sar12_trial / 512) - 2*floor(sar12_trial / 1024))*1.8
alter VD_B9 = $&sar12_drive
let sar12_drive = (floor(sar12_trial / 1024) - 2*floor(sar12_trial / 2048))*1.8
alter VD_B10 = $&sar12_drive
let sar12_drive = (floor(sar12_trial / 2048) - 2*floor(sar12_trial / 4096))*1.8
alter VD_B11 = $&sar12_drive
stop when time ge 9.53249999989999e-05
resume
let sar12_k = length(time)-1
if abs(time[sar12_k] - 9.53249999999999e-05) > 1e-12
print time[sar12_k]
echo expected_pause_time_s 9.53249999999999e-05
echo SAR12_PAUSE_FAILED
quit 1
end
print time[sar12_k] >> pause-times.txt
delete all
alter VD_EVAL = 1.8
stop when time ge 9.54999999989999e-05
resume
let sar12_k = length(time)-1
if abs(time[sar12_k] - 9.54999999999999e-05) > 1e-12
print time[sar12_k]
echo expected_pause_time_s 9.54999999999999e-05
echo SAR12_PAUSE_FAILED
quit 1
end
print time[sar12_k] >> pause-times.txt
delete all
let sar12_k = length(time)-1
let sar12_cmp = v(COMP)[sar12_k]
let sar12_cmpn = v(COMPN)[sar12_k]
let sar12_p = v(TOPP)[sar12_k]
let sar12_n = v(TOPN)[sar12_k]
let sar12_decision = 0
if sar12_cmp >= 0.9
let sar12_code = sar12_trial
let sar12_decision = 1
end
echo 9 10 $&sar12_trial $&sar12_cmp $&sar12_cmpn $&sar12_p $&sar12_n 0.00087890625 $&sar12_decision >> decisions.csv
alter VD_EVAL = 0
let sar12_trial = sar12_code + 512
let sar12_drive = (floor(sar12_trial / 1) - 2*floor(sar12_trial / 2))*1.8
alter VD_B0 = $&sar12_drive
let sar12_drive = (floor(sar12_trial / 2) - 2*floor(sar12_trial / 4))*1.8
alter VD_B1 = $&sar12_drive
let sar12_drive = (floor(sar12_trial / 4) - 2*floor(sar12_trial / 8))*1.8
alter VD_B2 = $&sar12_drive
let sar12_drive = (floor(sar12_trial / 8) - 2*floor(sar12_trial / 16))*1.8
alter VD_B3 = $&sar12_drive
let sar12_drive = (floor(sar12_trial / 16) - 2*floor(sar12_trial / 32))*1.8
alter VD_B4 = $&sar12_drive
let sar12_drive = (floor(sar12_trial / 32) - 2*floor(sar12_trial / 64))*1.8
alter VD_B5 = $&sar12_drive
let sar12_drive = (floor(sar12_trial / 64) - 2*floor(sar12_trial / 128))*1.8
alter VD_B6 = $&sar12_drive
let sar12_drive = (floor(sar12_trial / 128) - 2*floor(sar12_trial / 256))*1.8
alter VD_B7 = $&sar12_drive
let sar12_drive = (floor(sar12_trial / 256) - 2*floor(sar12_trial / 512))*1.8
alter VD_B8 = $&sar12_drive
let sar12_drive = (floor(sar12_trial / 512) - 2*floor(sar12_trial / 1024))*1.8
alter VD_B9 = $&sar12_drive
let sar12_drive = (floor(sar12_trial / 1024) - 2*floor(sar12_trial / 2048))*1.8
alter VD_B10 = $&sar12_drive
let sar12_drive = (floor(sar12_trial / 2048) - 2*floor(sar12_trial / 4096))*1.8
alter VD_B11 = $&sar12_drive
stop when time ge 9.58249999989999e-05
resume
let sar12_k = length(time)-1
if abs(time[sar12_k] - 9.58249999999999e-05) > 1e-12
print time[sar12_k]
echo expected_pause_time_s 9.58249999999999e-05
echo SAR12_PAUSE_FAILED
quit 1
end
print time[sar12_k] >> pause-times.txt
delete all
alter VD_EVAL = 1.8
stop when time ge 9.59999999989999e-05
resume
let sar12_k = length(time)-1
if abs(time[sar12_k] - 9.59999999999999e-05) > 1e-12
print time[sar12_k]
echo expected_pause_time_s 9.59999999999999e-05
echo SAR12_PAUSE_FAILED
quit 1
end
print time[sar12_k] >> pause-times.txt
delete all
let sar12_k = length(time)-1
let sar12_cmp = v(COMP)[sar12_k]
let sar12_cmpn = v(COMPN)[sar12_k]
let sar12_p = v(TOPP)[sar12_k]
let sar12_n = v(TOPN)[sar12_k]
let sar12_decision = 0
if sar12_cmp >= 0.9
let sar12_code = sar12_trial
let sar12_decision = 1
end
echo 9 9 $&sar12_trial $&sar12_cmp $&sar12_cmpn $&sar12_p $&sar12_n 0.00087890625 $&sar12_decision >> decisions.csv
alter VD_EVAL = 0
let sar12_trial = sar12_code + 256
let sar12_drive = (floor(sar12_trial / 1) - 2*floor(sar12_trial / 2))*1.8
alter VD_B0 = $&sar12_drive
let sar12_drive = (floor(sar12_trial / 2) - 2*floor(sar12_trial / 4))*1.8
alter VD_B1 = $&sar12_drive
let sar12_drive = (floor(sar12_trial / 4) - 2*floor(sar12_trial / 8))*1.8
alter VD_B2 = $&sar12_drive
let sar12_drive = (floor(sar12_trial / 8) - 2*floor(sar12_trial / 16))*1.8
alter VD_B3 = $&sar12_drive
let sar12_drive = (floor(sar12_trial / 16) - 2*floor(sar12_trial / 32))*1.8
alter VD_B4 = $&sar12_drive
let sar12_drive = (floor(sar12_trial / 32) - 2*floor(sar12_trial / 64))*1.8
alter VD_B5 = $&sar12_drive
let sar12_drive = (floor(sar12_trial / 64) - 2*floor(sar12_trial / 128))*1.8
alter VD_B6 = $&sar12_drive
let sar12_drive = (floor(sar12_trial / 128) - 2*floor(sar12_trial / 256))*1.8
alter VD_B7 = $&sar12_drive
let sar12_drive = (floor(sar12_trial / 256) - 2*floor(sar12_trial / 512))*1.8
alter VD_B8 = $&sar12_drive
let sar12_drive = (floor(sar12_trial / 512) - 2*floor(sar12_trial / 1024))*1.8
alter VD_B9 = $&sar12_drive
let sar12_drive = (floor(sar12_trial / 1024) - 2*floor(sar12_trial / 2048))*1.8
alter VD_B10 = $&sar12_drive
let sar12_drive = (floor(sar12_trial / 2048) - 2*floor(sar12_trial / 4096))*1.8
alter VD_B11 = $&sar12_drive
stop when time ge 9.63249999989999e-05
resume
let sar12_k = length(time)-1
if abs(time[sar12_k] - 9.63249999999999e-05) > 1e-12
print time[sar12_k]
echo expected_pause_time_s 9.63249999999999e-05
echo SAR12_PAUSE_FAILED
quit 1
end
print time[sar12_k] >> pause-times.txt
delete all
alter VD_EVAL = 1.8
stop when time ge 9.64999999989999e-05
resume
let sar12_k = length(time)-1
if abs(time[sar12_k] - 9.64999999999999e-05) > 1e-12
print time[sar12_k]
echo expected_pause_time_s 9.64999999999999e-05
echo SAR12_PAUSE_FAILED
quit 1
end
print time[sar12_k] >> pause-times.txt
delete all
let sar12_k = length(time)-1
let sar12_cmp = v(COMP)[sar12_k]
let sar12_cmpn = v(COMPN)[sar12_k]
let sar12_p = v(TOPP)[sar12_k]
let sar12_n = v(TOPN)[sar12_k]
let sar12_decision = 0
if sar12_cmp >= 0.9
let sar12_code = sar12_trial
let sar12_decision = 1
end
echo 9 8 $&sar12_trial $&sar12_cmp $&sar12_cmpn $&sar12_p $&sar12_n 0.00087890625 $&sar12_decision >> decisions.csv
alter VD_EVAL = 0
let sar12_trial = sar12_code + 128
let sar12_drive = (floor(sar12_trial / 1) - 2*floor(sar12_trial / 2))*1.8
alter VD_B0 = $&sar12_drive
let sar12_drive = (floor(sar12_trial / 2) - 2*floor(sar12_trial / 4))*1.8
alter VD_B1 = $&sar12_drive
let sar12_drive = (floor(sar12_trial / 4) - 2*floor(sar12_trial / 8))*1.8
alter VD_B2 = $&sar12_drive
let sar12_drive = (floor(sar12_trial / 8) - 2*floor(sar12_trial / 16))*1.8
alter VD_B3 = $&sar12_drive
let sar12_drive = (floor(sar12_trial / 16) - 2*floor(sar12_trial / 32))*1.8
alter VD_B4 = $&sar12_drive
let sar12_drive = (floor(sar12_trial / 32) - 2*floor(sar12_trial / 64))*1.8
alter VD_B5 = $&sar12_drive
let sar12_drive = (floor(sar12_trial / 64) - 2*floor(sar12_trial / 128))*1.8
alter VD_B6 = $&sar12_drive
let sar12_drive = (floor(sar12_trial / 128) - 2*floor(sar12_trial / 256))*1.8
alter VD_B7 = $&sar12_drive
let sar12_drive = (floor(sar12_trial / 256) - 2*floor(sar12_trial / 512))*1.8
alter VD_B8 = $&sar12_drive
let sar12_drive = (floor(sar12_trial / 512) - 2*floor(sar12_trial / 1024))*1.8
alter VD_B9 = $&sar12_drive
let sar12_drive = (floor(sar12_trial / 1024) - 2*floor(sar12_trial / 2048))*1.8
alter VD_B10 = $&sar12_drive
let sar12_drive = (floor(sar12_trial / 2048) - 2*floor(sar12_trial / 4096))*1.8
alter VD_B11 = $&sar12_drive
stop when time ge 9.68249999989999e-05
resume
let sar12_k = length(time)-1
if abs(time[sar12_k] - 9.68249999999999e-05) > 1e-12
print time[sar12_k]
echo expected_pause_time_s 9.68249999999999e-05
echo SAR12_PAUSE_FAILED
quit 1
end
print time[sar12_k] >> pause-times.txt
delete all
alter VD_EVAL = 1.8
stop when time ge 9.69999999989999e-05
resume
let sar12_k = length(time)-1
if abs(time[sar12_k] - 9.69999999999999e-05) > 1e-12
print time[sar12_k]
echo expected_pause_time_s 9.69999999999999e-05
echo SAR12_PAUSE_FAILED
quit 1
end
print time[sar12_k] >> pause-times.txt
delete all
let sar12_k = length(time)-1
let sar12_cmp = v(COMP)[sar12_k]
let sar12_cmpn = v(COMPN)[sar12_k]
let sar12_p = v(TOPP)[sar12_k]
let sar12_n = v(TOPN)[sar12_k]
let sar12_decision = 0
if sar12_cmp >= 0.9
let sar12_code = sar12_trial
let sar12_decision = 1
end
echo 9 7 $&sar12_trial $&sar12_cmp $&sar12_cmpn $&sar12_p $&sar12_n 0.00087890625 $&sar12_decision >> decisions.csv
alter VD_EVAL = 0
let sar12_trial = sar12_code + 64
let sar12_drive = (floor(sar12_trial / 1) - 2*floor(sar12_trial / 2))*1.8
alter VD_B0 = $&sar12_drive
let sar12_drive = (floor(sar12_trial / 2) - 2*floor(sar12_trial / 4))*1.8
alter VD_B1 = $&sar12_drive
let sar12_drive = (floor(sar12_trial / 4) - 2*floor(sar12_trial / 8))*1.8
alter VD_B2 = $&sar12_drive
let sar12_drive = (floor(sar12_trial / 8) - 2*floor(sar12_trial / 16))*1.8
alter VD_B3 = $&sar12_drive
let sar12_drive = (floor(sar12_trial / 16) - 2*floor(sar12_trial / 32))*1.8
alter VD_B4 = $&sar12_drive
let sar12_drive = (floor(sar12_trial / 32) - 2*floor(sar12_trial / 64))*1.8
alter VD_B5 = $&sar12_drive
let sar12_drive = (floor(sar12_trial / 64) - 2*floor(sar12_trial / 128))*1.8
alter VD_B6 = $&sar12_drive
let sar12_drive = (floor(sar12_trial / 128) - 2*floor(sar12_trial / 256))*1.8
alter VD_B7 = $&sar12_drive
let sar12_drive = (floor(sar12_trial / 256) - 2*floor(sar12_trial / 512))*1.8
alter VD_B8 = $&sar12_drive
let sar12_drive = (floor(sar12_trial / 512) - 2*floor(sar12_trial / 1024))*1.8
alter VD_B9 = $&sar12_drive
let sar12_drive = (floor(sar12_trial / 1024) - 2*floor(sar12_trial / 2048))*1.8
alter VD_B10 = $&sar12_drive
let sar12_drive = (floor(sar12_trial / 2048) - 2*floor(sar12_trial / 4096))*1.8
alter VD_B11 = $&sar12_drive
stop when time ge 9.73249999989999e-05
resume
let sar12_k = length(time)-1
if abs(time[sar12_k] - 9.73249999999999e-05) > 1e-12
print time[sar12_k]
echo expected_pause_time_s 9.73249999999999e-05
echo SAR12_PAUSE_FAILED
quit 1
end
print time[sar12_k] >> pause-times.txt
delete all
alter VD_EVAL = 1.8
stop when time ge 9.74999999989999e-05
resume
let sar12_k = length(time)-1
if abs(time[sar12_k] - 9.74999999999999e-05) > 1e-12
print time[sar12_k]
echo expected_pause_time_s 9.74999999999999e-05
echo SAR12_PAUSE_FAILED
quit 1
end
print time[sar12_k] >> pause-times.txt
delete all
let sar12_k = length(time)-1
let sar12_cmp = v(COMP)[sar12_k]
let sar12_cmpn = v(COMPN)[sar12_k]
let sar12_p = v(TOPP)[sar12_k]
let sar12_n = v(TOPN)[sar12_k]
let sar12_decision = 0
if sar12_cmp >= 0.9
let sar12_code = sar12_trial
let sar12_decision = 1
end
echo 9 6 $&sar12_trial $&sar12_cmp $&sar12_cmpn $&sar12_p $&sar12_n 0.00087890625 $&sar12_decision >> decisions.csv
alter VD_EVAL = 0
let sar12_trial = sar12_code + 32
let sar12_drive = (floor(sar12_trial / 1) - 2*floor(sar12_trial / 2))*1.8
alter VD_B0 = $&sar12_drive
let sar12_drive = (floor(sar12_trial / 2) - 2*floor(sar12_trial / 4))*1.8
alter VD_B1 = $&sar12_drive
let sar12_drive = (floor(sar12_trial / 4) - 2*floor(sar12_trial / 8))*1.8
alter VD_B2 = $&sar12_drive
let sar12_drive = (floor(sar12_trial / 8) - 2*floor(sar12_trial / 16))*1.8
alter VD_B3 = $&sar12_drive
let sar12_drive = (floor(sar12_trial / 16) - 2*floor(sar12_trial / 32))*1.8
alter VD_B4 = $&sar12_drive
let sar12_drive = (floor(sar12_trial / 32) - 2*floor(sar12_trial / 64))*1.8
alter VD_B5 = $&sar12_drive
let sar12_drive = (floor(sar12_trial / 64) - 2*floor(sar12_trial / 128))*1.8
alter VD_B6 = $&sar12_drive
let sar12_drive = (floor(sar12_trial / 128) - 2*floor(sar12_trial / 256))*1.8
alter VD_B7 = $&sar12_drive
let sar12_drive = (floor(sar12_trial / 256) - 2*floor(sar12_trial / 512))*1.8
alter VD_B8 = $&sar12_drive
let sar12_drive = (floor(sar12_trial / 512) - 2*floor(sar12_trial / 1024))*1.8
alter VD_B9 = $&sar12_drive
let sar12_drive = (floor(sar12_trial / 1024) - 2*floor(sar12_trial / 2048))*1.8
alter VD_B10 = $&sar12_drive
let sar12_drive = (floor(sar12_trial / 2048) - 2*floor(sar12_trial / 4096))*1.8
alter VD_B11 = $&sar12_drive
stop when time ge 9.78249999989999e-05
resume
let sar12_k = length(time)-1
if abs(time[sar12_k] - 9.78249999999999e-05) > 1e-12
print time[sar12_k]
echo expected_pause_time_s 9.78249999999999e-05
echo SAR12_PAUSE_FAILED
quit 1
end
print time[sar12_k] >> pause-times.txt
delete all
alter VD_EVAL = 1.8
stop when time ge 9.79999999989999e-05
resume
let sar12_k = length(time)-1
if abs(time[sar12_k] - 9.79999999999999e-05) > 1e-12
print time[sar12_k]
echo expected_pause_time_s 9.79999999999999e-05
echo SAR12_PAUSE_FAILED
quit 1
end
print time[sar12_k] >> pause-times.txt
delete all
let sar12_k = length(time)-1
let sar12_cmp = v(COMP)[sar12_k]
let sar12_cmpn = v(COMPN)[sar12_k]
let sar12_p = v(TOPP)[sar12_k]
let sar12_n = v(TOPN)[sar12_k]
let sar12_decision = 0
if sar12_cmp >= 0.9
let sar12_code = sar12_trial
let sar12_decision = 1
end
echo 9 5 $&sar12_trial $&sar12_cmp $&sar12_cmpn $&sar12_p $&sar12_n 0.00087890625 $&sar12_decision >> decisions.csv
alter VD_EVAL = 0
let sar12_trial = sar12_code + 16
let sar12_drive = (floor(sar12_trial / 1) - 2*floor(sar12_trial / 2))*1.8
alter VD_B0 = $&sar12_drive
let sar12_drive = (floor(sar12_trial / 2) - 2*floor(sar12_trial / 4))*1.8
alter VD_B1 = $&sar12_drive
let sar12_drive = (floor(sar12_trial / 4) - 2*floor(sar12_trial / 8))*1.8
alter VD_B2 = $&sar12_drive
let sar12_drive = (floor(sar12_trial / 8) - 2*floor(sar12_trial / 16))*1.8
alter VD_B3 = $&sar12_drive
let sar12_drive = (floor(sar12_trial / 16) - 2*floor(sar12_trial / 32))*1.8
alter VD_B4 = $&sar12_drive
let sar12_drive = (floor(sar12_trial / 32) - 2*floor(sar12_trial / 64))*1.8
alter VD_B5 = $&sar12_drive
let sar12_drive = (floor(sar12_trial / 64) - 2*floor(sar12_trial / 128))*1.8
alter VD_B6 = $&sar12_drive
let sar12_drive = (floor(sar12_trial / 128) - 2*floor(sar12_trial / 256))*1.8
alter VD_B7 = $&sar12_drive
let sar12_drive = (floor(sar12_trial / 256) - 2*floor(sar12_trial / 512))*1.8
alter VD_B8 = $&sar12_drive
let sar12_drive = (floor(sar12_trial / 512) - 2*floor(sar12_trial / 1024))*1.8
alter VD_B9 = $&sar12_drive
let sar12_drive = (floor(sar12_trial / 1024) - 2*floor(sar12_trial / 2048))*1.8
alter VD_B10 = $&sar12_drive
let sar12_drive = (floor(sar12_trial / 2048) - 2*floor(sar12_trial / 4096))*1.8
alter VD_B11 = $&sar12_drive
stop when time ge 9.83249999989999e-05
resume
let sar12_k = length(time)-1
if abs(time[sar12_k] - 9.83249999999999e-05) > 1e-12
print time[sar12_k]
echo expected_pause_time_s 9.83249999999999e-05
echo SAR12_PAUSE_FAILED
quit 1
end
print time[sar12_k] >> pause-times.txt
delete all
alter VD_EVAL = 1.8
stop when time ge 9.84999999989999e-05
resume
let sar12_k = length(time)-1
if abs(time[sar12_k] - 9.84999999999999e-05) > 1e-12
print time[sar12_k]
echo expected_pause_time_s 9.84999999999999e-05
echo SAR12_PAUSE_FAILED
quit 1
end
print time[sar12_k] >> pause-times.txt
delete all
let sar12_k = length(time)-1
let sar12_cmp = v(COMP)[sar12_k]
let sar12_cmpn = v(COMPN)[sar12_k]
let sar12_p = v(TOPP)[sar12_k]
let sar12_n = v(TOPN)[sar12_k]
let sar12_decision = 0
if sar12_cmp >= 0.9
let sar12_code = sar12_trial
let sar12_decision = 1
end
echo 9 4 $&sar12_trial $&sar12_cmp $&sar12_cmpn $&sar12_p $&sar12_n 0.00087890625 $&sar12_decision >> decisions.csv
alter VD_EVAL = 0
let sar12_trial = sar12_code + 8
let sar12_drive = (floor(sar12_trial / 1) - 2*floor(sar12_trial / 2))*1.8
alter VD_B0 = $&sar12_drive
let sar12_drive = (floor(sar12_trial / 2) - 2*floor(sar12_trial / 4))*1.8
alter VD_B1 = $&sar12_drive
let sar12_drive = (floor(sar12_trial / 4) - 2*floor(sar12_trial / 8))*1.8
alter VD_B2 = $&sar12_drive
let sar12_drive = (floor(sar12_trial / 8) - 2*floor(sar12_trial / 16))*1.8
alter VD_B3 = $&sar12_drive
let sar12_drive = (floor(sar12_trial / 16) - 2*floor(sar12_trial / 32))*1.8
alter VD_B4 = $&sar12_drive
let sar12_drive = (floor(sar12_trial / 32) - 2*floor(sar12_trial / 64))*1.8
alter VD_B5 = $&sar12_drive
let sar12_drive = (floor(sar12_trial / 64) - 2*floor(sar12_trial / 128))*1.8
alter VD_B6 = $&sar12_drive
let sar12_drive = (floor(sar12_trial / 128) - 2*floor(sar12_trial / 256))*1.8
alter VD_B7 = $&sar12_drive
let sar12_drive = (floor(sar12_trial / 256) - 2*floor(sar12_trial / 512))*1.8
alter VD_B8 = $&sar12_drive
let sar12_drive = (floor(sar12_trial / 512) - 2*floor(sar12_trial / 1024))*1.8
alter VD_B9 = $&sar12_drive
let sar12_drive = (floor(sar12_trial / 1024) - 2*floor(sar12_trial / 2048))*1.8
alter VD_B10 = $&sar12_drive
let sar12_drive = (floor(sar12_trial / 2048) - 2*floor(sar12_trial / 4096))*1.8
alter VD_B11 = $&sar12_drive
stop when time ge 9.88249999989999e-05
resume
let sar12_k = length(time)-1
if abs(time[sar12_k] - 9.88249999999999e-05) > 1e-12
print time[sar12_k]
echo expected_pause_time_s 9.88249999999999e-05
echo SAR12_PAUSE_FAILED
quit 1
end
print time[sar12_k] >> pause-times.txt
delete all
alter VD_EVAL = 1.8
stop when time ge 9.89999999989999e-05
resume
let sar12_k = length(time)-1
if abs(time[sar12_k] - 9.89999999999999e-05) > 1e-12
print time[sar12_k]
echo expected_pause_time_s 9.89999999999999e-05
echo SAR12_PAUSE_FAILED
quit 1
end
print time[sar12_k] >> pause-times.txt
delete all
let sar12_k = length(time)-1
let sar12_cmp = v(COMP)[sar12_k]
let sar12_cmpn = v(COMPN)[sar12_k]
let sar12_p = v(TOPP)[sar12_k]
let sar12_n = v(TOPN)[sar12_k]
let sar12_decision = 0
if sar12_cmp >= 0.9
let sar12_code = sar12_trial
let sar12_decision = 1
end
echo 9 3 $&sar12_trial $&sar12_cmp $&sar12_cmpn $&sar12_p $&sar12_n 0.00087890625 $&sar12_decision >> decisions.csv
alter VD_EVAL = 0
let sar12_trial = sar12_code + 4
let sar12_drive = (floor(sar12_trial / 1) - 2*floor(sar12_trial / 2))*1.8
alter VD_B0 = $&sar12_drive
let sar12_drive = (floor(sar12_trial / 2) - 2*floor(sar12_trial / 4))*1.8
alter VD_B1 = $&sar12_drive
let sar12_drive = (floor(sar12_trial / 4) - 2*floor(sar12_trial / 8))*1.8
alter VD_B2 = $&sar12_drive
let sar12_drive = (floor(sar12_trial / 8) - 2*floor(sar12_trial / 16))*1.8
alter VD_B3 = $&sar12_drive
let sar12_drive = (floor(sar12_trial / 16) - 2*floor(sar12_trial / 32))*1.8
alter VD_B4 = $&sar12_drive
let sar12_drive = (floor(sar12_trial / 32) - 2*floor(sar12_trial / 64))*1.8
alter VD_B5 = $&sar12_drive
let sar12_drive = (floor(sar12_trial / 64) - 2*floor(sar12_trial / 128))*1.8
alter VD_B6 = $&sar12_drive
let sar12_drive = (floor(sar12_trial / 128) - 2*floor(sar12_trial / 256))*1.8
alter VD_B7 = $&sar12_drive
let sar12_drive = (floor(sar12_trial / 256) - 2*floor(sar12_trial / 512))*1.8
alter VD_B8 = $&sar12_drive
let sar12_drive = (floor(sar12_trial / 512) - 2*floor(sar12_trial / 1024))*1.8
alter VD_B9 = $&sar12_drive
let sar12_drive = (floor(sar12_trial / 1024) - 2*floor(sar12_trial / 2048))*1.8
alter VD_B10 = $&sar12_drive
let sar12_drive = (floor(sar12_trial / 2048) - 2*floor(sar12_trial / 4096))*1.8
alter VD_B11 = $&sar12_drive
stop when time ge 9.93249999989999e-05
resume
let sar12_k = length(time)-1
if abs(time[sar12_k] - 9.93249999999999e-05) > 1e-12
print time[sar12_k]
echo expected_pause_time_s 9.93249999999999e-05
echo SAR12_PAUSE_FAILED
quit 1
end
print time[sar12_k] >> pause-times.txt
delete all
alter VD_EVAL = 1.8
stop when time ge 9.94999999989999e-05
resume
let sar12_k = length(time)-1
if abs(time[sar12_k] - 9.94999999999999e-05) > 1e-12
print time[sar12_k]
echo expected_pause_time_s 9.94999999999999e-05
echo SAR12_PAUSE_FAILED
quit 1
end
print time[sar12_k] >> pause-times.txt
delete all
let sar12_k = length(time)-1
let sar12_cmp = v(COMP)[sar12_k]
let sar12_cmpn = v(COMPN)[sar12_k]
let sar12_p = v(TOPP)[sar12_k]
let sar12_n = v(TOPN)[sar12_k]
let sar12_decision = 0
if sar12_cmp >= 0.9
let sar12_code = sar12_trial
let sar12_decision = 1
end
echo 9 2 $&sar12_trial $&sar12_cmp $&sar12_cmpn $&sar12_p $&sar12_n 0.00087890625 $&sar12_decision >> decisions.csv
alter VD_EVAL = 0
let sar12_trial = sar12_code + 2
let sar12_drive = (floor(sar12_trial / 1) - 2*floor(sar12_trial / 2))*1.8
alter VD_B0 = $&sar12_drive
let sar12_drive = (floor(sar12_trial / 2) - 2*floor(sar12_trial / 4))*1.8
alter VD_B1 = $&sar12_drive
let sar12_drive = (floor(sar12_trial / 4) - 2*floor(sar12_trial / 8))*1.8
alter VD_B2 = $&sar12_drive
let sar12_drive = (floor(sar12_trial / 8) - 2*floor(sar12_trial / 16))*1.8
alter VD_B3 = $&sar12_drive
let sar12_drive = (floor(sar12_trial / 16) - 2*floor(sar12_trial / 32))*1.8
alter VD_B4 = $&sar12_drive
let sar12_drive = (floor(sar12_trial / 32) - 2*floor(sar12_trial / 64))*1.8
alter VD_B5 = $&sar12_drive
let sar12_drive = (floor(sar12_trial / 64) - 2*floor(sar12_trial / 128))*1.8
alter VD_B6 = $&sar12_drive
let sar12_drive = (floor(sar12_trial / 128) - 2*floor(sar12_trial / 256))*1.8
alter VD_B7 = $&sar12_drive
let sar12_drive = (floor(sar12_trial / 256) - 2*floor(sar12_trial / 512))*1.8
alter VD_B8 = $&sar12_drive
let sar12_drive = (floor(sar12_trial / 512) - 2*floor(sar12_trial / 1024))*1.8
alter VD_B9 = $&sar12_drive
let sar12_drive = (floor(sar12_trial / 1024) - 2*floor(sar12_trial / 2048))*1.8
alter VD_B10 = $&sar12_drive
let sar12_drive = (floor(sar12_trial / 2048) - 2*floor(sar12_trial / 4096))*1.8
alter VD_B11 = $&sar12_drive
stop when time ge 9.98249999989999e-05
resume
let sar12_k = length(time)-1
if abs(time[sar12_k] - 9.98249999999999e-05) > 1e-12
print time[sar12_k]
echo expected_pause_time_s 9.98249999999999e-05
echo SAR12_PAUSE_FAILED
quit 1
end
print time[sar12_k] >> pause-times.txt
delete all
alter VD_EVAL = 1.8
stop when time ge 9.99999999989999e-05
resume
let sar12_k = length(time)-1
if abs(time[sar12_k] - 9.99999999999999e-05) > 1e-12
print time[sar12_k]
echo expected_pause_time_s 9.99999999999999e-05
echo SAR12_PAUSE_FAILED
quit 1
end
print time[sar12_k] >> pause-times.txt
delete all
let sar12_k = length(time)-1
let sar12_cmp = v(COMP)[sar12_k]
let sar12_cmpn = v(COMPN)[sar12_k]
let sar12_p = v(TOPP)[sar12_k]
let sar12_n = v(TOPN)[sar12_k]
let sar12_decision = 0
if sar12_cmp >= 0.9
let sar12_code = sar12_trial
let sar12_decision = 1
end
echo 9 1 $&sar12_trial $&sar12_cmp $&sar12_cmpn $&sar12_p $&sar12_n 0.00087890625 $&sar12_decision >> decisions.csv
alter VD_EVAL = 0
let sar12_trial = sar12_code + 1
let sar12_drive = (floor(sar12_trial / 1) - 2*floor(sar12_trial / 2))*1.8
alter VD_B0 = $&sar12_drive
let sar12_drive = (floor(sar12_trial / 2) - 2*floor(sar12_trial / 4))*1.8
alter VD_B1 = $&sar12_drive
let sar12_drive = (floor(sar12_trial / 4) - 2*floor(sar12_trial / 8))*1.8
alter VD_B2 = $&sar12_drive
let sar12_drive = (floor(sar12_trial / 8) - 2*floor(sar12_trial / 16))*1.8
alter VD_B3 = $&sar12_drive
let sar12_drive = (floor(sar12_trial / 16) - 2*floor(sar12_trial / 32))*1.8
alter VD_B4 = $&sar12_drive
let sar12_drive = (floor(sar12_trial / 32) - 2*floor(sar12_trial / 64))*1.8
alter VD_B5 = $&sar12_drive
let sar12_drive = (floor(sar12_trial / 64) - 2*floor(sar12_trial / 128))*1.8
alter VD_B6 = $&sar12_drive
let sar12_drive = (floor(sar12_trial / 128) - 2*floor(sar12_trial / 256))*1.8
alter VD_B7 = $&sar12_drive
let sar12_drive = (floor(sar12_trial / 256) - 2*floor(sar12_trial / 512))*1.8
alter VD_B8 = $&sar12_drive
let sar12_drive = (floor(sar12_trial / 512) - 2*floor(sar12_trial / 1024))*1.8
alter VD_B9 = $&sar12_drive
let sar12_drive = (floor(sar12_trial / 1024) - 2*floor(sar12_trial / 2048))*1.8
alter VD_B10 = $&sar12_drive
let sar12_drive = (floor(sar12_trial / 2048) - 2*floor(sar12_trial / 4096))*1.8
alter VD_B11 = $&sar12_drive
stop when time ge 0.000100324999999
resume
let sar12_k = length(time)-1
if abs(time[sar12_k] - 0.000100325) > 1e-12
print time[sar12_k]
echo expected_pause_time_s 0.000100325
echo SAR12_PAUSE_FAILED
quit 1
end
print time[sar12_k] >> pause-times.txt
delete all
alter VD_EVAL = 1.8
stop when time ge 0.000100499999999
resume
let sar12_k = length(time)-1
if abs(time[sar12_k] - 0.0001005) > 1e-12
print time[sar12_k]
echo expected_pause_time_s 0.0001005
echo SAR12_PAUSE_FAILED
quit 1
end
print time[sar12_k] >> pause-times.txt
delete all
let sar12_k = length(time)-1
let sar12_cmp = v(COMP)[sar12_k]
let sar12_cmpn = v(COMPN)[sar12_k]
let sar12_p = v(TOPP)[sar12_k]
let sar12_n = v(TOPN)[sar12_k]
let sar12_decision = 0
if sar12_cmp >= 0.9
let sar12_code = sar12_trial
let sar12_decision = 1
end
echo 9 0 $&sar12_trial $&sar12_cmp $&sar12_cmpn $&sar12_p $&sar12_n 0.00087890625 $&sar12_decision >> decisions.csv
alter VD_EVAL = 0
alter VINP = 1.20014648438
alter VINN = 0.599853515625
alter VD_SAMPLE = 1.8
alter VD_EVAL = 0
alter VD_B0 = 0
alter VD_B1 = 0
alter VD_B2 = 0
alter VD_B3 = 0
alter VD_B4 = 0
alter VD_B5 = 0
alter VD_B6 = 0
alter VD_B7 = 0
alter VD_B8 = 0
alter VD_B9 = 0
alter VD_B10 = 0
alter VD_B11 = 0
let sar12_code = 0
stop when time ge 0.000104499999999
resume
let sar12_k = length(time)-1
if abs(time[sar12_k] - 0.0001045) > 1e-12
print time[sar12_k]
echo expected_pause_time_s 0.0001045
echo SAR12_PAUSE_FAILED
quit 1
end
print time[sar12_k] >> pause-times.txt
delete all
alter VD_SAMPLE = 0
stop when time ge 0.000104549999999
resume
let sar12_k = length(time)-1
if abs(time[sar12_k] - 0.00010455) > 1e-12
print time[sar12_k]
echo expected_pause_time_s 0.00010455
echo SAR12_PAUSE_FAILED
quit 1
end
print time[sar12_k] >> pause-times.txt
delete all
alter VD_EVAL = 0
let sar12_trial = sar12_code + 2048
let sar12_drive = (floor(sar12_trial / 1) - 2*floor(sar12_trial / 2))*1.8
alter VD_B0 = $&sar12_drive
let sar12_drive = (floor(sar12_trial / 2) - 2*floor(sar12_trial / 4))*1.8
alter VD_B1 = $&sar12_drive
let sar12_drive = (floor(sar12_trial / 4) - 2*floor(sar12_trial / 8))*1.8
alter VD_B2 = $&sar12_drive
let sar12_drive = (floor(sar12_trial / 8) - 2*floor(sar12_trial / 16))*1.8
alter VD_B3 = $&sar12_drive
let sar12_drive = (floor(sar12_trial / 16) - 2*floor(sar12_trial / 32))*1.8
alter VD_B4 = $&sar12_drive
let sar12_drive = (floor(sar12_trial / 32) - 2*floor(sar12_trial / 64))*1.8
alter VD_B5 = $&sar12_drive
let sar12_drive = (floor(sar12_trial / 64) - 2*floor(sar12_trial / 128))*1.8
alter VD_B6 = $&sar12_drive
let sar12_drive = (floor(sar12_trial / 128) - 2*floor(sar12_trial / 256))*1.8
alter VD_B7 = $&sar12_drive
let sar12_drive = (floor(sar12_trial / 256) - 2*floor(sar12_trial / 512))*1.8
alter VD_B8 = $&sar12_drive
let sar12_drive = (floor(sar12_trial / 512) - 2*floor(sar12_trial / 1024))*1.8
alter VD_B9 = $&sar12_drive
let sar12_drive = (floor(sar12_trial / 1024) - 2*floor(sar12_trial / 2048))*1.8
alter VD_B10 = $&sar12_drive
let sar12_drive = (floor(sar12_trial / 2048) - 2*floor(sar12_trial / 4096))*1.8
alter VD_B11 = $&sar12_drive
stop when time ge 0.000104874999999
resume
let sar12_k = length(time)-1
if abs(time[sar12_k] - 0.000104875) > 1e-12
print time[sar12_k]
echo expected_pause_time_s 0.000104875
echo SAR12_PAUSE_FAILED
quit 1
end
print time[sar12_k] >> pause-times.txt
delete all
alter VD_EVAL = 1.8
stop when time ge 0.000105049999999
resume
let sar12_k = length(time)-1
if abs(time[sar12_k] - 0.00010505) > 1e-12
print time[sar12_k]
echo expected_pause_time_s 0.00010505
echo SAR12_PAUSE_FAILED
quit 1
end
print time[sar12_k] >> pause-times.txt
delete all
let sar12_k = length(time)-1
let sar12_cmp = v(COMP)[sar12_k]
let sar12_cmpn = v(COMPN)[sar12_k]
let sar12_p = v(TOPP)[sar12_k]
let sar12_n = v(TOPN)[sar12_k]
let sar12_decision = 0
if sar12_cmp >= 0.9
let sar12_code = sar12_trial
let sar12_decision = 1
end
echo 10 11 $&sar12_trial $&sar12_cmp $&sar12_cmpn $&sar12_p $&sar12_n 0.60029296875 $&sar12_decision >> decisions.csv
alter VD_EVAL = 0
let sar12_trial = sar12_code + 1024
let sar12_drive = (floor(sar12_trial / 1) - 2*floor(sar12_trial / 2))*1.8
alter VD_B0 = $&sar12_drive
let sar12_drive = (floor(sar12_trial / 2) - 2*floor(sar12_trial / 4))*1.8
alter VD_B1 = $&sar12_drive
let sar12_drive = (floor(sar12_trial / 4) - 2*floor(sar12_trial / 8))*1.8
alter VD_B2 = $&sar12_drive
let sar12_drive = (floor(sar12_trial / 8) - 2*floor(sar12_trial / 16))*1.8
alter VD_B3 = $&sar12_drive
let sar12_drive = (floor(sar12_trial / 16) - 2*floor(sar12_trial / 32))*1.8
alter VD_B4 = $&sar12_drive
let sar12_drive = (floor(sar12_trial / 32) - 2*floor(sar12_trial / 64))*1.8
alter VD_B5 = $&sar12_drive
let sar12_drive = (floor(sar12_trial / 64) - 2*floor(sar12_trial / 128))*1.8
alter VD_B6 = $&sar12_drive
let sar12_drive = (floor(sar12_trial / 128) - 2*floor(sar12_trial / 256))*1.8
alter VD_B7 = $&sar12_drive
let sar12_drive = (floor(sar12_trial / 256) - 2*floor(sar12_trial / 512))*1.8
alter VD_B8 = $&sar12_drive
let sar12_drive = (floor(sar12_trial / 512) - 2*floor(sar12_trial / 1024))*1.8
alter VD_B9 = $&sar12_drive
let sar12_drive = (floor(sar12_trial / 1024) - 2*floor(sar12_trial / 2048))*1.8
alter VD_B10 = $&sar12_drive
let sar12_drive = (floor(sar12_trial / 2048) - 2*floor(sar12_trial / 4096))*1.8
alter VD_B11 = $&sar12_drive
stop when time ge 0.000105374999999
resume
let sar12_k = length(time)-1
if abs(time[sar12_k] - 0.000105375) > 1e-12
print time[sar12_k]
echo expected_pause_time_s 0.000105375
echo SAR12_PAUSE_FAILED
quit 1
end
print time[sar12_k] >> pause-times.txt
delete all
alter VD_EVAL = 1.8
stop when time ge 0.000105549999999
resume
let sar12_k = length(time)-1
if abs(time[sar12_k] - 0.00010555) > 1e-12
print time[sar12_k]
echo expected_pause_time_s 0.00010555
echo SAR12_PAUSE_FAILED
quit 1
end
print time[sar12_k] >> pause-times.txt
delete all
let sar12_k = length(time)-1
let sar12_cmp = v(COMP)[sar12_k]
let sar12_cmpn = v(COMPN)[sar12_k]
let sar12_p = v(TOPP)[sar12_k]
let sar12_n = v(TOPN)[sar12_k]
let sar12_decision = 0
if sar12_cmp >= 0.9
let sar12_code = sar12_trial
let sar12_decision = 1
end
echo 10 10 $&sar12_trial $&sar12_cmp $&sar12_cmpn $&sar12_p $&sar12_n 0.60029296875 $&sar12_decision >> decisions.csv
alter VD_EVAL = 0
let sar12_trial = sar12_code + 512
let sar12_drive = (floor(sar12_trial / 1) - 2*floor(sar12_trial / 2))*1.8
alter VD_B0 = $&sar12_drive
let sar12_drive = (floor(sar12_trial / 2) - 2*floor(sar12_trial / 4))*1.8
alter VD_B1 = $&sar12_drive
let sar12_drive = (floor(sar12_trial / 4) - 2*floor(sar12_trial / 8))*1.8
alter VD_B2 = $&sar12_drive
let sar12_drive = (floor(sar12_trial / 8) - 2*floor(sar12_trial / 16))*1.8
alter VD_B3 = $&sar12_drive
let sar12_drive = (floor(sar12_trial / 16) - 2*floor(sar12_trial / 32))*1.8
alter VD_B4 = $&sar12_drive
let sar12_drive = (floor(sar12_trial / 32) - 2*floor(sar12_trial / 64))*1.8
alter VD_B5 = $&sar12_drive
let sar12_drive = (floor(sar12_trial / 64) - 2*floor(sar12_trial / 128))*1.8
alter VD_B6 = $&sar12_drive
let sar12_drive = (floor(sar12_trial / 128) - 2*floor(sar12_trial / 256))*1.8
alter VD_B7 = $&sar12_drive
let sar12_drive = (floor(sar12_trial / 256) - 2*floor(sar12_trial / 512))*1.8
alter VD_B8 = $&sar12_drive
let sar12_drive = (floor(sar12_trial / 512) - 2*floor(sar12_trial / 1024))*1.8
alter VD_B9 = $&sar12_drive
let sar12_drive = (floor(sar12_trial / 1024) - 2*floor(sar12_trial / 2048))*1.8
alter VD_B10 = $&sar12_drive
let sar12_drive = (floor(sar12_trial / 2048) - 2*floor(sar12_trial / 4096))*1.8
alter VD_B11 = $&sar12_drive
stop when time ge 0.000105874999999
resume
let sar12_k = length(time)-1
if abs(time[sar12_k] - 0.000105875) > 1e-12
print time[sar12_k]
echo expected_pause_time_s 0.000105875
echo SAR12_PAUSE_FAILED
quit 1
end
print time[sar12_k] >> pause-times.txt
delete all
alter VD_EVAL = 1.8
stop when time ge 0.000106049999999
resume
let sar12_k = length(time)-1
if abs(time[sar12_k] - 0.00010605) > 1e-12
print time[sar12_k]
echo expected_pause_time_s 0.00010605
echo SAR12_PAUSE_FAILED
quit 1
end
print time[sar12_k] >> pause-times.txt
delete all
let sar12_k = length(time)-1
let sar12_cmp = v(COMP)[sar12_k]
let sar12_cmpn = v(COMPN)[sar12_k]
let sar12_p = v(TOPP)[sar12_k]
let sar12_n = v(TOPN)[sar12_k]
let sar12_decision = 0
if sar12_cmp >= 0.9
let sar12_code = sar12_trial
let sar12_decision = 1
end
echo 10 9 $&sar12_trial $&sar12_cmp $&sar12_cmpn $&sar12_p $&sar12_n 0.60029296875 $&sar12_decision >> decisions.csv
alter VD_EVAL = 0
let sar12_trial = sar12_code + 256
let sar12_drive = (floor(sar12_trial / 1) - 2*floor(sar12_trial / 2))*1.8
alter VD_B0 = $&sar12_drive
let sar12_drive = (floor(sar12_trial / 2) - 2*floor(sar12_trial / 4))*1.8
alter VD_B1 = $&sar12_drive
let sar12_drive = (floor(sar12_trial / 4) - 2*floor(sar12_trial / 8))*1.8
alter VD_B2 = $&sar12_drive
let sar12_drive = (floor(sar12_trial / 8) - 2*floor(sar12_trial / 16))*1.8
alter VD_B3 = $&sar12_drive
let sar12_drive = (floor(sar12_trial / 16) - 2*floor(sar12_trial / 32))*1.8
alter VD_B4 = $&sar12_drive
let sar12_drive = (floor(sar12_trial / 32) - 2*floor(sar12_trial / 64))*1.8
alter VD_B5 = $&sar12_drive
let sar12_drive = (floor(sar12_trial / 64) - 2*floor(sar12_trial / 128))*1.8
alter VD_B6 = $&sar12_drive
let sar12_drive = (floor(sar12_trial / 128) - 2*floor(sar12_trial / 256))*1.8
alter VD_B7 = $&sar12_drive
let sar12_drive = (floor(sar12_trial / 256) - 2*floor(sar12_trial / 512))*1.8
alter VD_B8 = $&sar12_drive
let sar12_drive = (floor(sar12_trial / 512) - 2*floor(sar12_trial / 1024))*1.8
alter VD_B9 = $&sar12_drive
let sar12_drive = (floor(sar12_trial / 1024) - 2*floor(sar12_trial / 2048))*1.8
alter VD_B10 = $&sar12_drive
let sar12_drive = (floor(sar12_trial / 2048) - 2*floor(sar12_trial / 4096))*1.8
alter VD_B11 = $&sar12_drive
stop when time ge 0.000106374999999
resume
let sar12_k = length(time)-1
if abs(time[sar12_k] - 0.000106375) > 1e-12
print time[sar12_k]
echo expected_pause_time_s 0.000106375
echo SAR12_PAUSE_FAILED
quit 1
end
print time[sar12_k] >> pause-times.txt
delete all
alter VD_EVAL = 1.8
stop when time ge 0.000106549999999
resume
let sar12_k = length(time)-1
if abs(time[sar12_k] - 0.00010655) > 1e-12
print time[sar12_k]
echo expected_pause_time_s 0.00010655
echo SAR12_PAUSE_FAILED
quit 1
end
print time[sar12_k] >> pause-times.txt
delete all
let sar12_k = length(time)-1
let sar12_cmp = v(COMP)[sar12_k]
let sar12_cmpn = v(COMPN)[sar12_k]
let sar12_p = v(TOPP)[sar12_k]
let sar12_n = v(TOPN)[sar12_k]
let sar12_decision = 0
if sar12_cmp >= 0.9
let sar12_code = sar12_trial
let sar12_decision = 1
end
echo 10 8 $&sar12_trial $&sar12_cmp $&sar12_cmpn $&sar12_p $&sar12_n 0.60029296875 $&sar12_decision >> decisions.csv
alter VD_EVAL = 0
let sar12_trial = sar12_code + 128
let sar12_drive = (floor(sar12_trial / 1) - 2*floor(sar12_trial / 2))*1.8
alter VD_B0 = $&sar12_drive
let sar12_drive = (floor(sar12_trial / 2) - 2*floor(sar12_trial / 4))*1.8
alter VD_B1 = $&sar12_drive
let sar12_drive = (floor(sar12_trial / 4) - 2*floor(sar12_trial / 8))*1.8
alter VD_B2 = $&sar12_drive
let sar12_drive = (floor(sar12_trial / 8) - 2*floor(sar12_trial / 16))*1.8
alter VD_B3 = $&sar12_drive
let sar12_drive = (floor(sar12_trial / 16) - 2*floor(sar12_trial / 32))*1.8
alter VD_B4 = $&sar12_drive
let sar12_drive = (floor(sar12_trial / 32) - 2*floor(sar12_trial / 64))*1.8
alter VD_B5 = $&sar12_drive
let sar12_drive = (floor(sar12_trial / 64) - 2*floor(sar12_trial / 128))*1.8
alter VD_B6 = $&sar12_drive
let sar12_drive = (floor(sar12_trial / 128) - 2*floor(sar12_trial / 256))*1.8
alter VD_B7 = $&sar12_drive
let sar12_drive = (floor(sar12_trial / 256) - 2*floor(sar12_trial / 512))*1.8
alter VD_B8 = $&sar12_drive
let sar12_drive = (floor(sar12_trial / 512) - 2*floor(sar12_trial / 1024))*1.8
alter VD_B9 = $&sar12_drive
let sar12_drive = (floor(sar12_trial / 1024) - 2*floor(sar12_trial / 2048))*1.8
alter VD_B10 = $&sar12_drive
let sar12_drive = (floor(sar12_trial / 2048) - 2*floor(sar12_trial / 4096))*1.8
alter VD_B11 = $&sar12_drive
stop when time ge 0.000106874999999
resume
let sar12_k = length(time)-1
if abs(time[sar12_k] - 0.000106875) > 1e-12
print time[sar12_k]
echo expected_pause_time_s 0.000106875
echo SAR12_PAUSE_FAILED
quit 1
end
print time[sar12_k] >> pause-times.txt
delete all
alter VD_EVAL = 1.8
stop when time ge 0.000107049999999
resume
let sar12_k = length(time)-1
if abs(time[sar12_k] - 0.00010705) > 1e-12
print time[sar12_k]
echo expected_pause_time_s 0.00010705
echo SAR12_PAUSE_FAILED
quit 1
end
print time[sar12_k] >> pause-times.txt
delete all
let sar12_k = length(time)-1
let sar12_cmp = v(COMP)[sar12_k]
let sar12_cmpn = v(COMPN)[sar12_k]
let sar12_p = v(TOPP)[sar12_k]
let sar12_n = v(TOPN)[sar12_k]
let sar12_decision = 0
if sar12_cmp >= 0.9
let sar12_code = sar12_trial
let sar12_decision = 1
end
echo 10 7 $&sar12_trial $&sar12_cmp $&sar12_cmpn $&sar12_p $&sar12_n 0.60029296875 $&sar12_decision >> decisions.csv
alter VD_EVAL = 0
let sar12_trial = sar12_code + 64
let sar12_drive = (floor(sar12_trial / 1) - 2*floor(sar12_trial / 2))*1.8
alter VD_B0 = $&sar12_drive
let sar12_drive = (floor(sar12_trial / 2) - 2*floor(sar12_trial / 4))*1.8
alter VD_B1 = $&sar12_drive
let sar12_drive = (floor(sar12_trial / 4) - 2*floor(sar12_trial / 8))*1.8
alter VD_B2 = $&sar12_drive
let sar12_drive = (floor(sar12_trial / 8) - 2*floor(sar12_trial / 16))*1.8
alter VD_B3 = $&sar12_drive
let sar12_drive = (floor(sar12_trial / 16) - 2*floor(sar12_trial / 32))*1.8
alter VD_B4 = $&sar12_drive
let sar12_drive = (floor(sar12_trial / 32) - 2*floor(sar12_trial / 64))*1.8
alter VD_B5 = $&sar12_drive
let sar12_drive = (floor(sar12_trial / 64) - 2*floor(sar12_trial / 128))*1.8
alter VD_B6 = $&sar12_drive
let sar12_drive = (floor(sar12_trial / 128) - 2*floor(sar12_trial / 256))*1.8
alter VD_B7 = $&sar12_drive
let sar12_drive = (floor(sar12_trial / 256) - 2*floor(sar12_trial / 512))*1.8
alter VD_B8 = $&sar12_drive
let sar12_drive = (floor(sar12_trial / 512) - 2*floor(sar12_trial / 1024))*1.8
alter VD_B9 = $&sar12_drive
let sar12_drive = (floor(sar12_trial / 1024) - 2*floor(sar12_trial / 2048))*1.8
alter VD_B10 = $&sar12_drive
let sar12_drive = (floor(sar12_trial / 2048) - 2*floor(sar12_trial / 4096))*1.8
alter VD_B11 = $&sar12_drive
stop when time ge 0.000107374999999
resume
let sar12_k = length(time)-1
if abs(time[sar12_k] - 0.000107375) > 1e-12
print time[sar12_k]
echo expected_pause_time_s 0.000107375
echo SAR12_PAUSE_FAILED
quit 1
end
print time[sar12_k] >> pause-times.txt
delete all
alter VD_EVAL = 1.8
stop when time ge 0.000107549999999
resume
let sar12_k = length(time)-1
if abs(time[sar12_k] - 0.00010755) > 1e-12
print time[sar12_k]
echo expected_pause_time_s 0.00010755
echo SAR12_PAUSE_FAILED
quit 1
end
print time[sar12_k] >> pause-times.txt
delete all
let sar12_k = length(time)-1
let sar12_cmp = v(COMP)[sar12_k]
let sar12_cmpn = v(COMPN)[sar12_k]
let sar12_p = v(TOPP)[sar12_k]
let sar12_n = v(TOPN)[sar12_k]
let sar12_decision = 0
if sar12_cmp >= 0.9
let sar12_code = sar12_trial
let sar12_decision = 1
end
echo 10 6 $&sar12_trial $&sar12_cmp $&sar12_cmpn $&sar12_p $&sar12_n 0.60029296875 $&sar12_decision >> decisions.csv
alter VD_EVAL = 0
let sar12_trial = sar12_code + 32
let sar12_drive = (floor(sar12_trial / 1) - 2*floor(sar12_trial / 2))*1.8
alter VD_B0 = $&sar12_drive
let sar12_drive = (floor(sar12_trial / 2) - 2*floor(sar12_trial / 4))*1.8
alter VD_B1 = $&sar12_drive
let sar12_drive = (floor(sar12_trial / 4) - 2*floor(sar12_trial / 8))*1.8
alter VD_B2 = $&sar12_drive
let sar12_drive = (floor(sar12_trial / 8) - 2*floor(sar12_trial / 16))*1.8
alter VD_B3 = $&sar12_drive
let sar12_drive = (floor(sar12_trial / 16) - 2*floor(sar12_trial / 32))*1.8
alter VD_B4 = $&sar12_drive
let sar12_drive = (floor(sar12_trial / 32) - 2*floor(sar12_trial / 64))*1.8
alter VD_B5 = $&sar12_drive
let sar12_drive = (floor(sar12_trial / 64) - 2*floor(sar12_trial / 128))*1.8
alter VD_B6 = $&sar12_drive
let sar12_drive = (floor(sar12_trial / 128) - 2*floor(sar12_trial / 256))*1.8
alter VD_B7 = $&sar12_drive
let sar12_drive = (floor(sar12_trial / 256) - 2*floor(sar12_trial / 512))*1.8
alter VD_B8 = $&sar12_drive
let sar12_drive = (floor(sar12_trial / 512) - 2*floor(sar12_trial / 1024))*1.8
alter VD_B9 = $&sar12_drive
let sar12_drive = (floor(sar12_trial / 1024) - 2*floor(sar12_trial / 2048))*1.8
alter VD_B10 = $&sar12_drive
let sar12_drive = (floor(sar12_trial / 2048) - 2*floor(sar12_trial / 4096))*1.8
alter VD_B11 = $&sar12_drive
stop when time ge 0.000107874999999
resume
let sar12_k = length(time)-1
if abs(time[sar12_k] - 0.000107875) > 1e-12
print time[sar12_k]
echo expected_pause_time_s 0.000107875
echo SAR12_PAUSE_FAILED
quit 1
end
print time[sar12_k] >> pause-times.txt
delete all
alter VD_EVAL = 1.8
stop when time ge 0.000108049999999
resume
let sar12_k = length(time)-1
if abs(time[sar12_k] - 0.00010805) > 1e-12
print time[sar12_k]
echo expected_pause_time_s 0.00010805
echo SAR12_PAUSE_FAILED
quit 1
end
print time[sar12_k] >> pause-times.txt
delete all
let sar12_k = length(time)-1
let sar12_cmp = v(COMP)[sar12_k]
let sar12_cmpn = v(COMPN)[sar12_k]
let sar12_p = v(TOPP)[sar12_k]
let sar12_n = v(TOPN)[sar12_k]
let sar12_decision = 0
if sar12_cmp >= 0.9
let sar12_code = sar12_trial
let sar12_decision = 1
end
echo 10 5 $&sar12_trial $&sar12_cmp $&sar12_cmpn $&sar12_p $&sar12_n 0.60029296875 $&sar12_decision >> decisions.csv
alter VD_EVAL = 0
let sar12_trial = sar12_code + 16
let sar12_drive = (floor(sar12_trial / 1) - 2*floor(sar12_trial / 2))*1.8
alter VD_B0 = $&sar12_drive
let sar12_drive = (floor(sar12_trial / 2) - 2*floor(sar12_trial / 4))*1.8
alter VD_B1 = $&sar12_drive
let sar12_drive = (floor(sar12_trial / 4) - 2*floor(sar12_trial / 8))*1.8
alter VD_B2 = $&sar12_drive
let sar12_drive = (floor(sar12_trial / 8) - 2*floor(sar12_trial / 16))*1.8
alter VD_B3 = $&sar12_drive
let sar12_drive = (floor(sar12_trial / 16) - 2*floor(sar12_trial / 32))*1.8
alter VD_B4 = $&sar12_drive
let sar12_drive = (floor(sar12_trial / 32) - 2*floor(sar12_trial / 64))*1.8
alter VD_B5 = $&sar12_drive
let sar12_drive = (floor(sar12_trial / 64) - 2*floor(sar12_trial / 128))*1.8
alter VD_B6 = $&sar12_drive
let sar12_drive = (floor(sar12_trial / 128) - 2*floor(sar12_trial / 256))*1.8
alter VD_B7 = $&sar12_drive
let sar12_drive = (floor(sar12_trial / 256) - 2*floor(sar12_trial / 512))*1.8
alter VD_B8 = $&sar12_drive
let sar12_drive = (floor(sar12_trial / 512) - 2*floor(sar12_trial / 1024))*1.8
alter VD_B9 = $&sar12_drive
let sar12_drive = (floor(sar12_trial / 1024) - 2*floor(sar12_trial / 2048))*1.8
alter VD_B10 = $&sar12_drive
let sar12_drive = (floor(sar12_trial / 2048) - 2*floor(sar12_trial / 4096))*1.8
alter VD_B11 = $&sar12_drive
stop when time ge 0.000108374999999
resume
let sar12_k = length(time)-1
if abs(time[sar12_k] - 0.000108375) > 1e-12
print time[sar12_k]
echo expected_pause_time_s 0.000108375
echo SAR12_PAUSE_FAILED
quit 1
end
print time[sar12_k] >> pause-times.txt
delete all
alter VD_EVAL = 1.8
stop when time ge 0.000108549999999
resume
let sar12_k = length(time)-1
if abs(time[sar12_k] - 0.00010855) > 1e-12
print time[sar12_k]
echo expected_pause_time_s 0.00010855
echo SAR12_PAUSE_FAILED
quit 1
end
print time[sar12_k] >> pause-times.txt
delete all
let sar12_k = length(time)-1
let sar12_cmp = v(COMP)[sar12_k]
let sar12_cmpn = v(COMPN)[sar12_k]
let sar12_p = v(TOPP)[sar12_k]
let sar12_n = v(TOPN)[sar12_k]
let sar12_decision = 0
if sar12_cmp >= 0.9
let sar12_code = sar12_trial
let sar12_decision = 1
end
echo 10 4 $&sar12_trial $&sar12_cmp $&sar12_cmpn $&sar12_p $&sar12_n 0.60029296875 $&sar12_decision >> decisions.csv
alter VD_EVAL = 0
let sar12_trial = sar12_code + 8
let sar12_drive = (floor(sar12_trial / 1) - 2*floor(sar12_trial / 2))*1.8
alter VD_B0 = $&sar12_drive
let sar12_drive = (floor(sar12_trial / 2) - 2*floor(sar12_trial / 4))*1.8
alter VD_B1 = $&sar12_drive
let sar12_drive = (floor(sar12_trial / 4) - 2*floor(sar12_trial / 8))*1.8
alter VD_B2 = $&sar12_drive
let sar12_drive = (floor(sar12_trial / 8) - 2*floor(sar12_trial / 16))*1.8
alter VD_B3 = $&sar12_drive
let sar12_drive = (floor(sar12_trial / 16) - 2*floor(sar12_trial / 32))*1.8
alter VD_B4 = $&sar12_drive
let sar12_drive = (floor(sar12_trial / 32) - 2*floor(sar12_trial / 64))*1.8
alter VD_B5 = $&sar12_drive
let sar12_drive = (floor(sar12_trial / 64) - 2*floor(sar12_trial / 128))*1.8
alter VD_B6 = $&sar12_drive
let sar12_drive = (floor(sar12_trial / 128) - 2*floor(sar12_trial / 256))*1.8
alter VD_B7 = $&sar12_drive
let sar12_drive = (floor(sar12_trial / 256) - 2*floor(sar12_trial / 512))*1.8
alter VD_B8 = $&sar12_drive
let sar12_drive = (floor(sar12_trial / 512) - 2*floor(sar12_trial / 1024))*1.8
alter VD_B9 = $&sar12_drive
let sar12_drive = (floor(sar12_trial / 1024) - 2*floor(sar12_trial / 2048))*1.8
alter VD_B10 = $&sar12_drive
let sar12_drive = (floor(sar12_trial / 2048) - 2*floor(sar12_trial / 4096))*1.8
alter VD_B11 = $&sar12_drive
stop when time ge 0.000108874999999
resume
let sar12_k = length(time)-1
if abs(time[sar12_k] - 0.000108875) > 1e-12
print time[sar12_k]
echo expected_pause_time_s 0.000108875
echo SAR12_PAUSE_FAILED
quit 1
end
print time[sar12_k] >> pause-times.txt
delete all
alter VD_EVAL = 1.8
stop when time ge 0.000109049999999
resume
let sar12_k = length(time)-1
if abs(time[sar12_k] - 0.00010905) > 1e-12
print time[sar12_k]
echo expected_pause_time_s 0.00010905
echo SAR12_PAUSE_FAILED
quit 1
end
print time[sar12_k] >> pause-times.txt
delete all
let sar12_k = length(time)-1
let sar12_cmp = v(COMP)[sar12_k]
let sar12_cmpn = v(COMPN)[sar12_k]
let sar12_p = v(TOPP)[sar12_k]
let sar12_n = v(TOPN)[sar12_k]
let sar12_decision = 0
if sar12_cmp >= 0.9
let sar12_code = sar12_trial
let sar12_decision = 1
end
echo 10 3 $&sar12_trial $&sar12_cmp $&sar12_cmpn $&sar12_p $&sar12_n 0.60029296875 $&sar12_decision >> decisions.csv
alter VD_EVAL = 0
let sar12_trial = sar12_code + 4
let sar12_drive = (floor(sar12_trial / 1) - 2*floor(sar12_trial / 2))*1.8
alter VD_B0 = $&sar12_drive
let sar12_drive = (floor(sar12_trial / 2) - 2*floor(sar12_trial / 4))*1.8
alter VD_B1 = $&sar12_drive
let sar12_drive = (floor(sar12_trial / 4) - 2*floor(sar12_trial / 8))*1.8
alter VD_B2 = $&sar12_drive
let sar12_drive = (floor(sar12_trial / 8) - 2*floor(sar12_trial / 16))*1.8
alter VD_B3 = $&sar12_drive
let sar12_drive = (floor(sar12_trial / 16) - 2*floor(sar12_trial / 32))*1.8
alter VD_B4 = $&sar12_drive
let sar12_drive = (floor(sar12_trial / 32) - 2*floor(sar12_trial / 64))*1.8
alter VD_B5 = $&sar12_drive
let sar12_drive = (floor(sar12_trial / 64) - 2*floor(sar12_trial / 128))*1.8
alter VD_B6 = $&sar12_drive
let sar12_drive = (floor(sar12_trial / 128) - 2*floor(sar12_trial / 256))*1.8
alter VD_B7 = $&sar12_drive
let sar12_drive = (floor(sar12_trial / 256) - 2*floor(sar12_trial / 512))*1.8
alter VD_B8 = $&sar12_drive
let sar12_drive = (floor(sar12_trial / 512) - 2*floor(sar12_trial / 1024))*1.8
alter VD_B9 = $&sar12_drive
let sar12_drive = (floor(sar12_trial / 1024) - 2*floor(sar12_trial / 2048))*1.8
alter VD_B10 = $&sar12_drive
let sar12_drive = (floor(sar12_trial / 2048) - 2*floor(sar12_trial / 4096))*1.8
alter VD_B11 = $&sar12_drive
stop when time ge 0.000109374999999
resume
let sar12_k = length(time)-1
if abs(time[sar12_k] - 0.000109375) > 1e-12
print time[sar12_k]
echo expected_pause_time_s 0.000109375
echo SAR12_PAUSE_FAILED
quit 1
end
print time[sar12_k] >> pause-times.txt
delete all
alter VD_EVAL = 1.8
stop when time ge 0.000109549999999
resume
let sar12_k = length(time)-1
if abs(time[sar12_k] - 0.00010955) > 1e-12
print time[sar12_k]
echo expected_pause_time_s 0.00010955
echo SAR12_PAUSE_FAILED
quit 1
end
print time[sar12_k] >> pause-times.txt
delete all
let sar12_k = length(time)-1
let sar12_cmp = v(COMP)[sar12_k]
let sar12_cmpn = v(COMPN)[sar12_k]
let sar12_p = v(TOPP)[sar12_k]
let sar12_n = v(TOPN)[sar12_k]
let sar12_decision = 0
if sar12_cmp >= 0.9
let sar12_code = sar12_trial
let sar12_decision = 1
end
echo 10 2 $&sar12_trial $&sar12_cmp $&sar12_cmpn $&sar12_p $&sar12_n 0.60029296875 $&sar12_decision >> decisions.csv
alter VD_EVAL = 0
let sar12_trial = sar12_code + 2
let sar12_drive = (floor(sar12_trial / 1) - 2*floor(sar12_trial / 2))*1.8
alter VD_B0 = $&sar12_drive
let sar12_drive = (floor(sar12_trial / 2) - 2*floor(sar12_trial / 4))*1.8
alter VD_B1 = $&sar12_drive
let sar12_drive = (floor(sar12_trial / 4) - 2*floor(sar12_trial / 8))*1.8
alter VD_B2 = $&sar12_drive
let sar12_drive = (floor(sar12_trial / 8) - 2*floor(sar12_trial / 16))*1.8
alter VD_B3 = $&sar12_drive
let sar12_drive = (floor(sar12_trial / 16) - 2*floor(sar12_trial / 32))*1.8
alter VD_B4 = $&sar12_drive
let sar12_drive = (floor(sar12_trial / 32) - 2*floor(sar12_trial / 64))*1.8
alter VD_B5 = $&sar12_drive
let sar12_drive = (floor(sar12_trial / 64) - 2*floor(sar12_trial / 128))*1.8
alter VD_B6 = $&sar12_drive
let sar12_drive = (floor(sar12_trial / 128) - 2*floor(sar12_trial / 256))*1.8
alter VD_B7 = $&sar12_drive
let sar12_drive = (floor(sar12_trial / 256) - 2*floor(sar12_trial / 512))*1.8
alter VD_B8 = $&sar12_drive
let sar12_drive = (floor(sar12_trial / 512) - 2*floor(sar12_trial / 1024))*1.8
alter VD_B9 = $&sar12_drive
let sar12_drive = (floor(sar12_trial / 1024) - 2*floor(sar12_trial / 2048))*1.8
alter VD_B10 = $&sar12_drive
let sar12_drive = (floor(sar12_trial / 2048) - 2*floor(sar12_trial / 4096))*1.8
alter VD_B11 = $&sar12_drive
stop when time ge 0.000109874999999
resume
let sar12_k = length(time)-1
if abs(time[sar12_k] - 0.000109875) > 1e-12
print time[sar12_k]
echo expected_pause_time_s 0.000109875
echo SAR12_PAUSE_FAILED
quit 1
end
print time[sar12_k] >> pause-times.txt
delete all
alter VD_EVAL = 1.8
stop when time ge 0.000110049999999
resume
let sar12_k = length(time)-1
if abs(time[sar12_k] - 0.00011005) > 1e-12
print time[sar12_k]
echo expected_pause_time_s 0.00011005
echo SAR12_PAUSE_FAILED
quit 1
end
print time[sar12_k] >> pause-times.txt
delete all
let sar12_k = length(time)-1
let sar12_cmp = v(COMP)[sar12_k]
let sar12_cmpn = v(COMPN)[sar12_k]
let sar12_p = v(TOPP)[sar12_k]
let sar12_n = v(TOPN)[sar12_k]
let sar12_decision = 0
if sar12_cmp >= 0.9
let sar12_code = sar12_trial
let sar12_decision = 1
end
echo 10 1 $&sar12_trial $&sar12_cmp $&sar12_cmpn $&sar12_p $&sar12_n 0.60029296875 $&sar12_decision >> decisions.csv
alter VD_EVAL = 0
let sar12_trial = sar12_code + 1
let sar12_drive = (floor(sar12_trial / 1) - 2*floor(sar12_trial / 2))*1.8
alter VD_B0 = $&sar12_drive
let sar12_drive = (floor(sar12_trial / 2) - 2*floor(sar12_trial / 4))*1.8
alter VD_B1 = $&sar12_drive
let sar12_drive = (floor(sar12_trial / 4) - 2*floor(sar12_trial / 8))*1.8
alter VD_B2 = $&sar12_drive
let sar12_drive = (floor(sar12_trial / 8) - 2*floor(sar12_trial / 16))*1.8
alter VD_B3 = $&sar12_drive
let sar12_drive = (floor(sar12_trial / 16) - 2*floor(sar12_trial / 32))*1.8
alter VD_B4 = $&sar12_drive
let sar12_drive = (floor(sar12_trial / 32) - 2*floor(sar12_trial / 64))*1.8
alter VD_B5 = $&sar12_drive
let sar12_drive = (floor(sar12_trial / 64) - 2*floor(sar12_trial / 128))*1.8
alter VD_B6 = $&sar12_drive
let sar12_drive = (floor(sar12_trial / 128) - 2*floor(sar12_trial / 256))*1.8
alter VD_B7 = $&sar12_drive
let sar12_drive = (floor(sar12_trial / 256) - 2*floor(sar12_trial / 512))*1.8
alter VD_B8 = $&sar12_drive
let sar12_drive = (floor(sar12_trial / 512) - 2*floor(sar12_trial / 1024))*1.8
alter VD_B9 = $&sar12_drive
let sar12_drive = (floor(sar12_trial / 1024) - 2*floor(sar12_trial / 2048))*1.8
alter VD_B10 = $&sar12_drive
let sar12_drive = (floor(sar12_trial / 2048) - 2*floor(sar12_trial / 4096))*1.8
alter VD_B11 = $&sar12_drive
stop when time ge 0.000110374999999
resume
let sar12_k = length(time)-1
if abs(time[sar12_k] - 0.000110375) > 1e-12
print time[sar12_k]
echo expected_pause_time_s 0.000110375
echo SAR12_PAUSE_FAILED
quit 1
end
print time[sar12_k] >> pause-times.txt
delete all
alter VD_EVAL = 1.8
stop when time ge 0.000110549999999
resume
let sar12_k = length(time)-1
if abs(time[sar12_k] - 0.00011055) > 1e-12
print time[sar12_k]
echo expected_pause_time_s 0.00011055
echo SAR12_PAUSE_FAILED
quit 1
end
print time[sar12_k] >> pause-times.txt
delete all
let sar12_k = length(time)-1
let sar12_cmp = v(COMP)[sar12_k]
let sar12_cmpn = v(COMPN)[sar12_k]
let sar12_p = v(TOPP)[sar12_k]
let sar12_n = v(TOPN)[sar12_k]
let sar12_decision = 0
if sar12_cmp >= 0.9
let sar12_code = sar12_trial
let sar12_decision = 1
end
echo 10 0 $&sar12_trial $&sar12_cmp $&sar12_cmpn $&sar12_p $&sar12_n 0.60029296875 $&sar12_decision >> decisions.csv
alter VD_EVAL = 0
alter VINP = 1.48110351563
alter VINN = 0.318896484375
alter VD_SAMPLE = 1.8
alter VD_EVAL = 0
alter VD_B0 = 0
alter VD_B1 = 0
alter VD_B2 = 0
alter VD_B3 = 0
alter VD_B4 = 0
alter VD_B5 = 0
alter VD_B6 = 0
alter VD_B7 = 0
alter VD_B8 = 0
alter VD_B9 = 0
alter VD_B10 = 0
alter VD_B11 = 0
let sar12_code = 0
stop when time ge 0.000114549999999
resume
let sar12_k = length(time)-1
if abs(time[sar12_k] - 0.00011455) > 1e-12
print time[sar12_k]
echo expected_pause_time_s 0.00011455
echo SAR12_PAUSE_FAILED
quit 1
end
print time[sar12_k] >> pause-times.txt
delete all
alter VD_SAMPLE = 0
stop when time ge 0.000114599999999
resume
let sar12_k = length(time)-1
if abs(time[sar12_k] - 0.0001146) > 1e-12
print time[sar12_k]
echo expected_pause_time_s 0.0001146
echo SAR12_PAUSE_FAILED
quit 1
end
print time[sar12_k] >> pause-times.txt
delete all
alter VD_EVAL = 0
let sar12_trial = sar12_code + 2048
let sar12_drive = (floor(sar12_trial / 1) - 2*floor(sar12_trial / 2))*1.8
alter VD_B0 = $&sar12_drive
let sar12_drive = (floor(sar12_trial / 2) - 2*floor(sar12_trial / 4))*1.8
alter VD_B1 = $&sar12_drive
let sar12_drive = (floor(sar12_trial / 4) - 2*floor(sar12_trial / 8))*1.8
alter VD_B2 = $&sar12_drive
let sar12_drive = (floor(sar12_trial / 8) - 2*floor(sar12_trial / 16))*1.8
alter VD_B3 = $&sar12_drive
let sar12_drive = (floor(sar12_trial / 16) - 2*floor(sar12_trial / 32))*1.8
alter VD_B4 = $&sar12_drive
let sar12_drive = (floor(sar12_trial / 32) - 2*floor(sar12_trial / 64))*1.8
alter VD_B5 = $&sar12_drive
let sar12_drive = (floor(sar12_trial / 64) - 2*floor(sar12_trial / 128))*1.8
alter VD_B6 = $&sar12_drive
let sar12_drive = (floor(sar12_trial / 128) - 2*floor(sar12_trial / 256))*1.8
alter VD_B7 = $&sar12_drive
let sar12_drive = (floor(sar12_trial / 256) - 2*floor(sar12_trial / 512))*1.8
alter VD_B8 = $&sar12_drive
let sar12_drive = (floor(sar12_trial / 512) - 2*floor(sar12_trial / 1024))*1.8
alter VD_B9 = $&sar12_drive
let sar12_drive = (floor(sar12_trial / 1024) - 2*floor(sar12_trial / 2048))*1.8
alter VD_B10 = $&sar12_drive
let sar12_drive = (floor(sar12_trial / 2048) - 2*floor(sar12_trial / 4096))*1.8
alter VD_B11 = $&sar12_drive
stop when time ge 0.000114924999999
resume
let sar12_k = length(time)-1
if abs(time[sar12_k] - 0.000114925) > 1e-12
print time[sar12_k]
echo expected_pause_time_s 0.000114925
echo SAR12_PAUSE_FAILED
quit 1
end
print time[sar12_k] >> pause-times.txt
delete all
alter VD_EVAL = 1.8
stop when time ge 0.000115099999999
resume
let sar12_k = length(time)-1
if abs(time[sar12_k] - 0.0001151) > 1e-12
print time[sar12_k]
echo expected_pause_time_s 0.0001151
echo SAR12_PAUSE_FAILED
quit 1
end
print time[sar12_k] >> pause-times.txt
delete all
let sar12_k = length(time)-1
let sar12_cmp = v(COMP)[sar12_k]
let sar12_cmpn = v(COMPN)[sar12_k]
let sar12_p = v(TOPP)[sar12_k]
let sar12_n = v(TOPN)[sar12_k]
let sar12_decision = 0
if sar12_cmp >= 0.9
let sar12_code = sar12_trial
let sar12_decision = 1
end
echo 11 11 $&sar12_trial $&sar12_cmp $&sar12_cmpn $&sar12_p $&sar12_n 1.16220703125 $&sar12_decision >> decisions.csv
alter VD_EVAL = 0
let sar12_trial = sar12_code + 1024
let sar12_drive = (floor(sar12_trial / 1) - 2*floor(sar12_trial / 2))*1.8
alter VD_B0 = $&sar12_drive
let sar12_drive = (floor(sar12_trial / 2) - 2*floor(sar12_trial / 4))*1.8
alter VD_B1 = $&sar12_drive
let sar12_drive = (floor(sar12_trial / 4) - 2*floor(sar12_trial / 8))*1.8
alter VD_B2 = $&sar12_drive
let sar12_drive = (floor(sar12_trial / 8) - 2*floor(sar12_trial / 16))*1.8
alter VD_B3 = $&sar12_drive
let sar12_drive = (floor(sar12_trial / 16) - 2*floor(sar12_trial / 32))*1.8
alter VD_B4 = $&sar12_drive
let sar12_drive = (floor(sar12_trial / 32) - 2*floor(sar12_trial / 64))*1.8
alter VD_B5 = $&sar12_drive
let sar12_drive = (floor(sar12_trial / 64) - 2*floor(sar12_trial / 128))*1.8
alter VD_B6 = $&sar12_drive
let sar12_drive = (floor(sar12_trial / 128) - 2*floor(sar12_trial / 256))*1.8
alter VD_B7 = $&sar12_drive
let sar12_drive = (floor(sar12_trial / 256) - 2*floor(sar12_trial / 512))*1.8
alter VD_B8 = $&sar12_drive
let sar12_drive = (floor(sar12_trial / 512) - 2*floor(sar12_trial / 1024))*1.8
alter VD_B9 = $&sar12_drive
let sar12_drive = (floor(sar12_trial / 1024) - 2*floor(sar12_trial / 2048))*1.8
alter VD_B10 = $&sar12_drive
let sar12_drive = (floor(sar12_trial / 2048) - 2*floor(sar12_trial / 4096))*1.8
alter VD_B11 = $&sar12_drive
stop when time ge 0.000115424999999
resume
let sar12_k = length(time)-1
if abs(time[sar12_k] - 0.000115425) > 1e-12
print time[sar12_k]
echo expected_pause_time_s 0.000115425
echo SAR12_PAUSE_FAILED
quit 1
end
print time[sar12_k] >> pause-times.txt
delete all
alter VD_EVAL = 1.8
stop when time ge 0.000115599999999
resume
let sar12_k = length(time)-1
if abs(time[sar12_k] - 0.0001156) > 1e-12
print time[sar12_k]
echo expected_pause_time_s 0.0001156
echo SAR12_PAUSE_FAILED
quit 1
end
print time[sar12_k] >> pause-times.txt
delete all
let sar12_k = length(time)-1
let sar12_cmp = v(COMP)[sar12_k]
let sar12_cmpn = v(COMPN)[sar12_k]
let sar12_p = v(TOPP)[sar12_k]
let sar12_n = v(TOPN)[sar12_k]
let sar12_decision = 0
if sar12_cmp >= 0.9
let sar12_code = sar12_trial
let sar12_decision = 1
end
echo 11 10 $&sar12_trial $&sar12_cmp $&sar12_cmpn $&sar12_p $&sar12_n 1.16220703125 $&sar12_decision >> decisions.csv
alter VD_EVAL = 0
let sar12_trial = sar12_code + 512
let sar12_drive = (floor(sar12_trial / 1) - 2*floor(sar12_trial / 2))*1.8
alter VD_B0 = $&sar12_drive
let sar12_drive = (floor(sar12_trial / 2) - 2*floor(sar12_trial / 4))*1.8
alter VD_B1 = $&sar12_drive
let sar12_drive = (floor(sar12_trial / 4) - 2*floor(sar12_trial / 8))*1.8
alter VD_B2 = $&sar12_drive
let sar12_drive = (floor(sar12_trial / 8) - 2*floor(sar12_trial / 16))*1.8
alter VD_B3 = $&sar12_drive
let sar12_drive = (floor(sar12_trial / 16) - 2*floor(sar12_trial / 32))*1.8
alter VD_B4 = $&sar12_drive
let sar12_drive = (floor(sar12_trial / 32) - 2*floor(sar12_trial / 64))*1.8
alter VD_B5 = $&sar12_drive
let sar12_drive = (floor(sar12_trial / 64) - 2*floor(sar12_trial / 128))*1.8
alter VD_B6 = $&sar12_drive
let sar12_drive = (floor(sar12_trial / 128) - 2*floor(sar12_trial / 256))*1.8
alter VD_B7 = $&sar12_drive
let sar12_drive = (floor(sar12_trial / 256) - 2*floor(sar12_trial / 512))*1.8
alter VD_B8 = $&sar12_drive
let sar12_drive = (floor(sar12_trial / 512) - 2*floor(sar12_trial / 1024))*1.8
alter VD_B9 = $&sar12_drive
let sar12_drive = (floor(sar12_trial / 1024) - 2*floor(sar12_trial / 2048))*1.8
alter VD_B10 = $&sar12_drive
let sar12_drive = (floor(sar12_trial / 2048) - 2*floor(sar12_trial / 4096))*1.8
alter VD_B11 = $&sar12_drive
stop when time ge 0.000115924999999
resume
let sar12_k = length(time)-1
if abs(time[sar12_k] - 0.000115925) > 1e-12
print time[sar12_k]
echo expected_pause_time_s 0.000115925
echo SAR12_PAUSE_FAILED
quit 1
end
print time[sar12_k] >> pause-times.txt
delete all
alter VD_EVAL = 1.8
stop when time ge 0.000116099999999
resume
let sar12_k = length(time)-1
if abs(time[sar12_k] - 0.0001161) > 1e-12
print time[sar12_k]
echo expected_pause_time_s 0.0001161
echo SAR12_PAUSE_FAILED
quit 1
end
print time[sar12_k] >> pause-times.txt
delete all
let sar12_k = length(time)-1
let sar12_cmp = v(COMP)[sar12_k]
let sar12_cmpn = v(COMPN)[sar12_k]
let sar12_p = v(TOPP)[sar12_k]
let sar12_n = v(TOPN)[sar12_k]
let sar12_decision = 0
if sar12_cmp >= 0.9
let sar12_code = sar12_trial
let sar12_decision = 1
end
echo 11 9 $&sar12_trial $&sar12_cmp $&sar12_cmpn $&sar12_p $&sar12_n 1.16220703125 $&sar12_decision >> decisions.csv
alter VD_EVAL = 0
let sar12_trial = sar12_code + 256
let sar12_drive = (floor(sar12_trial / 1) - 2*floor(sar12_trial / 2))*1.8
alter VD_B0 = $&sar12_drive
let sar12_drive = (floor(sar12_trial / 2) - 2*floor(sar12_trial / 4))*1.8
alter VD_B1 = $&sar12_drive
let sar12_drive = (floor(sar12_trial / 4) - 2*floor(sar12_trial / 8))*1.8
alter VD_B2 = $&sar12_drive
let sar12_drive = (floor(sar12_trial / 8) - 2*floor(sar12_trial / 16))*1.8
alter VD_B3 = $&sar12_drive
let sar12_drive = (floor(sar12_trial / 16) - 2*floor(sar12_trial / 32))*1.8
alter VD_B4 = $&sar12_drive
let sar12_drive = (floor(sar12_trial / 32) - 2*floor(sar12_trial / 64))*1.8
alter VD_B5 = $&sar12_drive
let sar12_drive = (floor(sar12_trial / 64) - 2*floor(sar12_trial / 128))*1.8
alter VD_B6 = $&sar12_drive
let sar12_drive = (floor(sar12_trial / 128) - 2*floor(sar12_trial / 256))*1.8
alter VD_B7 = $&sar12_drive
let sar12_drive = (floor(sar12_trial / 256) - 2*floor(sar12_trial / 512))*1.8
alter VD_B8 = $&sar12_drive
let sar12_drive = (floor(sar12_trial / 512) - 2*floor(sar12_trial / 1024))*1.8
alter VD_B9 = $&sar12_drive
let sar12_drive = (floor(sar12_trial / 1024) - 2*floor(sar12_trial / 2048))*1.8
alter VD_B10 = $&sar12_drive
let sar12_drive = (floor(sar12_trial / 2048) - 2*floor(sar12_trial / 4096))*1.8
alter VD_B11 = $&sar12_drive
stop when time ge 0.000116424999999
resume
let sar12_k = length(time)-1
if abs(time[sar12_k] - 0.000116425) > 1e-12
print time[sar12_k]
echo expected_pause_time_s 0.000116425
echo SAR12_PAUSE_FAILED
quit 1
end
print time[sar12_k] >> pause-times.txt
delete all
alter VD_EVAL = 1.8
stop when time ge 0.000116599999999
resume
let sar12_k = length(time)-1
if abs(time[sar12_k] - 0.0001166) > 1e-12
print time[sar12_k]
echo expected_pause_time_s 0.0001166
echo SAR12_PAUSE_FAILED
quit 1
end
print time[sar12_k] >> pause-times.txt
delete all
let sar12_k = length(time)-1
let sar12_cmp = v(COMP)[sar12_k]
let sar12_cmpn = v(COMPN)[sar12_k]
let sar12_p = v(TOPP)[sar12_k]
let sar12_n = v(TOPN)[sar12_k]
let sar12_decision = 0
if sar12_cmp >= 0.9
let sar12_code = sar12_trial
let sar12_decision = 1
end
echo 11 8 $&sar12_trial $&sar12_cmp $&sar12_cmpn $&sar12_p $&sar12_n 1.16220703125 $&sar12_decision >> decisions.csv
alter VD_EVAL = 0
let sar12_trial = sar12_code + 128
let sar12_drive = (floor(sar12_trial / 1) - 2*floor(sar12_trial / 2))*1.8
alter VD_B0 = $&sar12_drive
let sar12_drive = (floor(sar12_trial / 2) - 2*floor(sar12_trial / 4))*1.8
alter VD_B1 = $&sar12_drive
let sar12_drive = (floor(sar12_trial / 4) - 2*floor(sar12_trial / 8))*1.8
alter VD_B2 = $&sar12_drive
let sar12_drive = (floor(sar12_trial / 8) - 2*floor(sar12_trial / 16))*1.8
alter VD_B3 = $&sar12_drive
let sar12_drive = (floor(sar12_trial / 16) - 2*floor(sar12_trial / 32))*1.8
alter VD_B4 = $&sar12_drive
let sar12_drive = (floor(sar12_trial / 32) - 2*floor(sar12_trial / 64))*1.8
alter VD_B5 = $&sar12_drive
let sar12_drive = (floor(sar12_trial / 64) - 2*floor(sar12_trial / 128))*1.8
alter VD_B6 = $&sar12_drive
let sar12_drive = (floor(sar12_trial / 128) - 2*floor(sar12_trial / 256))*1.8
alter VD_B7 = $&sar12_drive
let sar12_drive = (floor(sar12_trial / 256) - 2*floor(sar12_trial / 512))*1.8
alter VD_B8 = $&sar12_drive
let sar12_drive = (floor(sar12_trial / 512) - 2*floor(sar12_trial / 1024))*1.8
alter VD_B9 = $&sar12_drive
let sar12_drive = (floor(sar12_trial / 1024) - 2*floor(sar12_trial / 2048))*1.8
alter VD_B10 = $&sar12_drive
let sar12_drive = (floor(sar12_trial / 2048) - 2*floor(sar12_trial / 4096))*1.8
alter VD_B11 = $&sar12_drive
stop when time ge 0.000116924999999
resume
let sar12_k = length(time)-1
if abs(time[sar12_k] - 0.000116925) > 1e-12
print time[sar12_k]
echo expected_pause_time_s 0.000116925
echo SAR12_PAUSE_FAILED
quit 1
end
print time[sar12_k] >> pause-times.txt
delete all
alter VD_EVAL = 1.8
stop when time ge 0.000117099999999
resume
let sar12_k = length(time)-1
if abs(time[sar12_k] - 0.0001171) > 1e-12
print time[sar12_k]
echo expected_pause_time_s 0.0001171
echo SAR12_PAUSE_FAILED
quit 1
end
print time[sar12_k] >> pause-times.txt
delete all
let sar12_k = length(time)-1
let sar12_cmp = v(COMP)[sar12_k]
let sar12_cmpn = v(COMPN)[sar12_k]
let sar12_p = v(TOPP)[sar12_k]
let sar12_n = v(TOPN)[sar12_k]
let sar12_decision = 0
if sar12_cmp >= 0.9
let sar12_code = sar12_trial
let sar12_decision = 1
end
echo 11 7 $&sar12_trial $&sar12_cmp $&sar12_cmpn $&sar12_p $&sar12_n 1.16220703125 $&sar12_decision >> decisions.csv
alter VD_EVAL = 0
let sar12_trial = sar12_code + 64
let sar12_drive = (floor(sar12_trial / 1) - 2*floor(sar12_trial / 2))*1.8
alter VD_B0 = $&sar12_drive
let sar12_drive = (floor(sar12_trial / 2) - 2*floor(sar12_trial / 4))*1.8
alter VD_B1 = $&sar12_drive
let sar12_drive = (floor(sar12_trial / 4) - 2*floor(sar12_trial / 8))*1.8
alter VD_B2 = $&sar12_drive
let sar12_drive = (floor(sar12_trial / 8) - 2*floor(sar12_trial / 16))*1.8
alter VD_B3 = $&sar12_drive
let sar12_drive = (floor(sar12_trial / 16) - 2*floor(sar12_trial / 32))*1.8
alter VD_B4 = $&sar12_drive
let sar12_drive = (floor(sar12_trial / 32) - 2*floor(sar12_trial / 64))*1.8
alter VD_B5 = $&sar12_drive
let sar12_drive = (floor(sar12_trial / 64) - 2*floor(sar12_trial / 128))*1.8
alter VD_B6 = $&sar12_drive
let sar12_drive = (floor(sar12_trial / 128) - 2*floor(sar12_trial / 256))*1.8
alter VD_B7 = $&sar12_drive
let sar12_drive = (floor(sar12_trial / 256) - 2*floor(sar12_trial / 512))*1.8
alter VD_B8 = $&sar12_drive
let sar12_drive = (floor(sar12_trial / 512) - 2*floor(sar12_trial / 1024))*1.8
alter VD_B9 = $&sar12_drive
let sar12_drive = (floor(sar12_trial / 1024) - 2*floor(sar12_trial / 2048))*1.8
alter VD_B10 = $&sar12_drive
let sar12_drive = (floor(sar12_trial / 2048) - 2*floor(sar12_trial / 4096))*1.8
alter VD_B11 = $&sar12_drive
stop when time ge 0.000117424999999
resume
let sar12_k = length(time)-1
if abs(time[sar12_k] - 0.000117425) > 1e-12
print time[sar12_k]
echo expected_pause_time_s 0.000117425
echo SAR12_PAUSE_FAILED
quit 1
end
print time[sar12_k] >> pause-times.txt
delete all
alter VD_EVAL = 1.8
stop when time ge 0.000117599999999
resume
let sar12_k = length(time)-1
if abs(time[sar12_k] - 0.0001176) > 1e-12
print time[sar12_k]
echo expected_pause_time_s 0.0001176
echo SAR12_PAUSE_FAILED
quit 1
end
print time[sar12_k] >> pause-times.txt
delete all
let sar12_k = length(time)-1
let sar12_cmp = v(COMP)[sar12_k]
let sar12_cmpn = v(COMPN)[sar12_k]
let sar12_p = v(TOPP)[sar12_k]
let sar12_n = v(TOPN)[sar12_k]
let sar12_decision = 0
if sar12_cmp >= 0.9
let sar12_code = sar12_trial
let sar12_decision = 1
end
echo 11 6 $&sar12_trial $&sar12_cmp $&sar12_cmpn $&sar12_p $&sar12_n 1.16220703125 $&sar12_decision >> decisions.csv
alter VD_EVAL = 0
let sar12_trial = sar12_code + 32
let sar12_drive = (floor(sar12_trial / 1) - 2*floor(sar12_trial / 2))*1.8
alter VD_B0 = $&sar12_drive
let sar12_drive = (floor(sar12_trial / 2) - 2*floor(sar12_trial / 4))*1.8
alter VD_B1 = $&sar12_drive
let sar12_drive = (floor(sar12_trial / 4) - 2*floor(sar12_trial / 8))*1.8
alter VD_B2 = $&sar12_drive
let sar12_drive = (floor(sar12_trial / 8) - 2*floor(sar12_trial / 16))*1.8
alter VD_B3 = $&sar12_drive
let sar12_drive = (floor(sar12_trial / 16) - 2*floor(sar12_trial / 32))*1.8
alter VD_B4 = $&sar12_drive
let sar12_drive = (floor(sar12_trial / 32) - 2*floor(sar12_trial / 64))*1.8
alter VD_B5 = $&sar12_drive
let sar12_drive = (floor(sar12_trial / 64) - 2*floor(sar12_trial / 128))*1.8
alter VD_B6 = $&sar12_drive
let sar12_drive = (floor(sar12_trial / 128) - 2*floor(sar12_trial / 256))*1.8
alter VD_B7 = $&sar12_drive
let sar12_drive = (floor(sar12_trial / 256) - 2*floor(sar12_trial / 512))*1.8
alter VD_B8 = $&sar12_drive
let sar12_drive = (floor(sar12_trial / 512) - 2*floor(sar12_trial / 1024))*1.8
alter VD_B9 = $&sar12_drive
let sar12_drive = (floor(sar12_trial / 1024) - 2*floor(sar12_trial / 2048))*1.8
alter VD_B10 = $&sar12_drive
let sar12_drive = (floor(sar12_trial / 2048) - 2*floor(sar12_trial / 4096))*1.8
alter VD_B11 = $&sar12_drive
stop when time ge 0.000117924999999
resume
let sar12_k = length(time)-1
if abs(time[sar12_k] - 0.000117925) > 1e-12
print time[sar12_k]
echo expected_pause_time_s 0.000117925
echo SAR12_PAUSE_FAILED
quit 1
end
print time[sar12_k] >> pause-times.txt
delete all
alter VD_EVAL = 1.8
stop when time ge 0.000118099999999
resume
let sar12_k = length(time)-1
if abs(time[sar12_k] - 0.0001181) > 1e-12
print time[sar12_k]
echo expected_pause_time_s 0.0001181
echo SAR12_PAUSE_FAILED
quit 1
end
print time[sar12_k] >> pause-times.txt
delete all
let sar12_k = length(time)-1
let sar12_cmp = v(COMP)[sar12_k]
let sar12_cmpn = v(COMPN)[sar12_k]
let sar12_p = v(TOPP)[sar12_k]
let sar12_n = v(TOPN)[sar12_k]
let sar12_decision = 0
if sar12_cmp >= 0.9
let sar12_code = sar12_trial
let sar12_decision = 1
end
echo 11 5 $&sar12_trial $&sar12_cmp $&sar12_cmpn $&sar12_p $&sar12_n 1.16220703125 $&sar12_decision >> decisions.csv
alter VD_EVAL = 0
let sar12_trial = sar12_code + 16
let sar12_drive = (floor(sar12_trial / 1) - 2*floor(sar12_trial / 2))*1.8
alter VD_B0 = $&sar12_drive
let sar12_drive = (floor(sar12_trial / 2) - 2*floor(sar12_trial / 4))*1.8
alter VD_B1 = $&sar12_drive
let sar12_drive = (floor(sar12_trial / 4) - 2*floor(sar12_trial / 8))*1.8
alter VD_B2 = $&sar12_drive
let sar12_drive = (floor(sar12_trial / 8) - 2*floor(sar12_trial / 16))*1.8
alter VD_B3 = $&sar12_drive
let sar12_drive = (floor(sar12_trial / 16) - 2*floor(sar12_trial / 32))*1.8
alter VD_B4 = $&sar12_drive
let sar12_drive = (floor(sar12_trial / 32) - 2*floor(sar12_trial / 64))*1.8
alter VD_B5 = $&sar12_drive
let sar12_drive = (floor(sar12_trial / 64) - 2*floor(sar12_trial / 128))*1.8
alter VD_B6 = $&sar12_drive
let sar12_drive = (floor(sar12_trial / 128) - 2*floor(sar12_trial / 256))*1.8
alter VD_B7 = $&sar12_drive
let sar12_drive = (floor(sar12_trial / 256) - 2*floor(sar12_trial / 512))*1.8
alter VD_B8 = $&sar12_drive
let sar12_drive = (floor(sar12_trial / 512) - 2*floor(sar12_trial / 1024))*1.8
alter VD_B9 = $&sar12_drive
let sar12_drive = (floor(sar12_trial / 1024) - 2*floor(sar12_trial / 2048))*1.8
alter VD_B10 = $&sar12_drive
let sar12_drive = (floor(sar12_trial / 2048) - 2*floor(sar12_trial / 4096))*1.8
alter VD_B11 = $&sar12_drive
stop when time ge 0.000118424999999
resume
let sar12_k = length(time)-1
if abs(time[sar12_k] - 0.000118425) > 1e-12
print time[sar12_k]
echo expected_pause_time_s 0.000118425
echo SAR12_PAUSE_FAILED
quit 1
end
print time[sar12_k] >> pause-times.txt
delete all
alter VD_EVAL = 1.8
stop when time ge 0.000118599999999
resume
let sar12_k = length(time)-1
if abs(time[sar12_k] - 0.0001186) > 1e-12
print time[sar12_k]
echo expected_pause_time_s 0.0001186
echo SAR12_PAUSE_FAILED
quit 1
end
print time[sar12_k] >> pause-times.txt
delete all
let sar12_k = length(time)-1
let sar12_cmp = v(COMP)[sar12_k]
let sar12_cmpn = v(COMPN)[sar12_k]
let sar12_p = v(TOPP)[sar12_k]
let sar12_n = v(TOPN)[sar12_k]
let sar12_decision = 0
if sar12_cmp >= 0.9
let sar12_code = sar12_trial
let sar12_decision = 1
end
echo 11 4 $&sar12_trial $&sar12_cmp $&sar12_cmpn $&sar12_p $&sar12_n 1.16220703125 $&sar12_decision >> decisions.csv
alter VD_EVAL = 0
let sar12_trial = sar12_code + 8
let sar12_drive = (floor(sar12_trial / 1) - 2*floor(sar12_trial / 2))*1.8
alter VD_B0 = $&sar12_drive
let sar12_drive = (floor(sar12_trial / 2) - 2*floor(sar12_trial / 4))*1.8
alter VD_B1 = $&sar12_drive
let sar12_drive = (floor(sar12_trial / 4) - 2*floor(sar12_trial / 8))*1.8
alter VD_B2 = $&sar12_drive
let sar12_drive = (floor(sar12_trial / 8) - 2*floor(sar12_trial / 16))*1.8
alter VD_B3 = $&sar12_drive
let sar12_drive = (floor(sar12_trial / 16) - 2*floor(sar12_trial / 32))*1.8
alter VD_B4 = $&sar12_drive
let sar12_drive = (floor(sar12_trial / 32) - 2*floor(sar12_trial / 64))*1.8
alter VD_B5 = $&sar12_drive
let sar12_drive = (floor(sar12_trial / 64) - 2*floor(sar12_trial / 128))*1.8
alter VD_B6 = $&sar12_drive
let sar12_drive = (floor(sar12_trial / 128) - 2*floor(sar12_trial / 256))*1.8
alter VD_B7 = $&sar12_drive
let sar12_drive = (floor(sar12_trial / 256) - 2*floor(sar12_trial / 512))*1.8
alter VD_B8 = $&sar12_drive
let sar12_drive = (floor(sar12_trial / 512) - 2*floor(sar12_trial / 1024))*1.8
alter VD_B9 = $&sar12_drive
let sar12_drive = (floor(sar12_trial / 1024) - 2*floor(sar12_trial / 2048))*1.8
alter VD_B10 = $&sar12_drive
let sar12_drive = (floor(sar12_trial / 2048) - 2*floor(sar12_trial / 4096))*1.8
alter VD_B11 = $&sar12_drive
stop when time ge 0.000118924999999
resume
let sar12_k = length(time)-1
if abs(time[sar12_k] - 0.000118925) > 1e-12
print time[sar12_k]
echo expected_pause_time_s 0.000118925
echo SAR12_PAUSE_FAILED
quit 1
end
print time[sar12_k] >> pause-times.txt
delete all
alter VD_EVAL = 1.8
stop when time ge 0.000119099999999
resume
let sar12_k = length(time)-1
if abs(time[sar12_k] - 0.0001191) > 1e-12
print time[sar12_k]
echo expected_pause_time_s 0.0001191
echo SAR12_PAUSE_FAILED
quit 1
end
print time[sar12_k] >> pause-times.txt
delete all
let sar12_k = length(time)-1
let sar12_cmp = v(COMP)[sar12_k]
let sar12_cmpn = v(COMPN)[sar12_k]
let sar12_p = v(TOPP)[sar12_k]
let sar12_n = v(TOPN)[sar12_k]
let sar12_decision = 0
if sar12_cmp >= 0.9
let sar12_code = sar12_trial
let sar12_decision = 1
end
echo 11 3 $&sar12_trial $&sar12_cmp $&sar12_cmpn $&sar12_p $&sar12_n 1.16220703125 $&sar12_decision >> decisions.csv
alter VD_EVAL = 0
let sar12_trial = sar12_code + 4
let sar12_drive = (floor(sar12_trial / 1) - 2*floor(sar12_trial / 2))*1.8
alter VD_B0 = $&sar12_drive
let sar12_drive = (floor(sar12_trial / 2) - 2*floor(sar12_trial / 4))*1.8
alter VD_B1 = $&sar12_drive
let sar12_drive = (floor(sar12_trial / 4) - 2*floor(sar12_trial / 8))*1.8
alter VD_B2 = $&sar12_drive
let sar12_drive = (floor(sar12_trial / 8) - 2*floor(sar12_trial / 16))*1.8
alter VD_B3 = $&sar12_drive
let sar12_drive = (floor(sar12_trial / 16) - 2*floor(sar12_trial / 32))*1.8
alter VD_B4 = $&sar12_drive
let sar12_drive = (floor(sar12_trial / 32) - 2*floor(sar12_trial / 64))*1.8
alter VD_B5 = $&sar12_drive
let sar12_drive = (floor(sar12_trial / 64) - 2*floor(sar12_trial / 128))*1.8
alter VD_B6 = $&sar12_drive
let sar12_drive = (floor(sar12_trial / 128) - 2*floor(sar12_trial / 256))*1.8
alter VD_B7 = $&sar12_drive
let sar12_drive = (floor(sar12_trial / 256) - 2*floor(sar12_trial / 512))*1.8
alter VD_B8 = $&sar12_drive
let sar12_drive = (floor(sar12_trial / 512) - 2*floor(sar12_trial / 1024))*1.8
alter VD_B9 = $&sar12_drive
let sar12_drive = (floor(sar12_trial / 1024) - 2*floor(sar12_trial / 2048))*1.8
alter VD_B10 = $&sar12_drive
let sar12_drive = (floor(sar12_trial / 2048) - 2*floor(sar12_trial / 4096))*1.8
alter VD_B11 = $&sar12_drive
stop when time ge 0.000119424999999
resume
let sar12_k = length(time)-1
if abs(time[sar12_k] - 0.000119425) > 1e-12
print time[sar12_k]
echo expected_pause_time_s 0.000119425
echo SAR12_PAUSE_FAILED
quit 1
end
print time[sar12_k] >> pause-times.txt
delete all
alter VD_EVAL = 1.8
stop when time ge 0.000119599999999
resume
let sar12_k = length(time)-1
if abs(time[sar12_k] - 0.0001196) > 1e-12
print time[sar12_k]
echo expected_pause_time_s 0.0001196
echo SAR12_PAUSE_FAILED
quit 1
end
print time[sar12_k] >> pause-times.txt
delete all
let sar12_k = length(time)-1
let sar12_cmp = v(COMP)[sar12_k]
let sar12_cmpn = v(COMPN)[sar12_k]
let sar12_p = v(TOPP)[sar12_k]
let sar12_n = v(TOPN)[sar12_k]
let sar12_decision = 0
if sar12_cmp >= 0.9
let sar12_code = sar12_trial
let sar12_decision = 1
end
echo 11 2 $&sar12_trial $&sar12_cmp $&sar12_cmpn $&sar12_p $&sar12_n 1.16220703125 $&sar12_decision >> decisions.csv
alter VD_EVAL = 0
let sar12_trial = sar12_code + 2
let sar12_drive = (floor(sar12_trial / 1) - 2*floor(sar12_trial / 2))*1.8
alter VD_B0 = $&sar12_drive
let sar12_drive = (floor(sar12_trial / 2) - 2*floor(sar12_trial / 4))*1.8
alter VD_B1 = $&sar12_drive
let sar12_drive = (floor(sar12_trial / 4) - 2*floor(sar12_trial / 8))*1.8
alter VD_B2 = $&sar12_drive
let sar12_drive = (floor(sar12_trial / 8) - 2*floor(sar12_trial / 16))*1.8
alter VD_B3 = $&sar12_drive
let sar12_drive = (floor(sar12_trial / 16) - 2*floor(sar12_trial / 32))*1.8
alter VD_B4 = $&sar12_drive
let sar12_drive = (floor(sar12_trial / 32) - 2*floor(sar12_trial / 64))*1.8
alter VD_B5 = $&sar12_drive
let sar12_drive = (floor(sar12_trial / 64) - 2*floor(sar12_trial / 128))*1.8
alter VD_B6 = $&sar12_drive
let sar12_drive = (floor(sar12_trial / 128) - 2*floor(sar12_trial / 256))*1.8
alter VD_B7 = $&sar12_drive
let sar12_drive = (floor(sar12_trial / 256) - 2*floor(sar12_trial / 512))*1.8
alter VD_B8 = $&sar12_drive
let sar12_drive = (floor(sar12_trial / 512) - 2*floor(sar12_trial / 1024))*1.8
alter VD_B9 = $&sar12_drive
let sar12_drive = (floor(sar12_trial / 1024) - 2*floor(sar12_trial / 2048))*1.8
alter VD_B10 = $&sar12_drive
let sar12_drive = (floor(sar12_trial / 2048) - 2*floor(sar12_trial / 4096))*1.8
alter VD_B11 = $&sar12_drive
stop when time ge 0.000119924999999
resume
let sar12_k = length(time)-1
if abs(time[sar12_k] - 0.000119925) > 1e-12
print time[sar12_k]
echo expected_pause_time_s 0.000119925
echo SAR12_PAUSE_FAILED
quit 1
end
print time[sar12_k] >> pause-times.txt
delete all
alter VD_EVAL = 1.8
stop when time ge 0.000120099999999
resume
let sar12_k = length(time)-1
if abs(time[sar12_k] - 0.0001201) > 1e-12
print time[sar12_k]
echo expected_pause_time_s 0.0001201
echo SAR12_PAUSE_FAILED
quit 1
end
print time[sar12_k] >> pause-times.txt
delete all
let sar12_k = length(time)-1
let sar12_cmp = v(COMP)[sar12_k]
let sar12_cmpn = v(COMPN)[sar12_k]
let sar12_p = v(TOPP)[sar12_k]
let sar12_n = v(TOPN)[sar12_k]
let sar12_decision = 0
if sar12_cmp >= 0.9
let sar12_code = sar12_trial
let sar12_decision = 1
end
echo 11 1 $&sar12_trial $&sar12_cmp $&sar12_cmpn $&sar12_p $&sar12_n 1.16220703125 $&sar12_decision >> decisions.csv
alter VD_EVAL = 0
let sar12_trial = sar12_code + 1
let sar12_drive = (floor(sar12_trial / 1) - 2*floor(sar12_trial / 2))*1.8
alter VD_B0 = $&sar12_drive
let sar12_drive = (floor(sar12_trial / 2) - 2*floor(sar12_trial / 4))*1.8
alter VD_B1 = $&sar12_drive
let sar12_drive = (floor(sar12_trial / 4) - 2*floor(sar12_trial / 8))*1.8
alter VD_B2 = $&sar12_drive
let sar12_drive = (floor(sar12_trial / 8) - 2*floor(sar12_trial / 16))*1.8
alter VD_B3 = $&sar12_drive
let sar12_drive = (floor(sar12_trial / 16) - 2*floor(sar12_trial / 32))*1.8
alter VD_B4 = $&sar12_drive
let sar12_drive = (floor(sar12_trial / 32) - 2*floor(sar12_trial / 64))*1.8
alter VD_B5 = $&sar12_drive
let sar12_drive = (floor(sar12_trial / 64) - 2*floor(sar12_trial / 128))*1.8
alter VD_B6 = $&sar12_drive
let sar12_drive = (floor(sar12_trial / 128) - 2*floor(sar12_trial / 256))*1.8
alter VD_B7 = $&sar12_drive
let sar12_drive = (floor(sar12_trial / 256) - 2*floor(sar12_trial / 512))*1.8
alter VD_B8 = $&sar12_drive
let sar12_drive = (floor(sar12_trial / 512) - 2*floor(sar12_trial / 1024))*1.8
alter VD_B9 = $&sar12_drive
let sar12_drive = (floor(sar12_trial / 1024) - 2*floor(sar12_trial / 2048))*1.8
alter VD_B10 = $&sar12_drive
let sar12_drive = (floor(sar12_trial / 2048) - 2*floor(sar12_trial / 4096))*1.8
alter VD_B11 = $&sar12_drive
stop when time ge 0.000120424999999
resume
let sar12_k = length(time)-1
if abs(time[sar12_k] - 0.000120425) > 1e-12
print time[sar12_k]
echo expected_pause_time_s 0.000120425
echo SAR12_PAUSE_FAILED
quit 1
end
print time[sar12_k] >> pause-times.txt
delete all
alter VD_EVAL = 1.8
stop when time ge 0.000120599999999
resume
let sar12_k = length(time)-1
if abs(time[sar12_k] - 0.0001206) > 1e-12
print time[sar12_k]
echo expected_pause_time_s 0.0001206
echo SAR12_PAUSE_FAILED
quit 1
end
print time[sar12_k] >> pause-times.txt
delete all
let sar12_k = length(time)-1
let sar12_cmp = v(COMP)[sar12_k]
let sar12_cmpn = v(COMPN)[sar12_k]
let sar12_p = v(TOPP)[sar12_k]
let sar12_n = v(TOPN)[sar12_k]
let sar12_decision = 0
if sar12_cmp >= 0.9
let sar12_code = sar12_trial
let sar12_decision = 1
end
echo 11 0 $&sar12_trial $&sar12_cmp $&sar12_cmpn $&sar12_p $&sar12_n 1.16220703125 $&sar12_decision >> decisions.csv
alter VD_EVAL = 0
alter VINP = 1.49956054687
alter VINN = 0.300439453125
alter VD_SAMPLE = 1.8
alter VD_EVAL = 0
alter VD_B0 = 0
alter VD_B1 = 0
alter VD_B2 = 0
alter VD_B3 = 0
alter VD_B4 = 0
alter VD_B5 = 0
alter VD_B6 = 0
alter VD_B7 = 0
alter VD_B8 = 0
alter VD_B9 = 0
alter VD_B10 = 0
alter VD_B11 = 0
let sar12_code = 0
stop when time ge 0.000124599999999
resume
let sar12_k = length(time)-1
if abs(time[sar12_k] - 0.0001246) > 1e-12
print time[sar12_k]
echo expected_pause_time_s 0.0001246
echo SAR12_PAUSE_FAILED
quit 1
end
print time[sar12_k] >> pause-times.txt
delete all
alter VD_SAMPLE = 0
stop when time ge 0.000124649999999
resume
let sar12_k = length(time)-1
if abs(time[sar12_k] - 0.00012465) > 1e-12
print time[sar12_k]
echo expected_pause_time_s 0.00012465
echo SAR12_PAUSE_FAILED
quit 1
end
print time[sar12_k] >> pause-times.txt
delete all
alter VD_EVAL = 0
let sar12_trial = sar12_code + 2048
let sar12_drive = (floor(sar12_trial / 1) - 2*floor(sar12_trial / 2))*1.8
alter VD_B0 = $&sar12_drive
let sar12_drive = (floor(sar12_trial / 2) - 2*floor(sar12_trial / 4))*1.8
alter VD_B1 = $&sar12_drive
let sar12_drive = (floor(sar12_trial / 4) - 2*floor(sar12_trial / 8))*1.8
alter VD_B2 = $&sar12_drive
let sar12_drive = (floor(sar12_trial / 8) - 2*floor(sar12_trial / 16))*1.8
alter VD_B3 = $&sar12_drive
let sar12_drive = (floor(sar12_trial / 16) - 2*floor(sar12_trial / 32))*1.8
alter VD_B4 = $&sar12_drive
let sar12_drive = (floor(sar12_trial / 32) - 2*floor(sar12_trial / 64))*1.8
alter VD_B5 = $&sar12_drive
let sar12_drive = (floor(sar12_trial / 64) - 2*floor(sar12_trial / 128))*1.8
alter VD_B6 = $&sar12_drive
let sar12_drive = (floor(sar12_trial / 128) - 2*floor(sar12_trial / 256))*1.8
alter VD_B7 = $&sar12_drive
let sar12_drive = (floor(sar12_trial / 256) - 2*floor(sar12_trial / 512))*1.8
alter VD_B8 = $&sar12_drive
let sar12_drive = (floor(sar12_trial / 512) - 2*floor(sar12_trial / 1024))*1.8
alter VD_B9 = $&sar12_drive
let sar12_drive = (floor(sar12_trial / 1024) - 2*floor(sar12_trial / 2048))*1.8
alter VD_B10 = $&sar12_drive
let sar12_drive = (floor(sar12_trial / 2048) - 2*floor(sar12_trial / 4096))*1.8
alter VD_B11 = $&sar12_drive
stop when time ge 0.000124974999999
resume
let sar12_k = length(time)-1
if abs(time[sar12_k] - 0.000124975) > 1e-12
print time[sar12_k]
echo expected_pause_time_s 0.000124975
echo SAR12_PAUSE_FAILED
quit 1
end
print time[sar12_k] >> pause-times.txt
delete all
alter VD_EVAL = 1.8
stop when time ge 0.000125149999999
resume
let sar12_k = length(time)-1
if abs(time[sar12_k] - 0.00012515) > 1e-12
print time[sar12_k]
echo expected_pause_time_s 0.00012515
echo SAR12_PAUSE_FAILED
quit 1
end
print time[sar12_k] >> pause-times.txt
delete all
let sar12_k = length(time)-1
let sar12_cmp = v(COMP)[sar12_k]
let sar12_cmpn = v(COMPN)[sar12_k]
let sar12_p = v(TOPP)[sar12_k]
let sar12_n = v(TOPN)[sar12_k]
let sar12_decision = 0
if sar12_cmp >= 0.9
let sar12_code = sar12_trial
let sar12_decision = 1
end
echo 12 11 $&sar12_trial $&sar12_cmp $&sar12_cmpn $&sar12_p $&sar12_n 1.19912109375 $&sar12_decision >> decisions.csv
alter VD_EVAL = 0
let sar12_trial = sar12_code + 1024
let sar12_drive = (floor(sar12_trial / 1) - 2*floor(sar12_trial / 2))*1.8
alter VD_B0 = $&sar12_drive
let sar12_drive = (floor(sar12_trial / 2) - 2*floor(sar12_trial / 4))*1.8
alter VD_B1 = $&sar12_drive
let sar12_drive = (floor(sar12_trial / 4) - 2*floor(sar12_trial / 8))*1.8
alter VD_B2 = $&sar12_drive
let sar12_drive = (floor(sar12_trial / 8) - 2*floor(sar12_trial / 16))*1.8
alter VD_B3 = $&sar12_drive
let sar12_drive = (floor(sar12_trial / 16) - 2*floor(sar12_trial / 32))*1.8
alter VD_B4 = $&sar12_drive
let sar12_drive = (floor(sar12_trial / 32) - 2*floor(sar12_trial / 64))*1.8
alter VD_B5 = $&sar12_drive
let sar12_drive = (floor(sar12_trial / 64) - 2*floor(sar12_trial / 128))*1.8
alter VD_B6 = $&sar12_drive
let sar12_drive = (floor(sar12_trial / 128) - 2*floor(sar12_trial / 256))*1.8
alter VD_B7 = $&sar12_drive
let sar12_drive = (floor(sar12_trial / 256) - 2*floor(sar12_trial / 512))*1.8
alter VD_B8 = $&sar12_drive
let sar12_drive = (floor(sar12_trial / 512) - 2*floor(sar12_trial / 1024))*1.8
alter VD_B9 = $&sar12_drive
let sar12_drive = (floor(sar12_trial / 1024) - 2*floor(sar12_trial / 2048))*1.8
alter VD_B10 = $&sar12_drive
let sar12_drive = (floor(sar12_trial / 2048) - 2*floor(sar12_trial / 4096))*1.8
alter VD_B11 = $&sar12_drive
stop when time ge 0.000125474999999
resume
let sar12_k = length(time)-1
if abs(time[sar12_k] - 0.000125475) > 1e-12
print time[sar12_k]
echo expected_pause_time_s 0.000125475
echo SAR12_PAUSE_FAILED
quit 1
end
print time[sar12_k] >> pause-times.txt
delete all
alter VD_EVAL = 1.8
stop when time ge 0.000125649999999
resume
let sar12_k = length(time)-1
if abs(time[sar12_k] - 0.00012565) > 1e-12
print time[sar12_k]
echo expected_pause_time_s 0.00012565
echo SAR12_PAUSE_FAILED
quit 1
end
print time[sar12_k] >> pause-times.txt
delete all
let sar12_k = length(time)-1
let sar12_cmp = v(COMP)[sar12_k]
let sar12_cmpn = v(COMPN)[sar12_k]
let sar12_p = v(TOPP)[sar12_k]
let sar12_n = v(TOPN)[sar12_k]
let sar12_decision = 0
if sar12_cmp >= 0.9
let sar12_code = sar12_trial
let sar12_decision = 1
end
echo 12 10 $&sar12_trial $&sar12_cmp $&sar12_cmpn $&sar12_p $&sar12_n 1.19912109375 $&sar12_decision >> decisions.csv
alter VD_EVAL = 0
let sar12_trial = sar12_code + 512
let sar12_drive = (floor(sar12_trial / 1) - 2*floor(sar12_trial / 2))*1.8
alter VD_B0 = $&sar12_drive
let sar12_drive = (floor(sar12_trial / 2) - 2*floor(sar12_trial / 4))*1.8
alter VD_B1 = $&sar12_drive
let sar12_drive = (floor(sar12_trial / 4) - 2*floor(sar12_trial / 8))*1.8
alter VD_B2 = $&sar12_drive
let sar12_drive = (floor(sar12_trial / 8) - 2*floor(sar12_trial / 16))*1.8
alter VD_B3 = $&sar12_drive
let sar12_drive = (floor(sar12_trial / 16) - 2*floor(sar12_trial / 32))*1.8
alter VD_B4 = $&sar12_drive
let sar12_drive = (floor(sar12_trial / 32) - 2*floor(sar12_trial / 64))*1.8
alter VD_B5 = $&sar12_drive
let sar12_drive = (floor(sar12_trial / 64) - 2*floor(sar12_trial / 128))*1.8
alter VD_B6 = $&sar12_drive
let sar12_drive = (floor(sar12_trial / 128) - 2*floor(sar12_trial / 256))*1.8
alter VD_B7 = $&sar12_drive
let sar12_drive = (floor(sar12_trial / 256) - 2*floor(sar12_trial / 512))*1.8
alter VD_B8 = $&sar12_drive
let sar12_drive = (floor(sar12_trial / 512) - 2*floor(sar12_trial / 1024))*1.8
alter VD_B9 = $&sar12_drive
let sar12_drive = (floor(sar12_trial / 1024) - 2*floor(sar12_trial / 2048))*1.8
alter VD_B10 = $&sar12_drive
let sar12_drive = (floor(sar12_trial / 2048) - 2*floor(sar12_trial / 4096))*1.8
alter VD_B11 = $&sar12_drive
stop when time ge 0.000125974999999
resume
let sar12_k = length(time)-1
if abs(time[sar12_k] - 0.000125975) > 1e-12
print time[sar12_k]
echo expected_pause_time_s 0.000125975
echo SAR12_PAUSE_FAILED
quit 1
end
print time[sar12_k] >> pause-times.txt
delete all
alter VD_EVAL = 1.8
stop when time ge 0.000126149999999
resume
let sar12_k = length(time)-1
if abs(time[sar12_k] - 0.00012615) > 1e-12
print time[sar12_k]
echo expected_pause_time_s 0.00012615
echo SAR12_PAUSE_FAILED
quit 1
end
print time[sar12_k] >> pause-times.txt
delete all
let sar12_k = length(time)-1
let sar12_cmp = v(COMP)[sar12_k]
let sar12_cmpn = v(COMPN)[sar12_k]
let sar12_p = v(TOPP)[sar12_k]
let sar12_n = v(TOPN)[sar12_k]
let sar12_decision = 0
if sar12_cmp >= 0.9
let sar12_code = sar12_trial
let sar12_decision = 1
end
echo 12 9 $&sar12_trial $&sar12_cmp $&sar12_cmpn $&sar12_p $&sar12_n 1.19912109375 $&sar12_decision >> decisions.csv
alter VD_EVAL = 0
let sar12_trial = sar12_code + 256
let sar12_drive = (floor(sar12_trial / 1) - 2*floor(sar12_trial / 2))*1.8
alter VD_B0 = $&sar12_drive
let sar12_drive = (floor(sar12_trial / 2) - 2*floor(sar12_trial / 4))*1.8
alter VD_B1 = $&sar12_drive
let sar12_drive = (floor(sar12_trial / 4) - 2*floor(sar12_trial / 8))*1.8
alter VD_B2 = $&sar12_drive
let sar12_drive = (floor(sar12_trial / 8) - 2*floor(sar12_trial / 16))*1.8
alter VD_B3 = $&sar12_drive
let sar12_drive = (floor(sar12_trial / 16) - 2*floor(sar12_trial / 32))*1.8
alter VD_B4 = $&sar12_drive
let sar12_drive = (floor(sar12_trial / 32) - 2*floor(sar12_trial / 64))*1.8
alter VD_B5 = $&sar12_drive
let sar12_drive = (floor(sar12_trial / 64) - 2*floor(sar12_trial / 128))*1.8
alter VD_B6 = $&sar12_drive
let sar12_drive = (floor(sar12_trial / 128) - 2*floor(sar12_trial / 256))*1.8
alter VD_B7 = $&sar12_drive
let sar12_drive = (floor(sar12_trial / 256) - 2*floor(sar12_trial / 512))*1.8
alter VD_B8 = $&sar12_drive
let sar12_drive = (floor(sar12_trial / 512) - 2*floor(sar12_trial / 1024))*1.8
alter VD_B9 = $&sar12_drive
let sar12_drive = (floor(sar12_trial / 1024) - 2*floor(sar12_trial / 2048))*1.8
alter VD_B10 = $&sar12_drive
let sar12_drive = (floor(sar12_trial / 2048) - 2*floor(sar12_trial / 4096))*1.8
alter VD_B11 = $&sar12_drive
stop when time ge 0.000126474999999
resume
let sar12_k = length(time)-1
if abs(time[sar12_k] - 0.000126475) > 1e-12
print time[sar12_k]
echo expected_pause_time_s 0.000126475
echo SAR12_PAUSE_FAILED
quit 1
end
print time[sar12_k] >> pause-times.txt
delete all
alter VD_EVAL = 1.8
stop when time ge 0.000126649999999
resume
let sar12_k = length(time)-1
if abs(time[sar12_k] - 0.00012665) > 1e-12
print time[sar12_k]
echo expected_pause_time_s 0.00012665
echo SAR12_PAUSE_FAILED
quit 1
end
print time[sar12_k] >> pause-times.txt
delete all
let sar12_k = length(time)-1
let sar12_cmp = v(COMP)[sar12_k]
let sar12_cmpn = v(COMPN)[sar12_k]
let sar12_p = v(TOPP)[sar12_k]
let sar12_n = v(TOPN)[sar12_k]
let sar12_decision = 0
if sar12_cmp >= 0.9
let sar12_code = sar12_trial
let sar12_decision = 1
end
echo 12 8 $&sar12_trial $&sar12_cmp $&sar12_cmpn $&sar12_p $&sar12_n 1.19912109375 $&sar12_decision >> decisions.csv
alter VD_EVAL = 0
let sar12_trial = sar12_code + 128
let sar12_drive = (floor(sar12_trial / 1) - 2*floor(sar12_trial / 2))*1.8
alter VD_B0 = $&sar12_drive
let sar12_drive = (floor(sar12_trial / 2) - 2*floor(sar12_trial / 4))*1.8
alter VD_B1 = $&sar12_drive
let sar12_drive = (floor(sar12_trial / 4) - 2*floor(sar12_trial / 8))*1.8
alter VD_B2 = $&sar12_drive
let sar12_drive = (floor(sar12_trial / 8) - 2*floor(sar12_trial / 16))*1.8
alter VD_B3 = $&sar12_drive
let sar12_drive = (floor(sar12_trial / 16) - 2*floor(sar12_trial / 32))*1.8
alter VD_B4 = $&sar12_drive
let sar12_drive = (floor(sar12_trial / 32) - 2*floor(sar12_trial / 64))*1.8
alter VD_B5 = $&sar12_drive
let sar12_drive = (floor(sar12_trial / 64) - 2*floor(sar12_trial / 128))*1.8
alter VD_B6 = $&sar12_drive
let sar12_drive = (floor(sar12_trial / 128) - 2*floor(sar12_trial / 256))*1.8
alter VD_B7 = $&sar12_drive
let sar12_drive = (floor(sar12_trial / 256) - 2*floor(sar12_trial / 512))*1.8
alter VD_B8 = $&sar12_drive
let sar12_drive = (floor(sar12_trial / 512) - 2*floor(sar12_trial / 1024))*1.8
alter VD_B9 = $&sar12_drive
let sar12_drive = (floor(sar12_trial / 1024) - 2*floor(sar12_trial / 2048))*1.8
alter VD_B10 = $&sar12_drive
let sar12_drive = (floor(sar12_trial / 2048) - 2*floor(sar12_trial / 4096))*1.8
alter VD_B11 = $&sar12_drive
stop when time ge 0.000126974999999
resume
let sar12_k = length(time)-1
if abs(time[sar12_k] - 0.000126975) > 1e-12
print time[sar12_k]
echo expected_pause_time_s 0.000126975
echo SAR12_PAUSE_FAILED
quit 1
end
print time[sar12_k] >> pause-times.txt
delete all
alter VD_EVAL = 1.8
stop when time ge 0.000127149999999
resume
let sar12_k = length(time)-1
if abs(time[sar12_k] - 0.00012715) > 1e-12
print time[sar12_k]
echo expected_pause_time_s 0.00012715
echo SAR12_PAUSE_FAILED
quit 1
end
print time[sar12_k] >> pause-times.txt
delete all
let sar12_k = length(time)-1
let sar12_cmp = v(COMP)[sar12_k]
let sar12_cmpn = v(COMPN)[sar12_k]
let sar12_p = v(TOPP)[sar12_k]
let sar12_n = v(TOPN)[sar12_k]
let sar12_decision = 0
if sar12_cmp >= 0.9
let sar12_code = sar12_trial
let sar12_decision = 1
end
echo 12 7 $&sar12_trial $&sar12_cmp $&sar12_cmpn $&sar12_p $&sar12_n 1.19912109375 $&sar12_decision >> decisions.csv
alter VD_EVAL = 0
let sar12_trial = sar12_code + 64
let sar12_drive = (floor(sar12_trial / 1) - 2*floor(sar12_trial / 2))*1.8
alter VD_B0 = $&sar12_drive
let sar12_drive = (floor(sar12_trial / 2) - 2*floor(sar12_trial / 4))*1.8
alter VD_B1 = $&sar12_drive
let sar12_drive = (floor(sar12_trial / 4) - 2*floor(sar12_trial / 8))*1.8
alter VD_B2 = $&sar12_drive
let sar12_drive = (floor(sar12_trial / 8) - 2*floor(sar12_trial / 16))*1.8
alter VD_B3 = $&sar12_drive
let sar12_drive = (floor(sar12_trial / 16) - 2*floor(sar12_trial / 32))*1.8
alter VD_B4 = $&sar12_drive
let sar12_drive = (floor(sar12_trial / 32) - 2*floor(sar12_trial / 64))*1.8
alter VD_B5 = $&sar12_drive
let sar12_drive = (floor(sar12_trial / 64) - 2*floor(sar12_trial / 128))*1.8
alter VD_B6 = $&sar12_drive
let sar12_drive = (floor(sar12_trial / 128) - 2*floor(sar12_trial / 256))*1.8
alter VD_B7 = $&sar12_drive
let sar12_drive = (floor(sar12_trial / 256) - 2*floor(sar12_trial / 512))*1.8
alter VD_B8 = $&sar12_drive
let sar12_drive = (floor(sar12_trial / 512) - 2*floor(sar12_trial / 1024))*1.8
alter VD_B9 = $&sar12_drive
let sar12_drive = (floor(sar12_trial / 1024) - 2*floor(sar12_trial / 2048))*1.8
alter VD_B10 = $&sar12_drive
let sar12_drive = (floor(sar12_trial / 2048) - 2*floor(sar12_trial / 4096))*1.8
alter VD_B11 = $&sar12_drive
stop when time ge 0.000127474999999
resume
let sar12_k = length(time)-1
if abs(time[sar12_k] - 0.000127475) > 1e-12
print time[sar12_k]
echo expected_pause_time_s 0.000127475
echo SAR12_PAUSE_FAILED
quit 1
end
print time[sar12_k] >> pause-times.txt
delete all
alter VD_EVAL = 1.8
stop when time ge 0.000127649999999
resume
let sar12_k = length(time)-1
if abs(time[sar12_k] - 0.00012765) > 1e-12
print time[sar12_k]
echo expected_pause_time_s 0.00012765
echo SAR12_PAUSE_FAILED
quit 1
end
print time[sar12_k] >> pause-times.txt
delete all
let sar12_k = length(time)-1
let sar12_cmp = v(COMP)[sar12_k]
let sar12_cmpn = v(COMPN)[sar12_k]
let sar12_p = v(TOPP)[sar12_k]
let sar12_n = v(TOPN)[sar12_k]
let sar12_decision = 0
if sar12_cmp >= 0.9
let sar12_code = sar12_trial
let sar12_decision = 1
end
echo 12 6 $&sar12_trial $&sar12_cmp $&sar12_cmpn $&sar12_p $&sar12_n 1.19912109375 $&sar12_decision >> decisions.csv
alter VD_EVAL = 0
let sar12_trial = sar12_code + 32
let sar12_drive = (floor(sar12_trial / 1) - 2*floor(sar12_trial / 2))*1.8
alter VD_B0 = $&sar12_drive
let sar12_drive = (floor(sar12_trial / 2) - 2*floor(sar12_trial / 4))*1.8
alter VD_B1 = $&sar12_drive
let sar12_drive = (floor(sar12_trial / 4) - 2*floor(sar12_trial / 8))*1.8
alter VD_B2 = $&sar12_drive
let sar12_drive = (floor(sar12_trial / 8) - 2*floor(sar12_trial / 16))*1.8
alter VD_B3 = $&sar12_drive
let sar12_drive = (floor(sar12_trial / 16) - 2*floor(sar12_trial / 32))*1.8
alter VD_B4 = $&sar12_drive
let sar12_drive = (floor(sar12_trial / 32) - 2*floor(sar12_trial / 64))*1.8
alter VD_B5 = $&sar12_drive
let sar12_drive = (floor(sar12_trial / 64) - 2*floor(sar12_trial / 128))*1.8
alter VD_B6 = $&sar12_drive
let sar12_drive = (floor(sar12_trial / 128) - 2*floor(sar12_trial / 256))*1.8
alter VD_B7 = $&sar12_drive
let sar12_drive = (floor(sar12_trial / 256) - 2*floor(sar12_trial / 512))*1.8
alter VD_B8 = $&sar12_drive
let sar12_drive = (floor(sar12_trial / 512) - 2*floor(sar12_trial / 1024))*1.8
alter VD_B9 = $&sar12_drive
let sar12_drive = (floor(sar12_trial / 1024) - 2*floor(sar12_trial / 2048))*1.8
alter VD_B10 = $&sar12_drive
let sar12_drive = (floor(sar12_trial / 2048) - 2*floor(sar12_trial / 4096))*1.8
alter VD_B11 = $&sar12_drive
stop when time ge 0.000127974999999
resume
let sar12_k = length(time)-1
if abs(time[sar12_k] - 0.000127975) > 1e-12
print time[sar12_k]
echo expected_pause_time_s 0.000127975
echo SAR12_PAUSE_FAILED
quit 1
end
print time[sar12_k] >> pause-times.txt
delete all
alter VD_EVAL = 1.8
stop when time ge 0.000128149999999
resume
let sar12_k = length(time)-1
if abs(time[sar12_k] - 0.00012815) > 1e-12
print time[sar12_k]
echo expected_pause_time_s 0.00012815
echo SAR12_PAUSE_FAILED
quit 1
end
print time[sar12_k] >> pause-times.txt
delete all
let sar12_k = length(time)-1
let sar12_cmp = v(COMP)[sar12_k]
let sar12_cmpn = v(COMPN)[sar12_k]
let sar12_p = v(TOPP)[sar12_k]
let sar12_n = v(TOPN)[sar12_k]
let sar12_decision = 0
if sar12_cmp >= 0.9
let sar12_code = sar12_trial
let sar12_decision = 1
end
echo 12 5 $&sar12_trial $&sar12_cmp $&sar12_cmpn $&sar12_p $&sar12_n 1.19912109375 $&sar12_decision >> decisions.csv
alter VD_EVAL = 0
let sar12_trial = sar12_code + 16
let sar12_drive = (floor(sar12_trial / 1) - 2*floor(sar12_trial / 2))*1.8
alter VD_B0 = $&sar12_drive
let sar12_drive = (floor(sar12_trial / 2) - 2*floor(sar12_trial / 4))*1.8
alter VD_B1 = $&sar12_drive
let sar12_drive = (floor(sar12_trial / 4) - 2*floor(sar12_trial / 8))*1.8
alter VD_B2 = $&sar12_drive
let sar12_drive = (floor(sar12_trial / 8) - 2*floor(sar12_trial / 16))*1.8
alter VD_B3 = $&sar12_drive
let sar12_drive = (floor(sar12_trial / 16) - 2*floor(sar12_trial / 32))*1.8
alter VD_B4 = $&sar12_drive
let sar12_drive = (floor(sar12_trial / 32) - 2*floor(sar12_trial / 64))*1.8
alter VD_B5 = $&sar12_drive
let sar12_drive = (floor(sar12_trial / 64) - 2*floor(sar12_trial / 128))*1.8
alter VD_B6 = $&sar12_drive
let sar12_drive = (floor(sar12_trial / 128) - 2*floor(sar12_trial / 256))*1.8
alter VD_B7 = $&sar12_drive
let sar12_drive = (floor(sar12_trial / 256) - 2*floor(sar12_trial / 512))*1.8
alter VD_B8 = $&sar12_drive
let sar12_drive = (floor(sar12_trial / 512) - 2*floor(sar12_trial / 1024))*1.8
alter VD_B9 = $&sar12_drive
let sar12_drive = (floor(sar12_trial / 1024) - 2*floor(sar12_trial / 2048))*1.8
alter VD_B10 = $&sar12_drive
let sar12_drive = (floor(sar12_trial / 2048) - 2*floor(sar12_trial / 4096))*1.8
alter VD_B11 = $&sar12_drive
stop when time ge 0.000128474999999
resume
let sar12_k = length(time)-1
if abs(time[sar12_k] - 0.000128475) > 1e-12
print time[sar12_k]
echo expected_pause_time_s 0.000128475
echo SAR12_PAUSE_FAILED
quit 1
end
print time[sar12_k] >> pause-times.txt
delete all
alter VD_EVAL = 1.8
stop when time ge 0.000128649999999
resume
let sar12_k = length(time)-1
if abs(time[sar12_k] - 0.00012865) > 1e-12
print time[sar12_k]
echo expected_pause_time_s 0.00012865
echo SAR12_PAUSE_FAILED
quit 1
end
print time[sar12_k] >> pause-times.txt
delete all
let sar12_k = length(time)-1
let sar12_cmp = v(COMP)[sar12_k]
let sar12_cmpn = v(COMPN)[sar12_k]
let sar12_p = v(TOPP)[sar12_k]
let sar12_n = v(TOPN)[sar12_k]
let sar12_decision = 0
if sar12_cmp >= 0.9
let sar12_code = sar12_trial
let sar12_decision = 1
end
echo 12 4 $&sar12_trial $&sar12_cmp $&sar12_cmpn $&sar12_p $&sar12_n 1.19912109375 $&sar12_decision >> decisions.csv
alter VD_EVAL = 0
let sar12_trial = sar12_code + 8
let sar12_drive = (floor(sar12_trial / 1) - 2*floor(sar12_trial / 2))*1.8
alter VD_B0 = $&sar12_drive
let sar12_drive = (floor(sar12_trial / 2) - 2*floor(sar12_trial / 4))*1.8
alter VD_B1 = $&sar12_drive
let sar12_drive = (floor(sar12_trial / 4) - 2*floor(sar12_trial / 8))*1.8
alter VD_B2 = $&sar12_drive
let sar12_drive = (floor(sar12_trial / 8) - 2*floor(sar12_trial / 16))*1.8
alter VD_B3 = $&sar12_drive
let sar12_drive = (floor(sar12_trial / 16) - 2*floor(sar12_trial / 32))*1.8
alter VD_B4 = $&sar12_drive
let sar12_drive = (floor(sar12_trial / 32) - 2*floor(sar12_trial / 64))*1.8
alter VD_B5 = $&sar12_drive
let sar12_drive = (floor(sar12_trial / 64) - 2*floor(sar12_trial / 128))*1.8
alter VD_B6 = $&sar12_drive
let sar12_drive = (floor(sar12_trial / 128) - 2*floor(sar12_trial / 256))*1.8
alter VD_B7 = $&sar12_drive
let sar12_drive = (floor(sar12_trial / 256) - 2*floor(sar12_trial / 512))*1.8
alter VD_B8 = $&sar12_drive
let sar12_drive = (floor(sar12_trial / 512) - 2*floor(sar12_trial / 1024))*1.8
alter VD_B9 = $&sar12_drive
let sar12_drive = (floor(sar12_trial / 1024) - 2*floor(sar12_trial / 2048))*1.8
alter VD_B10 = $&sar12_drive
let sar12_drive = (floor(sar12_trial / 2048) - 2*floor(sar12_trial / 4096))*1.8
alter VD_B11 = $&sar12_drive
stop when time ge 0.000128974999999
resume
let sar12_k = length(time)-1
if abs(time[sar12_k] - 0.000128975) > 1e-12
print time[sar12_k]
echo expected_pause_time_s 0.000128975
echo SAR12_PAUSE_FAILED
quit 1
end
print time[sar12_k] >> pause-times.txt
delete all
alter VD_EVAL = 1.8
stop when time ge 0.000129149999999
resume
let sar12_k = length(time)-1
if abs(time[sar12_k] - 0.00012915) > 1e-12
print time[sar12_k]
echo expected_pause_time_s 0.00012915
echo SAR12_PAUSE_FAILED
quit 1
end
print time[sar12_k] >> pause-times.txt
delete all
let sar12_k = length(time)-1
let sar12_cmp = v(COMP)[sar12_k]
let sar12_cmpn = v(COMPN)[sar12_k]
let sar12_p = v(TOPP)[sar12_k]
let sar12_n = v(TOPN)[sar12_k]
let sar12_decision = 0
if sar12_cmp >= 0.9
let sar12_code = sar12_trial
let sar12_decision = 1
end
echo 12 3 $&sar12_trial $&sar12_cmp $&sar12_cmpn $&sar12_p $&sar12_n 1.19912109375 $&sar12_decision >> decisions.csv
alter VD_EVAL = 0
let sar12_trial = sar12_code + 4
let sar12_drive = (floor(sar12_trial / 1) - 2*floor(sar12_trial / 2))*1.8
alter VD_B0 = $&sar12_drive
let sar12_drive = (floor(sar12_trial / 2) - 2*floor(sar12_trial / 4))*1.8
alter VD_B1 = $&sar12_drive
let sar12_drive = (floor(sar12_trial / 4) - 2*floor(sar12_trial / 8))*1.8
alter VD_B2 = $&sar12_drive
let sar12_drive = (floor(sar12_trial / 8) - 2*floor(sar12_trial / 16))*1.8
alter VD_B3 = $&sar12_drive
let sar12_drive = (floor(sar12_trial / 16) - 2*floor(sar12_trial / 32))*1.8
alter VD_B4 = $&sar12_drive
let sar12_drive = (floor(sar12_trial / 32) - 2*floor(sar12_trial / 64))*1.8
alter VD_B5 = $&sar12_drive
let sar12_drive = (floor(sar12_trial / 64) - 2*floor(sar12_trial / 128))*1.8
alter VD_B6 = $&sar12_drive
let sar12_drive = (floor(sar12_trial / 128) - 2*floor(sar12_trial / 256))*1.8
alter VD_B7 = $&sar12_drive
let sar12_drive = (floor(sar12_trial / 256) - 2*floor(sar12_trial / 512))*1.8
alter VD_B8 = $&sar12_drive
let sar12_drive = (floor(sar12_trial / 512) - 2*floor(sar12_trial / 1024))*1.8
alter VD_B9 = $&sar12_drive
let sar12_drive = (floor(sar12_trial / 1024) - 2*floor(sar12_trial / 2048))*1.8
alter VD_B10 = $&sar12_drive
let sar12_drive = (floor(sar12_trial / 2048) - 2*floor(sar12_trial / 4096))*1.8
alter VD_B11 = $&sar12_drive
stop when time ge 0.000129474999999
resume
let sar12_k = length(time)-1
if abs(time[sar12_k] - 0.000129475) > 1e-12
print time[sar12_k]
echo expected_pause_time_s 0.000129475
echo SAR12_PAUSE_FAILED
quit 1
end
print time[sar12_k] >> pause-times.txt
delete all
alter VD_EVAL = 1.8
stop when time ge 0.000129649999999
resume
let sar12_k = length(time)-1
if abs(time[sar12_k] - 0.00012965) > 1e-12
print time[sar12_k]
echo expected_pause_time_s 0.00012965
echo SAR12_PAUSE_FAILED
quit 1
end
print time[sar12_k] >> pause-times.txt
delete all
let sar12_k = length(time)-1
let sar12_cmp = v(COMP)[sar12_k]
let sar12_cmpn = v(COMPN)[sar12_k]
let sar12_p = v(TOPP)[sar12_k]
let sar12_n = v(TOPN)[sar12_k]
let sar12_decision = 0
if sar12_cmp >= 0.9
let sar12_code = sar12_trial
let sar12_decision = 1
end
echo 12 2 $&sar12_trial $&sar12_cmp $&sar12_cmpn $&sar12_p $&sar12_n 1.19912109375 $&sar12_decision >> decisions.csv
alter VD_EVAL = 0
let sar12_trial = sar12_code + 2
let sar12_drive = (floor(sar12_trial / 1) - 2*floor(sar12_trial / 2))*1.8
alter VD_B0 = $&sar12_drive
let sar12_drive = (floor(sar12_trial / 2) - 2*floor(sar12_trial / 4))*1.8
alter VD_B1 = $&sar12_drive
let sar12_drive = (floor(sar12_trial / 4) - 2*floor(sar12_trial / 8))*1.8
alter VD_B2 = $&sar12_drive
let sar12_drive = (floor(sar12_trial / 8) - 2*floor(sar12_trial / 16))*1.8
alter VD_B3 = $&sar12_drive
let sar12_drive = (floor(sar12_trial / 16) - 2*floor(sar12_trial / 32))*1.8
alter VD_B4 = $&sar12_drive
let sar12_drive = (floor(sar12_trial / 32) - 2*floor(sar12_trial / 64))*1.8
alter VD_B5 = $&sar12_drive
let sar12_drive = (floor(sar12_trial / 64) - 2*floor(sar12_trial / 128))*1.8
alter VD_B6 = $&sar12_drive
let sar12_drive = (floor(sar12_trial / 128) - 2*floor(sar12_trial / 256))*1.8
alter VD_B7 = $&sar12_drive
let sar12_drive = (floor(sar12_trial / 256) - 2*floor(sar12_trial / 512))*1.8
alter VD_B8 = $&sar12_drive
let sar12_drive = (floor(sar12_trial / 512) - 2*floor(sar12_trial / 1024))*1.8
alter VD_B9 = $&sar12_drive
let sar12_drive = (floor(sar12_trial / 1024) - 2*floor(sar12_trial / 2048))*1.8
alter VD_B10 = $&sar12_drive
let sar12_drive = (floor(sar12_trial / 2048) - 2*floor(sar12_trial / 4096))*1.8
alter VD_B11 = $&sar12_drive
stop when time ge 0.000129974999999
resume
let sar12_k = length(time)-1
if abs(time[sar12_k] - 0.000129975) > 1e-12
print time[sar12_k]
echo expected_pause_time_s 0.000129975
echo SAR12_PAUSE_FAILED
quit 1
end
print time[sar12_k] >> pause-times.txt
delete all
alter VD_EVAL = 1.8
stop when time ge 0.000130149999999
resume
let sar12_k = length(time)-1
if abs(time[sar12_k] - 0.00013015) > 1e-12
print time[sar12_k]
echo expected_pause_time_s 0.00013015
echo SAR12_PAUSE_FAILED
quit 1
end
print time[sar12_k] >> pause-times.txt
delete all
let sar12_k = length(time)-1
let sar12_cmp = v(COMP)[sar12_k]
let sar12_cmpn = v(COMPN)[sar12_k]
let sar12_p = v(TOPP)[sar12_k]
let sar12_n = v(TOPN)[sar12_k]
let sar12_decision = 0
if sar12_cmp >= 0.9
let sar12_code = sar12_trial
let sar12_decision = 1
end
echo 12 1 $&sar12_trial $&sar12_cmp $&sar12_cmpn $&sar12_p $&sar12_n 1.19912109375 $&sar12_decision >> decisions.csv
alter VD_EVAL = 0
let sar12_trial = sar12_code + 1
let sar12_drive = (floor(sar12_trial / 1) - 2*floor(sar12_trial / 2))*1.8
alter VD_B0 = $&sar12_drive
let sar12_drive = (floor(sar12_trial / 2) - 2*floor(sar12_trial / 4))*1.8
alter VD_B1 = $&sar12_drive
let sar12_drive = (floor(sar12_trial / 4) - 2*floor(sar12_trial / 8))*1.8
alter VD_B2 = $&sar12_drive
let sar12_drive = (floor(sar12_trial / 8) - 2*floor(sar12_trial / 16))*1.8
alter VD_B3 = $&sar12_drive
let sar12_drive = (floor(sar12_trial / 16) - 2*floor(sar12_trial / 32))*1.8
alter VD_B4 = $&sar12_drive
let sar12_drive = (floor(sar12_trial / 32) - 2*floor(sar12_trial / 64))*1.8
alter VD_B5 = $&sar12_drive
let sar12_drive = (floor(sar12_trial / 64) - 2*floor(sar12_trial / 128))*1.8
alter VD_B6 = $&sar12_drive
let sar12_drive = (floor(sar12_trial / 128) - 2*floor(sar12_trial / 256))*1.8
alter VD_B7 = $&sar12_drive
let sar12_drive = (floor(sar12_trial / 256) - 2*floor(sar12_trial / 512))*1.8
alter VD_B8 = $&sar12_drive
let sar12_drive = (floor(sar12_trial / 512) - 2*floor(sar12_trial / 1024))*1.8
alter VD_B9 = $&sar12_drive
let sar12_drive = (floor(sar12_trial / 1024) - 2*floor(sar12_trial / 2048))*1.8
alter VD_B10 = $&sar12_drive
let sar12_drive = (floor(sar12_trial / 2048) - 2*floor(sar12_trial / 4096))*1.8
alter VD_B11 = $&sar12_drive
stop when time ge 0.000130474999999
resume
let sar12_k = length(time)-1
if abs(time[sar12_k] - 0.000130475) > 1e-12
print time[sar12_k]
echo expected_pause_time_s 0.000130475
echo SAR12_PAUSE_FAILED
quit 1
end
print time[sar12_k] >> pause-times.txt
delete all
alter VD_EVAL = 1.8
stop when time ge 0.000130649999999
resume
let sar12_k = length(time)-1
if abs(time[sar12_k] - 0.00013065) > 1e-12
print time[sar12_k]
echo expected_pause_time_s 0.00013065
echo SAR12_PAUSE_FAILED
quit 1
end
print time[sar12_k] >> pause-times.txt
delete all
let sar12_k = length(time)-1
let sar12_cmp = v(COMP)[sar12_k]
let sar12_cmpn = v(COMPN)[sar12_k]
let sar12_p = v(TOPP)[sar12_k]
let sar12_n = v(TOPN)[sar12_k]
let sar12_decision = 0
if sar12_cmp >= 0.9
let sar12_code = sar12_trial
let sar12_decision = 1
end
echo 12 0 $&sar12_trial $&sar12_cmp $&sar12_cmpn $&sar12_p $&sar12_n 1.19912109375 $&sar12_decision >> decisions.csv
alter VD_EVAL = 0
alter VINP = 1.49985351562
alter VINN = 0.300146484375
alter VD_SAMPLE = 1.8
alter VD_EVAL = 0
alter VD_B0 = 0
alter VD_B1 = 0
alter VD_B2 = 0
alter VD_B3 = 0
alter VD_B4 = 0
alter VD_B5 = 0
alter VD_B6 = 0
alter VD_B7 = 0
alter VD_B8 = 0
alter VD_B9 = 0
alter VD_B10 = 0
alter VD_B11 = 0
let sar12_code = 0
stop when time ge 0.000134649999999
resume
let sar12_k = length(time)-1
if abs(time[sar12_k] - 0.00013465) > 1e-12
print time[sar12_k]
echo expected_pause_time_s 0.00013465
echo SAR12_PAUSE_FAILED
quit 1
end
print time[sar12_k] >> pause-times.txt
delete all
alter VD_SAMPLE = 0
stop when time ge 0.000134699999999
resume
let sar12_k = length(time)-1
if abs(time[sar12_k] - 0.0001347) > 1e-12
print time[sar12_k]
echo expected_pause_time_s 0.0001347
echo SAR12_PAUSE_FAILED
quit 1
end
print time[sar12_k] >> pause-times.txt
delete all
alter VD_EVAL = 0
let sar12_trial = sar12_code + 2048
let sar12_drive = (floor(sar12_trial / 1) - 2*floor(sar12_trial / 2))*1.8
alter VD_B0 = $&sar12_drive
let sar12_drive = (floor(sar12_trial / 2) - 2*floor(sar12_trial / 4))*1.8
alter VD_B1 = $&sar12_drive
let sar12_drive = (floor(sar12_trial / 4) - 2*floor(sar12_trial / 8))*1.8
alter VD_B2 = $&sar12_drive
let sar12_drive = (floor(sar12_trial / 8) - 2*floor(sar12_trial / 16))*1.8
alter VD_B3 = $&sar12_drive
let sar12_drive = (floor(sar12_trial / 16) - 2*floor(sar12_trial / 32))*1.8
alter VD_B4 = $&sar12_drive
let sar12_drive = (floor(sar12_trial / 32) - 2*floor(sar12_trial / 64))*1.8
alter VD_B5 = $&sar12_drive
let sar12_drive = (floor(sar12_trial / 64) - 2*floor(sar12_trial / 128))*1.8
alter VD_B6 = $&sar12_drive
let sar12_drive = (floor(sar12_trial / 128) - 2*floor(sar12_trial / 256))*1.8
alter VD_B7 = $&sar12_drive
let sar12_drive = (floor(sar12_trial / 256) - 2*floor(sar12_trial / 512))*1.8
alter VD_B8 = $&sar12_drive
let sar12_drive = (floor(sar12_trial / 512) - 2*floor(sar12_trial / 1024))*1.8
alter VD_B9 = $&sar12_drive
let sar12_drive = (floor(sar12_trial / 1024) - 2*floor(sar12_trial / 2048))*1.8
alter VD_B10 = $&sar12_drive
let sar12_drive = (floor(sar12_trial / 2048) - 2*floor(sar12_trial / 4096))*1.8
alter VD_B11 = $&sar12_drive
stop when time ge 0.000135024999999
resume
let sar12_k = length(time)-1
if abs(time[sar12_k] - 0.000135025) > 1e-12
print time[sar12_k]
echo expected_pause_time_s 0.000135025
echo SAR12_PAUSE_FAILED
quit 1
end
print time[sar12_k] >> pause-times.txt
delete all
alter VD_EVAL = 1.8
stop when time ge 0.000135199999999
resume
let sar12_k = length(time)-1
if abs(time[sar12_k] - 0.0001352) > 1e-12
print time[sar12_k]
echo expected_pause_time_s 0.0001352
echo SAR12_PAUSE_FAILED
quit 1
end
print time[sar12_k] >> pause-times.txt
delete all
let sar12_k = length(time)-1
let sar12_cmp = v(COMP)[sar12_k]
let sar12_cmpn = v(COMPN)[sar12_k]
let sar12_p = v(TOPP)[sar12_k]
let sar12_n = v(TOPN)[sar12_k]
let sar12_decision = 0
if sar12_cmp >= 0.9
let sar12_code = sar12_trial
let sar12_decision = 1
end
echo 13 11 $&sar12_trial $&sar12_cmp $&sar12_cmpn $&sar12_p $&sar12_n 1.19970703125 $&sar12_decision >> decisions.csv
alter VD_EVAL = 0
let sar12_trial = sar12_code + 1024
let sar12_drive = (floor(sar12_trial / 1) - 2*floor(sar12_trial / 2))*1.8
alter VD_B0 = $&sar12_drive
let sar12_drive = (floor(sar12_trial / 2) - 2*floor(sar12_trial / 4))*1.8
alter VD_B1 = $&sar12_drive
let sar12_drive = (floor(sar12_trial / 4) - 2*floor(sar12_trial / 8))*1.8
alter VD_B2 = $&sar12_drive
let sar12_drive = (floor(sar12_trial / 8) - 2*floor(sar12_trial / 16))*1.8
alter VD_B3 = $&sar12_drive
let sar12_drive = (floor(sar12_trial / 16) - 2*floor(sar12_trial / 32))*1.8
alter VD_B4 = $&sar12_drive
let sar12_drive = (floor(sar12_trial / 32) - 2*floor(sar12_trial / 64))*1.8
alter VD_B5 = $&sar12_drive
let sar12_drive = (floor(sar12_trial / 64) - 2*floor(sar12_trial / 128))*1.8
alter VD_B6 = $&sar12_drive
let sar12_drive = (floor(sar12_trial / 128) - 2*floor(sar12_trial / 256))*1.8
alter VD_B7 = $&sar12_drive
let sar12_drive = (floor(sar12_trial / 256) - 2*floor(sar12_trial / 512))*1.8
alter VD_B8 = $&sar12_drive
let sar12_drive = (floor(sar12_trial / 512) - 2*floor(sar12_trial / 1024))*1.8
alter VD_B9 = $&sar12_drive
let sar12_drive = (floor(sar12_trial / 1024) - 2*floor(sar12_trial / 2048))*1.8
alter VD_B10 = $&sar12_drive
let sar12_drive = (floor(sar12_trial / 2048) - 2*floor(sar12_trial / 4096))*1.8
alter VD_B11 = $&sar12_drive
stop when time ge 0.000135524999999
resume
let sar12_k = length(time)-1
if abs(time[sar12_k] - 0.000135525) > 1e-12
print time[sar12_k]
echo expected_pause_time_s 0.000135525
echo SAR12_PAUSE_FAILED
quit 1
end
print time[sar12_k] >> pause-times.txt
delete all
alter VD_EVAL = 1.8
stop when time ge 0.000135699999999
resume
let sar12_k = length(time)-1
if abs(time[sar12_k] - 0.0001357) > 1e-12
print time[sar12_k]
echo expected_pause_time_s 0.0001357
echo SAR12_PAUSE_FAILED
quit 1
end
print time[sar12_k] >> pause-times.txt
delete all
let sar12_k = length(time)-1
let sar12_cmp = v(COMP)[sar12_k]
let sar12_cmpn = v(COMPN)[sar12_k]
let sar12_p = v(TOPP)[sar12_k]
let sar12_n = v(TOPN)[sar12_k]
let sar12_decision = 0
if sar12_cmp >= 0.9
let sar12_code = sar12_trial
let sar12_decision = 1
end
echo 13 10 $&sar12_trial $&sar12_cmp $&sar12_cmpn $&sar12_p $&sar12_n 1.19970703125 $&sar12_decision >> decisions.csv
alter VD_EVAL = 0
let sar12_trial = sar12_code + 512
let sar12_drive = (floor(sar12_trial / 1) - 2*floor(sar12_trial / 2))*1.8
alter VD_B0 = $&sar12_drive
let sar12_drive = (floor(sar12_trial / 2) - 2*floor(sar12_trial / 4))*1.8
alter VD_B1 = $&sar12_drive
let sar12_drive = (floor(sar12_trial / 4) - 2*floor(sar12_trial / 8))*1.8
alter VD_B2 = $&sar12_drive
let sar12_drive = (floor(sar12_trial / 8) - 2*floor(sar12_trial / 16))*1.8
alter VD_B3 = $&sar12_drive
let sar12_drive = (floor(sar12_trial / 16) - 2*floor(sar12_trial / 32))*1.8
alter VD_B4 = $&sar12_drive
let sar12_drive = (floor(sar12_trial / 32) - 2*floor(sar12_trial / 64))*1.8
alter VD_B5 = $&sar12_drive
let sar12_drive = (floor(sar12_trial / 64) - 2*floor(sar12_trial / 128))*1.8
alter VD_B6 = $&sar12_drive
let sar12_drive = (floor(sar12_trial / 128) - 2*floor(sar12_trial / 256))*1.8
alter VD_B7 = $&sar12_drive
let sar12_drive = (floor(sar12_trial / 256) - 2*floor(sar12_trial / 512))*1.8
alter VD_B8 = $&sar12_drive
let sar12_drive = (floor(sar12_trial / 512) - 2*floor(sar12_trial / 1024))*1.8
alter VD_B9 = $&sar12_drive
let sar12_drive = (floor(sar12_trial / 1024) - 2*floor(sar12_trial / 2048))*1.8
alter VD_B10 = $&sar12_drive
let sar12_drive = (floor(sar12_trial / 2048) - 2*floor(sar12_trial / 4096))*1.8
alter VD_B11 = $&sar12_drive
stop when time ge 0.000136024999999
resume
let sar12_k = length(time)-1
if abs(time[sar12_k] - 0.000136025) > 1e-12
print time[sar12_k]
echo expected_pause_time_s 0.000136025
echo SAR12_PAUSE_FAILED
quit 1
end
print time[sar12_k] >> pause-times.txt
delete all
alter VD_EVAL = 1.8
stop when time ge 0.000136199999999
resume
let sar12_k = length(time)-1
if abs(time[sar12_k] - 0.0001362) > 1e-12
print time[sar12_k]
echo expected_pause_time_s 0.0001362
echo SAR12_PAUSE_FAILED
quit 1
end
print time[sar12_k] >> pause-times.txt
delete all
let sar12_k = length(time)-1
let sar12_cmp = v(COMP)[sar12_k]
let sar12_cmpn = v(COMPN)[sar12_k]
let sar12_p = v(TOPP)[sar12_k]
let sar12_n = v(TOPN)[sar12_k]
let sar12_decision = 0
if sar12_cmp >= 0.9
let sar12_code = sar12_trial
let sar12_decision = 1
end
echo 13 9 $&sar12_trial $&sar12_cmp $&sar12_cmpn $&sar12_p $&sar12_n 1.19970703125 $&sar12_decision >> decisions.csv
alter VD_EVAL = 0
let sar12_trial = sar12_code + 256
let sar12_drive = (floor(sar12_trial / 1) - 2*floor(sar12_trial / 2))*1.8
alter VD_B0 = $&sar12_drive
let sar12_drive = (floor(sar12_trial / 2) - 2*floor(sar12_trial / 4))*1.8
alter VD_B1 = $&sar12_drive
let sar12_drive = (floor(sar12_trial / 4) - 2*floor(sar12_trial / 8))*1.8
alter VD_B2 = $&sar12_drive
let sar12_drive = (floor(sar12_trial / 8) - 2*floor(sar12_trial / 16))*1.8
alter VD_B3 = $&sar12_drive
let sar12_drive = (floor(sar12_trial / 16) - 2*floor(sar12_trial / 32))*1.8
alter VD_B4 = $&sar12_drive
let sar12_drive = (floor(sar12_trial / 32) - 2*floor(sar12_trial / 64))*1.8
alter VD_B5 = $&sar12_drive
let sar12_drive = (floor(sar12_trial / 64) - 2*floor(sar12_trial / 128))*1.8
alter VD_B6 = $&sar12_drive
let sar12_drive = (floor(sar12_trial / 128) - 2*floor(sar12_trial / 256))*1.8
alter VD_B7 = $&sar12_drive
let sar12_drive = (floor(sar12_trial / 256) - 2*floor(sar12_trial / 512))*1.8
alter VD_B8 = $&sar12_drive
let sar12_drive = (floor(sar12_trial / 512) - 2*floor(sar12_trial / 1024))*1.8
alter VD_B9 = $&sar12_drive
let sar12_drive = (floor(sar12_trial / 1024) - 2*floor(sar12_trial / 2048))*1.8
alter VD_B10 = $&sar12_drive
let sar12_drive = (floor(sar12_trial / 2048) - 2*floor(sar12_trial / 4096))*1.8
alter VD_B11 = $&sar12_drive
stop when time ge 0.000136524999999
resume
let sar12_k = length(time)-1
if abs(time[sar12_k] - 0.000136525) > 1e-12
print time[sar12_k]
echo expected_pause_time_s 0.000136525
echo SAR12_PAUSE_FAILED
quit 1
end
print time[sar12_k] >> pause-times.txt
delete all
alter VD_EVAL = 1.8
stop when time ge 0.000136699999999
resume
let sar12_k = length(time)-1
if abs(time[sar12_k] - 0.0001367) > 1e-12
print time[sar12_k]
echo expected_pause_time_s 0.0001367
echo SAR12_PAUSE_FAILED
quit 1
end
print time[sar12_k] >> pause-times.txt
delete all
let sar12_k = length(time)-1
let sar12_cmp = v(COMP)[sar12_k]
let sar12_cmpn = v(COMPN)[sar12_k]
let sar12_p = v(TOPP)[sar12_k]
let sar12_n = v(TOPN)[sar12_k]
let sar12_decision = 0
if sar12_cmp >= 0.9
let sar12_code = sar12_trial
let sar12_decision = 1
end
echo 13 8 $&sar12_trial $&sar12_cmp $&sar12_cmpn $&sar12_p $&sar12_n 1.19970703125 $&sar12_decision >> decisions.csv
alter VD_EVAL = 0
let sar12_trial = sar12_code + 128
let sar12_drive = (floor(sar12_trial / 1) - 2*floor(sar12_trial / 2))*1.8
alter VD_B0 = $&sar12_drive
let sar12_drive = (floor(sar12_trial / 2) - 2*floor(sar12_trial / 4))*1.8
alter VD_B1 = $&sar12_drive
let sar12_drive = (floor(sar12_trial / 4) - 2*floor(sar12_trial / 8))*1.8
alter VD_B2 = $&sar12_drive
let sar12_drive = (floor(sar12_trial / 8) - 2*floor(sar12_trial / 16))*1.8
alter VD_B3 = $&sar12_drive
let sar12_drive = (floor(sar12_trial / 16) - 2*floor(sar12_trial / 32))*1.8
alter VD_B4 = $&sar12_drive
let sar12_drive = (floor(sar12_trial / 32) - 2*floor(sar12_trial / 64))*1.8
alter VD_B5 = $&sar12_drive
let sar12_drive = (floor(sar12_trial / 64) - 2*floor(sar12_trial / 128))*1.8
alter VD_B6 = $&sar12_drive
let sar12_drive = (floor(sar12_trial / 128) - 2*floor(sar12_trial / 256))*1.8
alter VD_B7 = $&sar12_drive
let sar12_drive = (floor(sar12_trial / 256) - 2*floor(sar12_trial / 512))*1.8
alter VD_B8 = $&sar12_drive
let sar12_drive = (floor(sar12_trial / 512) - 2*floor(sar12_trial / 1024))*1.8
alter VD_B9 = $&sar12_drive
let sar12_drive = (floor(sar12_trial / 1024) - 2*floor(sar12_trial / 2048))*1.8
alter VD_B10 = $&sar12_drive
let sar12_drive = (floor(sar12_trial / 2048) - 2*floor(sar12_trial / 4096))*1.8
alter VD_B11 = $&sar12_drive
stop when time ge 0.000137024999999
resume
let sar12_k = length(time)-1
if abs(time[sar12_k] - 0.000137025) > 1e-12
print time[sar12_k]
echo expected_pause_time_s 0.000137025
echo SAR12_PAUSE_FAILED
quit 1
end
print time[sar12_k] >> pause-times.txt
delete all
alter VD_EVAL = 1.8
stop when time ge 0.000137199999999
resume
let sar12_k = length(time)-1
if abs(time[sar12_k] - 0.0001372) > 1e-12
print time[sar12_k]
echo expected_pause_time_s 0.0001372
echo SAR12_PAUSE_FAILED
quit 1
end
print time[sar12_k] >> pause-times.txt
delete all
let sar12_k = length(time)-1
let sar12_cmp = v(COMP)[sar12_k]
let sar12_cmpn = v(COMPN)[sar12_k]
let sar12_p = v(TOPP)[sar12_k]
let sar12_n = v(TOPN)[sar12_k]
let sar12_decision = 0
if sar12_cmp >= 0.9
let sar12_code = sar12_trial
let sar12_decision = 1
end
echo 13 7 $&sar12_trial $&sar12_cmp $&sar12_cmpn $&sar12_p $&sar12_n 1.19970703125 $&sar12_decision >> decisions.csv
alter VD_EVAL = 0
let sar12_trial = sar12_code + 64
let sar12_drive = (floor(sar12_trial / 1) - 2*floor(sar12_trial / 2))*1.8
alter VD_B0 = $&sar12_drive
let sar12_drive = (floor(sar12_trial / 2) - 2*floor(sar12_trial / 4))*1.8
alter VD_B1 = $&sar12_drive
let sar12_drive = (floor(sar12_trial / 4) - 2*floor(sar12_trial / 8))*1.8
alter VD_B2 = $&sar12_drive
let sar12_drive = (floor(sar12_trial / 8) - 2*floor(sar12_trial / 16))*1.8
alter VD_B3 = $&sar12_drive
let sar12_drive = (floor(sar12_trial / 16) - 2*floor(sar12_trial / 32))*1.8
alter VD_B4 = $&sar12_drive
let sar12_drive = (floor(sar12_trial / 32) - 2*floor(sar12_trial / 64))*1.8
alter VD_B5 = $&sar12_drive
let sar12_drive = (floor(sar12_trial / 64) - 2*floor(sar12_trial / 128))*1.8
alter VD_B6 = $&sar12_drive
let sar12_drive = (floor(sar12_trial / 128) - 2*floor(sar12_trial / 256))*1.8
alter VD_B7 = $&sar12_drive
let sar12_drive = (floor(sar12_trial / 256) - 2*floor(sar12_trial / 512))*1.8
alter VD_B8 = $&sar12_drive
let sar12_drive = (floor(sar12_trial / 512) - 2*floor(sar12_trial / 1024))*1.8
alter VD_B9 = $&sar12_drive
let sar12_drive = (floor(sar12_trial / 1024) - 2*floor(sar12_trial / 2048))*1.8
alter VD_B10 = $&sar12_drive
let sar12_drive = (floor(sar12_trial / 2048) - 2*floor(sar12_trial / 4096))*1.8
alter VD_B11 = $&sar12_drive
stop when time ge 0.000137524999999
resume
let sar12_k = length(time)-1
if abs(time[sar12_k] - 0.000137525) > 1e-12
print time[sar12_k]
echo expected_pause_time_s 0.000137525
echo SAR12_PAUSE_FAILED
quit 1
end
print time[sar12_k] >> pause-times.txt
delete all
alter VD_EVAL = 1.8
stop when time ge 0.000137699999999
resume
let sar12_k = length(time)-1
if abs(time[sar12_k] - 0.0001377) > 1e-12
print time[sar12_k]
echo expected_pause_time_s 0.0001377
echo SAR12_PAUSE_FAILED
quit 1
end
print time[sar12_k] >> pause-times.txt
delete all
let sar12_k = length(time)-1
let sar12_cmp = v(COMP)[sar12_k]
let sar12_cmpn = v(COMPN)[sar12_k]
let sar12_p = v(TOPP)[sar12_k]
let sar12_n = v(TOPN)[sar12_k]
let sar12_decision = 0
if sar12_cmp >= 0.9
let sar12_code = sar12_trial
let sar12_decision = 1
end
echo 13 6 $&sar12_trial $&sar12_cmp $&sar12_cmpn $&sar12_p $&sar12_n 1.19970703125 $&sar12_decision >> decisions.csv
alter VD_EVAL = 0
let sar12_trial = sar12_code + 32
let sar12_drive = (floor(sar12_trial / 1) - 2*floor(sar12_trial / 2))*1.8
alter VD_B0 = $&sar12_drive
let sar12_drive = (floor(sar12_trial / 2) - 2*floor(sar12_trial / 4))*1.8
alter VD_B1 = $&sar12_drive
let sar12_drive = (floor(sar12_trial / 4) - 2*floor(sar12_trial / 8))*1.8
alter VD_B2 = $&sar12_drive
let sar12_drive = (floor(sar12_trial / 8) - 2*floor(sar12_trial / 16))*1.8
alter VD_B3 = $&sar12_drive
let sar12_drive = (floor(sar12_trial / 16) - 2*floor(sar12_trial / 32))*1.8
alter VD_B4 = $&sar12_drive
let sar12_drive = (floor(sar12_trial / 32) - 2*floor(sar12_trial / 64))*1.8
alter VD_B5 = $&sar12_drive
let sar12_drive = (floor(sar12_trial / 64) - 2*floor(sar12_trial / 128))*1.8
alter VD_B6 = $&sar12_drive
let sar12_drive = (floor(sar12_trial / 128) - 2*floor(sar12_trial / 256))*1.8
alter VD_B7 = $&sar12_drive
let sar12_drive = (floor(sar12_trial / 256) - 2*floor(sar12_trial / 512))*1.8
alter VD_B8 = $&sar12_drive
let sar12_drive = (floor(sar12_trial / 512) - 2*floor(sar12_trial / 1024))*1.8
alter VD_B9 = $&sar12_drive
let sar12_drive = (floor(sar12_trial / 1024) - 2*floor(sar12_trial / 2048))*1.8
alter VD_B10 = $&sar12_drive
let sar12_drive = (floor(sar12_trial / 2048) - 2*floor(sar12_trial / 4096))*1.8
alter VD_B11 = $&sar12_drive
stop when time ge 0.000138024999999
resume
let sar12_k = length(time)-1
if abs(time[sar12_k] - 0.000138025) > 1e-12
print time[sar12_k]
echo expected_pause_time_s 0.000138025
echo SAR12_PAUSE_FAILED
quit 1
end
print time[sar12_k] >> pause-times.txt
delete all
alter VD_EVAL = 1.8
stop when time ge 0.000138199999999
resume
let sar12_k = length(time)-1
if abs(time[sar12_k] - 0.0001382) > 1e-12
print time[sar12_k]
echo expected_pause_time_s 0.0001382
echo SAR12_PAUSE_FAILED
quit 1
end
print time[sar12_k] >> pause-times.txt
delete all
let sar12_k = length(time)-1
let sar12_cmp = v(COMP)[sar12_k]
let sar12_cmpn = v(COMPN)[sar12_k]
let sar12_p = v(TOPP)[sar12_k]
let sar12_n = v(TOPN)[sar12_k]
let sar12_decision = 0
if sar12_cmp >= 0.9
let sar12_code = sar12_trial
let sar12_decision = 1
end
echo 13 5 $&sar12_trial $&sar12_cmp $&sar12_cmpn $&sar12_p $&sar12_n 1.19970703125 $&sar12_decision >> decisions.csv
alter VD_EVAL = 0
let sar12_trial = sar12_code + 16
let sar12_drive = (floor(sar12_trial / 1) - 2*floor(sar12_trial / 2))*1.8
alter VD_B0 = $&sar12_drive
let sar12_drive = (floor(sar12_trial / 2) - 2*floor(sar12_trial / 4))*1.8
alter VD_B1 = $&sar12_drive
let sar12_drive = (floor(sar12_trial / 4) - 2*floor(sar12_trial / 8))*1.8
alter VD_B2 = $&sar12_drive
let sar12_drive = (floor(sar12_trial / 8) - 2*floor(sar12_trial / 16))*1.8
alter VD_B3 = $&sar12_drive
let sar12_drive = (floor(sar12_trial / 16) - 2*floor(sar12_trial / 32))*1.8
alter VD_B4 = $&sar12_drive
let sar12_drive = (floor(sar12_trial / 32) - 2*floor(sar12_trial / 64))*1.8
alter VD_B5 = $&sar12_drive
let sar12_drive = (floor(sar12_trial / 64) - 2*floor(sar12_trial / 128))*1.8
alter VD_B6 = $&sar12_drive
let sar12_drive = (floor(sar12_trial / 128) - 2*floor(sar12_trial / 256))*1.8
alter VD_B7 = $&sar12_drive
let sar12_drive = (floor(sar12_trial / 256) - 2*floor(sar12_trial / 512))*1.8
alter VD_B8 = $&sar12_drive
let sar12_drive = (floor(sar12_trial / 512) - 2*floor(sar12_trial / 1024))*1.8
alter VD_B9 = $&sar12_drive
let sar12_drive = (floor(sar12_trial / 1024) - 2*floor(sar12_trial / 2048))*1.8
alter VD_B10 = $&sar12_drive
let sar12_drive = (floor(sar12_trial / 2048) - 2*floor(sar12_trial / 4096))*1.8
alter VD_B11 = $&sar12_drive
stop when time ge 0.000138524999999
resume
let sar12_k = length(time)-1
if abs(time[sar12_k] - 0.000138525) > 1e-12
print time[sar12_k]
echo expected_pause_time_s 0.000138525
echo SAR12_PAUSE_FAILED
quit 1
end
print time[sar12_k] >> pause-times.txt
delete all
alter VD_EVAL = 1.8
stop when time ge 0.000138699999999
resume
let sar12_k = length(time)-1
if abs(time[sar12_k] - 0.0001387) > 1e-12
print time[sar12_k]
echo expected_pause_time_s 0.0001387
echo SAR12_PAUSE_FAILED
quit 1
end
print time[sar12_k] >> pause-times.txt
delete all
let sar12_k = length(time)-1
let sar12_cmp = v(COMP)[sar12_k]
let sar12_cmpn = v(COMPN)[sar12_k]
let sar12_p = v(TOPP)[sar12_k]
let sar12_n = v(TOPN)[sar12_k]
let sar12_decision = 0
if sar12_cmp >= 0.9
let sar12_code = sar12_trial
let sar12_decision = 1
end
echo 13 4 $&sar12_trial $&sar12_cmp $&sar12_cmpn $&sar12_p $&sar12_n 1.19970703125 $&sar12_decision >> decisions.csv
alter VD_EVAL = 0
let sar12_trial = sar12_code + 8
let sar12_drive = (floor(sar12_trial / 1) - 2*floor(sar12_trial / 2))*1.8
alter VD_B0 = $&sar12_drive
let sar12_drive = (floor(sar12_trial / 2) - 2*floor(sar12_trial / 4))*1.8
alter VD_B1 = $&sar12_drive
let sar12_drive = (floor(sar12_trial / 4) - 2*floor(sar12_trial / 8))*1.8
alter VD_B2 = $&sar12_drive
let sar12_drive = (floor(sar12_trial / 8) - 2*floor(sar12_trial / 16))*1.8
alter VD_B3 = $&sar12_drive
let sar12_drive = (floor(sar12_trial / 16) - 2*floor(sar12_trial / 32))*1.8
alter VD_B4 = $&sar12_drive
let sar12_drive = (floor(sar12_trial / 32) - 2*floor(sar12_trial / 64))*1.8
alter VD_B5 = $&sar12_drive
let sar12_drive = (floor(sar12_trial / 64) - 2*floor(sar12_trial / 128))*1.8
alter VD_B6 = $&sar12_drive
let sar12_drive = (floor(sar12_trial / 128) - 2*floor(sar12_trial / 256))*1.8
alter VD_B7 = $&sar12_drive
let sar12_drive = (floor(sar12_trial / 256) - 2*floor(sar12_trial / 512))*1.8
alter VD_B8 = $&sar12_drive
let sar12_drive = (floor(sar12_trial / 512) - 2*floor(sar12_trial / 1024))*1.8
alter VD_B9 = $&sar12_drive
let sar12_drive = (floor(sar12_trial / 1024) - 2*floor(sar12_trial / 2048))*1.8
alter VD_B10 = $&sar12_drive
let sar12_drive = (floor(sar12_trial / 2048) - 2*floor(sar12_trial / 4096))*1.8
alter VD_B11 = $&sar12_drive
stop when time ge 0.000139024999999
resume
let sar12_k = length(time)-1
if abs(time[sar12_k] - 0.000139025) > 1e-12
print time[sar12_k]
echo expected_pause_time_s 0.000139025
echo SAR12_PAUSE_FAILED
quit 1
end
print time[sar12_k] >> pause-times.txt
delete all
alter VD_EVAL = 1.8
stop when time ge 0.000139199999999
resume
let sar12_k = length(time)-1
if abs(time[sar12_k] - 0.0001392) > 1e-12
print time[sar12_k]
echo expected_pause_time_s 0.0001392
echo SAR12_PAUSE_FAILED
quit 1
end
print time[sar12_k] >> pause-times.txt
delete all
let sar12_k = length(time)-1
let sar12_cmp = v(COMP)[sar12_k]
let sar12_cmpn = v(COMPN)[sar12_k]
let sar12_p = v(TOPP)[sar12_k]
let sar12_n = v(TOPN)[sar12_k]
let sar12_decision = 0
if sar12_cmp >= 0.9
let sar12_code = sar12_trial
let sar12_decision = 1
end
echo 13 3 $&sar12_trial $&sar12_cmp $&sar12_cmpn $&sar12_p $&sar12_n 1.19970703125 $&sar12_decision >> decisions.csv
alter VD_EVAL = 0
let sar12_trial = sar12_code + 4
let sar12_drive = (floor(sar12_trial / 1) - 2*floor(sar12_trial / 2))*1.8
alter VD_B0 = $&sar12_drive
let sar12_drive = (floor(sar12_trial / 2) - 2*floor(sar12_trial / 4))*1.8
alter VD_B1 = $&sar12_drive
let sar12_drive = (floor(sar12_trial / 4) - 2*floor(sar12_trial / 8))*1.8
alter VD_B2 = $&sar12_drive
let sar12_drive = (floor(sar12_trial / 8) - 2*floor(sar12_trial / 16))*1.8
alter VD_B3 = $&sar12_drive
let sar12_drive = (floor(sar12_trial / 16) - 2*floor(sar12_trial / 32))*1.8
alter VD_B4 = $&sar12_drive
let sar12_drive = (floor(sar12_trial / 32) - 2*floor(sar12_trial / 64))*1.8
alter VD_B5 = $&sar12_drive
let sar12_drive = (floor(sar12_trial / 64) - 2*floor(sar12_trial / 128))*1.8
alter VD_B6 = $&sar12_drive
let sar12_drive = (floor(sar12_trial / 128) - 2*floor(sar12_trial / 256))*1.8
alter VD_B7 = $&sar12_drive
let sar12_drive = (floor(sar12_trial / 256) - 2*floor(sar12_trial / 512))*1.8
alter VD_B8 = $&sar12_drive
let sar12_drive = (floor(sar12_trial / 512) - 2*floor(sar12_trial / 1024))*1.8
alter VD_B9 = $&sar12_drive
let sar12_drive = (floor(sar12_trial / 1024) - 2*floor(sar12_trial / 2048))*1.8
alter VD_B10 = $&sar12_drive
let sar12_drive = (floor(sar12_trial / 2048) - 2*floor(sar12_trial / 4096))*1.8
alter VD_B11 = $&sar12_drive
stop when time ge 0.000139524999999
resume
let sar12_k = length(time)-1
if abs(time[sar12_k] - 0.000139525) > 1e-12
print time[sar12_k]
echo expected_pause_time_s 0.000139525
echo SAR12_PAUSE_FAILED
quit 1
end
print time[sar12_k] >> pause-times.txt
delete all
alter VD_EVAL = 1.8
stop when time ge 0.000139699999999
resume
let sar12_k = length(time)-1
if abs(time[sar12_k] - 0.0001397) > 1e-12
print time[sar12_k]
echo expected_pause_time_s 0.0001397
echo SAR12_PAUSE_FAILED
quit 1
end
print time[sar12_k] >> pause-times.txt
delete all
let sar12_k = length(time)-1
let sar12_cmp = v(COMP)[sar12_k]
let sar12_cmpn = v(COMPN)[sar12_k]
let sar12_p = v(TOPP)[sar12_k]
let sar12_n = v(TOPN)[sar12_k]
let sar12_decision = 0
if sar12_cmp >= 0.9
let sar12_code = sar12_trial
let sar12_decision = 1
end
echo 13 2 $&sar12_trial $&sar12_cmp $&sar12_cmpn $&sar12_p $&sar12_n 1.19970703125 $&sar12_decision >> decisions.csv
alter VD_EVAL = 0
let sar12_trial = sar12_code + 2
let sar12_drive = (floor(sar12_trial / 1) - 2*floor(sar12_trial / 2))*1.8
alter VD_B0 = $&sar12_drive
let sar12_drive = (floor(sar12_trial / 2) - 2*floor(sar12_trial / 4))*1.8
alter VD_B1 = $&sar12_drive
let sar12_drive = (floor(sar12_trial / 4) - 2*floor(sar12_trial / 8))*1.8
alter VD_B2 = $&sar12_drive
let sar12_drive = (floor(sar12_trial / 8) - 2*floor(sar12_trial / 16))*1.8
alter VD_B3 = $&sar12_drive
let sar12_drive = (floor(sar12_trial / 16) - 2*floor(sar12_trial / 32))*1.8
alter VD_B4 = $&sar12_drive
let sar12_drive = (floor(sar12_trial / 32) - 2*floor(sar12_trial / 64))*1.8
alter VD_B5 = $&sar12_drive
let sar12_drive = (floor(sar12_trial / 64) - 2*floor(sar12_trial / 128))*1.8
alter VD_B6 = $&sar12_drive
let sar12_drive = (floor(sar12_trial / 128) - 2*floor(sar12_trial / 256))*1.8
alter VD_B7 = $&sar12_drive
let sar12_drive = (floor(sar12_trial / 256) - 2*floor(sar12_trial / 512))*1.8
alter VD_B8 = $&sar12_drive
let sar12_drive = (floor(sar12_trial / 512) - 2*floor(sar12_trial / 1024))*1.8
alter VD_B9 = $&sar12_drive
let sar12_drive = (floor(sar12_trial / 1024) - 2*floor(sar12_trial / 2048))*1.8
alter VD_B10 = $&sar12_drive
let sar12_drive = (floor(sar12_trial / 2048) - 2*floor(sar12_trial / 4096))*1.8
alter VD_B11 = $&sar12_drive
stop when time ge 0.000140024999999
resume
let sar12_k = length(time)-1
if abs(time[sar12_k] - 0.000140025) > 1e-12
print time[sar12_k]
echo expected_pause_time_s 0.000140025
echo SAR12_PAUSE_FAILED
quit 1
end
print time[sar12_k] >> pause-times.txt
delete all
alter VD_EVAL = 1.8
stop when time ge 0.000140199999999
resume
let sar12_k = length(time)-1
if abs(time[sar12_k] - 0.0001402) > 1e-12
print time[sar12_k]
echo expected_pause_time_s 0.0001402
echo SAR12_PAUSE_FAILED
quit 1
end
print time[sar12_k] >> pause-times.txt
delete all
let sar12_k = length(time)-1
let sar12_cmp = v(COMP)[sar12_k]
let sar12_cmpn = v(COMPN)[sar12_k]
let sar12_p = v(TOPP)[sar12_k]
let sar12_n = v(TOPN)[sar12_k]
let sar12_decision = 0
if sar12_cmp >= 0.9
let sar12_code = sar12_trial
let sar12_decision = 1
end
echo 13 1 $&sar12_trial $&sar12_cmp $&sar12_cmpn $&sar12_p $&sar12_n 1.19970703125 $&sar12_decision >> decisions.csv
alter VD_EVAL = 0
let sar12_trial = sar12_code + 1
let sar12_drive = (floor(sar12_trial / 1) - 2*floor(sar12_trial / 2))*1.8
alter VD_B0 = $&sar12_drive
let sar12_drive = (floor(sar12_trial / 2) - 2*floor(sar12_trial / 4))*1.8
alter VD_B1 = $&sar12_drive
let sar12_drive = (floor(sar12_trial / 4) - 2*floor(sar12_trial / 8))*1.8
alter VD_B2 = $&sar12_drive
let sar12_drive = (floor(sar12_trial / 8) - 2*floor(sar12_trial / 16))*1.8
alter VD_B3 = $&sar12_drive
let sar12_drive = (floor(sar12_trial / 16) - 2*floor(sar12_trial / 32))*1.8
alter VD_B4 = $&sar12_drive
let sar12_drive = (floor(sar12_trial / 32) - 2*floor(sar12_trial / 64))*1.8
alter VD_B5 = $&sar12_drive
let sar12_drive = (floor(sar12_trial / 64) - 2*floor(sar12_trial / 128))*1.8
alter VD_B6 = $&sar12_drive
let sar12_drive = (floor(sar12_trial / 128) - 2*floor(sar12_trial / 256))*1.8
alter VD_B7 = $&sar12_drive
let sar12_drive = (floor(sar12_trial / 256) - 2*floor(sar12_trial / 512))*1.8
alter VD_B8 = $&sar12_drive
let sar12_drive = (floor(sar12_trial / 512) - 2*floor(sar12_trial / 1024))*1.8
alter VD_B9 = $&sar12_drive
let sar12_drive = (floor(sar12_trial / 1024) - 2*floor(sar12_trial / 2048))*1.8
alter VD_B10 = $&sar12_drive
let sar12_drive = (floor(sar12_trial / 2048) - 2*floor(sar12_trial / 4096))*1.8
alter VD_B11 = $&sar12_drive
stop when time ge 0.000140524999999
resume
let sar12_k = length(time)-1
if abs(time[sar12_k] - 0.000140525) > 1e-12
print time[sar12_k]
echo expected_pause_time_s 0.000140525
echo SAR12_PAUSE_FAILED
quit 1
end
print time[sar12_k] >> pause-times.txt
delete all
alter VD_EVAL = 1.8
stop when time ge 0.000140699999999
resume
let sar12_k = length(time)-1
if abs(time[sar12_k] - 0.0001407) > 1e-12
print time[sar12_k]
echo expected_pause_time_s 0.0001407
echo SAR12_PAUSE_FAILED
quit 1
end
print time[sar12_k] >> pause-times.txt
delete all
let sar12_k = length(time)-1
let sar12_cmp = v(COMP)[sar12_k]
let sar12_cmpn = v(COMPN)[sar12_k]
let sar12_p = v(TOPP)[sar12_k]
let sar12_n = v(TOPN)[sar12_k]
let sar12_decision = 0
if sar12_cmp >= 0.9
let sar12_code = sar12_trial
let sar12_decision = 1
end
echo 13 0 $&sar12_trial $&sar12_cmp $&sar12_cmpn $&sar12_p $&sar12_n 1.19970703125 $&sar12_decision >> decisions.csv
alter VD_EVAL = 0
resume
let supply_current = -i(VDD)
let reference_current = -i(VREF)
wrdata waveform.dat v(VINP) v(VINN) v(SAMPLE) v(EVAL) v(TOPP) v(TOPN) v(COMP) v(COMPN) supply_current reference_current v(B0) v(B1) v(B2) v(B3) v(B4) v(B5) v(B6) v(B7) v(B8) v(B9) v(B10) v(B11)
echo SAR12_NATIVE_COMPLETE
quit
.endc
.end

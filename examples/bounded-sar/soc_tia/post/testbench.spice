Resistor analog SoC soc_tia
.include "/workspace/.runtime/eda/runs/f4e316604f654255bc94b85bd4a5b758/supported-tt.spice"
.options method=gear maxord=2
.include "/workspace/.runtime/eda/runs/f4e316604f654255bc94b85bd4a5b758/current-probe.spice"
.temp 27.0
VGND VGND 0 0
VDD VPWR VGND 1.8
VBIAS BIAS VGND 0.9
VCM VCM VGND 0.9
VSENSOR IIN SENSOR 0
ISENSOR SENSOR VGND DC 0 AC 1 SIN(0 1u 5000)
CLOAD OUT VGND 50f
XU VGND OUT VCM IIN VPWR BIAS soc_tia
.control
save v(OUT) i(VDD) i(VSENSOR) v(IIN) i(v.xu.vregister_cf_5291e9ac1947546e) i(v.xu.vregister_cf_473651f8f0e1c1f4) i(v.xu.vregister_cf_d9daa2f16c1e955b) i(v.xu.vregister_cf_c9b3468c26e9782f) i(v.xu.vregister_cf_58464bf257bde9e9) i(v.xu.vregister_cf_a1dc34115a40bd60) i(v.xu.vregister_cf_30c9205ca4803d03) i(v.xu.vregister_cf_4f07240b9d21151b) i(v.xu.vregister_cf_be8c7635482e675b) i(VGND) i(VBIAS) i(VCM) v(XU.AMP__FIRST__TAIL.t4) v(XU.AMP__PRE.t1) v(XU.VCM.t0) v(XU.VGND.t7) v(XU.VPWR.t5) v(XU.AMP__FIRST__MIR.t1) v(XU.AMP__FIRST__MIR.t0) v(XU.VPWR.t4) v(XU.AMP__FIRST__TAIL.t1) v(XU.AMP__FIRST__MIR.t3) v(XU.VGND.t11) v(XU.VGND.t5) v(XU.AMP__FIRST__TAIL.t0) v(XU.BIAS.t0) v(XU.VGND.t4) v(XU.VPWR.t3) v(XU.AMP__PRE.t2) v(XU.AMP__FIRST__MIR.t4) v(XU.VPWR.t2) v(XU.AMP__FIRST__TAIL.t2) v(XU.AMP__FIRST__MIR.t2) v(XU.VGND.t10) v(XU.AMP__FIRST__TAIL.t3) v(XU.AMP__PRE.t0) v(XU.VCM.t1) v(XU.VGND.t3) v(XU.VPWR.t1) v(XU.AMP__PRE.t6) v(XU.VPWR.t0) v(XU.VGND.t1) v(XU.BIAS.t1) v(XU.VGND.t0) v(VGND) v(VPWR) v(BIAS) v(VCM) v(SENSOR)
set num_threads=1
set numdgt=17
set wr_singlescale
set wr_vecnames
set noaskquit
tran 2e-08 0.0002
let mos_wave_0 = v(OUT)
let mos_wave_1 = -i(VDD)
let mos_wave_2 = i(VSENSOR)
let mos_wave_3 = v(IIN)
wrdata waveform.dat mos_wave_0 mos_wave_1 mos_wave_2 mos_wave_3
write waveform.raw all
let register_flow_0 = i(v.xu.vregister_cf_5291e9ac1947546e)
let register_flow_1 = i(v.xu.vregister_cf_473651f8f0e1c1f4)
let register_flow_2 = i(v.xu.vregister_cf_d9daa2f16c1e955b)
let register_flow_3 = i(v.xu.vregister_cf_c9b3468c26e9782f)
let register_flow_4 = i(v.xu.vregister_cf_58464bf257bde9e9)
let register_flow_5 = i(v.xu.vregister_cf_a1dc34115a40bd60)
let register_flow_6 = i(v.xu.vregister_cf_30c9205ca4803d03)
let register_flow_7 = i(v.xu.vregister_cf_4f07240b9d21151b)
let register_flow_8 = i(v.xu.vregister_cf_be8c7635482e675b)
let register_flow_9 = i(VGND)
let register_flow_10 = i(VDD)
let register_flow_11 = i(VBIAS)
let register_flow_12 = i(VCM)
let register_flow_13 = i(VSENSOR)
wrdata current-flow.dat register_flow_0 register_flow_1 register_flow_2 register_flow_3 register_flow_4 register_flow_5 register_flow_6 register_flow_7 register_flow_8 register_flow_9 register_flow_10 register_flow_11 register_flow_12 register_flow_13
let register_voltage_0 = v(XU.AMP__FIRST__TAIL.t4)
let register_voltage_1 = v(XU.AMP__PRE.t1)
let register_voltage_2 = v(XU.VCM.t0)
let register_voltage_3 = v(XU.VGND.t7)
let register_voltage_4 = v(XU.VPWR.t5)
let register_voltage_5 = v(XU.AMP__FIRST__MIR.t1)
let register_voltage_6 = v(XU.AMP__FIRST__MIR.t0)
let register_voltage_7 = v(XU.VPWR.t4)
let register_voltage_8 = v(XU.AMP__FIRST__TAIL.t1)
let register_voltage_9 = v(XU.AMP__FIRST__MIR.t3)
let register_voltage_10 = v(IIN)
let register_voltage_11 = v(XU.VGND.t11)
let register_voltage_12 = v(XU.VGND.t5)
let register_voltage_13 = v(XU.AMP__FIRST__TAIL.t0)
let register_voltage_14 = v(XU.BIAS.t0)
let register_voltage_15 = v(XU.VGND.t4)
let register_voltage_16 = v(XU.VPWR.t3)
let register_voltage_17 = v(XU.AMP__PRE.t2)
let register_voltage_18 = v(XU.AMP__FIRST__MIR.t4)
let register_voltage_19 = v(XU.VPWR.t2)
let register_voltage_20 = v(XU.AMP__FIRST__TAIL.t2)
let register_voltage_21 = v(XU.AMP__FIRST__MIR.t2)
let register_voltage_22 = v(XU.VGND.t10)
let register_voltage_23 = v(XU.AMP__FIRST__TAIL.t3)
let register_voltage_24 = v(XU.AMP__PRE.t0)
let register_voltage_25 = v(XU.VCM.t1)
let register_voltage_26 = v(XU.VGND.t3)
let register_voltage_27 = v(XU.VPWR.t1)
let register_voltage_28 = v(OUT)
let register_voltage_29 = v(XU.AMP__PRE.t6)
let register_voltage_30 = v(XU.VPWR.t0)
let register_voltage_31 = v(XU.VGND.t1)
let register_voltage_32 = v(XU.BIAS.t1)
let register_voltage_33 = v(XU.VGND.t0)
let register_voltage_34 = v(VGND)
let register_voltage_35 = 0*register_flow_0
let register_voltage_36 = v(VPWR)
let register_voltage_37 = v(BIAS)
let register_voltage_38 = v(VCM)
let register_voltage_39 = v(SENSOR)
wrdata node-voltages.dat register_voltage_0 register_voltage_1 register_voltage_2 register_voltage_3 register_voltage_4 register_voltage_5 register_voltage_6 register_voltage_7 register_voltage_8 register_voltage_9 register_voltage_10 register_voltage_11 register_voltage_12 register_voltage_13 register_voltage_14 register_voltage_15 register_voltage_16 register_voltage_17 register_voltage_18 register_voltage_19 register_voltage_20 register_voltage_21 register_voltage_22 register_voltage_23 register_voltage_24 register_voltage_25 register_voltage_26 register_voltage_27 register_voltage_28 register_voltage_29 register_voltage_30 register_voltage_31 register_voltage_32 register_voltage_33 register_voltage_34 register_voltage_35 register_voltage_36 register_voltage_37 register_voltage_38 register_voltage_39
quit
.endc
.end

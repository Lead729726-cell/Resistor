.subckt sar8_unit_cap TOP BOTTOM
CC_UNIT TOP BOTTOM 4e-13
.ends sar8_unit_cap

.subckt sar8_switch A Y EN ENB VPWR VGND
XN Y EN A VGND sky130_fd_pr__nfet_01v8 w=4 l=0.15 nf=1 m=1
XP Y ENB A VPWR sky130_fd_pr__pfet_01v8_hvt w=8 l=0.15 nf=1 m=1
.ends sar8_switch

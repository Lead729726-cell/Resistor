.subckt INV A Y VPWR VGND
XMN Y A VGND VGND sky130_fd_pr__nfet_01v8 w=0.65 l=0.15 nf=1 m=1
XMP Y A VPWR VPWR sky130_fd_pr__pfet_01v8_hvt w=0.65 l=0.15 nf=1 m=1
.ends INV
.subckt SAR8_TG A Y EN ENB VPWR VGND
XN Y EN A VGND sky130_fd_pr__nfet_01v8 w=4 l=0.15 nf=1 m=1
XP Y ENB A VPWR sky130_fd_pr__pfet_01v8_hvt w=8 l=0.15 nf=1 m=1
.ends SAR8_TG
.subckt sar8_bottom_switch VIN VREF BIT SAMPLE SAMPLEB OUT VPWR VGND
XACQUIRE VIN OUT SAMPLE SAMPLEB VPWR VGND SAR8_TG
XBIT_INV BIT BITB VPWR VGND INV
XCONVERT REFSEL OUT SAMPLEB SAMPLE VPWR VGND SAR8_TG
XHIGH VREF REFSEL BIT BITB VPWR VGND SAR8_TG
XLOW VGND REFSEL BITB BIT VPWR VGND SAR8_TG
.ends sar8_bottom_switch

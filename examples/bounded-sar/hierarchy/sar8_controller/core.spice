.subckt INV A Y VPWR VGND
XMN Y A VGND VGND sky130_fd_pr__nfet_01v8 w=0.65 l=0.15 nf=1 m=1
XMP Y A VPWR VPWR sky130_fd_pr__pfet_01v8_hvt w=0.65 l=0.15 nf=1 m=1
.ends INV
.subckt NAND2 A0 A1 Y VPWR VGND
XMN0 Y A0 N1 VGND sky130_fd_pr__nfet_01v8 w=0.65 l=0.15 nf=1 m=1
XMN1 N1 A1 VGND VGND sky130_fd_pr__nfet_01v8 w=0.65 l=0.15 nf=1 m=1
XMP0 Y A0 VPWR VPWR sky130_fd_pr__pfet_01v8_hvt w=0.65 l=0.15 nf=1 m=1
XMP1 Y A1 VPWR VPWR sky130_fd_pr__pfet_01v8_hvt w=0.65 l=0.15 nf=1 m=1
.ends NAND2
.subckt AND2 A B Y VPWR VGND
XI1 N Y VPWR VGND INV
XN1 A B N VPWR VGND NAND2
.ends AND2
.subckt NOR2 A B Y VPWR VGND
XN0 Y A VGND VGND sky130_fd_pr__nfet_01v8 w=0.65 l=0.15 nf=1 m=1
XN1 Y B VGND VGND sky130_fd_pr__nfet_01v8 w=0.65 l=0.15 nf=1 m=1
XP0 P A VPWR VPWR sky130_fd_pr__pfet_01v8_hvt w=0.65 l=0.15 nf=1 m=1
XP1 Y B P VPWR sky130_fd_pr__pfet_01v8_hvt w=0.65 l=0.15 nf=1 m=1
.ends NOR2
.subckt OR2 A B Y VPWR VGND
XINV N Y VPWR VGND INV
XNOR A B N VPWR VGND NOR2
.ends OR2
.subckt DFF D CLK Q VPWR VGND
XICLK CLK CLKB VPWR VGND INV
XM1 M MB VPWR VGND INV
XM2 MB MF VPWR VGND INV
XMNIN M CLKB D VGND sky130_fd_pr__nfet_01v8 w=0.65 l=0.15 nf=1 m=1
XMNMF M CLK MF VGND sky130_fd_pr__nfet_01v8 w=0.65 l=0.15 nf=1 m=1
XMNOUT T CLK MF VGND sky130_fd_pr__nfet_01v8 w=0.65 l=0.15 nf=1 m=1
XMNSF T CLKB Q VGND sky130_fd_pr__nfet_01v8 w=0.65 l=0.15 nf=1 m=1
XMPIN M CLK D VPWR sky130_fd_pr__pfet_01v8_hvt w=0.65 l=0.15 nf=1 m=1
XMPMF M CLKB MF VPWR sky130_fd_pr__pfet_01v8_hvt w=0.65 l=0.15 nf=1 m=1
XMPOUT T CLKB MF VPWR sky130_fd_pr__pfet_01v8_hvt w=0.65 l=0.15 nf=1 m=1
XMPSF T CLK Q VPWR sky130_fd_pr__pfet_01v8_hvt w=0.65 l=0.15 nf=1 m=1
XS1 T TB VPWR VGND INV
XS2 TB Q VPWR VGND INV
.ends DFF
.subckt sar8_controller CLK RESET START COMPARATOR SAMPLE BUSY VALID TRIAL0 TRIAL1 TRIAL2 TRIAL3 TRIAL4 TRIAL5 TRIAL6 TRIAL7 CODE0 CODE1 CODE2 CODE3 CODE4 CODE5 CODE6 CODE7 VPWR VGND
XG0 N25 N26 VPWR VGND INV
XG1 N27 N28 VPWR VGND INV
XG10 N25 N38 N39 VPWR VGND OR2
XG100 N33 N128 N129 VPWR VGND AND2
XG101 TRIAL4 N107 N130 VPWR VGND AND2
XG102 N83 N87 N131 VPWR VGND OR2
XG103 N36 N131 N132 VPWR VGND AND2
XG104 N130 N132 N133 VPWR VGND OR2
XG105 N33 N133 N134 VPWR VGND AND2
XG106 TRIAL5 N107 N135 VPWR VGND AND2
XG107 N90 N94 N136 VPWR VGND OR2
XG108 N36 N136 N137 VPWR VGND AND2
XG109 N135 N137 N138 VPWR VGND OR2
XG11 N30 N36 N40 VPWR VGND AND2
XG110 N33 N138 N139 VPWR VGND AND2
XG111 TRIAL6 N107 N140 VPWR VGND AND2
XG112 N97 N101 N141 VPWR VGND OR2
XG113 N36 N141 N142 VPWR VGND AND2
XG114 N140 N142 N143 VPWR VGND OR2
XG115 N33 N143 N144 VPWR VGND AND2
XG116 BUSY N104 N145 VPWR VGND AND2
XG117 TRIAL7 N107 N146 VPWR VGND AND2
XG118 N31 BUSY N147 VPWR VGND AND2
XG119 N146 N147 N148 VPWR VGND OR2
XG12 N29 N37 N41 VPWR VGND OR2
XG120 N145 N148 N149 VPWR VGND OR2
XG121 N33 N149 N150 VPWR VGND AND2
XG122 N46 N108 N151 VPWR VGND AND2
XG123 N34 START N152 VPWR VGND AND2
XG124 SAMPLE N152 N153 VPWR VGND OR2
XG125 RESET N147 N154 VPWR VGND OR2
XG126 N154 N155 VPWR VGND INV
XG127 N153 N155 N156 VPWR VGND AND2
XG128 N31 START N157 VPWR VGND OR2
XG129 N33 N157 N158 VPWR VGND AND2
XG13 N37 N38 N42 VPWR VGND OR2
XG130 N34 N158 N159 VPWR VGND AND2
XG131 N39 N40 N160 VPWR VGND AND2
XG132 RESET N152 N161 VPWR VGND OR2
XG133 N29 N37 N162 VPWR VGND AND2
XG134 N161 N162 N163 VPWR VGND OR2
XG135 N160 N163 N164 VPWR VGND OR2
XG136 N27 N41 N165 VPWR VGND AND2
XG137 N126 N161 N166 VPWR VGND OR2
XG138 N165 N166 N167 VPWR VGND OR2
XG139 N25 N42 N168 VPWR VGND AND2
XG14 N42 N43 VPWR VGND INV
XG140 N161 N168 N169 VPWR VGND OR2
XG141 N52 CLK CODE0 VPWR VGND DFF
XG142 N61 CLK CODE1 VPWR VGND DFF
XG143 N70 CLK CODE2 VPWR VGND DFF
XG144 N79 CLK CODE3 VPWR VGND DFF
XG145 N85 CLK CODE4 VPWR VGND DFF
XG146 N92 CLK CODE5 VPWR VGND DFF
XG147 N99 CLK CODE6 VPWR VGND DFF
XG148 N106 CLK CODE7 VPWR VGND DFF
XG149 N113 CLK TRIAL0 VPWR VGND DFF
XG15 N26 N43 N44 VPWR VGND AND2
XG150 N118 CLK TRIAL1 VPWR VGND DFF
XG151 N123 CLK TRIAL2 VPWR VGND DFF
XG152 N129 CLK TRIAL3 VPWR VGND DFF
XG153 N134 CLK TRIAL4 VPWR VGND DFF
XG154 N139 CLK TRIAL5 VPWR VGND DFF
XG155 N144 CLK TRIAL6 VPWR VGND DFF
XG156 N150 CLK TRIAL7 VPWR VGND DFF
XG157 N50 CLK VALID VPWR VGND DFF
XG158 N151 CLK BUSY VPWR VGND DFF
XG159 N156 CLK SAMPLE VPWR VGND DFF
XG16 N37 N39 N45 VPWR VGND OR2
XG160 N159 CLK N31 VPWR VGND DFF
XG161 N164 CLK N29 VPWR VGND DFF
XG162 N167 CLK N27 VPWR VGND DFF
XG163 N169 CLK N25 VPWR VGND DFF
XG17 N33 N45 N46 VPWR VGND AND2
XG18 CODE0 N46 N47 VPWR VGND AND2
XG19 COMPARATOR N39 N48 VPWR VGND OR2
XG2 N29 N30 VPWR VGND INV
XG20 TRIAL0 N48 N49 VPWR VGND AND2
XG21 N33 N44 N50 VPWR VGND AND2
XG22 N49 N50 N51 VPWR VGND AND2
XG23 N47 N51 N52 VPWR VGND OR2
XG24 CODE1 N46 N53 VPWR VGND AND2
XG25 N28 N29 N54 VPWR VGND AND2
XG26 N27 N30 N55 VPWR VGND OR2
XG27 N26 N54 N56 VPWR VGND AND2
XG28 N25 N55 N57 VPWR VGND OR2
XG29 COMPARATOR N57 N58 VPWR VGND OR2
XG3 N31 N32 VPWR VGND INV
XG30 TRIAL1 N58 N59 VPWR VGND AND2
XG31 N50 N59 N60 VPWR VGND AND2
XG32 N53 N60 N61 VPWR VGND OR2
XG33 CODE2 N46 N62 VPWR VGND AND2
XG34 N27 N30 N63 VPWR VGND AND2
XG35 N28 N29 N64 VPWR VGND OR2
XG36 N26 N63 N65 VPWR VGND AND2
XG37 N25 N64 N66 VPWR VGND OR2
XG38 COMPARATOR N66 N67 VPWR VGND OR2
XG39 TRIAL2 N67 N68 VPWR VGND AND2
XG4 RESET N33 VPWR VGND INV
XG40 N50 N68 N69 VPWR VGND AND2
XG41 N62 N69 N70 VPWR VGND OR2
XG42 CODE3 N46 N71 VPWR VGND AND2
XG43 N27 N29 N72 VPWR VGND AND2
XG44 N72 N73 VPWR VGND INV
XG45 N26 N72 N74 VPWR VGND AND2
XG46 N25 N73 N75 VPWR VGND OR2
XG47 COMPARATOR N75 N76 VPWR VGND OR2
XG48 TRIAL3 N76 N77 VPWR VGND AND2
XG49 N50 N77 N78 VPWR VGND AND2
XG5 BUSY N34 VPWR VGND INV
XG50 N71 N78 N79 VPWR VGND OR2
XG51 CODE4 N46 N80 VPWR VGND AND2
XG52 N26 N38 N81 VPWR VGND OR2
XG53 COMPARATOR N81 N82 VPWR VGND OR2
XG54 TRIAL4 N82 N83 VPWR VGND AND2
XG55 N50 N83 N84 VPWR VGND AND2
XG56 N80 N84 N85 VPWR VGND OR2
XG57 CODE5 N46 N86 VPWR VGND AND2
XG58 N25 N54 N87 VPWR VGND AND2
XG59 N26 N55 N88 VPWR VGND OR2
XG6 START N35 VPWR VGND INV
XG60 COMPARATOR N88 N89 VPWR VGND OR2
XG61 TRIAL5 N89 N90 VPWR VGND AND2
XG62 N50 N90 N91 VPWR VGND AND2
XG63 N86 N91 N92 VPWR VGND OR2
XG64 CODE6 N46 N93 VPWR VGND AND2
XG65 N25 N63 N94 VPWR VGND AND2
XG66 N26 N64 N95 VPWR VGND OR2
XG67 COMPARATOR N95 N96 VPWR VGND OR2
XG68 TRIAL6 N96 N97 VPWR VGND AND2
XG69 N50 N97 N98 VPWR VGND AND2
XG7 N32 BUSY N36 VPWR VGND AND2
XG70 N93 N98 N99 VPWR VGND OR2
XG71 CODE7 N46 N100 VPWR VGND AND2
XG72 N25 N72 N101 VPWR VGND AND2
XG73 N101 N102 VPWR VGND INV
XG74 COMPARATOR N102 N103 VPWR VGND OR2
XG75 TRIAL7 N103 N104 VPWR VGND AND2
XG76 N50 N104 N105 VPWR VGND AND2
XG77 N100 N105 N106 VPWR VGND OR2
XG78 N34 N35 N107 VPWR VGND AND2
XG79 N107 N108 VPWR VGND INV
XG8 N31 N34 N37 VPWR VGND OR2
XG80 TRIAL0 N107 N109 VPWR VGND AND2
XG81 N49 N56 N110 VPWR VGND OR2
XG82 N36 N110 N111 VPWR VGND AND2
XG83 N109 N111 N112 VPWR VGND OR2
XG84 N33 N112 N113 VPWR VGND AND2
XG85 TRIAL1 N107 N114 VPWR VGND AND2
XG86 N59 N65 N115 VPWR VGND OR2
XG87 N36 N115 N116 VPWR VGND AND2
XG88 N114 N116 N117 VPWR VGND OR2
XG89 N33 N117 N118 VPWR VGND AND2
XG9 N27 N29 N38 VPWR VGND OR2
XG90 TRIAL2 N107 N119 VPWR VGND AND2
XG91 N68 N74 N120 VPWR VGND OR2
XG92 N36 N120 N121 VPWR VGND AND2
XG93 N119 N121 N122 VPWR VGND OR2
XG94 N33 N122 N123 VPWR VGND AND2
XG95 N36 N77 N124 VPWR VGND AND2
XG96 TRIAL3 N107 N125 VPWR VGND AND2
XG97 N25 N43 N126 VPWR VGND AND2
XG98 N125 N126 N127 VPWR VGND OR2
XG99 N124 N127 N128 VPWR VGND OR2
.ends sar8_controller

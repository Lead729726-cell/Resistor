.subckt INV A Y VPWR VGND
XMN Y A VGND VGND sky130_fd_pr__nfet_01v8 w=0.65 l=0.15 nf=1 m=1
XMP Y A VPWR VPWR sky130_fd_pr__pfet_01v8_hvt w=0.65 l=0.15 nf=1 m=1
.ends INV
.subckt SAR8_TG A Y EN ENB VPWR VGND
XN Y EN A VGND sky130_fd_pr__nfet_01v8 w=4 l=0.15 nf=1 m=1
XP Y ENB A VPWR sky130_fd_pr__pfet_01v8_hvt w=8 l=0.15 nf=1 m=1
.ends SAR8_TG
.subckt SAR8_BOTTOM VIN VREF BIT SAMPLE SAMPLEB OUT VPWR VGND
XACQUIRE VIN OUT SAMPLE SAMPLEB VPWR VGND SAR8_TG
XBIT_INV BIT BITB VPWR VGND INV
XCONVERT REFSEL OUT SAMPLEB SAMPLE VPWR VGND SAR8_TG
XHIGH VREF REFSEL BIT BITB VPWR VGND SAR8_TG
XLOW VGND REFSEL BITB BIT VPWR VGND SAR8_TG
.ends SAR8_BOTTOM
.subckt SAR8_UNIT TOP BOTTOM
CC_UNIT TOP BOTTOM 4e-13
.ends SAR8_UNIT
.subckt sar8_cdac VIN VREF VCM SAMPLE TOP B0 B1 B2 B3 B4 B5 B6 B7 VPWR VGND
XBIT0 VIN VREF B0 SAMPLE SAMPLEB BOTTOM0 VPWR VGND SAR8_BOTTOM
XBIT1 VIN VREF B1 SAMPLE SAMPLEB BOTTOM1 VPWR VGND SAR8_BOTTOM
XBIT2 VIN VREF B2 SAMPLE SAMPLEB BOTTOM2 VPWR VGND SAR8_BOTTOM
XBIT3 VIN VREF B3 SAMPLE SAMPLEB BOTTOM3 VPWR VGND SAR8_BOTTOM
XBIT4 VIN VREF B4 SAMPLE SAMPLEB BOTTOM4 VPWR VGND SAR8_BOTTOM
XBIT5 VIN VREF B5 SAMPLE SAMPLEB BOTTOM5 VPWR VGND SAR8_BOTTOM
XBIT6 VIN VREF B6 SAMPLE SAMPLEB BOTTOM6 VPWR VGND SAR8_BOTTOM
XBIT7 VIN VREF B7 SAMPLE SAMPLEB BOTTOM7 VPWR VGND SAR8_BOTTOM
XC0_0 TOP BOTTOM0 SAR8_UNIT
XC1_0 TOP BOTTOM1 SAR8_UNIT
XC1_1 TOP BOTTOM1 SAR8_UNIT
XC2_0 TOP BOTTOM2 SAR8_UNIT
XC2_1 TOP BOTTOM2 SAR8_UNIT
XC2_2 TOP BOTTOM2 SAR8_UNIT
XC2_3 TOP BOTTOM2 SAR8_UNIT
XC3_0 TOP BOTTOM3 SAR8_UNIT
XC3_1 TOP BOTTOM3 SAR8_UNIT
XC3_2 TOP BOTTOM3 SAR8_UNIT
XC3_3 TOP BOTTOM3 SAR8_UNIT
XC3_4 TOP BOTTOM3 SAR8_UNIT
XC3_5 TOP BOTTOM3 SAR8_UNIT
XC3_6 TOP BOTTOM3 SAR8_UNIT
XC3_7 TOP BOTTOM3 SAR8_UNIT
XC4_0 TOP BOTTOM4 SAR8_UNIT
XC4_1 TOP BOTTOM4 SAR8_UNIT
XC4_10 TOP BOTTOM4 SAR8_UNIT
XC4_11 TOP BOTTOM4 SAR8_UNIT
XC4_12 TOP BOTTOM4 SAR8_UNIT
XC4_13 TOP BOTTOM4 SAR8_UNIT
XC4_14 TOP BOTTOM4 SAR8_UNIT
XC4_15 TOP BOTTOM4 SAR8_UNIT
XC4_2 TOP BOTTOM4 SAR8_UNIT
XC4_3 TOP BOTTOM4 SAR8_UNIT
XC4_4 TOP BOTTOM4 SAR8_UNIT
XC4_5 TOP BOTTOM4 SAR8_UNIT
XC4_6 TOP BOTTOM4 SAR8_UNIT
XC4_7 TOP BOTTOM4 SAR8_UNIT
XC4_8 TOP BOTTOM4 SAR8_UNIT
XC4_9 TOP BOTTOM4 SAR8_UNIT
XC5_0 TOP BOTTOM5 SAR8_UNIT
XC5_1 TOP BOTTOM5 SAR8_UNIT
XC5_10 TOP BOTTOM5 SAR8_UNIT
XC5_11 TOP BOTTOM5 SAR8_UNIT
XC5_12 TOP BOTTOM5 SAR8_UNIT
XC5_13 TOP BOTTOM5 SAR8_UNIT
XC5_14 TOP BOTTOM5 SAR8_UNIT
XC5_15 TOP BOTTOM5 SAR8_UNIT
XC5_16 TOP BOTTOM5 SAR8_UNIT
XC5_17 TOP BOTTOM5 SAR8_UNIT
XC5_18 TOP BOTTOM5 SAR8_UNIT
XC5_19 TOP BOTTOM5 SAR8_UNIT
XC5_2 TOP BOTTOM5 SAR8_UNIT
XC5_20 TOP BOTTOM5 SAR8_UNIT
XC5_21 TOP BOTTOM5 SAR8_UNIT
XC5_22 TOP BOTTOM5 SAR8_UNIT
XC5_23 TOP BOTTOM5 SAR8_UNIT
XC5_24 TOP BOTTOM5 SAR8_UNIT
XC5_25 TOP BOTTOM5 SAR8_UNIT
XC5_26 TOP BOTTOM5 SAR8_UNIT
XC5_27 TOP BOTTOM5 SAR8_UNIT
XC5_28 TOP BOTTOM5 SAR8_UNIT
XC5_29 TOP BOTTOM5 SAR8_UNIT
XC5_3 TOP BOTTOM5 SAR8_UNIT
XC5_30 TOP BOTTOM5 SAR8_UNIT
XC5_31 TOP BOTTOM5 SAR8_UNIT
XC5_4 TOP BOTTOM5 SAR8_UNIT
XC5_5 TOP BOTTOM5 SAR8_UNIT
XC5_6 TOP BOTTOM5 SAR8_UNIT
XC5_7 TOP BOTTOM5 SAR8_UNIT
XC5_8 TOP BOTTOM5 SAR8_UNIT
XC5_9 TOP BOTTOM5 SAR8_UNIT
XC6_0 TOP BOTTOM6 SAR8_UNIT
XC6_1 TOP BOTTOM6 SAR8_UNIT
XC6_10 TOP BOTTOM6 SAR8_UNIT
XC6_11 TOP BOTTOM6 SAR8_UNIT
XC6_12 TOP BOTTOM6 SAR8_UNIT
XC6_13 TOP BOTTOM6 SAR8_UNIT
XC6_14 TOP BOTTOM6 SAR8_UNIT
XC6_15 TOP BOTTOM6 SAR8_UNIT
XC6_16 TOP BOTTOM6 SAR8_UNIT
XC6_17 TOP BOTTOM6 SAR8_UNIT
XC6_18 TOP BOTTOM6 SAR8_UNIT
XC6_19 TOP BOTTOM6 SAR8_UNIT
XC6_2 TOP BOTTOM6 SAR8_UNIT
XC6_20 TOP BOTTOM6 SAR8_UNIT
XC6_21 TOP BOTTOM6 SAR8_UNIT
XC6_22 TOP BOTTOM6 SAR8_UNIT
XC6_23 TOP BOTTOM6 SAR8_UNIT
XC6_24 TOP BOTTOM6 SAR8_UNIT
XC6_25 TOP BOTTOM6 SAR8_UNIT
XC6_26 TOP BOTTOM6 SAR8_UNIT
XC6_27 TOP BOTTOM6 SAR8_UNIT
XC6_28 TOP BOTTOM6 SAR8_UNIT
XC6_29 TOP BOTTOM6 SAR8_UNIT
XC6_3 TOP BOTTOM6 SAR8_UNIT
XC6_30 TOP BOTTOM6 SAR8_UNIT
XC6_31 TOP BOTTOM6 SAR8_UNIT
XC6_32 TOP BOTTOM6 SAR8_UNIT
XC6_33 TOP BOTTOM6 SAR8_UNIT
XC6_34 TOP BOTTOM6 SAR8_UNIT
XC6_35 TOP BOTTOM6 SAR8_UNIT
XC6_36 TOP BOTTOM6 SAR8_UNIT
XC6_37 TOP BOTTOM6 SAR8_UNIT
XC6_38 TOP BOTTOM6 SAR8_UNIT
XC6_39 TOP BOTTOM6 SAR8_UNIT
XC6_4 TOP BOTTOM6 SAR8_UNIT
XC6_40 TOP BOTTOM6 SAR8_UNIT
XC6_41 TOP BOTTOM6 SAR8_UNIT
XC6_42 TOP BOTTOM6 SAR8_UNIT
XC6_43 TOP BOTTOM6 SAR8_UNIT
XC6_44 TOP BOTTOM6 SAR8_UNIT
XC6_45 TOP BOTTOM6 SAR8_UNIT
XC6_46 TOP BOTTOM6 SAR8_UNIT
XC6_47 TOP BOTTOM6 SAR8_UNIT
XC6_48 TOP BOTTOM6 SAR8_UNIT
XC6_49 TOP BOTTOM6 SAR8_UNIT
XC6_5 TOP BOTTOM6 SAR8_UNIT
XC6_50 TOP BOTTOM6 SAR8_UNIT
XC6_51 TOP BOTTOM6 SAR8_UNIT
XC6_52 TOP BOTTOM6 SAR8_UNIT
XC6_53 TOP BOTTOM6 SAR8_UNIT
XC6_54 TOP BOTTOM6 SAR8_UNIT
XC6_55 TOP BOTTOM6 SAR8_UNIT
XC6_56 TOP BOTTOM6 SAR8_UNIT
XC6_57 TOP BOTTOM6 SAR8_UNIT
XC6_58 TOP BOTTOM6 SAR8_UNIT
XC6_59 TOP BOTTOM6 SAR8_UNIT
XC6_6 TOP BOTTOM6 SAR8_UNIT
XC6_60 TOP BOTTOM6 SAR8_UNIT
XC6_61 TOP BOTTOM6 SAR8_UNIT
XC6_62 TOP BOTTOM6 SAR8_UNIT
XC6_63 TOP BOTTOM6 SAR8_UNIT
XC6_7 TOP BOTTOM6 SAR8_UNIT
XC6_8 TOP BOTTOM6 SAR8_UNIT
XC6_9 TOP BOTTOM6 SAR8_UNIT
XC7_0 TOP BOTTOM7 SAR8_UNIT
XC7_1 TOP BOTTOM7 SAR8_UNIT
XC7_10 TOP BOTTOM7 SAR8_UNIT
XC7_100 TOP BOTTOM7 SAR8_UNIT
XC7_101 TOP BOTTOM7 SAR8_UNIT
XC7_102 TOP BOTTOM7 SAR8_UNIT
XC7_103 TOP BOTTOM7 SAR8_UNIT
XC7_104 TOP BOTTOM7 SAR8_UNIT
XC7_105 TOP BOTTOM7 SAR8_UNIT
XC7_106 TOP BOTTOM7 SAR8_UNIT
XC7_107 TOP BOTTOM7 SAR8_UNIT
XC7_108 TOP BOTTOM7 SAR8_UNIT
XC7_109 TOP BOTTOM7 SAR8_UNIT
XC7_11 TOP BOTTOM7 SAR8_UNIT
XC7_110 TOP BOTTOM7 SAR8_UNIT
XC7_111 TOP BOTTOM7 SAR8_UNIT
XC7_112 TOP BOTTOM7 SAR8_UNIT
XC7_113 TOP BOTTOM7 SAR8_UNIT
XC7_114 TOP BOTTOM7 SAR8_UNIT
XC7_115 TOP BOTTOM7 SAR8_UNIT
XC7_116 TOP BOTTOM7 SAR8_UNIT
XC7_117 TOP BOTTOM7 SAR8_UNIT
XC7_118 TOP BOTTOM7 SAR8_UNIT
XC7_119 TOP BOTTOM7 SAR8_UNIT
XC7_12 TOP BOTTOM7 SAR8_UNIT
XC7_120 TOP BOTTOM7 SAR8_UNIT
XC7_121 TOP BOTTOM7 SAR8_UNIT
XC7_122 TOP BOTTOM7 SAR8_UNIT
XC7_123 TOP BOTTOM7 SAR8_UNIT
XC7_124 TOP BOTTOM7 SAR8_UNIT
XC7_125 TOP BOTTOM7 SAR8_UNIT
XC7_126 TOP BOTTOM7 SAR8_UNIT
XC7_127 TOP BOTTOM7 SAR8_UNIT
XC7_13 TOP BOTTOM7 SAR8_UNIT
XC7_14 TOP BOTTOM7 SAR8_UNIT
XC7_15 TOP BOTTOM7 SAR8_UNIT
XC7_16 TOP BOTTOM7 SAR8_UNIT
XC7_17 TOP BOTTOM7 SAR8_UNIT
XC7_18 TOP BOTTOM7 SAR8_UNIT
XC7_19 TOP BOTTOM7 SAR8_UNIT
XC7_2 TOP BOTTOM7 SAR8_UNIT
XC7_20 TOP BOTTOM7 SAR8_UNIT
XC7_21 TOP BOTTOM7 SAR8_UNIT
XC7_22 TOP BOTTOM7 SAR8_UNIT
XC7_23 TOP BOTTOM7 SAR8_UNIT
XC7_24 TOP BOTTOM7 SAR8_UNIT
XC7_25 TOP BOTTOM7 SAR8_UNIT
XC7_26 TOP BOTTOM7 SAR8_UNIT
XC7_27 TOP BOTTOM7 SAR8_UNIT
XC7_28 TOP BOTTOM7 SAR8_UNIT
XC7_29 TOP BOTTOM7 SAR8_UNIT
XC7_3 TOP BOTTOM7 SAR8_UNIT
XC7_30 TOP BOTTOM7 SAR8_UNIT
XC7_31 TOP BOTTOM7 SAR8_UNIT
XC7_32 TOP BOTTOM7 SAR8_UNIT
XC7_33 TOP BOTTOM7 SAR8_UNIT
XC7_34 TOP BOTTOM7 SAR8_UNIT
XC7_35 TOP BOTTOM7 SAR8_UNIT
XC7_36 TOP BOTTOM7 SAR8_UNIT
XC7_37 TOP BOTTOM7 SAR8_UNIT
XC7_38 TOP BOTTOM7 SAR8_UNIT
XC7_39 TOP BOTTOM7 SAR8_UNIT
XC7_4 TOP BOTTOM7 SAR8_UNIT
XC7_40 TOP BOTTOM7 SAR8_UNIT
XC7_41 TOP BOTTOM7 SAR8_UNIT
XC7_42 TOP BOTTOM7 SAR8_UNIT
XC7_43 TOP BOTTOM7 SAR8_UNIT
XC7_44 TOP BOTTOM7 SAR8_UNIT
XC7_45 TOP BOTTOM7 SAR8_UNIT
XC7_46 TOP BOTTOM7 SAR8_UNIT
XC7_47 TOP BOTTOM7 SAR8_UNIT
XC7_48 TOP BOTTOM7 SAR8_UNIT
XC7_49 TOP BOTTOM7 SAR8_UNIT
XC7_5 TOP BOTTOM7 SAR8_UNIT
XC7_50 TOP BOTTOM7 SAR8_UNIT
XC7_51 TOP BOTTOM7 SAR8_UNIT
XC7_52 TOP BOTTOM7 SAR8_UNIT
XC7_53 TOP BOTTOM7 SAR8_UNIT
XC7_54 TOP BOTTOM7 SAR8_UNIT
XC7_55 TOP BOTTOM7 SAR8_UNIT
XC7_56 TOP BOTTOM7 SAR8_UNIT
XC7_57 TOP BOTTOM7 SAR8_UNIT
XC7_58 TOP BOTTOM7 SAR8_UNIT
XC7_59 TOP BOTTOM7 SAR8_UNIT
XC7_6 TOP BOTTOM7 SAR8_UNIT
XC7_60 TOP BOTTOM7 SAR8_UNIT
XC7_61 TOP BOTTOM7 SAR8_UNIT
XC7_62 TOP BOTTOM7 SAR8_UNIT
XC7_63 TOP BOTTOM7 SAR8_UNIT
XC7_64 TOP BOTTOM7 SAR8_UNIT
XC7_65 TOP BOTTOM7 SAR8_UNIT
XC7_66 TOP BOTTOM7 SAR8_UNIT
XC7_67 TOP BOTTOM7 SAR8_UNIT
XC7_68 TOP BOTTOM7 SAR8_UNIT
XC7_69 TOP BOTTOM7 SAR8_UNIT
XC7_7 TOP BOTTOM7 SAR8_UNIT
XC7_70 TOP BOTTOM7 SAR8_UNIT
XC7_71 TOP BOTTOM7 SAR8_UNIT
XC7_72 TOP BOTTOM7 SAR8_UNIT
XC7_73 TOP BOTTOM7 SAR8_UNIT
XC7_74 TOP BOTTOM7 SAR8_UNIT
XC7_75 TOP BOTTOM7 SAR8_UNIT
XC7_76 TOP BOTTOM7 SAR8_UNIT
XC7_77 TOP BOTTOM7 SAR8_UNIT
XC7_78 TOP BOTTOM7 SAR8_UNIT
XC7_79 TOP BOTTOM7 SAR8_UNIT
XC7_8 TOP BOTTOM7 SAR8_UNIT
XC7_80 TOP BOTTOM7 SAR8_UNIT
XC7_81 TOP BOTTOM7 SAR8_UNIT
XC7_82 TOP BOTTOM7 SAR8_UNIT
XC7_83 TOP BOTTOM7 SAR8_UNIT
XC7_84 TOP BOTTOM7 SAR8_UNIT
XC7_85 TOP BOTTOM7 SAR8_UNIT
XC7_86 TOP BOTTOM7 SAR8_UNIT
XC7_87 TOP BOTTOM7 SAR8_UNIT
XC7_88 TOP BOTTOM7 SAR8_UNIT
XC7_89 TOP BOTTOM7 SAR8_UNIT
XC7_9 TOP BOTTOM7 SAR8_UNIT
XC7_90 TOP BOTTOM7 SAR8_UNIT
XC7_91 TOP BOTTOM7 SAR8_UNIT
XC7_92 TOP BOTTOM7 SAR8_UNIT
XC7_93 TOP BOTTOM7 SAR8_UNIT
XC7_94 TOP BOTTOM7 SAR8_UNIT
XC7_95 TOP BOTTOM7 SAR8_UNIT
XC7_96 TOP BOTTOM7 SAR8_UNIT
XC7_97 TOP BOTTOM7 SAR8_UNIT
XC7_98 TOP BOTTOM7 SAR8_UNIT
XC7_99 TOP BOTTOM7 SAR8_UNIT
XDUMMY_CAP TOP DUMMY SAR8_UNIT
XDUMMY_SWITCH VIN VREF VGND SAMPLE SAMPLEB DUMMY VPWR VGND SAR8_BOTTOM
XSAMPLE_INV SAMPLE SAMPLEB VPWR VGND INV
XTOP_RESET VCM TOP SAMPLE SAMPLEB VPWR VGND SAR8_TG
.ends sar8_cdac

* NGSPICE file created from soc_cascode_mirror.ext - technology: sky130A

.subckt soc_cascode_mirror VGND REF OUT
X0 LOW_REF.t0 REF.t0 REF.t1 VGND.t1 sky130_fd_pr__nfet_01v8 ad=0.58 pd=4.58 as=0.58 ps=4.58 w=2 l=1
X1 VGND.t5 LOW_REF.t1 LOW_REF.t2 VGND.t4 sky130_fd_pr__nfet_01v8 ad=0.58 pd=4.58 as=0.58 ps=4.58 w=2 l=1
X2 LOW_OUT.t0 REF.t2 OUT.t0 VGND.t0 sky130_fd_pr__nfet_01v8 ad=0.58 pd=4.58 as=0.58 ps=4.58 w=2 l=1
X3 VGND.t3 LOW_REF.t3 LOW_OUT.t1 VGND.t2 sky130_fd_pr__nfet_01v8 ad=0.58 pd=4.58 as=0.58 ps=4.58 w=2 l=1
C0 REF LOW_OUT 3.31726f
C1 OUT LOW_REF 2.18319f
C2 REF LOW_REF 0.87718f
C3 LOW_REF LOW_OUT 0.30677f
C4 REF OUT 0.26203f
C5 OUT LOW_OUT 2.81654f
R0 REF.t1 REF.n1 181.41
R1 REF.n2 REF.t1 174.912
R2 REF REF.t0 139.911
R3 REF REF.t2 139.911
R4 REF.n0 REF 28.8433
R5 REF.n0 REF 27.6135
R6 REF.n2 REF 19.837
R7 REF.n3 REF.n2 14.1895
R8 REF.n4 REF.n3 11.1726
R9 REF REF.n4 5.01438
R10 REF REF.n1 4.259
R11 REF.n3 REF.n1 3.04672
R12 REF.n4 REF.n0 0.270358
R13 LOW_REF.n2 LOW_REF.t2 181.41
R14 LOW_REF.n7 LOW_REF.t0 181.41
R15 LOW_REF.t2 LOW_REF.n1 174.912
R16 LOW_REF.t0 LOW_REF.n0 174.912
R17 LOW_REF LOW_REF.t1 139.911
R18 LOW_REF LOW_REF.t3 139.911
R19 LOW_REF.n5 LOW_REF 27.0603
R20 LOW_REF.n4 LOW_REF 26.3635
R21 LOW_REF LOW_REF.n1 19.837
R22 LOW_REF LOW_REF.n0 19.837
R23 LOW_REF.n3 LOW_REF.n1 14.1895
R24 LOW_REF.n6 LOW_REF.n0 14.1895
R25 LOW_REF.n4 LOW_REF.n3 10.1924
R26 LOW_REF.n6 LOW_REF.n5 9.92259
R27 LOW_REF.n2 LOW_REF 4.259
R28 LOW_REF LOW_REF.n7 4.259
R29 LOW_REF.n3 LOW_REF.n2 3.04672
R30 LOW_REF.n7 LOW_REF.n6 3.04672
R31 LOW_REF.n5 LOW_REF.n4 0.533558
R32 VGND.n108 VGND.n107 1680.62
R33 VGND.n175 VGND.n159 1680.62
R34 VGND.n212 VGND.n211 1680.62
R35 VGND.n234 VGND.n13 1210.97
R36 VGND.n260 VGND.n238 1210.97
R37 VGND.n232 VGND.n213 1210.97
R38 VGND.n242 VGND.n239 1210.97
R39 VGND.n143 VGND.n26 1210.97
R40 VGND.n209 VGND.n20 1210.97
R41 VGND.n157 VGND.n28 1210.97
R42 VGND.n195 VGND.n17 1210.97
R43 VGND.n130 VGND.n43 1210.97
R44 VGND.n177 VGND.n134 1210.97
R45 VGND.n128 VGND.n109 1210.97
R46 VGND.n138 VGND.n135 1210.97
R47 VGND.n64 VGND.n56 1210.97
R48 VGND.n105 VGND.n50 1210.97
R49 VGND.n91 VGND.n47 1210.97
R50 VGND.n78 VGND.n58 1210.97
R51 VGND.n134 VGND.n133 585
R52 VGND.n173 VGND.n172 585
R53 VGND.n171 VGND.n160 585
R54 VGND.n175 VGND.n160 585
R55 VGND.n170 VGND.n169 585
R56 VGND.n168 VGND.n167 585
R57 VGND.n166 VGND.n165 585
R58 VGND.n164 VGND.n163 585
R59 VGND.n162 VGND.n138 585
R60 VGND.n175 VGND.n138 585
R61 VGND.n161 VGND.n135 585
R62 VGND.n176 VGND.n135 585
R63 VGND.n37 VGND.n35 585
R64 VGND.n39 VGND.n37 585
R65 VGND VGND.n182 585
R66 VGND.n182 VGND.t2 585
R67 VGND.n36 VGND.n34 585
R68 VGND.n38 VGND.n36 585
R69 VGND.n128 VGND.n127 585
R70 VGND.n129 VGND.n128 585
R71 VGND.n126 VGND.n109 585
R72 VGND.n125 VGND.n124 585
R73 VGND.n122 VGND.n110 585
R74 VGND.n120 VGND.n119 585
R75 VGND.n118 VGND.n111 585
R76 VGND.n117 VGND.n116 585
R77 VGND.n114 VGND.n112 585
R78 VGND.n43 VGND.n42 585
R79 VGND.n131 VGND.n130 585
R80 VGND.n130 VGND.n129 585
R81 VGND.n132 VGND.n40 585
R82 VGND.n40 VGND.n38 585
R83 VGND.n181 VGND.n180 585
R84 VGND.t2 VGND.n181 585
R85 VGND.n179 VGND.n41 585
R86 VGND.n41 VGND.n39 585
R87 VGND.n178 VGND.n177 585
R88 VGND.n177 VGND.n176 585
R89 VGND.n209 VGND.n208 585
R90 VGND.n207 VGND.n19 585
R91 VGND.n206 VGND.n18 585
R92 VGND.n211 VGND.n18 585
R93 VGND.n205 VGND.n204 585
R94 VGND.n203 VGND.n202 585
R95 VGND.n201 VGND.n200 585
R96 VGND.n199 VGND.n198 585
R97 VGND.n197 VGND.n17 585
R98 VGND.n211 VGND.n17 585
R99 VGND.n196 VGND.n195 585
R100 VGND.n195 VGND.n14 585
R101 VGND.n194 VGND.n22 585
R102 VGND.n194 VGND.n193 585
R103 VGND VGND.n23 585
R104 VGND.t1 VGND.n23 585
R105 VGND.n186 VGND.n185 585
R106 VGND.n187 VGND.n186 585
R107 VGND.n29 VGND.n28 585
R108 VGND.n28 VGND.n27 585
R109 VGND.n157 VGND.n156 585
R110 VGND.n155 VGND.n142 585
R111 VGND.n154 VGND.n153 585
R112 VGND.n152 VGND.n151 585
R113 VGND.n150 VGND.n149 585
R114 VGND.n148 VGND.n147 585
R115 VGND.n146 VGND.n145 585
R116 VGND.n144 VGND.n143 585
R117 VGND.n26 VGND.n25 585
R118 VGND.n27 VGND.n26 585
R119 VGND.n189 VGND.n188 585
R120 VGND.n188 VGND.n187 585
R121 VGND.n190 VGND.n24 585
R122 VGND.n24 VGND.t1 585
R123 VGND.n192 VGND.n191 585
R124 VGND.n193 VGND.n192 585
R125 VGND.n21 VGND.n20 585
R126 VGND.n20 VGND.n14 585
R127 VGND.n238 VGND.n237 585
R128 VGND.n256 VGND.n255 585
R129 VGND.n254 VGND.n243 585
R130 VGND.n258 VGND.n243 585
R131 VGND.n253 VGND.n252 585
R132 VGND.n251 VGND.n250 585
R133 VGND.n249 VGND.n248 585
R134 VGND.n247 VGND.n246 585
R135 VGND.n245 VGND.n242 585
R136 VGND.n258 VGND.n242 585
R137 VGND.n244 VGND.n239 585
R138 VGND.n259 VGND.n239 585
R139 VGND.n7 VGND.n5 585
R140 VGND.n9 VGND.n7 585
R141 VGND VGND.n265 585
R142 VGND.n265 VGND.t4 585
R143 VGND.n6 VGND.n4 585
R144 VGND.n8 VGND.n6 585
R145 VGND.n232 VGND.n231 585
R146 VGND.n233 VGND.n232 585
R147 VGND.n230 VGND.n213 585
R148 VGND.n229 VGND.n228 585
R149 VGND.n226 VGND.n214 585
R150 VGND.n224 VGND.n223 585
R151 VGND.n222 VGND.n215 585
R152 VGND.n221 VGND.n220 585
R153 VGND.n218 VGND.n216 585
R154 VGND.n13 VGND.n12 585
R155 VGND.n235 VGND.n234 585
R156 VGND.n234 VGND.n233 585
R157 VGND.n236 VGND.n10 585
R158 VGND.n10 VGND.n8 585
R159 VGND.n264 VGND.n263 585
R160 VGND.t4 VGND.n264 585
R161 VGND.n262 VGND.n11 585
R162 VGND.n11 VGND.n9 585
R163 VGND.n261 VGND.n260 585
R164 VGND.n260 VGND.n259 585
R165 VGND.n79 VGND.n78 585
R166 VGND.n60 VGND.n59 585
R167 VGND.n74 VGND.n73 585
R168 VGND.n72 VGND.n63 585
R169 VGND.n71 VGND.n70 585
R170 VGND.n69 VGND.n68 585
R171 VGND.n67 VGND.n66 585
R172 VGND.n65 VGND.n64 585
R173 VGND.n56 VGND.n55 585
R174 VGND.n57 VGND.n56 585
R175 VGND.n85 VGND.n84 585
R176 VGND.n84 VGND.n83 585
R177 VGND.n86 VGND.n54 585
R178 VGND.n54 VGND.t0 585
R179 VGND.n88 VGND.n87 585
R180 VGND.n89 VGND.n88 585
R181 VGND.n51 VGND.n50 585
R182 VGND.n50 VGND.n44 585
R183 VGND.n105 VGND.n104 585
R184 VGND.n103 VGND.n49 585
R185 VGND.n102 VGND.n48 585
R186 VGND.n107 VGND.n48 585
R187 VGND.n101 VGND.n100 585
R188 VGND.n99 VGND.n98 585
R189 VGND.n97 VGND.n96 585
R190 VGND.n95 VGND.n94 585
R191 VGND.n93 VGND.n47 585
R192 VGND.n107 VGND.n47 585
R193 VGND.n92 VGND.n91 585
R194 VGND.n91 VGND.n44 585
R195 VGND.n90 VGND.n52 585
R196 VGND.n90 VGND.n89 585
R197 VGND VGND.n53 585
R198 VGND.t0 VGND.n53 585
R199 VGND.n82 VGND.n81 585
R200 VGND.n83 VGND.n82 585
R201 VGND.n80 VGND.n58 585
R202 VGND.n58 VGND.n57 585
R203 VGND.n234 VGND.n10 394
R204 VGND.n264 VGND.n10 394
R205 VGND.n264 VGND.n11 394
R206 VGND.n260 VGND.n11 394
R207 VGND.n220 VGND.n218 394
R208 VGND.n224 VGND.n215 394
R209 VGND.n228 VGND.n226 394
R210 VGND.n232 VGND.n6 394
R211 VGND.n265 VGND.n6 394
R212 VGND.n265 VGND.n7 394
R213 VGND.n239 VGND.n7 394
R214 VGND.n256 VGND.n243 394
R215 VGND.n252 VGND.n243 394
R216 VGND.n250 VGND.n249 394
R217 VGND.n246 VGND.n242 394
R218 VGND.n188 VGND.n26 394
R219 VGND.n188 VGND.n24 394
R220 VGND.n192 VGND.n24 394
R221 VGND.n192 VGND.n20 394
R222 VGND.n147 VGND.n146 394
R223 VGND.n151 VGND.n150 394
R224 VGND.n153 VGND.n142 394
R225 VGND.n186 VGND.n28 394
R226 VGND.n186 VGND.n23 394
R227 VGND.n194 VGND.n23 394
R228 VGND.n195 VGND.n194 394
R229 VGND.n19 VGND.n18 394
R230 VGND.n204 VGND.n18 394
R231 VGND.n202 VGND.n201 394
R232 VGND.n198 VGND.n17 394
R233 VGND.n130 VGND.n40 394
R234 VGND.n181 VGND.n40 394
R235 VGND.n181 VGND.n41 394
R236 VGND.n177 VGND.n41 394
R237 VGND.n116 VGND.n114 394
R238 VGND.n120 VGND.n111 394
R239 VGND.n124 VGND.n122 394
R240 VGND.n128 VGND.n36 394
R241 VGND.n182 VGND.n36 394
R242 VGND.n182 VGND.n37 394
R243 VGND.n135 VGND.n37 394
R244 VGND.n173 VGND.n160 394
R245 VGND.n169 VGND.n160 394
R246 VGND.n167 VGND.n166 394
R247 VGND.n163 VGND.n138 394
R248 VGND.n84 VGND.n56 394
R249 VGND.n84 VGND.n54 394
R250 VGND.n88 VGND.n54 394
R251 VGND.n88 VGND.n50 394
R252 VGND.n49 VGND.n48 394
R253 VGND.n100 VGND.n48 394
R254 VGND.n98 VGND.n97 394
R255 VGND.n94 VGND.n47 394
R256 VGND.n82 VGND.n58 394
R257 VGND.n82 VGND.n53 394
R258 VGND.n90 VGND.n53 394
R259 VGND.n91 VGND.n90 394
R260 VGND.n68 VGND.n67 394
R261 VGND.n70 VGND.n63 394
R262 VGND.n74 VGND.n60 394
R263 VGND.n175 VGND.n174 218.815
R264 VGND.n175 VGND.n136 218.815
R265 VGND.n175 VGND.n137 218.815
R266 VGND.n123 VGND.n108 218.815
R267 VGND.n121 VGND.n108 218.815
R268 VGND.n115 VGND.n108 218.815
R269 VGND.n113 VGND.n108 218.815
R270 VGND.n211 VGND.n210 218.815
R271 VGND.n211 VGND.n15 218.815
R272 VGND.n211 VGND.n16 218.815
R273 VGND.n159 VGND.n158 218.815
R274 VGND.n159 VGND.n141 218.815
R275 VGND.n159 VGND.n140 218.815
R276 VGND.n159 VGND.n139 218.815
R277 VGND.n258 VGND.n257 218.815
R278 VGND.n258 VGND.n240 218.815
R279 VGND.n258 VGND.n241 218.815
R280 VGND.n227 VGND.n212 218.815
R281 VGND.n225 VGND.n212 218.815
R282 VGND.n219 VGND.n212 218.815
R283 VGND.n217 VGND.n212 218.815
R284 VGND.n77 VGND.n76 218.815
R285 VGND.n76 VGND.n75 218.815
R286 VGND.n76 VGND.n62 218.815
R287 VGND.n76 VGND.n61 218.815
R288 VGND.n107 VGND.n106 218.815
R289 VGND.n107 VGND.n45 218.815
R290 VGND.n107 VGND.n46 218.815
R291 VGND.t5 VGND.n0 181.41
R292 VGND.n31 VGND.t3 181.41
R293 VGND.n1 VGND.t5 174.912
R294 VGND.t3 VGND.n30 174.912
R295 VGND.n76 VGND.n57 165.892
R296 VGND.n107 VGND.n44 165.892
R297 VGND.n129 VGND.n108 165.892
R298 VGND.n176 VGND.n175 165.892
R299 VGND.n159 VGND.n27 165.892
R300 VGND.n211 VGND.n14 165.892
R301 VGND.n233 VGND.n212 165.892
R302 VGND.n259 VGND.n258 165.892
R303 VGND.n218 VGND.n217 147.374
R304 VGND.n219 VGND.n215 147.374
R305 VGND.n226 VGND.n225 147.374
R306 VGND.n227 VGND.n213 147.374
R307 VGND.n257 VGND.n238 147.374
R308 VGND.n252 VGND.n240 147.374
R309 VGND.n249 VGND.n241 147.374
R310 VGND.n146 VGND.n139 147.374
R311 VGND.n150 VGND.n140 147.374
R312 VGND.n153 VGND.n141 147.374
R313 VGND.n158 VGND.n157 147.374
R314 VGND.n210 VGND.n209 147.374
R315 VGND.n204 VGND.n15 147.374
R316 VGND.n201 VGND.n16 147.374
R317 VGND.n114 VGND.n113 147.374
R318 VGND.n115 VGND.n111 147.374
R319 VGND.n122 VGND.n121 147.374
R320 VGND.n123 VGND.n109 147.374
R321 VGND.n174 VGND.n134 147.374
R322 VGND.n169 VGND.n136 147.374
R323 VGND.n166 VGND.n137 147.374
R324 VGND.n174 VGND.n173 147.374
R325 VGND.n167 VGND.n136 147.374
R326 VGND.n163 VGND.n137 147.374
R327 VGND.n124 VGND.n123 147.374
R328 VGND.n121 VGND.n120 147.374
R329 VGND.n116 VGND.n115 147.374
R330 VGND.n113 VGND.n43 147.374
R331 VGND.n210 VGND.n19 147.374
R332 VGND.n202 VGND.n15 147.374
R333 VGND.n198 VGND.n16 147.374
R334 VGND.n158 VGND.n142 147.374
R335 VGND.n151 VGND.n141 147.374
R336 VGND.n147 VGND.n140 147.374
R337 VGND.n143 VGND.n139 147.374
R338 VGND.n257 VGND.n256 147.374
R339 VGND.n250 VGND.n240 147.374
R340 VGND.n246 VGND.n241 147.374
R341 VGND.n228 VGND.n227 147.374
R342 VGND.n225 VGND.n224 147.374
R343 VGND.n220 VGND.n219 147.374
R344 VGND.n217 VGND.n13 147.374
R345 VGND.n106 VGND.n105 147.374
R346 VGND.n100 VGND.n45 147.374
R347 VGND.n97 VGND.n46 147.374
R348 VGND.n64 VGND.n61 147.374
R349 VGND.n68 VGND.n62 147.374
R350 VGND.n75 VGND.n63 147.374
R351 VGND.n77 VGND.n60 147.374
R352 VGND.n78 VGND.n77 147.374
R353 VGND.n75 VGND.n74 147.374
R354 VGND.n70 VGND.n62 147.374
R355 VGND.n67 VGND.n61 147.374
R356 VGND.n106 VGND.n49 147.374
R357 VGND.n98 VGND.n45 147.374
R358 VGND.n94 VGND.n46 147.374
R359 VGND.n83 VGND.n57 105.427
R360 VGND.n83 VGND.t0 105.427
R361 VGND.n89 VGND.t0 105.427
R362 VGND.n89 VGND.n44 105.427
R363 VGND.n129 VGND.n38 105.427
R364 VGND.t2 VGND.n38 105.427
R365 VGND.t2 VGND.n39 105.427
R366 VGND.n176 VGND.n39 105.427
R367 VGND.n187 VGND.n27 105.427
R368 VGND.n187 VGND.t1 105.427
R369 VGND.n193 VGND.t1 105.427
R370 VGND.n193 VGND.n14 105.427
R371 VGND.n233 VGND.n8 105.427
R372 VGND.t4 VGND.n8 105.427
R373 VGND.t4 VGND.n9 105.427
R374 VGND.n259 VGND.n9 105.427
R375 VGND.n235 VGND.n12 78.6829
R376 VGND.n261 VGND.n237 78.6829
R377 VGND.n231 VGND.n230 78.6829
R378 VGND.n245 VGND.n244 78.6829
R379 VGND.n144 VGND.n25 78.6829
R380 VGND.n208 VGND.n21 78.6829
R381 VGND.n156 VGND.n29 78.6829
R382 VGND.n197 VGND.n196 78.6829
R383 VGND.n131 VGND.n42 78.6829
R384 VGND.n178 VGND.n133 78.6829
R385 VGND.n127 VGND.n126 78.6829
R386 VGND.n162 VGND.n161 78.6829
R387 VGND.n65 VGND.n55 78.6829
R388 VGND.n80 VGND.n79 78.6829
R389 VGND.n104 VGND.n51 78.6829
R390 VGND.n93 VGND.n92 78.6829
R391 VGND.n236 VGND.n235 25.6005
R392 VGND.n263 VGND.n236 25.6005
R393 VGND.n263 VGND.n262 25.6005
R394 VGND.n262 VGND.n261 25.6005
R395 VGND.n216 VGND.n12 25.6005
R396 VGND.n221 VGND.n216 25.6005
R397 VGND.n222 VGND.n221 25.6005
R398 VGND.n223 VGND.n222 25.6005
R399 VGND.n223 VGND.n214 25.6005
R400 VGND.n229 VGND.n214 25.6005
R401 VGND.n230 VGND.n229 25.6005
R402 VGND.n231 VGND.n4 25.6005
R403 VGND VGND.n4 25.6005
R404 VGND VGND.n5 25.6005
R405 VGND.n244 VGND.n5 25.6005
R406 VGND.n255 VGND.n237 25.6005
R407 VGND.n255 VGND.n254 25.6005
R408 VGND.n254 VGND.n253 25.6005
R409 VGND.n253 VGND.n251 25.6005
R410 VGND.n251 VGND.n248 25.6005
R411 VGND.n248 VGND.n247 25.6005
R412 VGND.n247 VGND.n245 25.6005
R413 VGND.n189 VGND.n25 25.6005
R414 VGND.n190 VGND.n189 25.6005
R415 VGND.n191 VGND.n190 25.6005
R416 VGND.n191 VGND.n21 25.6005
R417 VGND.n145 VGND.n144 25.6005
R418 VGND.n148 VGND.n145 25.6005
R419 VGND.n149 VGND.n148 25.6005
R420 VGND.n152 VGND.n149 25.6005
R421 VGND.n154 VGND.n152 25.6005
R422 VGND.n155 VGND.n154 25.6005
R423 VGND.n156 VGND.n155 25.6005
R424 VGND.n185 VGND.n29 25.6005
R425 VGND.n185 VGND 25.6005
R426 VGND VGND.n22 25.6005
R427 VGND.n196 VGND.n22 25.6005
R428 VGND.n208 VGND.n207 25.6005
R429 VGND.n207 VGND.n206 25.6005
R430 VGND.n206 VGND.n205 25.6005
R431 VGND.n205 VGND.n203 25.6005
R432 VGND.n203 VGND.n200 25.6005
R433 VGND.n200 VGND.n199 25.6005
R434 VGND.n199 VGND.n197 25.6005
R435 VGND.n132 VGND.n131 25.6005
R436 VGND.n180 VGND.n132 25.6005
R437 VGND.n180 VGND.n179 25.6005
R438 VGND.n179 VGND.n178 25.6005
R439 VGND.n112 VGND.n42 25.6005
R440 VGND.n117 VGND.n112 25.6005
R441 VGND.n118 VGND.n117 25.6005
R442 VGND.n119 VGND.n118 25.6005
R443 VGND.n119 VGND.n110 25.6005
R444 VGND.n125 VGND.n110 25.6005
R445 VGND.n126 VGND.n125 25.6005
R446 VGND.n127 VGND.n34 25.6005
R447 VGND VGND.n34 25.6005
R448 VGND VGND.n35 25.6005
R449 VGND.n161 VGND.n35 25.6005
R450 VGND.n172 VGND.n133 25.6005
R451 VGND.n172 VGND.n171 25.6005
R452 VGND.n171 VGND.n170 25.6005
R453 VGND.n170 VGND.n168 25.6005
R454 VGND.n168 VGND.n165 25.6005
R455 VGND.n165 VGND.n164 25.6005
R456 VGND.n164 VGND.n162 25.6005
R457 VGND.n66 VGND.n65 25.6005
R458 VGND.n69 VGND.n66 25.6005
R459 VGND.n71 VGND.n69 25.6005
R460 VGND.n72 VGND.n71 25.6005
R461 VGND.n73 VGND.n72 25.6005
R462 VGND.n73 VGND.n59 25.6005
R463 VGND.n79 VGND.n59 25.6005
R464 VGND.n85 VGND.n55 25.6005
R465 VGND.n86 VGND.n85 25.6005
R466 VGND.n87 VGND.n86 25.6005
R467 VGND.n87 VGND.n51 25.6005
R468 VGND.n104 VGND.n103 25.6005
R469 VGND.n103 VGND.n102 25.6005
R470 VGND.n102 VGND.n101 25.6005
R471 VGND.n101 VGND.n99 25.6005
R472 VGND.n99 VGND.n96 25.6005
R473 VGND.n96 VGND.n95 25.6005
R474 VGND.n95 VGND.n93 25.6005
R475 VGND.n81 VGND.n80 25.6005
R476 VGND.n81 VGND 25.6005
R477 VGND VGND.n52 25.6005
R478 VGND.n92 VGND.n52 25.6005
R479 VGND VGND.n30 19.837
R480 VGND.n1 VGND 19.837
R481 VGND VGND.n33 18.846
R482 VGND.n266 VGND 18.3251
R483 VGND VGND.n184 18.3251
R484 VGND.n183 VGND 18.3251
R485 VGND.n32 VGND.n30 14.1895
R486 VGND.n2 VGND.n1 14.1895
R487 VGND.n33 VGND.n32 9.92259
R488 VGND.n3 VGND.n2 9.92259
R489 VGND VGND.n266 4.35246
R490 VGND.n31 VGND 4.259
R491 VGND VGND.n0 4.259
R492 VGND.n32 VGND.n31 3.04672
R493 VGND.n2 VGND.n0 3.04672
R494 VGND.n184 VGND.n183 0.615417
R495 VGND.n184 VGND.n3 0.521417
R496 VGND.n183 VGND.n33 0.0945
R497 VGND.n266 VGND.n3 0.0945
R498 OUT.n1 OUT.t0 181.41
R499 OUT.t0 OUT.n0 174.912
R500 OUT OUT.n0 19.837
R501 OUT OUT.n2 16.724
R502 OUT.n2 OUT.n0 14.1895
R503 OUT.n1 OUT 4.259
R504 OUT.n2 OUT.n1 3.04672
R505 LOW_OUT.n2 LOW_OUT.t1 181.41
R506 LOW_OUT.n5 LOW_OUT.t0 181.41
R507 LOW_OUT.t1 LOW_OUT.n1 174.912
R508 LOW_OUT.t0 LOW_OUT.n0 174.912
R509 LOW_OUT.n4 LOW_OUT.n3 22.3143
R510 LOW_OUT LOW_OUT.n1 19.837
R511 LOW_OUT LOW_OUT.n0 19.837
R512 LOW_OUT.n3 LOW_OUT.n1 14.1895
R513 LOW_OUT.n4 LOW_OUT.n0 14.1895
R514 LOW_OUT.n2 LOW_OUT 4.259
R515 LOW_OUT LOW_OUT.n5 4.259
R516 LOW_OUT.n3 LOW_OUT.n2 3.04672
R517 LOW_OUT.n5 LOW_OUT.n4 3.04672
C6 OUT VGND 4.56753f
C7 REF VGND 5.86522f
C8 LOW_OUT VGND 2.48848f $ **FLOATING
C9 LOW_REF VGND 5.54994f $ **FLOATING
C10 LOW_OUT.n0 VGND 0.02932f $ **FLOATING
C11 LOW_OUT.t0 VGND 0.04778f $ **FLOATING
C12 LOW_OUT.n1 VGND 0.02932f $ **FLOATING
C13 LOW_OUT.t1 VGND 0.04778f $ **FLOATING
C14 LOW_OUT.n2 VGND 0.02827f $ **FLOATING
C15 LOW_OUT.n3 VGND 2.98733f $ **FLOATING
C16 LOW_OUT.n4 VGND 2.87877f $ **FLOATING
C17 LOW_OUT.n5 VGND 0.02827f $ **FLOATING
C18 OUT.n0 VGND 0.03058f $ **FLOATING
C19 OUT.t0 VGND 0.04982f $ **FLOATING
C20 OUT.n1 VGND 0.02948f $ **FLOATING
C21 OUT.n2 VGND 1.7758f $ **FLOATING
C22 LOW_REF.n0 VGND 0.00933f $ **FLOATING
C23 LOW_REF.t0 VGND 0.01521f $ **FLOATING
C24 LOW_REF.t3 VGND 0.17846f $ **FLOATING
C25 LOW_REF.n1 VGND 0.00933f $ **FLOATING
C26 LOW_REF.t2 VGND 0.01521f $ **FLOATING
C27 LOW_REF.n2 VGND 0.009f $ **FLOATING
C28 LOW_REF.n3 VGND 0.12581f $ **FLOATING
C29 LOW_REF.t1 VGND 0.17846f $ **FLOATING
C30 LOW_REF.n4 VGND 0.74249f $ **FLOATING
C31 LOW_REF.n5 VGND 0.65471f $ **FLOATING
C32 LOW_REF.n6 VGND 0.11372f $ **FLOATING
C33 LOW_REF.n7 VGND 0.009f $ **FLOATING
C34 REF.t2 VGND 0.23264f $ **FLOATING
C35 REF.t0 VGND 0.23264f $ **FLOATING
C36 REF.n0 VGND 1.31474f $ **FLOATING
C37 REF.n1 VGND 0.01173f $ **FLOATING
C38 REF.t1 VGND 0.01983f $ **FLOATING
C39 REF.n2 VGND 0.01217f $ **FLOATING
C40 REF.n3 VGND 0.19793f $ **FLOATING
C41 REF.n4 VGND 0.9072f $ **FLOATING
.ends

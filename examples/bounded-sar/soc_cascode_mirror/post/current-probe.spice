* NGSPICE file created from soc_cascode_mirror.ext - technology: sky130A

.subckt soc_cascode_mirror VGND REF OUT
X0 register_cf_node_d4f01c71d35c270b REF.t0 register_cf_node_d4f01c71d35c270b_source VGND.t1 sky130_fd_pr__nfet_01v8 ad=0.58 pd=4.58 as=0.58 ps=4.58 w=2 l=1
Vregister_cf_d4f01c71d35c270b LOW_REF.t0 register_cf_node_d4f01c71d35c270b 0
Vregister_cf_d4f01c71d35c270b_source REF.t1 register_cf_node_d4f01c71d35c270b_source 0
X1 register_cf_node_75d0ab99e3ad4b4b LOW_REF.t1 register_cf_node_75d0ab99e3ad4b4b_source VGND.t4 sky130_fd_pr__nfet_01v8 ad=0.58 pd=4.58 as=0.58 ps=4.58 w=2 l=1
Vregister_cf_75d0ab99e3ad4b4b VGND.t5 register_cf_node_75d0ab99e3ad4b4b 0
Vregister_cf_75d0ab99e3ad4b4b_source LOW_REF.t2 register_cf_node_75d0ab99e3ad4b4b_source 0
X2 register_cf_node_e8d757f6f539c15b REF.t2 register_cf_node_e8d757f6f539c15b_source VGND.t0 sky130_fd_pr__nfet_01v8 ad=0.58 pd=4.58 as=0.58 ps=4.58 w=2 l=1
Vregister_cf_e8d757f6f539c15b LOW_OUT.t0 register_cf_node_e8d757f6f539c15b 0
Vregister_cf_e8d757f6f539c15b_source OUT.t0 register_cf_node_e8d757f6f539c15b_source 0
X3 register_cf_node_d0889b5ac86b52c4 LOW_REF.t3 register_cf_node_d0889b5ac86b52c4_source VGND.t2 sky130_fd_pr__nfet_01v8 ad=0.58 pd=4.58 as=0.58 ps=4.58 w=2 l=1
Vregister_cf_d0889b5ac86b52c4 VGND.t3 register_cf_node_d0889b5ac86b52c4 0
Vregister_cf_d0889b5ac86b52c4_source LOW_OUT.t1 register_cf_node_d0889b5ac86b52c4_source 0
C0 REF LOW_OUT 3.31726f
C1 OUT LOW_REF 2.18319f
C2 REF LOW_REF 0.87718f
C3 LOW_REF LOW_OUT 0.30677f
C4 REF OUT 0.26203f
C5 OUT LOW_OUT 2.81654f
C6 OUT VGND 4.56753f
C7 REF VGND 5.86522f
C8 LOW_OUT VGND 2.48848f $ **FLOATING
C9 LOW_REF VGND 5.54994f $ **FLOATING
C10 LOW_OUT.n0 VGND 0.02932f $ **FLOATING
C11 LOW_OUT.t0 VGND 0.04778f $ **FLOATING
C12 LOW_OUT.n1 VGND 0.02932f $ **FLOATING
C13 LOW_OUT.t1 VGND 0.04778f $ **FLOATING
C14 LOW_OUT.n2 VGND 0.02827f $ **FLOATING
C15 LOW_OUT.n3 VGND 2.98733f $ **FLOATING
C16 LOW_OUT.n4 VGND 2.87877f $ **FLOATING
C17 LOW_OUT.n5 VGND 0.02827f $ **FLOATING
C18 OUT.n0 VGND 0.03058f $ **FLOATING
C19 OUT.t0 VGND 0.04982f $ **FLOATING
C20 OUT.n1 VGND 0.02948f $ **FLOATING
C21 OUT.n2 VGND 1.7758f $ **FLOATING
C22 LOW_REF.n0 VGND 0.00933f $ **FLOATING
C23 LOW_REF.t0 VGND 0.01521f $ **FLOATING
C24 LOW_REF.t3 VGND 0.17846f $ **FLOATING
C25 LOW_REF.n1 VGND 0.00933f $ **FLOATING
C26 LOW_REF.t2 VGND 0.01521f $ **FLOATING
C27 LOW_REF.n2 VGND 0.009f $ **FLOATING
C28 LOW_REF.n3 VGND 0.12581f $ **FLOATING
C29 LOW_REF.t1 VGND 0.17846f $ **FLOATING
C30 LOW_REF.n4 VGND 0.74249f $ **FLOATING
C31 LOW_REF.n5 VGND 0.65471f $ **FLOATING
C32 LOW_REF.n6 VGND 0.11372f $ **FLOATING
C33 LOW_REF.n7 VGND 0.009f $ **FLOATING
C34 REF.t2 VGND 0.23264f $ **FLOATING
C35 REF.t0 VGND 0.23264f $ **FLOATING
C36 REF.n0 VGND 1.31474f $ **FLOATING
C37 REF.n1 VGND 0.01173f $ **FLOATING
C38 REF.t1 VGND 0.01983f $ **FLOATING
C39 REF.n2 VGND 0.01217f $ **FLOATING
C40 REF.n3 VGND 0.19793f $ **FLOATING
C41 REF.n4 VGND 0.9072f $ **FLOATING
rmesh_equiv_0 low_out low_out.n0 19.837
rmesh_equiv_1 low_out low_out.n1 19.837
rmesh_equiv_10 low_out.n3 low_out.n4 22.314299999999999
rmesh_equiv_11 low_out.n4 low_out.n5 3.0467200000000001
rmesh_equiv_12 low_out.n5 low_out.t0 181.41
rmesh_equiv_13 low_ref low_ref.n0 19.837
rmesh_equiv_14 low_ref low_ref.n1 19.837
rmesh_equiv_15 low_ref low_ref.n2 4.2590000000000003
rmesh_equiv_16 low_ref low_ref.n4 26.363499999999998
rmesh_equiv_17 low_ref low_ref.n5 27.060300000000002
rmesh_equiv_18 low_ref low_ref.n7 4.2590000000000003
rmesh_equiv_19 low_ref low_ref.t1 139.911
rmesh_equiv_2 low_out low_out.n2 4.2590000000000003
rmesh_equiv_20 low_ref low_ref.t3 139.911
rmesh_equiv_21 low_ref.n0 low_ref.n6 14.189499999999999
rmesh_equiv_22 low_ref.n0 low_ref.t0 174.91200000000001
rmesh_equiv_23 low_ref.n1 low_ref.n3 14.189499999999999
rmesh_equiv_24 low_ref.n1 low_ref.t2 174.91200000000001
rmesh_equiv_25 low_ref.n2 low_ref.n3 3.0467200000000001
rmesh_equiv_26 low_ref.n2 low_ref.t2 181.41
rmesh_equiv_27 low_ref.n3 low_ref.n4 10.192399999999999
rmesh_equiv_28 low_ref.n4 low_ref.n5 0.53355799999999998
rmesh_equiv_29 low_ref.n5 low_ref.n6 9.9225899999999996
rmesh_equiv_3 low_out low_out.n5 4.2590000000000003
rmesh_equiv_30 low_ref.n6 low_ref.n7 3.0467200000000001
rmesh_equiv_31 low_ref.n7 low_ref.t0 181.41
rmesh_equiv_32 out out.n0 19.837
rmesh_equiv_33 out out.n1 4.2590000000000003
rmesh_equiv_34 out out.n2 16.724
rmesh_equiv_35 out.n0 out.n2 14.189499999999999
rmesh_equiv_36 out.n0 out.t0 174.91200000000001
rmesh_equiv_37 out.n1 out.n2 3.0467200000000001
rmesh_equiv_38 out.n1 out.t0 181.41
rmesh_equiv_39 ref ref.n0 14.107502808341954
rmesh_equiv_4 low_out.n0 low_out.n4 14.189499999999999
rmesh_equiv_40 ref ref.n1 4.2590000000000003
rmesh_equiv_41 ref ref.n2 19.837
rmesh_equiv_42 ref ref.n4 5.0143800000000001
rmesh_equiv_43 ref ref.t0 139.911
rmesh_equiv_44 ref ref.t2 139.911
rmesh_equiv_45 ref.n0 ref.n4 0.27035799999999999
rmesh_equiv_46 ref.n1 ref.n3 3.0467200000000001
rmesh_equiv_47 ref.n1 ref.t1 181.41
rmesh_equiv_48 ref.n2 ref.n3 14.189499999999999
rmesh_equiv_49 ref.n2 ref.t1 174.91200000000001
rmesh_equiv_5 low_out.n0 low_out.t0 174.91200000000001
rmesh_equiv_50 ref.n3 ref.n4 11.172599999999999
rmesh_equiv_51 vgnd vgnd.t0 166.72747775691877
rmesh_equiv_52 vgnd vgnd.t1 166.72747717859738
rmesh_equiv_53 vgnd vgnd.t2 166.72747718726592
rmesh_equiv_54 vgnd vgnd.t3 93.048729744212963
rmesh_equiv_55 vgnd vgnd.t4 166.72747660894464
rmesh_equiv_56 vgnd vgnd.t5 93.031325316617242
rmesh_equiv_57 vgnd.t0 vgnd.t1 1167702.7076246357
rmesh_equiv_58 vgnd.t0 vgnd.t2 8885.1423713851491
rmesh_equiv_59 vgnd.t0 vgnd.t4 152303013.31028321
rmesh_equiv_6 low_out.n1 low_out.n3 14.189499999999999
rmesh_equiv_60 vgnd.t1 vgnd.t2 8952.7422178692959
rmesh_equiv_61 vgnd.t1 vgnd.t4 8885.1423960036409
rmesh_equiv_62 vgnd.t2 vgnd.t4 1167702.7108598566
rmesh_equiv_63 vgnd.t3 vgnd.t5 116424.17727219993
rmesh_equiv_7 low_out.n1 low_out.t1 174.91200000000001
rmesh_equiv_8 low_out.n2 low_out.n3 3.0467200000000001
rmesh_equiv_9 low_out.n2 low_out.t1 181.41
.ends

* NGSPICE file created from soc_cascode_mirror.ext - technology: sky130A

.subckt soc_cascode_mirror VGND REF OUT
X0 LOW_REF REF REF VGND sky130_fd_pr__nfet_01v8 ad=0.58 pd=4.58 as=0.58 ps=4.58 w=2 l=1
X1 VGND LOW_REF LOW_REF VGND sky130_fd_pr__nfet_01v8 ad=0.58 pd=4.58 as=0.58 ps=4.58 w=2 l=1
X2 LOW_OUT REF OUT VGND sky130_fd_pr__nfet_01v8 ad=0.58 pd=4.58 as=0.58 ps=4.58 w=2 l=1
X3 VGND LOW_REF LOW_OUT VGND sky130_fd_pr__nfet_01v8 ad=0.58 pd=4.58 as=0.58 ps=4.58 w=2 l=1
.ends

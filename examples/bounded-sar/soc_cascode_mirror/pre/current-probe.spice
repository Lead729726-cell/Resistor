.subckt soc_cascode_mirror REF OUT VGND
XN_OUT register_cf_node_29151762590876d4 LOW_REF register_cf_node_29151762590876d4_source VGND sky130_fd_pr__nfet_01v8 w=2 l=1 nf=1 m=1
Vregister_cf_29151762590876d4 LOW_OUT register_cf_node_29151762590876d4 0
Vregister_cf_29151762590876d4_source VGND register_cf_node_29151762590876d4_source 0
XN_OUT_CAS register_cf_node_67bc1ac676366eb7 REF register_cf_node_67bc1ac676366eb7_source VGND sky130_fd_pr__nfet_01v8 w=2 l=1 nf=1 m=1
Vregister_cf_67bc1ac676366eb7 OUT register_cf_node_67bc1ac676366eb7 0
Vregister_cf_67bc1ac676366eb7_source LOW_OUT register_cf_node_67bc1ac676366eb7_source 0
XN_REF register_cf_node_d2e253cde050b897 LOW_REF register_cf_node_d2e253cde050b897_source VGND sky130_fd_pr__nfet_01v8 w=2 l=1 nf=1 m=1
Vregister_cf_d2e253cde050b897 LOW_REF register_cf_node_d2e253cde050b897 0
Vregister_cf_d2e253cde050b897_source VGND register_cf_node_d2e253cde050b897_source 0
XN_REF_CAS register_cf_node_7c1f3f6495b66aca REF register_cf_node_7c1f3f6495b66aca_source VGND sky130_fd_pr__nfet_01v8 w=2 l=1 nf=1 m=1
Vregister_cf_7c1f3f6495b66aca REF register_cf_node_7c1f3f6495b66aca 0
Vregister_cf_7c1f3f6495b66aca_source LOW_REF register_cf_node_7c1f3f6495b66aca_source 0
.ends soc_cascode_mirror

.subckt sar8_analog VIN VREF VCM BIAS SAMPLE TOP COMP B0 B1 B2 B3 B4 B5 B6 B7 VPWR VGND
XCOMPARE_N_OUT COMPARE__DECISION_RAW COMPARE__PRE VGND VGND sky130_fd_pr__nfet_01v8 w=4 l=0.15 nf=1 m=1
XCOMPARE_PREAMP_N_INN COMPARE__PREAMP__MIR TOP COMPARE__PREAMP__TAIL VGND sky130_fd_pr__nfet_01v8 w=10 l=1 nf=1 m=1
XCOMPARE_PREAMP_N_INP COMPARE__PRE VCM COMPARE__PREAMP__TAIL VGND sky130_fd_pr__nfet_01v8 w=10 l=1 nf=1 m=1
XCOMPARE_PREAMP_N_TAIL COMPARE__PREAMP__TAIL BIAS VGND VGND sky130_fd_pr__nfet_01v8 w=2 l=1 nf=1 m=1
XCOMPARE_PREAMP_P_DIODE COMPARE__PREAMP__MIR COMPARE__PREAMP__MIR VPWR VPWR sky130_fd_pr__pfet_01v8_hvt w=20 l=1 nf=1 m=1
XCOMPARE_PREAMP_P_MIRROR COMPARE__PRE COMPARE__PREAMP__MIR VPWR VPWR sky130_fd_pr__pfet_01v8_hvt w=20 l=1 nf=1 m=1
XCOMPARE_P_OUT COMPARE__DECISION_RAW COMPARE__PRE VPWR VPWR sky130_fd_pr__pfet_01v8_hvt w=8 l=0.15 nf=1 m=1
XCOMPARE_RESTORE0_MN COMPARE__DECISION_B COMPARE__DECISION_RAW VGND VGND sky130_fd_pr__nfet_01v8 w=0.65 l=0.15 nf=1 m=1
XCOMPARE_RESTORE0_MP COMPARE__DECISION_B COMPARE__DECISION_RAW VPWR VPWR sky130_fd_pr__pfet_01v8_hvt w=0.65 l=0.15 nf=1 m=1
XCOMPARE_RESTORE1_MN COMP COMPARE__DECISION_B VGND VGND sky130_fd_pr__nfet_01v8 w=0.65 l=0.15 nf=1 m=1
XCOMPARE_RESTORE1_MP COMP COMPARE__DECISION_B VPWR VPWR sky130_fd_pr__pfet_01v8_hvt w=0.65 l=0.15 nf=1 m=1
XDAC_BIT0_ACQUIRE_N DAC__BOTTOM0 SAMPLE VIN VGND sky130_fd_pr__nfet_01v8 w=4 l=0.15 nf=1 m=1
XDAC_BIT0_ACQUIRE_P DAC__BOTTOM0 DAC__SAMPLEB VIN VPWR sky130_fd_pr__pfet_01v8_hvt w=8 l=0.15 nf=1 m=1
XDAC_BIT0_BIT_INV_MN DAC__BIT0__BITB B0 VGND VGND sky130_fd_pr__nfet_01v8 w=0.65 l=0.15 nf=1 m=1
XDAC_BIT0_BIT_INV_MP DAC__BIT0__BITB B0 VPWR VPWR sky130_fd_pr__pfet_01v8_hvt w=0.65 l=0.15 nf=1 m=1
XDAC_BIT0_CONVERT_N DAC__BOTTOM0 DAC__SAMPLEB DAC__BIT0__REFSEL VGND sky130_fd_pr__nfet_01v8 w=4 l=0.15 nf=1 m=1
XDAC_BIT0_CONVERT_P DAC__BOTTOM0 SAMPLE DAC__BIT0__REFSEL VPWR sky130_fd_pr__pfet_01v8_hvt w=8 l=0.15 nf=1 m=1
XDAC_BIT0_HIGH_N DAC__BIT0__REFSEL B0 VREF VGND sky130_fd_pr__nfet_01v8 w=4 l=0.15 nf=1 m=1
XDAC_BIT0_HIGH_P DAC__BIT0__REFSEL DAC__BIT0__BITB VREF VPWR sky130_fd_pr__pfet_01v8_hvt w=8 l=0.15 nf=1 m=1
XDAC_BIT0_LOW_N DAC__BIT0__REFSEL DAC__BIT0__BITB VGND VGND sky130_fd_pr__nfet_01v8 w=4 l=0.15 nf=1 m=1
XDAC_BIT0_LOW_P DAC__BIT0__REFSEL B0 VGND VPWR sky130_fd_pr__pfet_01v8_hvt w=8 l=0.15 nf=1 m=1
XDAC_BIT1_ACQUIRE_N DAC__BOTTOM1 SAMPLE VIN VGND sky130_fd_pr__nfet_01v8 w=4 l=0.15 nf=1 m=1
XDAC_BIT1_ACQUIRE_P DAC__BOTTOM1 DAC__SAMPLEB VIN VPWR sky130_fd_pr__pfet_01v8_hvt w=8 l=0.15 nf=1 m=1
XDAC_BIT1_BIT_INV_MN DAC__BIT1__BITB B1 VGND VGND sky130_fd_pr__nfet_01v8 w=0.65 l=0.15 nf=1 m=1
XDAC_BIT1_BIT_INV_MP DAC__BIT1__BITB B1 VPWR VPWR sky130_fd_pr__pfet_01v8_hvt w=0.65 l=0.15 nf=1 m=1
XDAC_BIT1_CONVERT_N DAC__BOTTOM1 DAC__SAMPLEB DAC__BIT1__REFSEL VGND sky130_fd_pr__nfet_01v8 w=4 l=0.15 nf=1 m=1
XDAC_BIT1_CONVERT_P DAC__BOTTOM1 SAMPLE DAC__BIT1__REFSEL VPWR sky130_fd_pr__pfet_01v8_hvt w=8 l=0.15 nf=1 m=1
XDAC_BIT1_HIGH_N DAC__BIT1__REFSEL B1 VREF VGND sky130_fd_pr__nfet_01v8 w=4 l=0.15 nf=1 m=1
XDAC_BIT1_HIGH_P DAC__BIT1__REFSEL DAC__BIT1__BITB VREF VPWR sky130_fd_pr__pfet_01v8_hvt w=8 l=0.15 nf=1 m=1
XDAC_BIT1_LOW_N DAC__BIT1__REFSEL DAC__BIT1__BITB VGND VGND sky130_fd_pr__nfet_01v8 w=4 l=0.15 nf=1 m=1
XDAC_BIT1_LOW_P DAC__BIT1__REFSEL B1 VGND VPWR sky130_fd_pr__pfet_01v8_hvt w=8 l=0.15 nf=1 m=1
XDAC_BIT2_ACQUIRE_N DAC__BOTTOM2 SAMPLE VIN VGND sky130_fd_pr__nfet_01v8 w=4 l=0.15 nf=1 m=1
XDAC_BIT2_ACQUIRE_P DAC__BOTTOM2 DAC__SAMPLEB VIN VPWR sky130_fd_pr__pfet_01v8_hvt w=8 l=0.15 nf=1 m=1
XDAC_BIT2_BIT_INV_MN DAC__BIT2__BITB B2 VGND VGND sky130_fd_pr__nfet_01v8 w=0.65 l=0.15 nf=1 m=1
XDAC_BIT2_BIT_INV_MP DAC__BIT2__BITB B2 VPWR VPWR sky130_fd_pr__pfet_01v8_hvt w=0.65 l=0.15 nf=1 m=1
XDAC_BIT2_CONVERT_N DAC__BOTTOM2 DAC__SAMPLEB DAC__BIT2__REFSEL VGND sky130_fd_pr__nfet_01v8 w=4 l=0.15 nf=1 m=1
XDAC_BIT2_CONVERT_P DAC__BOTTOM2 SAMPLE DAC__BIT2__REFSEL VPWR sky130_fd_pr__pfet_01v8_hvt w=8 l=0.15 nf=1 m=1
XDAC_BIT2_HIGH_N DAC__BIT2__REFSEL B2 VREF VGND sky130_fd_pr__nfet_01v8 w=4 l=0.15 nf=1 m=1
XDAC_BIT2_HIGH_P DAC__BIT2__REFSEL DAC__BIT2__BITB VREF VPWR sky130_fd_pr__pfet_01v8_hvt w=8 l=0.15 nf=1 m=1
XDAC_BIT2_LOW_N DAC__BIT2__REFSEL DAC__BIT2__BITB VGND VGND sky130_fd_pr__nfet_01v8 w=4 l=0.15 nf=1 m=1
XDAC_BIT2_LOW_P DAC__BIT2__REFSEL B2 VGND VPWR sky130_fd_pr__pfet_01v8_hvt w=8 l=0.15 nf=1 m=1
XDAC_BIT3_ACQUIRE_N DAC__BOTTOM3 SAMPLE VIN VGND sky130_fd_pr__nfet_01v8 w=4 l=0.15 nf=1 m=1
XDAC_BIT3_ACQUIRE_P DAC__BOTTOM3 DAC__SAMPLEB VIN VPWR sky130_fd_pr__pfet_01v8_hvt w=8 l=0.15 nf=1 m=1
XDAC_BIT3_BIT_INV_MN DAC__BIT3__BITB B3 VGND VGND sky130_fd_pr__nfet_01v8 w=0.65 l=0.15 nf=1 m=1
XDAC_BIT3_BIT_INV_MP DAC__BIT3__BITB B3 VPWR VPWR sky130_fd_pr__pfet_01v8_hvt w=0.65 l=0.15 nf=1 m=1
XDAC_BIT3_CONVERT_N DAC__BOTTOM3 DAC__SAMPLEB DAC__BIT3__REFSEL VGND sky130_fd_pr__nfet_01v8 w=4 l=0.15 nf=1 m=1
XDAC_BIT3_CONVERT_P DAC__BOTTOM3 SAMPLE DAC__BIT3__REFSEL VPWR sky130_fd_pr__pfet_01v8_hvt w=8 l=0.15 nf=1 m=1
XDAC_BIT3_HIGH_N DAC__BIT3__REFSEL B3 VREF VGND sky130_fd_pr__nfet_01v8 w=4 l=0.15 nf=1 m=1
XDAC_BIT3_HIGH_P DAC__BIT3__REFSEL DAC__BIT3__BITB VREF VPWR sky130_fd_pr__pfet_01v8_hvt w=8 l=0.15 nf=1 m=1
XDAC_BIT3_LOW_N DAC__BIT3__REFSEL DAC__BIT3__BITB VGND VGND sky130_fd_pr__nfet_01v8 w=4 l=0.15 nf=1 m=1
XDAC_BIT3_LOW_P DAC__BIT3__REFSEL B3 VGND VPWR sky130_fd_pr__pfet_01v8_hvt w=8 l=0.15 nf=1 m=1
XDAC_BIT4_ACQUIRE_N DAC__BOTTOM4 SAMPLE VIN VGND sky130_fd_pr__nfet_01v8 w=4 l=0.15 nf=1 m=1
XDAC_BIT4_ACQUIRE_P DAC__BOTTOM4 DAC__SAMPLEB VIN VPWR sky130_fd_pr__pfet_01v8_hvt w=8 l=0.15 nf=1 m=1
XDAC_BIT4_BIT_INV_MN DAC__BIT4__BITB B4 VGND VGND sky130_fd_pr__nfet_01v8 w=0.65 l=0.15 nf=1 m=1
XDAC_BIT4_BIT_INV_MP DAC__BIT4__BITB B4 VPWR VPWR sky130_fd_pr__pfet_01v8_hvt w=0.65 l=0.15 nf=1 m=1
XDAC_BIT4_CONVERT_N DAC__BOTTOM4 DAC__SAMPLEB DAC__BIT4__REFSEL VGND sky130_fd_pr__nfet_01v8 w=4 l=0.15 nf=1 m=1
XDAC_BIT4_CONVERT_P DAC__BOTTOM4 SAMPLE DAC__BIT4__REFSEL VPWR sky130_fd_pr__pfet_01v8_hvt w=8 l=0.15 nf=1 m=1
XDAC_BIT4_HIGH_N DAC__BIT4__REFSEL B4 VREF VGND sky130_fd_pr__nfet_01v8 w=4 l=0.15 nf=1 m=1
XDAC_BIT4_HIGH_P DAC__BIT4__REFSEL DAC__BIT4__BITB VREF VPWR sky130_fd_pr__pfet_01v8_hvt w=8 l=0.15 nf=1 m=1
XDAC_BIT4_LOW_N DAC__BIT4__REFSEL DAC__BIT4__BITB VGND VGND sky130_fd_pr__nfet_01v8 w=4 l=0.15 nf=1 m=1
XDAC_BIT4_LOW_P DAC__BIT4__REFSEL B4 VGND VPWR sky130_fd_pr__pfet_01v8_hvt w=8 l=0.15 nf=1 m=1
XDAC_BIT5_ACQUIRE_N DAC__BOTTOM5 SAMPLE VIN VGND sky130_fd_pr__nfet_01v8 w=4 l=0.15 nf=1 m=1
XDAC_BIT5_ACQUIRE_P DAC__BOTTOM5 DAC__SAMPLEB VIN VPWR sky130_fd_pr__pfet_01v8_hvt w=8 l=0.15 nf=1 m=1
XDAC_BIT5_BIT_INV_MN DAC__BIT5__BITB B5 VGND VGND sky130_fd_pr__nfet_01v8 w=0.65 l=0.15 nf=1 m=1
XDAC_BIT5_BIT_INV_MP DAC__BIT5__BITB B5 VPWR VPWR sky130_fd_pr__pfet_01v8_hvt w=0.65 l=0.15 nf=1 m=1
XDAC_BIT5_CONVERT_N DAC__BOTTOM5 DAC__SAMPLEB DAC__BIT5__REFSEL VGND sky130_fd_pr__nfet_01v8 w=4 l=0.15 nf=1 m=1
XDAC_BIT5_CONVERT_P DAC__BOTTOM5 SAMPLE DAC__BIT5__REFSEL VPWR sky130_fd_pr__pfet_01v8_hvt w=8 l=0.15 nf=1 m=1
XDAC_BIT5_HIGH_N DAC__BIT5__REFSEL B5 VREF VGND sky130_fd_pr__nfet_01v8 w=4 l=0.15 nf=1 m=1
XDAC_BIT5_HIGH_P DAC__BIT5__REFSEL DAC__BIT5__BITB VREF VPWR sky130_fd_pr__pfet_01v8_hvt w=8 l=0.15 nf=1 m=1
XDAC_BIT5_LOW_N DAC__BIT5__REFSEL DAC__BIT5__BITB VGND VGND sky130_fd_pr__nfet_01v8 w=4 l=0.15 nf=1 m=1
XDAC_BIT5_LOW_P DAC__BIT5__REFSEL B5 VGND VPWR sky130_fd_pr__pfet_01v8_hvt w=8 l=0.15 nf=1 m=1
XDAC_BIT6_ACQUIRE_N DAC__BOTTOM6 SAMPLE VIN VGND sky130_fd_pr__nfet_01v8 w=4 l=0.15 nf=1 m=1
XDAC_BIT6_ACQUIRE_P DAC__BOTTOM6 DAC__SAMPLEB VIN VPWR sky130_fd_pr__pfet_01v8_hvt w=8 l=0.15 nf=1 m=1
XDAC_BIT6_BIT_INV_MN DAC__BIT6__BITB B6 VGND VGND sky130_fd_pr__nfet_01v8 w=0.65 l=0.15 nf=1 m=1
XDAC_BIT6_BIT_INV_MP DAC__BIT6__BITB B6 VPWR VPWR sky130_fd_pr__pfet_01v8_hvt w=0.65 l=0.15 nf=1 m=1
XDAC_BIT6_CONVERT_N DAC__BOTTOM6 DAC__SAMPLEB DAC__BIT6__REFSEL VGND sky130_fd_pr__nfet_01v8 w=4 l=0.15 nf=1 m=1
XDAC_BIT6_CONVERT_P DAC__BOTTOM6 SAMPLE DAC__BIT6__REFSEL VPWR sky130_fd_pr__pfet_01v8_hvt w=8 l=0.15 nf=1 m=1
XDAC_BIT6_HIGH_N DAC__BIT6__REFSEL B6 VREF VGND sky130_fd_pr__nfet_01v8 w=4 l=0.15 nf=1 m=1
XDAC_BIT6_HIGH_P DAC__BIT6__REFSEL DAC__BIT6__BITB VREF VPWR sky130_fd_pr__pfet_01v8_hvt w=8 l=0.15 nf=1 m=1
XDAC_BIT6_LOW_N DAC__BIT6__REFSEL DAC__BIT6__BITB VGND VGND sky130_fd_pr__nfet_01v8 w=4 l=0.15 nf=1 m=1
XDAC_BIT6_LOW_P DAC__BIT6__REFSEL B6 VGND VPWR sky130_fd_pr__pfet_01v8_hvt w=8 l=0.15 nf=1 m=1
XDAC_BIT7_ACQUIRE_N DAC__BOTTOM7 SAMPLE VIN VGND sky130_fd_pr__nfet_01v8 w=4 l=0.15 nf=1 m=1
XDAC_BIT7_ACQUIRE_P DAC__BOTTOM7 DAC__SAMPLEB VIN VPWR sky130_fd_pr__pfet_01v8_hvt w=8 l=0.15 nf=1 m=1
XDAC_BIT7_BIT_INV_MN DAC__BIT7__BITB B7 VGND VGND sky130_fd_pr__nfet_01v8 w=0.65 l=0.15 nf=1 m=1
XDAC_BIT7_BIT_INV_MP DAC__BIT7__BITB B7 VPWR VPWR sky130_fd_pr__pfet_01v8_hvt w=0.65 l=0.15 nf=1 m=1
XDAC_BIT7_CONVERT_N DAC__BOTTOM7 DAC__SAMPLEB DAC__BIT7__REFSEL VGND sky130_fd_pr__nfet_01v8 w=4 l=0.15 nf=1 m=1
XDAC_BIT7_CONVERT_P DAC__BOTTOM7 SAMPLE DAC__BIT7__REFSEL VPWR sky130_fd_pr__pfet_01v8_hvt w=8 l=0.15 nf=1 m=1
XDAC_BIT7_HIGH_N DAC__BIT7__REFSEL B7 VREF VGND sky130_fd_pr__nfet_01v8 w=4 l=0.15 nf=1 m=1
XDAC_BIT7_HIGH_P DAC__BIT7__REFSEL DAC__BIT7__BITB VREF VPWR sky130_fd_pr__pfet_01v8_hvt w=8 l=0.15 nf=1 m=1
XDAC_BIT7_LOW_N DAC__BIT7__REFSEL DAC__BIT7__BITB VGND VGND sky130_fd_pr__nfet_01v8 w=4 l=0.15 nf=1 m=1
XDAC_BIT7_LOW_P DAC__BIT7__REFSEL B7 VGND VPWR sky130_fd_pr__pfet_01v8_hvt w=8 l=0.15 nf=1 m=1
XDAC_C0_0_C_UNIT_P0 TOP DAC__BOTTOM0 sky130_fd_pr__cap_mim_m3_1 w=13.955 l=13.955
XDAC_C1_0_C_UNIT_P0 TOP DAC__BOTTOM1 sky130_fd_pr__cap_mim_m3_1 w=13.955 l=13.955
XDAC_C1_1_C_UNIT_P0 TOP DAC__BOTTOM1 sky130_fd_pr__cap_mim_m3_1 w=13.955 l=13.955
XDAC_C2_0_C_UNIT_P0 TOP DAC__BOTTOM2 sky130_fd_pr__cap_mim_m3_1 w=13.955 l=13.955
XDAC_C2_1_C_UNIT_P0 TOP DAC__BOTTOM2 sky130_fd_pr__cap_mim_m3_1 w=13.955 l=13.955
XDAC_C2_2_C_UNIT_P0 TOP DAC__BOTTOM2 sky130_fd_pr__cap_mim_m3_1 w=13.955 l=13.955
XDAC_C2_3_C_UNIT_P0 TOP DAC__BOTTOM2 sky130_fd_pr__cap_mim_m3_1 w=13.955 l=13.955
XDAC_C3_0_C_UNIT_P0 TOP DAC__BOTTOM3 sky130_fd_pr__cap_mim_m3_1 w=13.955 l=13.955
XDAC_C3_1_C_UNIT_P0 TOP DAC__BOTTOM3 sky130_fd_pr__cap_mim_m3_1 w=13.955 l=13.955
XDAC_C3_2_C_UNIT_P0 TOP DAC__BOTTOM3 sky130_fd_pr__cap_mim_m3_1 w=13.955 l=13.955
XDAC_C3_3_C_UNIT_P0 TOP DAC__BOTTOM3 sky130_fd_pr__cap_mim_m3_1 w=13.955 l=13.955
XDAC_C3_4_C_UNIT_P0 TOP DAC__BOTTOM3 sky130_fd_pr__cap_mim_m3_1 w=13.955 l=13.955
XDAC_C3_5_C_UNIT_P0 TOP DAC__BOTTOM3 sky130_fd_pr__cap_mim_m3_1 w=13.955 l=13.955
XDAC_C3_6_C_UNIT_P0 TOP DAC__BOTTOM3 sky130_fd_pr__cap_mim_m3_1 w=13.955 l=13.955
XDAC_C3_7_C_UNIT_P0 TOP DAC__BOTTOM3 sky130_fd_pr__cap_mim_m3_1 w=13.955 l=13.955
XDAC_C4_0_C_UNIT_P0 TOP DAC__BOTTOM4 sky130_fd_pr__cap_mim_m3_1 w=13.955 l=13.955
XDAC_C4_1_C_UNIT_P0 TOP DAC__BOTTOM4 sky130_fd_pr__cap_mim_m3_1 w=13.955 l=13.955
XDAC_C4_10_C_UNIT_P0 TOP DAC__BOTTOM4 sky130_fd_pr__cap_mim_m3_1 w=13.955 l=13.955
XDAC_C4_11_C_UNIT_P0 TOP DAC__BOTTOM4 sky130_fd_pr__cap_mim_m3_1 w=13.955 l=13.955
XDAC_C4_12_C_UNIT_P0 TOP DAC__BOTTOM4 sky130_fd_pr__cap_mim_m3_1 w=13.955 l=13.955
XDAC_C4_13_C_UNIT_P0 TOP DAC__BOTTOM4 sky130_fd_pr__cap_mim_m3_1 w=13.955 l=13.955
XDAC_C4_14_C_UNIT_P0 TOP DAC__BOTTOM4 sky130_fd_pr__cap_mim_m3_1 w=13.955 l=13.955
XDAC_C4_15_C_UNIT_P0 TOP DAC__BOTTOM4 sky130_fd_pr__cap_mim_m3_1 w=13.955 l=13.955
XDAC_C4_2_C_UNIT_P0 TOP DAC__BOTTOM4 sky130_fd_pr__cap_mim_m3_1 w=13.955 l=13.955
XDAC_C4_3_C_UNIT_P0 TOP DAC__BOTTOM4 sky130_fd_pr__cap_mim_m3_1 w=13.955 l=13.955
XDAC_C4_4_C_UNIT_P0 TOP DAC__BOTTOM4 sky130_fd_pr__cap_mim_m3_1 w=13.955 l=13.955
XDAC_C4_5_C_UNIT_P0 TOP DAC__BOTTOM4 sky130_fd_pr__cap_mim_m3_1 w=13.955 l=13.955
XDAC_C4_6_C_UNIT_P0 TOP DAC__BOTTOM4 sky130_fd_pr__cap_mim_m3_1 w=13.955 l=13.955
XDAC_C4_7_C_UNIT_P0 TOP DAC__BOTTOM4 sky130_fd_pr__cap_mim_m3_1 w=13.955 l=13.955
XDAC_C4_8_C_UNIT_P0 TOP DAC__BOTTOM4 sky130_fd_pr__cap_mim_m3_1 w=13.955 l=13.955
XDAC_C4_9_C_UNIT_P0 TOP DAC__BOTTOM4 sky130_fd_pr__cap_mim_m3_1 w=13.955 l=13.955
XDAC_C5_0_C_UNIT_P0 TOP DAC__BOTTOM5 sky130_fd_pr__cap_mim_m3_1 w=13.955 l=13.955
XDAC_C5_1_C_UNIT_P0 TOP DAC__BOTTOM5 sky130_fd_pr__cap_mim_m3_1 w=13.955 l=13.955
XDAC_C5_10_C_UNIT_P0 TOP DAC__BOTTOM5 sky130_fd_pr__cap_mim_m3_1 w=13.955 l=13.955
XDAC_C5_11_C_UNIT_P0 TOP DAC__BOTTOM5 sky130_fd_pr__cap_mim_m3_1 w=13.955 l=13.955
XDAC_C5_12_C_UNIT_P0 TOP DAC__BOTTOM5 sky130_fd_pr__cap_mim_m3_1 w=13.955 l=13.955
XDAC_C5_13_C_UNIT_P0 TOP DAC__BOTTOM5 sky130_fd_pr__cap_mim_m3_1 w=13.955 l=13.955
XDAC_C5_14_C_UNIT_P0 TOP DAC__BOTTOM5 sky130_fd_pr__cap_mim_m3_1 w=13.955 l=13.955
XDAC_C5_15_C_UNIT_P0 TOP DAC__BOTTOM5 sky130_fd_pr__cap_mim_m3_1 w=13.955 l=13.955
XDAC_C5_16_C_UNIT_P0 TOP DAC__BOTTOM5 sky130_fd_pr__cap_mim_m3_1 w=13.955 l=13.955
XDAC_C5_17_C_UNIT_P0 TOP DAC__BOTTOM5 sky130_fd_pr__cap_mim_m3_1 w=13.955 l=13.955
XDAC_C5_18_C_UNIT_P0 TOP DAC__BOTTOM5 sky130_fd_pr__cap_mim_m3_1 w=13.955 l=13.955
XDAC_C5_19_C_UNIT_P0 TOP DAC__BOTTOM5 sky130_fd_pr__cap_mim_m3_1 w=13.955 l=13.955
XDAC_C5_2_C_UNIT_P0 TOP DAC__BOTTOM5 sky130_fd_pr__cap_mim_m3_1 w=13.955 l=13.955
XDAC_C5_20_C_UNIT_P0 TOP DAC__BOTTOM5 sky130_fd_pr__cap_mim_m3_1 w=13.955 l=13.955
XDAC_C5_21_C_UNIT_P0 TOP DAC__BOTTOM5 sky130_fd_pr__cap_mim_m3_1 w=13.955 l=13.955
XDAC_C5_22_C_UNIT_P0 TOP DAC__BOTTOM5 sky130_fd_pr__cap_mim_m3_1 w=13.955 l=13.955
XDAC_C5_23_C_UNIT_P0 TOP DAC__BOTTOM5 sky130_fd_pr__cap_mim_m3_1 w=13.955 l=13.955
XDAC_C5_24_C_UNIT_P0 TOP DAC__BOTTOM5 sky130_fd_pr__cap_mim_m3_1 w=13.955 l=13.955
XDAC_C5_25_C_UNIT_P0 TOP DAC__BOTTOM5 sky130_fd_pr__cap_mim_m3_1 w=13.955 l=13.955
XDAC_C5_26_C_UNIT_P0 TOP DAC__BOTTOM5 sky130_fd_pr__cap_mim_m3_1 w=13.955 l=13.955
XDAC_C5_27_C_UNIT_P0 TOP DAC__BOTTOM5 sky130_fd_pr__cap_mim_m3_1 w=13.955 l=13.955
XDAC_C5_28_C_UNIT_P0 TOP DAC__BOTTOM5 sky130_fd_pr__cap_mim_m3_1 w=13.955 l=13.955
XDAC_C5_29_C_UNIT_P0 TOP DAC__BOTTOM5 sky130_fd_pr__cap_mim_m3_1 w=13.955 l=13.955
XDAC_C5_3_C_UNIT_P0 TOP DAC__BOTTOM5 sky130_fd_pr__cap_mim_m3_1 w=13.955 l=13.955
XDAC_C5_30_C_UNIT_P0 TOP DAC__BOTTOM5 sky130_fd_pr__cap_mim_m3_1 w=13.955 l=13.955
XDAC_C5_31_C_UNIT_P0 TOP DAC__BOTTOM5 sky130_fd_pr__cap_mim_m3_1 w=13.955 l=13.955
XDAC_C5_4_C_UNIT_P0 TOP DAC__BOTTOM5 sky130_fd_pr__cap_mim_m3_1 w=13.955 l=13.955
XDAC_C5_5_C_UNIT_P0 TOP DAC__BOTTOM5 sky130_fd_pr__cap_mim_m3_1 w=13.955 l=13.955
XDAC_C5_6_C_UNIT_P0 TOP DAC__BOTTOM5 sky130_fd_pr__cap_mim_m3_1 w=13.955 l=13.955
XDAC_C5_7_C_UNIT_P0 TOP DAC__BOTTOM5 sky130_fd_pr__cap_mim_m3_1 w=13.955 l=13.955
XDAC_C5_8_C_UNIT_P0 TOP DAC__BOTTOM5 sky130_fd_pr__cap_mim_m3_1 w=13.955 l=13.955
XDAC_C5_9_C_UNIT_P0 TOP DAC__BOTTOM5 sky130_fd_pr__cap_mim_m3_1 w=13.955 l=13.955
XDAC_C6_0_C_UNIT_P0 TOP DAC__BOTTOM6 sky130_fd_pr__cap_mim_m3_1 w=13.955 l=13.955
XDAC_C6_1_C_UNIT_P0 TOP DAC__BOTTOM6 sky130_fd_pr__cap_mim_m3_1 w=13.955 l=13.955
XDAC_C6_10_C_UNIT_P0 TOP DAC__BOTTOM6 sky130_fd_pr__cap_mim_m3_1 w=13.955 l=13.955
XDAC_C6_11_C_UNIT_P0 TOP DAC__BOTTOM6 sky130_fd_pr__cap_mim_m3_1 w=13.955 l=13.955
XDAC_C6_12_C_UNIT_P0 TOP DAC__BOTTOM6 sky130_fd_pr__cap_mim_m3_1 w=13.955 l=13.955
XDAC_C6_13_C_UNIT_P0 TOP DAC__BOTTOM6 sky130_fd_pr__cap_mim_m3_1 w=13.955 l=13.955
XDAC_C6_14_C_UNIT_P0 TOP DAC__BOTTOM6 sky130_fd_pr__cap_mim_m3_1 w=13.955 l=13.955
XDAC_C6_15_C_UNIT_P0 TOP DAC__BOTTOM6 sky130_fd_pr__cap_mim_m3_1 w=13.955 l=13.955
XDAC_C6_16_C_UNIT_P0 TOP DAC__BOTTOM6 sky130_fd_pr__cap_mim_m3_1 w=13.955 l=13.955
XDAC_C6_17_C_UNIT_P0 TOP DAC__BOTTOM6 sky130_fd_pr__cap_mim_m3_1 w=13.955 l=13.955
XDAC_C6_18_C_UNIT_P0 TOP DAC__BOTTOM6 sky130_fd_pr__cap_mim_m3_1 w=13.955 l=13.955
XDAC_C6_19_C_UNIT_P0 TOP DAC__BOTTOM6 sky130_fd_pr__cap_mim_m3_1 w=13.955 l=13.955
XDAC_C6_2_C_UNIT_P0 TOP DAC__BOTTOM6 sky130_fd_pr__cap_mim_m3_1 w=13.955 l=13.955
XDAC_C6_20_C_UNIT_P0 TOP DAC__BOTTOM6 sky130_fd_pr__cap_mim_m3_1 w=13.955 l=13.955
XDAC_C6_21_C_UNIT_P0 TOP DAC__BOTTOM6 sky130_fd_pr__cap_mim_m3_1 w=13.955 l=13.955
XDAC_C6_22_C_UNIT_P0 TOP DAC__BOTTOM6 sky130_fd_pr__cap_mim_m3_1 w=13.955 l=13.955
XDAC_C6_23_C_UNIT_P0 TOP DAC__BOTTOM6 sky130_fd_pr__cap_mim_m3_1 w=13.955 l=13.955
XDAC_C6_24_C_UNIT_P0 TOP DAC__BOTTOM6 sky130_fd_pr__cap_mim_m3_1 w=13.955 l=13.955
XDAC_C6_25_C_UNIT_P0 TOP DAC__BOTTOM6 sky130_fd_pr__cap_mim_m3_1 w=13.955 l=13.955
XDAC_C6_26_C_UNIT_P0 TOP DAC__BOTTOM6 sky130_fd_pr__cap_mim_m3_1 w=13.955 l=13.955
XDAC_C6_27_C_UNIT_P0 TOP DAC__BOTTOM6 sky130_fd_pr__cap_mim_m3_1 w=13.955 l=13.955
XDAC_C6_28_C_UNIT_P0 TOP DAC__BOTTOM6 sky130_fd_pr__cap_mim_m3_1 w=13.955 l=13.955
XDAC_C6_29_C_UNIT_P0 TOP DAC__BOTTOM6 sky130_fd_pr__cap_mim_m3_1 w=13.955 l=13.955
XDAC_C6_3_C_UNIT_P0 TOP DAC__BOTTOM6 sky130_fd_pr__cap_mim_m3_1 w=13.955 l=13.955
XDAC_C6_30_C_UNIT_P0 TOP DAC__BOTTOM6 sky130_fd_pr__cap_mim_m3_1 w=13.955 l=13.955
XDAC_C6_31_C_UNIT_P0 TOP DAC__BOTTOM6 sky130_fd_pr__cap_mim_m3_1 w=13.955 l=13.955
XDAC_C6_32_C_UNIT_P0 TOP DAC__BOTTOM6 sky130_fd_pr__cap_mim_m3_1 w=13.955 l=13.955
XDAC_C6_33_C_UNIT_P0 TOP DAC__BOTTOM6 sky130_fd_pr__cap_mim_m3_1 w=13.955 l=13.955
XDAC_C6_34_C_UNIT_P0 TOP DAC__BOTTOM6 sky130_fd_pr__cap_mim_m3_1 w=13.955 l=13.955
XDAC_C6_35_C_UNIT_P0 TOP DAC__BOTTOM6 sky130_fd_pr__cap_mim_m3_1 w=13.955 l=13.955
XDAC_C6_36_C_UNIT_P0 TOP DAC__BOTTOM6 sky130_fd_pr__cap_mim_m3_1 w=13.955 l=13.955
XDAC_C6_37_C_UNIT_P0 TOP DAC__BOTTOM6 sky130_fd_pr__cap_mim_m3_1 w=13.955 l=13.955
XDAC_C6_38_C_UNIT_P0 TOP DAC__BOTTOM6 sky130_fd_pr__cap_mim_m3_1 w=13.955 l=13.955
XDAC_C6_39_C_UNIT_P0 TOP DAC__BOTTOM6 sky130_fd_pr__cap_mim_m3_1 w=13.955 l=13.955
XDAC_C6_4_C_UNIT_P0 TOP DAC__BOTTOM6 sky130_fd_pr__cap_mim_m3_1 w=13.955 l=13.955
XDAC_C6_40_C_UNIT_P0 TOP DAC__BOTTOM6 sky130_fd_pr__cap_mim_m3_1 w=13.955 l=13.955
XDAC_C6_41_C_UNIT_P0 TOP DAC__BOTTOM6 sky130_fd_pr__cap_mim_m3_1 w=13.955 l=13.955
XDAC_C6_42_C_UNIT_P0 TOP DAC__BOTTOM6 sky130_fd_pr__cap_mim_m3_1 w=13.955 l=13.955
XDAC_C6_43_C_UNIT_P0 TOP DAC__BOTTOM6 sky130_fd_pr__cap_mim_m3_1 w=13.955 l=13.955
XDAC_C6_44_C_UNIT_P0 TOP DAC__BOTTOM6 sky130_fd_pr__cap_mim_m3_1 w=13.955 l=13.955
XDAC_C6_45_C_UNIT_P0 TOP DAC__BOTTOM6 sky130_fd_pr__cap_mim_m3_1 w=13.955 l=13.955
XDAC_C6_46_C_UNIT_P0 TOP DAC__BOTTOM6 sky130_fd_pr__cap_mim_m3_1 w=13.955 l=13.955
XDAC_C6_47_C_UNIT_P0 TOP DAC__BOTTOM6 sky130_fd_pr__cap_mim_m3_1 w=13.955 l=13.955
XDAC_C6_48_C_UNIT_P0 TOP DAC__BOTTOM6 sky130_fd_pr__cap_mim_m3_1 w=13.955 l=13.955
XDAC_C6_49_C_UNIT_P0 TOP DAC__BOTTOM6 sky130_fd_pr__cap_mim_m3_1 w=13.955 l=13.955
XDAC_C6_5_C_UNIT_P0 TOP DAC__BOTTOM6 sky130_fd_pr__cap_mim_m3_1 w=13.955 l=13.955
XDAC_C6_50_C_UNIT_P0 TOP DAC__BOTTOM6 sky130_fd_pr__cap_mim_m3_1 w=13.955 l=13.955
XDAC_C6_51_C_UNIT_P0 TOP DAC__BOTTOM6 sky130_fd_pr__cap_mim_m3_1 w=13.955 l=13.955
XDAC_C6_52_C_UNIT_P0 TOP DAC__BOTTOM6 sky130_fd_pr__cap_mim_m3_1 w=13.955 l=13.955
XDAC_C6_53_C_UNIT_P0 TOP DAC__BOTTOM6 sky130_fd_pr__cap_mim_m3_1 w=13.955 l=13.955
XDAC_C6_54_C_UNIT_P0 TOP DAC__BOTTOM6 sky130_fd_pr__cap_mim_m3_1 w=13.955 l=13.955
XDAC_C6_55_C_UNIT_P0 TOP DAC__BOTTOM6 sky130_fd_pr__cap_mim_m3_1 w=13.955 l=13.955
XDAC_C6_56_C_UNIT_P0 TOP DAC__BOTTOM6 sky130_fd_pr__cap_mim_m3_1 w=13.955 l=13.955
XDAC_C6_57_C_UNIT_P0 TOP DAC__BOTTOM6 sky130_fd_pr__cap_mim_m3_1 w=13.955 l=13.955
XDAC_C6_58_C_UNIT_P0 TOP DAC__BOTTOM6 sky130_fd_pr__cap_mim_m3_1 w=13.955 l=13.955
XDAC_C6_59_C_UNIT_P0 TOP DAC__BOTTOM6 sky130_fd_pr__cap_mim_m3_1 w=13.955 l=13.955
XDAC_C6_6_C_UNIT_P0 TOP DAC__BOTTOM6 sky130_fd_pr__cap_mim_m3_1 w=13.955 l=13.955
XDAC_C6_60_C_UNIT_P0 TOP DAC__BOTTOM6 sky130_fd_pr__cap_mim_m3_1 w=13.955 l=13.955
XDAC_C6_61_C_UNIT_P0 TOP DAC__BOTTOM6 sky130_fd_pr__cap_mim_m3_1 w=13.955 l=13.955
XDAC_C6_62_C_UNIT_P0 TOP DAC__BOTTOM6 sky130_fd_pr__cap_mim_m3_1 w=13.955 l=13.955
XDAC_C6_63_C_UNIT_P0 TOP DAC__BOTTOM6 sky130_fd_pr__cap_mim_m3_1 w=13.955 l=13.955
XDAC_C6_7_C_UNIT_P0 TOP DAC__BOTTOM6 sky130_fd_pr__cap_mim_m3_1 w=13.955 l=13.955
XDAC_C6_8_C_UNIT_P0 TOP DAC__BOTTOM6 sky130_fd_pr__cap_mim_m3_1 w=13.955 l=13.955
XDAC_C6_9_C_UNIT_P0 TOP DAC__BOTTOM6 sky130_fd_pr__cap_mim_m3_1 w=13.955 l=13.955
XDAC_C7_0_C_UNIT_P0 TOP DAC__BOTTOM7 sky130_fd_pr__cap_mim_m3_1 w=13.955 l=13.955
XDAC_C7_1_C_UNIT_P0 TOP DAC__BOTTOM7 sky130_fd_pr__cap_mim_m3_1 w=13.955 l=13.955
XDAC_C7_10_C_UNIT_P0 TOP DAC__BOTTOM7 sky130_fd_pr__cap_mim_m3_1 w=13.955 l=13.955
XDAC_C7_100_C_UNIT_P0 TOP DAC__BOTTOM7 sky130_fd_pr__cap_mim_m3_1 w=13.955 l=13.955
XDAC_C7_101_C_UNIT_P0 TOP DAC__BOTTOM7 sky130_fd_pr__cap_mim_m3_1 w=13.955 l=13.955
XDAC_C7_102_C_UNIT_P0 TOP DAC__BOTTOM7 sky130_fd_pr__cap_mim_m3_1 w=13.955 l=13.955
XDAC_C7_103_C_UNIT_P0 TOP DAC__BOTTOM7 sky130_fd_pr__cap_mim_m3_1 w=13.955 l=13.955
XDAC_C7_104_C_UNIT_P0 TOP DAC__BOTTOM7 sky130_fd_pr__cap_mim_m3_1 w=13.955 l=13.955
XDAC_C7_105_C_UNIT_P0 TOP DAC__BOTTOM7 sky130_fd_pr__cap_mim_m3_1 w=13.955 l=13.955
XDAC_C7_106_C_UNIT_P0 TOP DAC__BOTTOM7 sky130_fd_pr__cap_mim_m3_1 w=13.955 l=13.955
XDAC_C7_107_C_UNIT_P0 TOP DAC__BOTTOM7 sky130_fd_pr__cap_mim_m3_1 w=13.955 l=13.955
XDAC_C7_108_C_UNIT_P0 TOP DAC__BOTTOM7 sky130_fd_pr__cap_mim_m3_1 w=13.955 l=13.955
XDAC_C7_109_C_UNIT_P0 TOP DAC__BOTTOM7 sky130_fd_pr__cap_mim_m3_1 w=13.955 l=13.955
XDAC_C7_11_C_UNIT_P0 TOP DAC__BOTTOM7 sky130_fd_pr__cap_mim_m3_1 w=13.955 l=13.955
XDAC_C7_110_C_UNIT_P0 TOP DAC__BOTTOM7 sky130_fd_pr__cap_mim_m3_1 w=13.955 l=13.955
XDAC_C7_111_C_UNIT_P0 TOP DAC__BOTTOM7 sky130_fd_pr__cap_mim_m3_1 w=13.955 l=13.955
XDAC_C7_112_C_UNIT_P0 TOP DAC__BOTTOM7 sky130_fd_pr__cap_mim_m3_1 w=13.955 l=13.955
XDAC_C7_113_C_UNIT_P0 TOP DAC__BOTTOM7 sky130_fd_pr__cap_mim_m3_1 w=13.955 l=13.955
XDAC_C7_114_C_UNIT_P0 TOP DAC__BOTTOM7 sky130_fd_pr__cap_mim_m3_1 w=13.955 l=13.955
XDAC_C7_115_C_UNIT_P0 TOP DAC__BOTTOM7 sky130_fd_pr__cap_mim_m3_1 w=13.955 l=13.955
XDAC_C7_116_C_UNIT_P0 TOP DAC__BOTTOM7 sky130_fd_pr__cap_mim_m3_1 w=13.955 l=13.955
XDAC_C7_117_C_UNIT_P0 TOP DAC__BOTTOM7 sky130_fd_pr__cap_mim_m3_1 w=13.955 l=13.955
XDAC_C7_118_C_UNIT_P0 TOP DAC__BOTTOM7 sky130_fd_pr__cap_mim_m3_1 w=13.955 l=13.955
XDAC_C7_119_C_UNIT_P0 TOP DAC__BOTTOM7 sky130_fd_pr__cap_mim_m3_1 w=13.955 l=13.955
XDAC_C7_12_C_UNIT_P0 TOP DAC__BOTTOM7 sky130_fd_pr__cap_mim_m3_1 w=13.955 l=13.955
XDAC_C7_120_C_UNIT_P0 TOP DAC__BOTTOM7 sky130_fd_pr__cap_mim_m3_1 w=13.955 l=13.955
XDAC_C7_121_C_UNIT_P0 TOP DAC__BOTTOM7 sky130_fd_pr__cap_mim_m3_1 w=13.955 l=13.955
XDAC_C7_122_C_UNIT_P0 TOP DAC__BOTTOM7 sky130_fd_pr__cap_mim_m3_1 w=13.955 l=13.955
XDAC_C7_123_C_UNIT_P0 TOP DAC__BOTTOM7 sky130_fd_pr__cap_mim_m3_1 w=13.955 l=13.955
XDAC_C7_124_C_UNIT_P0 TOP DAC__BOTTOM7 sky130_fd_pr__cap_mim_m3_1 w=13.955 l=13.955
XDAC_C7_125_C_UNIT_P0 TOP DAC__BOTTOM7 sky130_fd_pr__cap_mim_m3_1 w=13.955 l=13.955
XDAC_C7_126_C_UNIT_P0 TOP DAC__BOTTOM7 sky130_fd_pr__cap_mim_m3_1 w=13.955 l=13.955
XDAC_C7_127_C_UNIT_P0 TOP DAC__BOTTOM7 sky130_fd_pr__cap_mim_m3_1 w=13.955 l=13.955
XDAC_C7_13_C_UNIT_P0 TOP DAC__BOTTOM7 sky130_fd_pr__cap_mim_m3_1 w=13.955 l=13.955
XDAC_C7_14_C_UNIT_P0 TOP DAC__BOTTOM7 sky130_fd_pr__cap_mim_m3_1 w=13.955 l=13.955
XDAC_C7_15_C_UNIT_P0 TOP DAC__BOTTOM7 sky130_fd_pr__cap_mim_m3_1 w=13.955 l=13.955
XDAC_C7_16_C_UNIT_P0 TOP DAC__BOTTOM7 sky130_fd_pr__cap_mim_m3_1 w=13.955 l=13.955
XDAC_C7_17_C_UNIT_P0 TOP DAC__BOTTOM7 sky130_fd_pr__cap_mim_m3_1 w=13.955 l=13.955
XDAC_C7_18_C_UNIT_P0 TOP DAC__BOTTOM7 sky130_fd_pr__cap_mim_m3_1 w=13.955 l=13.955
XDAC_C7_19_C_UNIT_P0 TOP DAC__BOTTOM7 sky130_fd_pr__cap_mim_m3_1 w=13.955 l=13.955
XDAC_C7_2_C_UNIT_P0 TOP DAC__BOTTOM7 sky130_fd_pr__cap_mim_m3_1 w=13.955 l=13.955
XDAC_C7_20_C_UNIT_P0 TOP DAC__BOTTOM7 sky130_fd_pr__cap_mim_m3_1 w=13.955 l=13.955
XDAC_C7_21_C_UNIT_P0 TOP DAC__BOTTOM7 sky130_fd_pr__cap_mim_m3_1 w=13.955 l=13.955
XDAC_C7_22_C_UNIT_P0 TOP DAC__BOTTOM7 sky130_fd_pr__cap_mim_m3_1 w=13.955 l=13.955
XDAC_C7_23_C_UNIT_P0 TOP DAC__BOTTOM7 sky130_fd_pr__cap_mim_m3_1 w=13.955 l=13.955
XDAC_C7_24_C_UNIT_P0 TOP DAC__BOTTOM7 sky130_fd_pr__cap_mim_m3_1 w=13.955 l=13.955
XDAC_C7_25_C_UNIT_P0 TOP DAC__BOTTOM7 sky130_fd_pr__cap_mim_m3_1 w=13.955 l=13.955
XDAC_C7_26_C_UNIT_P0 TOP DAC__BOTTOM7 sky130_fd_pr__cap_mim_m3_1 w=13.955 l=13.955
XDAC_C7_27_C_UNIT_P0 TOP DAC__BOTTOM7 sky130_fd_pr__cap_mim_m3_1 w=13.955 l=13.955
XDAC_C7_28_C_UNIT_P0 TOP DAC__BOTTOM7 sky130_fd_pr__cap_mim_m3_1 w=13.955 l=13.955
XDAC_C7_29_C_UNIT_P0 TOP DAC__BOTTOM7 sky130_fd_pr__cap_mim_m3_1 w=13.955 l=13.955
XDAC_C7_3_C_UNIT_P0 TOP DAC__BOTTOM7 sky130_fd_pr__cap_mim_m3_1 w=13.955 l=13.955
XDAC_C7_30_C_UNIT_P0 TOP DAC__BOTTOM7 sky130_fd_pr__cap_mim_m3_1 w=13.955 l=13.955
XDAC_C7_31_C_UNIT_P0 TOP DAC__BOTTOM7 sky130_fd_pr__cap_mim_m3_1 w=13.955 l=13.955
XDAC_C7_32_C_UNIT_P0 TOP DAC__BOTTOM7 sky130_fd_pr__cap_mim_m3_1 w=13.955 l=13.955
XDAC_C7_33_C_UNIT_P0 TOP DAC__BOTTOM7 sky130_fd_pr__cap_mim_m3_1 w=13.955 l=13.955
XDAC_C7_34_C_UNIT_P0 TOP DAC__BOTTOM7 sky130_fd_pr__cap_mim_m3_1 w=13.955 l=13.955
XDAC_C7_35_C_UNIT_P0 TOP DAC__BOTTOM7 sky130_fd_pr__cap_mim_m3_1 w=13.955 l=13.955
XDAC_C7_36_C_UNIT_P0 TOP DAC__BOTTOM7 sky130_fd_pr__cap_mim_m3_1 w=13.955 l=13.955
XDAC_C7_37_C_UNIT_P0 TOP DAC__BOTTOM7 sky130_fd_pr__cap_mim_m3_1 w=13.955 l=13.955
XDAC_C7_38_C_UNIT_P0 TOP DAC__BOTTOM7 sky130_fd_pr__cap_mim_m3_1 w=13.955 l=13.955
XDAC_C7_39_C_UNIT_P0 TOP DAC__BOTTOM7 sky130_fd_pr__cap_mim_m3_1 w=13.955 l=13.955
XDAC_C7_4_C_UNIT_P0 TOP DAC__BOTTOM7 sky130_fd_pr__cap_mim_m3_1 w=13.955 l=13.955
XDAC_C7_40_C_UNIT_P0 TOP DAC__BOTTOM7 sky130_fd_pr__cap_mim_m3_1 w=13.955 l=13.955
XDAC_C7_41_C_UNIT_P0 TOP DAC__BOTTOM7 sky130_fd_pr__cap_mim_m3_1 w=13.955 l=13.955
XDAC_C7_42_C_UNIT_P0 TOP DAC__BOTTOM7 sky130_fd_pr__cap_mim_m3_1 w=13.955 l=13.955
XDAC_C7_43_C_UNIT_P0 TOP DAC__BOTTOM7 sky130_fd_pr__cap_mim_m3_1 w=13.955 l=13.955
XDAC_C7_44_C_UNIT_P0 TOP DAC__BOTTOM7 sky130_fd_pr__cap_mim_m3_1 w=13.955 l=13.955
XDAC_C7_45_C_UNIT_P0 TOP DAC__BOTTOM7 sky130_fd_pr__cap_mim_m3_1 w=13.955 l=13.955
XDAC_C7_46_C_UNIT_P0 TOP DAC__BOTTOM7 sky130_fd_pr__cap_mim_m3_1 w=13.955 l=13.955
XDAC_C7_47_C_UNIT_P0 TOP DAC__BOTTOM7 sky130_fd_pr__cap_mim_m3_1 w=13.955 l=13.955
XDAC_C7_48_C_UNIT_P0 TOP DAC__BOTTOM7 sky130_fd_pr__cap_mim_m3_1 w=13.955 l=13.955
XDAC_C7_49_C_UNIT_P0 TOP DAC__BOTTOM7 sky130_fd_pr__cap_mim_m3_1 w=13.955 l=13.955
XDAC_C7_5_C_UNIT_P0 TOP DAC__BOTTOM7 sky130_fd_pr__cap_mim_m3_1 w=13.955 l=13.955
XDAC_C7_50_C_UNIT_P0 TOP DAC__BOTTOM7 sky130_fd_pr__cap_mim_m3_1 w=13.955 l=13.955
XDAC_C7_51_C_UNIT_P0 TOP DAC__BOTTOM7 sky130_fd_pr__cap_mim_m3_1 w=13.955 l=13.955
XDAC_C7_52_C_UNIT_P0 TOP DAC__BOTTOM7 sky130_fd_pr__cap_mim_m3_1 w=13.955 l=13.955
XDAC_C7_53_C_UNIT_P0 TOP DAC__BOTTOM7 sky130_fd_pr__cap_mim_m3_1 w=13.955 l=13.955
XDAC_C7_54_C_UNIT_P0 TOP DAC__BOTTOM7 sky130_fd_pr__cap_mim_m3_1 w=13.955 l=13.955
XDAC_C7_55_C_UNIT_P0 TOP DAC__BOTTOM7 sky130_fd_pr__cap_mim_m3_1 w=13.955 l=13.955
XDAC_C7_56_C_UNIT_P0 TOP DAC__BOTTOM7 sky130_fd_pr__cap_mim_m3_1 w=13.955 l=13.955
XDAC_C7_57_C_UNIT_P0 TOP DAC__BOTTOM7 sky130_fd_pr__cap_mim_m3_1 w=13.955 l=13.955
XDAC_C7_58_C_UNIT_P0 TOP DAC__BOTTOM7 sky130_fd_pr__cap_mim_m3_1 w=13.955 l=13.955
XDAC_C7_59_C_UNIT_P0 TOP DAC__BOTTOM7 sky130_fd_pr__cap_mim_m3_1 w=13.955 l=13.955
XDAC_C7_6_C_UNIT_P0 TOP DAC__BOTTOM7 sky130_fd_pr__cap_mim_m3_1 w=13.955 l=13.955
XDAC_C7_60_C_UNIT_P0 TOP DAC__BOTTOM7 sky130_fd_pr__cap_mim_m3_1 w=13.955 l=13.955
XDAC_C7_61_C_UNIT_P0 TOP DAC__BOTTOM7 sky130_fd_pr__cap_mim_m3_1 w=13.955 l=13.955
XDAC_C7_62_C_UNIT_P0 TOP DAC__BOTTOM7 sky130_fd_pr__cap_mim_m3_1 w=13.955 l=13.955
XDAC_C7_63_C_UNIT_P0 TOP DAC__BOTTOM7 sky130_fd_pr__cap_mim_m3_1 w=13.955 l=13.955
XDAC_C7_64_C_UNIT_P0 TOP DAC__BOTTOM7 sky130_fd_pr__cap_mim_m3_1 w=13.955 l=13.955
XDAC_C7_65_C_UNIT_P0 TOP DAC__BOTTOM7 sky130_fd_pr__cap_mim_m3_1 w=13.955 l=13.955
XDAC_C7_66_C_UNIT_P0 TOP DAC__BOTTOM7 sky130_fd_pr__cap_mim_m3_1 w=13.955 l=13.955
XDAC_C7_67_C_UNIT_P0 TOP DAC__BOTTOM7 sky130_fd_pr__cap_mim_m3_1 w=13.955 l=13.955
XDAC_C7_68_C_UNIT_P0 TOP DAC__BOTTOM7 sky130_fd_pr__cap_mim_m3_1 w=13.955 l=13.955
XDAC_C7_69_C_UNIT_P0 TOP DAC__BOTTOM7 sky130_fd_pr__cap_mim_m3_1 w=13.955 l=13.955
XDAC_C7_7_C_UNIT_P0 TOP DAC__BOTTOM7 sky130_fd_pr__cap_mim_m3_1 w=13.955 l=13.955
XDAC_C7_70_C_UNIT_P0 TOP DAC__BOTTOM7 sky130_fd_pr__cap_mim_m3_1 w=13.955 l=13.955
XDAC_C7_71_C_UNIT_P0 TOP DAC__BOTTOM7 sky130_fd_pr__cap_mim_m3_1 w=13.955 l=13.955
XDAC_C7_72_C_UNIT_P0 TOP DAC__BOTTOM7 sky130_fd_pr__cap_mim_m3_1 w=13.955 l=13.955
XDAC_C7_73_C_UNIT_P0 TOP DAC__BOTTOM7 sky130_fd_pr__cap_mim_m3_1 w=13.955 l=13.955
XDAC_C7_74_C_UNIT_P0 TOP DAC__BOTTOM7 sky130_fd_pr__cap_mim_m3_1 w=13.955 l=13.955
XDAC_C7_75_C_UNIT_P0 TOP DAC__BOTTOM7 sky130_fd_pr__cap_mim_m3_1 w=13.955 l=13.955
XDAC_C7_76_C_UNIT_P0 TOP DAC__BOTTOM7 sky130_fd_pr__cap_mim_m3_1 w=13.955 l=13.955
XDAC_C7_77_C_UNIT_P0 TOP DAC__BOTTOM7 sky130_fd_pr__cap_mim_m3_1 w=13.955 l=13.955
XDAC_C7_78_C_UNIT_P0 TOP DAC__BOTTOM7 sky130_fd_pr__cap_mim_m3_1 w=13.955 l=13.955
XDAC_C7_79_C_UNIT_P0 TOP DAC__BOTTOM7 sky130_fd_pr__cap_mim_m3_1 w=13.955 l=13.955
XDAC_C7_8_C_UNIT_P0 TOP DAC__BOTTOM7 sky130_fd_pr__cap_mim_m3_1 w=13.955 l=13.955
XDAC_C7_80_C_UNIT_P0 TOP DAC__BOTTOM7 sky130_fd_pr__cap_mim_m3_1 w=13.955 l=13.955
XDAC_C7_81_C_UNIT_P0 TOP DAC__BOTTOM7 sky130_fd_pr__cap_mim_m3_1 w=13.955 l=13.955
XDAC_C7_82_C_UNIT_P0 TOP DAC__BOTTOM7 sky130_fd_pr__cap_mim_m3_1 w=13.955 l=13.955
XDAC_C7_83_C_UNIT_P0 TOP DAC__BOTTOM7 sky130_fd_pr__cap_mim_m3_1 w=13.955 l=13.955
XDAC_C7_84_C_UNIT_P0 TOP DAC__BOTTOM7 sky130_fd_pr__cap_mim_m3_1 w=13.955 l=13.955
XDAC_C7_85_C_UNIT_P0 TOP DAC__BOTTOM7 sky130_fd_pr__cap_mim_m3_1 w=13.955 l=13.955
XDAC_C7_86_C_UNIT_P0 TOP DAC__BOTTOM7 sky130_fd_pr__cap_mim_m3_1 w=13.955 l=13.955
XDAC_C7_87_C_UNIT_P0 TOP DAC__BOTTOM7 sky130_fd_pr__cap_mim_m3_1 w=13.955 l=13.955
XDAC_C7_88_C_UNIT_P0 TOP DAC__BOTTOM7 sky130_fd_pr__cap_mim_m3_1 w=13.955 l=13.955
XDAC_C7_89_C_UNIT_P0 TOP DAC__BOTTOM7 sky130_fd_pr__cap_mim_m3_1 w=13.955 l=13.955
XDAC_C7_9_C_UNIT_P0 TOP DAC__BOTTOM7 sky130_fd_pr__cap_mim_m3_1 w=13.955 l=13.955
XDAC_C7_90_C_UNIT_P0 TOP DAC__BOTTOM7 sky130_fd_pr__cap_mim_m3_1 w=13.955 l=13.955
XDAC_C7_91_C_UNIT_P0 TOP DAC__BOTTOM7 sky130_fd_pr__cap_mim_m3_1 w=13.955 l=13.955
XDAC_C7_92_C_UNIT_P0 TOP DAC__BOTTOM7 sky130_fd_pr__cap_mim_m3_1 w=13.955 l=13.955
XDAC_C7_93_C_UNIT_P0 TOP DAC__BOTTOM7 sky130_fd_pr__cap_mim_m3_1 w=13.955 l=13.955
XDAC_C7_94_C_UNIT_P0 TOP DAC__BOTTOM7 sky130_fd_pr__cap_mim_m3_1 w=13.955 l=13.955
XDAC_C7_95_C_UNIT_P0 TOP DAC__BOTTOM7 sky130_fd_pr__cap_mim_m3_1 w=13.955 l=13.955
XDAC_C7_96_C_UNIT_P0 TOP DAC__BOTTOM7 sky130_fd_pr__cap_mim_m3_1 w=13.955 l=13.955
XDAC_C7_97_C_UNIT_P0 TOP DAC__BOTTOM7 sky130_fd_pr__cap_mim_m3_1 w=13.955 l=13.955
XDAC_C7_98_C_UNIT_P0 TOP DAC__BOTTOM7 sky130_fd_pr__cap_mim_m3_1 w=13.955 l=13.955
XDAC_C7_99_C_UNIT_P0 TOP DAC__BOTTOM7 sky130_fd_pr__cap_mim_m3_1 w=13.955 l=13.955
XDAC_DUMMY_CAP_C_UNIT_P0 TOP DAC__DUMMY sky130_fd_pr__cap_mim_m3_1 w=13.955 l=13.955
XDAC_DUMMY_SWITCH_ACQUIRE_N DAC__DUMMY SAMPLE VIN VGND sky130_fd_pr__nfet_01v8 w=4 l=0.15 nf=1 m=1
XDAC_DUMMY_SWITCH_ACQUIRE_P DAC__DUMMY DAC__SAMPLEB VIN VPWR sky130_fd_pr__pfet_01v8_hvt w=8 l=0.15 nf=1 m=1
XDAC_DUMMY_SWITCH_BIT_INV_MN DAC__DUMMY_SWITCH__BITB VGND VGND VGND sky130_fd_pr__nfet_01v8 w=0.65 l=0.15 nf=1 m=1
XDAC_DUMMY_SWITCH_BIT_INV_MP DAC__DUMMY_SWITCH__BITB VGND VPWR VPWR sky130_fd_pr__pfet_01v8_hvt w=0.65 l=0.15 nf=1 m=1
XDAC_DUMMY_SWITCH_CONVERT_N DAC__DUMMY DAC__SAMPLEB DAC__DUMMY_SWITCH__REFSEL VGND sky130_fd_pr__nfet_01v8 w=4 l=0.15 nf=1 m=1
XDAC_DUMMY_SWITCH_CONVERT_P DAC__DUMMY SAMPLE DAC__DUMMY_SWITCH__REFSEL VPWR sky130_fd_pr__pfet_01v8_hvt w=8 l=0.15 nf=1 m=1
XDAC_DUMMY_SWITCH_HIGH_N DAC__DUMMY_SWITCH__REFSEL VGND VREF VGND sky130_fd_pr__nfet_01v8 w=4 l=0.15 nf=1 m=1
XDAC_DUMMY_SWITCH_HIGH_P DAC__DUMMY_SWITCH__REFSEL DAC__DUMMY_SWITCH__BITB VREF VPWR sky130_fd_pr__pfet_01v8_hvt w=8 l=0.15 nf=1 m=1
XDAC_DUMMY_SWITCH_LOW_N DAC__DUMMY_SWITCH__REFSEL DAC__DUMMY_SWITCH__BITB VGND VGND sky130_fd_pr__nfet_01v8 w=4 l=0.15 nf=1 m=1
XDAC_DUMMY_SWITCH_LOW_P DAC__DUMMY_SWITCH__REFSEL VGND VGND VPWR sky130_fd_pr__pfet_01v8_hvt w=8 l=0.15 nf=1 m=1
XDAC_SAMPLE_INV_MN DAC__SAMPLEB SAMPLE VGND VGND sky130_fd_pr__nfet_01v8 w=0.65 l=0.15 nf=1 m=1
XDAC_SAMPLE_INV_MP DAC__SAMPLEB SAMPLE VPWR VPWR sky130_fd_pr__pfet_01v8_hvt w=0.65 l=0.15 nf=1 m=1
XDAC_TOP_RESET_N TOP SAMPLE VCM VGND sky130_fd_pr__nfet_01v8 w=4 l=0.15 nf=1 m=1
XDAC_TOP_RESET_P TOP DAC__SAMPLEB VCM VPWR sky130_fd_pr__pfet_01v8_hvt w=8 l=0.15 nf=1 m=1
.ends sar8_analog

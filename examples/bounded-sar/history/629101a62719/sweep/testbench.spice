Actual SAR charge redistribution with continuous native comparator decisions
.include "/workspace/.runtime/eda/runs/f363f7d45d4f40c287a3433a660268be/supported-tt.spice"
.option scale=1e-6 method=gear
.include "/workspace/.runtime/eda/runs/f363f7d45d4f40c287a3433a660268be/analog.spice"
.temp 27.0
VGND VGND 0 0
VDD VPWR VGND 1.8
VIN VIN VGND 0.6
VREF VREF VGND 1.2
VCM VCM VGND 0.9
VBIAS BIAS VGND .9
VSAMPLE SAMPLE VGND 1.8
VB0 B0 VGND 0
VB1 B1 VGND 0
VB2 B2 VGND 0
VB3 B3 VGND 0
VB4 B4 VGND 0
VB5 B5 VGND 0
VB6 B6 VGND 0
VB7 B7 VGND 0
XU VIN VREF VCM BIAS SAMPLE TOP COMP B0 B1 B2 B3 B4 B5 B6 B7 VPWR VGND sar8_analog
.tran 2.59111111111e-08 0.004664 0 2.59111111111e-08
.control
set num_threads=1
set numdgt=17
set wr_singlescale
set wr_vecnames
save v(VIN) v(SAMPLE) v(TOP) v(COMP) v(VCM) i(VDD) i(VREF) v(B0) v(B1) v(B2) v(B3) v(B4) v(B5) v(B6) v(B7)
echo frame bit trial comp top vin decision > decisions.csv
alter VIN = 0.6
alter VSAMPLE = 1.8
alter VB0 = 0
alter VB1 = 0
alter VB2 = 0
alter VB3 = 0
alter VB4 = 0
alter VB5 = 0
alter VB6 = 0
alter VB7 = 0
let code = 0
stop when time = 2e-06
run
delete all
alter VSAMPLE = 0
let trial = code + 128
let drive = (floor(trial / 1) - 2*floor(trial / 2))*1.8
alter VB0 = $&drive
let drive = (floor(trial / 2) - 2*floor(trial / 4))*1.8
alter VB1 = $&drive
let drive = (floor(trial / 4) - 2*floor(trial / 8))*1.8
alter VB2 = $&drive
let drive = (floor(trial / 8) - 2*floor(trial / 16))*1.8
alter VB3 = $&drive
let drive = (floor(trial / 16) - 2*floor(trial / 32))*1.8
alter VB4 = $&drive
let drive = (floor(trial / 32) - 2*floor(trial / 64))*1.8
alter VB5 = $&drive
let drive = (floor(trial / 64) - 2*floor(trial / 128))*1.8
alter VB6 = $&drive
let drive = (floor(trial / 128) - 2*floor(trial / 256))*1.8
alter VB7 = $&drive
stop when time = 4e-06
resume
delete all
let endpoint = length(time)-1
let cmp = v(COMP)[endpoint]
let top = v(TOP)[endpoint]
let decision = 0
if cmp >= 0.9
let code = trial
let decision = 1
end
echo 0 7 $&trial $&cmp $&top 0.6 $&decision >> decisions.csv
let trial = code + 64
let drive = (floor(trial / 1) - 2*floor(trial / 2))*1.8
alter VB0 = $&drive
let drive = (floor(trial / 2) - 2*floor(trial / 4))*1.8
alter VB1 = $&drive
let drive = (floor(trial / 4) - 2*floor(trial / 8))*1.8
alter VB2 = $&drive
let drive = (floor(trial / 8) - 2*floor(trial / 16))*1.8
alter VB3 = $&drive
let drive = (floor(trial / 16) - 2*floor(trial / 32))*1.8
alter VB4 = $&drive
let drive = (floor(trial / 32) - 2*floor(trial / 64))*1.8
alter VB5 = $&drive
let drive = (floor(trial / 64) - 2*floor(trial / 128))*1.8
alter VB6 = $&drive
let drive = (floor(trial / 128) - 2*floor(trial / 256))*1.8
alter VB7 = $&drive
stop when time = 6e-06
resume
delete all
let endpoint = length(time)-1
let cmp = v(COMP)[endpoint]
let top = v(TOP)[endpoint]
let decision = 0
if cmp >= 0.9
let code = trial
let decision = 1
end
echo 0 6 $&trial $&cmp $&top 0.6 $&decision >> decisions.csv
let trial = code + 32
let drive = (floor(trial / 1) - 2*floor(trial / 2))*1.8
alter VB0 = $&drive
let drive = (floor(trial / 2) - 2*floor(trial / 4))*1.8
alter VB1 = $&drive
let drive = (floor(trial / 4) - 2*floor(trial / 8))*1.8
alter VB2 = $&drive
let drive = (floor(trial / 8) - 2*floor(trial / 16))*1.8
alter VB3 = $&drive
let drive = (floor(trial / 16) - 2*floor(trial / 32))*1.8
alter VB4 = $&drive
let drive = (floor(trial / 32) - 2*floor(trial / 64))*1.8
alter VB5 = $&drive
let drive = (floor(trial / 64) - 2*floor(trial / 128))*1.8
alter VB6 = $&drive
let drive = (floor(trial / 128) - 2*floor(trial / 256))*1.8
alter VB7 = $&drive
stop when time = 8e-06
resume
delete all
let endpoint = length(time)-1
let cmp = v(COMP)[endpoint]
let top = v(TOP)[endpoint]
let decision = 0
if cmp >= 0.9
let code = trial
let decision = 1
end
echo 0 5 $&trial $&cmp $&top 0.6 $&decision >> decisions.csv
let trial = code + 16
let drive = (floor(trial / 1) - 2*floor(trial / 2))*1.8
alter VB0 = $&drive
let drive = (floor(trial / 2) - 2*floor(trial / 4))*1.8
alter VB1 = $&drive
let drive = (floor(trial / 4) - 2*floor(trial / 8))*1.8
alter VB2 = $&drive
let drive = (floor(trial / 8) - 2*floor(trial / 16))*1.8
alter VB3 = $&drive
let drive = (floor(trial / 16) - 2*floor(trial / 32))*1.8
alter VB4 = $&drive
let drive = (floor(trial / 32) - 2*floor(trial / 64))*1.8
alter VB5 = $&drive
let drive = (floor(trial / 64) - 2*floor(trial / 128))*1.8
alter VB6 = $&drive
let drive = (floor(trial / 128) - 2*floor(trial / 256))*1.8
alter VB7 = $&drive
stop when time = 1e-05
resume
delete all
let endpoint = length(time)-1
let cmp = v(COMP)[endpoint]
let top = v(TOP)[endpoint]
let decision = 0
if cmp >= 0.9
let code = trial
let decision = 1
end
echo 0 4 $&trial $&cmp $&top 0.6 $&decision >> decisions.csv
let trial = code + 8
let drive = (floor(trial / 1) - 2*floor(trial / 2))*1.8
alter VB0 = $&drive
let drive = (floor(trial / 2) - 2*floor(trial / 4))*1.8
alter VB1 = $&drive
let drive = (floor(trial / 4) - 2*floor(trial / 8))*1.8
alter VB2 = $&drive
let drive = (floor(trial / 8) - 2*floor(trial / 16))*1.8
alter VB3 = $&drive
let drive = (floor(trial / 16) - 2*floor(trial / 32))*1.8
alter VB4 = $&drive
let drive = (floor(trial / 32) - 2*floor(trial / 64))*1.8
alter VB5 = $&drive
let drive = (floor(trial / 64) - 2*floor(trial / 128))*1.8
alter VB6 = $&drive
let drive = (floor(trial / 128) - 2*floor(trial / 256))*1.8
alter VB7 = $&drive
stop when time = 1.2e-05
resume
delete all
let endpoint = length(time)-1
let cmp = v(COMP)[endpoint]
let top = v(TOP)[endpoint]
let decision = 0
if cmp >= 0.9
let code = trial
let decision = 1
end
echo 0 3 $&trial $&cmp $&top 0.6 $&decision >> decisions.csv
let trial = code + 4
let drive = (floor(trial / 1) - 2*floor(trial / 2))*1.8
alter VB0 = $&drive
let drive = (floor(trial / 2) - 2*floor(trial / 4))*1.8
alter VB1 = $&drive
let drive = (floor(trial / 4) - 2*floor(trial / 8))*1.8
alter VB2 = $&drive
let drive = (floor(trial / 8) - 2*floor(trial / 16))*1.8
alter VB3 = $&drive
let drive = (floor(trial / 16) - 2*floor(trial / 32))*1.8
alter VB4 = $&drive
let drive = (floor(trial / 32) - 2*floor(trial / 64))*1.8
alter VB5 = $&drive
let drive = (floor(trial / 64) - 2*floor(trial / 128))*1.8
alter VB6 = $&drive
let drive = (floor(trial / 128) - 2*floor(trial / 256))*1.8
alter VB7 = $&drive
stop when time = 1.4e-05
resume
delete all
let endpoint = length(time)-1
let cmp = v(COMP)[endpoint]
let top = v(TOP)[endpoint]
let decision = 0
if cmp >= 0.9
let code = trial
let decision = 1
end
echo 0 2 $&trial $&cmp $&top 0.6 $&decision >> decisions.csv
let trial = code + 2
let drive = (floor(trial / 1) - 2*floor(trial / 2))*1.8
alter VB0 = $&drive
let drive = (floor(trial / 2) - 2*floor(trial / 4))*1.8
alter VB1 = $&drive
let drive = (floor(trial / 4) - 2*floor(trial / 8))*1.8
alter VB2 = $&drive
let drive = (floor(trial / 8) - 2*floor(trial / 16))*1.8
alter VB3 = $&drive
let drive = (floor(trial / 16) - 2*floor(trial / 32))*1.8
alter VB4 = $&drive
let drive = (floor(trial / 32) - 2*floor(trial / 64))*1.8
alter VB5 = $&drive
let drive = (floor(trial / 64) - 2*floor(trial / 128))*1.8
alter VB6 = $&drive
let drive = (floor(trial / 128) - 2*floor(trial / 256))*1.8
alter VB7 = $&drive
stop when time = 1.6e-05
resume
delete all
let endpoint = length(time)-1
let cmp = v(COMP)[endpoint]
let top = v(TOP)[endpoint]
let decision = 0
if cmp >= 0.9
let code = trial
let decision = 1
end
echo 0 1 $&trial $&cmp $&top 0.6 $&decision >> decisions.csv
let trial = code + 1
let drive = (floor(trial / 1) - 2*floor(trial / 2))*1.8
alter VB0 = $&drive
let drive = (floor(trial / 2) - 2*floor(trial / 4))*1.8
alter VB1 = $&drive
let drive = (floor(trial / 4) - 2*floor(trial / 8))*1.8
alter VB2 = $&drive
let drive = (floor(trial / 8) - 2*floor(trial / 16))*1.8
alter VB3 = $&drive
let drive = (floor(trial / 16) - 2*floor(trial / 32))*1.8
alter VB4 = $&drive
let drive = (floor(trial / 32) - 2*floor(trial / 64))*1.8
alter VB5 = $&drive
let drive = (floor(trial / 64) - 2*floor(trial / 128))*1.8
alter VB6 = $&drive
let drive = (floor(trial / 128) - 2*floor(trial / 256))*1.8
alter VB7 = $&drive
stop when time = 1.8e-05
resume
delete all
let endpoint = length(time)-1
let cmp = v(COMP)[endpoint]
let top = v(TOP)[endpoint]
let decision = 0
if cmp >= 0.9
let code = trial
let decision = 1
end
echo 0 0 $&trial $&cmp $&top 0.6 $&decision >> decisions.csv
alter VIN = 0
alter VSAMPLE = 1.8
alter VB0 = 0
alter VB1 = 0
alter VB2 = 0
alter VB3 = 0
alter VB4 = 0
alter VB5 = 0
alter VB6 = 0
alter VB7 = 0
let code = 0
stop when time = 2e-05
resume
delete all
alter VSAMPLE = 0
let trial = code + 128
let drive = (floor(trial / 1) - 2*floor(trial / 2))*1.8
alter VB0 = $&drive
let drive = (floor(trial / 2) - 2*floor(trial / 4))*1.8
alter VB1 = $&drive
let drive = (floor(trial / 4) - 2*floor(trial / 8))*1.8
alter VB2 = $&drive
let drive = (floor(trial / 8) - 2*floor(trial / 16))*1.8
alter VB3 = $&drive
let drive = (floor(trial / 16) - 2*floor(trial / 32))*1.8
alter VB4 = $&drive
let drive = (floor(trial / 32) - 2*floor(trial / 64))*1.8
alter VB5 = $&drive
let drive = (floor(trial / 64) - 2*floor(trial / 128))*1.8
alter VB6 = $&drive
let drive = (floor(trial / 128) - 2*floor(trial / 256))*1.8
alter VB7 = $&drive
stop when time = 2.2e-05
resume
delete all
let endpoint = length(time)-1
let cmp = v(COMP)[endpoint]
let top = v(TOP)[endpoint]
let decision = 0
if cmp >= 0.9
let code = trial
let decision = 1
end
echo 1 7 $&trial $&cmp $&top 0 $&decision >> decisions.csv
let trial = code + 64
let drive = (floor(trial / 1) - 2*floor(trial / 2))*1.8
alter VB0 = $&drive
let drive = (floor(trial / 2) - 2*floor(trial / 4))*1.8
alter VB1 = $&drive
let drive = (floor(trial / 4) - 2*floor(trial / 8))*1.8
alter VB2 = $&drive
let drive = (floor(trial / 8) - 2*floor(trial / 16))*1.8
alter VB3 = $&drive
let drive = (floor(trial / 16) - 2*floor(trial / 32))*1.8
alter VB4 = $&drive
let drive = (floor(trial / 32) - 2*floor(trial / 64))*1.8
alter VB5 = $&drive
let drive = (floor(trial / 64) - 2*floor(trial / 128))*1.8
alter VB6 = $&drive
let drive = (floor(trial / 128) - 2*floor(trial / 256))*1.8
alter VB7 = $&drive
stop when time = 2.4e-05
resume
delete all
let endpoint = length(time)-1
let cmp = v(COMP)[endpoint]
let top = v(TOP)[endpoint]
let decision = 0
if cmp >= 0.9
let code = trial
let decision = 1
end
echo 1 6 $&trial $&cmp $&top 0 $&decision >> decisions.csv
let trial = code + 32
let drive = (floor(trial / 1) - 2*floor(trial / 2))*1.8
alter VB0 = $&drive
let drive = (floor(trial / 2) - 2*floor(trial / 4))*1.8
alter VB1 = $&drive
let drive = (floor(trial / 4) - 2*floor(trial / 8))*1.8
alter VB2 = $&drive
let drive = (floor(trial / 8) - 2*floor(trial / 16))*1.8
alter VB3 = $&drive
let drive = (floor(trial / 16) - 2*floor(trial / 32))*1.8
alter VB4 = $&drive
let drive = (floor(trial / 32) - 2*floor(trial / 64))*1.8
alter VB5 = $&drive
let drive = (floor(trial / 64) - 2*floor(trial / 128))*1.8
alter VB6 = $&drive
let drive = (floor(trial / 128) - 2*floor(trial / 256))*1.8
alter VB7 = $&drive
stop when time = 2.6e-05
resume
delete all
let endpoint = length(time)-1
let cmp = v(COMP)[endpoint]
let top = v(TOP)[endpoint]
let decision = 0
if cmp >= 0.9
let code = trial
let decision = 1
end
echo 1 5 $&trial $&cmp $&top 0 $&decision >> decisions.csv
let trial = code + 16
let drive = (floor(trial / 1) - 2*floor(trial / 2))*1.8
alter VB0 = $&drive
let drive = (floor(trial / 2) - 2*floor(trial / 4))*1.8
alter VB1 = $&drive
let drive = (floor(trial / 4) - 2*floor(trial / 8))*1.8
alter VB2 = $&drive
let drive = (floor(trial / 8) - 2*floor(trial / 16))*1.8
alter VB3 = $&drive
let drive = (floor(trial / 16) - 2*floor(trial / 32))*1.8
alter VB4 = $&drive
let drive = (floor(trial / 32) - 2*floor(trial / 64))*1.8
alter VB5 = $&drive
let drive = (floor(trial / 64) - 2*floor(trial / 128))*1.8
alter VB6 = $&drive
let drive = (floor(trial / 128) - 2*floor(trial / 256))*1.8
alter VB7 = $&drive
stop when time = 2.8e-05
resume
delete all
let endpoint = length(time)-1
let cmp = v(COMP)[endpoint]
let top = v(TOP)[endpoint]
let decision = 0
if cmp >= 0.9
let code = trial
let decision = 1
end
echo 1 4 $&trial $&cmp $&top 0 $&decision >> decisions.csv
let trial = code + 8
let drive = (floor(trial / 1) - 2*floor(trial / 2))*1.8
alter VB0 = $&drive
let drive = (floor(trial / 2) - 2*floor(trial / 4))*1.8
alter VB1 = $&drive
let drive = (floor(trial / 4) - 2*floor(trial / 8))*1.8
alter VB2 = $&drive
let drive = (floor(trial / 8) - 2*floor(trial / 16))*1.8
alter VB3 = $&drive
let drive = (floor(trial / 16) - 2*floor(trial / 32))*1.8
alter VB4 = $&drive
let drive = (floor(trial / 32) - 2*floor(trial / 64))*1.8
alter VB5 = $&drive
let drive = (floor(trial / 64) - 2*floor(trial / 128))*1.8
alter VB6 = $&drive
let drive = (floor(trial / 128) - 2*floor(trial / 256))*1.8
alter VB7 = $&drive
stop when time = 3e-05
resume
delete all
let endpoint = length(time)-1
let cmp = v(COMP)[endpoint]
let top = v(TOP)[endpoint]
let decision = 0
if cmp >= 0.9
let code = trial
let decision = 1
end
echo 1 3 $&trial $&cmp $&top 0 $&decision >> decisions.csv
let trial = code + 4
let drive = (floor(trial / 1) - 2*floor(trial / 2))*1.8
alter VB0 = $&drive
let drive = (floor(trial / 2) - 2*floor(trial / 4))*1.8
alter VB1 = $&drive
let drive = (floor(trial / 4) - 2*floor(trial / 8))*1.8
alter VB2 = $&drive
let drive = (floor(trial / 8) - 2*floor(trial / 16))*1.8
alter VB3 = $&drive
let drive = (floor(trial / 16) - 2*floor(trial / 32))*1.8
alter VB4 = $&drive
let drive = (floor(trial / 32) - 2*floor(trial / 64))*1.8
alter VB5 = $&drive
let drive = (floor(trial / 64) - 2*floor(trial / 128))*1.8
alter VB6 = $&drive
let drive = (floor(trial / 128) - 2*floor(trial / 256))*1.8
alter VB7 = $&drive
stop when time = 3.2e-05
resume
delete all
let endpoint = length(time)-1
let cmp = v(COMP)[endpoint]
let top = v(TOP)[endpoint]
let decision = 0
if cmp >= 0.9
let code = trial
let decision = 1
end
echo 1 2 $&trial $&cmp $&top 0 $&decision >> decisions.csv
let trial = code + 2
let drive = (floor(trial / 1) - 2*floor(trial / 2))*1.8
alter VB0 = $&drive
let drive = (floor(trial / 2) - 2*floor(trial / 4))*1.8
alter VB1 = $&drive
let drive = (floor(trial / 4) - 2*floor(trial / 8))*1.8
alter VB2 = $&drive
let drive = (floor(trial / 8) - 2*floor(trial / 16))*1.8
alter VB3 = $&drive
let drive = (floor(trial / 16) - 2*floor(trial / 32))*1.8
alter VB4 = $&drive
let drive = (floor(trial / 32) - 2*floor(trial / 64))*1.8
alter VB5 = $&drive
let drive = (floor(trial / 64) - 2*floor(trial / 128))*1.8
alter VB6 = $&drive
let drive = (floor(trial / 128) - 2*floor(trial / 256))*1.8
alter VB7 = $&drive
stop when time = 3.4e-05
resume
delete all
let endpoint = length(time)-1
let cmp = v(COMP)[endpoint]
let top = v(TOP)[endpoint]
let decision = 0
if cmp >= 0.9
let code = trial
let decision = 1
end
echo 1 1 $&trial $&cmp $&top 0 $&decision >> decisions.csv
let trial = code + 1
let drive = (floor(trial / 1) - 2*floor(trial / 2))*1.8
alter VB0 = $&drive
let drive = (floor(trial / 2) - 2*floor(trial / 4))*1.8
alter VB1 = $&drive
let drive = (floor(trial / 4) - 2*floor(trial / 8))*1.8
alter VB2 = $&drive
let drive = (floor(trial / 8) - 2*floor(trial / 16))*1.8
alter VB3 = $&drive
let drive = (floor(trial / 16) - 2*floor(trial / 32))*1.8
alter VB4 = $&drive
let drive = (floor(trial / 32) - 2*floor(trial / 64))*1.8
alter VB5 = $&drive
let drive = (floor(trial / 64) - 2*floor(trial / 128))*1.8
alter VB6 = $&drive
let drive = (floor(trial / 128) - 2*floor(trial / 256))*1.8
alter VB7 = $&drive
stop when time = 3.6e-05
resume
delete all
let endpoint = length(time)-1
let cmp = v(COMP)[endpoint]
let top = v(TOP)[endpoint]
let decision = 0
if cmp >= 0.9
let code = trial
let decision = 1
end
echo 1 0 $&trial $&cmp $&top 0 $&decision >> decisions.csv
alter VIN = 1.2
alter VSAMPLE = 1.8
alter VB0 = 0
alter VB1 = 0
alter VB2 = 0
alter VB3 = 0
alter VB4 = 0
alter VB5 = 0
alter VB6 = 0
alter VB7 = 0
let code = 0
stop when time = 3.8e-05
resume
delete all
alter VSAMPLE = 0
let trial = code + 128
let drive = (floor(trial / 1) - 2*floor(trial / 2))*1.8
alter VB0 = $&drive
let drive = (floor(trial / 2) - 2*floor(trial / 4))*1.8
alter VB1 = $&drive
let drive = (floor(trial / 4) - 2*floor(trial / 8))*1.8
alter VB2 = $&drive
let drive = (floor(trial / 8) - 2*floor(trial / 16))*1.8
alter VB3 = $&drive
let drive = (floor(trial / 16) - 2*floor(trial / 32))*1.8
alter VB4 = $&drive
let drive = (floor(trial / 32) - 2*floor(trial / 64))*1.8
alter VB5 = $&drive
let drive = (floor(trial / 64) - 2*floor(trial / 128))*1.8
alter VB6 = $&drive
let drive = (floor(trial / 128) - 2*floor(trial / 256))*1.8
alter VB7 = $&drive
stop when time = 4e-05
resume
delete all
let endpoint = length(time)-1
let cmp = v(COMP)[endpoint]
let top = v(TOP)[endpoint]
let decision = 0
if cmp >= 0.9
let code = trial
let decision = 1
end
echo 2 7 $&trial $&cmp $&top 1.2 $&decision >> decisions.csv
let trial = code + 64
let drive = (floor(trial / 1) - 2*floor(trial / 2))*1.8
alter VB0 = $&drive
let drive = (floor(trial / 2) - 2*floor(trial / 4))*1.8
alter VB1 = $&drive
let drive = (floor(trial / 4) - 2*floor(trial / 8))*1.8
alter VB2 = $&drive
let drive = (floor(trial / 8) - 2*floor(trial / 16))*1.8
alter VB3 = $&drive
let drive = (floor(trial / 16) - 2*floor(trial / 32))*1.8
alter VB4 = $&drive
let drive = (floor(trial / 32) - 2*floor(trial / 64))*1.8
alter VB5 = $&drive
let drive = (floor(trial / 64) - 2*floor(trial / 128))*1.8
alter VB6 = $&drive
let drive = (floor(trial / 128) - 2*floor(trial / 256))*1.8
alter VB7 = $&drive
stop when time = 4.2e-05
resume
delete all
let endpoint = length(time)-1
let cmp = v(COMP)[endpoint]
let top = v(TOP)[endpoint]
let decision = 0
if cmp >= 0.9
let code = trial
let decision = 1
end
echo 2 6 $&trial $&cmp $&top 1.2 $&decision >> decisions.csv
let trial = code + 32
let drive = (floor(trial / 1) - 2*floor(trial / 2))*1.8
alter VB0 = $&drive
let drive = (floor(trial / 2) - 2*floor(trial / 4))*1.8
alter VB1 = $&drive
let drive = (floor(trial / 4) - 2*floor(trial / 8))*1.8
alter VB2 = $&drive
let drive = (floor(trial / 8) - 2*floor(trial / 16))*1.8
alter VB3 = $&drive
let drive = (floor(trial / 16) - 2*floor(trial / 32))*1.8
alter VB4 = $&drive
let drive = (floor(trial / 32) - 2*floor(trial / 64))*1.8
alter VB5 = $&drive
let drive = (floor(trial / 64) - 2*floor(trial / 128))*1.8
alter VB6 = $&drive
let drive = (floor(trial / 128) - 2*floor(trial / 256))*1.8
alter VB7 = $&drive
stop when time = 4.4e-05
resume
delete all
let endpoint = length(time)-1
let cmp = v(COMP)[endpoint]
let top = v(TOP)[endpoint]
let decision = 0
if cmp >= 0.9
let code = trial
let decision = 1
end
echo 2 5 $&trial $&cmp $&top 1.2 $&decision >> decisions.csv
let trial = code + 16
let drive = (floor(trial / 1) - 2*floor(trial / 2))*1.8
alter VB0 = $&drive
let drive = (floor(trial / 2) - 2*floor(trial / 4))*1.8
alter VB1 = $&drive
let drive = (floor(trial / 4) - 2*floor(trial / 8))*1.8
alter VB2 = $&drive
let drive = (floor(trial / 8) - 2*floor(trial / 16))*1.8
alter VB3 = $&drive
let drive = (floor(trial / 16) - 2*floor(trial / 32))*1.8
alter VB4 = $&drive
let drive = (floor(trial / 32) - 2*floor(trial / 64))*1.8
alter VB5 = $&drive
let drive = (floor(trial / 64) - 2*floor(trial / 128))*1.8
alter VB6 = $&drive
let drive = (floor(trial / 128) - 2*floor(trial / 256))*1.8
alter VB7 = $&drive
stop when time = 4.6e-05
resume
delete all
let endpoint = length(time)-1
let cmp = v(COMP)[endpoint]
let top = v(TOP)[endpoint]
let decision = 0
if cmp >= 0.9
let code = trial
let decision = 1
end
echo 2 4 $&trial $&cmp $&top 1.2 $&decision >> decisions.csv
let trial = code + 8
let drive = (floor(trial / 1) - 2*floor(trial / 2))*1.8
alter VB0 = $&drive
let drive = (floor(trial / 2) - 2*floor(trial / 4))*1.8
alter VB1 = $&drive
let drive = (floor(trial / 4) - 2*floor(trial / 8))*1.8
alter VB2 = $&drive
let drive = (floor(trial / 8) - 2*floor(trial / 16))*1.8
alter VB3 = $&drive
let drive = (floor(trial / 16) - 2*floor(trial / 32))*1.8
alter VB4 = $&drive
let drive = (floor(trial / 32) - 2*floor(trial / 64))*1.8
alter VB5 = $&drive
let drive = (floor(trial / 64) - 2*floor(trial / 128))*1.8
alter VB6 = $&drive
let drive = (floor(trial / 128) - 2*floor(trial / 256))*1.8
alter VB7 = $&drive
stop when time = 4.8e-05
resume
delete all
let endpoint = length(time)-1
let cmp = v(COMP)[endpoint]
let top = v(TOP)[endpoint]
let decision = 0
if cmp >= 0.9
let code = trial
let decision = 1
end
echo 2 3 $&trial $&cmp $&top 1.2 $&decision >> decisions.csv
let trial = code + 4
let drive = (floor(trial / 1) - 2*floor(trial / 2))*1.8
alter VB0 = $&drive
let drive = (floor(trial / 2) - 2*floor(trial / 4))*1.8
alter VB1 = $&drive
let drive = (floor(trial / 4) - 2*floor(trial / 8))*1.8
alter VB2 = $&drive
let drive = (floor(trial / 8) - 2*floor(trial / 16))*1.8
alter VB3 = $&drive
let drive = (floor(trial / 16) - 2*floor(trial / 32))*1.8
alter VB4 = $&drive
let drive = (floor(trial / 32) - 2*floor(trial / 64))*1.8
alter VB5 = $&drive
let drive = (floor(trial / 64) - 2*floor(trial / 128))*1.8
alter VB6 = $&drive
let drive = (floor(trial / 128) - 2*floor(trial / 256))*1.8
alter VB7 = $&drive
stop when time = 5e-05
resume
delete all
let endpoint = length(time)-1
let cmp = v(COMP)[endpoint]
let top = v(TOP)[endpoint]
let decision = 0
if cmp >= 0.9
let code = trial
let decision = 1
end
echo 2 2 $&trial $&cmp $&top 1.2 $&decision >> decisions.csv
let trial = code + 2
let drive = (floor(trial / 1) - 2*floor(trial / 2))*1.8
alter VB0 = $&drive
let drive = (floor(trial / 2) - 2*floor(trial / 4))*1.8
alter VB1 = $&drive
let drive = (floor(trial / 4) - 2*floor(trial / 8))*1.8
alter VB2 = $&drive
let drive = (floor(trial / 8) - 2*floor(trial / 16))*1.8
alter VB3 = $&drive
let drive = (floor(trial / 16) - 2*floor(trial / 32))*1.8
alter VB4 = $&drive
let drive = (floor(trial / 32) - 2*floor(trial / 64))*1.8
alter VB5 = $&drive
let drive = (floor(trial / 64) - 2*floor(trial / 128))*1.8
alter VB6 = $&drive
let drive = (floor(trial / 128) - 2*floor(trial / 256))*1.8
alter VB7 = $&drive
stop when time = 5.2e-05
resume
delete all
let endpoint = length(time)-1
let cmp = v(COMP)[endpoint]
let top = v(TOP)[endpoint]
let decision = 0
if cmp >= 0.9
let code = trial
let decision = 1
end
echo 2 1 $&trial $&cmp $&top 1.2 $&decision >> decisions.csv
let trial = code + 1
let drive = (floor(trial / 1) - 2*floor(trial / 2))*1.8
alter VB0 = $&drive
let drive = (floor(trial / 2) - 2*floor(trial / 4))*1.8
alter VB1 = $&drive
let drive = (floor(trial / 4) - 2*floor(trial / 8))*1.8
alter VB2 = $&drive
let drive = (floor(trial / 8) - 2*floor(trial / 16))*1.8
alter VB3 = $&drive
let drive = (floor(trial / 16) - 2*floor(trial / 32))*1.8
alter VB4 = $&drive
let drive = (floor(trial / 32) - 2*floor(trial / 64))*1.8
alter VB5 = $&drive
let drive = (floor(trial / 64) - 2*floor(trial / 128))*1.8
alter VB6 = $&drive
let drive = (floor(trial / 128) - 2*floor(trial / 256))*1.8
alter VB7 = $&drive
stop when time = 5.4e-05
resume
delete all
let endpoint = length(time)-1
let cmp = v(COMP)[endpoint]
let top = v(TOP)[endpoint]
let decision = 0
if cmp >= 0.9
let code = trial
let decision = 1
end
echo 2 0 $&trial $&cmp $&top 1.2 $&decision >> decisions.csv
alter VIN = 0.00234375
alter VSAMPLE = 1.8
alter VB0 = 0
alter VB1 = 0
alter VB2 = 0
alter VB3 = 0
alter VB4 = 0
alter VB5 = 0
alter VB6 = 0
alter VB7 = 0
let code = 0
stop when time = 5.6e-05
resume
delete all
alter VSAMPLE = 0
let trial = code + 128
let drive = (floor(trial / 1) - 2*floor(trial / 2))*1.8
alter VB0 = $&drive
let drive = (floor(trial / 2) - 2*floor(trial / 4))*1.8
alter VB1 = $&drive
let drive = (floor(trial / 4) - 2*floor(trial / 8))*1.8
alter VB2 = $&drive
let drive = (floor(trial / 8) - 2*floor(trial / 16))*1.8
alter VB3 = $&drive
let drive = (floor(trial / 16) - 2*floor(trial / 32))*1.8
alter VB4 = $&drive
let drive = (floor(trial / 32) - 2*floor(trial / 64))*1.8
alter VB5 = $&drive
let drive = (floor(trial / 64) - 2*floor(trial / 128))*1.8
alter VB6 = $&drive
let drive = (floor(trial / 128) - 2*floor(trial / 256))*1.8
alter VB7 = $&drive
stop when time = 5.8e-05
resume
delete all
let endpoint = length(time)-1
let cmp = v(COMP)[endpoint]
let top = v(TOP)[endpoint]
let decision = 0
if cmp >= 0.9
let code = trial
let decision = 1
end
echo 3 7 $&trial $&cmp $&top 0.00234375 $&decision >> decisions.csv
let trial = code + 64
let drive = (floor(trial / 1) - 2*floor(trial / 2))*1.8
alter VB0 = $&drive
let drive = (floor(trial / 2) - 2*floor(trial / 4))*1.8
alter VB1 = $&drive
let drive = (floor(trial / 4) - 2*floor(trial / 8))*1.8
alter VB2 = $&drive
let drive = (floor(trial / 8) - 2*floor(trial / 16))*1.8
alter VB3 = $&drive
let drive = (floor(trial / 16) - 2*floor(trial / 32))*1.8
alter VB4 = $&drive
let drive = (floor(trial / 32) - 2*floor(trial / 64))*1.8
alter VB5 = $&drive
let drive = (floor(trial / 64) - 2*floor(trial / 128))*1.8
alter VB6 = $&drive
let drive = (floor(trial / 128) - 2*floor(trial / 256))*1.8
alter VB7 = $&drive
stop when time = 6e-05
resume
delete all
let endpoint = length(time)-1
let cmp = v(COMP)[endpoint]
let top = v(TOP)[endpoint]
let decision = 0
if cmp >= 0.9
let code = trial
let decision = 1
end
echo 3 6 $&trial $&cmp $&top 0.00234375 $&decision >> decisions.csv
let trial = code + 32
let drive = (floor(trial / 1) - 2*floor(trial / 2))*1.8
alter VB0 = $&drive
let drive = (floor(trial / 2) - 2*floor(trial / 4))*1.8
alter VB1 = $&drive
let drive = (floor(trial / 4) - 2*floor(trial / 8))*1.8
alter VB2 = $&drive
let drive = (floor(trial / 8) - 2*floor(trial / 16))*1.8
alter VB3 = $&drive
let drive = (floor(trial / 16) - 2*floor(trial / 32))*1.8
alter VB4 = $&drive
let drive = (floor(trial / 32) - 2*floor(trial / 64))*1.8
alter VB5 = $&drive
let drive = (floor(trial / 64) - 2*floor(trial / 128))*1.8
alter VB6 = $&drive
let drive = (floor(trial / 128) - 2*floor(trial / 256))*1.8
alter VB7 = $&drive
stop when time = 6.2e-05
resume
delete all
let endpoint = length(time)-1
let cmp = v(COMP)[endpoint]
let top = v(TOP)[endpoint]
let decision = 0
if cmp >= 0.9
let code = trial
let decision = 1
end
echo 3 5 $&trial $&cmp $&top 0.00234375 $&decision >> decisions.csv
let trial = code + 16
let drive = (floor(trial / 1) - 2*floor(trial / 2))*1.8
alter VB0 = $&drive
let drive = (floor(trial / 2) - 2*floor(trial / 4))*1.8
alter VB1 = $&drive
let drive = (floor(trial / 4) - 2*floor(trial / 8))*1.8
alter VB2 = $&drive
let drive = (floor(trial / 8) - 2*floor(trial / 16))*1.8
alter VB3 = $&drive
let drive = (floor(trial / 16) - 2*floor(trial / 32))*1.8
alter VB4 = $&drive
let drive = (floor(trial / 32) - 2*floor(trial / 64))*1.8
alter VB5 = $&drive
let drive = (floor(trial / 64) - 2*floor(trial / 128))*1.8
alter VB6 = $&drive
let drive = (floor(trial / 128) - 2*floor(trial / 256))*1.8
alter VB7 = $&drive
stop when time = 6.4e-05
resume
delete all
let endpoint = length(time)-1
let cmp = v(COMP)[endpoint]
let top = v(TOP)[endpoint]
let decision = 0
if cmp >= 0.9
let code = trial
let decision = 1
end
echo 3 4 $&trial $&cmp $&top 0.00234375 $&decision >> decisions.csv
let trial = code + 8
let drive = (floor(trial / 1) - 2*floor(trial / 2))*1.8
alter VB0 = $&drive
let drive = (floor(trial / 2) - 2*floor(trial / 4))*1.8
alter VB1 = $&drive
let drive = (floor(trial / 4) - 2*floor(trial / 8))*1.8
alter VB2 = $&drive
let drive = (floor(trial / 8) - 2*floor(trial / 16))*1.8
alter VB3 = $&drive
let drive = (floor(trial / 16) - 2*floor(trial / 32))*1.8
alter VB4 = $&drive
let drive = (floor(trial / 32) - 2*floor(trial / 64))*1.8
alter VB5 = $&drive
let drive = (floor(trial / 64) - 2*floor(trial / 128))*1.8
alter VB6 = $&drive
let drive = (floor(trial / 128) - 2*floor(trial / 256))*1.8
alter VB7 = $&drive
stop when time = 6.6e-05
resume
delete all
let endpoint = length(time)-1
let cmp = v(COMP)[endpoint]
let top = v(TOP)[endpoint]
let decision = 0
if cmp >= 0.9
let code = trial
let decision = 1
end
echo 3 3 $&trial $&cmp $&top 0.00234375 $&decision >> decisions.csv
let trial = code + 4
let drive = (floor(trial / 1) - 2*floor(trial / 2))*1.8
alter VB0 = $&drive
let drive = (floor(trial / 2) - 2*floor(trial / 4))*1.8
alter VB1 = $&drive
let drive = (floor(trial / 4) - 2*floor(trial / 8))*1.8
alter VB2 = $&drive
let drive = (floor(trial / 8) - 2*floor(trial / 16))*1.8
alter VB3 = $&drive
let drive = (floor(trial / 16) - 2*floor(trial / 32))*1.8
alter VB4 = $&drive
let drive = (floor(trial / 32) - 2*floor(trial / 64))*1.8
alter VB5 = $&drive
let drive = (floor(trial / 64) - 2*floor(trial / 128))*1.8
alter VB6 = $&drive
let drive = (floor(trial / 128) - 2*floor(trial / 256))*1.8
alter VB7 = $&drive
stop when time = 6.8e-05
resume
delete all
let endpoint = length(time)-1
let cmp = v(COMP)[endpoint]
let top = v(TOP)[endpoint]
let decision = 0
if cmp >= 0.9
let code = trial
let decision = 1
end
echo 3 2 $&trial $&cmp $&top 0.00234375 $&decision >> decisions.csv
let trial = code + 2
let drive = (floor(trial / 1) - 2*floor(trial / 2))*1.8
alter VB0 = $&drive
let drive = (floor(trial / 2) - 2*floor(trial / 4))*1.8
alter VB1 = $&drive
let drive = (floor(trial / 4) - 2*floor(trial / 8))*1.8
alter VB2 = $&drive
let drive = (floor(trial / 8) - 2*floor(trial / 16))*1.8
alter VB3 = $&drive
let drive = (floor(trial / 16) - 2*floor(trial / 32))*1.8
alter VB4 = $&drive
let drive = (floor(trial / 32) - 2*floor(trial / 64))*1.8
alter VB5 = $&drive
let drive = (floor(trial / 64) - 2*floor(trial / 128))*1.8
alter VB6 = $&drive
let drive = (floor(trial / 128) - 2*floor(trial / 256))*1.8
alter VB7 = $&drive
stop when time = 7e-05
resume
delete all
let endpoint = length(time)-1
let cmp = v(COMP)[endpoint]
let top = v(TOP)[endpoint]
let decision = 0
if cmp >= 0.9
let code = trial
let decision = 1
end
echo 3 1 $&trial $&cmp $&top 0.00234375 $&decision >> decisions.csv
let trial = code + 1
let drive = (floor(trial / 1) - 2*floor(trial / 2))*1.8
alter VB0 = $&drive
let drive = (floor(trial / 2) - 2*floor(trial / 4))*1.8
alter VB1 = $&drive
let drive = (floor(trial / 4) - 2*floor(trial / 8))*1.8
alter VB2 = $&drive
let drive = (floor(trial / 8) - 2*floor(trial / 16))*1.8
alter VB3 = $&drive
let drive = (floor(trial / 16) - 2*floor(trial / 32))*1.8
alter VB4 = $&drive
let drive = (floor(trial / 32) - 2*floor(trial / 64))*1.8
alter VB5 = $&drive
let drive = (floor(trial / 64) - 2*floor(trial / 128))*1.8
alter VB6 = $&drive
let drive = (floor(trial / 128) - 2*floor(trial / 256))*1.8
alter VB7 = $&drive
stop when time = 7.2e-05
resume
delete all
let endpoint = length(time)-1
let cmp = v(COMP)[endpoint]
let top = v(TOP)[endpoint]
let decision = 0
if cmp >= 0.9
let code = trial
let decision = 1
end
echo 3 0 $&trial $&cmp $&top 0.00234375 $&decision >> decisions.csv
alter VIN = 0.00703125
alter VSAMPLE = 1.8
alter VB0 = 0
alter VB1 = 0
alter VB2 = 0
alter VB3 = 0
alter VB4 = 0
alter VB5 = 0
alter VB6 = 0
alter VB7 = 0
let code = 0
stop when time = 7.4e-05
resume
delete all
alter VSAMPLE = 0
let trial = code + 128
let drive = (floor(trial / 1) - 2*floor(trial / 2))*1.8
alter VB0 = $&drive
let drive = (floor(trial / 2) - 2*floor(trial / 4))*1.8
alter VB1 = $&drive
let drive = (floor(trial / 4) - 2*floor(trial / 8))*1.8
alter VB2 = $&drive
let drive = (floor(trial / 8) - 2*floor(trial / 16))*1.8
alter VB3 = $&drive
let drive = (floor(trial / 16) - 2*floor(trial / 32))*1.8
alter VB4 = $&drive
let drive = (floor(trial / 32) - 2*floor(trial / 64))*1.8
alter VB5 = $&drive
let drive = (floor(trial / 64) - 2*floor(trial / 128))*1.8
alter VB6 = $&drive
let drive = (floor(trial / 128) - 2*floor(trial / 256))*1.8
alter VB7 = $&drive
stop when time = 7.6e-05
resume
delete all
let endpoint = length(time)-1
let cmp = v(COMP)[endpoint]
let top = v(TOP)[endpoint]
let decision = 0
if cmp >= 0.9
let code = trial
let decision = 1
end
echo 4 7 $&trial $&cmp $&top 0.00703125 $&decision >> decisions.csv
let trial = code + 64
let drive = (floor(trial / 1) - 2*floor(trial / 2))*1.8
alter VB0 = $&drive
let drive = (floor(trial / 2) - 2*floor(trial / 4))*1.8
alter VB1 = $&drive
let drive = (floor(trial / 4) - 2*floor(trial / 8))*1.8
alter VB2 = $&drive
let drive = (floor(trial / 8) - 2*floor(trial / 16))*1.8
alter VB3 = $&drive
let drive = (floor(trial / 16) - 2*floor(trial / 32))*1.8
alter VB4 = $&drive
let drive = (floor(trial / 32) - 2*floor(trial / 64))*1.8
alter VB5 = $&drive
let drive = (floor(trial / 64) - 2*floor(trial / 128))*1.8
alter VB6 = $&drive
let drive = (floor(trial / 128) - 2*floor(trial / 256))*1.8
alter VB7 = $&drive
stop when time = 7.8e-05
resume
delete all
let endpoint = length(time)-1
let cmp = v(COMP)[endpoint]
let top = v(TOP)[endpoint]
let decision = 0
if cmp >= 0.9
let code = trial
let decision = 1
end
echo 4 6 $&trial $&cmp $&top 0.00703125 $&decision >> decisions.csv
let trial = code + 32
let drive = (floor(trial / 1) - 2*floor(trial / 2))*1.8
alter VB0 = $&drive
let drive = (floor(trial / 2) - 2*floor(trial / 4))*1.8
alter VB1 = $&drive
let drive = (floor(trial / 4) - 2*floor(trial / 8))*1.8
alter VB2 = $&drive
let drive = (floor(trial / 8) - 2*floor(trial / 16))*1.8
alter VB3 = $&drive
let drive = (floor(trial / 16) - 2*floor(trial / 32))*1.8
alter VB4 = $&drive
let drive = (floor(trial / 32) - 2*floor(trial / 64))*1.8
alter VB5 = $&drive
let drive = (floor(trial / 64) - 2*floor(trial / 128))*1.8
alter VB6 = $&drive
let drive = (floor(trial / 128) - 2*floor(trial / 256))*1.8
alter VB7 = $&drive
stop when time = 8e-05
resume
delete all
let endpoint = length(time)-1
let cmp = v(COMP)[endpoint]
let top = v(TOP)[endpoint]
let decision = 0
if cmp >= 0.9
let code = trial
let decision = 1
end
echo 4 5 $&trial $&cmp $&top 0.00703125 $&decision >> decisions.csv
let trial = code + 16
let drive = (floor(trial / 1) - 2*floor(trial / 2))*1.8
alter VB0 = $&drive
let drive = (floor(trial / 2) - 2*floor(trial / 4))*1.8
alter VB1 = $&drive
let drive = (floor(trial / 4) - 2*floor(trial / 8))*1.8
alter VB2 = $&drive
let drive = (floor(trial / 8) - 2*floor(trial / 16))*1.8
alter VB3 = $&drive
let drive = (floor(trial / 16) - 2*floor(trial / 32))*1.8
alter VB4 = $&drive
let drive = (floor(trial / 32) - 2*floor(trial / 64))*1.8
alter VB5 = $&drive
let drive = (floor(trial / 64) - 2*floor(trial / 128))*1.8
alter VB6 = $&drive
let drive = (floor(trial / 128) - 2*floor(trial / 256))*1.8
alter VB7 = $&drive
stop when time = 8.2e-05
resume
delete all
let endpoint = length(time)-1
let cmp = v(COMP)[endpoint]
let top = v(TOP)[endpoint]
let decision = 0
if cmp >= 0.9
let code = trial
let decision = 1
end
echo 4 4 $&trial $&cmp $&top 0.00703125 $&decision >> decisions.csv
let trial = code + 8
let drive = (floor(trial / 1) - 2*floor(trial / 2))*1.8
alter VB0 = $&drive
let drive = (floor(trial / 2) - 2*floor(trial / 4))*1.8
alter VB1 = $&drive
let drive = (floor(trial / 4) - 2*floor(trial / 8))*1.8
alter VB2 = $&drive
let drive = (floor(trial / 8) - 2*floor(trial / 16))*1.8
alter VB3 = $&drive
let drive = (floor(trial / 16) - 2*floor(trial / 32))*1.8
alter VB4 = $&drive
let drive = (floor(trial / 32) - 2*floor(trial / 64))*1.8
alter VB5 = $&drive
let drive = (floor(trial / 64) - 2*floor(trial / 128))*1.8
alter VB6 = $&drive
let drive = (floor(trial / 128) - 2*floor(trial / 256))*1.8
alter VB7 = $&drive
stop when time = 8.4e-05
resume
delete all
let endpoint = length(time)-1
let cmp = v(COMP)[endpoint]
let top = v(TOP)[endpoint]
let decision = 0
if cmp >= 0.9
let code = trial
let decision = 1
end
echo 4 3 $&trial $&cmp $&top 0.00703125 $&decision >> decisions.csv
let trial = code + 4
let drive = (floor(trial / 1) - 2*floor(trial / 2))*1.8
alter VB0 = $&drive
let drive = (floor(trial / 2) - 2*floor(trial / 4))*1.8
alter VB1 = $&drive
let drive = (floor(trial / 4) - 2*floor(trial / 8))*1.8
alter VB2 = $&drive
let drive = (floor(trial / 8) - 2*floor(trial / 16))*1.8
alter VB3 = $&drive
let drive = (floor(trial / 16) - 2*floor(trial / 32))*1.8
alter VB4 = $&drive
let drive = (floor(trial / 32) - 2*floor(trial / 64))*1.8
alter VB5 = $&drive
let drive = (floor(trial / 64) - 2*floor(trial / 128))*1.8
alter VB6 = $&drive
let drive = (floor(trial / 128) - 2*floor(trial / 256))*1.8
alter VB7 = $&drive
stop when time = 8.6e-05
resume
delete all
let endpoint = length(time)-1
let cmp = v(COMP)[endpoint]
let top = v(TOP)[endpoint]
let decision = 0
if cmp >= 0.9
let code = trial
let decision = 1
end
echo 4 2 $&trial $&cmp $&top 0.00703125 $&decision >> decisions.csv
let trial = code + 2
let drive = (floor(trial / 1) - 2*floor(trial / 2))*1.8
alter VB0 = $&drive
let drive = (floor(trial / 2) - 2*floor(trial / 4))*1.8
alter VB1 = $&drive
let drive = (floor(trial / 4) - 2*floor(trial / 8))*1.8
alter VB2 = $&drive
let drive = (floor(trial / 8) - 2*floor(trial / 16))*1.8
alter VB3 = $&drive
let drive = (floor(trial / 16) - 2*floor(trial / 32))*1.8
alter VB4 = $&drive
let drive = (floor(trial / 32) - 2*floor(trial / 64))*1.8
alter VB5 = $&drive
let drive = (floor(trial / 64) - 2*floor(trial / 128))*1.8
alter VB6 = $&drive
let drive = (floor(trial / 128) - 2*floor(trial / 256))*1.8
alter VB7 = $&drive
stop when time = 8.8e-05
resume
delete all
let endpoint = length(time)-1
let cmp = v(COMP)[endpoint]
let top = v(TOP)[endpoint]
let decision = 0
if cmp >= 0.9
let code = trial
let decision = 1
end
echo 4 1 $&trial $&cmp $&top 0.00703125 $&decision >> decisions.csv
let trial = code + 1
let drive = (floor(trial / 1) - 2*floor(trial / 2))*1.8
alter VB0 = $&drive
let drive = (floor(trial / 2) - 2*floor(trial / 4))*1.8
alter VB1 = $&drive
let drive = (floor(trial / 4) - 2*floor(trial / 8))*1.8
alter VB2 = $&drive
let drive = (floor(trial / 8) - 2*floor(trial / 16))*1.8
alter VB3 = $&drive
let drive = (floor(trial / 16) - 2*floor(trial / 32))*1.8
alter VB4 = $&drive
let drive = (floor(trial / 32) - 2*floor(trial / 64))*1.8
alter VB5 = $&drive
let drive = (floor(trial / 64) - 2*floor(trial / 128))*1.8
alter VB6 = $&drive
let drive = (floor(trial / 128) - 2*floor(trial / 256))*1.8
alter VB7 = $&drive
stop when time = 9e-05
resume
delete all
let endpoint = length(time)-1
let cmp = v(COMP)[endpoint]
let top = v(TOP)[endpoint]
let decision = 0
if cmp >= 0.9
let code = trial
let decision = 1
end
echo 4 0 $&trial $&cmp $&top 0.00703125 $&decision >> decisions.csv
alter VIN = 0.01171875
alter VSAMPLE = 1.8
alter VB0 = 0
alter VB1 = 0
alter VB2 = 0
alter VB3 = 0
alter VB4 = 0
alter VB5 = 0
alter VB6 = 0
alter VB7 = 0
let code = 0
stop when time = 9.2e-05
resume
delete all
alter VSAMPLE = 0
let trial = code + 128
let drive = (floor(trial / 1) - 2*floor(trial / 2))*1.8
alter VB0 = $&drive
let drive = (floor(trial / 2) - 2*floor(trial / 4))*1.8
alter VB1 = $&drive
let drive = (floor(trial / 4) - 2*floor(trial / 8))*1.8
alter VB2 = $&drive
let drive = (floor(trial / 8) - 2*floor(trial / 16))*1.8
alter VB3 = $&drive
let drive = (floor(trial / 16) - 2*floor(trial / 32))*1.8
alter VB4 = $&drive
let drive = (floor(trial / 32) - 2*floor(trial / 64))*1.8
alter VB5 = $&drive
let drive = (floor(trial / 64) - 2*floor(trial / 128))*1.8
alter VB6 = $&drive
let drive = (floor(trial / 128) - 2*floor(trial / 256))*1.8
alter VB7 = $&drive
stop when time = 9.4e-05
resume
delete all
let endpoint = length(time)-1
let cmp = v(COMP)[endpoint]
let top = v(TOP)[endpoint]
let decision = 0
if cmp >= 0.9
let code = trial
let decision = 1
end
echo 5 7 $&trial $&cmp $&top 0.01171875 $&decision >> decisions.csv
let trial = code + 64
let drive = (floor(trial / 1) - 2*floor(trial / 2))*1.8
alter VB0 = $&drive
let drive = (floor(trial / 2) - 2*floor(trial / 4))*1.8
alter VB1 = $&drive
let drive = (floor(trial / 4) - 2*floor(trial / 8))*1.8
alter VB2 = $&drive
let drive = (floor(trial / 8) - 2*floor(trial / 16))*1.8
alter VB3 = $&drive
let drive = (floor(trial / 16) - 2*floor(trial / 32))*1.8
alter VB4 = $&drive
let drive = (floor(trial / 32) - 2*floor(trial / 64))*1.8
alter VB5 = $&drive
let drive = (floor(trial / 64) - 2*floor(trial / 128))*1.8
alter VB6 = $&drive
let drive = (floor(trial / 128) - 2*floor(trial / 256))*1.8
alter VB7 = $&drive
stop when time = 9.6e-05
resume
delete all
let endpoint = length(time)-1
let cmp = v(COMP)[endpoint]
let top = v(TOP)[endpoint]
let decision = 0
if cmp >= 0.9
let code = trial
let decision = 1
end
echo 5 6 $&trial $&cmp $&top 0.01171875 $&decision >> decisions.csv
let trial = code + 32
let drive = (floor(trial / 1) - 2*floor(trial / 2))*1.8
alter VB0 = $&drive
let drive = (floor(trial / 2) - 2*floor(trial / 4))*1.8
alter VB1 = $&drive
let drive = (floor(trial / 4) - 2*floor(trial / 8))*1.8
alter VB2 = $&drive
let drive = (floor(trial / 8) - 2*floor(trial / 16))*1.8
alter VB3 = $&drive
let drive = (floor(trial / 16) - 2*floor(trial / 32))*1.8
alter VB4 = $&drive
let drive = (floor(trial / 32) - 2*floor(trial / 64))*1.8
alter VB5 = $&drive
let drive = (floor(trial / 64) - 2*floor(trial / 128))*1.8
alter VB6 = $&drive
let drive = (floor(trial / 128) - 2*floor(trial / 256))*1.8
alter VB7 = $&drive
stop when time = 9.8e-05
resume
delete all
let endpoint = length(time)-1
let cmp = v(COMP)[endpoint]
let top = v(TOP)[endpoint]
let decision = 0
if cmp >= 0.9
let code = trial
let decision = 1
end
echo 5 5 $&trial $&cmp $&top 0.01171875 $&decision >> decisions.csv
let trial = code + 16
let drive = (floor(trial / 1) - 2*floor(trial / 2))*1.8
alter VB0 = $&drive
let drive = (floor(trial / 2) - 2*floor(trial / 4))*1.8
alter VB1 = $&drive
let drive = (floor(trial / 4) - 2*floor(trial / 8))*1.8
alter VB2 = $&drive
let drive = (floor(trial / 8) - 2*floor(trial / 16))*1.8
alter VB3 = $&drive
let drive = (floor(trial / 16) - 2*floor(trial / 32))*1.8
alter VB4 = $&drive
let drive = (floor(trial / 32) - 2*floor(trial / 64))*1.8
alter VB5 = $&drive
let drive = (floor(trial / 64) - 2*floor(trial / 128))*1.8
alter VB6 = $&drive
let drive = (floor(trial / 128) - 2*floor(trial / 256))*1.8
alter VB7 = $&drive
stop when time = 0.0001
resume
delete all
let endpoint = length(time)-1
let cmp = v(COMP)[endpoint]
let top = v(TOP)[endpoint]
let decision = 0
if cmp >= 0.9
let code = trial
let decision = 1
end
echo 5 4 $&trial $&cmp $&top 0.01171875 $&decision >> decisions.csv
let trial = code + 8
let drive = (floor(trial / 1) - 2*floor(trial / 2))*1.8
alter VB0 = $&drive
let drive = (floor(trial / 2) - 2*floor(trial / 4))*1.8
alter VB1 = $&drive
let drive = (floor(trial / 4) - 2*floor(trial / 8))*1.8
alter VB2 = $&drive
let drive = (floor(trial / 8) - 2*floor(trial / 16))*1.8
alter VB3 = $&drive
let drive = (floor(trial / 16) - 2*floor(trial / 32))*1.8
alter VB4 = $&drive
let drive = (floor(trial / 32) - 2*floor(trial / 64))*1.8
alter VB5 = $&drive
let drive = (floor(trial / 64) - 2*floor(trial / 128))*1.8
alter VB6 = $&drive
let drive = (floor(trial / 128) - 2*floor(trial / 256))*1.8
alter VB7 = $&drive
stop when time = 0.000102
resume
delete all
let endpoint = length(time)-1
let cmp = v(COMP)[endpoint]
let top = v(TOP)[endpoint]
let decision = 0
if cmp >= 0.9
let code = trial
let decision = 1
end
echo 5 3 $&trial $&cmp $&top 0.01171875 $&decision >> decisions.csv
let trial = code + 4
let drive = (floor(trial / 1) - 2*floor(trial / 2))*1.8
alter VB0 = $&drive
let drive = (floor(trial / 2) - 2*floor(trial / 4))*1.8
alter VB1 = $&drive
let drive = (floor(trial / 4) - 2*floor(trial / 8))*1.8
alter VB2 = $&drive
let drive = (floor(trial / 8) - 2*floor(trial / 16))*1.8
alter VB3 = $&drive
let drive = (floor(trial / 16) - 2*floor(trial / 32))*1.8
alter VB4 = $&drive
let drive = (floor(trial / 32) - 2*floor(trial / 64))*1.8
alter VB5 = $&drive
let drive = (floor(trial / 64) - 2*floor(trial / 128))*1.8
alter VB6 = $&drive
let drive = (floor(trial / 128) - 2*floor(trial / 256))*1.8
alter VB7 = $&drive
stop when time = 0.000104
resume
delete all
let endpoint = length(time)-1
let cmp = v(COMP)[endpoint]
let top = v(TOP)[endpoint]
let decision = 0
if cmp >= 0.9
let code = trial
let decision = 1
end
echo 5 2 $&trial $&cmp $&top 0.01171875 $&decision >> decisions.csv
let trial = code + 2
let drive = (floor(trial / 1) - 2*floor(trial / 2))*1.8
alter VB0 = $&drive
let drive = (floor(trial / 2) - 2*floor(trial / 4))*1.8
alter VB1 = $&drive
let drive = (floor(trial / 4) - 2*floor(trial / 8))*1.8
alter VB2 = $&drive
let drive = (floor(trial / 8) - 2*floor(trial / 16))*1.8
alter VB3 = $&drive
let drive = (floor(trial / 16) - 2*floor(trial / 32))*1.8
alter VB4 = $&drive
let drive = (floor(trial / 32) - 2*floor(trial / 64))*1.8
alter VB5 = $&drive
let drive = (floor(trial / 64) - 2*floor(trial / 128))*1.8
alter VB6 = $&drive
let drive = (floor(trial / 128) - 2*floor(trial / 256))*1.8
alter VB7 = $&drive
stop when time = 0.000106
resume
delete all
let endpoint = length(time)-1
let cmp = v(COMP)[endpoint]
let top = v(TOP)[endpoint]
let decision = 0
if cmp >= 0.9
let code = trial
let decision = 1
end
echo 5 1 $&trial $&cmp $&top 0.01171875 $&decision >> decisions.csv
let trial = code + 1
let drive = (floor(trial / 1) - 2*floor(trial / 2))*1.8
alter VB0 = $&drive
let drive = (floor(trial / 2) - 2*floor(trial / 4))*1.8
alter VB1 = $&drive
let drive = (floor(trial / 4) - 2*floor(trial / 8))*1.8
alter VB2 = $&drive
let drive = (floor(trial / 8) - 2*floor(trial / 16))*1.8
alter VB3 = $&drive
let drive = (floor(trial / 16) - 2*floor(trial / 32))*1.8
alter VB4 = $&drive
let drive = (floor(trial / 32) - 2*floor(trial / 64))*1.8
alter VB5 = $&drive
let drive = (floor(trial / 64) - 2*floor(trial / 128))*1.8
alter VB6 = $&drive
let drive = (floor(trial / 128) - 2*floor(trial / 256))*1.8
alter VB7 = $&drive
stop when time = 0.000108
resume
delete all
let endpoint = length(time)-1
let cmp = v(COMP)[endpoint]
let top = v(TOP)[endpoint]
let decision = 0
if cmp >= 0.9
let code = trial
let decision = 1
end
echo 5 0 $&trial $&cmp $&top 0.01171875 $&decision >> decisions.csv
alter VIN = 0.01640625
alter VSAMPLE = 1.8
alter VB0 = 0
alter VB1 = 0
alter VB2 = 0
alter VB3 = 0
alter VB4 = 0
alter VB5 = 0
alter VB6 = 0
alter VB7 = 0
let code = 0
stop when time = 0.00011
resume
delete all
alter VSAMPLE = 0
let trial = code + 128
let drive = (floor(trial / 1) - 2*floor(trial / 2))*1.8
alter VB0 = $&drive
let drive = (floor(trial / 2) - 2*floor(trial / 4))*1.8
alter VB1 = $&drive
let drive = (floor(trial / 4) - 2*floor(trial / 8))*1.8
alter VB2 = $&drive
let drive = (floor(trial / 8) - 2*floor(trial / 16))*1.8
alter VB3 = $&drive
let drive = (floor(trial / 16) - 2*floor(trial / 32))*1.8
alter VB4 = $&drive
let drive = (floor(trial / 32) - 2*floor(trial / 64))*1.8
alter VB5 = $&drive
let drive = (floor(trial / 64) - 2*floor(trial / 128))*1.8
alter VB6 = $&drive
let drive = (floor(trial / 128) - 2*floor(trial / 256))*1.8
alter VB7 = $&drive
stop when time = 0.000112
resume
delete all
let endpoint = length(time)-1
let cmp = v(COMP)[endpoint]
let top = v(TOP)[endpoint]
let decision = 0
if cmp >= 0.9
let code = trial
let decision = 1
end
echo 6 7 $&trial $&cmp $&top 0.01640625 $&decision >> decisions.csv
let trial = code + 64
let drive = (floor(trial / 1) - 2*floor(trial / 2))*1.8
alter VB0 = $&drive
let drive = (floor(trial / 2) - 2*floor(trial / 4))*1.8
alter VB1 = $&drive
let drive = (floor(trial / 4) - 2*floor(trial / 8))*1.8
alter VB2 = $&drive
let drive = (floor(trial / 8) - 2*floor(trial / 16))*1.8
alter VB3 = $&drive
let drive = (floor(trial / 16) - 2*floor(trial / 32))*1.8
alter VB4 = $&drive
let drive = (floor(trial / 32) - 2*floor(trial / 64))*1.8
alter VB5 = $&drive
let drive = (floor(trial / 64) - 2*floor(trial / 128))*1.8
alter VB6 = $&drive
let drive = (floor(trial / 128) - 2*floor(trial / 256))*1.8
alter VB7 = $&drive
stop when time = 0.000114
resume
delete all
let endpoint = length(time)-1
let cmp = v(COMP)[endpoint]
let top = v(TOP)[endpoint]
let decision = 0
if cmp >= 0.9
let code = trial
let decision = 1
end
echo 6 6 $&trial $&cmp $&top 0.01640625 $&decision >> decisions.csv
let trial = code + 32
let drive = (floor(trial / 1) - 2*floor(trial / 2))*1.8
alter VB0 = $&drive
let drive = (floor(trial / 2) - 2*floor(trial / 4))*1.8
alter VB1 = $&drive
let drive = (floor(trial / 4) - 2*floor(trial / 8))*1.8
alter VB2 = $&drive
let drive = (floor(trial / 8) - 2*floor(trial / 16))*1.8
alter VB3 = $&drive
let drive = (floor(trial / 16) - 2*floor(trial / 32))*1.8
alter VB4 = $&drive
let drive = (floor(trial / 32) - 2*floor(trial / 64))*1.8
alter VB5 = $&drive
let drive = (floor(trial / 64) - 2*floor(trial / 128))*1.8
alter VB6 = $&drive
let drive = (floor(trial / 128) - 2*floor(trial / 256))*1.8
alter VB7 = $&drive
stop when time = 0.000116
resume
delete all
let endpoint = length(time)-1
let cmp = v(COMP)[endpoint]
let top = v(TOP)[endpoint]
let decision = 0
if cmp >= 0.9
let code = trial
let decision = 1
end
echo 6 5 $&trial $&cmp $&top 0.01640625 $&decision >> decisions.csv
let trial = code + 16
let drive = (floor(trial / 1) - 2*floor(trial / 2))*1.8
alter VB0 = $&drive
let drive = (floor(trial / 2) - 2*floor(trial / 4))*1.8
alter VB1 = $&drive
let drive = (floor(trial / 4) - 2*floor(trial / 8))*1.8
alter VB2 = $&drive
let drive = (floor(trial / 8) - 2*floor(trial / 16))*1.8
alter VB3 = $&drive
let drive = (floor(trial / 16) - 2*floor(trial / 32))*1.8
alter VB4 = $&drive
let drive = (floor(trial / 32) - 2*floor(trial / 64))*1.8
alter VB5 = $&drive
let drive = (floor(trial / 64) - 2*floor(trial / 128))*1.8
alter VB6 = $&drive
let drive = (floor(trial / 128) - 2*floor(trial / 256))*1.8
alter VB7 = $&drive
stop when time = 0.000118
resume
delete all
let endpoint = length(time)-1
let cmp = v(COMP)[endpoint]
let top = v(TOP)[endpoint]
let decision = 0
if cmp >= 0.9
let code = trial
let decision = 1
end
echo 6 4 $&trial $&cmp $&top 0.01640625 $&decision >> decisions.csv
let trial = code + 8
let drive = (floor(trial / 1) - 2*floor(trial / 2))*1.8
alter VB0 = $&drive
let drive = (floor(trial / 2) - 2*floor(trial / 4))*1.8
alter VB1 = $&drive
let drive = (floor(trial / 4) - 2*floor(trial / 8))*1.8
alter VB2 = $&drive
let drive = (floor(trial / 8) - 2*floor(trial / 16))*1.8
alter VB3 = $&drive
let drive = (floor(trial / 16) - 2*floor(trial / 32))*1.8
alter VB4 = $&drive
let drive = (floor(trial / 32) - 2*floor(trial / 64))*1.8
alter VB5 = $&drive
let drive = (floor(trial / 64) - 2*floor(trial / 128))*1.8
alter VB6 = $&drive
let drive = (floor(trial / 128) - 2*floor(trial / 256))*1.8
alter VB7 = $&drive
stop when time = 0.00012
resume
delete all
let endpoint = length(time)-1
let cmp = v(COMP)[endpoint]
let top = v(TOP)[endpoint]
let decision = 0
if cmp >= 0.9
let code = trial
let decision = 1
end
echo 6 3 $&trial $&cmp $&top 0.01640625 $&decision >> decisions.csv
let trial = code + 4
let drive = (floor(trial / 1) - 2*floor(trial / 2))*1.8
alter VB0 = $&drive
let drive = (floor(trial / 2) - 2*floor(trial / 4))*1.8
alter VB1 = $&drive
let drive = (floor(trial / 4) - 2*floor(trial / 8))*1.8
alter VB2 = $&drive
let drive = (floor(trial / 8) - 2*floor(trial / 16))*1.8
alter VB3 = $&drive
let drive = (floor(trial / 16) - 2*floor(trial / 32))*1.8
alter VB4 = $&drive
let drive = (floor(trial / 32) - 2*floor(trial / 64))*1.8
alter VB5 = $&drive
let drive = (floor(trial / 64) - 2*floor(trial / 128))*1.8
alter VB6 = $&drive
let drive = (floor(trial / 128) - 2*floor(trial / 256))*1.8
alter VB7 = $&drive
stop when time = 0.000122
resume
delete all
let endpoint = length(time)-1
let cmp = v(COMP)[endpoint]
let top = v(TOP)[endpoint]
let decision = 0
if cmp >= 0.9
let code = trial
let decision = 1
end
echo 6 2 $&trial $&cmp $&top 0.01640625 $&decision >> decisions.csv
let trial = code + 2
let drive = (floor(trial / 1) - 2*floor(trial / 2))*1.8
alter VB0 = $&drive
let drive = (floor(trial / 2) - 2*floor(trial / 4))*1.8
alter VB1 = $&drive
let drive = (floor(trial / 4) - 2*floor(trial / 8))*1.8
alter VB2 = $&drive
let drive = (floor(trial / 8) - 2*floor(trial / 16))*1.8
alter VB3 = $&drive
let drive = (floor(trial / 16) - 2*floor(trial / 32))*1.8
alter VB4 = $&drive
let drive = (floor(trial / 32) - 2*floor(trial / 64))*1.8
alter VB5 = $&drive
let drive = (floor(trial / 64) - 2*floor(trial / 128))*1.8
alter VB6 = $&drive
let drive = (floor(trial / 128) - 2*floor(trial / 256))*1.8
alter VB7 = $&drive
stop when time = 0.000124
resume
delete all
let endpoint = length(time)-1
let cmp = v(COMP)[endpoint]
let top = v(TOP)[endpoint]
let decision = 0
if cmp >= 0.9
let code = trial
let decision = 1
end
echo 6 1 $&trial $&cmp $&top 0.01640625 $&decision >> decisions.csv
let trial = code + 1
let drive = (floor(trial / 1) - 2*floor(trial / 2))*1.8
alter VB0 = $&drive
let drive = (floor(trial / 2) - 2*floor(trial / 4))*1.8
alter VB1 = $&drive
let drive = (floor(trial / 4) - 2*floor(trial / 8))*1.8
alter VB2 = $&drive
let drive = (floor(trial / 8) - 2*floor(trial / 16))*1.8
alter VB3 = $&drive
let drive = (floor(trial / 16) - 2*floor(trial / 32))*1.8
alter VB4 = $&drive
let drive = (floor(trial / 32) - 2*floor(trial / 64))*1.8
alter VB5 = $&drive
let drive = (floor(trial / 64) - 2*floor(trial / 128))*1.8
alter VB6 = $&drive
let drive = (floor(trial / 128) - 2*floor(trial / 256))*1.8
alter VB7 = $&drive
stop when time = 0.000126
resume
delete all
let endpoint = length(time)-1
let cmp = v(COMP)[endpoint]
let top = v(TOP)[endpoint]
let decision = 0
if cmp >= 0.9
let code = trial
let decision = 1
end
echo 6 0 $&trial $&cmp $&top 0.01640625 $&decision >> decisions.csv
alter VIN = 0.02109375
alter VSAMPLE = 1.8
alter VB0 = 0
alter VB1 = 0
alter VB2 = 0
alter VB3 = 0
alter VB4 = 0
alter VB5 = 0
alter VB6 = 0
alter VB7 = 0
let code = 0
stop when time = 0.000128
resume
delete all
alter VSAMPLE = 0
let trial = code + 128
let drive = (floor(trial / 1) - 2*floor(trial / 2))*1.8
alter VB0 = $&drive
let drive = (floor(trial / 2) - 2*floor(trial / 4))*1.8
alter VB1 = $&drive
let drive = (floor(trial / 4) - 2*floor(trial / 8))*1.8
alter VB2 = $&drive
let drive = (floor(trial / 8) - 2*floor(trial / 16))*1.8
alter VB3 = $&drive
let drive = (floor(trial / 16) - 2*floor(trial / 32))*1.8
alter VB4 = $&drive
let drive = (floor(trial / 32) - 2*floor(trial / 64))*1.8
alter VB5 = $&drive
let drive = (floor(trial / 64) - 2*floor(trial / 128))*1.8
alter VB6 = $&drive
let drive = (floor(trial / 128) - 2*floor(trial / 256))*1.8
alter VB7 = $&drive
stop when time = 0.00013
resume
delete all
let endpoint = length(time)-1
let cmp = v(COMP)[endpoint]
let top = v(TOP)[endpoint]
let decision = 0
if cmp >= 0.9
let code = trial
let decision = 1
end
echo 7 7 $&trial $&cmp $&top 0.02109375 $&decision >> decisions.csv
let trial = code + 64
let drive = (floor(trial / 1) - 2*floor(trial / 2))*1.8
alter VB0 = $&drive
let drive = (floor(trial / 2) - 2*floor(trial / 4))*1.8
alter VB1 = $&drive
let drive = (floor(trial / 4) - 2*floor(trial / 8))*1.8
alter VB2 = $&drive
let drive = (floor(trial / 8) - 2*floor(trial / 16))*1.8
alter VB3 = $&drive
let drive = (floor(trial / 16) - 2*floor(trial / 32))*1.8
alter VB4 = $&drive
let drive = (floor(trial / 32) - 2*floor(trial / 64))*1.8
alter VB5 = $&drive
let drive = (floor(trial / 64) - 2*floor(trial / 128))*1.8
alter VB6 = $&drive
let drive = (floor(trial / 128) - 2*floor(trial / 256))*1.8
alter VB7 = $&drive
stop when time = 0.000132
resume
delete all
let endpoint = length(time)-1
let cmp = v(COMP)[endpoint]
let top = v(TOP)[endpoint]
let decision = 0
if cmp >= 0.9
let code = trial
let decision = 1
end
echo 7 6 $&trial $&cmp $&top 0.02109375 $&decision >> decisions.csv
let trial = code + 32
let drive = (floor(trial / 1) - 2*floor(trial / 2))*1.8
alter VB0 = $&drive
let drive = (floor(trial / 2) - 2*floor(trial / 4))*1.8
alter VB1 = $&drive
let drive = (floor(trial / 4) - 2*floor(trial / 8))*1.8
alter VB2 = $&drive
let drive = (floor(trial / 8) - 2*floor(trial / 16))*1.8
alter VB3 = $&drive
let drive = (floor(trial / 16) - 2*floor(trial / 32))*1.8
alter VB4 = $&drive
let drive = (floor(trial / 32) - 2*floor(trial / 64))*1.8
alter VB5 = $&drive
let drive = (floor(trial / 64) - 2*floor(trial / 128))*1.8
alter VB6 = $&drive
let drive = (floor(trial / 128) - 2*floor(trial / 256))*1.8
alter VB7 = $&drive
stop when time = 0.000134
resume
delete all
let endpoint = length(time)-1
let cmp = v(COMP)[endpoint]
let top = v(TOP)[endpoint]
let decision = 0
if cmp >= 0.9
let code = trial
let decision = 1
end
echo 7 5 $&trial $&cmp $&top 0.02109375 $&decision >> decisions.csv
let trial = code + 16
let drive = (floor(trial / 1) - 2*floor(trial / 2))*1.8
alter VB0 = $&drive
let drive = (floor(trial / 2) - 2*floor(trial / 4))*1.8
alter VB1 = $&drive
let drive = (floor(trial / 4) - 2*floor(trial / 8))*1.8
alter VB2 = $&drive
let drive = (floor(trial / 8) - 2*floor(trial / 16))*1.8
alter VB3 = $&drive
let drive = (floor(trial / 16) - 2*floor(trial / 32))*1.8
alter VB4 = $&drive
let drive = (floor(trial / 32) - 2*floor(trial / 64))*1.8
alter VB5 = $&drive
let drive = (floor(trial / 64) - 2*floor(trial / 128))*1.8
alter VB6 = $&drive
let drive = (floor(trial / 128) - 2*floor(trial / 256))*1.8
alter VB7 = $&drive
stop when time = 0.000136
resume
delete all
let endpoint = length(time)-1
let cmp = v(COMP)[endpoint]
let top = v(TOP)[endpoint]
let decision = 0
if cmp >= 0.9
let code = trial
let decision = 1
end
echo 7 4 $&trial $&cmp $&top 0.02109375 $&decision >> decisions.csv
let trial = code + 8
let drive = (floor(trial / 1) - 2*floor(trial / 2))*1.8
alter VB0 = $&drive
let drive = (floor(trial / 2) - 2*floor(trial / 4))*1.8
alter VB1 = $&drive
let drive = (floor(trial / 4) - 2*floor(trial / 8))*1.8
alter VB2 = $&drive
let drive = (floor(trial / 8) - 2*floor(trial / 16))*1.8
alter VB3 = $&drive
let drive = (floor(trial / 16) - 2*floor(trial / 32))*1.8
alter VB4 = $&drive
let drive = (floor(trial / 32) - 2*floor(trial / 64))*1.8
alter VB5 = $&drive
let drive = (floor(trial / 64) - 2*floor(trial / 128))*1.8
alter VB6 = $&drive
let drive = (floor(trial / 128) - 2*floor(trial / 256))*1.8
alter VB7 = $&drive
stop when time = 0.000138
resume
delete all
let endpoint = length(time)-1
let cmp = v(COMP)[endpoint]
let top = v(TOP)[endpoint]
let decision = 0
if cmp >= 0.9
let code = trial
let decision = 1
end
echo 7 3 $&trial $&cmp $&top 0.02109375 $&decision >> decisions.csv
let trial = code + 4
let drive = (floor(trial / 1) - 2*floor(trial / 2))*1.8
alter VB0 = $&drive
let drive = (floor(trial / 2) - 2*floor(trial / 4))*1.8
alter VB1 = $&drive
let drive = (floor(trial / 4) - 2*floor(trial / 8))*1.8
alter VB2 = $&drive
let drive = (floor(trial / 8) - 2*floor(trial / 16))*1.8
alter VB3 = $&drive
let drive = (floor(trial / 16) - 2*floor(trial / 32))*1.8
alter VB4 = $&drive
let drive = (floor(trial / 32) - 2*floor(trial / 64))*1.8
alter VB5 = $&drive
let drive = (floor(trial / 64) - 2*floor(trial / 128))*1.8
alter VB6 = $&drive
let drive = (floor(trial / 128) - 2*floor(trial / 256))*1.8
alter VB7 = $&drive
stop when time = 0.00014
resume
delete all
let endpoint = length(time)-1
let cmp = v(COMP)[endpoint]
let top = v(TOP)[endpoint]
let decision = 0
if cmp >= 0.9
let code = trial
let decision = 1
end
echo 7 2 $&trial $&cmp $&top 0.02109375 $&decision >> decisions.csv
let trial = code + 2
let drive = (floor(trial / 1) - 2*floor(trial / 2))*1.8
alter VB0 = $&drive
let drive = (floor(trial / 2) - 2*floor(trial / 4))*1.8
alter VB1 = $&drive
let drive = (floor(trial / 4) - 2*floor(trial / 8))*1.8
alter VB2 = $&drive
let drive = (floor(trial / 8) - 2*floor(trial / 16))*1.8
alter VB3 = $&drive
let drive = (floor(trial / 16) - 2*floor(trial / 32))*1.8
alter VB4 = $&drive
let drive = (floor(trial / 32) - 2*floor(trial / 64))*1.8
alter VB5 = $&drive
let drive = (floor(trial / 64) - 2*floor(trial / 128))*1.8
alter VB6 = $&drive
let drive = (floor(trial / 128) - 2*floor(trial / 256))*1.8
alter VB7 = $&drive
stop when time = 0.000142
resume
delete all
let endpoint = length(time)-1
let cmp = v(COMP)[endpoint]
let top = v(TOP)[endpoint]
let decision = 0
if cmp >= 0.9
let code = trial
let decision = 1
end
echo 7 1 $&trial $&cmp $&top 0.02109375 $&decision >> decisions.csv
let trial = code + 1
let drive = (floor(trial / 1) - 2*floor(trial / 2))*1.8
alter VB0 = $&drive
let drive = (floor(trial / 2) - 2*floor(trial / 4))*1.8
alter VB1 = $&drive
let drive = (floor(trial / 4) - 2*floor(trial / 8))*1.8
alter VB2 = $&drive
let drive = (floor(trial / 8) - 2*floor(trial / 16))*1.8
alter VB3 = $&drive
let drive = (floor(trial / 16) - 2*floor(trial / 32))*1.8
alter VB4 = $&drive
let drive = (floor(trial / 32) - 2*floor(trial / 64))*1.8
alter VB5 = $&drive
let drive = (floor(trial / 64) - 2*floor(trial / 128))*1.8
alter VB6 = $&drive
let drive = (floor(trial / 128) - 2*floor(trial / 256))*1.8
alter VB7 = $&drive
stop when time = 0.000144
resume
delete all
let endpoint = length(time)-1
let cmp = v(COMP)[endpoint]
let top = v(TOP)[endpoint]
let decision = 0
if cmp >= 0.9
let code = trial
let decision = 1
end
echo 7 0 $&trial $&cmp $&top 0.02109375 $&decision >> decisions.csv
alter VIN = 0.02578125
alter VSAMPLE = 1.8
alter VB0 = 0
alter VB1 = 0
alter VB2 = 0
alter VB3 = 0
alter VB4 = 0
alter VB5 = 0
alter VB6 = 0
alter VB7 = 0
let code = 0
stop when time = 0.000146
resume
delete all
alter VSAMPLE = 0
let trial = code + 128
let drive = (floor(trial / 1) - 2*floor(trial / 2))*1.8
alter VB0 = $&drive
let drive = (floor(trial / 2) - 2*floor(trial / 4))*1.8
alter VB1 = $&drive
let drive = (floor(trial / 4) - 2*floor(trial / 8))*1.8
alter VB2 = $&drive
let drive = (floor(trial / 8) - 2*floor(trial / 16))*1.8
alter VB3 = $&drive
let drive = (floor(trial / 16) - 2*floor(trial / 32))*1.8
alter VB4 = $&drive
let drive = (floor(trial / 32) - 2*floor(trial / 64))*1.8
alter VB5 = $&drive
let drive = (floor(trial / 64) - 2*floor(trial / 128))*1.8
alter VB6 = $&drive
let drive = (floor(trial / 128) - 2*floor(trial / 256))*1.8
alter VB7 = $&drive
stop when time = 0.000148
resume
delete all
let endpoint = length(time)-1
let cmp = v(COMP)[endpoint]
let top = v(TOP)[endpoint]
let decision = 0
if cmp >= 0.9
let code = trial
let decision = 1
end
echo 8 7 $&trial $&cmp $&top 0.02578125 $&decision >> decisions.csv
let trial = code + 64
let drive = (floor(trial / 1) - 2*floor(trial / 2))*1.8
alter VB0 = $&drive
let drive = (floor(trial / 2) - 2*floor(trial / 4))*1.8
alter VB1 = $&drive
let drive = (floor(trial / 4) - 2*floor(trial / 8))*1.8
alter VB2 = $&drive
let drive = (floor(trial / 8) - 2*floor(trial / 16))*1.8
alter VB3 = $&drive
let drive = (floor(trial / 16) - 2*floor(trial / 32))*1.8
alter VB4 = $&drive
let drive = (floor(trial / 32) - 2*floor(trial / 64))*1.8
alter VB5 = $&drive
let drive = (floor(trial / 64) - 2*floor(trial / 128))*1.8
alter VB6 = $&drive
let drive = (floor(trial / 128) - 2*floor(trial / 256))*1.8
alter VB7 = $&drive
stop when time = 0.00015
resume
delete all
let endpoint = length(time)-1
let cmp = v(COMP)[endpoint]
let top = v(TOP)[endpoint]
let decision = 0
if cmp >= 0.9
let code = trial
let decision = 1
end
echo 8 6 $&trial $&cmp $&top 0.02578125 $&decision >> decisions.csv
let trial = code + 32
let drive = (floor(trial / 1) - 2*floor(trial / 2))*1.8
alter VB0 = $&drive
let drive = (floor(trial / 2) - 2*floor(trial / 4))*1.8
alter VB1 = $&drive
let drive = (floor(trial / 4) - 2*floor(trial / 8))*1.8
alter VB2 = $&drive
let drive = (floor(trial / 8) - 2*floor(trial / 16))*1.8
alter VB3 = $&drive
let drive = (floor(trial / 16) - 2*floor(trial / 32))*1.8
alter VB4 = $&drive
let drive = (floor(trial / 32) - 2*floor(trial / 64))*1.8
alter VB5 = $&drive
let drive = (floor(trial / 64) - 2*floor(trial / 128))*1.8
alter VB6 = $&drive
let drive = (floor(trial / 128) - 2*floor(trial / 256))*1.8
alter VB7 = $&drive
stop when time = 0.000152
resume
delete all
let endpoint = length(time)-1
let cmp = v(COMP)[endpoint]
let top = v(TOP)[endpoint]
let decision = 0
if cmp >= 0.9
let code = trial
let decision = 1
end
echo 8 5 $&trial $&cmp $&top 0.02578125 $&decision >> decisions.csv
let trial = code + 16
let drive = (floor(trial / 1) - 2*floor(trial / 2))*1.8
alter VB0 = $&drive
let drive = (floor(trial / 2) - 2*floor(trial / 4))*1.8
alter VB1 = $&drive
let drive = (floor(trial / 4) - 2*floor(trial / 8))*1.8
alter VB2 = $&drive
let drive = (floor(trial / 8) - 2*floor(trial / 16))*1.8
alter VB3 = $&drive
let drive = (floor(trial / 16) - 2*floor(trial / 32))*1.8
alter VB4 = $&drive
let drive = (floor(trial / 32) - 2*floor(trial / 64))*1.8
alter VB5 = $&drive
let drive = (floor(trial / 64) - 2*floor(trial / 128))*1.8
alter VB6 = $&drive
let drive = (floor(trial / 128) - 2*floor(trial / 256))*1.8
alter VB7 = $&drive
stop when time = 0.000154
resume
delete all
let endpoint = length(time)-1
let cmp = v(COMP)[endpoint]
let top = v(TOP)[endpoint]
let decision = 0
if cmp >= 0.9
let code = trial
let decision = 1
end
echo 8 4 $&trial $&cmp $&top 0.02578125 $&decision >> decisions.csv
let trial = code + 8
let drive = (floor(trial / 1) - 2*floor(trial / 2))*1.8
alter VB0 = $&drive
let drive = (floor(trial / 2) - 2*floor(trial / 4))*1.8
alter VB1 = $&drive
let drive = (floor(trial / 4) - 2*floor(trial / 8))*1.8
alter VB2 = $&drive
let drive = (floor(trial / 8) - 2*floor(trial / 16))*1.8
alter VB3 = $&drive
let drive = (floor(trial / 16) - 2*floor(trial / 32))*1.8
alter VB4 = $&drive
let drive = (floor(trial / 32) - 2*floor(trial / 64))*1.8
alter VB5 = $&drive
let drive = (floor(trial / 64) - 2*floor(trial / 128))*1.8
alter VB6 = $&drive
let drive = (floor(trial / 128) - 2*floor(trial / 256))*1.8
alter VB7 = $&drive
stop when time = 0.000156
resume
delete all
let endpoint = length(time)-1
let cmp = v(COMP)[endpoint]
let top = v(TOP)[endpoint]
let decision = 0
if cmp >= 0.9
let code = trial
let decision = 1
end
echo 8 3 $&trial $&cmp $&top 0.02578125 $&decision >> decisions.csv
let trial = code + 4
let drive = (floor(trial / 1) - 2*floor(trial / 2))*1.8
alter VB0 = $&drive
let drive = (floor(trial / 2) - 2*floor(trial / 4))*1.8
alter VB1 = $&drive
let drive = (floor(trial / 4) - 2*floor(trial / 8))*1.8
alter VB2 = $&drive
let drive = (floor(trial / 8) - 2*floor(trial / 16))*1.8
alter VB3 = $&drive
let drive = (floor(trial / 16) - 2*floor(trial / 32))*1.8
alter VB4 = $&drive
let drive = (floor(trial / 32) - 2*floor(trial / 64))*1.8
alter VB5 = $&drive
let drive = (floor(trial / 64) - 2*floor(trial / 128))*1.8
alter VB6 = $&drive
let drive = (floor(trial / 128) - 2*floor(trial / 256))*1.8
alter VB7 = $&drive
stop when time = 0.000158
resume
delete all
let endpoint = length(time)-1
let cmp = v(COMP)[endpoint]
let top = v(TOP)[endpoint]
let decision = 0
if cmp >= 0.9
let code = trial
let decision = 1
end
echo 8 2 $&trial $&cmp $&top 0.02578125 $&decision >> decisions.csv
let trial = code + 2
let drive = (floor(trial / 1) - 2*floor(trial / 2))*1.8
alter VB0 = $&drive
let drive = (floor(trial / 2) - 2*floor(trial / 4))*1.8
alter VB1 = $&drive
let drive = (floor(trial / 4) - 2*floor(trial / 8))*1.8
alter VB2 = $&drive
let drive = (floor(trial / 8) - 2*floor(trial / 16))*1.8
alter VB3 = $&drive
let drive = (floor(trial / 16) - 2*floor(trial / 32))*1.8
alter VB4 = $&drive
let drive = (floor(trial / 32) - 2*floor(trial / 64))*1.8
alter VB5 = $&drive
let drive = (floor(trial / 64) - 2*floor(trial / 128))*1.8
alter VB6 = $&drive
let drive = (floor(trial / 128) - 2*floor(trial / 256))*1.8
alter VB7 = $&drive
stop when time = 0.00016
resume
delete all
let endpoint = length(time)-1
let cmp = v(COMP)[endpoint]
let top = v(TOP)[endpoint]
let decision = 0
if cmp >= 0.9
let code = trial
let decision = 1
end
echo 8 1 $&trial $&cmp $&top 0.02578125 $&decision >> decisions.csv
let trial = code + 1
let drive = (floor(trial / 1) - 2*floor(trial / 2))*1.8
alter VB0 = $&drive
let drive = (floor(trial / 2) - 2*floor(trial / 4))*1.8
alter VB1 = $&drive
let drive = (floor(trial / 4) - 2*floor(trial / 8))*1.8
alter VB2 = $&drive
let drive = (floor(trial / 8) - 2*floor(trial / 16))*1.8
alter VB3 = $&drive
let drive = (floor(trial / 16) - 2*floor(trial / 32))*1.8
alter VB4 = $&drive
let drive = (floor(trial / 32) - 2*floor(trial / 64))*1.8
alter VB5 = $&drive
let drive = (floor(trial / 64) - 2*floor(trial / 128))*1.8
alter VB6 = $&drive
let drive = (floor(trial / 128) - 2*floor(trial / 256))*1.8
alter VB7 = $&drive
stop when time = 0.000162
resume
delete all
let endpoint = length(time)-1
let cmp = v(COMP)[endpoint]
let top = v(TOP)[endpoint]
let decision = 0
if cmp >= 0.9
let code = trial
let decision = 1
end
echo 8 0 $&trial $&cmp $&top 0.02578125 $&decision >> decisions.csv
alter VIN = 0.03046875
alter VSAMPLE = 1.8
alter VB0 = 0
alter VB1 = 0
alter VB2 = 0
alter VB3 = 0
alter VB4 = 0
alter VB5 = 0
alter VB6 = 0
alter VB7 = 0
let code = 0
stop when time = 0.000164
resume
delete all
alter VSAMPLE = 0
let trial = code + 128
let drive = (floor(trial / 1) - 2*floor(trial / 2))*1.8
alter VB0 = $&drive
let drive = (floor(trial / 2) - 2*floor(trial / 4))*1.8
alter VB1 = $&drive
let drive = (floor(trial / 4) - 2*floor(trial / 8))*1.8
alter VB2 = $&drive
let drive = (floor(trial / 8) - 2*floor(trial / 16))*1.8
alter VB3 = $&drive
let drive = (floor(trial / 16) - 2*floor(trial / 32))*1.8
alter VB4 = $&drive
let drive = (floor(trial / 32) - 2*floor(trial / 64))*1.8
alter VB5 = $&drive
let drive = (floor(trial / 64) - 2*floor(trial / 128))*1.8
alter VB6 = $&drive
let drive = (floor(trial / 128) - 2*floor(trial / 256))*1.8
alter VB7 = $&drive
stop when time = 0.000166
resume
delete all
let endpoint = length(time)-1
let cmp = v(COMP)[endpoint]
let top = v(TOP)[endpoint]
let decision = 0
if cmp >= 0.9
let code = trial
let decision = 1
end
echo 9 7 $&trial $&cmp $&top 0.03046875 $&decision >> decisions.csv
let trial = code + 64
let drive = (floor(trial / 1) - 2*floor(trial / 2))*1.8
alter VB0 = $&drive
let drive = (floor(trial / 2) - 2*floor(trial / 4))*1.8
alter VB1 = $&drive
let drive = (floor(trial / 4) - 2*floor(trial / 8))*1.8
alter VB2 = $&drive
let drive = (floor(trial / 8) - 2*floor(trial / 16))*1.8
alter VB3 = $&drive
let drive = (floor(trial / 16) - 2*floor(trial / 32))*1.8
alter VB4 = $&drive
let drive = (floor(trial / 32) - 2*floor(trial / 64))*1.8
alter VB5 = $&drive
let drive = (floor(trial / 64) - 2*floor(trial / 128))*1.8
alter VB6 = $&drive
let drive = (floor(trial / 128) - 2*floor(trial / 256))*1.8
alter VB7 = $&drive
stop when time = 0.000168
resume
delete all
let endpoint = length(time)-1
let cmp = v(COMP)[endpoint]
let top = v(TOP)[endpoint]
let decision = 0
if cmp >= 0.9
let code = trial
let decision = 1
end
echo 9 6 $&trial $&cmp $&top 0.03046875 $&decision >> decisions.csv
let trial = code + 32
let drive = (floor(trial / 1) - 2*floor(trial / 2))*1.8
alter VB0 = $&drive
let drive = (floor(trial / 2) - 2*floor(trial / 4))*1.8
alter VB1 = $&drive
let drive = (floor(trial / 4) - 2*floor(trial / 8))*1.8
alter VB2 = $&drive
let drive = (floor(trial / 8) - 2*floor(trial / 16))*1.8
alter VB3 = $&drive
let drive = (floor(trial / 16) - 2*floor(trial / 32))*1.8
alter VB4 = $&drive
let drive = (floor(trial / 32) - 2*floor(trial / 64))*1.8
alter VB5 = $&drive
let drive = (floor(trial / 64) - 2*floor(trial / 128))*1.8
alter VB6 = $&drive
let drive = (floor(trial / 128) - 2*floor(trial / 256))*1.8
alter VB7 = $&drive
stop when time = 0.00017
resume
delete all
let endpoint = length(time)-1
let cmp = v(COMP)[endpoint]
let top = v(TOP)[endpoint]
let decision = 0
if cmp >= 0.9
let code = trial
let decision = 1
end
echo 9 5 $&trial $&cmp $&top 0.03046875 $&decision >> decisions.csv
let trial = code + 16
let drive = (floor(trial / 1) - 2*floor(trial / 2))*1.8
alter VB0 = $&drive
let drive = (floor(trial / 2) - 2*floor(trial / 4))*1.8
alter VB1 = $&drive
let drive = (floor(trial / 4) - 2*floor(trial / 8))*1.8
alter VB2 = $&drive
let drive = (floor(trial / 8) - 2*floor(trial / 16))*1.8
alter VB3 = $&drive
let drive = (floor(trial / 16) - 2*floor(trial / 32))*1.8
alter VB4 = $&drive
let drive = (floor(trial / 32) - 2*floor(trial / 64))*1.8
alter VB5 = $&drive
let drive = (floor(trial / 64) - 2*floor(trial / 128))*1.8
alter VB6 = $&drive
let drive = (floor(trial / 128) - 2*floor(trial / 256))*1.8
alter VB7 = $&drive
stop when time = 0.000172
resume
delete all
let endpoint = length(time)-1
let cmp = v(COMP)[endpoint]
let top = v(TOP)[endpoint]
let decision = 0
if cmp >= 0.9
let code = trial
let decision = 1
end
echo 9 4 $&trial $&cmp $&top 0.03046875 $&decision >> decisions.csv
let trial = code + 8
let drive = (floor(trial / 1) - 2*floor(trial / 2))*1.8
alter VB0 = $&drive
let drive = (floor(trial / 2) - 2*floor(trial / 4))*1.8
alter VB1 = $&drive
let drive = (floor(trial / 4) - 2*floor(trial / 8))*1.8
alter VB2 = $&drive
let drive = (floor(trial / 8) - 2*floor(trial / 16))*1.8
alter VB3 = $&drive
let drive = (floor(trial / 16) - 2*floor(trial / 32))*1.8
alter VB4 = $&drive
let drive = (floor(trial / 32) - 2*floor(trial / 64))*1.8
alter VB5 = $&drive
let drive = (floor(trial / 64) - 2*floor(trial / 128))*1.8
alter VB6 = $&drive
let drive = (floor(trial / 128) - 2*floor(trial / 256))*1.8
alter VB7 = $&drive
stop when time = 0.000174
resume
delete all
let endpoint = length(time)-1
let cmp = v(COMP)[endpoint]
let top = v(TOP)[endpoint]
let decision = 0
if cmp >= 0.9
let code = trial
let decision = 1
end
echo 9 3 $&trial $&cmp $&top 0.03046875 $&decision >> decisions.csv
let trial = code + 4
let drive = (floor(trial / 1) - 2*floor(trial / 2))*1.8
alter VB0 = $&drive
let drive = (floor(trial / 2) - 2*floor(trial / 4))*1.8
alter VB1 = $&drive
let drive = (floor(trial / 4) - 2*floor(trial / 8))*1.8
alter VB2 = $&drive
let drive = (floor(trial / 8) - 2*floor(trial / 16))*1.8
alter VB3 = $&drive
let drive = (floor(trial / 16) - 2*floor(trial / 32))*1.8
alter VB4 = $&drive
let drive = (floor(trial / 32) - 2*floor(trial / 64))*1.8
alter VB5 = $&drive
let drive = (floor(trial / 64) - 2*floor(trial / 128))*1.8
alter VB6 = $&drive
let drive = (floor(trial / 128) - 2*floor(trial / 256))*1.8
alter VB7 = $&drive
stop when time = 0.000176
resume
delete all
let endpoint = length(time)-1
let cmp = v(COMP)[endpoint]
let top = v(TOP)[endpoint]
let decision = 0
if cmp >= 0.9
let code = trial
let decision = 1
end
echo 9 2 $&trial $&cmp $&top 0.03046875 $&decision >> decisions.csv
let trial = code + 2
let drive = (floor(trial / 1) - 2*floor(trial / 2))*1.8
alter VB0 = $&drive
let drive = (floor(trial / 2) - 2*floor(trial / 4))*1.8
alter VB1 = $&drive
let drive = (floor(trial / 4) - 2*floor(trial / 8))*1.8
alter VB2 = $&drive
let drive = (floor(trial / 8) - 2*floor(trial / 16))*1.8
alter VB3 = $&drive
let drive = (floor(trial / 16) - 2*floor(trial / 32))*1.8
alter VB4 = $&drive
let drive = (floor(trial / 32) - 2*floor(trial / 64))*1.8
alter VB5 = $&drive
let drive = (floor(trial / 64) - 2*floor(trial / 128))*1.8
alter VB6 = $&drive
let drive = (floor(trial / 128) - 2*floor(trial / 256))*1.8
alter VB7 = $&drive
stop when time = 0.000178
resume
delete all
let endpoint = length(time)-1
let cmp = v(COMP)[endpoint]
let top = v(TOP)[endpoint]
let decision = 0
if cmp >= 0.9
let code = trial
let decision = 1
end
echo 9 1 $&trial $&cmp $&top 0.03046875 $&decision >> decisions.csv
let trial = code + 1
let drive = (floor(trial / 1) - 2*floor(trial / 2))*1.8
alter VB0 = $&drive
let drive = (floor(trial / 2) - 2*floor(trial / 4))*1.8
alter VB1 = $&drive
let drive = (floor(trial / 4) - 2*floor(trial / 8))*1.8
alter VB2 = $&drive
let drive = (floor(trial / 8) - 2*floor(trial / 16))*1.8
alter VB3 = $&drive
let drive = (floor(trial / 16) - 2*floor(trial / 32))*1.8
alter VB4 = $&drive
let drive = (floor(trial / 32) - 2*floor(trial / 64))*1.8
alter VB5 = $&drive
let drive = (floor(trial / 64) - 2*floor(trial / 128))*1.8
alter VB6 = $&drive
let drive = (floor(trial / 128) - 2*floor(trial / 256))*1.8
alter VB7 = $&drive
stop when time = 0.00018
resume
delete all
let endpoint = length(time)-1
let cmp = v(COMP)[endpoint]
let top = v(TOP)[endpoint]
let decision = 0
if cmp >= 0.9
let code = trial
let decision = 1
end
echo 9 0 $&trial $&cmp $&top 0.03046875 $&decision >> decisions.csv
alter VIN = 0.03515625
alter VSAMPLE = 1.8
alter VB0 = 0
alter VB1 = 0
alter VB2 = 0
alter VB3 = 0
alter VB4 = 0
alter VB5 = 0
alter VB6 = 0
alter VB7 = 0
let code = 0
stop when time = 0.000182
resume
delete all
alter VSAMPLE = 0
let trial = code + 128
let drive = (floor(trial / 1) - 2*floor(trial / 2))*1.8
alter VB0 = $&drive
let drive = (floor(trial / 2) - 2*floor(trial / 4))*1.8
alter VB1 = $&drive
let drive = (floor(trial / 4) - 2*floor(trial / 8))*1.8
alter VB2 = $&drive
let drive = (floor(trial / 8) - 2*floor(trial / 16))*1.8
alter VB3 = $&drive
let drive = (floor(trial / 16) - 2*floor(trial / 32))*1.8
alter VB4 = $&drive
let drive = (floor(trial / 32) - 2*floor(trial / 64))*1.8
alter VB5 = $&drive
let drive = (floor(trial / 64) - 2*floor(trial / 128))*1.8
alter VB6 = $&drive
let drive = (floor(trial / 128) - 2*floor(trial / 256))*1.8
alter VB7 = $&drive
stop when time = 0.000184
resume
delete all
let endpoint = length(time)-1
let cmp = v(COMP)[endpoint]
let top = v(TOP)[endpoint]
let decision = 0
if cmp >= 0.9
let code = trial
let decision = 1
end
echo 10 7 $&trial $&cmp $&top 0.03515625 $&decision >> decisions.csv
let trial = code + 64
let drive = (floor(trial / 1) - 2*floor(trial / 2))*1.8
alter VB0 = $&drive
let drive = (floor(trial / 2) - 2*floor(trial / 4))*1.8
alter VB1 = $&drive
let drive = (floor(trial / 4) - 2*floor(trial / 8))*1.8
alter VB2 = $&drive
let drive = (floor(trial / 8) - 2*floor(trial / 16))*1.8
alter VB3 = $&drive
let drive = (floor(trial / 16) - 2*floor(trial / 32))*1.8
alter VB4 = $&drive
let drive = (floor(trial / 32) - 2*floor(trial / 64))*1.8
alter VB5 = $&drive
let drive = (floor(trial / 64) - 2*floor(trial / 128))*1.8
alter VB6 = $&drive
let drive = (floor(trial / 128) - 2*floor(trial / 256))*1.8
alter VB7 = $&drive
stop when time = 0.000186
resume
delete all
let endpoint = length(time)-1
let cmp = v(COMP)[endpoint]
let top = v(TOP)[endpoint]
let decision = 0
if cmp >= 0.9
let code = trial
let decision = 1
end
echo 10 6 $&trial $&cmp $&top 0.03515625 $&decision >> decisions.csv
let trial = code + 32
let drive = (floor(trial / 1) - 2*floor(trial / 2))*1.8
alter VB0 = $&drive
let drive = (floor(trial / 2) - 2*floor(trial / 4))*1.8
alter VB1 = $&drive
let drive = (floor(trial / 4) - 2*floor(trial / 8))*1.8
alter VB2 = $&drive
let drive = (floor(trial / 8) - 2*floor(trial / 16))*1.8
alter VB3 = $&drive
let drive = (floor(trial / 16) - 2*floor(trial / 32))*1.8
alter VB4 = $&drive
let drive = (floor(trial / 32) - 2*floor(trial / 64))*1.8
alter VB5 = $&drive
let drive = (floor(trial / 64) - 2*floor(trial / 128))*1.8
alter VB6 = $&drive
let drive = (floor(trial / 128) - 2*floor(trial / 256))*1.8
alter VB7 = $&drive
stop when time = 0.000188
resume
delete all
let endpoint = length(time)-1
let cmp = v(COMP)[endpoint]
let top = v(TOP)[endpoint]
let decision = 0
if cmp >= 0.9
let code = trial
let decision = 1
end
echo 10 5 $&trial $&cmp $&top 0.03515625 $&decision >> decisions.csv
let trial = code + 16
let drive = (floor(trial / 1) - 2*floor(trial / 2))*1.8
alter VB0 = $&drive
let drive = (floor(trial / 2) - 2*floor(trial / 4))*1.8
alter VB1 = $&drive
let drive = (floor(trial / 4) - 2*floor(trial / 8))*1.8
alter VB2 = $&drive
let drive = (floor(trial / 8) - 2*floor(trial / 16))*1.8
alter VB3 = $&drive
let drive = (floor(trial / 16) - 2*floor(trial / 32))*1.8
alter VB4 = $&drive
let drive = (floor(trial / 32) - 2*floor(trial / 64))*1.8
alter VB5 = $&drive
let drive = (floor(trial / 64) - 2*floor(trial / 128))*1.8
alter VB6 = $&drive
let drive = (floor(trial / 128) - 2*floor(trial / 256))*1.8
alter VB7 = $&drive
stop when time = 0.00019
resume
delete all
let endpoint = length(time)-1
let cmp = v(COMP)[endpoint]
let top = v(TOP)[endpoint]
let decision = 0
if cmp >= 0.9
let code = trial
let decision = 1
end
echo 10 4 $&trial $&cmp $&top 0.03515625 $&decision >> decisions.csv
let trial = code + 8
let drive = (floor(trial / 1) - 2*floor(trial / 2))*1.8
alter VB0 = $&drive
let drive = (floor(trial / 2) - 2*floor(trial / 4))*1.8
alter VB1 = $&drive
let drive = (floor(trial / 4) - 2*floor(trial / 8))*1.8
alter VB2 = $&drive
let drive = (floor(trial / 8) - 2*floor(trial / 16))*1.8
alter VB3 = $&drive
let drive = (floor(trial / 16) - 2*floor(trial / 32))*1.8
alter VB4 = $&drive
let drive = (floor(trial / 32) - 2*floor(trial / 64))*1.8
alter VB5 = $&drive
let drive = (floor(trial / 64) - 2*floor(trial / 128))*1.8
alter VB6 = $&drive
let drive = (floor(trial / 128) - 2*floor(trial / 256))*1.8
alter VB7 = $&drive
stop when time = 0.000192
resume
delete all
let endpoint = length(time)-1
let cmp = v(COMP)[endpoint]
let top = v(TOP)[endpoint]
let decision = 0
if cmp >= 0.9
let code = trial
let decision = 1
end
echo 10 3 $&trial $&cmp $&top 0.03515625 $&decision >> decisions.csv
let trial = code + 4
let drive = (floor(trial / 1) - 2*floor(trial / 2))*1.8
alter VB0 = $&drive
let drive = (floor(trial / 2) - 2*floor(trial / 4))*1.8
alter VB1 = $&drive
let drive = (floor(trial / 4) - 2*floor(trial / 8))*1.8
alter VB2 = $&drive
let drive = (floor(trial / 8) - 2*floor(trial / 16))*1.8
alter VB3 = $&drive
let drive = (floor(trial / 16) - 2*floor(trial / 32))*1.8
alter VB4 = $&drive
let drive = (floor(trial / 32) - 2*floor(trial / 64))*1.8
alter VB5 = $&drive
let drive = (floor(trial / 64) - 2*floor(trial / 128))*1.8
alter VB6 = $&drive
let drive = (floor(trial / 128) - 2*floor(trial / 256))*1.8
alter VB7 = $&drive
stop when time = 0.000194
resume
delete all
let endpoint = length(time)-1
let cmp = v(COMP)[endpoint]
let top = v(TOP)[endpoint]
let decision = 0
if cmp >= 0.9
let code = trial
let decision = 1
end
echo 10 2 $&trial $&cmp $&top 0.03515625 $&decision >> decisions.csv
let trial = code + 2
let drive = (floor(trial / 1) - 2*floor(trial / 2))*1.8
alter VB0 = $&drive
let drive = (floor(trial / 2) - 2*floor(trial / 4))*1.8
alter VB1 = $&drive
let drive = (floor(trial / 4) - 2*floor(trial / 8))*1.8
alter VB2 = $&drive
let drive = (floor(trial / 8) - 2*floor(trial / 16))*1.8
alter VB3 = $&drive
let drive = (floor(trial / 16) - 2*floor(trial / 32))*1.8
alter VB4 = $&drive
let drive = (floor(trial / 32) - 2*floor(trial / 64))*1.8
alter VB5 = $&drive
let drive = (floor(trial / 64) - 2*floor(trial / 128))*1.8
alter VB6 = $&drive
let drive = (floor(trial / 128) - 2*floor(trial / 256))*1.8
alter VB7 = $&drive
stop when time = 0.000196
resume
delete all
let endpoint = length(time)-1
let cmp = v(COMP)[endpoint]
let top = v(TOP)[endpoint]
let decision = 0
if cmp >= 0.9
let code = trial
let decision = 1
end
echo 10 1 $&trial $&cmp $&top 0.03515625 $&decision >> decisions.csv
let trial = code + 1
let drive = (floor(trial / 1) - 2*floor(trial / 2))*1.8
alter VB0 = $&drive
let drive = (floor(trial / 2) - 2*floor(trial / 4))*1.8
alter VB1 = $&drive
let drive = (floor(trial / 4) - 2*floor(trial / 8))*1.8
alter VB2 = $&drive
let drive = (floor(trial / 8) - 2*floor(trial / 16))*1.8
alter VB3 = $&drive
let drive = (floor(trial / 16) - 2*floor(trial / 32))*1.8
alter VB4 = $&drive
let drive = (floor(trial / 32) - 2*floor(trial / 64))*1.8
alter VB5 = $&drive
let drive = (floor(trial / 64) - 2*floor(trial / 128))*1.8
alter VB6 = $&drive
let drive = (floor(trial / 128) - 2*floor(trial / 256))*1.8
alter VB7 = $&drive
stop when time = 0.000198
resume
delete all
let endpoint = length(time)-1
let cmp = v(COMP)[endpoint]
let top = v(TOP)[endpoint]
let decision = 0
if cmp >= 0.9
let code = trial
let decision = 1
end
echo 10 0 $&trial $&cmp $&top 0.03515625 $&decision >> decisions.csv
alter VIN = 0.03984375
alter VSAMPLE = 1.8
alter VB0 = 0
alter VB1 = 0
alter VB2 = 0
alter VB3 = 0
alter VB4 = 0
alter VB5 = 0
alter VB6 = 0
alter VB7 = 0
let code = 0
stop when time = 0.0002
resume
delete all
alter VSAMPLE = 0
let trial = code + 128
let drive = (floor(trial / 1) - 2*floor(trial / 2))*1.8
alter VB0 = $&drive
let drive = (floor(trial / 2) - 2*floor(trial / 4))*1.8
alter VB1 = $&drive
let drive = (floor(trial / 4) - 2*floor(trial / 8))*1.8
alter VB2 = $&drive
let drive = (floor(trial / 8) - 2*floor(trial / 16))*1.8
alter VB3 = $&drive
let drive = (floor(trial / 16) - 2*floor(trial / 32))*1.8
alter VB4 = $&drive
let drive = (floor(trial / 32) - 2*floor(trial / 64))*1.8
alter VB5 = $&drive
let drive = (floor(trial / 64) - 2*floor(trial / 128))*1.8
alter VB6 = $&drive
let drive = (floor(trial / 128) - 2*floor(trial / 256))*1.8
alter VB7 = $&drive
stop when time = 0.000202
resume
delete all
let endpoint = length(time)-1
let cmp = v(COMP)[endpoint]
let top = v(TOP)[endpoint]
let decision = 0
if cmp >= 0.9
let code = trial
let decision = 1
end
echo 11 7 $&trial $&cmp $&top 0.03984375 $&decision >> decisions.csv
let trial = code + 64
let drive = (floor(trial / 1) - 2*floor(trial / 2))*1.8
alter VB0 = $&drive
let drive = (floor(trial / 2) - 2*floor(trial / 4))*1.8
alter VB1 = $&drive
let drive = (floor(trial / 4) - 2*floor(trial / 8))*1.8
alter VB2 = $&drive
let drive = (floor(trial / 8) - 2*floor(trial / 16))*1.8
alter VB3 = $&drive
let drive = (floor(trial / 16) - 2*floor(trial / 32))*1.8
alter VB4 = $&drive
let drive = (floor(trial / 32) - 2*floor(trial / 64))*1.8
alter VB5 = $&drive
let drive = (floor(trial / 64) - 2*floor(trial / 128))*1.8
alter VB6 = $&drive
let drive = (floor(trial / 128) - 2*floor(trial / 256))*1.8
alter VB7 = $&drive
stop when time = 0.000204
resume
delete all
let endpoint = length(time)-1
let cmp = v(COMP)[endpoint]
let top = v(TOP)[endpoint]
let decision = 0
if cmp >= 0.9
let code = trial
let decision = 1
end
echo 11 6 $&trial $&cmp $&top 0.03984375 $&decision >> decisions.csv
let trial = code + 32
let drive = (floor(trial / 1) - 2*floor(trial / 2))*1.8
alter VB0 = $&drive
let drive = (floor(trial / 2) - 2*floor(trial / 4))*1.8
alter VB1 = $&drive
let drive = (floor(trial / 4) - 2*floor(trial / 8))*1.8
alter VB2 = $&drive
let drive = (floor(trial / 8) - 2*floor(trial / 16))*1.8
alter VB3 = $&drive
let drive = (floor(trial / 16) - 2*floor(trial / 32))*1.8
alter VB4 = $&drive
let drive = (floor(trial / 32) - 2*floor(trial / 64))*1.8
alter VB5 = $&drive
let drive = (floor(trial / 64) - 2*floor(trial / 128))*1.8
alter VB6 = $&drive
let drive = (floor(trial / 128) - 2*floor(trial / 256))*1.8
alter VB7 = $&drive
stop when time = 0.000206
resume
delete all
let endpoint = length(time)-1
let cmp = v(COMP)[endpoint]
let top = v(TOP)[endpoint]
let decision = 0
if cmp >= 0.9
let code = trial
let decision = 1
end
echo 11 5 $&trial $&cmp $&top 0.03984375 $&decision >> decisions.csv
let trial = code + 16
let drive = (floor(trial / 1) - 2*floor(trial / 2))*1.8
alter VB0 = $&drive
let drive = (floor(trial / 2) - 2*floor(trial / 4))*1.8
alter VB1 = $&drive
let drive = (floor(trial / 4) - 2*floor(trial / 8))*1.8
alter VB2 = $&drive
let drive = (floor(trial / 8) - 2*floor(trial / 16))*1.8
alter VB3 = $&drive
let drive = (floor(trial / 16) - 2*floor(trial / 32))*1.8
alter VB4 = $&drive
let drive = (floor(trial / 32) - 2*floor(trial / 64))*1.8
alter VB5 = $&drive
let drive = (floor(trial / 64) - 2*floor(trial / 128))*1.8
alter VB6 = $&drive
let drive = (floor(trial / 128) - 2*floor(trial / 256))*1.8
alter VB7 = $&drive
stop when time = 0.000208
resume
delete all
let endpoint = length(time)-1
let cmp = v(COMP)[endpoint]
let top = v(TOP)[endpoint]
let decision = 0
if cmp >= 0.9
let code = trial
let decision = 1
end
echo 11 4 $&trial $&cmp $&top 0.03984375 $&decision >> decisions.csv
let trial = code + 8
let drive = (floor(trial / 1) - 2*floor(trial / 2))*1.8
alter VB0 = $&drive
let drive = (floor(trial / 2) - 2*floor(trial / 4))*1.8
alter VB1 = $&drive
let drive = (floor(trial / 4) - 2*floor(trial / 8))*1.8
alter VB2 = $&drive
let drive = (floor(trial / 8) - 2*floor(trial / 16))*1.8
alter VB3 = $&drive
let drive = (floor(trial / 16) - 2*floor(trial / 32))*1.8
alter VB4 = $&drive
let drive = (floor(trial / 32) - 2*floor(trial / 64))*1.8
alter VB5 = $&drive
let drive = (floor(trial / 64) - 2*floor(trial / 128))*1.8
alter VB6 = $&drive
let drive = (floor(trial / 128) - 2*floor(trial / 256))*1.8
alter VB7 = $&drive
stop when time = 0.00021
resume
delete all
let endpoint = length(time)-1
let cmp = v(COMP)[endpoint]
let top = v(TOP)[endpoint]
let decision = 0
if cmp >= 0.9
let code = trial
let decision = 1
end
echo 11 3 $&trial $&cmp $&top 0.03984375 $&decision >> decisions.csv
let trial = code + 4
let drive = (floor(trial / 1) - 2*floor(trial / 2))*1.8
alter VB0 = $&drive
let drive = (floor(trial / 2) - 2*floor(trial / 4))*1.8
alter VB1 = $&drive
let drive = (floor(trial / 4) - 2*floor(trial / 8))*1.8
alter VB2 = $&drive
let drive = (floor(trial / 8) - 2*floor(trial / 16))*1.8
alter VB3 = $&drive
let drive = (floor(trial / 16) - 2*floor(trial / 32))*1.8
alter VB4 = $&drive
let drive = (floor(trial / 32) - 2*floor(trial / 64))*1.8
alter VB5 = $&drive
let drive = (floor(trial / 64) - 2*floor(trial / 128))*1.8
alter VB6 = $&drive
let drive = (floor(trial / 128) - 2*floor(trial / 256))*1.8
alter VB7 = $&drive
stop when time = 0.000212
resume
delete all
let endpoint = length(time)-1
let cmp = v(COMP)[endpoint]
let top = v(TOP)[endpoint]
let decision = 0
if cmp >= 0.9
let code = trial
let decision = 1
end
echo 11 2 $&trial $&cmp $&top 0.03984375 $&decision >> decisions.csv
let trial = code + 2
let drive = (floor(trial / 1) - 2*floor(trial / 2))*1.8
alter VB0 = $&drive
let drive = (floor(trial / 2) - 2*floor(trial / 4))*1.8
alter VB1 = $&drive
let drive = (floor(trial / 4) - 2*floor(trial / 8))*1.8
alter VB2 = $&drive
let drive = (floor(trial / 8) - 2*floor(trial / 16))*1.8
alter VB3 = $&drive
let drive = (floor(trial / 16) - 2*floor(trial / 32))*1.8
alter VB4 = $&drive
let drive = (floor(trial / 32) - 2*floor(trial / 64))*1.8
alter VB5 = $&drive
let drive = (floor(trial / 64) - 2*floor(trial / 128))*1.8
alter VB6 = $&drive
let drive = (floor(trial / 128) - 2*floor(trial / 256))*1.8
alter VB7 = $&drive
stop when time = 0.000214
resume
delete all
let endpoint = length(time)-1
let cmp = v(COMP)[endpoint]
let top = v(TOP)[endpoint]
let decision = 0
if cmp >= 0.9
let code = trial
let decision = 1
end
echo 11 1 $&trial $&cmp $&top 0.03984375 $&decision >> decisions.csv
let trial = code + 1
let drive = (floor(trial / 1) - 2*floor(trial / 2))*1.8
alter VB0 = $&drive
let drive = (floor(trial / 2) - 2*floor(trial / 4))*1.8
alter VB1 = $&drive
let drive = (floor(trial / 4) - 2*floor(trial / 8))*1.8
alter VB2 = $&drive
let drive = (floor(trial / 8) - 2*floor(trial / 16))*1.8
alter VB3 = $&drive
let drive = (floor(trial / 16) - 2*floor(trial / 32))*1.8
alter VB4 = $&drive
let drive = (floor(trial / 32) - 2*floor(trial / 64))*1.8
alter VB5 = $&drive
let drive = (floor(trial / 64) - 2*floor(trial / 128))*1.8
alter VB6 = $&drive
let drive = (floor(trial / 128) - 2*floor(trial / 256))*1.8
alter VB7 = $&drive
stop when time = 0.000216
resume
delete all
let endpoint = length(time)-1
let cmp = v(COMP)[endpoint]
let top = v(TOP)[endpoint]
let decision = 0
if cmp >= 0.9
let code = trial
let decision = 1
end
echo 11 0 $&trial $&cmp $&top 0.03984375 $&decision >> decisions.csv
alter VIN = 0.04453125
alter VSAMPLE = 1.8
alter VB0 = 0
alter VB1 = 0
alter VB2 = 0
alter VB3 = 0
alter VB4 = 0
alter VB5 = 0
alter VB6 = 0
alter VB7 = 0
let code = 0
stop when time = 0.000218
resume
delete all
alter VSAMPLE = 0
let trial = code + 128
let drive = (floor(trial / 1) - 2*floor(trial / 2))*1.8
alter VB0 = $&drive
let drive = (floor(trial / 2) - 2*floor(trial / 4))*1.8
alter VB1 = $&drive
let drive = (floor(trial / 4) - 2*floor(trial / 8))*1.8
alter VB2 = $&drive
let drive = (floor(trial / 8) - 2*floor(trial / 16))*1.8
alter VB3 = $&drive
let drive = (floor(trial / 16) - 2*floor(trial / 32))*1.8
alter VB4 = $&drive
let drive = (floor(trial / 32) - 2*floor(trial / 64))*1.8
alter VB5 = $&drive
let drive = (floor(trial / 64) - 2*floor(trial / 128))*1.8
alter VB6 = $&drive
let drive = (floor(trial / 128) - 2*floor(trial / 256))*1.8
alter VB7 = $&drive
stop when time = 0.00022
resume
delete all
let endpoint = length(time)-1
let cmp = v(COMP)[endpoint]
let top = v(TOP)[endpoint]
let decision = 0
if cmp >= 0.9
let code = trial
let decision = 1
end
echo 12 7 $&trial $&cmp $&top 0.04453125 $&decision >> decisions.csv
let trial = code + 64
let drive = (floor(trial / 1) - 2*floor(trial / 2))*1.8
alter VB0 = $&drive
let drive = (floor(trial / 2) - 2*floor(trial / 4))*1.8
alter VB1 = $&drive
let drive = (floor(trial / 4) - 2*floor(trial / 8))*1.8
alter VB2 = $&drive
let drive = (floor(trial / 8) - 2*floor(trial / 16))*1.8
alter VB3 = $&drive
let drive = (floor(trial / 16) - 2*floor(trial / 32))*1.8
alter VB4 = $&drive
let drive = (floor(trial / 32) - 2*floor(trial / 64))*1.8
alter VB5 = $&drive
let drive = (floor(trial / 64) - 2*floor(trial / 128))*1.8
alter VB6 = $&drive
let drive = (floor(trial / 128) - 2*floor(trial / 256))*1.8
alter VB7 = $&drive
stop when time = 0.000222
resume
delete all
let endpoint = length(time)-1
let cmp = v(COMP)[endpoint]
let top = v(TOP)[endpoint]
let decision = 0
if cmp >= 0.9
let code = trial
let decision = 1
end
echo 12 6 $&trial $&cmp $&top 0.04453125 $&decision >> decisions.csv
let trial = code + 32
let drive = (floor(trial / 1) - 2*floor(trial / 2))*1.8
alter VB0 = $&drive
let drive = (floor(trial / 2) - 2*floor(trial / 4))*1.8
alter VB1 = $&drive
let drive = (floor(trial / 4) - 2*floor(trial / 8))*1.8
alter VB2 = $&drive
let drive = (floor(trial / 8) - 2*floor(trial / 16))*1.8
alter VB3 = $&drive
let drive = (floor(trial / 16) - 2*floor(trial / 32))*1.8
alter VB4 = $&drive
let drive = (floor(trial / 32) - 2*floor(trial / 64))*1.8
alter VB5 = $&drive
let drive = (floor(trial / 64) - 2*floor(trial / 128))*1.8
alter VB6 = $&drive
let drive = (floor(trial / 128) - 2*floor(trial / 256))*1.8
alter VB7 = $&drive
stop when time = 0.000224
resume
delete all
let endpoint = length(time)-1
let cmp = v(COMP)[endpoint]
let top = v(TOP)[endpoint]
let decision = 0
if cmp >= 0.9
let code = trial
let decision = 1
end
echo 12 5 $&trial $&cmp $&top 0.04453125 $&decision >> decisions.csv
let trial = code + 16
let drive = (floor(trial / 1) - 2*floor(trial / 2))*1.8
alter VB0 = $&drive
let drive = (floor(trial / 2) - 2*floor(trial / 4))*1.8
alter VB1 = $&drive
let drive = (floor(trial / 4) - 2*floor(trial / 8))*1.8
alter VB2 = $&drive
let drive = (floor(trial / 8) - 2*floor(trial / 16))*1.8
alter VB3 = $&drive
let drive = (floor(trial / 16) - 2*floor(trial / 32))*1.8
alter VB4 = $&drive
let drive = (floor(trial / 32) - 2*floor(trial / 64))*1.8
alter VB5 = $&drive
let drive = (floor(trial / 64) - 2*floor(trial / 128))*1.8
alter VB6 = $&drive
let drive = (floor(trial / 128) - 2*floor(trial / 256))*1.8
alter VB7 = $&drive
stop when time = 0.000226
resume
delete all
let endpoint = length(time)-1
let cmp = v(COMP)[endpoint]
let top = v(TOP)[endpoint]
let decision = 0
if cmp >= 0.9
let code = trial
let decision = 1
end
echo 12 4 $&trial $&cmp $&top 0.04453125 $&decision >> decisions.csv
let trial = code + 8
let drive = (floor(trial / 1) - 2*floor(trial / 2))*1.8
alter VB0 = $&drive
let drive = (floor(trial / 2) - 2*floor(trial / 4))*1.8
alter VB1 = $&drive
let drive = (floor(trial / 4) - 2*floor(trial / 8))*1.8
alter VB2 = $&drive
let drive = (floor(trial / 8) - 2*floor(trial / 16))*1.8
alter VB3 = $&drive
let drive = (floor(trial / 16) - 2*floor(trial / 32))*1.8
alter VB4 = $&drive
let drive = (floor(trial / 32) - 2*floor(trial / 64))*1.8
alter VB5 = $&drive
let drive = (floor(trial / 64) - 2*floor(trial / 128))*1.8
alter VB6 = $&drive
let drive = (floor(trial / 128) - 2*floor(trial / 256))*1.8
alter VB7 = $&drive
stop when time = 0.000228
resume
delete all
let endpoint = length(time)-1
let cmp = v(COMP)[endpoint]
let top = v(TOP)[endpoint]
let decision = 0
if cmp >= 0.9
let code = trial
let decision = 1
end
echo 12 3 $&trial $&cmp $&top 0.04453125 $&decision >> decisions.csv
let trial = code + 4
let drive = (floor(trial / 1) - 2*floor(trial / 2))*1.8
alter VB0 = $&drive
let drive = (floor(trial / 2) - 2*floor(trial / 4))*1.8
alter VB1 = $&drive
let drive = (floor(trial / 4) - 2*floor(trial / 8))*1.8
alter VB2 = $&drive
let drive = (floor(trial / 8) - 2*floor(trial / 16))*1.8
alter VB3 = $&drive
let drive = (floor(trial / 16) - 2*floor(trial / 32))*1.8
alter VB4 = $&drive
let drive = (floor(trial / 32) - 2*floor(trial / 64))*1.8
alter VB5 = $&drive
let drive = (floor(trial / 64) - 2*floor(trial / 128))*1.8
alter VB6 = $&drive
let drive = (floor(trial / 128) - 2*floor(trial / 256))*1.8
alter VB7 = $&drive
stop when time = 0.00023
resume
delete all
let endpoint = length(time)-1
let cmp = v(COMP)[endpoint]
let top = v(TOP)[endpoint]
let decision = 0
if cmp >= 0.9
let code = trial
let decision = 1
end
echo 12 2 $&trial $&cmp $&top 0.04453125 $&decision >> decisions.csv
let trial = code + 2
let drive = (floor(trial / 1) - 2*floor(trial / 2))*1.8
alter VB0 = $&drive
let drive = (floor(trial / 2) - 2*floor(trial / 4))*1.8
alter VB1 = $&drive
let drive = (floor(trial / 4) - 2*floor(trial / 8))*1.8
alter VB2 = $&drive
let drive = (floor(trial / 8) - 2*floor(trial / 16))*1.8
alter VB3 = $&drive
let drive = (floor(trial / 16) - 2*floor(trial / 32))*1.8
alter VB4 = $&drive
let drive = (floor(trial / 32) - 2*floor(trial / 64))*1.8
alter VB5 = $&drive
let drive = (floor(trial / 64) - 2*floor(trial / 128))*1.8
alter VB6 = $&drive
let drive = (floor(trial / 128) - 2*floor(trial / 256))*1.8
alter VB7 = $&drive
stop when time = 0.000232
resume
delete all
let endpoint = length(time)-1
let cmp = v(COMP)[endpoint]
let top = v(TOP)[endpoint]
let decision = 0
if cmp >= 0.9
let code = trial
let decision = 1
end
echo 12 1 $&trial $&cmp $&top 0.04453125 $&decision >> decisions.csv
let trial = code + 1
let drive = (floor(trial / 1) - 2*floor(trial / 2))*1.8
alter VB0 = $&drive
let drive = (floor(trial / 2) - 2*floor(trial / 4))*1.8
alter VB1 = $&drive
let drive = (floor(trial / 4) - 2*floor(trial / 8))*1.8
alter VB2 = $&drive
let drive = (floor(trial / 8) - 2*floor(trial / 16))*1.8
alter VB3 = $&drive
let drive = (floor(trial / 16) - 2*floor(trial / 32))*1.8
alter VB4 = $&drive
let drive = (floor(trial / 32) - 2*floor(trial / 64))*1.8
alter VB5 = $&drive
let drive = (floor(trial / 64) - 2*floor(trial / 128))*1.8
alter VB6 = $&drive
let drive = (floor(trial / 128) - 2*floor(trial / 256))*1.8
alter VB7 = $&drive
stop when time = 0.000234
resume
delete all
let endpoint = length(time)-1
let cmp = v(COMP)[endpoint]
let top = v(TOP)[endpoint]
let decision = 0
if cmp >= 0.9
let code = trial
let decision = 1
end
echo 12 0 $&trial $&cmp $&top 0.04453125 $&decision >> decisions.csv
alter VIN = 0.04921875
alter VSAMPLE = 1.8
alter VB0 = 0
alter VB1 = 0
alter VB2 = 0
alter VB3 = 0
alter VB4 = 0
alter VB5 = 0
alter VB6 = 0
alter VB7 = 0
let code = 0
stop when time = 0.000236
resume
delete all
alter VSAMPLE = 0
let trial = code + 128
let drive = (floor(trial / 1) - 2*floor(trial / 2))*1.8
alter VB0 = $&drive
let drive = (floor(trial / 2) - 2*floor(trial / 4))*1.8
alter VB1 = $&drive
let drive = (floor(trial / 4) - 2*floor(trial / 8))*1.8
alter VB2 = $&drive
let drive = (floor(trial / 8) - 2*floor(trial / 16))*1.8
alter VB3 = $&drive
let drive = (floor(trial / 16) - 2*floor(trial / 32))*1.8
alter VB4 = $&drive
let drive = (floor(trial / 32) - 2*floor(trial / 64))*1.8
alter VB5 = $&drive
let drive = (floor(trial / 64) - 2*floor(trial / 128))*1.8
alter VB6 = $&drive
let drive = (floor(trial / 128) - 2*floor(trial / 256))*1.8
alter VB7 = $&drive
stop when time = 0.000238
resume
delete all
let endpoint = length(time)-1
let cmp = v(COMP)[endpoint]
let top = v(TOP)[endpoint]
let decision = 0
if cmp >= 0.9
let code = trial
let decision = 1
end
echo 13 7 $&trial $&cmp $&top 0.04921875 $&decision >> decisions.csv
let trial = code + 64
let drive = (floor(trial / 1) - 2*floor(trial / 2))*1.8
alter VB0 = $&drive
let drive = (floor(trial / 2) - 2*floor(trial / 4))*1.8
alter VB1 = $&drive
let drive = (floor(trial / 4) - 2*floor(trial / 8))*1.8
alter VB2 = $&drive
let drive = (floor(trial / 8) - 2*floor(trial / 16))*1.8
alter VB3 = $&drive
let drive = (floor(trial / 16) - 2*floor(trial / 32))*1.8
alter VB4 = $&drive
let drive = (floor(trial / 32) - 2*floor(trial / 64))*1.8
alter VB5 = $&drive
let drive = (floor(trial / 64) - 2*floor(trial / 128))*1.8
alter VB6 = $&drive
let drive = (floor(trial / 128) - 2*floor(trial / 256))*1.8
alter VB7 = $&drive
stop when time = 0.00024
resume
delete all
let endpoint = length(time)-1
let cmp = v(COMP)[endpoint]
let top = v(TOP)[endpoint]
let decision = 0
if cmp >= 0.9
let code = trial
let decision = 1
end
echo 13 6 $&trial $&cmp $&top 0.04921875 $&decision >> decisions.csv
let trial = code + 32
let drive = (floor(trial / 1) - 2*floor(trial / 2))*1.8
alter VB0 = $&drive
let drive = (floor(trial / 2) - 2*floor(trial / 4))*1.8
alter VB1 = $&drive
let drive = (floor(trial / 4) - 2*floor(trial / 8))*1.8
alter VB2 = $&drive
let drive = (floor(trial / 8) - 2*floor(trial / 16))*1.8
alter VB3 = $&drive
let drive = (floor(trial / 16) - 2*floor(trial / 32))*1.8
alter VB4 = $&drive
let drive = (floor(trial / 32) - 2*floor(trial / 64))*1.8
alter VB5 = $&drive
let drive = (floor(trial / 64) - 2*floor(trial / 128))*1.8
alter VB6 = $&drive
let drive = (floor(trial / 128) - 2*floor(trial / 256))*1.8
alter VB7 = $&drive
stop when time = 0.000242
resume
delete all
let endpoint = length(time)-1
let cmp = v(COMP)[endpoint]
let top = v(TOP)[endpoint]
let decision = 0
if cmp >= 0.9
let code = trial
let decision = 1
end
echo 13 5 $&trial $&cmp $&top 0.04921875 $&decision >> decisions.csv
let trial = code + 16
let drive = (floor(trial / 1) - 2*floor(trial / 2))*1.8
alter VB0 = $&drive
let drive = (floor(trial / 2) - 2*floor(trial / 4))*1.8
alter VB1 = $&drive
let drive = (floor(trial / 4) - 2*floor(trial / 8))*1.8
alter VB2 = $&drive
let drive = (floor(trial / 8) - 2*floor(trial / 16))*1.8
alter VB3 = $&drive
let drive = (floor(trial / 16) - 2*floor(trial / 32))*1.8
alter VB4 = $&drive
let drive = (floor(trial / 32) - 2*floor(trial / 64))*1.8
alter VB5 = $&drive
let drive = (floor(trial / 64) - 2*floor(trial / 128))*1.8
alter VB6 = $&drive
let drive = (floor(trial / 128) - 2*floor(trial / 256))*1.8
alter VB7 = $&drive
stop when time = 0.000244
resume
delete all
let endpoint = length(time)-1
let cmp = v(COMP)[endpoint]
let top = v(TOP)[endpoint]
let decision = 0
if cmp >= 0.9
let code = trial
let decision = 1
end
echo 13 4 $&trial $&cmp $&top 0.04921875 $&decision >> decisions.csv
let trial = code + 8
let drive = (floor(trial / 1) - 2*floor(trial / 2))*1.8
alter VB0 = $&drive
let drive = (floor(trial / 2) - 2*floor(trial / 4))*1.8
alter VB1 = $&drive
let drive = (floor(trial / 4) - 2*floor(trial / 8))*1.8
alter VB2 = $&drive
let drive = (floor(trial / 8) - 2*floor(trial / 16))*1.8
alter VB3 = $&drive
let drive = (floor(trial / 16) - 2*floor(trial / 32))*1.8
alter VB4 = $&drive
let drive = (floor(trial / 32) - 2*floor(trial / 64))*1.8
alter VB5 = $&drive
let drive = (floor(trial / 64) - 2*floor(trial / 128))*1.8
alter VB6 = $&drive
let drive = (floor(trial / 128) - 2*floor(trial / 256))*1.8
alter VB7 = $&drive
stop when time = 0.000246
resume
delete all
let endpoint = length(time)-1
let cmp = v(COMP)[endpoint]
let top = v(TOP)[endpoint]
let decision = 0
if cmp >= 0.9
let code = trial
let decision = 1
end
echo 13 3 $&trial $&cmp $&top 0.04921875 $&decision >> decisions.csv
let trial = code + 4
let drive = (floor(trial / 1) - 2*floor(trial / 2))*1.8
alter VB0 = $&drive
let drive = (floor(trial / 2) - 2*floor(trial / 4))*1.8
alter VB1 = $&drive
let drive = (floor(trial / 4) - 2*floor(trial / 8))*1.8
alter VB2 = $&drive
let drive = (floor(trial / 8) - 2*floor(trial / 16))*1.8
alter VB3 = $&drive
let drive = (floor(trial / 16) - 2*floor(trial / 32))*1.8
alter VB4 = $&drive
let drive = (floor(trial / 32) - 2*floor(trial / 64))*1.8
alter VB5 = $&drive
let drive = (floor(trial / 64) - 2*floor(trial / 128))*1.8
alter VB6 = $&drive
let drive = (floor(trial / 128) - 2*floor(trial / 256))*1.8
alter VB7 = $&drive
stop when time = 0.000248
resume
delete all
let endpoint = length(time)-1
let cmp = v(COMP)[endpoint]
let top = v(TOP)[endpoint]
let decision = 0
if cmp >= 0.9
let code = trial
let decision = 1
end
echo 13 2 $&trial $&cmp $&top 0.04921875 $&decision >> decisions.csv
let trial = code + 2
let drive = (floor(trial / 1) - 2*floor(trial / 2))*1.8
alter VB0 = $&drive
let drive = (floor(trial / 2) - 2*floor(trial / 4))*1.8
alter VB1 = $&drive
let drive = (floor(trial / 4) - 2*floor(trial / 8))*1.8
alter VB2 = $&drive
let drive = (floor(trial / 8) - 2*floor(trial / 16))*1.8
alter VB3 = $&drive
let drive = (floor(trial / 16) - 2*floor(trial / 32))*1.8
alter VB4 = $&drive
let drive = (floor(trial / 32) - 2*floor(trial / 64))*1.8
alter VB5 = $&drive
let drive = (floor(trial / 64) - 2*floor(trial / 128))*1.8
alter VB6 = $&drive
let drive = (floor(trial / 128) - 2*floor(trial / 256))*1.8
alter VB7 = $&drive
stop when time = 0.00025
resume
delete all
let endpoint = length(time)-1
let cmp = v(COMP)[endpoint]
let top = v(TOP)[endpoint]
let decision = 0
if cmp >= 0.9
let code = trial
let decision = 1
end
echo 13 1 $&trial $&cmp $&top 0.04921875 $&decision >> decisions.csv
let trial = code + 1
let drive = (floor(trial / 1) - 2*floor(trial / 2))*1.8
alter VB0 = $&drive
let drive = (floor(trial / 2) - 2*floor(trial / 4))*1.8
alter VB1 = $&drive
let drive = (floor(trial / 4) - 2*floor(trial / 8))*1.8
alter VB2 = $&drive
let drive = (floor(trial / 8) - 2*floor(trial / 16))*1.8
alter VB3 = $&drive
let drive = (floor(trial / 16) - 2*floor(trial / 32))*1.8
alter VB4 = $&drive
let drive = (floor(trial / 32) - 2*floor(trial / 64))*1.8
alter VB5 = $&drive
let drive = (floor(trial / 64) - 2*floor(trial / 128))*1.8
alter VB6 = $&drive
let drive = (floor(trial / 128) - 2*floor(trial / 256))*1.8
alter VB7 = $&drive
stop when time = 0.000252
resume
delete all
let endpoint = length(time)-1
let cmp = v(COMP)[endpoint]
let top = v(TOP)[endpoint]
let decision = 0
if cmp >= 0.9
let code = trial
let decision = 1
end
echo 13 0 $&trial $&cmp $&top 0.04921875 $&decision >> decisions.csv
alter VIN = 0.05390625
alter VSAMPLE = 1.8
alter VB0 = 0
alter VB1 = 0
alter VB2 = 0
alter VB3 = 0
alter VB4 = 0
alter VB5 = 0
alter VB6 = 0
alter VB7 = 0
let code = 0
stop when time = 0.000254
resume
delete all
alter VSAMPLE = 0
let trial = code + 128
let drive = (floor(trial / 1) - 2*floor(trial / 2))*1.8
alter VB0 = $&drive
let drive = (floor(trial / 2) - 2*floor(trial / 4))*1.8
alter VB1 = $&drive
let drive = (floor(trial / 4) - 2*floor(trial / 8))*1.8
alter VB2 = $&drive
let drive = (floor(trial / 8) - 2*floor(trial / 16))*1.8
alter VB3 = $&drive
let drive = (floor(trial / 16) - 2*floor(trial / 32))*1.8
alter VB4 = $&drive
let drive = (floor(trial / 32) - 2*floor(trial / 64))*1.8
alter VB5 = $&drive
let drive = (floor(trial / 64) - 2*floor(trial / 128))*1.8
alter VB6 = $&drive
let drive = (floor(trial / 128) - 2*floor(trial / 256))*1.8
alter VB7 = $&drive
stop when time = 0.000256
resume
delete all
let endpoint = length(time)-1
let cmp = v(COMP)[endpoint]
let top = v(TOP)[endpoint]
let decision = 0
if cmp >= 0.9
let code = trial
let decision = 1
end
echo 14 7 $&trial $&cmp $&top 0.05390625 $&decision >> decisions.csv
let trial = code + 64
let drive = (floor(trial / 1) - 2*floor(trial / 2))*1.8
alter VB0 = $&drive
let drive = (floor(trial / 2) - 2*floor(trial / 4))*1.8
alter VB1 = $&drive
let drive = (floor(trial / 4) - 2*floor(trial / 8))*1.8
alter VB2 = $&drive
let drive = (floor(trial / 8) - 2*floor(trial / 16))*1.8
alter VB3 = $&drive
let drive = (floor(trial / 16) - 2*floor(trial / 32))*1.8
alter VB4 = $&drive
let drive = (floor(trial / 32) - 2*floor(trial / 64))*1.8
alter VB5 = $&drive
let drive = (floor(trial / 64) - 2*floor(trial / 128))*1.8
alter VB6 = $&drive
let drive = (floor(trial / 128) - 2*floor(trial / 256))*1.8
alter VB7 = $&drive
stop when time = 0.000258
resume
delete all
let endpoint = length(time)-1
let cmp = v(COMP)[endpoint]
let top = v(TOP)[endpoint]
let decision = 0
if cmp >= 0.9
let code = trial
let decision = 1
end
echo 14 6 $&trial $&cmp $&top 0.05390625 $&decision >> decisions.csv
let trial = code + 32
let drive = (floor(trial / 1) - 2*floor(trial / 2))*1.8
alter VB0 = $&drive
let drive = (floor(trial / 2) - 2*floor(trial / 4))*1.8
alter VB1 = $&drive
let drive = (floor(trial / 4) - 2*floor(trial / 8))*1.8
alter VB2 = $&drive
let drive = (floor(trial / 8) - 2*floor(trial / 16))*1.8
alter VB3 = $&drive
let drive = (floor(trial / 16) - 2*floor(trial / 32))*1.8
alter VB4 = $&drive
let drive = (floor(trial / 32) - 2*floor(trial / 64))*1.8
alter VB5 = $&drive
let drive = (floor(trial / 64) - 2*floor(trial / 128))*1.8
alter VB6 = $&drive
let drive = (floor(trial / 128) - 2*floor(trial / 256))*1.8
alter VB7 = $&drive
stop when time = 0.00026
resume
delete all
let endpoint = length(time)-1
let cmp = v(COMP)[endpoint]
let top = v(TOP)[endpoint]
let decision = 0
if cmp >= 0.9
let code = trial
let decision = 1
end
echo 14 5 $&trial $&cmp $&top 0.05390625 $&decision >> decisions.csv
let trial = code + 16
let drive = (floor(trial / 1) - 2*floor(trial / 2))*1.8
alter VB0 = $&drive
let drive = (floor(trial / 2) - 2*floor(trial / 4))*1.8
alter VB1 = $&drive
let drive = (floor(trial / 4) - 2*floor(trial / 8))*1.8
alter VB2 = $&drive
let drive = (floor(trial / 8) - 2*floor(trial / 16))*1.8
alter VB3 = $&drive
let drive = (floor(trial / 16) - 2*floor(trial / 32))*1.8
alter VB4 = $&drive
let drive = (floor(trial / 32) - 2*floor(trial / 64))*1.8
alter VB5 = $&drive
let drive = (floor(trial / 64) - 2*floor(trial / 128))*1.8
alter VB6 = $&drive
let drive = (floor(trial / 128) - 2*floor(trial / 256))*1.8
alter VB7 = $&drive
stop when time = 0.000262
resume
delete all
let endpoint = length(time)-1
let cmp = v(COMP)[endpoint]
let top = v(TOP)[endpoint]
let decision = 0
if cmp >= 0.9
let code = trial
let decision = 1
end
echo 14 4 $&trial $&cmp $&top 0.05390625 $&decision >> decisions.csv
let trial = code + 8
let drive = (floor(trial / 1) - 2*floor(trial / 2))*1.8
alter VB0 = $&drive
let drive = (floor(trial / 2) - 2*floor(trial / 4))*1.8
alter VB1 = $&drive
let drive = (floor(trial / 4) - 2*floor(trial / 8))*1.8
alter VB2 = $&drive
let drive = (floor(trial / 8) - 2*floor(trial / 16))*1.8
alter VB3 = $&drive
let drive = (floor(trial / 16) - 2*floor(trial / 32))*1.8
alter VB4 = $&drive
let drive = (floor(trial / 32) - 2*floor(trial / 64))*1.8
alter VB5 = $&drive
let drive = (floor(trial / 64) - 2*floor(trial / 128))*1.8
alter VB6 = $&drive
let drive = (floor(trial / 128) - 2*floor(trial / 256))*1.8
alter VB7 = $&drive
stop when time = 0.000264
resume
delete all
let endpoint = length(time)-1
let cmp = v(COMP)[endpoint]
let top = v(TOP)[endpoint]
let decision = 0
if cmp >= 0.9
let code = trial
let decision = 1
end
echo 14 3 $&trial $&cmp $&top 0.05390625 $&decision >> decisions.csv
let trial = code + 4
let drive = (floor(trial / 1) - 2*floor(trial / 2))*1.8
alter VB0 = $&drive
let drive = (floor(trial / 2) - 2*floor(trial / 4))*1.8
alter VB1 = $&drive
let drive = (floor(trial / 4) - 2*floor(trial / 8))*1.8
alter VB2 = $&drive
let drive = (floor(trial / 8) - 2*floor(trial / 16))*1.8
alter VB3 = $&drive
let drive = (floor(trial / 16) - 2*floor(trial / 32))*1.8
alter VB4 = $&drive
let drive = (floor(trial / 32) - 2*floor(trial / 64))*1.8
alter VB5 = $&drive
let drive = (floor(trial / 64) - 2*floor(trial / 128))*1.8
alter VB6 = $&drive
let drive = (floor(trial / 128) - 2*floor(trial / 256))*1.8
alter VB7 = $&drive
stop when time = 0.000266
resume
delete all
let endpoint = length(time)-1
let cmp = v(COMP)[endpoint]
let top = v(TOP)[endpoint]
let decision = 0
if cmp >= 0.9
let code = trial
let decision = 1
end
echo 14 2 $&trial $&cmp $&top 0.05390625 $&decision >> decisions.csv
let trial = code + 2
let drive = (floor(trial / 1) - 2*floor(trial / 2))*1.8
alter VB0 = $&drive
let drive = (floor(trial / 2) - 2*floor(trial / 4))*1.8
alter VB1 = $&drive
let drive = (floor(trial / 4) - 2*floor(trial / 8))*1.8
alter VB2 = $&drive
let drive = (floor(trial / 8) - 2*floor(trial / 16))*1.8
alter VB3 = $&drive
let drive = (floor(trial / 16) - 2*floor(trial / 32))*1.8
alter VB4 = $&drive
let drive = (floor(trial / 32) - 2*floor(trial / 64))*1.8
alter VB5 = $&drive
let drive = (floor(trial / 64) - 2*floor(trial / 128))*1.8
alter VB6 = $&drive
let drive = (floor(trial / 128) - 2*floor(trial / 256))*1.8
alter VB7 = $&drive
stop when time = 0.000268
resume
delete all
let endpoint = length(time)-1
let cmp = v(COMP)[endpoint]
let top = v(TOP)[endpoint]
let decision = 0
if cmp >= 0.9
let code = trial
let decision = 1
end
echo 14 1 $&trial $&cmp $&top 0.05390625 $&decision >> decisions.csv
let trial = code + 1
let drive = (floor(trial / 1) - 2*floor(trial / 2))*1.8
alter VB0 = $&drive
let drive = (floor(trial / 2) - 2*floor(trial / 4))*1.8
alter VB1 = $&drive
let drive = (floor(trial / 4) - 2*floor(trial / 8))*1.8
alter VB2 = $&drive
let drive = (floor(trial / 8) - 2*floor(trial / 16))*1.8
alter VB3 = $&drive
let drive = (floor(trial / 16) - 2*floor(trial / 32))*1.8
alter VB4 = $&drive
let drive = (floor(trial / 32) - 2*floor(trial / 64))*1.8
alter VB5 = $&drive
let drive = (floor(trial / 64) - 2*floor(trial / 128))*1.8
alter VB6 = $&drive
let drive = (floor(trial / 128) - 2*floor(trial / 256))*1.8
alter VB7 = $&drive
stop when time = 0.00027
resume
delete all
let endpoint = length(time)-1
let cmp = v(COMP)[endpoint]
let top = v(TOP)[endpoint]
let decision = 0
if cmp >= 0.9
let code = trial
let decision = 1
end
echo 14 0 $&trial $&cmp $&top 0.05390625 $&decision >> decisions.csv
alter VIN = 0.05859375
alter VSAMPLE = 1.8
alter VB0 = 0
alter VB1 = 0
alter VB2 = 0
alter VB3 = 0
alter VB4 = 0
alter VB5 = 0
alter VB6 = 0
alter VB7 = 0
let code = 0
stop when time = 0.000272
resume
delete all
alter VSAMPLE = 0
let trial = code + 128
let drive = (floor(trial / 1) - 2*floor(trial / 2))*1.8
alter VB0 = $&drive
let drive = (floor(trial / 2) - 2*floor(trial / 4))*1.8
alter VB1 = $&drive
let drive = (floor(trial / 4) - 2*floor(trial / 8))*1.8
alter VB2 = $&drive
let drive = (floor(trial / 8) - 2*floor(trial / 16))*1.8
alter VB3 = $&drive
let drive = (floor(trial / 16) - 2*floor(trial / 32))*1.8
alter VB4 = $&drive
let drive = (floor(trial / 32) - 2*floor(trial / 64))*1.8
alter VB5 = $&drive
let drive = (floor(trial / 64) - 2*floor(trial / 128))*1.8
alter VB6 = $&drive
let drive = (floor(trial / 128) - 2*floor(trial / 256))*1.8
alter VB7 = $&drive
stop when time = 0.000274
resume
delete all
let endpoint = length(time)-1
let cmp = v(COMP)[endpoint]
let top = v(TOP)[endpoint]
let decision = 0
if cmp >= 0.9
let code = trial
let decision = 1
end
echo 15 7 $&trial $&cmp $&top 0.05859375 $&decision >> decisions.csv
let trial = code + 64
let drive = (floor(trial / 1) - 2*floor(trial / 2))*1.8
alter VB0 = $&drive
let drive = (floor(trial / 2) - 2*floor(trial / 4))*1.8
alter VB1 = $&drive
let drive = (floor(trial / 4) - 2*floor(trial / 8))*1.8
alter VB2 = $&drive
let drive = (floor(trial / 8) - 2*floor(trial / 16))*1.8
alter VB3 = $&drive
let drive = (floor(trial / 16) - 2*floor(trial / 32))*1.8
alter VB4 = $&drive
let drive = (floor(trial / 32) - 2*floor(trial / 64))*1.8
alter VB5 = $&drive
let drive = (floor(trial / 64) - 2*floor(trial / 128))*1.8
alter VB6 = $&drive
let drive = (floor(trial / 128) - 2*floor(trial / 256))*1.8
alter VB7 = $&drive
stop when time = 0.000276
resume
delete all
let endpoint = length(time)-1
let cmp = v(COMP)[endpoint]
let top = v(TOP)[endpoint]
let decision = 0
if cmp >= 0.9
let code = trial
let decision = 1
end
echo 15 6 $&trial $&cmp $&top 0.05859375 $&decision >> decisions.csv
let trial = code + 32
let drive = (floor(trial / 1) - 2*floor(trial / 2))*1.8
alter VB0 = $&drive
let drive = (floor(trial / 2) - 2*floor(trial / 4))*1.8
alter VB1 = $&drive
let drive = (floor(trial / 4) - 2*floor(trial / 8))*1.8
alter VB2 = $&drive
let drive = (floor(trial / 8) - 2*floor(trial / 16))*1.8
alter VB3 = $&drive
let drive = (floor(trial / 16) - 2*floor(trial / 32))*1.8
alter VB4 = $&drive
let drive = (floor(trial / 32) - 2*floor(trial / 64))*1.8
alter VB5 = $&drive
let drive = (floor(trial / 64) - 2*floor(trial / 128))*1.8
alter VB6 = $&drive
let drive = (floor(trial / 128) - 2*floor(trial / 256))*1.8
alter VB7 = $&drive
stop when time = 0.000278
resume
delete all
let endpoint = length(time)-1
let cmp = v(COMP)[endpoint]
let top = v(TOP)[endpoint]
let decision = 0
if cmp >= 0.9
let code = trial
let decision = 1
end
echo 15 5 $&trial $&cmp $&top 0.05859375 $&decision >> decisions.csv
let trial = code + 16
let drive = (floor(trial / 1) - 2*floor(trial / 2))*1.8
alter VB0 = $&drive
let drive = (floor(trial / 2) - 2*floor(trial / 4))*1.8
alter VB1 = $&drive
let drive = (floor(trial / 4) - 2*floor(trial / 8))*1.8
alter VB2 = $&drive
let drive = (floor(trial / 8) - 2*floor(trial / 16))*1.8
alter VB3 = $&drive
let drive = (floor(trial / 16) - 2*floor(trial / 32))*1.8
alter VB4 = $&drive
let drive = (floor(trial / 32) - 2*floor(trial / 64))*1.8
alter VB5 = $&drive
let drive = (floor(trial / 64) - 2*floor(trial / 128))*1.8
alter VB6 = $&drive
let drive = (floor(trial / 128) - 2*floor(trial / 256))*1.8
alter VB7 = $&drive
stop when time = 0.00028
resume
delete all
let endpoint = length(time)-1
let cmp = v(COMP)[endpoint]
let top = v(TOP)[endpoint]
let decision = 0
if cmp >= 0.9
let code = trial
let decision = 1
end
echo 15 4 $&trial $&cmp $&top 0.05859375 $&decision >> decisions.csv
let trial = code + 8
let drive = (floor(trial / 1) - 2*floor(trial / 2))*1.8
alter VB0 = $&drive
let drive = (floor(trial / 2) - 2*floor(trial / 4))*1.8
alter VB1 = $&drive
let drive = (floor(trial / 4) - 2*floor(trial / 8))*1.8
alter VB2 = $&drive
let drive = (floor(trial / 8) - 2*floor(trial / 16))*1.8
alter VB3 = $&drive
let drive = (floor(trial / 16) - 2*floor(trial / 32))*1.8
alter VB4 = $&drive
let drive = (floor(trial / 32) - 2*floor(trial / 64))*1.8
alter VB5 = $&drive
let drive = (floor(trial / 64) - 2*floor(trial / 128))*1.8
alter VB6 = $&drive
let drive = (floor(trial / 128) - 2*floor(trial / 256))*1.8
alter VB7 = $&drive
stop when time = 0.000282
resume
delete all
let endpoint = length(time)-1
let cmp = v(COMP)[endpoint]
let top = v(TOP)[endpoint]
let decision = 0
if cmp >= 0.9
let code = trial
let decision = 1
end
echo 15 3 $&trial $&cmp $&top 0.05859375 $&decision >> decisions.csv
let trial = code + 4
let drive = (floor(trial / 1) - 2*floor(trial / 2))*1.8
alter VB0 = $&drive
let drive = (floor(trial / 2) - 2*floor(trial / 4))*1.8
alter VB1 = $&drive
let drive = (floor(trial / 4) - 2*floor(trial / 8))*1.8
alter VB2 = $&drive
let drive = (floor(trial / 8) - 2*floor(trial / 16))*1.8
alter VB3 = $&drive
let drive = (floor(trial / 16) - 2*floor(trial / 32))*1.8
alter VB4 = $&drive
let drive = (floor(trial / 32) - 2*floor(trial / 64))*1.8
alter VB5 = $&drive
let drive = (floor(trial / 64) - 2*floor(trial / 128))*1.8
alter VB6 = $&drive
let drive = (floor(trial / 128) - 2*floor(trial / 256))*1.8
alter VB7 = $&drive
stop when time = 0.000284
resume
delete all
let endpoint = length(time)-1
let cmp = v(COMP)[endpoint]
let top = v(TOP)[endpoint]
let decision = 0
if cmp >= 0.9
let code = trial
let decision = 1
end
echo 15 2 $&trial $&cmp $&top 0.05859375 $&decision >> decisions.csv
let trial = code + 2
let drive = (floor(trial / 1) - 2*floor(trial / 2))*1.8
alter VB0 = $&drive
let drive = (floor(trial / 2) - 2*floor(trial / 4))*1.8
alter VB1 = $&drive
let drive = (floor(trial / 4) - 2*floor(trial / 8))*1.8
alter VB2 = $&drive
let drive = (floor(trial / 8) - 2*floor(trial / 16))*1.8
alter VB3 = $&drive
let drive = (floor(trial / 16) - 2*floor(trial / 32))*1.8
alter VB4 = $&drive
let drive = (floor(trial / 32) - 2*floor(trial / 64))*1.8
alter VB5 = $&drive
let drive = (floor(trial / 64) - 2*floor(trial / 128))*1.8
alter VB6 = $&drive
let drive = (floor(trial / 128) - 2*floor(trial / 256))*1.8
alter VB7 = $&drive
stop when time = 0.000286
resume
delete all
let endpoint = length(time)-1
let cmp = v(COMP)[endpoint]
let top = v(TOP)[endpoint]
let decision = 0
if cmp >= 0.9
let code = trial
let decision = 1
end
echo 15 1 $&trial $&cmp $&top 0.05859375 $&decision >> decisions.csv
let trial = code + 1
let drive = (floor(trial / 1) - 2*floor(trial / 2))*1.8
alter VB0 = $&drive
let drive = (floor(trial / 2) - 2*floor(trial / 4))*1.8
alter VB1 = $&drive
let drive = (floor(trial / 4) - 2*floor(trial / 8))*1.8
alter VB2 = $&drive
let drive = (floor(trial / 8) - 2*floor(trial / 16))*1.8
alter VB3 = $&drive
let drive = (floor(trial / 16) - 2*floor(trial / 32))*1.8
alter VB4 = $&drive
let drive = (floor(trial / 32) - 2*floor(trial / 64))*1.8
alter VB5 = $&drive
let drive = (floor(trial / 64) - 2*floor(trial / 128))*1.8
alter VB6 = $&drive
let drive = (floor(trial / 128) - 2*floor(trial / 256))*1.8
alter VB7 = $&drive
stop when time = 0.000288
resume
delete all
let endpoint = length(time)-1
let cmp = v(COMP)[endpoint]
let top = v(TOP)[endpoint]
let decision = 0
if cmp >= 0.9
let code = trial
let decision = 1
end
echo 15 0 $&trial $&cmp $&top 0.05859375 $&decision >> decisions.csv
alter VIN = 0.06328125
alter VSAMPLE = 1.8
alter VB0 = 0
alter VB1 = 0
alter VB2 = 0
alter VB3 = 0
alter VB4 = 0
alter VB5 = 0
alter VB6 = 0
alter VB7 = 0
let code = 0
stop when time = 0.00029
resume
delete all
alter VSAMPLE = 0
let trial = code + 128
let drive = (floor(trial / 1) - 2*floor(trial / 2))*1.8
alter VB0 = $&drive
let drive = (floor(trial / 2) - 2*floor(trial / 4))*1.8
alter VB1 = $&drive
let drive = (floor(trial / 4) - 2*floor(trial / 8))*1.8
alter VB2 = $&drive
let drive = (floor(trial / 8) - 2*floor(trial / 16))*1.8
alter VB3 = $&drive
let drive = (floor(trial / 16) - 2*floor(trial / 32))*1.8
alter VB4 = $&drive
let drive = (floor(trial / 32) - 2*floor(trial / 64))*1.8
alter VB5 = $&drive
let drive = (floor(trial / 64) - 2*floor(trial / 128))*1.8
alter VB6 = $&drive
let drive = (floor(trial / 128) - 2*floor(trial / 256))*1.8
alter VB7 = $&drive
stop when time = 0.000292
resume
delete all
let endpoint = length(time)-1
let cmp = v(COMP)[endpoint]
let top = v(TOP)[endpoint]
let decision = 0
if cmp >= 0.9
let code = trial
let decision = 1
end
echo 16 7 $&trial $&cmp $&top 0.06328125 $&decision >> decisions.csv
let trial = code + 64
let drive = (floor(trial / 1) - 2*floor(trial / 2))*1.8
alter VB0 = $&drive
let drive = (floor(trial / 2) - 2*floor(trial / 4))*1.8
alter VB1 = $&drive
let drive = (floor(trial / 4) - 2*floor(trial / 8))*1.8
alter VB2 = $&drive
let drive = (floor(trial / 8) - 2*floor(trial / 16))*1.8
alter VB3 = $&drive
let drive = (floor(trial / 16) - 2*floor(trial / 32))*1.8
alter VB4 = $&drive
let drive = (floor(trial / 32) - 2*floor(trial / 64))*1.8
alter VB5 = $&drive
let drive = (floor(trial / 64) - 2*floor(trial / 128))*1.8
alter VB6 = $&drive
let drive = (floor(trial / 128) - 2*floor(trial / 256))*1.8
alter VB7 = $&drive
stop when time = 0.000294
resume
delete all
let endpoint = length(time)-1
let cmp = v(COMP)[endpoint]
let top = v(TOP)[endpoint]
let decision = 0
if cmp >= 0.9
let code = trial
let decision = 1
end
echo 16 6 $&trial $&cmp $&top 0.06328125 $&decision >> decisions.csv
let trial = code + 32
let drive = (floor(trial / 1) - 2*floor(trial / 2))*1.8
alter VB0 = $&drive
let drive = (floor(trial / 2) - 2*floor(trial / 4))*1.8
alter VB1 = $&drive
let drive = (floor(trial / 4) - 2*floor(trial / 8))*1.8
alter VB2 = $&drive
let drive = (floor(trial / 8) - 2*floor(trial / 16))*1.8
alter VB3 = $&drive
let drive = (floor(trial / 16) - 2*floor(trial / 32))*1.8
alter VB4 = $&drive
let drive = (floor(trial / 32) - 2*floor(trial / 64))*1.8
alter VB5 = $&drive
let drive = (floor(trial / 64) - 2*floor(trial / 128))*1.8
alter VB6 = $&drive
let drive = (floor(trial / 128) - 2*floor(trial / 256))*1.8
alter VB7 = $&drive
stop when time = 0.000296
resume
delete all
let endpoint = length(time)-1
let cmp = v(COMP)[endpoint]
let top = v(TOP)[endpoint]
let decision = 0
if cmp >= 0.9
let code = trial
let decision = 1
end
echo 16 5 $&trial $&cmp $&top 0.06328125 $&decision >> decisions.csv
let trial = code + 16
let drive = (floor(trial / 1) - 2*floor(trial / 2))*1.8
alter VB0 = $&drive
let drive = (floor(trial / 2) - 2*floor(trial / 4))*1.8
alter VB1 = $&drive
let drive = (floor(trial / 4) - 2*floor(trial / 8))*1.8
alter VB2 = $&drive
let drive = (floor(trial / 8) - 2*floor(trial / 16))*1.8
alter VB3 = $&drive
let drive = (floor(trial / 16) - 2*floor(trial / 32))*1.8
alter VB4 = $&drive
let drive = (floor(trial / 32) - 2*floor(trial / 64))*1.8
alter VB5 = $&drive
let drive = (floor(trial / 64) - 2*floor(trial / 128))*1.8
alter VB6 = $&drive
let drive = (floor(trial / 128) - 2*floor(trial / 256))*1.8
alter VB7 = $&drive
stop when time = 0.000298
resume
delete all
let endpoint = length(time)-1
let cmp = v(COMP)[endpoint]
let top = v(TOP)[endpoint]
let decision = 0
if cmp >= 0.9
let code = trial
let decision = 1
end
echo 16 4 $&trial $&cmp $&top 0.06328125 $&decision >> decisions.csv
let trial = code + 8
let drive = (floor(trial / 1) - 2*floor(trial / 2))*1.8
alter VB0 = $&drive
let drive = (floor(trial / 2) - 2*floor(trial / 4))*1.8
alter VB1 = $&drive
let drive = (floor(trial / 4) - 2*floor(trial / 8))*1.8
alter VB2 = $&drive
let drive = (floor(trial / 8) - 2*floor(trial / 16))*1.8
alter VB3 = $&drive
let drive = (floor(trial / 16) - 2*floor(trial / 32))*1.8
alter VB4 = $&drive
let drive = (floor(trial / 32) - 2*floor(trial / 64))*1.8
alter VB5 = $&drive
let drive = (floor(trial / 64) - 2*floor(trial / 128))*1.8
alter VB6 = $&drive
let drive = (floor(trial / 128) - 2*floor(trial / 256))*1.8
alter VB7 = $&drive
stop when time = 0.0003
resume
delete all
let endpoint = length(time)-1
let cmp = v(COMP)[endpoint]
let top = v(TOP)[endpoint]
let decision = 0
if cmp >= 0.9
let code = trial
let decision = 1
end
echo 16 3 $&trial $&cmp $&top 0.06328125 $&decision >> decisions.csv
let trial = code + 4
let drive = (floor(trial / 1) - 2*floor(trial / 2))*1.8
alter VB0 = $&drive
let drive = (floor(trial / 2) - 2*floor(trial / 4))*1.8
alter VB1 = $&drive
let drive = (floor(trial / 4) - 2*floor(trial / 8))*1.8
alter VB2 = $&drive
let drive = (floor(trial / 8) - 2*floor(trial / 16))*1.8
alter VB3 = $&drive
let drive = (floor(trial / 16) - 2*floor(trial / 32))*1.8
alter VB4 = $&drive
let drive = (floor(trial / 32) - 2*floor(trial / 64))*1.8
alter VB5 = $&drive
let drive = (floor(trial / 64) - 2*floor(trial / 128))*1.8
alter VB6 = $&drive
let drive = (floor(trial / 128) - 2*floor(trial / 256))*1.8
alter VB7 = $&drive
stop when time = 0.000302
resume
delete all
let endpoint = length(time)-1
let cmp = v(COMP)[endpoint]
let top = v(TOP)[endpoint]
let decision = 0
if cmp >= 0.9
let code = trial
let decision = 1
end
echo 16 2 $&trial $&cmp $&top 0.06328125 $&decision >> decisions.csv
let trial = code + 2
let drive = (floor(trial / 1) - 2*floor(trial / 2))*1.8
alter VB0 = $&drive
let drive = (floor(trial / 2) - 2*floor(trial / 4))*1.8
alter VB1 = $&drive
let drive = (floor(trial / 4) - 2*floor(trial / 8))*1.8
alter VB2 = $&drive
let drive = (floor(trial / 8) - 2*floor(trial / 16))*1.8
alter VB3 = $&drive
let drive = (floor(trial / 16) - 2*floor(trial / 32))*1.8
alter VB4 = $&drive
let drive = (floor(trial / 32) - 2*floor(trial / 64))*1.8
alter VB5 = $&drive
let drive = (floor(trial / 64) - 2*floor(trial / 128))*1.8
alter VB6 = $&drive
let drive = (floor(trial / 128) - 2*floor(trial / 256))*1.8
alter VB7 = $&drive
stop when time = 0.000304
resume
delete all
let endpoint = length(time)-1
let cmp = v(COMP)[endpoint]
let top = v(TOP)[endpoint]
let decision = 0
if cmp >= 0.9
let code = trial
let decision = 1
end
echo 16 1 $&trial $&cmp $&top 0.06328125 $&decision >> decisions.csv
let trial = code + 1
let drive = (floor(trial / 1) - 2*floor(trial / 2))*1.8
alter VB0 = $&drive
let drive = (floor(trial / 2) - 2*floor(trial / 4))*1.8
alter VB1 = $&drive
let drive = (floor(trial / 4) - 2*floor(trial / 8))*1.8
alter VB2 = $&drive
let drive = (floor(trial / 8) - 2*floor(trial / 16))*1.8
alter VB3 = $&drive
let drive = (floor(trial / 16) - 2*floor(trial / 32))*1.8
alter VB4 = $&drive
let drive = (floor(trial / 32) - 2*floor(trial / 64))*1.8
alter VB5 = $&drive
let drive = (floor(trial / 64) - 2*floor(trial / 128))*1.8
alter VB6 = $&drive
let drive = (floor(trial / 128) - 2*floor(trial / 256))*1.8
alter VB7 = $&drive
stop when time = 0.000306
resume
delete all
let endpoint = length(time)-1
let cmp = v(COMP)[endpoint]
let top = v(TOP)[endpoint]
let decision = 0
if cmp >= 0.9
let code = trial
let decision = 1
end
echo 16 0 $&trial $&cmp $&top 0.06328125 $&decision >> decisions.csv
alter VIN = 0.06796875
alter VSAMPLE = 1.8
alter VB0 = 0
alter VB1 = 0
alter VB2 = 0
alter VB3 = 0
alter VB4 = 0
alter VB5 = 0
alter VB6 = 0
alter VB7 = 0
let code = 0
stop when time = 0.000308
resume
delete all
alter VSAMPLE = 0
let trial = code + 128
let drive = (floor(trial / 1) - 2*floor(trial / 2))*1.8
alter VB0 = $&drive
let drive = (floor(trial / 2) - 2*floor(trial / 4))*1.8
alter VB1 = $&drive
let drive = (floor(trial / 4) - 2*floor(trial / 8))*1.8
alter VB2 = $&drive
let drive = (floor(trial / 8) - 2*floor(trial / 16))*1.8
alter VB3 = $&drive
let drive = (floor(trial / 16) - 2*floor(trial / 32))*1.8
alter VB4 = $&drive
let drive = (floor(trial / 32) - 2*floor(trial / 64))*1.8
alter VB5 = $&drive
let drive = (floor(trial / 64) - 2*floor(trial / 128))*1.8
alter VB6 = $&drive
let drive = (floor(trial / 128) - 2*floor(trial / 256))*1.8
alter VB7 = $&drive
stop when time = 0.00031
resume
delete all
let endpoint = length(time)-1
let cmp = v(COMP)[endpoint]
let top = v(TOP)[endpoint]
let decision = 0
if cmp >= 0.9
let code = trial
let decision = 1
end
echo 17 7 $&trial $&cmp $&top 0.06796875 $&decision >> decisions.csv
let trial = code + 64
let drive = (floor(trial / 1) - 2*floor(trial / 2))*1.8
alter VB0 = $&drive
let drive = (floor(trial / 2) - 2*floor(trial / 4))*1.8
alter VB1 = $&drive
let drive = (floor(trial / 4) - 2*floor(trial / 8))*1.8
alter VB2 = $&drive
let drive = (floor(trial / 8) - 2*floor(trial / 16))*1.8
alter VB3 = $&drive
let drive = (floor(trial / 16) - 2*floor(trial / 32))*1.8
alter VB4 = $&drive
let drive = (floor(trial / 32) - 2*floor(trial / 64))*1.8
alter VB5 = $&drive
let drive = (floor(trial / 64) - 2*floor(trial / 128))*1.8
alter VB6 = $&drive
let drive = (floor(trial / 128) - 2*floor(trial / 256))*1.8
alter VB7 = $&drive
stop when time = 0.000312
resume
delete all
let endpoint = length(time)-1
let cmp = v(COMP)[endpoint]
let top = v(TOP)[endpoint]
let decision = 0
if cmp >= 0.9
let code = trial
let decision = 1
end
echo 17 6 $&trial $&cmp $&top 0.06796875 $&decision >> decisions.csv
let trial = code + 32
let drive = (floor(trial / 1) - 2*floor(trial / 2))*1.8
alter VB0 = $&drive
let drive = (floor(trial / 2) - 2*floor(trial / 4))*1.8
alter VB1 = $&drive
let drive = (floor(trial / 4) - 2*floor(trial / 8))*1.8
alter VB2 = $&drive
let drive = (floor(trial / 8) - 2*floor(trial / 16))*1.8
alter VB3 = $&drive
let drive = (floor(trial / 16) - 2*floor(trial / 32))*1.8
alter VB4 = $&drive
let drive = (floor(trial / 32) - 2*floor(trial / 64))*1.8
alter VB5 = $&drive
let drive = (floor(trial / 64) - 2*floor(trial / 128))*1.8
alter VB6 = $&drive
let drive = (floor(trial / 128) - 2*floor(trial / 256))*1.8
alter VB7 = $&drive
stop when time = 0.000314
resume
delete all
let endpoint = length(time)-1
let cmp = v(COMP)[endpoint]
let top = v(TOP)[endpoint]
let decision = 0
if cmp >= 0.9
let code = trial
let decision = 1
end
echo 17 5 $&trial $&cmp $&top 0.06796875 $&decision >> decisions.csv
let trial = code + 16
let drive = (floor(trial / 1) - 2*floor(trial / 2))*1.8
alter VB0 = $&drive
let drive = (floor(trial / 2) - 2*floor(trial / 4))*1.8
alter VB1 = $&drive
let drive = (floor(trial / 4) - 2*floor(trial / 8))*1.8
alter VB2 = $&drive
let drive = (floor(trial / 8) - 2*floor(trial / 16))*1.8
alter VB3 = $&drive
let drive = (floor(trial / 16) - 2*floor(trial / 32))*1.8
alter VB4 = $&drive
let drive = (floor(trial / 32) - 2*floor(trial / 64))*1.8
alter VB5 = $&drive
let drive = (floor(trial / 64) - 2*floor(trial / 128))*1.8
alter VB6 = $&drive
let drive = (floor(trial / 128) - 2*floor(trial / 256))*1.8
alter VB7 = $&drive
stop when time = 0.000316
resume
delete all
let endpoint = length(time)-1
let cmp = v(COMP)[endpoint]
let top = v(TOP)[endpoint]
let decision = 0
if cmp >= 0.9
let code = trial
let decision = 1
end
echo 17 4 $&trial $&cmp $&top 0.06796875 $&decision >> decisions.csv
let trial = code + 8
let drive = (floor(trial / 1) - 2*floor(trial / 2))*1.8
alter VB0 = $&drive
let drive = (floor(trial / 2) - 2*floor(trial / 4))*1.8
alter VB1 = $&drive
let drive = (floor(trial / 4) - 2*floor(trial / 8))*1.8
alter VB2 = $&drive
let drive = (floor(trial / 8) - 2*floor(trial / 16))*1.8
alter VB3 = $&drive
let drive = (floor(trial / 16) - 2*floor(trial / 32))*1.8
alter VB4 = $&drive
let drive = (floor(trial / 32) - 2*floor(trial / 64))*1.8
alter VB5 = $&drive
let drive = (floor(trial / 64) - 2*floor(trial / 128))*1.8
alter VB6 = $&drive
let drive = (floor(trial / 128) - 2*floor(trial / 256))*1.8
alter VB7 = $&drive
stop when time = 0.000318
resume
delete all
let endpoint = length(time)-1
let cmp = v(COMP)[endpoint]
let top = v(TOP)[endpoint]
let decision = 0
if cmp >= 0.9
let code = trial
let decision = 1
end
echo 17 3 $&trial $&cmp $&top 0.06796875 $&decision >> decisions.csv
let trial = code + 4
let drive = (floor(trial / 1) - 2*floor(trial / 2))*1.8
alter VB0 = $&drive
let drive = (floor(trial / 2) - 2*floor(trial / 4))*1.8
alter VB1 = $&drive
let drive = (floor(trial / 4) - 2*floor(trial / 8))*1.8
alter VB2 = $&drive
let drive = (floor(trial / 8) - 2*floor(trial / 16))*1.8
alter VB3 = $&drive
let drive = (floor(trial / 16) - 2*floor(trial / 32))*1.8
alter VB4 = $&drive
let drive = (floor(trial / 32) - 2*floor(trial / 64))*1.8
alter VB5 = $&drive
let drive = (floor(trial / 64) - 2*floor(trial / 128))*1.8
alter VB6 = $&drive
let drive = (floor(trial / 128) - 2*floor(trial / 256))*1.8
alter VB7 = $&drive
stop when time = 0.00032
resume
delete all
let endpoint = length(time)-1
let cmp = v(COMP)[endpoint]
let top = v(TOP)[endpoint]
let decision = 0
if cmp >= 0.9
let code = trial
let decision = 1
end
echo 17 2 $&trial $&cmp $&top 0.06796875 $&decision >> decisions.csv
let trial = code + 2
let drive = (floor(trial / 1) - 2*floor(trial / 2))*1.8
alter VB0 = $&drive
let drive = (floor(trial / 2) - 2*floor(trial / 4))*1.8
alter VB1 = $&drive
let drive = (floor(trial / 4) - 2*floor(trial / 8))*1.8
alter VB2 = $&drive
let drive = (floor(trial / 8) - 2*floor(trial / 16))*1.8
alter VB3 = $&drive
let drive = (floor(trial / 16) - 2*floor(trial / 32))*1.8
alter VB4 = $&drive
let drive = (floor(trial / 32) - 2*floor(trial / 64))*1.8
alter VB5 = $&drive
let drive = (floor(trial / 64) - 2*floor(trial / 128))*1.8
alter VB6 = $&drive
let drive = (floor(trial / 128) - 2*floor(trial / 256))*1.8
alter VB7 = $&drive
stop when time = 0.000322
resume
delete all
let endpoint = length(time)-1
let cmp = v(COMP)[endpoint]
let top = v(TOP)[endpoint]
let decision = 0
if cmp >= 0.9
let code = trial
let decision = 1
end
echo 17 1 $&trial $&cmp $&top 0.06796875 $&decision >> decisions.csv
let trial = code + 1
let drive = (floor(trial / 1) - 2*floor(trial / 2))*1.8
alter VB0 = $&drive
let drive = (floor(trial / 2) - 2*floor(trial / 4))*1.8
alter VB1 = $&drive
let drive = (floor(trial / 4) - 2*floor(trial / 8))*1.8
alter VB2 = $&drive
let drive = (floor(trial / 8) - 2*floor(trial / 16))*1.8
alter VB3 = $&drive
let drive = (floor(trial / 16) - 2*floor(trial / 32))*1.8
alter VB4 = $&drive
let drive = (floor(trial / 32) - 2*floor(trial / 64))*1.8
alter VB5 = $&drive
let drive = (floor(trial / 64) - 2*floor(trial / 128))*1.8
alter VB6 = $&drive
let drive = (floor(trial / 128) - 2*floor(trial / 256))*1.8
alter VB7 = $&drive
stop when time = 0.000324
resume
delete all
let endpoint = length(time)-1
let cmp = v(COMP)[endpoint]
let top = v(TOP)[endpoint]
let decision = 0
if cmp >= 0.9
let code = trial
let decision = 1
end
echo 17 0 $&trial $&cmp $&top 0.06796875 $&decision >> decisions.csv
alter VIN = 0.07265625
alter VSAMPLE = 1.8
alter VB0 = 0
alter VB1 = 0
alter VB2 = 0
alter VB3 = 0
alter VB4 = 0
alter VB5 = 0
alter VB6 = 0
alter VB7 = 0
let code = 0
stop when time = 0.000326
resume
delete all
alter VSAMPLE = 0
let trial = code + 128
let drive = (floor(trial / 1) - 2*floor(trial / 2))*1.8
alter VB0 = $&drive
let drive = (floor(trial / 2) - 2*floor(trial / 4))*1.8
alter VB1 = $&drive
let drive = (floor(trial / 4) - 2*floor(trial / 8))*1.8
alter VB2 = $&drive
let drive = (floor(trial / 8) - 2*floor(trial / 16))*1.8
alter VB3 = $&drive
let drive = (floor(trial / 16) - 2*floor(trial / 32))*1.8
alter VB4 = $&drive
let drive = (floor(trial / 32) - 2*floor(trial / 64))*1.8
alter VB5 = $&drive
let drive = (floor(trial / 64) - 2*floor(trial / 128))*1.8
alter VB6 = $&drive
let drive = (floor(trial / 128) - 2*floor(trial / 256))*1.8
alter VB7 = $&drive
stop when time = 0.000328
resume
delete all
let endpoint = length(time)-1
let cmp = v(COMP)[endpoint]
let top = v(TOP)[endpoint]
let decision = 0
if cmp >= 0.9
let code = trial
let decision = 1
end
echo 18 7 $&trial $&cmp $&top 0.07265625 $&decision >> decisions.csv
let trial = code + 64
let drive = (floor(trial / 1) - 2*floor(trial / 2))*1.8
alter VB0 = $&drive
let drive = (floor(trial / 2) - 2*floor(trial / 4))*1.8
alter VB1 = $&drive
let drive = (floor(trial / 4) - 2*floor(trial / 8))*1.8
alter VB2 = $&drive
let drive = (floor(trial / 8) - 2*floor(trial / 16))*1.8
alter VB3 = $&drive
let drive = (floor(trial / 16) - 2*floor(trial / 32))*1.8
alter VB4 = $&drive
let drive = (floor(trial / 32) - 2*floor(trial / 64))*1.8
alter VB5 = $&drive
let drive = (floor(trial / 64) - 2*floor(trial / 128))*1.8
alter VB6 = $&drive
let drive = (floor(trial / 128) - 2*floor(trial / 256))*1.8
alter VB7 = $&drive
stop when time = 0.00033
resume
delete all
let endpoint = length(time)-1
let cmp = v(COMP)[endpoint]
let top = v(TOP)[endpoint]
let decision = 0
if cmp >= 0.9
let code = trial
let decision = 1
end
echo 18 6 $&trial $&cmp $&top 0.07265625 $&decision >> decisions.csv
let trial = code + 32
let drive = (floor(trial / 1) - 2*floor(trial / 2))*1.8
alter VB0 = $&drive
let drive = (floor(trial / 2) - 2*floor(trial / 4))*1.8
alter VB1 = $&drive
let drive = (floor(trial / 4) - 2*floor(trial / 8))*1.8
alter VB2 = $&drive
let drive = (floor(trial / 8) - 2*floor(trial / 16))*1.8
alter VB3 = $&drive
let drive = (floor(trial / 16) - 2*floor(trial / 32))*1.8
alter VB4 = $&drive
let drive = (floor(trial / 32) - 2*floor(trial / 64))*1.8
alter VB5 = $&drive
let drive = (floor(trial / 64) - 2*floor(trial / 128))*1.8
alter VB6 = $&drive
let drive = (floor(trial / 128) - 2*floor(trial / 256))*1.8
alter VB7 = $&drive
stop when time = 0.000332
resume
delete all
let endpoint = length(time)-1
let cmp = v(COMP)[endpoint]
let top = v(TOP)[endpoint]
let decision = 0
if cmp >= 0.9
let code = trial
let decision = 1
end
echo 18 5 $&trial $&cmp $&top 0.07265625 $&decision >> decisions.csv
let trial = code + 16
let drive = (floor(trial / 1) - 2*floor(trial / 2))*1.8
alter VB0 = $&drive
let drive = (floor(trial / 2) - 2*floor(trial / 4))*1.8
alter VB1 = $&drive
let drive = (floor(trial / 4) - 2*floor(trial / 8))*1.8
alter VB2 = $&drive
let drive = (floor(trial / 8) - 2*floor(trial / 16))*1.8
alter VB3 = $&drive
let drive = (floor(trial / 16) - 2*floor(trial / 32))*1.8
alter VB4 = $&drive
let drive = (floor(trial / 32) - 2*floor(trial / 64))*1.8
alter VB5 = $&drive
let drive = (floor(trial / 64) - 2*floor(trial / 128))*1.8
alter VB6 = $&drive
let drive = (floor(trial / 128) - 2*floor(trial / 256))*1.8
alter VB7 = $&drive
stop when time = 0.000334
resume
delete all
let endpoint = length(time)-1
let cmp = v(COMP)[endpoint]
let top = v(TOP)[endpoint]
let decision = 0
if cmp >= 0.9
let code = trial
let decision = 1
end
echo 18 4 $&trial $&cmp $&top 0.07265625 $&decision >> decisions.csv
let trial = code + 8
let drive = (floor(trial / 1) - 2*floor(trial / 2))*1.8
alter VB0 = $&drive
let drive = (floor(trial / 2) - 2*floor(trial / 4))*1.8
alter VB1 = $&drive
let drive = (floor(trial / 4) - 2*floor(trial / 8))*1.8
alter VB2 = $&drive
let drive = (floor(trial / 8) - 2*floor(trial / 16))*1.8
alter VB3 = $&drive
let drive = (floor(trial / 16) - 2*floor(trial / 32))*1.8
alter VB4 = $&drive
let drive = (floor(trial / 32) - 2*floor(trial / 64))*1.8
alter VB5 = $&drive
let drive = (floor(trial / 64) - 2*floor(trial / 128))*1.8
alter VB6 = $&drive
let drive = (floor(trial / 128) - 2*floor(trial / 256))*1.8
alter VB7 = $&drive
stop when time = 0.000336
resume
delete all
let endpoint = length(time)-1
let cmp = v(COMP)[endpoint]
let top = v(TOP)[endpoint]
let decision = 0
if cmp >= 0.9
let code = trial
let decision = 1
end
echo 18 3 $&trial $&cmp $&top 0.07265625 $&decision >> decisions.csv
let trial = code + 4
let drive = (floor(trial / 1) - 2*floor(trial / 2))*1.8
alter VB0 = $&drive
let drive = (floor(trial / 2) - 2*floor(trial / 4))*1.8
alter VB1 = $&drive
let drive = (floor(trial / 4) - 2*floor(trial / 8))*1.8
alter VB2 = $&drive
let drive = (floor(trial / 8) - 2*floor(trial / 16))*1.8
alter VB3 = $&drive
let drive = (floor(trial / 16) - 2*floor(trial / 32))*1.8
alter VB4 = $&drive
let drive = (floor(trial / 32) - 2*floor(trial / 64))*1.8
alter VB5 = $&drive
let drive = (floor(trial / 64) - 2*floor(trial / 128))*1.8
alter VB6 = $&drive
let drive = (floor(trial / 128) - 2*floor(trial / 256))*1.8
alter VB7 = $&drive
stop when time = 0.000338
resume
delete all
let endpoint = length(time)-1
let cmp = v(COMP)[endpoint]
let top = v(TOP)[endpoint]
let decision = 0
if cmp >= 0.9
let code = trial
let decision = 1
end
echo 18 2 $&trial $&cmp $&top 0.07265625 $&decision >> decisions.csv
let trial = code + 2
let drive = (floor(trial / 1) - 2*floor(trial / 2))*1.8
alter VB0 = $&drive
let drive = (floor(trial / 2) - 2*floor(trial / 4))*1.8
alter VB1 = $&drive
let drive = (floor(trial / 4) - 2*floor(trial / 8))*1.8
alter VB2 = $&drive
let drive = (floor(trial / 8) - 2*floor(trial / 16))*1.8
alter VB3 = $&drive
let drive = (floor(trial / 16) - 2*floor(trial / 32))*1.8
alter VB4 = $&drive
let drive = (floor(trial / 32) - 2*floor(trial / 64))*1.8
alter VB5 = $&drive
let drive = (floor(trial / 64) - 2*floor(trial / 128))*1.8
alter VB6 = $&drive
let drive = (floor(trial / 128) - 2*floor(trial / 256))*1.8
alter VB7 = $&drive
stop when time = 0.00034
resume
delete all
let endpoint = length(time)-1
let cmp = v(COMP)[endpoint]
let top = v(TOP)[endpoint]
let decision = 0
if cmp >= 0.9
let code = trial
let decision = 1
end
echo 18 1 $&trial $&cmp $&top 0.07265625 $&decision >> decisions.csv
let trial = code + 1
let drive = (floor(trial / 1) - 2*floor(trial / 2))*1.8
alter VB0 = $&drive
let drive = (floor(trial / 2) - 2*floor(trial / 4))*1.8
alter VB1 = $&drive
let drive = (floor(trial / 4) - 2*floor(trial / 8))*1.8
alter VB2 = $&drive
let drive = (floor(trial / 8) - 2*floor(trial / 16))*1.8
alter VB3 = $&drive
let drive = (floor(trial / 16) - 2*floor(trial / 32))*1.8
alter VB4 = $&drive
let drive = (floor(trial / 32) - 2*floor(trial / 64))*1.8
alter VB5 = $&drive
let drive = (floor(trial / 64) - 2*floor(trial / 128))*1.8
alter VB6 = $&drive
let drive = (floor(trial / 128) - 2*floor(trial / 256))*1.8
alter VB7 = $&drive
stop when time = 0.000342
resume
delete all
let endpoint = length(time)-1
let cmp = v(COMP)[endpoint]
let top = v(TOP)[endpoint]
let decision = 0
if cmp >= 0.9
let code = trial
let decision = 1
end
echo 18 0 $&trial $&cmp $&top 0.07265625 $&decision >> decisions.csv
alter VIN = 0.07734375
alter VSAMPLE = 1.8
alter VB0 = 0
alter VB1 = 0
alter VB2 = 0
alter VB3 = 0
alter VB4 = 0
alter VB5 = 0
alter VB6 = 0
alter VB7 = 0
let code = 0
stop when time = 0.000344
resume
delete all
alter VSAMPLE = 0
let trial = code + 128
let drive = (floor(trial / 1) - 2*floor(trial / 2))*1.8
alter VB0 = $&drive
let drive = (floor(trial / 2) - 2*floor(trial / 4))*1.8
alter VB1 = $&drive
let drive = (floor(trial / 4) - 2*floor(trial / 8))*1.8
alter VB2 = $&drive
let drive = (floor(trial / 8) - 2*floor(trial / 16))*1.8
alter VB3 = $&drive
let drive = (floor(trial / 16) - 2*floor(trial / 32))*1.8
alter VB4 = $&drive
let drive = (floor(trial / 32) - 2*floor(trial / 64))*1.8
alter VB5 = $&drive
let drive = (floor(trial / 64) - 2*floor(trial / 128))*1.8
alter VB6 = $&drive
let drive = (floor(trial / 128) - 2*floor(trial / 256))*1.8
alter VB7 = $&drive
stop when time = 0.000346
resume
delete all
let endpoint = length(time)-1
let cmp = v(COMP)[endpoint]
let top = v(TOP)[endpoint]
let decision = 0
if cmp >= 0.9
let code = trial
let decision = 1
end
echo 19 7 $&trial $&cmp $&top 0.07734375 $&decision >> decisions.csv
let trial = code + 64
let drive = (floor(trial / 1) - 2*floor(trial / 2))*1.8
alter VB0 = $&drive
let drive = (floor(trial / 2) - 2*floor(trial / 4))*1.8
alter VB1 = $&drive
let drive = (floor(trial / 4) - 2*floor(trial / 8))*1.8
alter VB2 = $&drive
let drive = (floor(trial / 8) - 2*floor(trial / 16))*1.8
alter VB3 = $&drive
let drive = (floor(trial / 16) - 2*floor(trial / 32))*1.8
alter VB4 = $&drive
let drive = (floor(trial / 32) - 2*floor(trial / 64))*1.8
alter VB5 = $&drive
let drive = (floor(trial / 64) - 2*floor(trial / 128))*1.8
alter VB6 = $&drive
let drive = (floor(trial / 128) - 2*floor(trial / 256))*1.8
alter VB7 = $&drive
stop when time = 0.000348
resume
delete all
let endpoint = length(time)-1
let cmp = v(COMP)[endpoint]
let top = v(TOP)[endpoint]
let decision = 0
if cmp >= 0.9
let code = trial
let decision = 1
end
echo 19 6 $&trial $&cmp $&top 0.07734375 $&decision >> decisions.csv
let trial = code + 32
let drive = (floor(trial / 1) - 2*floor(trial / 2))*1.8
alter VB0 = $&drive
let drive = (floor(trial / 2) - 2*floor(trial / 4))*1.8
alter VB1 = $&drive
let drive = (floor(trial / 4) - 2*floor(trial / 8))*1.8
alter VB2 = $&drive
let drive = (floor(trial / 8) - 2*floor(trial / 16))*1.8
alter VB3 = $&drive
let drive = (floor(trial / 16) - 2*floor(trial / 32))*1.8
alter VB4 = $&drive
let drive = (floor(trial / 32) - 2*floor(trial / 64))*1.8
alter VB5 = $&drive
let drive = (floor(trial / 64) - 2*floor(trial / 128))*1.8
alter VB6 = $&drive
let drive = (floor(trial / 128) - 2*floor(trial / 256))*1.8
alter VB7 = $&drive
stop when time = 0.00035
resume
delete all
let endpoint = length(time)-1
let cmp = v(COMP)[endpoint]
let top = v(TOP)[endpoint]
let decision = 0
if cmp >= 0.9
let code = trial
let decision = 1
end
echo 19 5 $&trial $&cmp $&top 0.07734375 $&decision >> decisions.csv
let trial = code + 16
let drive = (floor(trial / 1) - 2*floor(trial / 2))*1.8
alter VB0 = $&drive
let drive = (floor(trial / 2) - 2*floor(trial / 4))*1.8
alter VB1 = $&drive
let drive = (floor(trial / 4) - 2*floor(trial / 8))*1.8
alter VB2 = $&drive
let drive = (floor(trial / 8) - 2*floor(trial / 16))*1.8
alter VB3 = $&drive
let drive = (floor(trial / 16) - 2*floor(trial / 32))*1.8
alter VB4 = $&drive
let drive = (floor(trial / 32) - 2*floor(trial / 64))*1.8
alter VB5 = $&drive
let drive = (floor(trial / 64) - 2*floor(trial / 128))*1.8
alter VB6 = $&drive
let drive = (floor(trial / 128) - 2*floor(trial / 256))*1.8
alter VB7 = $&drive
stop when time = 0.000352
resume
delete all
let endpoint = length(time)-1
let cmp = v(COMP)[endpoint]
let top = v(TOP)[endpoint]
let decision = 0
if cmp >= 0.9
let code = trial
let decision = 1
end
echo 19 4 $&trial $&cmp $&top 0.07734375 $&decision >> decisions.csv
let trial = code + 8
let drive = (floor(trial / 1) - 2*floor(trial / 2))*1.8
alter VB0 = $&drive
let drive = (floor(trial / 2) - 2*floor(trial / 4))*1.8
alter VB1 = $&drive
let drive = (floor(trial / 4) - 2*floor(trial / 8))*1.8
alter VB2 = $&drive
let drive = (floor(trial / 8) - 2*floor(trial / 16))*1.8
alter VB3 = $&drive
let drive = (floor(trial / 16) - 2*floor(trial / 32))*1.8
alter VB4 = $&drive
let drive = (floor(trial / 32) - 2*floor(trial / 64))*1.8
alter VB5 = $&drive
let drive = (floor(trial / 64) - 2*floor(trial / 128))*1.8
alter VB6 = $&drive
let drive = (floor(trial / 128) - 2*floor(trial / 256))*1.8
alter VB7 = $&drive
stop when time = 0.000354
resume
delete all
let endpoint = length(time)-1
let cmp = v(COMP)[endpoint]
let top = v(TOP)[endpoint]
let decision = 0
if cmp >= 0.9
let code = trial
let decision = 1
end
echo 19 3 $&trial $&cmp $&top 0.07734375 $&decision >> decisions.csv
let trial = code + 4
let drive = (floor(trial / 1) - 2*floor(trial / 2))*1.8
alter VB0 = $&drive
let drive = (floor(trial / 2) - 2*floor(trial / 4))*1.8
alter VB1 = $&drive
let drive = (floor(trial / 4) - 2*floor(trial / 8))*1.8
alter VB2 = $&drive
let drive = (floor(trial / 8) - 2*floor(trial / 16))*1.8
alter VB3 = $&drive
let drive = (floor(trial / 16) - 2*floor(trial / 32))*1.8
alter VB4 = $&drive
let drive = (floor(trial / 32) - 2*floor(trial / 64))*1.8
alter VB5 = $&drive
let drive = (floor(trial / 64) - 2*floor(trial / 128))*1.8
alter VB6 = $&drive
let drive = (floor(trial / 128) - 2*floor(trial / 256))*1.8
alter VB7 = $&drive
stop when time = 0.000356
resume
delete all
let endpoint = length(time)-1
let cmp = v(COMP)[endpoint]
let top = v(TOP)[endpoint]
let decision = 0
if cmp >= 0.9
let code = trial
let decision = 1
end
echo 19 2 $&trial $&cmp $&top 0.07734375 $&decision >> decisions.csv
let trial = code + 2
let drive = (floor(trial / 1) - 2*floor(trial / 2))*1.8
alter VB0 = $&drive
let drive = (floor(trial / 2) - 2*floor(trial / 4))*1.8
alter VB1 = $&drive
let drive = (floor(trial / 4) - 2*floor(trial / 8))*1.8
alter VB2 = $&drive
let drive = (floor(trial / 8) - 2*floor(trial / 16))*1.8
alter VB3 = $&drive
let drive = (floor(trial / 16) - 2*floor(trial / 32))*1.8
alter VB4 = $&drive
let drive = (floor(trial / 32) - 2*floor(trial / 64))*1.8
alter VB5 = $&drive
let drive = (floor(trial / 64) - 2*floor(trial / 128))*1.8
alter VB6 = $&drive
let drive = (floor(trial / 128) - 2*floor(trial / 256))*1.8
alter VB7 = $&drive
stop when time = 0.000358
resume
delete all
let endpoint = length(time)-1
let cmp = v(COMP)[endpoint]
let top = v(TOP)[endpoint]
let decision = 0
if cmp >= 0.9
let code = trial
let decision = 1
end
echo 19 1 $&trial $&cmp $&top 0.07734375 $&decision >> decisions.csv
let trial = code + 1
let drive = (floor(trial / 1) - 2*floor(trial / 2))*1.8
alter VB0 = $&drive
let drive = (floor(trial / 2) - 2*floor(trial / 4))*1.8
alter VB1 = $&drive
let drive = (floor(trial / 4) - 2*floor(trial / 8))*1.8
alter VB2 = $&drive
let drive = (floor(trial / 8) - 2*floor(trial / 16))*1.8
alter VB3 = $&drive
let drive = (floor(trial / 16) - 2*floor(trial / 32))*1.8
alter VB4 = $&drive
let drive = (floor(trial / 32) - 2*floor(trial / 64))*1.8
alter VB5 = $&drive
let drive = (floor(trial / 64) - 2*floor(trial / 128))*1.8
alter VB6 = $&drive
let drive = (floor(trial / 128) - 2*floor(trial / 256))*1.8
alter VB7 = $&drive
stop when time = 0.00036
resume
delete all
let endpoint = length(time)-1
let cmp = v(COMP)[endpoint]
let top = v(TOP)[endpoint]
let decision = 0
if cmp >= 0.9
let code = trial
let decision = 1
end
echo 19 0 $&trial $&cmp $&top 0.07734375 $&decision >> decisions.csv
alter VIN = 0.08203125
alter VSAMPLE = 1.8
alter VB0 = 0
alter VB1 = 0
alter VB2 = 0
alter VB3 = 0
alter VB4 = 0
alter VB5 = 0
alter VB6 = 0
alter VB7 = 0
let code = 0
stop when time = 0.000362
resume
delete all
alter VSAMPLE = 0
let trial = code + 128
let drive = (floor(trial / 1) - 2*floor(trial / 2))*1.8
alter VB0 = $&drive
let drive = (floor(trial / 2) - 2*floor(trial / 4))*1.8
alter VB1 = $&drive
let drive = (floor(trial / 4) - 2*floor(trial / 8))*1.8
alter VB2 = $&drive
let drive = (floor(trial / 8) - 2*floor(trial / 16))*1.8
alter VB3 = $&drive
let drive = (floor(trial / 16) - 2*floor(trial / 32))*1.8
alter VB4 = $&drive
let drive = (floor(trial / 32) - 2*floor(trial / 64))*1.8
alter VB5 = $&drive
let drive = (floor(trial / 64) - 2*floor(trial / 128))*1.8
alter VB6 = $&drive
let drive = (floor(trial / 128) - 2*floor(trial / 256))*1.8
alter VB7 = $&drive
stop when time = 0.000364
resume
delete all
let endpoint = length(time)-1
let cmp = v(COMP)[endpoint]
let top = v(TOP)[endpoint]
let decision = 0
if cmp >= 0.9
let code = trial
let decision = 1
end
echo 20 7 $&trial $&cmp $&top 0.08203125 $&decision >> decisions.csv
let trial = code + 64
let drive = (floor(trial / 1) - 2*floor(trial / 2))*1.8
alter VB0 = $&drive
let drive = (floor(trial / 2) - 2*floor(trial / 4))*1.8
alter VB1 = $&drive
let drive = (floor(trial / 4) - 2*floor(trial / 8))*1.8
alter VB2 = $&drive
let drive = (floor(trial / 8) - 2*floor(trial / 16))*1.8
alter VB3 = $&drive
let drive = (floor(trial / 16) - 2*floor(trial / 32))*1.8
alter VB4 = $&drive
let drive = (floor(trial / 32) - 2*floor(trial / 64))*1.8
alter VB5 = $&drive
let drive = (floor(trial / 64) - 2*floor(trial / 128))*1.8
alter VB6 = $&drive
let drive = (floor(trial / 128) - 2*floor(trial / 256))*1.8
alter VB7 = $&drive
stop when time = 0.000366
resume
delete all
let endpoint = length(time)-1
let cmp = v(COMP)[endpoint]
let top = v(TOP)[endpoint]
let decision = 0
if cmp >= 0.9
let code = trial
let decision = 1
end
echo 20 6 $&trial $&cmp $&top 0.08203125 $&decision >> decisions.csv
let trial = code + 32
let drive = (floor(trial / 1) - 2*floor(trial / 2))*1.8
alter VB0 = $&drive
let drive = (floor(trial / 2) - 2*floor(trial / 4))*1.8
alter VB1 = $&drive
let drive = (floor(trial / 4) - 2*floor(trial / 8))*1.8
alter VB2 = $&drive
let drive = (floor(trial / 8) - 2*floor(trial / 16))*1.8
alter VB3 = $&drive
let drive = (floor(trial / 16) - 2*floor(trial / 32))*1.8
alter VB4 = $&drive
let drive = (floor(trial / 32) - 2*floor(trial / 64))*1.8
alter VB5 = $&drive
let drive = (floor(trial / 64) - 2*floor(trial / 128))*1.8
alter VB6 = $&drive
let drive = (floor(trial / 128) - 2*floor(trial / 256))*1.8
alter VB7 = $&drive
stop when time = 0.000368
resume
delete all
let endpoint = length(time)-1
let cmp = v(COMP)[endpoint]
let top = v(TOP)[endpoint]
let decision = 0
if cmp >= 0.9
let code = trial
let decision = 1
end
echo 20 5 $&trial $&cmp $&top 0.08203125 $&decision >> decisions.csv
let trial = code + 16
let drive = (floor(trial / 1) - 2*floor(trial / 2))*1.8
alter VB0 = $&drive
let drive = (floor(trial / 2) - 2*floor(trial / 4))*1.8
alter VB1 = $&drive
let drive = (floor(trial / 4) - 2*floor(trial / 8))*1.8
alter VB2 = $&drive
let drive = (floor(trial / 8) - 2*floor(trial / 16))*1.8
alter VB3 = $&drive
let drive = (floor(trial / 16) - 2*floor(trial / 32))*1.8
alter VB4 = $&drive
let drive = (floor(trial / 32) - 2*floor(trial / 64))*1.8
alter VB5 = $&drive
let drive = (floor(trial / 64) - 2*floor(trial / 128))*1.8
alter VB6 = $&drive
let drive = (floor(trial / 128) - 2*floor(trial / 256))*1.8
alter VB7 = $&drive
stop when time = 0.00037
resume
delete all
let endpoint = length(time)-1
let cmp = v(COMP)[endpoint]
let top = v(TOP)[endpoint]
let decision = 0
if cmp >= 0.9
let code = trial
let decision = 1
end
echo 20 4 $&trial $&cmp $&top 0.08203125 $&decision >> decisions.csv
let trial = code + 8
let drive = (floor(trial / 1) - 2*floor(trial / 2))*1.8
alter VB0 = $&drive
let drive = (floor(trial / 2) - 2*floor(trial / 4))*1.8
alter VB1 = $&drive
let drive = (floor(trial / 4) - 2*floor(trial / 8))*1.8
alter VB2 = $&drive
let drive = (floor(trial / 8) - 2*floor(trial / 16))*1.8
alter VB3 = $&drive
let drive = (floor(trial / 16) - 2*floor(trial / 32))*1.8
alter VB4 = $&drive
let drive = (floor(trial / 32) - 2*floor(trial / 64))*1.8
alter VB5 = $&drive
let drive = (floor(trial / 64) - 2*floor(trial / 128))*1.8
alter VB6 = $&drive
let drive = (floor(trial / 128) - 2*floor(trial / 256))*1.8
alter VB7 = $&drive
stop when time = 0.000372
resume
delete all
let endpoint = length(time)-1
let cmp = v(COMP)[endpoint]
let top = v(TOP)[endpoint]
let decision = 0
if cmp >= 0.9
let code = trial
let decision = 1
end
echo 20 3 $&trial $&cmp $&top 0.08203125 $&decision >> decisions.csv
let trial = code + 4
let drive = (floor(trial / 1) - 2*floor(trial / 2))*1.8
alter VB0 = $&drive
let drive = (floor(trial / 2) - 2*floor(trial / 4))*1.8
alter VB1 = $&drive
let drive = (floor(trial / 4) - 2*floor(trial / 8))*1.8
alter VB2 = $&drive
let drive = (floor(trial / 8) - 2*floor(trial / 16))*1.8
alter VB3 = $&drive
let drive = (floor(trial / 16) - 2*floor(trial / 32))*1.8
alter VB4 = $&drive
let drive = (floor(trial / 32) - 2*floor(trial / 64))*1.8
alter VB5 = $&drive
let drive = (floor(trial / 64) - 2*floor(trial / 128))*1.8
alter VB6 = $&drive
let drive = (floor(trial / 128) - 2*floor(trial / 256))*1.8
alter VB7 = $&drive
stop when time = 0.000374
resume
delete all
let endpoint = length(time)-1
let cmp = v(COMP)[endpoint]
let top = v(TOP)[endpoint]
let decision = 0
if cmp >= 0.9
let code = trial
let decision = 1
end
echo 20 2 $&trial $&cmp $&top 0.08203125 $&decision >> decisions.csv
let trial = code + 2
let drive = (floor(trial / 1) - 2*floor(trial / 2))*1.8
alter VB0 = $&drive
let drive = (floor(trial / 2) - 2*floor(trial / 4))*1.8
alter VB1 = $&drive
let drive = (floor(trial / 4) - 2*floor(trial / 8))*1.8
alter VB2 = $&drive
let drive = (floor(trial / 8) - 2*floor(trial / 16))*1.8
alter VB3 = $&drive
let drive = (floor(trial / 16) - 2*floor(trial / 32))*1.8
alter VB4 = $&drive
let drive = (floor(trial / 32) - 2*floor(trial / 64))*1.8
alter VB5 = $&drive
let drive = (floor(trial / 64) - 2*floor(trial / 128))*1.8
alter VB6 = $&drive
let drive = (floor(trial / 128) - 2*floor(trial / 256))*1.8
alter VB7 = $&drive
stop when time = 0.000376
resume
delete all
let endpoint = length(time)-1
let cmp = v(COMP)[endpoint]
let top = v(TOP)[endpoint]
let decision = 0
if cmp >= 0.9
let code = trial
let decision = 1
end
echo 20 1 $&trial $&cmp $&top 0.08203125 $&decision >> decisions.csv
let trial = code + 1
let drive = (floor(trial / 1) - 2*floor(trial / 2))*1.8
alter VB0 = $&drive
let drive = (floor(trial / 2) - 2*floor(trial / 4))*1.8
alter VB1 = $&drive
let drive = (floor(trial / 4) - 2*floor(trial / 8))*1.8
alter VB2 = $&drive
let drive = (floor(trial / 8) - 2*floor(trial / 16))*1.8
alter VB3 = $&drive
let drive = (floor(trial / 16) - 2*floor(trial / 32))*1.8
alter VB4 = $&drive
let drive = (floor(trial / 32) - 2*floor(trial / 64))*1.8
alter VB5 = $&drive
let drive = (floor(trial / 64) - 2*floor(trial / 128))*1.8
alter VB6 = $&drive
let drive = (floor(trial / 128) - 2*floor(trial / 256))*1.8
alter VB7 = $&drive
stop when time = 0.000378
resume
delete all
let endpoint = length(time)-1
let cmp = v(COMP)[endpoint]
let top = v(TOP)[endpoint]
let decision = 0
if cmp >= 0.9
let code = trial
let decision = 1
end
echo 20 0 $&trial $&cmp $&top 0.08203125 $&decision >> decisions.csv
alter VIN = 0.08671875
alter VSAMPLE = 1.8
alter VB0 = 0
alter VB1 = 0
alter VB2 = 0
alter VB3 = 0
alter VB4 = 0
alter VB5 = 0
alter VB6 = 0
alter VB7 = 0
let code = 0
stop when time = 0.00038
resume
delete all
alter VSAMPLE = 0
let trial = code + 128
let drive = (floor(trial / 1) - 2*floor(trial / 2))*1.8
alter VB0 = $&drive
let drive = (floor(trial / 2) - 2*floor(trial / 4))*1.8
alter VB1 = $&drive
let drive = (floor(trial / 4) - 2*floor(trial / 8))*1.8
alter VB2 = $&drive
let drive = (floor(trial / 8) - 2*floor(trial / 16))*1.8
alter VB3 = $&drive
let drive = (floor(trial / 16) - 2*floor(trial / 32))*1.8
alter VB4 = $&drive
let drive = (floor(trial / 32) - 2*floor(trial / 64))*1.8
alter VB5 = $&drive
let drive = (floor(trial / 64) - 2*floor(trial / 128))*1.8
alter VB6 = $&drive
let drive = (floor(trial / 128) - 2*floor(trial / 256))*1.8
alter VB7 = $&drive
stop when time = 0.000382
resume
delete all
let endpoint = length(time)-1
let cmp = v(COMP)[endpoint]
let top = v(TOP)[endpoint]
let decision = 0
if cmp >= 0.9
let code = trial
let decision = 1
end
echo 21 7 $&trial $&cmp $&top 0.08671875 $&decision >> decisions.csv
let trial = code + 64
let drive = (floor(trial / 1) - 2*floor(trial / 2))*1.8
alter VB0 = $&drive
let drive = (floor(trial / 2) - 2*floor(trial / 4))*1.8
alter VB1 = $&drive
let drive = (floor(trial / 4) - 2*floor(trial / 8))*1.8
alter VB2 = $&drive
let drive = (floor(trial / 8) - 2*floor(trial / 16))*1.8
alter VB3 = $&drive
let drive = (floor(trial / 16) - 2*floor(trial / 32))*1.8
alter VB4 = $&drive
let drive = (floor(trial / 32) - 2*floor(trial / 64))*1.8
alter VB5 = $&drive
let drive = (floor(trial / 64) - 2*floor(trial / 128))*1.8
alter VB6 = $&drive
let drive = (floor(trial / 128) - 2*floor(trial / 256))*1.8
alter VB7 = $&drive
stop when time = 0.000384
resume
delete all
let endpoint = length(time)-1
let cmp = v(COMP)[endpoint]
let top = v(TOP)[endpoint]
let decision = 0
if cmp >= 0.9
let code = trial
let decision = 1
end
echo 21 6 $&trial $&cmp $&top 0.08671875 $&decision >> decisions.csv
let trial = code + 32
let drive = (floor(trial / 1) - 2*floor(trial / 2))*1.8
alter VB0 = $&drive
let drive = (floor(trial / 2) - 2*floor(trial / 4))*1.8
alter VB1 = $&drive
let drive = (floor(trial / 4) - 2*floor(trial / 8))*1.8
alter VB2 = $&drive
let drive = (floor(trial / 8) - 2*floor(trial / 16))*1.8
alter VB3 = $&drive
let drive = (floor(trial / 16) - 2*floor(trial / 32))*1.8
alter VB4 = $&drive
let drive = (floor(trial / 32) - 2*floor(trial / 64))*1.8
alter VB5 = $&drive
let drive = (floor(trial / 64) - 2*floor(trial / 128))*1.8
alter VB6 = $&drive
let drive = (floor(trial / 128) - 2*floor(trial / 256))*1.8
alter VB7 = $&drive
stop when time = 0.000386
resume
delete all
let endpoint = length(time)-1
let cmp = v(COMP)[endpoint]
let top = v(TOP)[endpoint]
let decision = 0
if cmp >= 0.9
let code = trial
let decision = 1
end
echo 21 5 $&trial $&cmp $&top 0.08671875 $&decision >> decisions.csv
let trial = code + 16
let drive = (floor(trial / 1) - 2*floor(trial / 2))*1.8
alter VB0 = $&drive
let drive = (floor(trial / 2) - 2*floor(trial / 4))*1.8
alter VB1 = $&drive
let drive = (floor(trial / 4) - 2*floor(trial / 8))*1.8
alter VB2 = $&drive
let drive = (floor(trial / 8) - 2*floor(trial / 16))*1.8
alter VB3 = $&drive
let drive = (floor(trial / 16) - 2*floor(trial / 32))*1.8
alter VB4 = $&drive
let drive = (floor(trial / 32) - 2*floor(trial / 64))*1.8
alter VB5 = $&drive
let drive = (floor(trial / 64) - 2*floor(trial / 128))*1.8
alter VB6 = $&drive
let drive = (floor(trial / 128) - 2*floor(trial / 256))*1.8
alter VB7 = $&drive
stop when time = 0.000388
resume
delete all
let endpoint = length(time)-1
let cmp = v(COMP)[endpoint]
let top = v(TOP)[endpoint]
let decision = 0
if cmp >= 0.9
let code = trial
let decision = 1
end
echo 21 4 $&trial $&cmp $&top 0.08671875 $&decision >> decisions.csv
let trial = code + 8
let drive = (floor(trial / 1) - 2*floor(trial / 2))*1.8
alter VB0 = $&drive
let drive = (floor(trial / 2) - 2*floor(trial / 4))*1.8
alter VB1 = $&drive
let drive = (floor(trial / 4) - 2*floor(trial / 8))*1.8
alter VB2 = $&drive
let drive = (floor(trial / 8) - 2*floor(trial / 16))*1.8
alter VB3 = $&drive
let drive = (floor(trial / 16) - 2*floor(trial / 32))*1.8
alter VB4 = $&drive
let drive = (floor(trial / 32) - 2*floor(trial / 64))*1.8
alter VB5 = $&drive
let drive = (floor(trial / 64) - 2*floor(trial / 128))*1.8
alter VB6 = $&drive
let drive = (floor(trial / 128) - 2*floor(trial / 256))*1.8
alter VB7 = $&drive
stop when time = 0.00039
resume
delete all
let endpoint = length(time)-1
let cmp = v(COMP)[endpoint]
let top = v(TOP)[endpoint]
let decision = 0
if cmp >= 0.9
let code = trial
let decision = 1
end
echo 21 3 $&trial $&cmp $&top 0.08671875 $&decision >> decisions.csv
let trial = code + 4
let drive = (floor(trial / 1) - 2*floor(trial / 2))*1.8
alter VB0 = $&drive
let drive = (floor(trial / 2) - 2*floor(trial / 4))*1.8
alter VB1 = $&drive
let drive = (floor(trial / 4) - 2*floor(trial / 8))*1.8
alter VB2 = $&drive
let drive = (floor(trial / 8) - 2*floor(trial / 16))*1.8
alter VB3 = $&drive
let drive = (floor(trial / 16) - 2*floor(trial / 32))*1.8
alter VB4 = $&drive
let drive = (floor(trial / 32) - 2*floor(trial / 64))*1.8
alter VB5 = $&drive
let drive = (floor(trial / 64) - 2*floor(trial / 128))*1.8
alter VB6 = $&drive
let drive = (floor(trial / 128) - 2*floor(trial / 256))*1.8
alter VB7 = $&drive
stop when time = 0.000392
resume
delete all
let endpoint = length(time)-1
let cmp = v(COMP)[endpoint]
let top = v(TOP)[endpoint]
let decision = 0
if cmp >= 0.9
let code = trial
let decision = 1
end
echo 21 2 $&trial $&cmp $&top 0.08671875 $&decision >> decisions.csv
let trial = code + 2
let drive = (floor(trial / 1) - 2*floor(trial / 2))*1.8
alter VB0 = $&drive
let drive = (floor(trial / 2) - 2*floor(trial / 4))*1.8
alter VB1 = $&drive
let drive = (floor(trial / 4) - 2*floor(trial / 8))*1.8
alter VB2 = $&drive
let drive = (floor(trial / 8) - 2*floor(trial / 16))*1.8
alter VB3 = $&drive
let drive = (floor(trial / 16) - 2*floor(trial / 32))*1.8
alter VB4 = $&drive
let drive = (floor(trial / 32) - 2*floor(trial / 64))*1.8
alter VB5 = $&drive
let drive = (floor(trial / 64) - 2*floor(trial / 128))*1.8
alter VB6 = $&drive
let drive = (floor(trial / 128) - 2*floor(trial / 256))*1.8
alter VB7 = $&drive
stop when time = 0.000394
resume
delete all
let endpoint = length(time)-1
let cmp = v(COMP)[endpoint]
let top = v(TOP)[endpoint]
let decision = 0
if cmp >= 0.9
let code = trial
let decision = 1
end
echo 21 1 $&trial $&cmp $&top 0.08671875 $&decision >> decisions.csv
let trial = code + 1
let drive = (floor(trial / 1) - 2*floor(trial / 2))*1.8
alter VB0 = $&drive
let drive = (floor(trial / 2) - 2*floor(trial / 4))*1.8
alter VB1 = $&drive
let drive = (floor(trial / 4) - 2*floor(trial / 8))*1.8
alter VB2 = $&drive
let drive = (floor(trial / 8) - 2*floor(trial / 16))*1.8
alter VB3 = $&drive
let drive = (floor(trial / 16) - 2*floor(trial / 32))*1.8
alter VB4 = $&drive
let drive = (floor(trial / 32) - 2*floor(trial / 64))*1.8
alter VB5 = $&drive
let drive = (floor(trial / 64) - 2*floor(trial / 128))*1.8
alter VB6 = $&drive
let drive = (floor(trial / 128) - 2*floor(trial / 256))*1.8
alter VB7 = $&drive
stop when time = 0.000396
resume
delete all
let endpoint = length(time)-1
let cmp = v(COMP)[endpoint]
let top = v(TOP)[endpoint]
let decision = 0
if cmp >= 0.9
let code = trial
let decision = 1
end
echo 21 0 $&trial $&cmp $&top 0.08671875 $&decision >> decisions.csv
alter VIN = 0.09140625
alter VSAMPLE = 1.8
alter VB0 = 0
alter VB1 = 0
alter VB2 = 0
alter VB3 = 0
alter VB4 = 0
alter VB5 = 0
alter VB6 = 0
alter VB7 = 0
let code = 0
stop when time = 0.000398
resume
delete all
alter VSAMPLE = 0
let trial = code + 128
let drive = (floor(trial / 1) - 2*floor(trial / 2))*1.8
alter VB0 = $&drive
let drive = (floor(trial / 2) - 2*floor(trial / 4))*1.8
alter VB1 = $&drive
let drive = (floor(trial / 4) - 2*floor(trial / 8))*1.8
alter VB2 = $&drive
let drive = (floor(trial / 8) - 2*floor(trial / 16))*1.8
alter VB3 = $&drive
let drive = (floor(trial / 16) - 2*floor(trial / 32))*1.8
alter VB4 = $&drive
let drive = (floor(trial / 32) - 2*floor(trial / 64))*1.8
alter VB5 = $&drive
let drive = (floor(trial / 64) - 2*floor(trial / 128))*1.8
alter VB6 = $&drive
let drive = (floor(trial / 128) - 2*floor(trial / 256))*1.8
alter VB7 = $&drive
stop when time = 0.0004
resume
delete all
let endpoint = length(time)-1
let cmp = v(COMP)[endpoint]
let top = v(TOP)[endpoint]
let decision = 0
if cmp >= 0.9
let code = trial
let decision = 1
end
echo 22 7 $&trial $&cmp $&top 0.09140625 $&decision >> decisions.csv
let trial = code + 64
let drive = (floor(trial / 1) - 2*floor(trial / 2))*1.8
alter VB0 = $&drive
let drive = (floor(trial / 2) - 2*floor(trial / 4))*1.8
alter VB1 = $&drive
let drive = (floor(trial / 4) - 2*floor(trial / 8))*1.8
alter VB2 = $&drive
let drive = (floor(trial / 8) - 2*floor(trial / 16))*1.8
alter VB3 = $&drive
let drive = (floor(trial / 16) - 2*floor(trial / 32))*1.8
alter VB4 = $&drive
let drive = (floor(trial / 32) - 2*floor(trial / 64))*1.8
alter VB5 = $&drive
let drive = (floor(trial / 64) - 2*floor(trial / 128))*1.8
alter VB6 = $&drive
let drive = (floor(trial / 128) - 2*floor(trial / 256))*1.8
alter VB7 = $&drive
stop when time = 0.000402
resume
delete all
let endpoint = length(time)-1
let cmp = v(COMP)[endpoint]
let top = v(TOP)[endpoint]
let decision = 0
if cmp >= 0.9
let code = trial
let decision = 1
end
echo 22 6 $&trial $&cmp $&top 0.09140625 $&decision >> decisions.csv
let trial = code + 32
let drive = (floor(trial / 1) - 2*floor(trial / 2))*1.8
alter VB0 = $&drive
let drive = (floor(trial / 2) - 2*floor(trial / 4))*1.8
alter VB1 = $&drive
let drive = (floor(trial / 4) - 2*floor(trial / 8))*1.8
alter VB2 = $&drive
let drive = (floor(trial / 8) - 2*floor(trial / 16))*1.8
alter VB3 = $&drive
let drive = (floor(trial / 16) - 2*floor(trial / 32))*1.8
alter VB4 = $&drive
let drive = (floor(trial / 32) - 2*floor(trial / 64))*1.8
alter VB5 = $&drive
let drive = (floor(trial / 64) - 2*floor(trial / 128))*1.8
alter VB6 = $&drive
let drive = (floor(trial / 128) - 2*floor(trial / 256))*1.8
alter VB7 = $&drive
stop when time = 0.000404
resume
delete all
let endpoint = length(time)-1
let cmp = v(COMP)[endpoint]
let top = v(TOP)[endpoint]
let decision = 0
if cmp >= 0.9
let code = trial
let decision = 1
end
echo 22 5 $&trial $&cmp $&top 0.09140625 $&decision >> decisions.csv
let trial = code + 16
let drive = (floor(trial / 1) - 2*floor(trial / 2))*1.8
alter VB0 = $&drive
let drive = (floor(trial / 2) - 2*floor(trial / 4))*1.8
alter VB1 = $&drive
let drive = (floor(trial / 4) - 2*floor(trial / 8))*1.8
alter VB2 = $&drive
let drive = (floor(trial / 8) - 2*floor(trial / 16))*1.8
alter VB3 = $&drive
let drive = (floor(trial / 16) - 2*floor(trial / 32))*1.8
alter VB4 = $&drive
let drive = (floor(trial / 32) - 2*floor(trial / 64))*1.8
alter VB5 = $&drive
let drive = (floor(trial / 64) - 2*floor(trial / 128))*1.8
alter VB6 = $&drive
let drive = (floor(trial / 128) - 2*floor(trial / 256))*1.8
alter VB7 = $&drive
stop when time = 0.000406
resume
delete all
let endpoint = length(time)-1
let cmp = v(COMP)[endpoint]
let top = v(TOP)[endpoint]
let decision = 0
if cmp >= 0.9
let code = trial
let decision = 1
end
echo 22 4 $&trial $&cmp $&top 0.09140625 $&decision >> decisions.csv
let trial = code + 8
let drive = (floor(trial / 1) - 2*floor(trial / 2))*1.8
alter VB0 = $&drive
let drive = (floor(trial / 2) - 2*floor(trial / 4))*1.8
alter VB1 = $&drive
let drive = (floor(trial / 4) - 2*floor(trial / 8))*1.8
alter VB2 = $&drive
let drive = (floor(trial / 8) - 2*floor(trial / 16))*1.8
alter VB3 = $&drive
let drive = (floor(trial / 16) - 2*floor(trial / 32))*1.8
alter VB4 = $&drive
let drive = (floor(trial / 32) - 2*floor(trial / 64))*1.8
alter VB5 = $&drive
let drive = (floor(trial / 64) - 2*floor(trial / 128))*1.8
alter VB6 = $&drive
let drive = (floor(trial / 128) - 2*floor(trial / 256))*1.8
alter VB7 = $&drive
stop when time = 0.000408
resume
delete all
let endpoint = length(time)-1
let cmp = v(COMP)[endpoint]
let top = v(TOP)[endpoint]
let decision = 0
if cmp >= 0.9
let code = trial
let decision = 1
end
echo 22 3 $&trial $&cmp $&top 0.09140625 $&decision >> decisions.csv
let trial = code + 4
let drive = (floor(trial / 1) - 2*floor(trial / 2))*1.8
alter VB0 = $&drive
let drive = (floor(trial / 2) - 2*floor(trial / 4))*1.8
alter VB1 = $&drive
let drive = (floor(trial / 4) - 2*floor(trial / 8))*1.8
alter VB2 = $&drive
let drive = (floor(trial / 8) - 2*floor(trial / 16))*1.8
alter VB3 = $&drive
let drive = (floor(trial / 16) - 2*floor(trial / 32))*1.8
alter VB4 = $&drive
let drive = (floor(trial / 32) - 2*floor(trial / 64))*1.8
alter VB5 = $&drive
let drive = (floor(trial / 64) - 2*floor(trial / 128))*1.8
alter VB6 = $&drive
let drive = (floor(trial / 128) - 2*floor(trial / 256))*1.8
alter VB7 = $&drive
stop when time = 0.00041
resume
delete all
let endpoint = length(time)-1
let cmp = v(COMP)[endpoint]
let top = v(TOP)[endpoint]
let decision = 0
if cmp >= 0.9
let code = trial
let decision = 1
end
echo 22 2 $&trial $&cmp $&top 0.09140625 $&decision >> decisions.csv
let trial = code + 2
let drive = (floor(trial / 1) - 2*floor(trial / 2))*1.8
alter VB0 = $&drive
let drive = (floor(trial / 2) - 2*floor(trial / 4))*1.8
alter VB1 = $&drive
let drive = (floor(trial / 4) - 2*floor(trial / 8))*1.8
alter VB2 = $&drive
let drive = (floor(trial / 8) - 2*floor(trial / 16))*1.8
alter VB3 = $&drive
let drive = (floor(trial / 16) - 2*floor(trial / 32))*1.8
alter VB4 = $&drive
let drive = (floor(trial / 32) - 2*floor(trial / 64))*1.8
alter VB5 = $&drive
let drive = (floor(trial / 64) - 2*floor(trial / 128))*1.8
alter VB6 = $&drive
let drive = (floor(trial / 128) - 2*floor(trial / 256))*1.8
alter VB7 = $&drive
stop when time = 0.000412
resume
delete all
let endpoint = length(time)-1
let cmp = v(COMP)[endpoint]
let top = v(TOP)[endpoint]
let decision = 0
if cmp >= 0.9
let code = trial
let decision = 1
end
echo 22 1 $&trial $&cmp $&top 0.09140625 $&decision >> decisions.csv
let trial = code + 1
let drive = (floor(trial / 1) - 2*floor(trial / 2))*1.8
alter VB0 = $&drive
let drive = (floor(trial / 2) - 2*floor(trial / 4))*1.8
alter VB1 = $&drive
let drive = (floor(trial / 4) - 2*floor(trial / 8))*1.8
alter VB2 = $&drive
let drive = (floor(trial / 8) - 2*floor(trial / 16))*1.8
alter VB3 = $&drive
let drive = (floor(trial / 16) - 2*floor(trial / 32))*1.8
alter VB4 = $&drive
let drive = (floor(trial / 32) - 2*floor(trial / 64))*1.8
alter VB5 = $&drive
let drive = (floor(trial / 64) - 2*floor(trial / 128))*1.8
alter VB6 = $&drive
let drive = (floor(trial / 128) - 2*floor(trial / 256))*1.8
alter VB7 = $&drive
stop when time = 0.000414
resume
delete all
let endpoint = length(time)-1
let cmp = v(COMP)[endpoint]
let top = v(TOP)[endpoint]
let decision = 0
if cmp >= 0.9
let code = trial
let decision = 1
end
echo 22 0 $&trial $&cmp $&top 0.09140625 $&decision >> decisions.csv
alter VIN = 0.09609375
alter VSAMPLE = 1.8
alter VB0 = 0
alter VB1 = 0
alter VB2 = 0
alter VB3 = 0
alter VB4 = 0
alter VB5 = 0
alter VB6 = 0
alter VB7 = 0
let code = 0
stop when time = 0.000416
resume
delete all
alter VSAMPLE = 0
let trial = code + 128
let drive = (floor(trial / 1) - 2*floor(trial / 2))*1.8
alter VB0 = $&drive
let drive = (floor(trial / 2) - 2*floor(trial / 4))*1.8
alter VB1 = $&drive
let drive = (floor(trial / 4) - 2*floor(trial / 8))*1.8
alter VB2 = $&drive
let drive = (floor(trial / 8) - 2*floor(trial / 16))*1.8
alter VB3 = $&drive
let drive = (floor(trial / 16) - 2*floor(trial / 32))*1.8
alter VB4 = $&drive
let drive = (floor(trial / 32) - 2*floor(trial / 64))*1.8
alter VB5 = $&drive
let drive = (floor(trial / 64) - 2*floor(trial / 128))*1.8
alter VB6 = $&drive
let drive = (floor(trial / 128) - 2*floor(trial / 256))*1.8
alter VB7 = $&drive
stop when time = 0.000418
resume
delete all
let endpoint = length(time)-1
let cmp = v(COMP)[endpoint]
let top = v(TOP)[endpoint]
let decision = 0
if cmp >= 0.9
let code = trial
let decision = 1
end
echo 23 7 $&trial $&cmp $&top 0.09609375 $&decision >> decisions.csv
let trial = code + 64
let drive = (floor(trial / 1) - 2*floor(trial / 2))*1.8
alter VB0 = $&drive
let drive = (floor(trial / 2) - 2*floor(trial / 4))*1.8
alter VB1 = $&drive
let drive = (floor(trial / 4) - 2*floor(trial / 8))*1.8
alter VB2 = $&drive
let drive = (floor(trial / 8) - 2*floor(trial / 16))*1.8
alter VB3 = $&drive
let drive = (floor(trial / 16) - 2*floor(trial / 32))*1.8
alter VB4 = $&drive
let drive = (floor(trial / 32) - 2*floor(trial / 64))*1.8
alter VB5 = $&drive
let drive = (floor(trial / 64) - 2*floor(trial / 128))*1.8
alter VB6 = $&drive
let drive = (floor(trial / 128) - 2*floor(trial / 256))*1.8
alter VB7 = $&drive
stop when time = 0.00042
resume
delete all
let endpoint = length(time)-1
let cmp = v(COMP)[endpoint]
let top = v(TOP)[endpoint]
let decision = 0
if cmp >= 0.9
let code = trial
let decision = 1
end
echo 23 6 $&trial $&cmp $&top 0.09609375 $&decision >> decisions.csv
let trial = code + 32
let drive = (floor(trial / 1) - 2*floor(trial / 2))*1.8
alter VB0 = $&drive
let drive = (floor(trial / 2) - 2*floor(trial / 4))*1.8
alter VB1 = $&drive
let drive = (floor(trial / 4) - 2*floor(trial / 8))*1.8
alter VB2 = $&drive
let drive = (floor(trial / 8) - 2*floor(trial / 16))*1.8
alter VB3 = $&drive
let drive = (floor(trial / 16) - 2*floor(trial / 32))*1.8
alter VB4 = $&drive
let drive = (floor(trial / 32) - 2*floor(trial / 64))*1.8
alter VB5 = $&drive
let drive = (floor(trial / 64) - 2*floor(trial / 128))*1.8
alter VB6 = $&drive
let drive = (floor(trial / 128) - 2*floor(trial / 256))*1.8
alter VB7 = $&drive
stop when time = 0.000422
resume
delete all
let endpoint = length(time)-1
let cmp = v(COMP)[endpoint]
let top = v(TOP)[endpoint]
let decision = 0
if cmp >= 0.9
let code = trial
let decision = 1
end
echo 23 5 $&trial $&cmp $&top 0.09609375 $&decision >> decisions.csv
let trial = code + 16
let drive = (floor(trial / 1) - 2*floor(trial / 2))*1.8
alter VB0 = $&drive
let drive = (floor(trial / 2) - 2*floor(trial / 4))*1.8
alter VB1 = $&drive
let drive = (floor(trial / 4) - 2*floor(trial / 8))*1.8
alter VB2 = $&drive
let drive = (floor(trial / 8) - 2*floor(trial / 16))*1.8
alter VB3 = $&drive
let drive = (floor(trial / 16) - 2*floor(trial / 32))*1.8
alter VB4 = $&drive
let drive = (floor(trial / 32) - 2*floor(trial / 64))*1.8
alter VB5 = $&drive
let drive = (floor(trial / 64) - 2*floor(trial / 128))*1.8
alter VB6 = $&drive
let drive = (floor(trial / 128) - 2*floor(trial / 256))*1.8
alter VB7 = $&drive
stop when time = 0.000424
resume
delete all
let endpoint = length(time)-1
let cmp = v(COMP)[endpoint]
let top = v(TOP)[endpoint]
let decision = 0
if cmp >= 0.9
let code = trial
let decision = 1
end
echo 23 4 $&trial $&cmp $&top 0.09609375 $&decision >> decisions.csv
let trial = code + 8
let drive = (floor(trial / 1) - 2*floor(trial / 2))*1.8
alter VB0 = $&drive
let drive = (floor(trial / 2) - 2*floor(trial / 4))*1.8
alter VB1 = $&drive
let drive = (floor(trial / 4) - 2*floor(trial / 8))*1.8
alter VB2 = $&drive
let drive = (floor(trial / 8) - 2*floor(trial / 16))*1.8
alter VB3 = $&drive
let drive = (floor(trial / 16) - 2*floor(trial / 32))*1.8
alter VB4 = $&drive
let drive = (floor(trial / 32) - 2*floor(trial / 64))*1.8
alter VB5 = $&drive
let drive = (floor(trial / 64) - 2*floor(trial / 128))*1.8
alter VB6 = $&drive
let drive = (floor(trial / 128) - 2*floor(trial / 256))*1.8
alter VB7 = $&drive
stop when time = 0.000426
resume
delete all
let endpoint = length(time)-1
let cmp = v(COMP)[endpoint]
let top = v(TOP)[endpoint]
let decision = 0
if cmp >= 0.9
let code = trial
let decision = 1
end
echo 23 3 $&trial $&cmp $&top 0.09609375 $&decision >> decisions.csv
let trial = code + 4
let drive = (floor(trial / 1) - 2*floor(trial / 2))*1.8
alter VB0 = $&drive
let drive = (floor(trial / 2) - 2*floor(trial / 4))*1.8
alter VB1 = $&drive
let drive = (floor(trial / 4) - 2*floor(trial / 8))*1.8
alter VB2 = $&drive
let drive = (floor(trial / 8) - 2*floor(trial / 16))*1.8
alter VB3 = $&drive
let drive = (floor(trial / 16) - 2*floor(trial / 32))*1.8
alter VB4 = $&drive
let drive = (floor(trial / 32) - 2*floor(trial / 64))*1.8
alter VB5 = $&drive
let drive = (floor(trial / 64) - 2*floor(trial / 128))*1.8
alter VB6 = $&drive
let drive = (floor(trial / 128) - 2*floor(trial / 256))*1.8
alter VB7 = $&drive
stop when time = 0.000428
resume
delete all
let endpoint = length(time)-1
let cmp = v(COMP)[endpoint]
let top = v(TOP)[endpoint]
let decision = 0
if cmp >= 0.9
let code = trial
let decision = 1
end
echo 23 2 $&trial $&cmp $&top 0.09609375 $&decision >> decisions.csv
let trial = code + 2
let drive = (floor(trial / 1) - 2*floor(trial / 2))*1.8
alter VB0 = $&drive
let drive = (floor(trial / 2) - 2*floor(trial / 4))*1.8
alter VB1 = $&drive
let drive = (floor(trial / 4) - 2*floor(trial / 8))*1.8
alter VB2 = $&drive
let drive = (floor(trial / 8) - 2*floor(trial / 16))*1.8
alter VB3 = $&drive
let drive = (floor(trial / 16) - 2*floor(trial / 32))*1.8
alter VB4 = $&drive
let drive = (floor(trial / 32) - 2*floor(trial / 64))*1.8
alter VB5 = $&drive
let drive = (floor(trial / 64) - 2*floor(trial / 128))*1.8
alter VB6 = $&drive
let drive = (floor(trial / 128) - 2*floor(trial / 256))*1.8
alter VB7 = $&drive
stop when time = 0.00043
resume
delete all
let endpoint = length(time)-1
let cmp = v(COMP)[endpoint]
let top = v(TOP)[endpoint]
let decision = 0
if cmp >= 0.9
let code = trial
let decision = 1
end
echo 23 1 $&trial $&cmp $&top 0.09609375 $&decision >> decisions.csv
let trial = code + 1
let drive = (floor(trial / 1) - 2*floor(trial / 2))*1.8
alter VB0 = $&drive
let drive = (floor(trial / 2) - 2*floor(trial / 4))*1.8
alter VB1 = $&drive
let drive = (floor(trial / 4) - 2*floor(trial / 8))*1.8
alter VB2 = $&drive
let drive = (floor(trial / 8) - 2*floor(trial / 16))*1.8
alter VB3 = $&drive
let drive = (floor(trial / 16) - 2*floor(trial / 32))*1.8
alter VB4 = $&drive
let drive = (floor(trial / 32) - 2*floor(trial / 64))*1.8
alter VB5 = $&drive
let drive = (floor(trial / 64) - 2*floor(trial / 128))*1.8
alter VB6 = $&drive
let drive = (floor(trial / 128) - 2*floor(trial / 256))*1.8
alter VB7 = $&drive
stop when time = 0.000432
resume
delete all
let endpoint = length(time)-1
let cmp = v(COMP)[endpoint]
let top = v(TOP)[endpoint]
let decision = 0
if cmp >= 0.9
let code = trial
let decision = 1
end
echo 23 0 $&trial $&cmp $&top 0.09609375 $&decision >> decisions.csv
alter VIN = 0.10078125
alter VSAMPLE = 1.8
alter VB0 = 0
alter VB1 = 0
alter VB2 = 0
alter VB3 = 0
alter VB4 = 0
alter VB5 = 0
alter VB6 = 0
alter VB7 = 0
let code = 0
stop when time = 0.000434
resume
delete all
alter VSAMPLE = 0
let trial = code + 128
let drive = (floor(trial / 1) - 2*floor(trial / 2))*1.8
alter VB0 = $&drive
let drive = (floor(trial / 2) - 2*floor(trial / 4))*1.8
alter VB1 = $&drive
let drive = (floor(trial / 4) - 2*floor(trial / 8))*1.8
alter VB2 = $&drive
let drive = (floor(trial / 8) - 2*floor(trial / 16))*1.8
alter VB3 = $&drive
let drive = (floor(trial / 16) - 2*floor(trial / 32))*1.8
alter VB4 = $&drive
let drive = (floor(trial / 32) - 2*floor(trial / 64))*1.8
alter VB5 = $&drive
let drive = (floor(trial / 64) - 2*floor(trial / 128))*1.8
alter VB6 = $&drive
let drive = (floor(trial / 128) - 2*floor(trial / 256))*1.8
alter VB7 = $&drive
stop when time = 0.000436
resume
delete all
let endpoint = length(time)-1
let cmp = v(COMP)[endpoint]
let top = v(TOP)[endpoint]
let decision = 0
if cmp >= 0.9
let code = trial
let decision = 1
end
echo 24 7 $&trial $&cmp $&top 0.10078125 $&decision >> decisions.csv
let trial = code + 64
let drive = (floor(trial / 1) - 2*floor(trial / 2))*1.8
alter VB0 = $&drive
let drive = (floor(trial / 2) - 2*floor(trial / 4))*1.8
alter VB1 = $&drive
let drive = (floor(trial / 4) - 2*floor(trial / 8))*1.8
alter VB2 = $&drive
let drive = (floor(trial / 8) - 2*floor(trial / 16))*1.8
alter VB3 = $&drive
let drive = (floor(trial / 16) - 2*floor(trial / 32))*1.8
alter VB4 = $&drive
let drive = (floor(trial / 32) - 2*floor(trial / 64))*1.8
alter VB5 = $&drive
let drive = (floor(trial / 64) - 2*floor(trial / 128))*1.8
alter VB6 = $&drive
let drive = (floor(trial / 128) - 2*floor(trial / 256))*1.8
alter VB7 = $&drive
stop when time = 0.000438
resume
delete all
let endpoint = length(time)-1
let cmp = v(COMP)[endpoint]
let top = v(TOP)[endpoint]
let decision = 0
if cmp >= 0.9
let code = trial
let decision = 1
end
echo 24 6 $&trial $&cmp $&top 0.10078125 $&decision >> decisions.csv
let trial = code + 32
let drive = (floor(trial / 1) - 2*floor(trial / 2))*1.8
alter VB0 = $&drive
let drive = (floor(trial / 2) - 2*floor(trial / 4))*1.8
alter VB1 = $&drive
let drive = (floor(trial / 4) - 2*floor(trial / 8))*1.8
alter VB2 = $&drive
let drive = (floor(trial / 8) - 2*floor(trial / 16))*1.8
alter VB3 = $&drive
let drive = (floor(trial / 16) - 2*floor(trial / 32))*1.8
alter VB4 = $&drive
let drive = (floor(trial / 32) - 2*floor(trial / 64))*1.8
alter VB5 = $&drive
let drive = (floor(trial / 64) - 2*floor(trial / 128))*1.8
alter VB6 = $&drive
let drive = (floor(trial / 128) - 2*floor(trial / 256))*1.8
alter VB7 = $&drive
stop when time = 0.00044
resume
delete all
let endpoint = length(time)-1
let cmp = v(COMP)[endpoint]
let top = v(TOP)[endpoint]
let decision = 0
if cmp >= 0.9
let code = trial
let decision = 1
end
echo 24 5 $&trial $&cmp $&top 0.10078125 $&decision >> decisions.csv
let trial = code + 16
let drive = (floor(trial / 1) - 2*floor(trial / 2))*1.8
alter VB0 = $&drive
let drive = (floor(trial / 2) - 2*floor(trial / 4))*1.8
alter VB1 = $&drive
let drive = (floor(trial / 4) - 2*floor(trial / 8))*1.8
alter VB2 = $&drive
let drive = (floor(trial / 8) - 2*floor(trial / 16))*1.8
alter VB3 = $&drive
let drive = (floor(trial / 16) - 2*floor(trial / 32))*1.8
alter VB4 = $&drive
let drive = (floor(trial / 32) - 2*floor(trial / 64))*1.8
alter VB5 = $&drive
let drive = (floor(trial / 64) - 2*floor(trial / 128))*1.8
alter VB6 = $&drive
let drive = (floor(trial / 128) - 2*floor(trial / 256))*1.8
alter VB7 = $&drive
stop when time = 0.000442
resume
delete all
let endpoint = length(time)-1
let cmp = v(COMP)[endpoint]
let top = v(TOP)[endpoint]
let decision = 0
if cmp >= 0.9
let code = trial
let decision = 1
end
echo 24 4 $&trial $&cmp $&top 0.10078125 $&decision >> decisions.csv
let trial = code + 8
let drive = (floor(trial / 1) - 2*floor(trial / 2))*1.8
alter VB0 = $&drive
let drive = (floor(trial / 2) - 2*floor(trial / 4))*1.8
alter VB1 = $&drive
let drive = (floor(trial / 4) - 2*floor(trial / 8))*1.8
alter VB2 = $&drive
let drive = (floor(trial / 8) - 2*floor(trial / 16))*1.8
alter VB3 = $&drive
let drive = (floor(trial / 16) - 2*floor(trial / 32))*1.8
alter VB4 = $&drive
let drive = (floor(trial / 32) - 2*floor(trial / 64))*1.8
alter VB5 = $&drive
let drive = (floor(trial / 64) - 2*floor(trial / 128))*1.8
alter VB6 = $&drive
let drive = (floor(trial / 128) - 2*floor(trial / 256))*1.8
alter VB7 = $&drive
stop when time = 0.000444
resume
delete all
let endpoint = length(time)-1
let cmp = v(COMP)[endpoint]
let top = v(TOP)[endpoint]
let decision = 0
if cmp >= 0.9
let code = trial
let decision = 1
end
echo 24 3 $&trial $&cmp $&top 0.10078125 $&decision >> decisions.csv
let trial = code + 4
let drive = (floor(trial / 1) - 2*floor(trial / 2))*1.8
alter VB0 = $&drive
let drive = (floor(trial / 2) - 2*floor(trial / 4))*1.8
alter VB1 = $&drive
let drive = (floor(trial / 4) - 2*floor(trial / 8))*1.8
alter VB2 = $&drive
let drive = (floor(trial / 8) - 2*floor(trial / 16))*1.8
alter VB3 = $&drive
let drive = (floor(trial / 16) - 2*floor(trial / 32))*1.8
alter VB4 = $&drive
let drive = (floor(trial / 32) - 2*floor(trial / 64))*1.8
alter VB5 = $&drive
let drive = (floor(trial / 64) - 2*floor(trial / 128))*1.8
alter VB6 = $&drive
let drive = (floor(trial / 128) - 2*floor(trial / 256))*1.8
alter VB7 = $&drive
stop when time = 0.000446
resume
delete all
let endpoint = length(time)-1
let cmp = v(COMP)[endpoint]
let top = v(TOP)[endpoint]
let decision = 0
if cmp >= 0.9
let code = trial
let decision = 1
end
echo 24 2 $&trial $&cmp $&top 0.10078125 $&decision >> decisions.csv
let trial = code + 2
let drive = (floor(trial / 1) - 2*floor(trial / 2))*1.8
alter VB0 = $&drive
let drive = (floor(trial / 2) - 2*floor(trial / 4))*1.8
alter VB1 = $&drive
let drive = (floor(trial / 4) - 2*floor(trial / 8))*1.8
alter VB2 = $&drive
let drive = (floor(trial / 8) - 2*floor(trial / 16))*1.8
alter VB3 = $&drive
let drive = (floor(trial / 16) - 2*floor(trial / 32))*1.8
alter VB4 = $&drive
let drive = (floor(trial / 32) - 2*floor(trial / 64))*1.8
alter VB5 = $&drive
let drive = (floor(trial / 64) - 2*floor(trial / 128))*1.8
alter VB6 = $&drive
let drive = (floor(trial / 128) - 2*floor(trial / 256))*1.8
alter VB7 = $&drive
stop when time = 0.000448
resume
delete all
let endpoint = length(time)-1
let cmp = v(COMP)[endpoint]
let top = v(TOP)[endpoint]
let decision = 0
if cmp >= 0.9
let code = trial
let decision = 1
end
echo 24 1 $&trial $&cmp $&top 0.10078125 $&decision >> decisions.csv
let trial = code + 1
let drive = (floor(trial / 1) - 2*floor(trial / 2))*1.8
alter VB0 = $&drive
let drive = (floor(trial / 2) - 2*floor(trial / 4))*1.8
alter VB1 = $&drive
let drive = (floor(trial / 4) - 2*floor(trial / 8))*1.8
alter VB2 = $&drive
let drive = (floor(trial / 8) - 2*floor(trial / 16))*1.8
alter VB3 = $&drive
let drive = (floor(trial / 16) - 2*floor(trial / 32))*1.8
alter VB4 = $&drive
let drive = (floor(trial / 32) - 2*floor(trial / 64))*1.8
alter VB5 = $&drive
let drive = (floor(trial / 64) - 2*floor(trial / 128))*1.8
alter VB6 = $&drive
let drive = (floor(trial / 128) - 2*floor(trial / 256))*1.8
alter VB7 = $&drive
stop when time = 0.00045
resume
delete all
let endpoint = length(time)-1
let cmp = v(COMP)[endpoint]
let top = v(TOP)[endpoint]
let decision = 0
if cmp >= 0.9
let code = trial
let decision = 1
end
echo 24 0 $&trial $&cmp $&top 0.10078125 $&decision >> decisions.csv
alter VIN = 0.10546875
alter VSAMPLE = 1.8
alter VB0 = 0
alter VB1 = 0
alter VB2 = 0
alter VB3 = 0
alter VB4 = 0
alter VB5 = 0
alter VB6 = 0
alter VB7 = 0
let code = 0
stop when time = 0.000452
resume
delete all
alter VSAMPLE = 0
let trial = code + 128
let drive = (floor(trial / 1) - 2*floor(trial / 2))*1.8
alter VB0 = $&drive
let drive = (floor(trial / 2) - 2*floor(trial / 4))*1.8
alter VB1 = $&drive
let drive = (floor(trial / 4) - 2*floor(trial / 8))*1.8
alter VB2 = $&drive
let drive = (floor(trial / 8) - 2*floor(trial / 16))*1.8
alter VB3 = $&drive
let drive = (floor(trial / 16) - 2*floor(trial / 32))*1.8
alter VB4 = $&drive
let drive = (floor(trial / 32) - 2*floor(trial / 64))*1.8
alter VB5 = $&drive
let drive = (floor(trial / 64) - 2*floor(trial / 128))*1.8
alter VB6 = $&drive
let drive = (floor(trial / 128) - 2*floor(trial / 256))*1.8
alter VB7 = $&drive
stop when time = 0.000454
resume
delete all
let endpoint = length(time)-1
let cmp = v(COMP)[endpoint]
let top = v(TOP)[endpoint]
let decision = 0
if cmp >= 0.9
let code = trial
let decision = 1
end
echo 25 7 $&trial $&cmp $&top 0.10546875 $&decision >> decisions.csv
let trial = code + 64
let drive = (floor(trial / 1) - 2*floor(trial / 2))*1.8
alter VB0 = $&drive
let drive = (floor(trial / 2) - 2*floor(trial / 4))*1.8
alter VB1 = $&drive
let drive = (floor(trial / 4) - 2*floor(trial / 8))*1.8
alter VB2 = $&drive
let drive = (floor(trial / 8) - 2*floor(trial / 16))*1.8
alter VB3 = $&drive
let drive = (floor(trial / 16) - 2*floor(trial / 32))*1.8
alter VB4 = $&drive
let drive = (floor(trial / 32) - 2*floor(trial / 64))*1.8
alter VB5 = $&drive
let drive = (floor(trial / 64) - 2*floor(trial / 128))*1.8
alter VB6 = $&drive
let drive = (floor(trial / 128) - 2*floor(trial / 256))*1.8
alter VB7 = $&drive
stop when time = 0.000456
resume
delete all
let endpoint = length(time)-1
let cmp = v(COMP)[endpoint]
let top = v(TOP)[endpoint]
let decision = 0
if cmp >= 0.9
let code = trial
let decision = 1
end
echo 25 6 $&trial $&cmp $&top 0.10546875 $&decision >> decisions.csv
let trial = code + 32
let drive = (floor(trial / 1) - 2*floor(trial / 2))*1.8
alter VB0 = $&drive
let drive = (floor(trial / 2) - 2*floor(trial / 4))*1.8
alter VB1 = $&drive
let drive = (floor(trial / 4) - 2*floor(trial / 8))*1.8
alter VB2 = $&drive
let drive = (floor(trial / 8) - 2*floor(trial / 16))*1.8
alter VB3 = $&drive
let drive = (floor(trial / 16) - 2*floor(trial / 32))*1.8
alter VB4 = $&drive
let drive = (floor(trial / 32) - 2*floor(trial / 64))*1.8
alter VB5 = $&drive
let drive = (floor(trial / 64) - 2*floor(trial / 128))*1.8
alter VB6 = $&drive
let drive = (floor(trial / 128) - 2*floor(trial / 256))*1.8
alter VB7 = $&drive
stop when time = 0.000458
resume
delete all
let endpoint = length(time)-1
let cmp = v(COMP)[endpoint]
let top = v(TOP)[endpoint]
let decision = 0
if cmp >= 0.9
let code = trial
let decision = 1
end
echo 25 5 $&trial $&cmp $&top 0.10546875 $&decision >> decisions.csv
let trial = code + 16
let drive = (floor(trial / 1) - 2*floor(trial / 2))*1.8
alter VB0 = $&drive
let drive = (floor(trial / 2) - 2*floor(trial / 4))*1.8
alter VB1 = $&drive
let drive = (floor(trial / 4) - 2*floor(trial / 8))*1.8
alter VB2 = $&drive
let drive = (floor(trial / 8) - 2*floor(trial / 16))*1.8
alter VB3 = $&drive
let drive = (floor(trial / 16) - 2*floor(trial / 32))*1.8
alter VB4 = $&drive
let drive = (floor(trial / 32) - 2*floor(trial / 64))*1.8
alter VB5 = $&drive
let drive = (floor(trial / 64) - 2*floor(trial / 128))*1.8
alter VB6 = $&drive
let drive = (floor(trial / 128) - 2*floor(trial / 256))*1.8
alter VB7 = $&drive
stop when time = 0.00046
resume
delete all
let endpoint = length(time)-1
let cmp = v(COMP)[endpoint]
let top = v(TOP)[endpoint]
let decision = 0
if cmp >= 0.9
let code = trial
let decision = 1
end
echo 25 4 $&trial $&cmp $&top 0.10546875 $&decision >> decisions.csv
let trial = code + 8
let drive = (floor(trial / 1) - 2*floor(trial / 2))*1.8
alter VB0 = $&drive
let drive = (floor(trial / 2) - 2*floor(trial / 4))*1.8
alter VB1 = $&drive
let drive = (floor(trial / 4) - 2*floor(trial / 8))*1.8
alter VB2 = $&drive
let drive = (floor(trial / 8) - 2*floor(trial / 16))*1.8
alter VB3 = $&drive
let drive = (floor(trial / 16) - 2*floor(trial / 32))*1.8
alter VB4 = $&drive
let drive = (floor(trial / 32) - 2*floor(trial / 64))*1.8
alter VB5 = $&drive
let drive = (floor(trial / 64) - 2*floor(trial / 128))*1.8
alter VB6 = $&drive
let drive = (floor(trial / 128) - 2*floor(trial / 256))*1.8
alter VB7 = $&drive
stop when time = 0.000462
resume
delete all
let endpoint = length(time)-1
let cmp = v(COMP)[endpoint]
let top = v(TOP)[endpoint]
let decision = 0
if cmp >= 0.9
let code = trial
let decision = 1
end
echo 25 3 $&trial $&cmp $&top 0.10546875 $&decision >> decisions.csv
let trial = code + 4
let drive = (floor(trial / 1) - 2*floor(trial / 2))*1.8
alter VB0 = $&drive
let drive = (floor(trial / 2) - 2*floor(trial / 4))*1.8
alter VB1 = $&drive
let drive = (floor(trial / 4) - 2*floor(trial / 8))*1.8
alter VB2 = $&drive
let drive = (floor(trial / 8) - 2*floor(trial / 16))*1.8
alter VB3 = $&drive
let drive = (floor(trial / 16) - 2*floor(trial / 32))*1.8
alter VB4 = $&drive
let drive = (floor(trial / 32) - 2*floor(trial / 64))*1.8
alter VB5 = $&drive
let drive = (floor(trial / 64) - 2*floor(trial / 128))*1.8
alter VB6 = $&drive
let drive = (floor(trial / 128) - 2*floor(trial / 256))*1.8
alter VB7 = $&drive
stop when time = 0.000464
resume
delete all
let endpoint = length(time)-1
let cmp = v(COMP)[endpoint]
let top = v(TOP)[endpoint]
let decision = 0
if cmp >= 0.9
let code = trial
let decision = 1
end
echo 25 2 $&trial $&cmp $&top 0.10546875 $&decision >> decisions.csv
let trial = code + 2
let drive = (floor(trial / 1) - 2*floor(trial / 2))*1.8
alter VB0 = $&drive
let drive = (floor(trial / 2) - 2*floor(trial / 4))*1.8
alter VB1 = $&drive
let drive = (floor(trial / 4) - 2*floor(trial / 8))*1.8
alter VB2 = $&drive
let drive = (floor(trial / 8) - 2*floor(trial / 16))*1.8
alter VB3 = $&drive
let drive = (floor(trial / 16) - 2*floor(trial / 32))*1.8
alter VB4 = $&drive
let drive = (floor(trial / 32) - 2*floor(trial / 64))*1.8
alter VB5 = $&drive
let drive = (floor(trial / 64) - 2*floor(trial / 128))*1.8
alter VB6 = $&drive
let drive = (floor(trial / 128) - 2*floor(trial / 256))*1.8
alter VB7 = $&drive
stop when time = 0.000466
resume
delete all
let endpoint = length(time)-1
let cmp = v(COMP)[endpoint]
let top = v(TOP)[endpoint]
let decision = 0
if cmp >= 0.9
let code = trial
let decision = 1
end
echo 25 1 $&trial $&cmp $&top 0.10546875 $&decision >> decisions.csv
let trial = code + 1
let drive = (floor(trial / 1) - 2*floor(trial / 2))*1.8
alter VB0 = $&drive
let drive = (floor(trial / 2) - 2*floor(trial / 4))*1.8
alter VB1 = $&drive
let drive = (floor(trial / 4) - 2*floor(trial / 8))*1.8
alter VB2 = $&drive
let drive = (floor(trial / 8) - 2*floor(trial / 16))*1.8
alter VB3 = $&drive
let drive = (floor(trial / 16) - 2*floor(trial / 32))*1.8
alter VB4 = $&drive
let drive = (floor(trial / 32) - 2*floor(trial / 64))*1.8
alter VB5 = $&drive
let drive = (floor(trial / 64) - 2*floor(trial / 128))*1.8
alter VB6 = $&drive
let drive = (floor(trial / 128) - 2*floor(trial / 256))*1.8
alter VB7 = $&drive
stop when time = 0.000468
resume
delete all
let endpoint = length(time)-1
let cmp = v(COMP)[endpoint]
let top = v(TOP)[endpoint]
let decision = 0
if cmp >= 0.9
let code = trial
let decision = 1
end
echo 25 0 $&trial $&cmp $&top 0.10546875 $&decision >> decisions.csv
alter VIN = 0.11015625
alter VSAMPLE = 1.8
alter VB0 = 0
alter VB1 = 0
alter VB2 = 0
alter VB3 = 0
alter VB4 = 0
alter VB5 = 0
alter VB6 = 0
alter VB7 = 0
let code = 0
stop when time = 0.00047
resume
delete all
alter VSAMPLE = 0
let trial = code + 128
let drive = (floor(trial / 1) - 2*floor(trial / 2))*1.8
alter VB0 = $&drive
let drive = (floor(trial / 2) - 2*floor(trial / 4))*1.8
alter VB1 = $&drive
let drive = (floor(trial / 4) - 2*floor(trial / 8))*1.8
alter VB2 = $&drive
let drive = (floor(trial / 8) - 2*floor(trial / 16))*1.8
alter VB3 = $&drive
let drive = (floor(trial / 16) - 2*floor(trial / 32))*1.8
alter VB4 = $&drive
let drive = (floor(trial / 32) - 2*floor(trial / 64))*1.8
alter VB5 = $&drive
let drive = (floor(trial / 64) - 2*floor(trial / 128))*1.8
alter VB6 = $&drive
let drive = (floor(trial / 128) - 2*floor(trial / 256))*1.8
alter VB7 = $&drive
stop when time = 0.000472
resume
delete all
let endpoint = length(time)-1
let cmp = v(COMP)[endpoint]
let top = v(TOP)[endpoint]
let decision = 0
if cmp >= 0.9
let code = trial
let decision = 1
end
echo 26 7 $&trial $&cmp $&top 0.11015625 $&decision >> decisions.csv
let trial = code + 64
let drive = (floor(trial / 1) - 2*floor(trial / 2))*1.8
alter VB0 = $&drive
let drive = (floor(trial / 2) - 2*floor(trial / 4))*1.8
alter VB1 = $&drive
let drive = (floor(trial / 4) - 2*floor(trial / 8))*1.8
alter VB2 = $&drive
let drive = (floor(trial / 8) - 2*floor(trial / 16))*1.8
alter VB3 = $&drive
let drive = (floor(trial / 16) - 2*floor(trial / 32))*1.8
alter VB4 = $&drive
let drive = (floor(trial / 32) - 2*floor(trial / 64))*1.8
alter VB5 = $&drive
let drive = (floor(trial / 64) - 2*floor(trial / 128))*1.8
alter VB6 = $&drive
let drive = (floor(trial / 128) - 2*floor(trial / 256))*1.8
alter VB7 = $&drive
stop when time = 0.000474
resume
delete all
let endpoint = length(time)-1
let cmp = v(COMP)[endpoint]
let top = v(TOP)[endpoint]
let decision = 0
if cmp >= 0.9
let code = trial
let decision = 1
end
echo 26 6 $&trial $&cmp $&top 0.11015625 $&decision >> decisions.csv
let trial = code + 32
let drive = (floor(trial / 1) - 2*floor(trial / 2))*1.8
alter VB0 = $&drive
let drive = (floor(trial / 2) - 2*floor(trial / 4))*1.8
alter VB1 = $&drive
let drive = (floor(trial / 4) - 2*floor(trial / 8))*1.8
alter VB2 = $&drive
let drive = (floor(trial / 8) - 2*floor(trial / 16))*1.8
alter VB3 = $&drive
let drive = (floor(trial / 16) - 2*floor(trial / 32))*1.8
alter VB4 = $&drive
let drive = (floor(trial / 32) - 2*floor(trial / 64))*1.8
alter VB5 = $&drive
let drive = (floor(trial / 64) - 2*floor(trial / 128))*1.8
alter VB6 = $&drive
let drive = (floor(trial / 128) - 2*floor(trial / 256))*1.8
alter VB7 = $&drive
stop when time = 0.000476
resume
delete all
let endpoint = length(time)-1
let cmp = v(COMP)[endpoint]
let top = v(TOP)[endpoint]
let decision = 0
if cmp >= 0.9
let code = trial
let decision = 1
end
echo 26 5 $&trial $&cmp $&top 0.11015625 $&decision >> decisions.csv
let trial = code + 16
let drive = (floor(trial / 1) - 2*floor(trial / 2))*1.8
alter VB0 = $&drive
let drive = (floor(trial / 2) - 2*floor(trial / 4))*1.8
alter VB1 = $&drive
let drive = (floor(trial / 4) - 2*floor(trial / 8))*1.8
alter VB2 = $&drive
let drive = (floor(trial / 8) - 2*floor(trial / 16))*1.8
alter VB3 = $&drive
let drive = (floor(trial / 16) - 2*floor(trial / 32))*1.8
alter VB4 = $&drive
let drive = (floor(trial / 32) - 2*floor(trial / 64))*1.8
alter VB5 = $&drive
let drive = (floor(trial / 64) - 2*floor(trial / 128))*1.8
alter VB6 = $&drive
let drive = (floor(trial / 128) - 2*floor(trial / 256))*1.8
alter VB7 = $&drive
stop when time = 0.000478
resume
delete all
let endpoint = length(time)-1
let cmp = v(COMP)[endpoint]
let top = v(TOP)[endpoint]
let decision = 0
if cmp >= 0.9
let code = trial
let decision = 1
end
echo 26 4 $&trial $&cmp $&top 0.11015625 $&decision >> decisions.csv
let trial = code + 8
let drive = (floor(trial / 1) - 2*floor(trial / 2))*1.8
alter VB0 = $&drive
let drive = (floor(trial / 2) - 2*floor(trial / 4))*1.8
alter VB1 = $&drive
let drive = (floor(trial / 4) - 2*floor(trial / 8))*1.8
alter VB2 = $&drive
let drive = (floor(trial / 8) - 2*floor(trial / 16))*1.8
alter VB3 = $&drive
let drive = (floor(trial / 16) - 2*floor(trial / 32))*1.8
alter VB4 = $&drive
let drive = (floor(trial / 32) - 2*floor(trial / 64))*1.8
alter VB5 = $&drive
let drive = (floor(trial / 64) - 2*floor(trial / 128))*1.8
alter VB6 = $&drive
let drive = (floor(trial / 128) - 2*floor(trial / 256))*1.8
alter VB7 = $&drive
stop when time = 0.00048
resume
delete all
let endpoint = length(time)-1
let cmp = v(COMP)[endpoint]
let top = v(TOP)[endpoint]
let decision = 0
if cmp >= 0.9
let code = trial
let decision = 1
end
echo 26 3 $&trial $&cmp $&top 0.11015625 $&decision >> decisions.csv
let trial = code + 4
let drive = (floor(trial / 1) - 2*floor(trial / 2))*1.8
alter VB0 = $&drive
let drive = (floor(trial / 2) - 2*floor(trial / 4))*1.8
alter VB1 = $&drive
let drive = (floor(trial / 4) - 2*floor(trial / 8))*1.8
alter VB2 = $&drive
let drive = (floor(trial / 8) - 2*floor(trial / 16))*1.8
alter VB3 = $&drive
let drive = (floor(trial / 16) - 2*floor(trial / 32))*1.8
alter VB4 = $&drive
let drive = (floor(trial / 32) - 2*floor(trial / 64))*1.8
alter VB5 = $&drive
let drive = (floor(trial / 64) - 2*floor(trial / 128))*1.8
alter VB6 = $&drive
let drive = (floor(trial / 128) - 2*floor(trial / 256))*1.8
alter VB7 = $&drive
stop when time = 0.000482
resume
delete all
let endpoint = length(time)-1
let cmp = v(COMP)[endpoint]
let top = v(TOP)[endpoint]
let decision = 0
if cmp >= 0.9
let code = trial
let decision = 1
end
echo 26 2 $&trial $&cmp $&top 0.11015625 $&decision >> decisions.csv
let trial = code + 2
let drive = (floor(trial / 1) - 2*floor(trial / 2))*1.8
alter VB0 = $&drive
let drive = (floor(trial / 2) - 2*floor(trial / 4))*1.8
alter VB1 = $&drive
let drive = (floor(trial / 4) - 2*floor(trial / 8))*1.8
alter VB2 = $&drive
let drive = (floor(trial / 8) - 2*floor(trial / 16))*1.8
alter VB3 = $&drive
let drive = (floor(trial / 16) - 2*floor(trial / 32))*1.8
alter VB4 = $&drive
let drive = (floor(trial / 32) - 2*floor(trial / 64))*1.8
alter VB5 = $&drive
let drive = (floor(trial / 64) - 2*floor(trial / 128))*1.8
alter VB6 = $&drive
let drive = (floor(trial / 128) - 2*floor(trial / 256))*1.8
alter VB7 = $&drive
stop when time = 0.000484
resume
delete all
let endpoint = length(time)-1
let cmp = v(COMP)[endpoint]
let top = v(TOP)[endpoint]
let decision = 0
if cmp >= 0.9
let code = trial
let decision = 1
end
echo 26 1 $&trial $&cmp $&top 0.11015625 $&decision >> decisions.csv
let trial = code + 1
let drive = (floor(trial / 1) - 2*floor(trial / 2))*1.8
alter VB0 = $&drive
let drive = (floor(trial / 2) - 2*floor(trial / 4))*1.8
alter VB1 = $&drive
let drive = (floor(trial / 4) - 2*floor(trial / 8))*1.8
alter VB2 = $&drive
let drive = (floor(trial / 8) - 2*floor(trial / 16))*1.8
alter VB3 = $&drive
let drive = (floor(trial / 16) - 2*floor(trial / 32))*1.8
alter VB4 = $&drive
let drive = (floor(trial / 32) - 2*floor(trial / 64))*1.8
alter VB5 = $&drive
let drive = (floor(trial / 64) - 2*floor(trial / 128))*1.8
alter VB6 = $&drive
let drive = (floor(trial / 128) - 2*floor(trial / 256))*1.8
alter VB7 = $&drive
stop when time = 0.000486
resume
delete all
let endpoint = length(time)-1
let cmp = v(COMP)[endpoint]
let top = v(TOP)[endpoint]
let decision = 0
if cmp >= 0.9
let code = trial
let decision = 1
end
echo 26 0 $&trial $&cmp $&top 0.11015625 $&decision >> decisions.csv
alter VIN = 0.11484375
alter VSAMPLE = 1.8
alter VB0 = 0
alter VB1 = 0
alter VB2 = 0
alter VB3 = 0
alter VB4 = 0
alter VB5 = 0
alter VB6 = 0
alter VB7 = 0
let code = 0
stop when time = 0.000488
resume
delete all
alter VSAMPLE = 0
let trial = code + 128
let drive = (floor(trial / 1) - 2*floor(trial / 2))*1.8
alter VB0 = $&drive
let drive = (floor(trial / 2) - 2*floor(trial / 4))*1.8
alter VB1 = $&drive
let drive = (floor(trial / 4) - 2*floor(trial / 8))*1.8
alter VB2 = $&drive
let drive = (floor(trial / 8) - 2*floor(trial / 16))*1.8
alter VB3 = $&drive
let drive = (floor(trial / 16) - 2*floor(trial / 32))*1.8
alter VB4 = $&drive
let drive = (floor(trial / 32) - 2*floor(trial / 64))*1.8
alter VB5 = $&drive
let drive = (floor(trial / 64) - 2*floor(trial / 128))*1.8
alter VB6 = $&drive
let drive = (floor(trial / 128) - 2*floor(trial / 256))*1.8
alter VB7 = $&drive
stop when time = 0.00049
resume
delete all
let endpoint = length(time)-1
let cmp = v(COMP)[endpoint]
let top = v(TOP)[endpoint]
let decision = 0
if cmp >= 0.9
let code = trial
let decision = 1
end
echo 27 7 $&trial $&cmp $&top 0.11484375 $&decision >> decisions.csv
let trial = code + 64
let drive = (floor(trial / 1) - 2*floor(trial / 2))*1.8
alter VB0 = $&drive
let drive = (floor(trial / 2) - 2*floor(trial / 4))*1.8
alter VB1 = $&drive
let drive = (floor(trial / 4) - 2*floor(trial / 8))*1.8
alter VB2 = $&drive
let drive = (floor(trial / 8) - 2*floor(trial / 16))*1.8
alter VB3 = $&drive
let drive = (floor(trial / 16) - 2*floor(trial / 32))*1.8
alter VB4 = $&drive
let drive = (floor(trial / 32) - 2*floor(trial / 64))*1.8
alter VB5 = $&drive
let drive = (floor(trial / 64) - 2*floor(trial / 128))*1.8
alter VB6 = $&drive
let drive = (floor(trial / 128) - 2*floor(trial / 256))*1.8
alter VB7 = $&drive
stop when time = 0.000492
resume
delete all
let endpoint = length(time)-1
let cmp = v(COMP)[endpoint]
let top = v(TOP)[endpoint]
let decision = 0
if cmp >= 0.9
let code = trial
let decision = 1
end
echo 27 6 $&trial $&cmp $&top 0.11484375 $&decision >> decisions.csv
let trial = code + 32
let drive = (floor(trial / 1) - 2*floor(trial / 2))*1.8
alter VB0 = $&drive
let drive = (floor(trial / 2) - 2*floor(trial / 4))*1.8
alter VB1 = $&drive
let drive = (floor(trial / 4) - 2*floor(trial / 8))*1.8
alter VB2 = $&drive
let drive = (floor(trial / 8) - 2*floor(trial / 16))*1.8
alter VB3 = $&drive
let drive = (floor(trial / 16) - 2*floor(trial / 32))*1.8
alter VB4 = $&drive
let drive = (floor(trial / 32) - 2*floor(trial / 64))*1.8
alter VB5 = $&drive
let drive = (floor(trial / 64) - 2*floor(trial / 128))*1.8
alter VB6 = $&drive
let drive = (floor(trial / 128) - 2*floor(trial / 256))*1.8
alter VB7 = $&drive
stop when time = 0.000494
resume
delete all
let endpoint = length(time)-1
let cmp = v(COMP)[endpoint]
let top = v(TOP)[endpoint]
let decision = 0
if cmp >= 0.9
let code = trial
let decision = 1
end
echo 27 5 $&trial $&cmp $&top 0.11484375 $&decision >> decisions.csv
let trial = code + 16
let drive = (floor(trial / 1) - 2*floor(trial / 2))*1.8
alter VB0 = $&drive
let drive = (floor(trial / 2) - 2*floor(trial / 4))*1.8
alter VB1 = $&drive
let drive = (floor(trial / 4) - 2*floor(trial / 8))*1.8
alter VB2 = $&drive
let drive = (floor(trial / 8) - 2*floor(trial / 16))*1.8
alter VB3 = $&drive
let drive = (floor(trial / 16) - 2*floor(trial / 32))*1.8
alter VB4 = $&drive
let drive = (floor(trial / 32) - 2*floor(trial / 64))*1.8
alter VB5 = $&drive
let drive = (floor(trial / 64) - 2*floor(trial / 128))*1.8
alter VB6 = $&drive
let drive = (floor(trial / 128) - 2*floor(trial / 256))*1.8
alter VB7 = $&drive
stop when time = 0.000496
resume
delete all
let endpoint = length(time)-1
let cmp = v(COMP)[endpoint]
let top = v(TOP)[endpoint]
let decision = 0
if cmp >= 0.9
let code = trial
let decision = 1
end
echo 27 4 $&trial $&cmp $&top 0.11484375 $&decision >> decisions.csv
let trial = code + 8
let drive = (floor(trial / 1) - 2*floor(trial / 2))*1.8
alter VB0 = $&drive
let drive = (floor(trial / 2) - 2*floor(trial / 4))*1.8
alter VB1 = $&drive
let drive = (floor(trial / 4) - 2*floor(trial / 8))*1.8
alter VB2 = $&drive
let drive = (floor(trial / 8) - 2*floor(trial / 16))*1.8
alter VB3 = $&drive
let drive = (floor(trial / 16) - 2*floor(trial / 32))*1.8
alter VB4 = $&drive
let drive = (floor(trial / 32) - 2*floor(trial / 64))*1.8
alter VB5 = $&drive
let drive = (floor(trial / 64) - 2*floor(trial / 128))*1.8
alter VB6 = $&drive
let drive = (floor(trial / 128) - 2*floor(trial / 256))*1.8
alter VB7 = $&drive
stop when time = 0.000498
resume
delete all
let endpoint = length(time)-1
let cmp = v(COMP)[endpoint]
let top = v(TOP)[endpoint]
let decision = 0
if cmp >= 0.9
let code = trial
let decision = 1
end
echo 27 3 $&trial $&cmp $&top 0.11484375 $&decision >> decisions.csv
let trial = code + 4
let drive = (floor(trial / 1) - 2*floor(trial / 2))*1.8
alter VB0 = $&drive
let drive = (floor(trial / 2) - 2*floor(trial / 4))*1.8
alter VB1 = $&drive
let drive = (floor(trial / 4) - 2*floor(trial / 8))*1.8
alter VB2 = $&drive
let drive = (floor(trial / 8) - 2*floor(trial / 16))*1.8
alter VB3 = $&drive
let drive = (floor(trial / 16) - 2*floor(trial / 32))*1.8
alter VB4 = $&drive
let drive = (floor(trial / 32) - 2*floor(trial / 64))*1.8
alter VB5 = $&drive
let drive = (floor(trial / 64) - 2*floor(trial / 128))*1.8
alter VB6 = $&drive
let drive = (floor(trial / 128) - 2*floor(trial / 256))*1.8
alter VB7 = $&drive
stop when time = 0.0005
resume
delete all
let endpoint = length(time)-1
let cmp = v(COMP)[endpoint]
let top = v(TOP)[endpoint]
let decision = 0
if cmp >= 0.9
let code = trial
let decision = 1
end
echo 27 2 $&trial $&cmp $&top 0.11484375 $&decision >> decisions.csv
let trial = code + 2
let drive = (floor(trial / 1) - 2*floor(trial / 2))*1.8
alter VB0 = $&drive
let drive = (floor(trial / 2) - 2*floor(trial / 4))*1.8
alter VB1 = $&drive
let drive = (floor(trial / 4) - 2*floor(trial / 8))*1.8
alter VB2 = $&drive
let drive = (floor(trial / 8) - 2*floor(trial / 16))*1.8
alter VB3 = $&drive
let drive = (floor(trial / 16) - 2*floor(trial / 32))*1.8
alter VB4 = $&drive
let drive = (floor(trial / 32) - 2*floor(trial / 64))*1.8
alter VB5 = $&drive
let drive = (floor(trial / 64) - 2*floor(trial / 128))*1.8
alter VB6 = $&drive
let drive = (floor(trial / 128) - 2*floor(trial / 256))*1.8
alter VB7 = $&drive
stop when time = 0.000502
resume
delete all
let endpoint = length(time)-1
let cmp = v(COMP)[endpoint]
let top = v(TOP)[endpoint]
let decision = 0
if cmp >= 0.9
let code = trial
let decision = 1
end
echo 27 1 $&trial $&cmp $&top 0.11484375 $&decision >> decisions.csv
let trial = code + 1
let drive = (floor(trial / 1) - 2*floor(trial / 2))*1.8
alter VB0 = $&drive
let drive = (floor(trial / 2) - 2*floor(trial / 4))*1.8
alter VB1 = $&drive
let drive = (floor(trial / 4) - 2*floor(trial / 8))*1.8
alter VB2 = $&drive
let drive = (floor(trial / 8) - 2*floor(trial / 16))*1.8
alter VB3 = $&drive
let drive = (floor(trial / 16) - 2*floor(trial / 32))*1.8
alter VB4 = $&drive
let drive = (floor(trial / 32) - 2*floor(trial / 64))*1.8
alter VB5 = $&drive
let drive = (floor(trial / 64) - 2*floor(trial / 128))*1.8
alter VB6 = $&drive
let drive = (floor(trial / 128) - 2*floor(trial / 256))*1.8
alter VB7 = $&drive
stop when time = 0.000504
resume
delete all
let endpoint = length(time)-1
let cmp = v(COMP)[endpoint]
let top = v(TOP)[endpoint]
let decision = 0
if cmp >= 0.9
let code = trial
let decision = 1
end
echo 27 0 $&trial $&cmp $&top 0.11484375 $&decision >> decisions.csv
alter VIN = 0.11953125
alter VSAMPLE = 1.8
alter VB0 = 0
alter VB1 = 0
alter VB2 = 0
alter VB3 = 0
alter VB4 = 0
alter VB5 = 0
alter VB6 = 0
alter VB7 = 0
let code = 0
stop when time = 0.000506
resume
delete all
alter VSAMPLE = 0
let trial = code + 128
let drive = (floor(trial / 1) - 2*floor(trial / 2))*1.8
alter VB0 = $&drive
let drive = (floor(trial / 2) - 2*floor(trial / 4))*1.8
alter VB1 = $&drive
let drive = (floor(trial / 4) - 2*floor(trial / 8))*1.8
alter VB2 = $&drive
let drive = (floor(trial / 8) - 2*floor(trial / 16))*1.8
alter VB3 = $&drive
let drive = (floor(trial / 16) - 2*floor(trial / 32))*1.8
alter VB4 = $&drive
let drive = (floor(trial / 32) - 2*floor(trial / 64))*1.8
alter VB5 = $&drive
let drive = (floor(trial / 64) - 2*floor(trial / 128))*1.8
alter VB6 = $&drive
let drive = (floor(trial / 128) - 2*floor(trial / 256))*1.8
alter VB7 = $&drive
stop when time = 0.000508
resume
delete all
let endpoint = length(time)-1
let cmp = v(COMP)[endpoint]
let top = v(TOP)[endpoint]
let decision = 0
if cmp >= 0.9
let code = trial
let decision = 1
end
echo 28 7 $&trial $&cmp $&top 0.11953125 $&decision >> decisions.csv
let trial = code + 64
let drive = (floor(trial / 1) - 2*floor(trial / 2))*1.8
alter VB0 = $&drive
let drive = (floor(trial / 2) - 2*floor(trial / 4))*1.8
alter VB1 = $&drive
let drive = (floor(trial / 4) - 2*floor(trial / 8))*1.8
alter VB2 = $&drive
let drive = (floor(trial / 8) - 2*floor(trial / 16))*1.8
alter VB3 = $&drive
let drive = (floor(trial / 16) - 2*floor(trial / 32))*1.8
alter VB4 = $&drive
let drive = (floor(trial / 32) - 2*floor(trial / 64))*1.8
alter VB5 = $&drive
let drive = (floor(trial / 64) - 2*floor(trial / 128))*1.8
alter VB6 = $&drive
let drive = (floor(trial / 128) - 2*floor(trial / 256))*1.8
alter VB7 = $&drive
stop when time = 0.00051
resume
delete all
let endpoint = length(time)-1
let cmp = v(COMP)[endpoint]
let top = v(TOP)[endpoint]
let decision = 0
if cmp >= 0.9
let code = trial
let decision = 1
end
echo 28 6 $&trial $&cmp $&top 0.11953125 $&decision >> decisions.csv
let trial = code + 32
let drive = (floor(trial / 1) - 2*floor(trial / 2))*1.8
alter VB0 = $&drive
let drive = (floor(trial / 2) - 2*floor(trial / 4))*1.8
alter VB1 = $&drive
let drive = (floor(trial / 4) - 2*floor(trial / 8))*1.8
alter VB2 = $&drive
let drive = (floor(trial / 8) - 2*floor(trial / 16))*1.8
alter VB3 = $&drive
let drive = (floor(trial / 16) - 2*floor(trial / 32))*1.8
alter VB4 = $&drive
let drive = (floor(trial / 32) - 2*floor(trial / 64))*1.8
alter VB5 = $&drive
let drive = (floor(trial / 64) - 2*floor(trial / 128))*1.8
alter VB6 = $&drive
let drive = (floor(trial / 128) - 2*floor(trial / 256))*1.8
alter VB7 = $&drive
stop when time = 0.000512
resume
delete all
let endpoint = length(time)-1
let cmp = v(COMP)[endpoint]
let top = v(TOP)[endpoint]
let decision = 0
if cmp >= 0.9
let code = trial
let decision = 1
end
echo 28 5 $&trial $&cmp $&top 0.11953125 $&decision >> decisions.csv
let trial = code + 16
let drive = (floor(trial / 1) - 2*floor(trial / 2))*1.8
alter VB0 = $&drive
let drive = (floor(trial / 2) - 2*floor(trial / 4))*1.8
alter VB1 = $&drive
let drive = (floor(trial / 4) - 2*floor(trial / 8))*1.8
alter VB2 = $&drive
let drive = (floor(trial / 8) - 2*floor(trial / 16))*1.8
alter VB3 = $&drive
let drive = (floor(trial / 16) - 2*floor(trial / 32))*1.8
alter VB4 = $&drive
let drive = (floor(trial / 32) - 2*floor(trial / 64))*1.8
alter VB5 = $&drive
let drive = (floor(trial / 64) - 2*floor(trial / 128))*1.8
alter VB6 = $&drive
let drive = (floor(trial / 128) - 2*floor(trial / 256))*1.8
alter VB7 = $&drive
stop when time = 0.000514
resume
delete all
let endpoint = length(time)-1
let cmp = v(COMP)[endpoint]
let top = v(TOP)[endpoint]
let decision = 0
if cmp >= 0.9
let code = trial
let decision = 1
end
echo 28 4 $&trial $&cmp $&top 0.11953125 $&decision >> decisions.csv
let trial = code + 8
let drive = (floor(trial / 1) - 2*floor(trial / 2))*1.8
alter VB0 = $&drive
let drive = (floor(trial / 2) - 2*floor(trial / 4))*1.8
alter VB1 = $&drive
let drive = (floor(trial / 4) - 2*floor(trial / 8))*1.8
alter VB2 = $&drive
let drive = (floor(trial / 8) - 2*floor(trial / 16))*1.8
alter VB3 = $&drive
let drive = (floor(trial / 16) - 2*floor(trial / 32))*1.8
alter VB4 = $&drive
let drive = (floor(trial / 32) - 2*floor(trial / 64))*1.8
alter VB5 = $&drive
let drive = (floor(trial / 64) - 2*floor(trial / 128))*1.8
alter VB6 = $&drive
let drive = (floor(trial / 128) - 2*floor(trial / 256))*1.8
alter VB7 = $&drive
stop when time = 0.000516
resume
delete all
let endpoint = length(time)-1
let cmp = v(COMP)[endpoint]
let top = v(TOP)[endpoint]
let decision = 0
if cmp >= 0.9
let code = trial
let decision = 1
end
echo 28 3 $&trial $&cmp $&top 0.11953125 $&decision >> decisions.csv
let trial = code + 4
let drive = (floor(trial / 1) - 2*floor(trial / 2))*1.8
alter VB0 = $&drive
let drive = (floor(trial / 2) - 2*floor(trial / 4))*1.8
alter VB1 = $&drive
let drive = (floor(trial / 4) - 2*floor(trial / 8))*1.8
alter VB2 = $&drive
let drive = (floor(trial / 8) - 2*floor(trial / 16))*1.8
alter VB3 = $&drive
let drive = (floor(trial / 16) - 2*floor(trial / 32))*1.8
alter VB4 = $&drive
let drive = (floor(trial / 32) - 2*floor(trial / 64))*1.8
alter VB5 = $&drive
let drive = (floor(trial / 64) - 2*floor(trial / 128))*1.8
alter VB6 = $&drive
let drive = (floor(trial / 128) - 2*floor(trial / 256))*1.8
alter VB7 = $&drive
stop when time = 0.000518
resume
delete all
let endpoint = length(time)-1
let cmp = v(COMP)[endpoint]
let top = v(TOP)[endpoint]
let decision = 0
if cmp >= 0.9
let code = trial
let decision = 1
end
echo 28 2 $&trial $&cmp $&top 0.11953125 $&decision >> decisions.csv
let trial = code + 2
let drive = (floor(trial / 1) - 2*floor(trial / 2))*1.8
alter VB0 = $&drive
let drive = (floor(trial / 2) - 2*floor(trial / 4))*1.8
alter VB1 = $&drive
let drive = (floor(trial / 4) - 2*floor(trial / 8))*1.8
alter VB2 = $&drive
let drive = (floor(trial / 8) - 2*floor(trial / 16))*1.8
alter VB3 = $&drive
let drive = (floor(trial / 16) - 2*floor(trial / 32))*1.8
alter VB4 = $&drive
let drive = (floor(trial / 32) - 2*floor(trial / 64))*1.8
alter VB5 = $&drive
let drive = (floor(trial / 64) - 2*floor(trial / 128))*1.8
alter VB6 = $&drive
let drive = (floor(trial / 128) - 2*floor(trial / 256))*1.8
alter VB7 = $&drive
stop when time = 0.00052
resume
delete all
let endpoint = length(time)-1
let cmp = v(COMP)[endpoint]
let top = v(TOP)[endpoint]
let decision = 0
if cmp >= 0.9
let code = trial
let decision = 1
end
echo 28 1 $&trial $&cmp $&top 0.11953125 $&decision >> decisions.csv
let trial = code + 1
let drive = (floor(trial / 1) - 2*floor(trial / 2))*1.8
alter VB0 = $&drive
let drive = (floor(trial / 2) - 2*floor(trial / 4))*1.8
alter VB1 = $&drive
let drive = (floor(trial / 4) - 2*floor(trial / 8))*1.8
alter VB2 = $&drive
let drive = (floor(trial / 8) - 2*floor(trial / 16))*1.8
alter VB3 = $&drive
let drive = (floor(trial / 16) - 2*floor(trial / 32))*1.8
alter VB4 = $&drive
let drive = (floor(trial / 32) - 2*floor(trial / 64))*1.8
alter VB5 = $&drive
let drive = (floor(trial / 64) - 2*floor(trial / 128))*1.8
alter VB6 = $&drive
let drive = (floor(trial / 128) - 2*floor(trial / 256))*1.8
alter VB7 = $&drive
stop when time = 0.000522
resume
delete all
let endpoint = length(time)-1
let cmp = v(COMP)[endpoint]
let top = v(TOP)[endpoint]
let decision = 0
if cmp >= 0.9
let code = trial
let decision = 1
end
echo 28 0 $&trial $&cmp $&top 0.11953125 $&decision >> decisions.csv
alter VIN = 0.12421875
alter VSAMPLE = 1.8
alter VB0 = 0
alter VB1 = 0
alter VB2 = 0
alter VB3 = 0
alter VB4 = 0
alter VB5 = 0
alter VB6 = 0
alter VB7 = 0
let code = 0
stop when time = 0.000524
resume
delete all
alter VSAMPLE = 0
let trial = code + 128
let drive = (floor(trial / 1) - 2*floor(trial / 2))*1.8
alter VB0 = $&drive
let drive = (floor(trial / 2) - 2*floor(trial / 4))*1.8
alter VB1 = $&drive
let drive = (floor(trial / 4) - 2*floor(trial / 8))*1.8
alter VB2 = $&drive
let drive = (floor(trial / 8) - 2*floor(trial / 16))*1.8
alter VB3 = $&drive
let drive = (floor(trial / 16) - 2*floor(trial / 32))*1.8
alter VB4 = $&drive
let drive = (floor(trial / 32) - 2*floor(trial / 64))*1.8
alter VB5 = $&drive
let drive = (floor(trial / 64) - 2*floor(trial / 128))*1.8
alter VB6 = $&drive
let drive = (floor(trial / 128) - 2*floor(trial / 256))*1.8
alter VB7 = $&drive
stop when time = 0.000526
resume
delete all
let endpoint = length(time)-1
let cmp = v(COMP)[endpoint]
let top = v(TOP)[endpoint]
let decision = 0
if cmp >= 0.9
let code = trial
let decision = 1
end
echo 29 7 $&trial $&cmp $&top 0.12421875 $&decision >> decisions.csv
let trial = code + 64
let drive = (floor(trial / 1) - 2*floor(trial / 2))*1.8
alter VB0 = $&drive
let drive = (floor(trial / 2) - 2*floor(trial / 4))*1.8
alter VB1 = $&drive
let drive = (floor(trial / 4) - 2*floor(trial / 8))*1.8
alter VB2 = $&drive
let drive = (floor(trial / 8) - 2*floor(trial / 16))*1.8
alter VB3 = $&drive
let drive = (floor(trial / 16) - 2*floor(trial / 32))*1.8
alter VB4 = $&drive
let drive = (floor(trial / 32) - 2*floor(trial / 64))*1.8
alter VB5 = $&drive
let drive = (floor(trial / 64) - 2*floor(trial / 128))*1.8
alter VB6 = $&drive
let drive = (floor(trial / 128) - 2*floor(trial / 256))*1.8
alter VB7 = $&drive
stop when time = 0.000528
resume
delete all
let endpoint = length(time)-1
let cmp = v(COMP)[endpoint]
let top = v(TOP)[endpoint]
let decision = 0
if cmp >= 0.9
let code = trial
let decision = 1
end
echo 29 6 $&trial $&cmp $&top 0.12421875 $&decision >> decisions.csv
let trial = code + 32
let drive = (floor(trial / 1) - 2*floor(trial / 2))*1.8
alter VB0 = $&drive
let drive = (floor(trial / 2) - 2*floor(trial / 4))*1.8
alter VB1 = $&drive
let drive = (floor(trial / 4) - 2*floor(trial / 8))*1.8
alter VB2 = $&drive
let drive = (floor(trial / 8) - 2*floor(trial / 16))*1.8
alter VB3 = $&drive
let drive = (floor(trial / 16) - 2*floor(trial / 32))*1.8
alter VB4 = $&drive
let drive = (floor(trial / 32) - 2*floor(trial / 64))*1.8
alter VB5 = $&drive
let drive = (floor(trial / 64) - 2*floor(trial / 128))*1.8
alter VB6 = $&drive
let drive = (floor(trial / 128) - 2*floor(trial / 256))*1.8
alter VB7 = $&drive
stop when time = 0.00053
resume
delete all
let endpoint = length(time)-1
let cmp = v(COMP)[endpoint]
let top = v(TOP)[endpoint]
let decision = 0
if cmp >= 0.9
let code = trial
let decision = 1
end
echo 29 5 $&trial $&cmp $&top 0.12421875 $&decision >> decisions.csv
let trial = code + 16
let drive = (floor(trial / 1) - 2*floor(trial / 2))*1.8
alter VB0 = $&drive
let drive = (floor(trial / 2) - 2*floor(trial / 4))*1.8
alter VB1 = $&drive
let drive = (floor(trial / 4) - 2*floor(trial / 8))*1.8
alter VB2 = $&drive
let drive = (floor(trial / 8) - 2*floor(trial / 16))*1.8
alter VB3 = $&drive
let drive = (floor(trial / 16) - 2*floor(trial / 32))*1.8
alter VB4 = $&drive
let drive = (floor(trial / 32) - 2*floor(trial / 64))*1.8
alter VB5 = $&drive
let drive = (floor(trial / 64) - 2*floor(trial / 128))*1.8
alter VB6 = $&drive
let drive = (floor(trial / 128) - 2*floor(trial / 256))*1.8
alter VB7 = $&drive
stop when time = 0.000532
resume
delete all
let endpoint = length(time)-1
let cmp = v(COMP)[endpoint]
let top = v(TOP)[endpoint]
let decision = 0
if cmp >= 0.9
let code = trial
let decision = 1
end
echo 29 4 $&trial $&cmp $&top 0.12421875 $&decision >> decisions.csv
let trial = code + 8
let drive = (floor(trial / 1) - 2*floor(trial / 2))*1.8
alter VB0 = $&drive
let drive = (floor(trial / 2) - 2*floor(trial / 4))*1.8
alter VB1 = $&drive
let drive = (floor(trial / 4) - 2*floor(trial / 8))*1.8
alter VB2 = $&drive
let drive = (floor(trial / 8) - 2*floor(trial / 16))*1.8
alter VB3 = $&drive
let drive = (floor(trial / 16) - 2*floor(trial / 32))*1.8
alter VB4 = $&drive
let drive = (floor(trial / 32) - 2*floor(trial / 64))*1.8
alter VB5 = $&drive
let drive = (floor(trial / 64) - 2*floor(trial / 128))*1.8
alter VB6 = $&drive
let drive = (floor(trial / 128) - 2*floor(trial / 256))*1.8
alter VB7 = $&drive
stop when time = 0.000534
resume
delete all
let endpoint = length(time)-1
let cmp = v(COMP)[endpoint]
let top = v(TOP)[endpoint]
let decision = 0
if cmp >= 0.9
let code = trial
let decision = 1
end
echo 29 3 $&trial $&cmp $&top 0.12421875 $&decision >> decisions.csv
let trial = code + 4
let drive = (floor(trial / 1) - 2*floor(trial / 2))*1.8
alter VB0 = $&drive
let drive = (floor(trial / 2) - 2*floor(trial / 4))*1.8
alter VB1 = $&drive
let drive = (floor(trial / 4) - 2*floor(trial / 8))*1.8
alter VB2 = $&drive
let drive = (floor(trial / 8) - 2*floor(trial / 16))*1.8
alter VB3 = $&drive
let drive = (floor(trial / 16) - 2*floor(trial / 32))*1.8
alter VB4 = $&drive
let drive = (floor(trial / 32) - 2*floor(trial / 64))*1.8
alter VB5 = $&drive
let drive = (floor(trial / 64) - 2*floor(trial / 128))*1.8
alter VB6 = $&drive
let drive = (floor(trial / 128) - 2*floor(trial / 256))*1.8
alter VB7 = $&drive
stop when time = 0.000536
resume
delete all
let endpoint = length(time)-1
let cmp = v(COMP)[endpoint]
let top = v(TOP)[endpoint]
let decision = 0
if cmp >= 0.9
let code = trial
let decision = 1
end
echo 29 2 $&trial $&cmp $&top 0.12421875 $&decision >> decisions.csv
let trial = code + 2
let drive = (floor(trial / 1) - 2*floor(trial / 2))*1.8
alter VB0 = $&drive
let drive = (floor(trial / 2) - 2*floor(trial / 4))*1.8
alter VB1 = $&drive
let drive = (floor(trial / 4) - 2*floor(trial / 8))*1.8
alter VB2 = $&drive
let drive = (floor(trial / 8) - 2*floor(trial / 16))*1.8
alter VB3 = $&drive
let drive = (floor(trial / 16) - 2*floor(trial / 32))*1.8
alter VB4 = $&drive
let drive = (floor(trial / 32) - 2*floor(trial / 64))*1.8
alter VB5 = $&drive
let drive = (floor(trial / 64) - 2*floor(trial / 128))*1.8
alter VB6 = $&drive
let drive = (floor(trial / 128) - 2*floor(trial / 256))*1.8
alter VB7 = $&drive
stop when time = 0.000538
resume
delete all
let endpoint = length(time)-1
let cmp = v(COMP)[endpoint]
let top = v(TOP)[endpoint]
let decision = 0
if cmp >= 0.9
let code = trial
let decision = 1
end
echo 29 1 $&trial $&cmp $&top 0.12421875 $&decision >> decisions.csv
let trial = code + 1
let drive = (floor(trial / 1) - 2*floor(trial / 2))*1.8
alter VB0 = $&drive
let drive = (floor(trial / 2) - 2*floor(trial / 4))*1.8
alter VB1 = $&drive
let drive = (floor(trial / 4) - 2*floor(trial / 8))*1.8
alter VB2 = $&drive
let drive = (floor(trial / 8) - 2*floor(trial / 16))*1.8
alter VB3 = $&drive
let drive = (floor(trial / 16) - 2*floor(trial / 32))*1.8
alter VB4 = $&drive
let drive = (floor(trial / 32) - 2*floor(trial / 64))*1.8
alter VB5 = $&drive
let drive = (floor(trial / 64) - 2*floor(trial / 128))*1.8
alter VB6 = $&drive
let drive = (floor(trial / 128) - 2*floor(trial / 256))*1.8
alter VB7 = $&drive
stop when time = 0.00054
resume
delete all
let endpoint = length(time)-1
let cmp = v(COMP)[endpoint]
let top = v(TOP)[endpoint]
let decision = 0
if cmp >= 0.9
let code = trial
let decision = 1
end
echo 29 0 $&trial $&cmp $&top 0.12421875 $&decision >> decisions.csv
alter VIN = 0.12890625
alter VSAMPLE = 1.8
alter VB0 = 0
alter VB1 = 0
alter VB2 = 0
alter VB3 = 0
alter VB4 = 0
alter VB5 = 0
alter VB6 = 0
alter VB7 = 0
let code = 0
stop when time = 0.000542
resume
delete all
alter VSAMPLE = 0
let trial = code + 128
let drive = (floor(trial / 1) - 2*floor(trial / 2))*1.8
alter VB0 = $&drive
let drive = (floor(trial / 2) - 2*floor(trial / 4))*1.8
alter VB1 = $&drive
let drive = (floor(trial / 4) - 2*floor(trial / 8))*1.8
alter VB2 = $&drive
let drive = (floor(trial / 8) - 2*floor(trial / 16))*1.8
alter VB3 = $&drive
let drive = (floor(trial / 16) - 2*floor(trial / 32))*1.8
alter VB4 = $&drive
let drive = (floor(trial / 32) - 2*floor(trial / 64))*1.8
alter VB5 = $&drive
let drive = (floor(trial / 64) - 2*floor(trial / 128))*1.8
alter VB6 = $&drive
let drive = (floor(trial / 128) - 2*floor(trial / 256))*1.8
alter VB7 = $&drive
stop when time = 0.000544
resume
delete all
let endpoint = length(time)-1
let cmp = v(COMP)[endpoint]
let top = v(TOP)[endpoint]
let decision = 0
if cmp >= 0.9
let code = trial
let decision = 1
end
echo 30 7 $&trial $&cmp $&top 0.12890625 $&decision >> decisions.csv
let trial = code + 64
let drive = (floor(trial / 1) - 2*floor(trial / 2))*1.8
alter VB0 = $&drive
let drive = (floor(trial / 2) - 2*floor(trial / 4))*1.8
alter VB1 = $&drive
let drive = (floor(trial / 4) - 2*floor(trial / 8))*1.8
alter VB2 = $&drive
let drive = (floor(trial / 8) - 2*floor(trial / 16))*1.8
alter VB3 = $&drive
let drive = (floor(trial / 16) - 2*floor(trial / 32))*1.8
alter VB4 = $&drive
let drive = (floor(trial / 32) - 2*floor(trial / 64))*1.8
alter VB5 = $&drive
let drive = (floor(trial / 64) - 2*floor(trial / 128))*1.8
alter VB6 = $&drive
let drive = (floor(trial / 128) - 2*floor(trial / 256))*1.8
alter VB7 = $&drive
stop when time = 0.000546
resume
delete all
let endpoint = length(time)-1
let cmp = v(COMP)[endpoint]
let top = v(TOP)[endpoint]
let decision = 0
if cmp >= 0.9
let code = trial
let decision = 1
end
echo 30 6 $&trial $&cmp $&top 0.12890625 $&decision >> decisions.csv
let trial = code + 32
let drive = (floor(trial / 1) - 2*floor(trial / 2))*1.8
alter VB0 = $&drive
let drive = (floor(trial / 2) - 2*floor(trial / 4))*1.8
alter VB1 = $&drive
let drive = (floor(trial / 4) - 2*floor(trial / 8))*1.8
alter VB2 = $&drive
let drive = (floor(trial / 8) - 2*floor(trial / 16))*1.8
alter VB3 = $&drive
let drive = (floor(trial / 16) - 2*floor(trial / 32))*1.8
alter VB4 = $&drive
let drive = (floor(trial / 32) - 2*floor(trial / 64))*1.8
alter VB5 = $&drive
let drive = (floor(trial / 64) - 2*floor(trial / 128))*1.8
alter VB6 = $&drive
let drive = (floor(trial / 128) - 2*floor(trial / 256))*1.8
alter VB7 = $&drive
stop when time = 0.000548
resume
delete all
let endpoint = length(time)-1
let cmp = v(COMP)[endpoint]
let top = v(TOP)[endpoint]
let decision = 0
if cmp >= 0.9
let code = trial
let decision = 1
end
echo 30 5 $&trial $&cmp $&top 0.12890625 $&decision >> decisions.csv
let trial = code + 16
let drive = (floor(trial / 1) - 2*floor(trial / 2))*1.8
alter VB0 = $&drive
let drive = (floor(trial / 2) - 2*floor(trial / 4))*1.8
alter VB1 = $&drive
let drive = (floor(trial / 4) - 2*floor(trial / 8))*1.8
alter VB2 = $&drive
let drive = (floor(trial / 8) - 2*floor(trial / 16))*1.8
alter VB3 = $&drive
let drive = (floor(trial / 16) - 2*floor(trial / 32))*1.8
alter VB4 = $&drive
let drive = (floor(trial / 32) - 2*floor(trial / 64))*1.8
alter VB5 = $&drive
let drive = (floor(trial / 64) - 2*floor(trial / 128))*1.8
alter VB6 = $&drive
let drive = (floor(trial / 128) - 2*floor(trial / 256))*1.8
alter VB7 = $&drive
stop when time = 0.00055
resume
delete all
let endpoint = length(time)-1
let cmp = v(COMP)[endpoint]
let top = v(TOP)[endpoint]
let decision = 0
if cmp >= 0.9
let code = trial
let decision = 1
end
echo 30 4 $&trial $&cmp $&top 0.12890625 $&decision >> decisions.csv
let trial = code + 8
let drive = (floor(trial / 1) - 2*floor(trial / 2))*1.8
alter VB0 = $&drive
let drive = (floor(trial / 2) - 2*floor(trial / 4))*1.8
alter VB1 = $&drive
let drive = (floor(trial / 4) - 2*floor(trial / 8))*1.8
alter VB2 = $&drive
let drive = (floor(trial / 8) - 2*floor(trial / 16))*1.8
alter VB3 = $&drive
let drive = (floor(trial / 16) - 2*floor(trial / 32))*1.8
alter VB4 = $&drive
let drive = (floor(trial / 32) - 2*floor(trial / 64))*1.8
alter VB5 = $&drive
let drive = (floor(trial / 64) - 2*floor(trial / 128))*1.8
alter VB6 = $&drive
let drive = (floor(trial / 128) - 2*floor(trial / 256))*1.8
alter VB7 = $&drive
stop when time = 0.000552
resume
delete all
let endpoint = length(time)-1
let cmp = v(COMP)[endpoint]
let top = v(TOP)[endpoint]
let decision = 0
if cmp >= 0.9
let code = trial
let decision = 1
end
echo 30 3 $&trial $&cmp $&top 0.12890625 $&decision >> decisions.csv
let trial = code + 4
let drive = (floor(trial / 1) - 2*floor(trial / 2))*1.8
alter VB0 = $&drive
let drive = (floor(trial / 2) - 2*floor(trial / 4))*1.8
alter VB1 = $&drive
let drive = (floor(trial / 4) - 2*floor(trial / 8))*1.8
alter VB2 = $&drive
let drive = (floor(trial / 8) - 2*floor(trial / 16))*1.8
alter VB3 = $&drive
let drive = (floor(trial / 16) - 2*floor(trial / 32))*1.8
alter VB4 = $&drive
let drive = (floor(trial / 32) - 2*floor(trial / 64))*1.8
alter VB5 = $&drive
let drive = (floor(trial / 64) - 2*floor(trial / 128))*1.8
alter VB6 = $&drive
let drive = (floor(trial / 128) - 2*floor(trial / 256))*1.8
alter VB7 = $&drive
stop when time = 0.000554
resume
delete all
let endpoint = length(time)-1
let cmp = v(COMP)[endpoint]
let top = v(TOP)[endpoint]
let decision = 0
if cmp >= 0.9
let code = trial
let decision = 1
end
echo 30 2 $&trial $&cmp $&top 0.12890625 $&decision >> decisions.csv
let trial = code + 2
let drive = (floor(trial / 1) - 2*floor(trial / 2))*1.8
alter VB0 = $&drive
let drive = (floor(trial / 2) - 2*floor(trial / 4))*1.8
alter VB1 = $&drive
let drive = (floor(trial / 4) - 2*floor(trial / 8))*1.8
alter VB2 = $&drive
let drive = (floor(trial / 8) - 2*floor(trial / 16))*1.8
alter VB3 = $&drive
let drive = (floor(trial / 16) - 2*floor(trial / 32))*1.8
alter VB4 = $&drive
let drive = (floor(trial / 32) - 2*floor(trial / 64))*1.8
alter VB5 = $&drive
let drive = (floor(trial / 64) - 2*floor(trial / 128))*1.8
alter VB6 = $&drive
let drive = (floor(trial / 128) - 2*floor(trial / 256))*1.8
alter VB7 = $&drive
stop when time = 0.000556
resume
delete all
let endpoint = length(time)-1
let cmp = v(COMP)[endpoint]
let top = v(TOP)[endpoint]
let decision = 0
if cmp >= 0.9
let code = trial
let decision = 1
end
echo 30 1 $&trial $&cmp $&top 0.12890625 $&decision >> decisions.csv
let trial = code + 1
let drive = (floor(trial / 1) - 2*floor(trial / 2))*1.8
alter VB0 = $&drive
let drive = (floor(trial / 2) - 2*floor(trial / 4))*1.8
alter VB1 = $&drive
let drive = (floor(trial / 4) - 2*floor(trial / 8))*1.8
alter VB2 = $&drive
let drive = (floor(trial / 8) - 2*floor(trial / 16))*1.8
alter VB3 = $&drive
let drive = (floor(trial / 16) - 2*floor(trial / 32))*1.8
alter VB4 = $&drive
let drive = (floor(trial / 32) - 2*floor(trial / 64))*1.8
alter VB5 = $&drive
let drive = (floor(trial / 64) - 2*floor(trial / 128))*1.8
alter VB6 = $&drive
let drive = (floor(trial / 128) - 2*floor(trial / 256))*1.8
alter VB7 = $&drive
stop when time = 0.000558
resume
delete all
let endpoint = length(time)-1
let cmp = v(COMP)[endpoint]
let top = v(TOP)[endpoint]
let decision = 0
if cmp >= 0.9
let code = trial
let decision = 1
end
echo 30 0 $&trial $&cmp $&top 0.12890625 $&decision >> decisions.csv
alter VIN = 0.13359375
alter VSAMPLE = 1.8
alter VB0 = 0
alter VB1 = 0
alter VB2 = 0
alter VB3 = 0
alter VB4 = 0
alter VB5 = 0
alter VB6 = 0
alter VB7 = 0
let code = 0
stop when time = 0.00056
resume
delete all
alter VSAMPLE = 0
let trial = code + 128
let drive = (floor(trial / 1) - 2*floor(trial / 2))*1.8
alter VB0 = $&drive
let drive = (floor(trial / 2) - 2*floor(trial / 4))*1.8
alter VB1 = $&drive
let drive = (floor(trial / 4) - 2*floor(trial / 8))*1.8
alter VB2 = $&drive
let drive = (floor(trial / 8) - 2*floor(trial / 16))*1.8
alter VB3 = $&drive
let drive = (floor(trial / 16) - 2*floor(trial / 32))*1.8
alter VB4 = $&drive
let drive = (floor(trial / 32) - 2*floor(trial / 64))*1.8
alter VB5 = $&drive
let drive = (floor(trial / 64) - 2*floor(trial / 128))*1.8
alter VB6 = $&drive
let drive = (floor(trial / 128) - 2*floor(trial / 256))*1.8
alter VB7 = $&drive
stop when time = 0.000562
resume
delete all
let endpoint = length(time)-1
let cmp = v(COMP)[endpoint]
let top = v(TOP)[endpoint]
let decision = 0
if cmp >= 0.9
let code = trial
let decision = 1
end
echo 31 7 $&trial $&cmp $&top 0.13359375 $&decision >> decisions.csv
let trial = code + 64
let drive = (floor(trial / 1) - 2*floor(trial / 2))*1.8
alter VB0 = $&drive
let drive = (floor(trial / 2) - 2*floor(trial / 4))*1.8
alter VB1 = $&drive
let drive = (floor(trial / 4) - 2*floor(trial / 8))*1.8
alter VB2 = $&drive
let drive = (floor(trial / 8) - 2*floor(trial / 16))*1.8
alter VB3 = $&drive
let drive = (floor(trial / 16) - 2*floor(trial / 32))*1.8
alter VB4 = $&drive
let drive = (floor(trial / 32) - 2*floor(trial / 64))*1.8
alter VB5 = $&drive
let drive = (floor(trial / 64) - 2*floor(trial / 128))*1.8
alter VB6 = $&drive
let drive = (floor(trial / 128) - 2*floor(trial / 256))*1.8
alter VB7 = $&drive
stop when time = 0.000564
resume
delete all
let endpoint = length(time)-1
let cmp = v(COMP)[endpoint]
let top = v(TOP)[endpoint]
let decision = 0
if cmp >= 0.9
let code = trial
let decision = 1
end
echo 31 6 $&trial $&cmp $&top 0.13359375 $&decision >> decisions.csv
let trial = code + 32
let drive = (floor(trial / 1) - 2*floor(trial / 2))*1.8
alter VB0 = $&drive
let drive = (floor(trial / 2) - 2*floor(trial / 4))*1.8
alter VB1 = $&drive
let drive = (floor(trial / 4) - 2*floor(trial / 8))*1.8
alter VB2 = $&drive
let drive = (floor(trial / 8) - 2*floor(trial / 16))*1.8
alter VB3 = $&drive
let drive = (floor(trial / 16) - 2*floor(trial / 32))*1.8
alter VB4 = $&drive
let drive = (floor(trial / 32) - 2*floor(trial / 64))*1.8
alter VB5 = $&drive
let drive = (floor(trial / 64) - 2*floor(trial / 128))*1.8
alter VB6 = $&drive
let drive = (floor(trial / 128) - 2*floor(trial / 256))*1.8
alter VB7 = $&drive
stop when time = 0.000566
resume
delete all
let endpoint = length(time)-1
let cmp = v(COMP)[endpoint]
let top = v(TOP)[endpoint]
let decision = 0
if cmp >= 0.9
let code = trial
let decision = 1
end
echo 31 5 $&trial $&cmp $&top 0.13359375 $&decision >> decisions.csv
let trial = code + 16
let drive = (floor(trial / 1) - 2*floor(trial / 2))*1.8
alter VB0 = $&drive
let drive = (floor(trial / 2) - 2*floor(trial / 4))*1.8
alter VB1 = $&drive
let drive = (floor(trial / 4) - 2*floor(trial / 8))*1.8
alter VB2 = $&drive
let drive = (floor(trial / 8) - 2*floor(trial / 16))*1.8
alter VB3 = $&drive
let drive = (floor(trial / 16) - 2*floor(trial / 32))*1.8
alter VB4 = $&drive
let drive = (floor(trial / 32) - 2*floor(trial / 64))*1.8
alter VB5 = $&drive
let drive = (floor(trial / 64) - 2*floor(trial / 128))*1.8
alter VB6 = $&drive
let drive = (floor(trial / 128) - 2*floor(trial / 256))*1.8
alter VB7 = $&drive
stop when time = 0.000568
resume
delete all
let endpoint = length(time)-1
let cmp = v(COMP)[endpoint]
let top = v(TOP)[endpoint]
let decision = 0
if cmp >= 0.9
let code = trial
let decision = 1
end
echo 31 4 $&trial $&cmp $&top 0.13359375 $&decision >> decisions.csv
let trial = code + 8
let drive = (floor(trial / 1) - 2*floor(trial / 2))*1.8
alter VB0 = $&drive
let drive = (floor(trial / 2) - 2*floor(trial / 4))*1.8
alter VB1 = $&drive
let drive = (floor(trial / 4) - 2*floor(trial / 8))*1.8
alter VB2 = $&drive
let drive = (floor(trial / 8) - 2*floor(trial / 16))*1.8
alter VB3 = $&drive
let drive = (floor(trial / 16) - 2*floor(trial / 32))*1.8
alter VB4 = $&drive
let drive = (floor(trial / 32) - 2*floor(trial / 64))*1.8
alter VB5 = $&drive
let drive = (floor(trial / 64) - 2*floor(trial / 128))*1.8
alter VB6 = $&drive
let drive = (floor(trial / 128) - 2*floor(trial / 256))*1.8
alter VB7 = $&drive
stop when time = 0.00057
resume
delete all
let endpoint = length(time)-1
let cmp = v(COMP)[endpoint]
let top = v(TOP)[endpoint]
let decision = 0
if cmp >= 0.9
let code = trial
let decision = 1
end
echo 31 3 $&trial $&cmp $&top 0.13359375 $&decision >> decisions.csv
let trial = code + 4
let drive = (floor(trial / 1) - 2*floor(trial / 2))*1.8
alter VB0 = $&drive
let drive = (floor(trial / 2) - 2*floor(trial / 4))*1.8
alter VB1 = $&drive
let drive = (floor(trial / 4) - 2*floor(trial / 8))*1.8
alter VB2 = $&drive
let drive = (floor(trial / 8) - 2*floor(trial / 16))*1.8
alter VB3 = $&drive
let drive = (floor(trial / 16) - 2*floor(trial / 32))*1.8
alter VB4 = $&drive
let drive = (floor(trial / 32) - 2*floor(trial / 64))*1.8
alter VB5 = $&drive
let drive = (floor(trial / 64) - 2*floor(trial / 128))*1.8
alter VB6 = $&drive
let drive = (floor(trial / 128) - 2*floor(trial / 256))*1.8
alter VB7 = $&drive
stop when time = 0.000572
resume
delete all
let endpoint = length(time)-1
let cmp = v(COMP)[endpoint]
let top = v(TOP)[endpoint]
let decision = 0
if cmp >= 0.9
let code = trial
let decision = 1
end
echo 31 2 $&trial $&cmp $&top 0.13359375 $&decision >> decisions.csv
let trial = code + 2
let drive = (floor(trial / 1) - 2*floor(trial / 2))*1.8
alter VB0 = $&drive
let drive = (floor(trial / 2) - 2*floor(trial / 4))*1.8
alter VB1 = $&drive
let drive = (floor(trial / 4) - 2*floor(trial / 8))*1.8
alter VB2 = $&drive
let drive = (floor(trial / 8) - 2*floor(trial / 16))*1.8
alter VB3 = $&drive
let drive = (floor(trial / 16) - 2*floor(trial / 32))*1.8
alter VB4 = $&drive
let drive = (floor(trial / 32) - 2*floor(trial / 64))*1.8
alter VB5 = $&drive
let drive = (floor(trial / 64) - 2*floor(trial / 128))*1.8
alter VB6 = $&drive
let drive = (floor(trial / 128) - 2*floor(trial / 256))*1.8
alter VB7 = $&drive
stop when time = 0.000574
resume
delete all
let endpoint = length(time)-1
let cmp = v(COMP)[endpoint]
let top = v(TOP)[endpoint]
let decision = 0
if cmp >= 0.9
let code = trial
let decision = 1
end
echo 31 1 $&trial $&cmp $&top 0.13359375 $&decision >> decisions.csv
let trial = code + 1
let drive = (floor(trial / 1) - 2*floor(trial / 2))*1.8
alter VB0 = $&drive
let drive = (floor(trial / 2) - 2*floor(trial / 4))*1.8
alter VB1 = $&drive
let drive = (floor(trial / 4) - 2*floor(trial / 8))*1.8
alter VB2 = $&drive
let drive = (floor(trial / 8) - 2*floor(trial / 16))*1.8
alter VB3 = $&drive
let drive = (floor(trial / 16) - 2*floor(trial / 32))*1.8
alter VB4 = $&drive
let drive = (floor(trial / 32) - 2*floor(trial / 64))*1.8
alter VB5 = $&drive
let drive = (floor(trial / 64) - 2*floor(trial / 128))*1.8
alter VB6 = $&drive
let drive = (floor(trial / 128) - 2*floor(trial / 256))*1.8
alter VB7 = $&drive
stop when time = 0.000576
resume
delete all
let endpoint = length(time)-1
let cmp = v(COMP)[endpoint]
let top = v(TOP)[endpoint]
let decision = 0
if cmp >= 0.9
let code = trial
let decision = 1
end
echo 31 0 $&trial $&cmp $&top 0.13359375 $&decision >> decisions.csv
alter VIN = 0.13828125
alter VSAMPLE = 1.8
alter VB0 = 0
alter VB1 = 0
alter VB2 = 0
alter VB3 = 0
alter VB4 = 0
alter VB5 = 0
alter VB6 = 0
alter VB7 = 0
let code = 0
stop when time = 0.000578
resume
delete all
alter VSAMPLE = 0
let trial = code + 128
let drive = (floor(trial / 1) - 2*floor(trial / 2))*1.8
alter VB0 = $&drive
let drive = (floor(trial / 2) - 2*floor(trial / 4))*1.8
alter VB1 = $&drive
let drive = (floor(trial / 4) - 2*floor(trial / 8))*1.8
alter VB2 = $&drive
let drive = (floor(trial / 8) - 2*floor(trial / 16))*1.8
alter VB3 = $&drive
let drive = (floor(trial / 16) - 2*floor(trial / 32))*1.8
alter VB4 = $&drive
let drive = (floor(trial / 32) - 2*floor(trial / 64))*1.8
alter VB5 = $&drive
let drive = (floor(trial / 64) - 2*floor(trial / 128))*1.8
alter VB6 = $&drive
let drive = (floor(trial / 128) - 2*floor(trial / 256))*1.8
alter VB7 = $&drive
stop when time = 0.00058
resume
delete all
let endpoint = length(time)-1
let cmp = v(COMP)[endpoint]
let top = v(TOP)[endpoint]
let decision = 0
if cmp >= 0.9
let code = trial
let decision = 1
end
echo 32 7 $&trial $&cmp $&top 0.13828125 $&decision >> decisions.csv
let trial = code + 64
let drive = (floor(trial / 1) - 2*floor(trial / 2))*1.8
alter VB0 = $&drive
let drive = (floor(trial / 2) - 2*floor(trial / 4))*1.8
alter VB1 = $&drive
let drive = (floor(trial / 4) - 2*floor(trial / 8))*1.8
alter VB2 = $&drive
let drive = (floor(trial / 8) - 2*floor(trial / 16))*1.8
alter VB3 = $&drive
let drive = (floor(trial / 16) - 2*floor(trial / 32))*1.8
alter VB4 = $&drive
let drive = (floor(trial / 32) - 2*floor(trial / 64))*1.8
alter VB5 = $&drive
let drive = (floor(trial / 64) - 2*floor(trial / 128))*1.8
alter VB6 = $&drive
let drive = (floor(trial / 128) - 2*floor(trial / 256))*1.8
alter VB7 = $&drive
stop when time = 0.000582
resume
delete all
let endpoint = length(time)-1
let cmp = v(COMP)[endpoint]
let top = v(TOP)[endpoint]
let decision = 0
if cmp >= 0.9
let code = trial
let decision = 1
end
echo 32 6 $&trial $&cmp $&top 0.13828125 $&decision >> decisions.csv
let trial = code + 32
let drive = (floor(trial / 1) - 2*floor(trial / 2))*1.8
alter VB0 = $&drive
let drive = (floor(trial / 2) - 2*floor(trial / 4))*1.8
alter VB1 = $&drive
let drive = (floor(trial / 4) - 2*floor(trial / 8))*1.8
alter VB2 = $&drive
let drive = (floor(trial / 8) - 2*floor(trial / 16))*1.8
alter VB3 = $&drive
let drive = (floor(trial / 16) - 2*floor(trial / 32))*1.8
alter VB4 = $&drive
let drive = (floor(trial / 32) - 2*floor(trial / 64))*1.8
alter VB5 = $&drive
let drive = (floor(trial / 64) - 2*floor(trial / 128))*1.8
alter VB6 = $&drive
let drive = (floor(trial / 128) - 2*floor(trial / 256))*1.8
alter VB7 = $&drive
stop when time = 0.000584
resume
delete all
let endpoint = length(time)-1
let cmp = v(COMP)[endpoint]
let top = v(TOP)[endpoint]
let decision = 0
if cmp >= 0.9
let code = trial
let decision = 1
end
echo 32 5 $&trial $&cmp $&top 0.13828125 $&decision >> decisions.csv
let trial = code + 16
let drive = (floor(trial / 1) - 2*floor(trial / 2))*1.8
alter VB0 = $&drive
let drive = (floor(trial / 2) - 2*floor(trial / 4))*1.8
alter VB1 = $&drive
let drive = (floor(trial / 4) - 2*floor(trial / 8))*1.8
alter VB2 = $&drive
let drive = (floor(trial / 8) - 2*floor(trial / 16))*1.8
alter VB3 = $&drive
let drive = (floor(trial / 16) - 2*floor(trial / 32))*1.8
alter VB4 = $&drive
let drive = (floor(trial / 32) - 2*floor(trial / 64))*1.8
alter VB5 = $&drive
let drive = (floor(trial / 64) - 2*floor(trial / 128))*1.8
alter VB6 = $&drive
let drive = (floor(trial / 128) - 2*floor(trial / 256))*1.8
alter VB7 = $&drive
stop when time = 0.000586
resume
delete all
let endpoint = length(time)-1
let cmp = v(COMP)[endpoint]
let top = v(TOP)[endpoint]
let decision = 0
if cmp >= 0.9
let code = trial
let decision = 1
end
echo 32 4 $&trial $&cmp $&top 0.13828125 $&decision >> decisions.csv
let trial = code + 8
let drive = (floor(trial / 1) - 2*floor(trial / 2))*1.8
alter VB0 = $&drive
let drive = (floor(trial / 2) - 2*floor(trial / 4))*1.8
alter VB1 = $&drive
let drive = (floor(trial / 4) - 2*floor(trial / 8))*1.8
alter VB2 = $&drive
let drive = (floor(trial / 8) - 2*floor(trial / 16))*1.8
alter VB3 = $&drive
let drive = (floor(trial / 16) - 2*floor(trial / 32))*1.8
alter VB4 = $&drive
let drive = (floor(trial / 32) - 2*floor(trial / 64))*1.8
alter VB5 = $&drive
let drive = (floor(trial / 64) - 2*floor(trial / 128))*1.8
alter VB6 = $&drive
let drive = (floor(trial / 128) - 2*floor(trial / 256))*1.8
alter VB7 = $&drive
stop when time = 0.000588
resume
delete all
let endpoint = length(time)-1
let cmp = v(COMP)[endpoint]
let top = v(TOP)[endpoint]
let decision = 0
if cmp >= 0.9
let code = trial
let decision = 1
end
echo 32 3 $&trial $&cmp $&top 0.13828125 $&decision >> decisions.csv
let trial = code + 4
let drive = (floor(trial / 1) - 2*floor(trial / 2))*1.8
alter VB0 = $&drive
let drive = (floor(trial / 2) - 2*floor(trial / 4))*1.8
alter VB1 = $&drive
let drive = (floor(trial / 4) - 2*floor(trial / 8))*1.8
alter VB2 = $&drive
let drive = (floor(trial / 8) - 2*floor(trial / 16))*1.8
alter VB3 = $&drive
let drive = (floor(trial / 16) - 2*floor(trial / 32))*1.8
alter VB4 = $&drive
let drive = (floor(trial / 32) - 2*floor(trial / 64))*1.8
alter VB5 = $&drive
let drive = (floor(trial / 64) - 2*floor(trial / 128))*1.8
alter VB6 = $&drive
let drive = (floor(trial / 128) - 2*floor(trial / 256))*1.8
alter VB7 = $&drive
stop when time = 0.00059
resume
delete all
let endpoint = length(time)-1
let cmp = v(COMP)[endpoint]
let top = v(TOP)[endpoint]
let decision = 0
if cmp >= 0.9
let code = trial
let decision = 1
end
echo 32 2 $&trial $&cmp $&top 0.13828125 $&decision >> decisions.csv
let trial = code + 2
let drive = (floor(trial / 1) - 2*floor(trial / 2))*1.8
alter VB0 = $&drive
let drive = (floor(trial / 2) - 2*floor(trial / 4))*1.8
alter VB1 = $&drive
let drive = (floor(trial / 4) - 2*floor(trial / 8))*1.8
alter VB2 = $&drive
let drive = (floor(trial / 8) - 2*floor(trial / 16))*1.8
alter VB3 = $&drive
let drive = (floor(trial / 16) - 2*floor(trial / 32))*1.8
alter VB4 = $&drive
let drive = (floor(trial / 32) - 2*floor(trial / 64))*1.8
alter VB5 = $&drive
let drive = (floor(trial / 64) - 2*floor(trial / 128))*1.8
alter VB6 = $&drive
let drive = (floor(trial / 128) - 2*floor(trial / 256))*1.8
alter VB7 = $&drive
stop when time = 0.000592
resume
delete all
let endpoint = length(time)-1
let cmp = v(COMP)[endpoint]
let top = v(TOP)[endpoint]
let decision = 0
if cmp >= 0.9
let code = trial
let decision = 1
end
echo 32 1 $&trial $&cmp $&top 0.13828125 $&decision >> decisions.csv
let trial = code + 1
let drive = (floor(trial / 1) - 2*floor(trial / 2))*1.8
alter VB0 = $&drive
let drive = (floor(trial / 2) - 2*floor(trial / 4))*1.8
alter VB1 = $&drive
let drive = (floor(trial / 4) - 2*floor(trial / 8))*1.8
alter VB2 = $&drive
let drive = (floor(trial / 8) - 2*floor(trial / 16))*1.8
alter VB3 = $&drive
let drive = (floor(trial / 16) - 2*floor(trial / 32))*1.8
alter VB4 = $&drive
let drive = (floor(trial / 32) - 2*floor(trial / 64))*1.8
alter VB5 = $&drive
let drive = (floor(trial / 64) - 2*floor(trial / 128))*1.8
alter VB6 = $&drive
let drive = (floor(trial / 128) - 2*floor(trial / 256))*1.8
alter VB7 = $&drive
stop when time = 0.000594
resume
delete all
let endpoint = length(time)-1
let cmp = v(COMP)[endpoint]
let top = v(TOP)[endpoint]
let decision = 0
if cmp >= 0.9
let code = trial
let decision = 1
end
echo 32 0 $&trial $&cmp $&top 0.13828125 $&decision >> decisions.csv
alter VIN = 0.14296875
alter VSAMPLE = 1.8
alter VB0 = 0
alter VB1 = 0
alter VB2 = 0
alter VB3 = 0
alter VB4 = 0
alter VB5 = 0
alter VB6 = 0
alter VB7 = 0
let code = 0
stop when time = 0.000596
resume
delete all
alter VSAMPLE = 0
let trial = code + 128
let drive = (floor(trial / 1) - 2*floor(trial / 2))*1.8
alter VB0 = $&drive
let drive = (floor(trial / 2) - 2*floor(trial / 4))*1.8
alter VB1 = $&drive
let drive = (floor(trial / 4) - 2*floor(trial / 8))*1.8
alter VB2 = $&drive
let drive = (floor(trial / 8) - 2*floor(trial / 16))*1.8
alter VB3 = $&drive
let drive = (floor(trial / 16) - 2*floor(trial / 32))*1.8
alter VB4 = $&drive
let drive = (floor(trial / 32) - 2*floor(trial / 64))*1.8
alter VB5 = $&drive
let drive = (floor(trial / 64) - 2*floor(trial / 128))*1.8
alter VB6 = $&drive
let drive = (floor(trial / 128) - 2*floor(trial / 256))*1.8
alter VB7 = $&drive
stop when time = 0.000598
resume
delete all
let endpoint = length(time)-1
let cmp = v(COMP)[endpoint]
let top = v(TOP)[endpoint]
let decision = 0
if cmp >= 0.9
let code = trial
let decision = 1
end
echo 33 7 $&trial $&cmp $&top 0.14296875 $&decision >> decisions.csv
let trial = code + 64
let drive = (floor(trial / 1) - 2*floor(trial / 2))*1.8
alter VB0 = $&drive
let drive = (floor(trial / 2) - 2*floor(trial / 4))*1.8
alter VB1 = $&drive
let drive = (floor(trial / 4) - 2*floor(trial / 8))*1.8
alter VB2 = $&drive
let drive = (floor(trial / 8) - 2*floor(trial / 16))*1.8
alter VB3 = $&drive
let drive = (floor(trial / 16) - 2*floor(trial / 32))*1.8
alter VB4 = $&drive
let drive = (floor(trial / 32) - 2*floor(trial / 64))*1.8
alter VB5 = $&drive
let drive = (floor(trial / 64) - 2*floor(trial / 128))*1.8
alter VB6 = $&drive
let drive = (floor(trial / 128) - 2*floor(trial / 256))*1.8
alter VB7 = $&drive
stop when time = 0.0006
resume
delete all
let endpoint = length(time)-1
let cmp = v(COMP)[endpoint]
let top = v(TOP)[endpoint]
let decision = 0
if cmp >= 0.9
let code = trial
let decision = 1
end
echo 33 6 $&trial $&cmp $&top 0.14296875 $&decision >> decisions.csv
let trial = code + 32
let drive = (floor(trial / 1) - 2*floor(trial / 2))*1.8
alter VB0 = $&drive
let drive = (floor(trial / 2) - 2*floor(trial / 4))*1.8
alter VB1 = $&drive
let drive = (floor(trial / 4) - 2*floor(trial / 8))*1.8
alter VB2 = $&drive
let drive = (floor(trial / 8) - 2*floor(trial / 16))*1.8
alter VB3 = $&drive
let drive = (floor(trial / 16) - 2*floor(trial / 32))*1.8
alter VB4 = $&drive
let drive = (floor(trial / 32) - 2*floor(trial / 64))*1.8
alter VB5 = $&drive
let drive = (floor(trial / 64) - 2*floor(trial / 128))*1.8
alter VB6 = $&drive
let drive = (floor(trial / 128) - 2*floor(trial / 256))*1.8
alter VB7 = $&drive
stop when time = 0.000602
resume
delete all
let endpoint = length(time)-1
let cmp = v(COMP)[endpoint]
let top = v(TOP)[endpoint]
let decision = 0
if cmp >= 0.9
let code = trial
let decision = 1
end
echo 33 5 $&trial $&cmp $&top 0.14296875 $&decision >> decisions.csv
let trial = code + 16
let drive = (floor(trial / 1) - 2*floor(trial / 2))*1.8
alter VB0 = $&drive
let drive = (floor(trial / 2) - 2*floor(trial / 4))*1.8
alter VB1 = $&drive
let drive = (floor(trial / 4) - 2*floor(trial / 8))*1.8
alter VB2 = $&drive
let drive = (floor(trial / 8) - 2*floor(trial / 16))*1.8
alter VB3 = $&drive
let drive = (floor(trial / 16) - 2*floor(trial / 32))*1.8
alter VB4 = $&drive
let drive = (floor(trial / 32) - 2*floor(trial / 64))*1.8
alter VB5 = $&drive
let drive = (floor(trial / 64) - 2*floor(trial / 128))*1.8
alter VB6 = $&drive
let drive = (floor(trial / 128) - 2*floor(trial / 256))*1.8
alter VB7 = $&drive
stop when time = 0.000604
resume
delete all
let endpoint = length(time)-1
let cmp = v(COMP)[endpoint]
let top = v(TOP)[endpoint]
let decision = 0
if cmp >= 0.9
let code = trial
let decision = 1
end
echo 33 4 $&trial $&cmp $&top 0.14296875 $&decision >> decisions.csv
let trial = code + 8
let drive = (floor(trial / 1) - 2*floor(trial / 2))*1.8
alter VB0 = $&drive
let drive = (floor(trial / 2) - 2*floor(trial / 4))*1.8
alter VB1 = $&drive
let drive = (floor(trial / 4) - 2*floor(trial / 8))*1.8
alter VB2 = $&drive
let drive = (floor(trial / 8) - 2*floor(trial / 16))*1.8
alter VB3 = $&drive
let drive = (floor(trial / 16) - 2*floor(trial / 32))*1.8
alter VB4 = $&drive
let drive = (floor(trial / 32) - 2*floor(trial / 64))*1.8
alter VB5 = $&drive
let drive = (floor(trial / 64) - 2*floor(trial / 128))*1.8
alter VB6 = $&drive
let drive = (floor(trial / 128) - 2*floor(trial / 256))*1.8
alter VB7 = $&drive
stop when time = 0.000606
resume
delete all
let endpoint = length(time)-1
let cmp = v(COMP)[endpoint]
let top = v(TOP)[endpoint]
let decision = 0
if cmp >= 0.9
let code = trial
let decision = 1
end
echo 33 3 $&trial $&cmp $&top 0.14296875 $&decision >> decisions.csv
let trial = code + 4
let drive = (floor(trial / 1) - 2*floor(trial / 2))*1.8
alter VB0 = $&drive
let drive = (floor(trial / 2) - 2*floor(trial / 4))*1.8
alter VB1 = $&drive
let drive = (floor(trial / 4) - 2*floor(trial / 8))*1.8
alter VB2 = $&drive
let drive = (floor(trial / 8) - 2*floor(trial / 16))*1.8
alter VB3 = $&drive
let drive = (floor(trial / 16) - 2*floor(trial / 32))*1.8
alter VB4 = $&drive
let drive = (floor(trial / 32) - 2*floor(trial / 64))*1.8
alter VB5 = $&drive
let drive = (floor(trial / 64) - 2*floor(trial / 128))*1.8
alter VB6 = $&drive
let drive = (floor(trial / 128) - 2*floor(trial / 256))*1.8
alter VB7 = $&drive
stop when time = 0.000608
resume
delete all
let endpoint = length(time)-1
let cmp = v(COMP)[endpoint]
let top = v(TOP)[endpoint]
let decision = 0
if cmp >= 0.9
let code = trial
let decision = 1
end
echo 33 2 $&trial $&cmp $&top 0.14296875 $&decision >> decisions.csv
let trial = code + 2
let drive = (floor(trial / 1) - 2*floor(trial / 2))*1.8
alter VB0 = $&drive
let drive = (floor(trial / 2) - 2*floor(trial / 4))*1.8
alter VB1 = $&drive
let drive = (floor(trial / 4) - 2*floor(trial / 8))*1.8
alter VB2 = $&drive
let drive = (floor(trial / 8) - 2*floor(trial / 16))*1.8
alter VB3 = $&drive
let drive = (floor(trial / 16) - 2*floor(trial / 32))*1.8
alter VB4 = $&drive
let drive = (floor(trial / 32) - 2*floor(trial / 64))*1.8
alter VB5 = $&drive
let drive = (floor(trial / 64) - 2*floor(trial / 128))*1.8
alter VB6 = $&drive
let drive = (floor(trial / 128) - 2*floor(trial / 256))*1.8
alter VB7 = $&drive
stop when time = 0.00061
resume
delete all
let endpoint = length(time)-1
let cmp = v(COMP)[endpoint]
let top = v(TOP)[endpoint]
let decision = 0
if cmp >= 0.9
let code = trial
let decision = 1
end
echo 33 1 $&trial $&cmp $&top 0.14296875 $&decision >> decisions.csv
let trial = code + 1
let drive = (floor(trial / 1) - 2*floor(trial / 2))*1.8
alter VB0 = $&drive
let drive = (floor(trial / 2) - 2*floor(trial / 4))*1.8
alter VB1 = $&drive
let drive = (floor(trial / 4) - 2*floor(trial / 8))*1.8
alter VB2 = $&drive
let drive = (floor(trial / 8) - 2*floor(trial / 16))*1.8
alter VB3 = $&drive
let drive = (floor(trial / 16) - 2*floor(trial / 32))*1.8
alter VB4 = $&drive
let drive = (floor(trial / 32) - 2*floor(trial / 64))*1.8
alter VB5 = $&drive
let drive = (floor(trial / 64) - 2*floor(trial / 128))*1.8
alter VB6 = $&drive
let drive = (floor(trial / 128) - 2*floor(trial / 256))*1.8
alter VB7 = $&drive
stop when time = 0.000612
resume
delete all
let endpoint = length(time)-1
let cmp = v(COMP)[endpoint]
let top = v(TOP)[endpoint]
let decision = 0
if cmp >= 0.9
let code = trial
let decision = 1
end
echo 33 0 $&trial $&cmp $&top 0.14296875 $&decision >> decisions.csv
alter VIN = 0.14765625
alter VSAMPLE = 1.8
alter VB0 = 0
alter VB1 = 0
alter VB2 = 0
alter VB3 = 0
alter VB4 = 0
alter VB5 = 0
alter VB6 = 0
alter VB7 = 0
let code = 0
stop when time = 0.000614
resume
delete all
alter VSAMPLE = 0
let trial = code + 128
let drive = (floor(trial / 1) - 2*floor(trial / 2))*1.8
alter VB0 = $&drive
let drive = (floor(trial / 2) - 2*floor(trial / 4))*1.8
alter VB1 = $&drive
let drive = (floor(trial / 4) - 2*floor(trial / 8))*1.8
alter VB2 = $&drive
let drive = (floor(trial / 8) - 2*floor(trial / 16))*1.8
alter VB3 = $&drive
let drive = (floor(trial / 16) - 2*floor(trial / 32))*1.8
alter VB4 = $&drive
let drive = (floor(trial / 32) - 2*floor(trial / 64))*1.8
alter VB5 = $&drive
let drive = (floor(trial / 64) - 2*floor(trial / 128))*1.8
alter VB6 = $&drive
let drive = (floor(trial / 128) - 2*floor(trial / 256))*1.8
alter VB7 = $&drive
stop when time = 0.000616
resume
delete all
let endpoint = length(time)-1
let cmp = v(COMP)[endpoint]
let top = v(TOP)[endpoint]
let decision = 0
if cmp >= 0.9
let code = trial
let decision = 1
end
echo 34 7 $&trial $&cmp $&top 0.14765625 $&decision >> decisions.csv
let trial = code + 64
let drive = (floor(trial / 1) - 2*floor(trial / 2))*1.8
alter VB0 = $&drive
let drive = (floor(trial / 2) - 2*floor(trial / 4))*1.8
alter VB1 = $&drive
let drive = (floor(trial / 4) - 2*floor(trial / 8))*1.8
alter VB2 = $&drive
let drive = (floor(trial / 8) - 2*floor(trial / 16))*1.8
alter VB3 = $&drive
let drive = (floor(trial / 16) - 2*floor(trial / 32))*1.8
alter VB4 = $&drive
let drive = (floor(trial / 32) - 2*floor(trial / 64))*1.8
alter VB5 = $&drive
let drive = (floor(trial / 64) - 2*floor(trial / 128))*1.8
alter VB6 = $&drive
let drive = (floor(trial / 128) - 2*floor(trial / 256))*1.8
alter VB7 = $&drive
stop when time = 0.000618
resume
delete all
let endpoint = length(time)-1
let cmp = v(COMP)[endpoint]
let top = v(TOP)[endpoint]
let decision = 0
if cmp >= 0.9
let code = trial
let decision = 1
end
echo 34 6 $&trial $&cmp $&top 0.14765625 $&decision >> decisions.csv
let trial = code + 32
let drive = (floor(trial / 1) - 2*floor(trial / 2))*1.8
alter VB0 = $&drive
let drive = (floor(trial / 2) - 2*floor(trial / 4))*1.8
alter VB1 = $&drive
let drive = (floor(trial / 4) - 2*floor(trial / 8))*1.8
alter VB2 = $&drive
let drive = (floor(trial / 8) - 2*floor(trial / 16))*1.8
alter VB3 = $&drive
let drive = (floor(trial / 16) - 2*floor(trial / 32))*1.8
alter VB4 = $&drive
let drive = (floor(trial / 32) - 2*floor(trial / 64))*1.8
alter VB5 = $&drive
let drive = (floor(trial / 64) - 2*floor(trial / 128))*1.8
alter VB6 = $&drive
let drive = (floor(trial / 128) - 2*floor(trial / 256))*1.8
alter VB7 = $&drive
stop when time = 0.00062
resume
delete all
let endpoint = length(time)-1
let cmp = v(COMP)[endpoint]
let top = v(TOP)[endpoint]
let decision = 0
if cmp >= 0.9
let code = trial
let decision = 1
end
echo 34 5 $&trial $&cmp $&top 0.14765625 $&decision >> decisions.csv
let trial = code + 16
let drive = (floor(trial / 1) - 2*floor(trial / 2))*1.8
alter VB0 = $&drive
let drive = (floor(trial / 2) - 2*floor(trial / 4))*1.8
alter VB1 = $&drive
let drive = (floor(trial / 4) - 2*floor(trial / 8))*1.8
alter VB2 = $&drive
let drive = (floor(trial / 8) - 2*floor(trial / 16))*1.8
alter VB3 = $&drive
let drive = (floor(trial / 16) - 2*floor(trial / 32))*1.8
alter VB4 = $&drive
let drive = (floor(trial / 32) - 2*floor(trial / 64))*1.8
alter VB5 = $&drive
let drive = (floor(trial / 64) - 2*floor(trial / 128))*1.8
alter VB6 = $&drive
let drive = (floor(trial / 128) - 2*floor(trial / 256))*1.8
alter VB7 = $&drive
stop when time = 0.000622
resume
delete all
let endpoint = length(time)-1
let cmp = v(COMP)[endpoint]
let top = v(TOP)[endpoint]
let decision = 0
if cmp >= 0.9
let code = trial
let decision = 1
end
echo 34 4 $&trial $&cmp $&top 0.14765625 $&decision >> decisions.csv
let trial = code + 8
let drive = (floor(trial / 1) - 2*floor(trial / 2))*1.8
alter VB0 = $&drive
let drive = (floor(trial / 2) - 2*floor(trial / 4))*1.8
alter VB1 = $&drive
let drive = (floor(trial / 4) - 2*floor(trial / 8))*1.8
alter VB2 = $&drive
let drive = (floor(trial / 8) - 2*floor(trial / 16))*1.8
alter VB3 = $&drive
let drive = (floor(trial / 16) - 2*floor(trial / 32))*1.8
alter VB4 = $&drive
let drive = (floor(trial / 32) - 2*floor(trial / 64))*1.8
alter VB5 = $&drive
let drive = (floor(trial / 64) - 2*floor(trial / 128))*1.8
alter VB6 = $&drive
let drive = (floor(trial / 128) - 2*floor(trial / 256))*1.8
alter VB7 = $&drive
stop when time = 0.000624
resume
delete all
let endpoint = length(time)-1
let cmp = v(COMP)[endpoint]
let top = v(TOP)[endpoint]
let decision = 0
if cmp >= 0.9
let code = trial
let decision = 1
end
echo 34 3 $&trial $&cmp $&top 0.14765625 $&decision >> decisions.csv
let trial = code + 4
let drive = (floor(trial / 1) - 2*floor(trial / 2))*1.8
alter VB0 = $&drive
let drive = (floor(trial / 2) - 2*floor(trial / 4))*1.8
alter VB1 = $&drive
let drive = (floor(trial / 4) - 2*floor(trial / 8))*1.8
alter VB2 = $&drive
let drive = (floor(trial / 8) - 2*floor(trial / 16))*1.8
alter VB3 = $&drive
let drive = (floor(trial / 16) - 2*floor(trial / 32))*1.8
alter VB4 = $&drive
let drive = (floor(trial / 32) - 2*floor(trial / 64))*1.8
alter VB5 = $&drive
let drive = (floor(trial / 64) - 2*floor(trial / 128))*1.8
alter VB6 = $&drive
let drive = (floor(trial / 128) - 2*floor(trial / 256))*1.8
alter VB7 = $&drive
stop when time = 0.000626
resume
delete all
let endpoint = length(time)-1
let cmp = v(COMP)[endpoint]
let top = v(TOP)[endpoint]
let decision = 0
if cmp >= 0.9
let code = trial
let decision = 1
end
echo 34 2 $&trial $&cmp $&top 0.14765625 $&decision >> decisions.csv
let trial = code + 2
let drive = (floor(trial / 1) - 2*floor(trial / 2))*1.8
alter VB0 = $&drive
let drive = (floor(trial / 2) - 2*floor(trial / 4))*1.8
alter VB1 = $&drive
let drive = (floor(trial / 4) - 2*floor(trial / 8))*1.8
alter VB2 = $&drive
let drive = (floor(trial / 8) - 2*floor(trial / 16))*1.8
alter VB3 = $&drive
let drive = (floor(trial / 16) - 2*floor(trial / 32))*1.8
alter VB4 = $&drive
let drive = (floor(trial / 32) - 2*floor(trial / 64))*1.8
alter VB5 = $&drive
let drive = (floor(trial / 64) - 2*floor(trial / 128))*1.8
alter VB6 = $&drive
let drive = (floor(trial / 128) - 2*floor(trial / 256))*1.8
alter VB7 = $&drive
stop when time = 0.000628
resume
delete all
let endpoint = length(time)-1
let cmp = v(COMP)[endpoint]
let top = v(TOP)[endpoint]
let decision = 0
if cmp >= 0.9
let code = trial
let decision = 1
end
echo 34 1 $&trial $&cmp $&top 0.14765625 $&decision >> decisions.csv
let trial = code + 1
let drive = (floor(trial / 1) - 2*floor(trial / 2))*1.8
alter VB0 = $&drive
let drive = (floor(trial / 2) - 2*floor(trial / 4))*1.8
alter VB1 = $&drive
let drive = (floor(trial / 4) - 2*floor(trial / 8))*1.8
alter VB2 = $&drive
let drive = (floor(trial / 8) - 2*floor(trial / 16))*1.8
alter VB3 = $&drive
let drive = (floor(trial / 16) - 2*floor(trial / 32))*1.8
alter VB4 = $&drive
let drive = (floor(trial / 32) - 2*floor(trial / 64))*1.8
alter VB5 = $&drive
let drive = (floor(trial / 64) - 2*floor(trial / 128))*1.8
alter VB6 = $&drive
let drive = (floor(trial / 128) - 2*floor(trial / 256))*1.8
alter VB7 = $&drive
stop when time = 0.00063
resume
delete all
let endpoint = length(time)-1
let cmp = v(COMP)[endpoint]
let top = v(TOP)[endpoint]
let decision = 0
if cmp >= 0.9
let code = trial
let decision = 1
end
echo 34 0 $&trial $&cmp $&top 0.14765625 $&decision >> decisions.csv
alter VIN = 0.15234375
alter VSAMPLE = 1.8
alter VB0 = 0
alter VB1 = 0
alter VB2 = 0
alter VB3 = 0
alter VB4 = 0
alter VB5 = 0
alter VB6 = 0
alter VB7 = 0
let code = 0
stop when time = 0.000632
resume
delete all
alter VSAMPLE = 0
let trial = code + 128
let drive = (floor(trial / 1) - 2*floor(trial / 2))*1.8
alter VB0 = $&drive
let drive = (floor(trial / 2) - 2*floor(trial / 4))*1.8
alter VB1 = $&drive
let drive = (floor(trial / 4) - 2*floor(trial / 8))*1.8
alter VB2 = $&drive
let drive = (floor(trial / 8) - 2*floor(trial / 16))*1.8
alter VB3 = $&drive
let drive = (floor(trial / 16) - 2*floor(trial / 32))*1.8
alter VB4 = $&drive
let drive = (floor(trial / 32) - 2*floor(trial / 64))*1.8
alter VB5 = $&drive
let drive = (floor(trial / 64) - 2*floor(trial / 128))*1.8
alter VB6 = $&drive
let drive = (floor(trial / 128) - 2*floor(trial / 256))*1.8
alter VB7 = $&drive
stop when time = 0.000634
resume
delete all
let endpoint = length(time)-1
let cmp = v(COMP)[endpoint]
let top = v(TOP)[endpoint]
let decision = 0
if cmp >= 0.9
let code = trial
let decision = 1
end
echo 35 7 $&trial $&cmp $&top 0.15234375 $&decision >> decisions.csv
let trial = code + 64
let drive = (floor(trial / 1) - 2*floor(trial / 2))*1.8
alter VB0 = $&drive
let drive = (floor(trial / 2) - 2*floor(trial / 4))*1.8
alter VB1 = $&drive
let drive = (floor(trial / 4) - 2*floor(trial / 8))*1.8
alter VB2 = $&drive
let drive = (floor(trial / 8) - 2*floor(trial / 16))*1.8
alter VB3 = $&drive
let drive = (floor(trial / 16) - 2*floor(trial / 32))*1.8
alter VB4 = $&drive
let drive = (floor(trial / 32) - 2*floor(trial / 64))*1.8
alter VB5 = $&drive
let drive = (floor(trial / 64) - 2*floor(trial / 128))*1.8
alter VB6 = $&drive
let drive = (floor(trial / 128) - 2*floor(trial / 256))*1.8
alter VB7 = $&drive
stop when time = 0.000636
resume
delete all
let endpoint = length(time)-1
let cmp = v(COMP)[endpoint]
let top = v(TOP)[endpoint]
let decision = 0
if cmp >= 0.9
let code = trial
let decision = 1
end
echo 35 6 $&trial $&cmp $&top 0.15234375 $&decision >> decisions.csv
let trial = code + 32
let drive = (floor(trial / 1) - 2*floor(trial / 2))*1.8
alter VB0 = $&drive
let drive = (floor(trial / 2) - 2*floor(trial / 4))*1.8
alter VB1 = $&drive
let drive = (floor(trial / 4) - 2*floor(trial / 8))*1.8
alter VB2 = $&drive
let drive = (floor(trial / 8) - 2*floor(trial / 16))*1.8
alter VB3 = $&drive
let drive = (floor(trial / 16) - 2*floor(trial / 32))*1.8
alter VB4 = $&drive
let drive = (floor(trial / 32) - 2*floor(trial / 64))*1.8
alter VB5 = $&drive
let drive = (floor(trial / 64) - 2*floor(trial / 128))*1.8
alter VB6 = $&drive
let drive = (floor(trial / 128) - 2*floor(trial / 256))*1.8
alter VB7 = $&drive
stop when time = 0.000638
resume
delete all
let endpoint = length(time)-1
let cmp = v(COMP)[endpoint]
let top = v(TOP)[endpoint]
let decision = 0
if cmp >= 0.9
let code = trial
let decision = 1
end
echo 35 5 $&trial $&cmp $&top 0.15234375 $&decision >> decisions.csv
let trial = code + 16
let drive = (floor(trial / 1) - 2*floor(trial / 2))*1.8
alter VB0 = $&drive
let drive = (floor(trial / 2) - 2*floor(trial / 4))*1.8
alter VB1 = $&drive
let drive = (floor(trial / 4) - 2*floor(trial / 8))*1.8
alter VB2 = $&drive
let drive = (floor(trial / 8) - 2*floor(trial / 16))*1.8
alter VB3 = $&drive
let drive = (floor(trial / 16) - 2*floor(trial / 32))*1.8
alter VB4 = $&drive
let drive = (floor(trial / 32) - 2*floor(trial / 64))*1.8
alter VB5 = $&drive
let drive = (floor(trial / 64) - 2*floor(trial / 128))*1.8
alter VB6 = $&drive
let drive = (floor(trial / 128) - 2*floor(trial / 256))*1.8
alter VB7 = $&drive
stop when time = 0.00064
resume
delete all
let endpoint = length(time)-1
let cmp = v(COMP)[endpoint]
let top = v(TOP)[endpoint]
let decision = 0
if cmp >= 0.9
let code = trial
let decision = 1
end
echo 35 4 $&trial $&cmp $&top 0.15234375 $&decision >> decisions.csv
let trial = code + 8
let drive = (floor(trial / 1) - 2*floor(trial / 2))*1.8
alter VB0 = $&drive
let drive = (floor(trial / 2) - 2*floor(trial / 4))*1.8
alter VB1 = $&drive
let drive = (floor(trial / 4) - 2*floor(trial / 8))*1.8
alter VB2 = $&drive
let drive = (floor(trial / 8) - 2*floor(trial / 16))*1.8
alter VB3 = $&drive
let drive = (floor(trial / 16) - 2*floor(trial / 32))*1.8
alter VB4 = $&drive
let drive = (floor(trial / 32) - 2*floor(trial / 64))*1.8
alter VB5 = $&drive
let drive = (floor(trial / 64) - 2*floor(trial / 128))*1.8
alter VB6 = $&drive
let drive = (floor(trial / 128) - 2*floor(trial / 256))*1.8
alter VB7 = $&drive
stop when time = 0.000642
resume
delete all
let endpoint = length(time)-1
let cmp = v(COMP)[endpoint]
let top = v(TOP)[endpoint]
let decision = 0
if cmp >= 0.9
let code = trial
let decision = 1
end
echo 35 3 $&trial $&cmp $&top 0.15234375 $&decision >> decisions.csv
let trial = code + 4
let drive = (floor(trial / 1) - 2*floor(trial / 2))*1.8
alter VB0 = $&drive
let drive = (floor(trial / 2) - 2*floor(trial / 4))*1.8
alter VB1 = $&drive
let drive = (floor(trial / 4) - 2*floor(trial / 8))*1.8
alter VB2 = $&drive
let drive = (floor(trial / 8) - 2*floor(trial / 16))*1.8
alter VB3 = $&drive
let drive = (floor(trial / 16) - 2*floor(trial / 32))*1.8
alter VB4 = $&drive
let drive = (floor(trial / 32) - 2*floor(trial / 64))*1.8
alter VB5 = $&drive
let drive = (floor(trial / 64) - 2*floor(trial / 128))*1.8
alter VB6 = $&drive
let drive = (floor(trial / 128) - 2*floor(trial / 256))*1.8
alter VB7 = $&drive
stop when time = 0.000644
resume
delete all
let endpoint = length(time)-1
let cmp = v(COMP)[endpoint]
let top = v(TOP)[endpoint]
let decision = 0
if cmp >= 0.9
let code = trial
let decision = 1
end
echo 35 2 $&trial $&cmp $&top 0.15234375 $&decision >> decisions.csv
let trial = code + 2
let drive = (floor(trial / 1) - 2*floor(trial / 2))*1.8
alter VB0 = $&drive
let drive = (floor(trial / 2) - 2*floor(trial / 4))*1.8
alter VB1 = $&drive
let drive = (floor(trial / 4) - 2*floor(trial / 8))*1.8
alter VB2 = $&drive
let drive = (floor(trial / 8) - 2*floor(trial / 16))*1.8
alter VB3 = $&drive
let drive = (floor(trial / 16) - 2*floor(trial / 32))*1.8
alter VB4 = $&drive
let drive = (floor(trial / 32) - 2*floor(trial / 64))*1.8
alter VB5 = $&drive
let drive = (floor(trial / 64) - 2*floor(trial / 128))*1.8
alter VB6 = $&drive
let drive = (floor(trial / 128) - 2*floor(trial / 256))*1.8
alter VB7 = $&drive
stop when time = 0.000646
resume
delete all
let endpoint = length(time)-1
let cmp = v(COMP)[endpoint]
let top = v(TOP)[endpoint]
let decision = 0
if cmp >= 0.9
let code = trial
let decision = 1
end
echo 35 1 $&trial $&cmp $&top 0.15234375 $&decision >> decisions.csv
let trial = code + 1
let drive = (floor(trial / 1) - 2*floor(trial / 2))*1.8
alter VB0 = $&drive
let drive = (floor(trial / 2) - 2*floor(trial / 4))*1.8
alter VB1 = $&drive
let drive = (floor(trial / 4) - 2*floor(trial / 8))*1.8
alter VB2 = $&drive
let drive = (floor(trial / 8) - 2*floor(trial / 16))*1.8
alter VB3 = $&drive
let drive = (floor(trial / 16) - 2*floor(trial / 32))*1.8
alter VB4 = $&drive
let drive = (floor(trial / 32) - 2*floor(trial / 64))*1.8
alter VB5 = $&drive
let drive = (floor(trial / 64) - 2*floor(trial / 128))*1.8
alter VB6 = $&drive
let drive = (floor(trial / 128) - 2*floor(trial / 256))*1.8
alter VB7 = $&drive
stop when time = 0.000648
resume
delete all
let endpoint = length(time)-1
let cmp = v(COMP)[endpoint]
let top = v(TOP)[endpoint]
let decision = 0
if cmp >= 0.9
let code = trial
let decision = 1
end
echo 35 0 $&trial $&cmp $&top 0.15234375 $&decision >> decisions.csv
alter VIN = 0.15703125
alter VSAMPLE = 1.8
alter VB0 = 0
alter VB1 = 0
alter VB2 = 0
alter VB3 = 0
alter VB4 = 0
alter VB5 = 0
alter VB6 = 0
alter VB7 = 0
let code = 0
stop when time = 0.00065
resume
delete all
alter VSAMPLE = 0
let trial = code + 128
let drive = (floor(trial / 1) - 2*floor(trial / 2))*1.8
alter VB0 = $&drive
let drive = (floor(trial / 2) - 2*floor(trial / 4))*1.8
alter VB1 = $&drive
let drive = (floor(trial / 4) - 2*floor(trial / 8))*1.8
alter VB2 = $&drive
let drive = (floor(trial / 8) - 2*floor(trial / 16))*1.8
alter VB3 = $&drive
let drive = (floor(trial / 16) - 2*floor(trial / 32))*1.8
alter VB4 = $&drive
let drive = (floor(trial / 32) - 2*floor(trial / 64))*1.8
alter VB5 = $&drive
let drive = (floor(trial / 64) - 2*floor(trial / 128))*1.8
alter VB6 = $&drive
let drive = (floor(trial / 128) - 2*floor(trial / 256))*1.8
alter VB7 = $&drive
stop when time = 0.000652
resume
delete all
let endpoint = length(time)-1
let cmp = v(COMP)[endpoint]
let top = v(TOP)[endpoint]
let decision = 0
if cmp >= 0.9
let code = trial
let decision = 1
end
echo 36 7 $&trial $&cmp $&top 0.15703125 $&decision >> decisions.csv
let trial = code + 64
let drive = (floor(trial / 1) - 2*floor(trial / 2))*1.8
alter VB0 = $&drive
let drive = (floor(trial / 2) - 2*floor(trial / 4))*1.8
alter VB1 = $&drive
let drive = (floor(trial / 4) - 2*floor(trial / 8))*1.8
alter VB2 = $&drive
let drive = (floor(trial / 8) - 2*floor(trial / 16))*1.8
alter VB3 = $&drive
let drive = (floor(trial / 16) - 2*floor(trial / 32))*1.8
alter VB4 = $&drive
let drive = (floor(trial / 32) - 2*floor(trial / 64))*1.8
alter VB5 = $&drive
let drive = (floor(trial / 64) - 2*floor(trial / 128))*1.8
alter VB6 = $&drive
let drive = (floor(trial / 128) - 2*floor(trial / 256))*1.8
alter VB7 = $&drive
stop when time = 0.000654
resume
delete all
let endpoint = length(time)-1
let cmp = v(COMP)[endpoint]
let top = v(TOP)[endpoint]
let decision = 0
if cmp >= 0.9
let code = trial
let decision = 1
end
echo 36 6 $&trial $&cmp $&top 0.15703125 $&decision >> decisions.csv
let trial = code + 32
let drive = (floor(trial / 1) - 2*floor(trial / 2))*1.8
alter VB0 = $&drive
let drive = (floor(trial / 2) - 2*floor(trial / 4))*1.8
alter VB1 = $&drive
let drive = (floor(trial / 4) - 2*floor(trial / 8))*1.8
alter VB2 = $&drive
let drive = (floor(trial / 8) - 2*floor(trial / 16))*1.8
alter VB3 = $&drive
let drive = (floor(trial / 16) - 2*floor(trial / 32))*1.8
alter VB4 = $&drive
let drive = (floor(trial / 32) - 2*floor(trial / 64))*1.8
alter VB5 = $&drive
let drive = (floor(trial / 64) - 2*floor(trial / 128))*1.8
alter VB6 = $&drive
let drive = (floor(trial / 128) - 2*floor(trial / 256))*1.8
alter VB7 = $&drive
stop when time = 0.000656
resume
delete all
let endpoint = length(time)-1
let cmp = v(COMP)[endpoint]
let top = v(TOP)[endpoint]
let decision = 0
if cmp >= 0.9
let code = trial
let decision = 1
end
echo 36 5 $&trial $&cmp $&top 0.15703125 $&decision >> decisions.csv
let trial = code + 16
let drive = (floor(trial / 1) - 2*floor(trial / 2))*1.8
alter VB0 = $&drive
let drive = (floor(trial / 2) - 2*floor(trial / 4))*1.8
alter VB1 = $&drive
let drive = (floor(trial / 4) - 2*floor(trial / 8))*1.8
alter VB2 = $&drive
let drive = (floor(trial / 8) - 2*floor(trial / 16))*1.8
alter VB3 = $&drive
let drive = (floor(trial / 16) - 2*floor(trial / 32))*1.8
alter VB4 = $&drive
let drive = (floor(trial / 32) - 2*floor(trial / 64))*1.8
alter VB5 = $&drive
let drive = (floor(trial / 64) - 2*floor(trial / 128))*1.8
alter VB6 = $&drive
let drive = (floor(trial / 128) - 2*floor(trial / 256))*1.8
alter VB7 = $&drive
stop when time = 0.000658
resume
delete all
let endpoint = length(time)-1
let cmp = v(COMP)[endpoint]
let top = v(TOP)[endpoint]
let decision = 0
if cmp >= 0.9
let code = trial
let decision = 1
end
echo 36 4 $&trial $&cmp $&top 0.15703125 $&decision >> decisions.csv
let trial = code + 8
let drive = (floor(trial / 1) - 2*floor(trial / 2))*1.8
alter VB0 = $&drive
let drive = (floor(trial / 2) - 2*floor(trial / 4))*1.8
alter VB1 = $&drive
let drive = (floor(trial / 4) - 2*floor(trial / 8))*1.8
alter VB2 = $&drive
let drive = (floor(trial / 8) - 2*floor(trial / 16))*1.8
alter VB3 = $&drive
let drive = (floor(trial / 16) - 2*floor(trial / 32))*1.8
alter VB4 = $&drive
let drive = (floor(trial / 32) - 2*floor(trial / 64))*1.8
alter VB5 = $&drive
let drive = (floor(trial / 64) - 2*floor(trial / 128))*1.8
alter VB6 = $&drive
let drive = (floor(trial / 128) - 2*floor(trial / 256))*1.8
alter VB7 = $&drive
stop when time = 0.00066
resume
delete all
let endpoint = length(time)-1
let cmp = v(COMP)[endpoint]
let top = v(TOP)[endpoint]
let decision = 0
if cmp >= 0.9
let code = trial
let decision = 1
end
echo 36 3 $&trial $&cmp $&top 0.15703125 $&decision >> decisions.csv
let trial = code + 4
let drive = (floor(trial / 1) - 2*floor(trial / 2))*1.8
alter VB0 = $&drive
let drive = (floor(trial / 2) - 2*floor(trial / 4))*1.8
alter VB1 = $&drive
let drive = (floor(trial / 4) - 2*floor(trial / 8))*1.8
alter VB2 = $&drive
let drive = (floor(trial / 8) - 2*floor(trial / 16))*1.8
alter VB3 = $&drive
let drive = (floor(trial / 16) - 2*floor(trial / 32))*1.8
alter VB4 = $&drive
let drive = (floor(trial / 32) - 2*floor(trial / 64))*1.8
alter VB5 = $&drive
let drive = (floor(trial / 64) - 2*floor(trial / 128))*1.8
alter VB6 = $&drive
let drive = (floor(trial / 128) - 2*floor(trial / 256))*1.8
alter VB7 = $&drive
stop when time = 0.000662
resume
delete all
let endpoint = length(time)-1
let cmp = v(COMP)[endpoint]
let top = v(TOP)[endpoint]
let decision = 0
if cmp >= 0.9
let code = trial
let decision = 1
end
echo 36 2 $&trial $&cmp $&top 0.15703125 $&decision >> decisions.csv
let trial = code + 2
let drive = (floor(trial / 1) - 2*floor(trial / 2))*1.8
alter VB0 = $&drive
let drive = (floor(trial / 2) - 2*floor(trial / 4))*1.8
alter VB1 = $&drive
let drive = (floor(trial / 4) - 2*floor(trial / 8))*1.8
alter VB2 = $&drive
let drive = (floor(trial / 8) - 2*floor(trial / 16))*1.8
alter VB3 = $&drive
let drive = (floor(trial / 16) - 2*floor(trial / 32))*1.8
alter VB4 = $&drive
let drive = (floor(trial / 32) - 2*floor(trial / 64))*1.8
alter VB5 = $&drive
let drive = (floor(trial / 64) - 2*floor(trial / 128))*1.8
alter VB6 = $&drive
let drive = (floor(trial / 128) - 2*floor(trial / 256))*1.8
alter VB7 = $&drive
stop when time = 0.000664
resume
delete all
let endpoint = length(time)-1
let cmp = v(COMP)[endpoint]
let top = v(TOP)[endpoint]
let decision = 0
if cmp >= 0.9
let code = trial
let decision = 1
end
echo 36 1 $&trial $&cmp $&top 0.15703125 $&decision >> decisions.csv
let trial = code + 1
let drive = (floor(trial / 1) - 2*floor(trial / 2))*1.8
alter VB0 = $&drive
let drive = (floor(trial / 2) - 2*floor(trial / 4))*1.8
alter VB1 = $&drive
let drive = (floor(trial / 4) - 2*floor(trial / 8))*1.8
alter VB2 = $&drive
let drive = (floor(trial / 8) - 2*floor(trial / 16))*1.8
alter VB3 = $&drive
let drive = (floor(trial / 16) - 2*floor(trial / 32))*1.8
alter VB4 = $&drive
let drive = (floor(trial / 32) - 2*floor(trial / 64))*1.8
alter VB5 = $&drive
let drive = (floor(trial / 64) - 2*floor(trial / 128))*1.8
alter VB6 = $&drive
let drive = (floor(trial / 128) - 2*floor(trial / 256))*1.8
alter VB7 = $&drive
stop when time = 0.000666
resume
delete all
let endpoint = length(time)-1
let cmp = v(COMP)[endpoint]
let top = v(TOP)[endpoint]
let decision = 0
if cmp >= 0.9
let code = trial
let decision = 1
end
echo 36 0 $&trial $&cmp $&top 0.15703125 $&decision >> decisions.csv
alter VIN = 0.16171875
alter VSAMPLE = 1.8
alter VB0 = 0
alter VB1 = 0
alter VB2 = 0
alter VB3 = 0
alter VB4 = 0
alter VB5 = 0
alter VB6 = 0
alter VB7 = 0
let code = 0
stop when time = 0.000668
resume
delete all
alter VSAMPLE = 0
let trial = code + 128
let drive = (floor(trial / 1) - 2*floor(trial / 2))*1.8
alter VB0 = $&drive
let drive = (floor(trial / 2) - 2*floor(trial / 4))*1.8
alter VB1 = $&drive
let drive = (floor(trial / 4) - 2*floor(trial / 8))*1.8
alter VB2 = $&drive
let drive = (floor(trial / 8) - 2*floor(trial / 16))*1.8
alter VB3 = $&drive
let drive = (floor(trial / 16) - 2*floor(trial / 32))*1.8
alter VB4 = $&drive
let drive = (floor(trial / 32) - 2*floor(trial / 64))*1.8
alter VB5 = $&drive
let drive = (floor(trial / 64) - 2*floor(trial / 128))*1.8
alter VB6 = $&drive
let drive = (floor(trial / 128) - 2*floor(trial / 256))*1.8
alter VB7 = $&drive
stop when time = 0.00067
resume
delete all
let endpoint = length(time)-1
let cmp = v(COMP)[endpoint]
let top = v(TOP)[endpoint]
let decision = 0
if cmp >= 0.9
let code = trial
let decision = 1
end
echo 37 7 $&trial $&cmp $&top 0.16171875 $&decision >> decisions.csv
let trial = code + 64
let drive = (floor(trial / 1) - 2*floor(trial / 2))*1.8
alter VB0 = $&drive
let drive = (floor(trial / 2) - 2*floor(trial / 4))*1.8
alter VB1 = $&drive
let drive = (floor(trial / 4) - 2*floor(trial / 8))*1.8
alter VB2 = $&drive
let drive = (floor(trial / 8) - 2*floor(trial / 16))*1.8
alter VB3 = $&drive
let drive = (floor(trial / 16) - 2*floor(trial / 32))*1.8
alter VB4 = $&drive
let drive = (floor(trial / 32) - 2*floor(trial / 64))*1.8
alter VB5 = $&drive
let drive = (floor(trial / 64) - 2*floor(trial / 128))*1.8
alter VB6 = $&drive
let drive = (floor(trial / 128) - 2*floor(trial / 256))*1.8
alter VB7 = $&drive
stop when time = 0.000672
resume
delete all
let endpoint = length(time)-1
let cmp = v(COMP)[endpoint]
let top = v(TOP)[endpoint]
let decision = 0
if cmp >= 0.9
let code = trial
let decision = 1
end
echo 37 6 $&trial $&cmp $&top 0.16171875 $&decision >> decisions.csv
let trial = code + 32
let drive = (floor(trial / 1) - 2*floor(trial / 2))*1.8
alter VB0 = $&drive
let drive = (floor(trial / 2) - 2*floor(trial / 4))*1.8
alter VB1 = $&drive
let drive = (floor(trial / 4) - 2*floor(trial / 8))*1.8
alter VB2 = $&drive
let drive = (floor(trial / 8) - 2*floor(trial / 16))*1.8
alter VB3 = $&drive
let drive = (floor(trial / 16) - 2*floor(trial / 32))*1.8
alter VB4 = $&drive
let drive = (floor(trial / 32) - 2*floor(trial / 64))*1.8
alter VB5 = $&drive
let drive = (floor(trial / 64) - 2*floor(trial / 128))*1.8
alter VB6 = $&drive
let drive = (floor(trial / 128) - 2*floor(trial / 256))*1.8
alter VB7 = $&drive
stop when time = 0.000674
resume
delete all
let endpoint = length(time)-1
let cmp = v(COMP)[endpoint]
let top = v(TOP)[endpoint]
let decision = 0
if cmp >= 0.9
let code = trial
let decision = 1
end
echo 37 5 $&trial $&cmp $&top 0.16171875 $&decision >> decisions.csv
let trial = code + 16
let drive = (floor(trial / 1) - 2*floor(trial / 2))*1.8
alter VB0 = $&drive
let drive = (floor(trial / 2) - 2*floor(trial / 4))*1.8
alter VB1 = $&drive
let drive = (floor(trial / 4) - 2*floor(trial / 8))*1.8
alter VB2 = $&drive
let drive = (floor(trial / 8) - 2*floor(trial / 16))*1.8
alter VB3 = $&drive
let drive = (floor(trial / 16) - 2*floor(trial / 32))*1.8
alter VB4 = $&drive
let drive = (floor(trial / 32) - 2*floor(trial / 64))*1.8
alter VB5 = $&drive
let drive = (floor(trial / 64) - 2*floor(trial / 128))*1.8
alter VB6 = $&drive
let drive = (floor(trial / 128) - 2*floor(trial / 256))*1.8
alter VB7 = $&drive
stop when time = 0.000676
resume
delete all
let endpoint = length(time)-1
let cmp = v(COMP)[endpoint]
let top = v(TOP)[endpoint]
let decision = 0
if cmp >= 0.9
let code = trial
let decision = 1
end
echo 37 4 $&trial $&cmp $&top 0.16171875 $&decision >> decisions.csv
let trial = code + 8
let drive = (floor(trial / 1) - 2*floor(trial / 2))*1.8
alter VB0 = $&drive
let drive = (floor(trial / 2) - 2*floor(trial / 4))*1.8
alter VB1 = $&drive
let drive = (floor(trial / 4) - 2*floor(trial / 8))*1.8
alter VB2 = $&drive
let drive = (floor(trial / 8) - 2*floor(trial / 16))*1.8
alter VB3 = $&drive
let drive = (floor(trial / 16) - 2*floor(trial / 32))*1.8
alter VB4 = $&drive
let drive = (floor(trial / 32) - 2*floor(trial / 64))*1.8
alter VB5 = $&drive
let drive = (floor(trial / 64) - 2*floor(trial / 128))*1.8
alter VB6 = $&drive
let drive = (floor(trial / 128) - 2*floor(trial / 256))*1.8
alter VB7 = $&drive
stop when time = 0.000678
resume
delete all
let endpoint = length(time)-1
let cmp = v(COMP)[endpoint]
let top = v(TOP)[endpoint]
let decision = 0
if cmp >= 0.9
let code = trial
let decision = 1
end
echo 37 3 $&trial $&cmp $&top 0.16171875 $&decision >> decisions.csv
let trial = code + 4
let drive = (floor(trial / 1) - 2*floor(trial / 2))*1.8
alter VB0 = $&drive
let drive = (floor(trial / 2) - 2*floor(trial / 4))*1.8
alter VB1 = $&drive
let drive = (floor(trial / 4) - 2*floor(trial / 8))*1.8
alter VB2 = $&drive
let drive = (floor(trial / 8) - 2*floor(trial / 16))*1.8
alter VB3 = $&drive
let drive = (floor(trial / 16) - 2*floor(trial / 32))*1.8
alter VB4 = $&drive
let drive = (floor(trial / 32) - 2*floor(trial / 64))*1.8
alter VB5 = $&drive
let drive = (floor(trial / 64) - 2*floor(trial / 128))*1.8
alter VB6 = $&drive
let drive = (floor(trial / 128) - 2*floor(trial / 256))*1.8
alter VB7 = $&drive
stop when time = 0.00068
resume
delete all
let endpoint = length(time)-1
let cmp = v(COMP)[endpoint]
let top = v(TOP)[endpoint]
let decision = 0
if cmp >= 0.9
let code = trial
let decision = 1
end
echo 37 2 $&trial $&cmp $&top 0.16171875 $&decision >> decisions.csv
let trial = code + 2
let drive = (floor(trial / 1) - 2*floor(trial / 2))*1.8
alter VB0 = $&drive
let drive = (floor(trial / 2) - 2*floor(trial / 4))*1.8
alter VB1 = $&drive
let drive = (floor(trial / 4) - 2*floor(trial / 8))*1.8
alter VB2 = $&drive
let drive = (floor(trial / 8) - 2*floor(trial / 16))*1.8
alter VB3 = $&drive
let drive = (floor(trial / 16) - 2*floor(trial / 32))*1.8
alter VB4 = $&drive
let drive = (floor(trial / 32) - 2*floor(trial / 64))*1.8
alter VB5 = $&drive
let drive = (floor(trial / 64) - 2*floor(trial / 128))*1.8
alter VB6 = $&drive
let drive = (floor(trial / 128) - 2*floor(trial / 256))*1.8
alter VB7 = $&drive
stop when time = 0.000682
resume
delete all
let endpoint = length(time)-1
let cmp = v(COMP)[endpoint]
let top = v(TOP)[endpoint]
let decision = 0
if cmp >= 0.9
let code = trial
let decision = 1
end
echo 37 1 $&trial $&cmp $&top 0.16171875 $&decision >> decisions.csv
let trial = code + 1
let drive = (floor(trial / 1) - 2*floor(trial / 2))*1.8
alter VB0 = $&drive
let drive = (floor(trial / 2) - 2*floor(trial / 4))*1.8
alter VB1 = $&drive
let drive = (floor(trial / 4) - 2*floor(trial / 8))*1.8
alter VB2 = $&drive
let drive = (floor(trial / 8) - 2*floor(trial / 16))*1.8
alter VB3 = $&drive
let drive = (floor(trial / 16) - 2*floor(trial / 32))*1.8
alter VB4 = $&drive
let drive = (floor(trial / 32) - 2*floor(trial / 64))*1.8
alter VB5 = $&drive
let drive = (floor(trial / 64) - 2*floor(trial / 128))*1.8
alter VB6 = $&drive
let drive = (floor(trial / 128) - 2*floor(trial / 256))*1.8
alter VB7 = $&drive
stop when time = 0.000684
resume
delete all
let endpoint = length(time)-1
let cmp = v(COMP)[endpoint]
let top = v(TOP)[endpoint]
let decision = 0
if cmp >= 0.9
let code = trial
let decision = 1
end
echo 37 0 $&trial $&cmp $&top 0.16171875 $&decision >> decisions.csv
alter VIN = 0.16640625
alter VSAMPLE = 1.8
alter VB0 = 0
alter VB1 = 0
alter VB2 = 0
alter VB3 = 0
alter VB4 = 0
alter VB5 = 0
alter VB6 = 0
alter VB7 = 0
let code = 0
stop when time = 0.000686
resume
delete all
alter VSAMPLE = 0
let trial = code + 128
let drive = (floor(trial / 1) - 2*floor(trial / 2))*1.8
alter VB0 = $&drive
let drive = (floor(trial / 2) - 2*floor(trial / 4))*1.8
alter VB1 = $&drive
let drive = (floor(trial / 4) - 2*floor(trial / 8))*1.8
alter VB2 = $&drive
let drive = (floor(trial / 8) - 2*floor(trial / 16))*1.8
alter VB3 = $&drive
let drive = (floor(trial / 16) - 2*floor(trial / 32))*1.8
alter VB4 = $&drive
let drive = (floor(trial / 32) - 2*floor(trial / 64))*1.8
alter VB5 = $&drive
let drive = (floor(trial / 64) - 2*floor(trial / 128))*1.8
alter VB6 = $&drive
let drive = (floor(trial / 128) - 2*floor(trial / 256))*1.8
alter VB7 = $&drive
stop when time = 0.000688
resume
delete all
let endpoint = length(time)-1
let cmp = v(COMP)[endpoint]
let top = v(TOP)[endpoint]
let decision = 0
if cmp >= 0.9
let code = trial
let decision = 1
end
echo 38 7 $&trial $&cmp $&top 0.16640625 $&decision >> decisions.csv
let trial = code + 64
let drive = (floor(trial / 1) - 2*floor(trial / 2))*1.8
alter VB0 = $&drive
let drive = (floor(trial / 2) - 2*floor(trial / 4))*1.8
alter VB1 = $&drive
let drive = (floor(trial / 4) - 2*floor(trial / 8))*1.8
alter VB2 = $&drive
let drive = (floor(trial / 8) - 2*floor(trial / 16))*1.8
alter VB3 = $&drive
let drive = (floor(trial / 16) - 2*floor(trial / 32))*1.8
alter VB4 = $&drive
let drive = (floor(trial / 32) - 2*floor(trial / 64))*1.8
alter VB5 = $&drive
let drive = (floor(trial / 64) - 2*floor(trial / 128))*1.8
alter VB6 = $&drive
let drive = (floor(trial / 128) - 2*floor(trial / 256))*1.8
alter VB7 = $&drive
stop when time = 0.00069
resume
delete all
let endpoint = length(time)-1
let cmp = v(COMP)[endpoint]
let top = v(TOP)[endpoint]
let decision = 0
if cmp >= 0.9
let code = trial
let decision = 1
end
echo 38 6 $&trial $&cmp $&top 0.16640625 $&decision >> decisions.csv
let trial = code + 32
let drive = (floor(trial / 1) - 2*floor(trial / 2))*1.8
alter VB0 = $&drive
let drive = (floor(trial / 2) - 2*floor(trial / 4))*1.8
alter VB1 = $&drive
let drive = (floor(trial / 4) - 2*floor(trial / 8))*1.8
alter VB2 = $&drive
let drive = (floor(trial / 8) - 2*floor(trial / 16))*1.8
alter VB3 = $&drive
let drive = (floor(trial / 16) - 2*floor(trial / 32))*1.8
alter VB4 = $&drive
let drive = (floor(trial / 32) - 2*floor(trial / 64))*1.8
alter VB5 = $&drive
let drive = (floor(trial / 64) - 2*floor(trial / 128))*1.8
alter VB6 = $&drive
let drive = (floor(trial / 128) - 2*floor(trial / 256))*1.8
alter VB7 = $&drive
stop when time = 0.000692
resume
delete all
let endpoint = length(time)-1
let cmp = v(COMP)[endpoint]
let top = v(TOP)[endpoint]
let decision = 0
if cmp >= 0.9
let code = trial
let decision = 1
end
echo 38 5 $&trial $&cmp $&top 0.16640625 $&decision >> decisions.csv
let trial = code + 16
let drive = (floor(trial / 1) - 2*floor(trial / 2))*1.8
alter VB0 = $&drive
let drive = (floor(trial / 2) - 2*floor(trial / 4))*1.8
alter VB1 = $&drive
let drive = (floor(trial / 4) - 2*floor(trial / 8))*1.8
alter VB2 = $&drive
let drive = (floor(trial / 8) - 2*floor(trial / 16))*1.8
alter VB3 = $&drive
let drive = (floor(trial / 16) - 2*floor(trial / 32))*1.8
alter VB4 = $&drive
let drive = (floor(trial / 32) - 2*floor(trial / 64))*1.8
alter VB5 = $&drive
let drive = (floor(trial / 64) - 2*floor(trial / 128))*1.8
alter VB6 = $&drive
let drive = (floor(trial / 128) - 2*floor(trial / 256))*1.8
alter VB7 = $&drive
stop when time = 0.000694
resume
delete all
let endpoint = length(time)-1
let cmp = v(COMP)[endpoint]
let top = v(TOP)[endpoint]
let decision = 0
if cmp >= 0.9
let code = trial
let decision = 1
end
echo 38 4 $&trial $&cmp $&top 0.16640625 $&decision >> decisions.csv
let trial = code + 8
let drive = (floor(trial / 1) - 2*floor(trial / 2))*1.8
alter VB0 = $&drive
let drive = (floor(trial / 2) - 2*floor(trial / 4))*1.8
alter VB1 = $&drive
let drive = (floor(trial / 4) - 2*floor(trial / 8))*1.8
alter VB2 = $&drive
let drive = (floor(trial / 8) - 2*floor(trial / 16))*1.8
alter VB3 = $&drive
let drive = (floor(trial / 16) - 2*floor(trial / 32))*1.8
alter VB4 = $&drive
let drive = (floor(trial / 32) - 2*floor(trial / 64))*1.8
alter VB5 = $&drive
let drive = (floor(trial / 64) - 2*floor(trial / 128))*1.8
alter VB6 = $&drive
let drive = (floor(trial / 128) - 2*floor(trial / 256))*1.8
alter VB7 = $&drive
stop when time = 0.000696
resume
delete all
let endpoint = length(time)-1
let cmp = v(COMP)[endpoint]
let top = v(TOP)[endpoint]
let decision = 0
if cmp >= 0.9
let code = trial
let decision = 1
end
echo 38 3 $&trial $&cmp $&top 0.16640625 $&decision >> decisions.csv
let trial = code + 4
let drive = (floor(trial / 1) - 2*floor(trial / 2))*1.8
alter VB0 = $&drive
let drive = (floor(trial / 2) - 2*floor(trial / 4))*1.8
alter VB1 = $&drive
let drive = (floor(trial / 4) - 2*floor(trial / 8))*1.8
alter VB2 = $&drive
let drive = (floor(trial / 8) - 2*floor(trial / 16))*1.8
alter VB3 = $&drive
let drive = (floor(trial / 16) - 2*floor(trial / 32))*1.8
alter VB4 = $&drive
let drive = (floor(trial / 32) - 2*floor(trial / 64))*1.8
alter VB5 = $&drive
let drive = (floor(trial / 64) - 2*floor(trial / 128))*1.8
alter VB6 = $&drive
let drive = (floor(trial / 128) - 2*floor(trial / 256))*1.8
alter VB7 = $&drive
stop when time = 0.000698
resume
delete all
let endpoint = length(time)-1
let cmp = v(COMP)[endpoint]
let top = v(TOP)[endpoint]
let decision = 0
if cmp >= 0.9
let code = trial
let decision = 1
end
echo 38 2 $&trial $&cmp $&top 0.16640625 $&decision >> decisions.csv
let trial = code + 2
let drive = (floor(trial / 1) - 2*floor(trial / 2))*1.8
alter VB0 = $&drive
let drive = (floor(trial / 2) - 2*floor(trial / 4))*1.8
alter VB1 = $&drive
let drive = (floor(trial / 4) - 2*floor(trial / 8))*1.8
alter VB2 = $&drive
let drive = (floor(trial / 8) - 2*floor(trial / 16))*1.8
alter VB3 = $&drive
let drive = (floor(trial / 16) - 2*floor(trial / 32))*1.8
alter VB4 = $&drive
let drive = (floor(trial / 32) - 2*floor(trial / 64))*1.8
alter VB5 = $&drive
let drive = (floor(trial / 64) - 2*floor(trial / 128))*1.8
alter VB6 = $&drive
let drive = (floor(trial / 128) - 2*floor(trial / 256))*1.8
alter VB7 = $&drive
stop when time = 0.0007
resume
delete all
let endpoint = length(time)-1
let cmp = v(COMP)[endpoint]
let top = v(TOP)[endpoint]
let decision = 0
if cmp >= 0.9
let code = trial
let decision = 1
end
echo 38 1 $&trial $&cmp $&top 0.16640625 $&decision >> decisions.csv
let trial = code + 1
let drive = (floor(trial / 1) - 2*floor(trial / 2))*1.8
alter VB0 = $&drive
let drive = (floor(trial / 2) - 2*floor(trial / 4))*1.8
alter VB1 = $&drive
let drive = (floor(trial / 4) - 2*floor(trial / 8))*1.8
alter VB2 = $&drive
let drive = (floor(trial / 8) - 2*floor(trial / 16))*1.8
alter VB3 = $&drive
let drive = (floor(trial / 16) - 2*floor(trial / 32))*1.8
alter VB4 = $&drive
let drive = (floor(trial / 32) - 2*floor(trial / 64))*1.8
alter VB5 = $&drive
let drive = (floor(trial / 64) - 2*floor(trial / 128))*1.8
alter VB6 = $&drive
let drive = (floor(trial / 128) - 2*floor(trial / 256))*1.8
alter VB7 = $&drive
stop when time = 0.000702
resume
delete all
let endpoint = length(time)-1
let cmp = v(COMP)[endpoint]
let top = v(TOP)[endpoint]
let decision = 0
if cmp >= 0.9
let code = trial
let decision = 1
end
echo 38 0 $&trial $&cmp $&top 0.16640625 $&decision >> decisions.csv
alter VIN = 0.17109375
alter VSAMPLE = 1.8
alter VB0 = 0
alter VB1 = 0
alter VB2 = 0
alter VB3 = 0
alter VB4 = 0
alter VB5 = 0
alter VB6 = 0
alter VB7 = 0
let code = 0
stop when time = 0.000704
resume
delete all
alter VSAMPLE = 0
let trial = code + 128
let drive = (floor(trial / 1) - 2*floor(trial / 2))*1.8
alter VB0 = $&drive
let drive = (floor(trial / 2) - 2*floor(trial / 4))*1.8
alter VB1 = $&drive
let drive = (floor(trial / 4) - 2*floor(trial / 8))*1.8
alter VB2 = $&drive
let drive = (floor(trial / 8) - 2*floor(trial / 16))*1.8
alter VB3 = $&drive
let drive = (floor(trial / 16) - 2*floor(trial / 32))*1.8
alter VB4 = $&drive
let drive = (floor(trial / 32) - 2*floor(trial / 64))*1.8
alter VB5 = $&drive
let drive = (floor(trial / 64) - 2*floor(trial / 128))*1.8
alter VB6 = $&drive
let drive = (floor(trial / 128) - 2*floor(trial / 256))*1.8
alter VB7 = $&drive
stop when time = 0.000706
resume
delete all
let endpoint = length(time)-1
let cmp = v(COMP)[endpoint]
let top = v(TOP)[endpoint]
let decision = 0
if cmp >= 0.9
let code = trial
let decision = 1
end
echo 39 7 $&trial $&cmp $&top 0.17109375 $&decision >> decisions.csv
let trial = code + 64
let drive = (floor(trial / 1) - 2*floor(trial / 2))*1.8
alter VB0 = $&drive
let drive = (floor(trial / 2) - 2*floor(trial / 4))*1.8
alter VB1 = $&drive
let drive = (floor(trial / 4) - 2*floor(trial / 8))*1.8
alter VB2 = $&drive
let drive = (floor(trial / 8) - 2*floor(trial / 16))*1.8
alter VB3 = $&drive
let drive = (floor(trial / 16) - 2*floor(trial / 32))*1.8
alter VB4 = $&drive
let drive = (floor(trial / 32) - 2*floor(trial / 64))*1.8
alter VB5 = $&drive
let drive = (floor(trial / 64) - 2*floor(trial / 128))*1.8
alter VB6 = $&drive
let drive = (floor(trial / 128) - 2*floor(trial / 256))*1.8
alter VB7 = $&drive
stop when time = 0.000708
resume
delete all
let endpoint = length(time)-1
let cmp = v(COMP)[endpoint]
let top = v(TOP)[endpoint]
let decision = 0
if cmp >= 0.9
let code = trial
let decision = 1
end
echo 39 6 $&trial $&cmp $&top 0.17109375 $&decision >> decisions.csv
let trial = code + 32
let drive = (floor(trial / 1) - 2*floor(trial / 2))*1.8
alter VB0 = $&drive
let drive = (floor(trial / 2) - 2*floor(trial / 4))*1.8
alter VB1 = $&drive
let drive = (floor(trial / 4) - 2*floor(trial / 8))*1.8
alter VB2 = $&drive
let drive = (floor(trial / 8) - 2*floor(trial / 16))*1.8
alter VB3 = $&drive
let drive = (floor(trial / 16) - 2*floor(trial / 32))*1.8
alter VB4 = $&drive
let drive = (floor(trial / 32) - 2*floor(trial / 64))*1.8
alter VB5 = $&drive
let drive = (floor(trial / 64) - 2*floor(trial / 128))*1.8
alter VB6 = $&drive
let drive = (floor(trial / 128) - 2*floor(trial / 256))*1.8
alter VB7 = $&drive
stop when time = 0.00071
resume
delete all
let endpoint = length(time)-1
let cmp = v(COMP)[endpoint]
let top = v(TOP)[endpoint]
let decision = 0
if cmp >= 0.9
let code = trial
let decision = 1
end
echo 39 5 $&trial $&cmp $&top 0.17109375 $&decision >> decisions.csv
let trial = code + 16
let drive = (floor(trial / 1) - 2*floor(trial / 2))*1.8
alter VB0 = $&drive
let drive = (floor(trial / 2) - 2*floor(trial / 4))*1.8
alter VB1 = $&drive
let drive = (floor(trial / 4) - 2*floor(trial / 8))*1.8
alter VB2 = $&drive
let drive = (floor(trial / 8) - 2*floor(trial / 16))*1.8
alter VB3 = $&drive
let drive = (floor(trial / 16) - 2*floor(trial / 32))*1.8
alter VB4 = $&drive
let drive = (floor(trial / 32) - 2*floor(trial / 64))*1.8
alter VB5 = $&drive
let drive = (floor(trial / 64) - 2*floor(trial / 128))*1.8
alter VB6 = $&drive
let drive = (floor(trial / 128) - 2*floor(trial / 256))*1.8
alter VB7 = $&drive
stop when time = 0.000712
resume
delete all
let endpoint = length(time)-1
let cmp = v(COMP)[endpoint]
let top = v(TOP)[endpoint]
let decision = 0
if cmp >= 0.9
let code = trial
let decision = 1
end
echo 39 4 $&trial $&cmp $&top 0.17109375 $&decision >> decisions.csv
let trial = code + 8
let drive = (floor(trial / 1) - 2*floor(trial / 2))*1.8
alter VB0 = $&drive
let drive = (floor(trial / 2) - 2*floor(trial / 4))*1.8
alter VB1 = $&drive
let drive = (floor(trial / 4) - 2*floor(trial / 8))*1.8
alter VB2 = $&drive
let drive = (floor(trial / 8) - 2*floor(trial / 16))*1.8
alter VB3 = $&drive
let drive = (floor(trial / 16) - 2*floor(trial / 32))*1.8
alter VB4 = $&drive
let drive = (floor(trial / 32) - 2*floor(trial / 64))*1.8
alter VB5 = $&drive
let drive = (floor(trial / 64) - 2*floor(trial / 128))*1.8
alter VB6 = $&drive
let drive = (floor(trial / 128) - 2*floor(trial / 256))*1.8
alter VB7 = $&drive
stop when time = 0.000714
resume
delete all
let endpoint = length(time)-1
let cmp = v(COMP)[endpoint]
let top = v(TOP)[endpoint]
let decision = 0
if cmp >= 0.9
let code = trial
let decision = 1
end
echo 39 3 $&trial $&cmp $&top 0.17109375 $&decision >> decisions.csv
let trial = code + 4
let drive = (floor(trial / 1) - 2*floor(trial / 2))*1.8
alter VB0 = $&drive
let drive = (floor(trial / 2) - 2*floor(trial / 4))*1.8
alter VB1 = $&drive
let drive = (floor(trial / 4) - 2*floor(trial / 8))*1.8
alter VB2 = $&drive
let drive = (floor(trial / 8) - 2*floor(trial / 16))*1.8
alter VB3 = $&drive
let drive = (floor(trial / 16) - 2*floor(trial / 32))*1.8
alter VB4 = $&drive
let drive = (floor(trial / 32) - 2*floor(trial / 64))*1.8
alter VB5 = $&drive
let drive = (floor(trial / 64) - 2*floor(trial / 128))*1.8
alter VB6 = $&drive
let drive = (floor(trial / 128) - 2*floor(trial / 256))*1.8
alter VB7 = $&drive
stop when time = 0.000716
resume
delete all
let endpoint = length(time)-1
let cmp = v(COMP)[endpoint]
let top = v(TOP)[endpoint]
let decision = 0
if cmp >= 0.9
let code = trial
let decision = 1
end
echo 39 2 $&trial $&cmp $&top 0.17109375 $&decision >> decisions.csv
let trial = code + 2
let drive = (floor(trial / 1) - 2*floor(trial / 2))*1.8
alter VB0 = $&drive
let drive = (floor(trial / 2) - 2*floor(trial / 4))*1.8
alter VB1 = $&drive
let drive = (floor(trial / 4) - 2*floor(trial / 8))*1.8
alter VB2 = $&drive
let drive = (floor(trial / 8) - 2*floor(trial / 16))*1.8
alter VB3 = $&drive
let drive = (floor(trial / 16) - 2*floor(trial / 32))*1.8
alter VB4 = $&drive
let drive = (floor(trial / 32) - 2*floor(trial / 64))*1.8
alter VB5 = $&drive
let drive = (floor(trial / 64) - 2*floor(trial / 128))*1.8
alter VB6 = $&drive
let drive = (floor(trial / 128) - 2*floor(trial / 256))*1.8
alter VB7 = $&drive
stop when time = 0.000718
resume
delete all
let endpoint = length(time)-1
let cmp = v(COMP)[endpoint]
let top = v(TOP)[endpoint]
let decision = 0
if cmp >= 0.9
let code = trial
let decision = 1
end
echo 39 1 $&trial $&cmp $&top 0.17109375 $&decision >> decisions.csv
let trial = code + 1
let drive = (floor(trial / 1) - 2*floor(trial / 2))*1.8
alter VB0 = $&drive
let drive = (floor(trial / 2) - 2*floor(trial / 4))*1.8
alter VB1 = $&drive
let drive = (floor(trial / 4) - 2*floor(trial / 8))*1.8
alter VB2 = $&drive
let drive = (floor(trial / 8) - 2*floor(trial / 16))*1.8
alter VB3 = $&drive
let drive = (floor(trial / 16) - 2*floor(trial / 32))*1.8
alter VB4 = $&drive
let drive = (floor(trial / 32) - 2*floor(trial / 64))*1.8
alter VB5 = $&drive
let drive = (floor(trial / 64) - 2*floor(trial / 128))*1.8
alter VB6 = $&drive
let drive = (floor(trial / 128) - 2*floor(trial / 256))*1.8
alter VB7 = $&drive
stop when time = 0.00072
resume
delete all
let endpoint = length(time)-1
let cmp = v(COMP)[endpoint]
let top = v(TOP)[endpoint]
let decision = 0
if cmp >= 0.9
let code = trial
let decision = 1
end
echo 39 0 $&trial $&cmp $&top 0.17109375 $&decision >> decisions.csv
alter VIN = 0.17578125
alter VSAMPLE = 1.8
alter VB0 = 0
alter VB1 = 0
alter VB2 = 0
alter VB3 = 0
alter VB4 = 0
alter VB5 = 0
alter VB6 = 0
alter VB7 = 0
let code = 0
stop when time = 0.000722
resume
delete all
alter VSAMPLE = 0
let trial = code + 128
let drive = (floor(trial / 1) - 2*floor(trial / 2))*1.8
alter VB0 = $&drive
let drive = (floor(trial / 2) - 2*floor(trial / 4))*1.8
alter VB1 = $&drive
let drive = (floor(trial / 4) - 2*floor(trial / 8))*1.8
alter VB2 = $&drive
let drive = (floor(trial / 8) - 2*floor(trial / 16))*1.8
alter VB3 = $&drive
let drive = (floor(trial / 16) - 2*floor(trial / 32))*1.8
alter VB4 = $&drive
let drive = (floor(trial / 32) - 2*floor(trial / 64))*1.8
alter VB5 = $&drive
let drive = (floor(trial / 64) - 2*floor(trial / 128))*1.8
alter VB6 = $&drive
let drive = (floor(trial / 128) - 2*floor(trial / 256))*1.8
alter VB7 = $&drive
stop when time = 0.000724
resume
delete all
let endpoint = length(time)-1
let cmp = v(COMP)[endpoint]
let top = v(TOP)[endpoint]
let decision = 0
if cmp >= 0.9
let code = trial
let decision = 1
end
echo 40 7 $&trial $&cmp $&top 0.17578125 $&decision >> decisions.csv
let trial = code + 64
let drive = (floor(trial / 1) - 2*floor(trial / 2))*1.8
alter VB0 = $&drive
let drive = (floor(trial / 2) - 2*floor(trial / 4))*1.8
alter VB1 = $&drive
let drive = (floor(trial / 4) - 2*floor(trial / 8))*1.8
alter VB2 = $&drive
let drive = (floor(trial / 8) - 2*floor(trial / 16))*1.8
alter VB3 = $&drive
let drive = (floor(trial / 16) - 2*floor(trial / 32))*1.8
alter VB4 = $&drive
let drive = (floor(trial / 32) - 2*floor(trial / 64))*1.8
alter VB5 = $&drive
let drive = (floor(trial / 64) - 2*floor(trial / 128))*1.8
alter VB6 = $&drive
let drive = (floor(trial / 128) - 2*floor(trial / 256))*1.8
alter VB7 = $&drive
stop when time = 0.000726
resume
delete all
let endpoint = length(time)-1
let cmp = v(COMP)[endpoint]
let top = v(TOP)[endpoint]
let decision = 0
if cmp >= 0.9
let code = trial
let decision = 1
end
echo 40 6 $&trial $&cmp $&top 0.17578125 $&decision >> decisions.csv
let trial = code + 32
let drive = (floor(trial / 1) - 2*floor(trial / 2))*1.8
alter VB0 = $&drive
let drive = (floor(trial / 2) - 2*floor(trial / 4))*1.8
alter VB1 = $&drive
let drive = (floor(trial / 4) - 2*floor(trial / 8))*1.8
alter VB2 = $&drive
let drive = (floor(trial / 8) - 2*floor(trial / 16))*1.8
alter VB3 = $&drive
let drive = (floor(trial / 16) - 2*floor(trial / 32))*1.8
alter VB4 = $&drive
let drive = (floor(trial / 32) - 2*floor(trial / 64))*1.8
alter VB5 = $&drive
let drive = (floor(trial / 64) - 2*floor(trial / 128))*1.8
alter VB6 = $&drive
let drive = (floor(trial / 128) - 2*floor(trial / 256))*1.8
alter VB7 = $&drive
stop when time = 0.000728
resume
delete all
let endpoint = length(time)-1
let cmp = v(COMP)[endpoint]
let top = v(TOP)[endpoint]
let decision = 0
if cmp >= 0.9
let code = trial
let decision = 1
end
echo 40 5 $&trial $&cmp $&top 0.17578125 $&decision >> decisions.csv
let trial = code + 16
let drive = (floor(trial / 1) - 2*floor(trial / 2))*1.8
alter VB0 = $&drive
let drive = (floor(trial / 2) - 2*floor(trial / 4))*1.8
alter VB1 = $&drive
let drive = (floor(trial / 4) - 2*floor(trial / 8))*1.8
alter VB2 = $&drive
let drive = (floor(trial / 8) - 2*floor(trial / 16))*1.8
alter VB3 = $&drive
let drive = (floor(trial / 16) - 2*floor(trial / 32))*1.8
alter VB4 = $&drive
let drive = (floor(trial / 32) - 2*floor(trial / 64))*1.8
alter VB5 = $&drive
let drive = (floor(trial / 64) - 2*floor(trial / 128))*1.8
alter VB6 = $&drive
let drive = (floor(trial / 128) - 2*floor(trial / 256))*1.8
alter VB7 = $&drive
stop when time = 0.00073
resume
delete all
let endpoint = length(time)-1
let cmp = v(COMP)[endpoint]
let top = v(TOP)[endpoint]
let decision = 0
if cmp >= 0.9
let code = trial
let decision = 1
end
echo 40 4 $&trial $&cmp $&top 0.17578125 $&decision >> decisions.csv
let trial = code + 8
let drive = (floor(trial / 1) - 2*floor(trial / 2))*1.8
alter VB0 = $&drive
let drive = (floor(trial / 2) - 2*floor(trial / 4))*1.8
alter VB1 = $&drive
let drive = (floor(trial / 4) - 2*floor(trial / 8))*1.8
alter VB2 = $&drive
let drive = (floor(trial / 8) - 2*floor(trial / 16))*1.8
alter VB3 = $&drive
let drive = (floor(trial / 16) - 2*floor(trial / 32))*1.8
alter VB4 = $&drive
let drive = (floor(trial / 32) - 2*floor(trial / 64))*1.8
alter VB5 = $&drive
let drive = (floor(trial / 64) - 2*floor(trial / 128))*1.8
alter VB6 = $&drive
let drive = (floor(trial / 128) - 2*floor(trial / 256))*1.8
alter VB7 = $&drive
stop when time = 0.000732
resume
delete all
let endpoint = length(time)-1
let cmp = v(COMP)[endpoint]
let top = v(TOP)[endpoint]
let decision = 0
if cmp >= 0.9
let code = trial
let decision = 1
end
echo 40 3 $&trial $&cmp $&top 0.17578125 $&decision >> decisions.csv
let trial = code + 4
let drive = (floor(trial / 1) - 2*floor(trial / 2))*1.8
alter VB0 = $&drive
let drive = (floor(trial / 2) - 2*floor(trial / 4))*1.8
alter VB1 = $&drive
let drive = (floor(trial / 4) - 2*floor(trial / 8))*1.8
alter VB2 = $&drive
let drive = (floor(trial / 8) - 2*floor(trial / 16))*1.8
alter VB3 = $&drive
let drive = (floor(trial / 16) - 2*floor(trial / 32))*1.8
alter VB4 = $&drive
let drive = (floor(trial / 32) - 2*floor(trial / 64))*1.8
alter VB5 = $&drive
let drive = (floor(trial / 64) - 2*floor(trial / 128))*1.8
alter VB6 = $&drive
let drive = (floor(trial / 128) - 2*floor(trial / 256))*1.8
alter VB7 = $&drive
stop when time = 0.000734
resume
delete all
let endpoint = length(time)-1
let cmp = v(COMP)[endpoint]
let top = v(TOP)[endpoint]
let decision = 0
if cmp >= 0.9
let code = trial
let decision = 1
end
echo 40 2 $&trial $&cmp $&top 0.17578125 $&decision >> decisions.csv
let trial = code + 2
let drive = (floor(trial / 1) - 2*floor(trial / 2))*1.8
alter VB0 = $&drive
let drive = (floor(trial / 2) - 2*floor(trial / 4))*1.8
alter VB1 = $&drive
let drive = (floor(trial / 4) - 2*floor(trial / 8))*1.8
alter VB2 = $&drive
let drive = (floor(trial / 8) - 2*floor(trial / 16))*1.8
alter VB3 = $&drive
let drive = (floor(trial / 16) - 2*floor(trial / 32))*1.8
alter VB4 = $&drive
let drive = (floor(trial / 32) - 2*floor(trial / 64))*1.8
alter VB5 = $&drive
let drive = (floor(trial / 64) - 2*floor(trial / 128))*1.8
alter VB6 = $&drive
let drive = (floor(trial / 128) - 2*floor(trial / 256))*1.8
alter VB7 = $&drive
stop when time = 0.000736
resume
delete all
let endpoint = length(time)-1
let cmp = v(COMP)[endpoint]
let top = v(TOP)[endpoint]
let decision = 0
if cmp >= 0.9
let code = trial
let decision = 1
end
echo 40 1 $&trial $&cmp $&top 0.17578125 $&decision >> decisions.csv
let trial = code + 1
let drive = (floor(trial / 1) - 2*floor(trial / 2))*1.8
alter VB0 = $&drive
let drive = (floor(trial / 2) - 2*floor(trial / 4))*1.8
alter VB1 = $&drive
let drive = (floor(trial / 4) - 2*floor(trial / 8))*1.8
alter VB2 = $&drive
let drive = (floor(trial / 8) - 2*floor(trial / 16))*1.8
alter VB3 = $&drive
let drive = (floor(trial / 16) - 2*floor(trial / 32))*1.8
alter VB4 = $&drive
let drive = (floor(trial / 32) - 2*floor(trial / 64))*1.8
alter VB5 = $&drive
let drive = (floor(trial / 64) - 2*floor(trial / 128))*1.8
alter VB6 = $&drive
let drive = (floor(trial / 128) - 2*floor(trial / 256))*1.8
alter VB7 = $&drive
stop when time = 0.000738
resume
delete all
let endpoint = length(time)-1
let cmp = v(COMP)[endpoint]
let top = v(TOP)[endpoint]
let decision = 0
if cmp >= 0.9
let code = trial
let decision = 1
end
echo 40 0 $&trial $&cmp $&top 0.17578125 $&decision >> decisions.csv
alter VIN = 0.18046875
alter VSAMPLE = 1.8
alter VB0 = 0
alter VB1 = 0
alter VB2 = 0
alter VB3 = 0
alter VB4 = 0
alter VB5 = 0
alter VB6 = 0
alter VB7 = 0
let code = 0
stop when time = 0.00074
resume
delete all
alter VSAMPLE = 0
let trial = code + 128
let drive = (floor(trial / 1) - 2*floor(trial / 2))*1.8
alter VB0 = $&drive
let drive = (floor(trial / 2) - 2*floor(trial / 4))*1.8
alter VB1 = $&drive
let drive = (floor(trial / 4) - 2*floor(trial / 8))*1.8
alter VB2 = $&drive
let drive = (floor(trial / 8) - 2*floor(trial / 16))*1.8
alter VB3 = $&drive
let drive = (floor(trial / 16) - 2*floor(trial / 32))*1.8
alter VB4 = $&drive
let drive = (floor(trial / 32) - 2*floor(trial / 64))*1.8
alter VB5 = $&drive
let drive = (floor(trial / 64) - 2*floor(trial / 128))*1.8
alter VB6 = $&drive
let drive = (floor(trial / 128) - 2*floor(trial / 256))*1.8
alter VB7 = $&drive
stop when time = 0.000742
resume
delete all
let endpoint = length(time)-1
let cmp = v(COMP)[endpoint]
let top = v(TOP)[endpoint]
let decision = 0
if cmp >= 0.9
let code = trial
let decision = 1
end
echo 41 7 $&trial $&cmp $&top 0.18046875 $&decision >> decisions.csv
let trial = code + 64
let drive = (floor(trial / 1) - 2*floor(trial / 2))*1.8
alter VB0 = $&drive
let drive = (floor(trial / 2) - 2*floor(trial / 4))*1.8
alter VB1 = $&drive
let drive = (floor(trial / 4) - 2*floor(trial / 8))*1.8
alter VB2 = $&drive
let drive = (floor(trial / 8) - 2*floor(trial / 16))*1.8
alter VB3 = $&drive
let drive = (floor(trial / 16) - 2*floor(trial / 32))*1.8
alter VB4 = $&drive
let drive = (floor(trial / 32) - 2*floor(trial / 64))*1.8
alter VB5 = $&drive
let drive = (floor(trial / 64) - 2*floor(trial / 128))*1.8
alter VB6 = $&drive
let drive = (floor(trial / 128) - 2*floor(trial / 256))*1.8
alter VB7 = $&drive
stop when time = 0.000744
resume
delete all
let endpoint = length(time)-1
let cmp = v(COMP)[endpoint]
let top = v(TOP)[endpoint]
let decision = 0
if cmp >= 0.9
let code = trial
let decision = 1
end
echo 41 6 $&trial $&cmp $&top 0.18046875 $&decision >> decisions.csv
let trial = code + 32
let drive = (floor(trial / 1) - 2*floor(trial / 2))*1.8
alter VB0 = $&drive
let drive = (floor(trial / 2) - 2*floor(trial / 4))*1.8
alter VB1 = $&drive
let drive = (floor(trial / 4) - 2*floor(trial / 8))*1.8
alter VB2 = $&drive
let drive = (floor(trial / 8) - 2*floor(trial / 16))*1.8
alter VB3 = $&drive
let drive = (floor(trial / 16) - 2*floor(trial / 32))*1.8
alter VB4 = $&drive
let drive = (floor(trial / 32) - 2*floor(trial / 64))*1.8
alter VB5 = $&drive
let drive = (floor(trial / 64) - 2*floor(trial / 128))*1.8
alter VB6 = $&drive
let drive = (floor(trial / 128) - 2*floor(trial / 256))*1.8
alter VB7 = $&drive
stop when time = 0.000746
resume
delete all
let endpoint = length(time)-1
let cmp = v(COMP)[endpoint]
let top = v(TOP)[endpoint]
let decision = 0
if cmp >= 0.9
let code = trial
let decision = 1
end
echo 41 5 $&trial $&cmp $&top 0.18046875 $&decision >> decisions.csv
let trial = code + 16
let drive = (floor(trial / 1) - 2*floor(trial / 2))*1.8
alter VB0 = $&drive
let drive = (floor(trial / 2) - 2*floor(trial / 4))*1.8
alter VB1 = $&drive
let drive = (floor(trial / 4) - 2*floor(trial / 8))*1.8
alter VB2 = $&drive
let drive = (floor(trial / 8) - 2*floor(trial / 16))*1.8
alter VB3 = $&drive
let drive = (floor(trial / 16) - 2*floor(trial / 32))*1.8
alter VB4 = $&drive
let drive = (floor(trial / 32) - 2*floor(trial / 64))*1.8
alter VB5 = $&drive
let drive = (floor(trial / 64) - 2*floor(trial / 128))*1.8
alter VB6 = $&drive
let drive = (floor(trial / 128) - 2*floor(trial / 256))*1.8
alter VB7 = $&drive
stop when time = 0.000748
resume
delete all
let endpoint = length(time)-1
let cmp = v(COMP)[endpoint]
let top = v(TOP)[endpoint]
let decision = 0
if cmp >= 0.9
let code = trial
let decision = 1
end
echo 41 4 $&trial $&cmp $&top 0.18046875 $&decision >> decisions.csv
let trial = code + 8
let drive = (floor(trial / 1) - 2*floor(trial / 2))*1.8
alter VB0 = $&drive
let drive = (floor(trial / 2) - 2*floor(trial / 4))*1.8
alter VB1 = $&drive
let drive = (floor(trial / 4) - 2*floor(trial / 8))*1.8
alter VB2 = $&drive
let drive = (floor(trial / 8) - 2*floor(trial / 16))*1.8
alter VB3 = $&drive
let drive = (floor(trial / 16) - 2*floor(trial / 32))*1.8
alter VB4 = $&drive
let drive = (floor(trial / 32) - 2*floor(trial / 64))*1.8
alter VB5 = $&drive
let drive = (floor(trial / 64) - 2*floor(trial / 128))*1.8
alter VB6 = $&drive
let drive = (floor(trial / 128) - 2*floor(trial / 256))*1.8
alter VB7 = $&drive
stop when time = 0.00075
resume
delete all
let endpoint = length(time)-1
let cmp = v(COMP)[endpoint]
let top = v(TOP)[endpoint]
let decision = 0
if cmp >= 0.9
let code = trial
let decision = 1
end
echo 41 3 $&trial $&cmp $&top 0.18046875 $&decision >> decisions.csv
let trial = code + 4
let drive = (floor(trial / 1) - 2*floor(trial / 2))*1.8
alter VB0 = $&drive
let drive = (floor(trial / 2) - 2*floor(trial / 4))*1.8
alter VB1 = $&drive
let drive = (floor(trial / 4) - 2*floor(trial / 8))*1.8
alter VB2 = $&drive
let drive = (floor(trial / 8) - 2*floor(trial / 16))*1.8
alter VB3 = $&drive
let drive = (floor(trial / 16) - 2*floor(trial / 32))*1.8
alter VB4 = $&drive
let drive = (floor(trial / 32) - 2*floor(trial / 64))*1.8
alter VB5 = $&drive
let drive = (floor(trial / 64) - 2*floor(trial / 128))*1.8
alter VB6 = $&drive
let drive = (floor(trial / 128) - 2*floor(trial / 256))*1.8
alter VB7 = $&drive
stop when time = 0.000752
resume
delete all
let endpoint = length(time)-1
let cmp = v(COMP)[endpoint]
let top = v(TOP)[endpoint]
let decision = 0
if cmp >= 0.9
let code = trial
let decision = 1
end
echo 41 2 $&trial $&cmp $&top 0.18046875 $&decision >> decisions.csv
let trial = code + 2
let drive = (floor(trial / 1) - 2*floor(trial / 2))*1.8
alter VB0 = $&drive
let drive = (floor(trial / 2) - 2*floor(trial / 4))*1.8
alter VB1 = $&drive
let drive = (floor(trial / 4) - 2*floor(trial / 8))*1.8
alter VB2 = $&drive
let drive = (floor(trial / 8) - 2*floor(trial / 16))*1.8
alter VB3 = $&drive
let drive = (floor(trial / 16) - 2*floor(trial / 32))*1.8
alter VB4 = $&drive
let drive = (floor(trial / 32) - 2*floor(trial / 64))*1.8
alter VB5 = $&drive
let drive = (floor(trial / 64) - 2*floor(trial / 128))*1.8
alter VB6 = $&drive
let drive = (floor(trial / 128) - 2*floor(trial / 256))*1.8
alter VB7 = $&drive
stop when time = 0.000754
resume
delete all
let endpoint = length(time)-1
let cmp = v(COMP)[endpoint]
let top = v(TOP)[endpoint]
let decision = 0
if cmp >= 0.9
let code = trial
let decision = 1
end
echo 41 1 $&trial $&cmp $&top 0.18046875 $&decision >> decisions.csv
let trial = code + 1
let drive = (floor(trial / 1) - 2*floor(trial / 2))*1.8
alter VB0 = $&drive
let drive = (floor(trial / 2) - 2*floor(trial / 4))*1.8
alter VB1 = $&drive
let drive = (floor(trial / 4) - 2*floor(trial / 8))*1.8
alter VB2 = $&drive
let drive = (floor(trial / 8) - 2*floor(trial / 16))*1.8
alter VB3 = $&drive
let drive = (floor(trial / 16) - 2*floor(trial / 32))*1.8
alter VB4 = $&drive
let drive = (floor(trial / 32) - 2*floor(trial / 64))*1.8
alter VB5 = $&drive
let drive = (floor(trial / 64) - 2*floor(trial / 128))*1.8
alter VB6 = $&drive
let drive = (floor(trial / 128) - 2*floor(trial / 256))*1.8
alter VB7 = $&drive
stop when time = 0.000756
resume
delete all
let endpoint = length(time)-1
let cmp = v(COMP)[endpoint]
let top = v(TOP)[endpoint]
let decision = 0
if cmp >= 0.9
let code = trial
let decision = 1
end
echo 41 0 $&trial $&cmp $&top 0.18046875 $&decision >> decisions.csv
alter VIN = 0.18515625
alter VSAMPLE = 1.8
alter VB0 = 0
alter VB1 = 0
alter VB2 = 0
alter VB3 = 0
alter VB4 = 0
alter VB5 = 0
alter VB6 = 0
alter VB7 = 0
let code = 0
stop when time = 0.000758
resume
delete all
alter VSAMPLE = 0
let trial = code + 128
let drive = (floor(trial / 1) - 2*floor(trial / 2))*1.8
alter VB0 = $&drive
let drive = (floor(trial / 2) - 2*floor(trial / 4))*1.8
alter VB1 = $&drive
let drive = (floor(trial / 4) - 2*floor(trial / 8))*1.8
alter VB2 = $&drive
let drive = (floor(trial / 8) - 2*floor(trial / 16))*1.8
alter VB3 = $&drive
let drive = (floor(trial / 16) - 2*floor(trial / 32))*1.8
alter VB4 = $&drive
let drive = (floor(trial / 32) - 2*floor(trial / 64))*1.8
alter VB5 = $&drive
let drive = (floor(trial / 64) - 2*floor(trial / 128))*1.8
alter VB6 = $&drive
let drive = (floor(trial / 128) - 2*floor(trial / 256))*1.8
alter VB7 = $&drive
stop when time = 0.00076
resume
delete all
let endpoint = length(time)-1
let cmp = v(COMP)[endpoint]
let top = v(TOP)[endpoint]
let decision = 0
if cmp >= 0.9
let code = trial
let decision = 1
end
echo 42 7 $&trial $&cmp $&top 0.18515625 $&decision >> decisions.csv
let trial = code + 64
let drive = (floor(trial / 1) - 2*floor(trial / 2))*1.8
alter VB0 = $&drive
let drive = (floor(trial / 2) - 2*floor(trial / 4))*1.8
alter VB1 = $&drive
let drive = (floor(trial / 4) - 2*floor(trial / 8))*1.8
alter VB2 = $&drive
let drive = (floor(trial / 8) - 2*floor(trial / 16))*1.8
alter VB3 = $&drive
let drive = (floor(trial / 16) - 2*floor(trial / 32))*1.8
alter VB4 = $&drive
let drive = (floor(trial / 32) - 2*floor(trial / 64))*1.8
alter VB5 = $&drive
let drive = (floor(trial / 64) - 2*floor(trial / 128))*1.8
alter VB6 = $&drive
let drive = (floor(trial / 128) - 2*floor(trial / 256))*1.8
alter VB7 = $&drive
stop when time = 0.000762
resume
delete all
let endpoint = length(time)-1
let cmp = v(COMP)[endpoint]
let top = v(TOP)[endpoint]
let decision = 0
if cmp >= 0.9
let code = trial
let decision = 1
end
echo 42 6 $&trial $&cmp $&top 0.18515625 $&decision >> decisions.csv
let trial = code + 32
let drive = (floor(trial / 1) - 2*floor(trial / 2))*1.8
alter VB0 = $&drive
let drive = (floor(trial / 2) - 2*floor(trial / 4))*1.8
alter VB1 = $&drive
let drive = (floor(trial / 4) - 2*floor(trial / 8))*1.8
alter VB2 = $&drive
let drive = (floor(trial / 8) - 2*floor(trial / 16))*1.8
alter VB3 = $&drive
let drive = (floor(trial / 16) - 2*floor(trial / 32))*1.8
alter VB4 = $&drive
let drive = (floor(trial / 32) - 2*floor(trial / 64))*1.8
alter VB5 = $&drive
let drive = (floor(trial / 64) - 2*floor(trial / 128))*1.8
alter VB6 = $&drive
let drive = (floor(trial / 128) - 2*floor(trial / 256))*1.8
alter VB7 = $&drive
stop when time = 0.000764
resume
delete all
let endpoint = length(time)-1
let cmp = v(COMP)[endpoint]
let top = v(TOP)[endpoint]
let decision = 0
if cmp >= 0.9
let code = trial
let decision = 1
end
echo 42 5 $&trial $&cmp $&top 0.18515625 $&decision >> decisions.csv
let trial = code + 16
let drive = (floor(trial / 1) - 2*floor(trial / 2))*1.8
alter VB0 = $&drive
let drive = (floor(trial / 2) - 2*floor(trial / 4))*1.8
alter VB1 = $&drive
let drive = (floor(trial / 4) - 2*floor(trial / 8))*1.8
alter VB2 = $&drive
let drive = (floor(trial / 8) - 2*floor(trial / 16))*1.8
alter VB3 = $&drive
let drive = (floor(trial / 16) - 2*floor(trial / 32))*1.8
alter VB4 = $&drive
let drive = (floor(trial / 32) - 2*floor(trial / 64))*1.8
alter VB5 = $&drive
let drive = (floor(trial / 64) - 2*floor(trial / 128))*1.8
alter VB6 = $&drive
let drive = (floor(trial / 128) - 2*floor(trial / 256))*1.8
alter VB7 = $&drive
stop when time = 0.000766
resume
delete all
let endpoint = length(time)-1
let cmp = v(COMP)[endpoint]
let top = v(TOP)[endpoint]
let decision = 0
if cmp >= 0.9
let code = trial
let decision = 1
end
echo 42 4 $&trial $&cmp $&top 0.18515625 $&decision >> decisions.csv
let trial = code + 8
let drive = (floor(trial / 1) - 2*floor(trial / 2))*1.8
alter VB0 = $&drive
let drive = (floor(trial / 2) - 2*floor(trial / 4))*1.8
alter VB1 = $&drive
let drive = (floor(trial / 4) - 2*floor(trial / 8))*1.8
alter VB2 = $&drive
let drive = (floor(trial / 8) - 2*floor(trial / 16))*1.8
alter VB3 = $&drive
let drive = (floor(trial / 16) - 2*floor(trial / 32))*1.8
alter VB4 = $&drive
let drive = (floor(trial / 32) - 2*floor(trial / 64))*1.8
alter VB5 = $&drive
let drive = (floor(trial / 64) - 2*floor(trial / 128))*1.8
alter VB6 = $&drive
let drive = (floor(trial / 128) - 2*floor(trial / 256))*1.8
alter VB7 = $&drive
stop when time = 0.000768
resume
delete all
let endpoint = length(time)-1
let cmp = v(COMP)[endpoint]
let top = v(TOP)[endpoint]
let decision = 0
if cmp >= 0.9
let code = trial
let decision = 1
end
echo 42 3 $&trial $&cmp $&top 0.18515625 $&decision >> decisions.csv
let trial = code + 4
let drive = (floor(trial / 1) - 2*floor(trial / 2))*1.8
alter VB0 = $&drive
let drive = (floor(trial / 2) - 2*floor(trial / 4))*1.8
alter VB1 = $&drive
let drive = (floor(trial / 4) - 2*floor(trial / 8))*1.8
alter VB2 = $&drive
let drive = (floor(trial / 8) - 2*floor(trial / 16))*1.8
alter VB3 = $&drive
let drive = (floor(trial / 16) - 2*floor(trial / 32))*1.8
alter VB4 = $&drive
let drive = (floor(trial / 32) - 2*floor(trial / 64))*1.8
alter VB5 = $&drive
let drive = (floor(trial / 64) - 2*floor(trial / 128))*1.8
alter VB6 = $&drive
let drive = (floor(trial / 128) - 2*floor(trial / 256))*1.8
alter VB7 = $&drive
stop when time = 0.00077
resume
delete all
let endpoint = length(time)-1
let cmp = v(COMP)[endpoint]
let top = v(TOP)[endpoint]
let decision = 0
if cmp >= 0.9
let code = trial
let decision = 1
end
echo 42 2 $&trial $&cmp $&top 0.18515625 $&decision >> decisions.csv
let trial = code + 2
let drive = (floor(trial / 1) - 2*floor(trial / 2))*1.8
alter VB0 = $&drive
let drive = (floor(trial / 2) - 2*floor(trial / 4))*1.8
alter VB1 = $&drive
let drive = (floor(trial / 4) - 2*floor(trial / 8))*1.8
alter VB2 = $&drive
let drive = (floor(trial / 8) - 2*floor(trial / 16))*1.8
alter VB3 = $&drive
let drive = (floor(trial / 16) - 2*floor(trial / 32))*1.8
alter VB4 = $&drive
let drive = (floor(trial / 32) - 2*floor(trial / 64))*1.8
alter VB5 = $&drive
let drive = (floor(trial / 64) - 2*floor(trial / 128))*1.8
alter VB6 = $&drive
let drive = (floor(trial / 128) - 2*floor(trial / 256))*1.8
alter VB7 = $&drive
stop when time = 0.000772
resume
delete all
let endpoint = length(time)-1
let cmp = v(COMP)[endpoint]
let top = v(TOP)[endpoint]
let decision = 0
if cmp >= 0.9
let code = trial
let decision = 1
end
echo 42 1 $&trial $&cmp $&top 0.18515625 $&decision >> decisions.csv
let trial = code + 1
let drive = (floor(trial / 1) - 2*floor(trial / 2))*1.8
alter VB0 = $&drive
let drive = (floor(trial / 2) - 2*floor(trial / 4))*1.8
alter VB1 = $&drive
let drive = (floor(trial / 4) - 2*floor(trial / 8))*1.8
alter VB2 = $&drive
let drive = (floor(trial / 8) - 2*floor(trial / 16))*1.8
alter VB3 = $&drive
let drive = (floor(trial / 16) - 2*floor(trial / 32))*1.8
alter VB4 = $&drive
let drive = (floor(trial / 32) - 2*floor(trial / 64))*1.8
alter VB5 = $&drive
let drive = (floor(trial / 64) - 2*floor(trial / 128))*1.8
alter VB6 = $&drive
let drive = (floor(trial / 128) - 2*floor(trial / 256))*1.8
alter VB7 = $&drive
stop when time = 0.000774
resume
delete all
let endpoint = length(time)-1
let cmp = v(COMP)[endpoint]
let top = v(TOP)[endpoint]
let decision = 0
if cmp >= 0.9
let code = trial
let decision = 1
end
echo 42 0 $&trial $&cmp $&top 0.18515625 $&decision >> decisions.csv
alter VIN = 0.18984375
alter VSAMPLE = 1.8
alter VB0 = 0
alter VB1 = 0
alter VB2 = 0
alter VB3 = 0
alter VB4 = 0
alter VB5 = 0
alter VB6 = 0
alter VB7 = 0
let code = 0
stop when time = 0.000776
resume
delete all
alter VSAMPLE = 0
let trial = code + 128
let drive = (floor(trial / 1) - 2*floor(trial / 2))*1.8
alter VB0 = $&drive
let drive = (floor(trial / 2) - 2*floor(trial / 4))*1.8
alter VB1 = $&drive
let drive = (floor(trial / 4) - 2*floor(trial / 8))*1.8
alter VB2 = $&drive
let drive = (floor(trial / 8) - 2*floor(trial / 16))*1.8
alter VB3 = $&drive
let drive = (floor(trial / 16) - 2*floor(trial / 32))*1.8
alter VB4 = $&drive
let drive = (floor(trial / 32) - 2*floor(trial / 64))*1.8
alter VB5 = $&drive
let drive = (floor(trial / 64) - 2*floor(trial / 128))*1.8
alter VB6 = $&drive
let drive = (floor(trial / 128) - 2*floor(trial / 256))*1.8
alter VB7 = $&drive
stop when time = 0.000778
resume
delete all
let endpoint = length(time)-1
let cmp = v(COMP)[endpoint]
let top = v(TOP)[endpoint]
let decision = 0
if cmp >= 0.9
let code = trial
let decision = 1
end
echo 43 7 $&trial $&cmp $&top 0.18984375 $&decision >> decisions.csv
let trial = code + 64
let drive = (floor(trial / 1) - 2*floor(trial / 2))*1.8
alter VB0 = $&drive
let drive = (floor(trial / 2) - 2*floor(trial / 4))*1.8
alter VB1 = $&drive
let drive = (floor(trial / 4) - 2*floor(trial / 8))*1.8
alter VB2 = $&drive
let drive = (floor(trial / 8) - 2*floor(trial / 16))*1.8
alter VB3 = $&drive
let drive = (floor(trial / 16) - 2*floor(trial / 32))*1.8
alter VB4 = $&drive
let drive = (floor(trial / 32) - 2*floor(trial / 64))*1.8
alter VB5 = $&drive
let drive = (floor(trial / 64) - 2*floor(trial / 128))*1.8
alter VB6 = $&drive
let drive = (floor(trial / 128) - 2*floor(trial / 256))*1.8
alter VB7 = $&drive
stop when time = 0.00078
resume
delete all
let endpoint = length(time)-1
let cmp = v(COMP)[endpoint]
let top = v(TOP)[endpoint]
let decision = 0
if cmp >= 0.9
let code = trial
let decision = 1
end
echo 43 6 $&trial $&cmp $&top 0.18984375 $&decision >> decisions.csv
let trial = code + 32
let drive = (floor(trial / 1) - 2*floor(trial / 2))*1.8
alter VB0 = $&drive
let drive = (floor(trial / 2) - 2*floor(trial / 4))*1.8
alter VB1 = $&drive
let drive = (floor(trial / 4) - 2*floor(trial / 8))*1.8
alter VB2 = $&drive
let drive = (floor(trial / 8) - 2*floor(trial / 16))*1.8
alter VB3 = $&drive
let drive = (floor(trial / 16) - 2*floor(trial / 32))*1.8
alter VB4 = $&drive
let drive = (floor(trial / 32) - 2*floor(trial / 64))*1.8
alter VB5 = $&drive
let drive = (floor(trial / 64) - 2*floor(trial / 128))*1.8
alter VB6 = $&drive
let drive = (floor(trial / 128) - 2*floor(trial / 256))*1.8
alter VB7 = $&drive
stop when time = 0.000782
resume
delete all
let endpoint = length(time)-1
let cmp = v(COMP)[endpoint]
let top = v(TOP)[endpoint]
let decision = 0
if cmp >= 0.9
let code = trial
let decision = 1
end
echo 43 5 $&trial $&cmp $&top 0.18984375 $&decision >> decisions.csv
let trial = code + 16
let drive = (floor(trial / 1) - 2*floor(trial / 2))*1.8
alter VB0 = $&drive
let drive = (floor(trial / 2) - 2*floor(trial / 4))*1.8
alter VB1 = $&drive
let drive = (floor(trial / 4) - 2*floor(trial / 8))*1.8
alter VB2 = $&drive
let drive = (floor(trial / 8) - 2*floor(trial / 16))*1.8
alter VB3 = $&drive
let drive = (floor(trial / 16) - 2*floor(trial / 32))*1.8
alter VB4 = $&drive
let drive = (floor(trial / 32) - 2*floor(trial / 64))*1.8
alter VB5 = $&drive
let drive = (floor(trial / 64) - 2*floor(trial / 128))*1.8
alter VB6 = $&drive
let drive = (floor(trial / 128) - 2*floor(trial / 256))*1.8
alter VB7 = $&drive
stop when time = 0.000784
resume
delete all
let endpoint = length(time)-1
let cmp = v(COMP)[endpoint]
let top = v(TOP)[endpoint]
let decision = 0
if cmp >= 0.9
let code = trial
let decision = 1
end
echo 43 4 $&trial $&cmp $&top 0.18984375 $&decision >> decisions.csv
let trial = code + 8
let drive = (floor(trial / 1) - 2*floor(trial / 2))*1.8
alter VB0 = $&drive
let drive = (floor(trial / 2) - 2*floor(trial / 4))*1.8
alter VB1 = $&drive
let drive = (floor(trial / 4) - 2*floor(trial / 8))*1.8
alter VB2 = $&drive
let drive = (floor(trial / 8) - 2*floor(trial / 16))*1.8
alter VB3 = $&drive
let drive = (floor(trial / 16) - 2*floor(trial / 32))*1.8
alter VB4 = $&drive
let drive = (floor(trial / 32) - 2*floor(trial / 64))*1.8
alter VB5 = $&drive
let drive = (floor(trial / 64) - 2*floor(trial / 128))*1.8
alter VB6 = $&drive
let drive = (floor(trial / 128) - 2*floor(trial / 256))*1.8
alter VB7 = $&drive
stop when time = 0.000786
resume
delete all
let endpoint = length(time)-1
let cmp = v(COMP)[endpoint]
let top = v(TOP)[endpoint]
let decision = 0
if cmp >= 0.9
let code = trial
let decision = 1
end
echo 43 3 $&trial $&cmp $&top 0.18984375 $&decision >> decisions.csv
let trial = code + 4
let drive = (floor(trial / 1) - 2*floor(trial / 2))*1.8
alter VB0 = $&drive
let drive = (floor(trial / 2) - 2*floor(trial / 4))*1.8
alter VB1 = $&drive
let drive = (floor(trial / 4) - 2*floor(trial / 8))*1.8
alter VB2 = $&drive
let drive = (floor(trial / 8) - 2*floor(trial / 16))*1.8
alter VB3 = $&drive
let drive = (floor(trial / 16) - 2*floor(trial / 32))*1.8
alter VB4 = $&drive
let drive = (floor(trial / 32) - 2*floor(trial / 64))*1.8
alter VB5 = $&drive
let drive = (floor(trial / 64) - 2*floor(trial / 128))*1.8
alter VB6 = $&drive
let drive = (floor(trial / 128) - 2*floor(trial / 256))*1.8
alter VB7 = $&drive
stop when time = 0.000788
resume
delete all
let endpoint = length(time)-1
let cmp = v(COMP)[endpoint]
let top = v(TOP)[endpoint]
let decision = 0
if cmp >= 0.9
let code = trial
let decision = 1
end
echo 43 2 $&trial $&cmp $&top 0.18984375 $&decision >> decisions.csv
let trial = code + 2
let drive = (floor(trial / 1) - 2*floor(trial / 2))*1.8
alter VB0 = $&drive
let drive = (floor(trial / 2) - 2*floor(trial / 4))*1.8
alter VB1 = $&drive
let drive = (floor(trial / 4) - 2*floor(trial / 8))*1.8
alter VB2 = $&drive
let drive = (floor(trial / 8) - 2*floor(trial / 16))*1.8
alter VB3 = $&drive
let drive = (floor(trial / 16) - 2*floor(trial / 32))*1.8
alter VB4 = $&drive
let drive = (floor(trial / 32) - 2*floor(trial / 64))*1.8
alter VB5 = $&drive
let drive = (floor(trial / 64) - 2*floor(trial / 128))*1.8
alter VB6 = $&drive
let drive = (floor(trial / 128) - 2*floor(trial / 256))*1.8
alter VB7 = $&drive
stop when time = 0.00079
resume
delete all
let endpoint = length(time)-1
let cmp = v(COMP)[endpoint]
let top = v(TOP)[endpoint]
let decision = 0
if cmp >= 0.9
let code = trial
let decision = 1
end
echo 43 1 $&trial $&cmp $&top 0.18984375 $&decision >> decisions.csv
let trial = code + 1
let drive = (floor(trial / 1) - 2*floor(trial / 2))*1.8
alter VB0 = $&drive
let drive = (floor(trial / 2) - 2*floor(trial / 4))*1.8
alter VB1 = $&drive
let drive = (floor(trial / 4) - 2*floor(trial / 8))*1.8
alter VB2 = $&drive
let drive = (floor(trial / 8) - 2*floor(trial / 16))*1.8
alter VB3 = $&drive
let drive = (floor(trial / 16) - 2*floor(trial / 32))*1.8
alter VB4 = $&drive
let drive = (floor(trial / 32) - 2*floor(trial / 64))*1.8
alter VB5 = $&drive
let drive = (floor(trial / 64) - 2*floor(trial / 128))*1.8
alter VB6 = $&drive
let drive = (floor(trial / 128) - 2*floor(trial / 256))*1.8
alter VB7 = $&drive
stop when time = 0.000792
resume
delete all
let endpoint = length(time)-1
let cmp = v(COMP)[endpoint]
let top = v(TOP)[endpoint]
let decision = 0
if cmp >= 0.9
let code = trial
let decision = 1
end
echo 43 0 $&trial $&cmp $&top 0.18984375 $&decision >> decisions.csv
alter VIN = 0.19453125
alter VSAMPLE = 1.8
alter VB0 = 0
alter VB1 = 0
alter VB2 = 0
alter VB3 = 0
alter VB4 = 0
alter VB5 = 0
alter VB6 = 0
alter VB7 = 0
let code = 0
stop when time = 0.000794
resume
delete all
alter VSAMPLE = 0
let trial = code + 128
let drive = (floor(trial / 1) - 2*floor(trial / 2))*1.8
alter VB0 = $&drive
let drive = (floor(trial / 2) - 2*floor(trial / 4))*1.8
alter VB1 = $&drive
let drive = (floor(trial / 4) - 2*floor(trial / 8))*1.8
alter VB2 = $&drive
let drive = (floor(trial / 8) - 2*floor(trial / 16))*1.8
alter VB3 = $&drive
let drive = (floor(trial / 16) - 2*floor(trial / 32))*1.8
alter VB4 = $&drive
let drive = (floor(trial / 32) - 2*floor(trial / 64))*1.8
alter VB5 = $&drive
let drive = (floor(trial / 64) - 2*floor(trial / 128))*1.8
alter VB6 = $&drive
let drive = (floor(trial / 128) - 2*floor(trial / 256))*1.8
alter VB7 = $&drive
stop when time = 0.000796
resume
delete all
let endpoint = length(time)-1
let cmp = v(COMP)[endpoint]
let top = v(TOP)[endpoint]
let decision = 0
if cmp >= 0.9
let code = trial
let decision = 1
end
echo 44 7 $&trial $&cmp $&top 0.19453125 $&decision >> decisions.csv
let trial = code + 64
let drive = (floor(trial / 1) - 2*floor(trial / 2))*1.8
alter VB0 = $&drive
let drive = (floor(trial / 2) - 2*floor(trial / 4))*1.8
alter VB1 = $&drive
let drive = (floor(trial / 4) - 2*floor(trial / 8))*1.8
alter VB2 = $&drive
let drive = (floor(trial / 8) - 2*floor(trial / 16))*1.8
alter VB3 = $&drive
let drive = (floor(trial / 16) - 2*floor(trial / 32))*1.8
alter VB4 = $&drive
let drive = (floor(trial / 32) - 2*floor(trial / 64))*1.8
alter VB5 = $&drive
let drive = (floor(trial / 64) - 2*floor(trial / 128))*1.8
alter VB6 = $&drive
let drive = (floor(trial / 128) - 2*floor(trial / 256))*1.8
alter VB7 = $&drive
stop when time = 0.000798
resume
delete all
let endpoint = length(time)-1
let cmp = v(COMP)[endpoint]
let top = v(TOP)[endpoint]
let decision = 0
if cmp >= 0.9
let code = trial
let decision = 1
end
echo 44 6 $&trial $&cmp $&top 0.19453125 $&decision >> decisions.csv
let trial = code + 32
let drive = (floor(trial / 1) - 2*floor(trial / 2))*1.8
alter VB0 = $&drive
let drive = (floor(trial / 2) - 2*floor(trial / 4))*1.8
alter VB1 = $&drive
let drive = (floor(trial / 4) - 2*floor(trial / 8))*1.8
alter VB2 = $&drive
let drive = (floor(trial / 8) - 2*floor(trial / 16))*1.8
alter VB3 = $&drive
let drive = (floor(trial / 16) - 2*floor(trial / 32))*1.8
alter VB4 = $&drive
let drive = (floor(trial / 32) - 2*floor(trial / 64))*1.8
alter VB5 = $&drive
let drive = (floor(trial / 64) - 2*floor(trial / 128))*1.8
alter VB6 = $&drive
let drive = (floor(trial / 128) - 2*floor(trial / 256))*1.8
alter VB7 = $&drive
stop when time = 0.0008
resume
delete all
let endpoint = length(time)-1
let cmp = v(COMP)[endpoint]
let top = v(TOP)[endpoint]
let decision = 0
if cmp >= 0.9
let code = trial
let decision = 1
end
echo 44 5 $&trial $&cmp $&top 0.19453125 $&decision >> decisions.csv
let trial = code + 16
let drive = (floor(trial / 1) - 2*floor(trial / 2))*1.8
alter VB0 = $&drive
let drive = (floor(trial / 2) - 2*floor(trial / 4))*1.8
alter VB1 = $&drive
let drive = (floor(trial / 4) - 2*floor(trial / 8))*1.8
alter VB2 = $&drive
let drive = (floor(trial / 8) - 2*floor(trial / 16))*1.8
alter VB3 = $&drive
let drive = (floor(trial / 16) - 2*floor(trial / 32))*1.8
alter VB4 = $&drive
let drive = (floor(trial / 32) - 2*floor(trial / 64))*1.8
alter VB5 = $&drive
let drive = (floor(trial / 64) - 2*floor(trial / 128))*1.8
alter VB6 = $&drive
let drive = (floor(trial / 128) - 2*floor(trial / 256))*1.8
alter VB7 = $&drive
stop when time = 0.000802
resume
delete all
let endpoint = length(time)-1
let cmp = v(COMP)[endpoint]
let top = v(TOP)[endpoint]
let decision = 0
if cmp >= 0.9
let code = trial
let decision = 1
end
echo 44 4 $&trial $&cmp $&top 0.19453125 $&decision >> decisions.csv
let trial = code + 8
let drive = (floor(trial / 1) - 2*floor(trial / 2))*1.8
alter VB0 = $&drive
let drive = (floor(trial / 2) - 2*floor(trial / 4))*1.8
alter VB1 = $&drive
let drive = (floor(trial / 4) - 2*floor(trial / 8))*1.8
alter VB2 = $&drive
let drive = (floor(trial / 8) - 2*floor(trial / 16))*1.8
alter VB3 = $&drive
let drive = (floor(trial / 16) - 2*floor(trial / 32))*1.8
alter VB4 = $&drive
let drive = (floor(trial / 32) - 2*floor(trial / 64))*1.8
alter VB5 = $&drive
let drive = (floor(trial / 64) - 2*floor(trial / 128))*1.8
alter VB6 = $&drive
let drive = (floor(trial / 128) - 2*floor(trial / 256))*1.8
alter VB7 = $&drive
stop when time = 0.000804
resume
delete all
let endpoint = length(time)-1
let cmp = v(COMP)[endpoint]
let top = v(TOP)[endpoint]
let decision = 0
if cmp >= 0.9
let code = trial
let decision = 1
end
echo 44 3 $&trial $&cmp $&top 0.19453125 $&decision >> decisions.csv
let trial = code + 4
let drive = (floor(trial / 1) - 2*floor(trial / 2))*1.8
alter VB0 = $&drive
let drive = (floor(trial / 2) - 2*floor(trial / 4))*1.8
alter VB1 = $&drive
let drive = (floor(trial / 4) - 2*floor(trial / 8))*1.8
alter VB2 = $&drive
let drive = (floor(trial / 8) - 2*floor(trial / 16))*1.8
alter VB3 = $&drive
let drive = (floor(trial / 16) - 2*floor(trial / 32))*1.8
alter VB4 = $&drive
let drive = (floor(trial / 32) - 2*floor(trial / 64))*1.8
alter VB5 = $&drive
let drive = (floor(trial / 64) - 2*floor(trial / 128))*1.8
alter VB6 = $&drive
let drive = (floor(trial / 128) - 2*floor(trial / 256))*1.8
alter VB7 = $&drive
stop when time = 0.000806
resume
delete all
let endpoint = length(time)-1
let cmp = v(COMP)[endpoint]
let top = v(TOP)[endpoint]
let decision = 0
if cmp >= 0.9
let code = trial
let decision = 1
end
echo 44 2 $&trial $&cmp $&top 0.19453125 $&decision >> decisions.csv
let trial = code + 2
let drive = (floor(trial / 1) - 2*floor(trial / 2))*1.8
alter VB0 = $&drive
let drive = (floor(trial / 2) - 2*floor(trial / 4))*1.8
alter VB1 = $&drive
let drive = (floor(trial / 4) - 2*floor(trial / 8))*1.8
alter VB2 = $&drive
let drive = (floor(trial / 8) - 2*floor(trial / 16))*1.8
alter VB3 = $&drive
let drive = (floor(trial / 16) - 2*floor(trial / 32))*1.8
alter VB4 = $&drive
let drive = (floor(trial / 32) - 2*floor(trial / 64))*1.8
alter VB5 = $&drive
let drive = (floor(trial / 64) - 2*floor(trial / 128))*1.8
alter VB6 = $&drive
let drive = (floor(trial / 128) - 2*floor(trial / 256))*1.8
alter VB7 = $&drive
stop when time = 0.000808
resume
delete all
let endpoint = length(time)-1
let cmp = v(COMP)[endpoint]
let top = v(TOP)[endpoint]
let decision = 0
if cmp >= 0.9
let code = trial
let decision = 1
end
echo 44 1 $&trial $&cmp $&top 0.19453125 $&decision >> decisions.csv
let trial = code + 1
let drive = (floor(trial / 1) - 2*floor(trial / 2))*1.8
alter VB0 = $&drive
let drive = (floor(trial / 2) - 2*floor(trial / 4))*1.8
alter VB1 = $&drive
let drive = (floor(trial / 4) - 2*floor(trial / 8))*1.8
alter VB2 = $&drive
let drive = (floor(trial / 8) - 2*floor(trial / 16))*1.8
alter VB3 = $&drive
let drive = (floor(trial / 16) - 2*floor(trial / 32))*1.8
alter VB4 = $&drive
let drive = (floor(trial / 32) - 2*floor(trial / 64))*1.8
alter VB5 = $&drive
let drive = (floor(trial / 64) - 2*floor(trial / 128))*1.8
alter VB6 = $&drive
let drive = (floor(trial / 128) - 2*floor(trial / 256))*1.8
alter VB7 = $&drive
stop when time = 0.00081
resume
delete all
let endpoint = length(time)-1
let cmp = v(COMP)[endpoint]
let top = v(TOP)[endpoint]
let decision = 0
if cmp >= 0.9
let code = trial
let decision = 1
end
echo 44 0 $&trial $&cmp $&top 0.19453125 $&decision >> decisions.csv
alter VIN = 0.19921875
alter VSAMPLE = 1.8
alter VB0 = 0
alter VB1 = 0
alter VB2 = 0
alter VB3 = 0
alter VB4 = 0
alter VB5 = 0
alter VB6 = 0
alter VB7 = 0
let code = 0
stop when time = 0.000812
resume
delete all
alter VSAMPLE = 0
let trial = code + 128
let drive = (floor(trial / 1) - 2*floor(trial / 2))*1.8
alter VB0 = $&drive
let drive = (floor(trial / 2) - 2*floor(trial / 4))*1.8
alter VB1 = $&drive
let drive = (floor(trial / 4) - 2*floor(trial / 8))*1.8
alter VB2 = $&drive
let drive = (floor(trial / 8) - 2*floor(trial / 16))*1.8
alter VB3 = $&drive
let drive = (floor(trial / 16) - 2*floor(trial / 32))*1.8
alter VB4 = $&drive
let drive = (floor(trial / 32) - 2*floor(trial / 64))*1.8
alter VB5 = $&drive
let drive = (floor(trial / 64) - 2*floor(trial / 128))*1.8
alter VB6 = $&drive
let drive = (floor(trial / 128) - 2*floor(trial / 256))*1.8
alter VB7 = $&drive
stop when time = 0.000814
resume
delete all
let endpoint = length(time)-1
let cmp = v(COMP)[endpoint]
let top = v(TOP)[endpoint]
let decision = 0
if cmp >= 0.9
let code = trial
let decision = 1
end
echo 45 7 $&trial $&cmp $&top 0.19921875 $&decision >> decisions.csv
let trial = code + 64
let drive = (floor(trial / 1) - 2*floor(trial / 2))*1.8
alter VB0 = $&drive
let drive = (floor(trial / 2) - 2*floor(trial / 4))*1.8
alter VB1 = $&drive
let drive = (floor(trial / 4) - 2*floor(trial / 8))*1.8
alter VB2 = $&drive
let drive = (floor(trial / 8) - 2*floor(trial / 16))*1.8
alter VB3 = $&drive
let drive = (floor(trial / 16) - 2*floor(trial / 32))*1.8
alter VB4 = $&drive
let drive = (floor(trial / 32) - 2*floor(trial / 64))*1.8
alter VB5 = $&drive
let drive = (floor(trial / 64) - 2*floor(trial / 128))*1.8
alter VB6 = $&drive
let drive = (floor(trial / 128) - 2*floor(trial / 256))*1.8
alter VB7 = $&drive
stop when time = 0.000816
resume
delete all
let endpoint = length(time)-1
let cmp = v(COMP)[endpoint]
let top = v(TOP)[endpoint]
let decision = 0
if cmp >= 0.9
let code = trial
let decision = 1
end
echo 45 6 $&trial $&cmp $&top 0.19921875 $&decision >> decisions.csv
let trial = code + 32
let drive = (floor(trial / 1) - 2*floor(trial / 2))*1.8
alter VB0 = $&drive
let drive = (floor(trial / 2) - 2*floor(trial / 4))*1.8
alter VB1 = $&drive
let drive = (floor(trial / 4) - 2*floor(trial / 8))*1.8
alter VB2 = $&drive
let drive = (floor(trial / 8) - 2*floor(trial / 16))*1.8
alter VB3 = $&drive
let drive = (floor(trial / 16) - 2*floor(trial / 32))*1.8
alter VB4 = $&drive
let drive = (floor(trial / 32) - 2*floor(trial / 64))*1.8
alter VB5 = $&drive
let drive = (floor(trial / 64) - 2*floor(trial / 128))*1.8
alter VB6 = $&drive
let drive = (floor(trial / 128) - 2*floor(trial / 256))*1.8
alter VB7 = $&drive
stop when time = 0.000818
resume
delete all
let endpoint = length(time)-1
let cmp = v(COMP)[endpoint]
let top = v(TOP)[endpoint]
let decision = 0
if cmp >= 0.9
let code = trial
let decision = 1
end
echo 45 5 $&trial $&cmp $&top 0.19921875 $&decision >> decisions.csv
let trial = code + 16
let drive = (floor(trial / 1) - 2*floor(trial / 2))*1.8
alter VB0 = $&drive
let drive = (floor(trial / 2) - 2*floor(trial / 4))*1.8
alter VB1 = $&drive
let drive = (floor(trial / 4) - 2*floor(trial / 8))*1.8
alter VB2 = $&drive
let drive = (floor(trial / 8) - 2*floor(trial / 16))*1.8
alter VB3 = $&drive
let drive = (floor(trial / 16) - 2*floor(trial / 32))*1.8
alter VB4 = $&drive
let drive = (floor(trial / 32) - 2*floor(trial / 64))*1.8
alter VB5 = $&drive
let drive = (floor(trial / 64) - 2*floor(trial / 128))*1.8
alter VB6 = $&drive
let drive = (floor(trial / 128) - 2*floor(trial / 256))*1.8
alter VB7 = $&drive
stop when time = 0.00082
resume
delete all
let endpoint = length(time)-1
let cmp = v(COMP)[endpoint]
let top = v(TOP)[endpoint]
let decision = 0
if cmp >= 0.9
let code = trial
let decision = 1
end
echo 45 4 $&trial $&cmp $&top 0.19921875 $&decision >> decisions.csv
let trial = code + 8
let drive = (floor(trial / 1) - 2*floor(trial / 2))*1.8
alter VB0 = $&drive
let drive = (floor(trial / 2) - 2*floor(trial / 4))*1.8
alter VB1 = $&drive
let drive = (floor(trial / 4) - 2*floor(trial / 8))*1.8
alter VB2 = $&drive
let drive = (floor(trial / 8) - 2*floor(trial / 16))*1.8
alter VB3 = $&drive
let drive = (floor(trial / 16) - 2*floor(trial / 32))*1.8
alter VB4 = $&drive
let drive = (floor(trial / 32) - 2*floor(trial / 64))*1.8
alter VB5 = $&drive
let drive = (floor(trial / 64) - 2*floor(trial / 128))*1.8
alter VB6 = $&drive
let drive = (floor(trial / 128) - 2*floor(trial / 256))*1.8
alter VB7 = $&drive
stop when time = 0.000822
resume
delete all
let endpoint = length(time)-1
let cmp = v(COMP)[endpoint]
let top = v(TOP)[endpoint]
let decision = 0
if cmp >= 0.9
let code = trial
let decision = 1
end
echo 45 3 $&trial $&cmp $&top 0.19921875 $&decision >> decisions.csv
let trial = code + 4
let drive = (floor(trial / 1) - 2*floor(trial / 2))*1.8
alter VB0 = $&drive
let drive = (floor(trial / 2) - 2*floor(trial / 4))*1.8
alter VB1 = $&drive
let drive = (floor(trial / 4) - 2*floor(trial / 8))*1.8
alter VB2 = $&drive
let drive = (floor(trial / 8) - 2*floor(trial / 16))*1.8
alter VB3 = $&drive
let drive = (floor(trial / 16) - 2*floor(trial / 32))*1.8
alter VB4 = $&drive
let drive = (floor(trial / 32) - 2*floor(trial / 64))*1.8
alter VB5 = $&drive
let drive = (floor(trial / 64) - 2*floor(trial / 128))*1.8
alter VB6 = $&drive
let drive = (floor(trial / 128) - 2*floor(trial / 256))*1.8
alter VB7 = $&drive
stop when time = 0.000824
resume
delete all
let endpoint = length(time)-1
let cmp = v(COMP)[endpoint]
let top = v(TOP)[endpoint]
let decision = 0
if cmp >= 0.9
let code = trial
let decision = 1
end
echo 45 2 $&trial $&cmp $&top 0.19921875 $&decision >> decisions.csv
let trial = code + 2
let drive = (floor(trial / 1) - 2*floor(trial / 2))*1.8
alter VB0 = $&drive
let drive = (floor(trial / 2) - 2*floor(trial / 4))*1.8
alter VB1 = $&drive
let drive = (floor(trial / 4) - 2*floor(trial / 8))*1.8
alter VB2 = $&drive
let drive = (floor(trial / 8) - 2*floor(trial / 16))*1.8
alter VB3 = $&drive
let drive = (floor(trial / 16) - 2*floor(trial / 32))*1.8
alter VB4 = $&drive
let drive = (floor(trial / 32) - 2*floor(trial / 64))*1.8
alter VB5 = $&drive
let drive = (floor(trial / 64) - 2*floor(trial / 128))*1.8
alter VB6 = $&drive
let drive = (floor(trial / 128) - 2*floor(trial / 256))*1.8
alter VB7 = $&drive
stop when time = 0.000826
resume
delete all
let endpoint = length(time)-1
let cmp = v(COMP)[endpoint]
let top = v(TOP)[endpoint]
let decision = 0
if cmp >= 0.9
let code = trial
let decision = 1
end
echo 45 1 $&trial $&cmp $&top 0.19921875 $&decision >> decisions.csv
let trial = code + 1
let drive = (floor(trial / 1) - 2*floor(trial / 2))*1.8
alter VB0 = $&drive
let drive = (floor(trial / 2) - 2*floor(trial / 4))*1.8
alter VB1 = $&drive
let drive = (floor(trial / 4) - 2*floor(trial / 8))*1.8
alter VB2 = $&drive
let drive = (floor(trial / 8) - 2*floor(trial / 16))*1.8
alter VB3 = $&drive
let drive = (floor(trial / 16) - 2*floor(trial / 32))*1.8
alter VB4 = $&drive
let drive = (floor(trial / 32) - 2*floor(trial / 64))*1.8
alter VB5 = $&drive
let drive = (floor(trial / 64) - 2*floor(trial / 128))*1.8
alter VB6 = $&drive
let drive = (floor(trial / 128) - 2*floor(trial / 256))*1.8
alter VB7 = $&drive
stop when time = 0.000828
resume
delete all
let endpoint = length(time)-1
let cmp = v(COMP)[endpoint]
let top = v(TOP)[endpoint]
let decision = 0
if cmp >= 0.9
let code = trial
let decision = 1
end
echo 45 0 $&trial $&cmp $&top 0.19921875 $&decision >> decisions.csv
alter VIN = 0.20390625
alter VSAMPLE = 1.8
alter VB0 = 0
alter VB1 = 0
alter VB2 = 0
alter VB3 = 0
alter VB4 = 0
alter VB5 = 0
alter VB6 = 0
alter VB7 = 0
let code = 0
stop when time = 0.00083
resume
delete all
alter VSAMPLE = 0
let trial = code + 128
let drive = (floor(trial / 1) - 2*floor(trial / 2))*1.8
alter VB0 = $&drive
let drive = (floor(trial / 2) - 2*floor(trial / 4))*1.8
alter VB1 = $&drive
let drive = (floor(trial / 4) - 2*floor(trial / 8))*1.8
alter VB2 = $&drive
let drive = (floor(trial / 8) - 2*floor(trial / 16))*1.8
alter VB3 = $&drive
let drive = (floor(trial / 16) - 2*floor(trial / 32))*1.8
alter VB4 = $&drive
let drive = (floor(trial / 32) - 2*floor(trial / 64))*1.8
alter VB5 = $&drive
let drive = (floor(trial / 64) - 2*floor(trial / 128))*1.8
alter VB6 = $&drive
let drive = (floor(trial / 128) - 2*floor(trial / 256))*1.8
alter VB7 = $&drive
stop when time = 0.000832
resume
delete all
let endpoint = length(time)-1
let cmp = v(COMP)[endpoint]
let top = v(TOP)[endpoint]
let decision = 0
if cmp >= 0.9
let code = trial
let decision = 1
end
echo 46 7 $&trial $&cmp $&top 0.20390625 $&decision >> decisions.csv
let trial = code + 64
let drive = (floor(trial / 1) - 2*floor(trial / 2))*1.8
alter VB0 = $&drive
let drive = (floor(trial / 2) - 2*floor(trial / 4))*1.8
alter VB1 = $&drive
let drive = (floor(trial / 4) - 2*floor(trial / 8))*1.8
alter VB2 = $&drive
let drive = (floor(trial / 8) - 2*floor(trial / 16))*1.8
alter VB3 = $&drive
let drive = (floor(trial / 16) - 2*floor(trial / 32))*1.8
alter VB4 = $&drive
let drive = (floor(trial / 32) - 2*floor(trial / 64))*1.8
alter VB5 = $&drive
let drive = (floor(trial / 64) - 2*floor(trial / 128))*1.8
alter VB6 = $&drive
let drive = (floor(trial / 128) - 2*floor(trial / 256))*1.8
alter VB7 = $&drive
stop when time = 0.000834
resume
delete all
let endpoint = length(time)-1
let cmp = v(COMP)[endpoint]
let top = v(TOP)[endpoint]
let decision = 0
if cmp >= 0.9
let code = trial
let decision = 1
end
echo 46 6 $&trial $&cmp $&top 0.20390625 $&decision >> decisions.csv
let trial = code + 32
let drive = (floor(trial / 1) - 2*floor(trial / 2))*1.8
alter VB0 = $&drive
let drive = (floor(trial / 2) - 2*floor(trial / 4))*1.8
alter VB1 = $&drive
let drive = (floor(trial / 4) - 2*floor(trial / 8))*1.8
alter VB2 = $&drive
let drive = (floor(trial / 8) - 2*floor(trial / 16))*1.8
alter VB3 = $&drive
let drive = (floor(trial / 16) - 2*floor(trial / 32))*1.8
alter VB4 = $&drive
let drive = (floor(trial / 32) - 2*floor(trial / 64))*1.8
alter VB5 = $&drive
let drive = (floor(trial / 64) - 2*floor(trial / 128))*1.8
alter VB6 = $&drive
let drive = (floor(trial / 128) - 2*floor(trial / 256))*1.8
alter VB7 = $&drive
stop when time = 0.000836
resume
delete all
let endpoint = length(time)-1
let cmp = v(COMP)[endpoint]
let top = v(TOP)[endpoint]
let decision = 0
if cmp >= 0.9
let code = trial
let decision = 1
end
echo 46 5 $&trial $&cmp $&top 0.20390625 $&decision >> decisions.csv
let trial = code + 16
let drive = (floor(trial / 1) - 2*floor(trial / 2))*1.8
alter VB0 = $&drive
let drive = (floor(trial / 2) - 2*floor(trial / 4))*1.8
alter VB1 = $&drive
let drive = (floor(trial / 4) - 2*floor(trial / 8))*1.8
alter VB2 = $&drive
let drive = (floor(trial / 8) - 2*floor(trial / 16))*1.8
alter VB3 = $&drive
let drive = (floor(trial / 16) - 2*floor(trial / 32))*1.8
alter VB4 = $&drive
let drive = (floor(trial / 32) - 2*floor(trial / 64))*1.8
alter VB5 = $&drive
let drive = (floor(trial / 64) - 2*floor(trial / 128))*1.8
alter VB6 = $&drive
let drive = (floor(trial / 128) - 2*floor(trial / 256))*1.8
alter VB7 = $&drive
stop when time = 0.000838
resume
delete all
let endpoint = length(time)-1
let cmp = v(COMP)[endpoint]
let top = v(TOP)[endpoint]
let decision = 0
if cmp >= 0.9
let code = trial
let decision = 1
end
echo 46 4 $&trial $&cmp $&top 0.20390625 $&decision >> decisions.csv
let trial = code + 8
let drive = (floor(trial / 1) - 2*floor(trial / 2))*1.8
alter VB0 = $&drive
let drive = (floor(trial / 2) - 2*floor(trial / 4))*1.8
alter VB1 = $&drive
let drive = (floor(trial / 4) - 2*floor(trial / 8))*1.8
alter VB2 = $&drive
let drive = (floor(trial / 8) - 2*floor(trial / 16))*1.8
alter VB3 = $&drive
let drive = (floor(trial / 16) - 2*floor(trial / 32))*1.8
alter VB4 = $&drive
let drive = (floor(trial / 32) - 2*floor(trial / 64))*1.8
alter VB5 = $&drive
let drive = (floor(trial / 64) - 2*floor(trial / 128))*1.8
alter VB6 = $&drive
let drive = (floor(trial / 128) - 2*floor(trial / 256))*1.8
alter VB7 = $&drive
stop when time = 0.00084
resume
delete all
let endpoint = length(time)-1
let cmp = v(COMP)[endpoint]
let top = v(TOP)[endpoint]
let decision = 0
if cmp >= 0.9
let code = trial
let decision = 1
end
echo 46 3 $&trial $&cmp $&top 0.20390625 $&decision >> decisions.csv
let trial = code + 4
let drive = (floor(trial / 1) - 2*floor(trial / 2))*1.8
alter VB0 = $&drive
let drive = (floor(trial / 2) - 2*floor(trial / 4))*1.8
alter VB1 = $&drive
let drive = (floor(trial / 4) - 2*floor(trial / 8))*1.8
alter VB2 = $&drive
let drive = (floor(trial / 8) - 2*floor(trial / 16))*1.8
alter VB3 = $&drive
let drive = (floor(trial / 16) - 2*floor(trial / 32))*1.8
alter VB4 = $&drive
let drive = (floor(trial / 32) - 2*floor(trial / 64))*1.8
alter VB5 = $&drive
let drive = (floor(trial / 64) - 2*floor(trial / 128))*1.8
alter VB6 = $&drive
let drive = (floor(trial / 128) - 2*floor(trial / 256))*1.8
alter VB7 = $&drive
stop when time = 0.000842
resume
delete all
let endpoint = length(time)-1
let cmp = v(COMP)[endpoint]
let top = v(TOP)[endpoint]
let decision = 0
if cmp >= 0.9
let code = trial
let decision = 1
end
echo 46 2 $&trial $&cmp $&top 0.20390625 $&decision >> decisions.csv
let trial = code + 2
let drive = (floor(trial / 1) - 2*floor(trial / 2))*1.8
alter VB0 = $&drive
let drive = (floor(trial / 2) - 2*floor(trial / 4))*1.8
alter VB1 = $&drive
let drive = (floor(trial / 4) - 2*floor(trial / 8))*1.8
alter VB2 = $&drive
let drive = (floor(trial / 8) - 2*floor(trial / 16))*1.8
alter VB3 = $&drive
let drive = (floor(trial / 16) - 2*floor(trial / 32))*1.8
alter VB4 = $&drive
let drive = (floor(trial / 32) - 2*floor(trial / 64))*1.8
alter VB5 = $&drive
let drive = (floor(trial / 64) - 2*floor(trial / 128))*1.8
alter VB6 = $&drive
let drive = (floor(trial / 128) - 2*floor(trial / 256))*1.8
alter VB7 = $&drive
stop when time = 0.000844
resume
delete all
let endpoint = length(time)-1
let cmp = v(COMP)[endpoint]
let top = v(TOP)[endpoint]
let decision = 0
if cmp >= 0.9
let code = trial
let decision = 1
end
echo 46 1 $&trial $&cmp $&top 0.20390625 $&decision >> decisions.csv
let trial = code + 1
let drive = (floor(trial / 1) - 2*floor(trial / 2))*1.8
alter VB0 = $&drive
let drive = (floor(trial / 2) - 2*floor(trial / 4))*1.8
alter VB1 = $&drive
let drive = (floor(trial / 4) - 2*floor(trial / 8))*1.8
alter VB2 = $&drive
let drive = (floor(trial / 8) - 2*floor(trial / 16))*1.8
alter VB3 = $&drive
let drive = (floor(trial / 16) - 2*floor(trial / 32))*1.8
alter VB4 = $&drive
let drive = (floor(trial / 32) - 2*floor(trial / 64))*1.8
alter VB5 = $&drive
let drive = (floor(trial / 64) - 2*floor(trial / 128))*1.8
alter VB6 = $&drive
let drive = (floor(trial / 128) - 2*floor(trial / 256))*1.8
alter VB7 = $&drive
stop when time = 0.000846
resume
delete all
let endpoint = length(time)-1
let cmp = v(COMP)[endpoint]
let top = v(TOP)[endpoint]
let decision = 0
if cmp >= 0.9
let code = trial
let decision = 1
end
echo 46 0 $&trial $&cmp $&top 0.20390625 $&decision >> decisions.csv
alter VIN = 0.20859375
alter VSAMPLE = 1.8
alter VB0 = 0
alter VB1 = 0
alter VB2 = 0
alter VB3 = 0
alter VB4 = 0
alter VB5 = 0
alter VB6 = 0
alter VB7 = 0
let code = 0
stop when time = 0.000848
resume
delete all
alter VSAMPLE = 0
let trial = code + 128
let drive = (floor(trial / 1) - 2*floor(trial / 2))*1.8
alter VB0 = $&drive
let drive = (floor(trial / 2) - 2*floor(trial / 4))*1.8
alter VB1 = $&drive
let drive = (floor(trial / 4) - 2*floor(trial / 8))*1.8
alter VB2 = $&drive
let drive = (floor(trial / 8) - 2*floor(trial / 16))*1.8
alter VB3 = $&drive
let drive = (floor(trial / 16) - 2*floor(trial / 32))*1.8
alter VB4 = $&drive
let drive = (floor(trial / 32) - 2*floor(trial / 64))*1.8
alter VB5 = $&drive
let drive = (floor(trial / 64) - 2*floor(trial / 128))*1.8
alter VB6 = $&drive
let drive = (floor(trial / 128) - 2*floor(trial / 256))*1.8
alter VB7 = $&drive
stop when time = 0.00085
resume
delete all
let endpoint = length(time)-1
let cmp = v(COMP)[endpoint]
let top = v(TOP)[endpoint]
let decision = 0
if cmp >= 0.9
let code = trial
let decision = 1
end
echo 47 7 $&trial $&cmp $&top 0.20859375 $&decision >> decisions.csv
let trial = code + 64
let drive = (floor(trial / 1) - 2*floor(trial / 2))*1.8
alter VB0 = $&drive
let drive = (floor(trial / 2) - 2*floor(trial / 4))*1.8
alter VB1 = $&drive
let drive = (floor(trial / 4) - 2*floor(trial / 8))*1.8
alter VB2 = $&drive
let drive = (floor(trial / 8) - 2*floor(trial / 16))*1.8
alter VB3 = $&drive
let drive = (floor(trial / 16) - 2*floor(trial / 32))*1.8
alter VB4 = $&drive
let drive = (floor(trial / 32) - 2*floor(trial / 64))*1.8
alter VB5 = $&drive
let drive = (floor(trial / 64) - 2*floor(trial / 128))*1.8
alter VB6 = $&drive
let drive = (floor(trial / 128) - 2*floor(trial / 256))*1.8
alter VB7 = $&drive
stop when time = 0.000852
resume
delete all
let endpoint = length(time)-1
let cmp = v(COMP)[endpoint]
let top = v(TOP)[endpoint]
let decision = 0
if cmp >= 0.9
let code = trial
let decision = 1
end
echo 47 6 $&trial $&cmp $&top 0.20859375 $&decision >> decisions.csv
let trial = code + 32
let drive = (floor(trial / 1) - 2*floor(trial / 2))*1.8
alter VB0 = $&drive
let drive = (floor(trial / 2) - 2*floor(trial / 4))*1.8
alter VB1 = $&drive
let drive = (floor(trial / 4) - 2*floor(trial / 8))*1.8
alter VB2 = $&drive
let drive = (floor(trial / 8) - 2*floor(trial / 16))*1.8
alter VB3 = $&drive
let drive = (floor(trial / 16) - 2*floor(trial / 32))*1.8
alter VB4 = $&drive
let drive = (floor(trial / 32) - 2*floor(trial / 64))*1.8
alter VB5 = $&drive
let drive = (floor(trial / 64) - 2*floor(trial / 128))*1.8
alter VB6 = $&drive
let drive = (floor(trial / 128) - 2*floor(trial / 256))*1.8
alter VB7 = $&drive
stop when time = 0.000854
resume
delete all
let endpoint = length(time)-1
let cmp = v(COMP)[endpoint]
let top = v(TOP)[endpoint]
let decision = 0
if cmp >= 0.9
let code = trial
let decision = 1
end
echo 47 5 $&trial $&cmp $&top 0.20859375 $&decision >> decisions.csv
let trial = code + 16
let drive = (floor(trial / 1) - 2*floor(trial / 2))*1.8
alter VB0 = $&drive
let drive = (floor(trial / 2) - 2*floor(trial / 4))*1.8
alter VB1 = $&drive
let drive = (floor(trial / 4) - 2*floor(trial / 8))*1.8
alter VB2 = $&drive
let drive = (floor(trial / 8) - 2*floor(trial / 16))*1.8
alter VB3 = $&drive
let drive = (floor(trial / 16) - 2*floor(trial / 32))*1.8
alter VB4 = $&drive
let drive = (floor(trial / 32) - 2*floor(trial / 64))*1.8
alter VB5 = $&drive
let drive = (floor(trial / 64) - 2*floor(trial / 128))*1.8
alter VB6 = $&drive
let drive = (floor(trial / 128) - 2*floor(trial / 256))*1.8
alter VB7 = $&drive
stop when time = 0.000856
resume
delete all
let endpoint = length(time)-1
let cmp = v(COMP)[endpoint]
let top = v(TOP)[endpoint]
let decision = 0
if cmp >= 0.9
let code = trial
let decision = 1
end
echo 47 4 $&trial $&cmp $&top 0.20859375 $&decision >> decisions.csv
let trial = code + 8
let drive = (floor(trial / 1) - 2*floor(trial / 2))*1.8
alter VB0 = $&drive
let drive = (floor(trial / 2) - 2*floor(trial / 4))*1.8
alter VB1 = $&drive
let drive = (floor(trial / 4) - 2*floor(trial / 8))*1.8
alter VB2 = $&drive
let drive = (floor(trial / 8) - 2*floor(trial / 16))*1.8
alter VB3 = $&drive
let drive = (floor(trial / 16) - 2*floor(trial / 32))*1.8
alter VB4 = $&drive
let drive = (floor(trial / 32) - 2*floor(trial / 64))*1.8
alter VB5 = $&drive
let drive = (floor(trial / 64) - 2*floor(trial / 128))*1.8
alter VB6 = $&drive
let drive = (floor(trial / 128) - 2*floor(trial / 256))*1.8
alter VB7 = $&drive
stop when time = 0.000858
resume
delete all
let endpoint = length(time)-1
let cmp = v(COMP)[endpoint]
let top = v(TOP)[endpoint]
let decision = 0
if cmp >= 0.9
let code = trial
let decision = 1
end
echo 47 3 $&trial $&cmp $&top 0.20859375 $&decision >> decisions.csv
let trial = code + 4
let drive = (floor(trial / 1) - 2*floor(trial / 2))*1.8
alter VB0 = $&drive
let drive = (floor(trial / 2) - 2*floor(trial / 4))*1.8
alter VB1 = $&drive
let drive = (floor(trial / 4) - 2*floor(trial / 8))*1.8
alter VB2 = $&drive
let drive = (floor(trial / 8) - 2*floor(trial / 16))*1.8
alter VB3 = $&drive
let drive = (floor(trial / 16) - 2*floor(trial / 32))*1.8
alter VB4 = $&drive
let drive = (floor(trial / 32) - 2*floor(trial / 64))*1.8
alter VB5 = $&drive
let drive = (floor(trial / 64) - 2*floor(trial / 128))*1.8
alter VB6 = $&drive
let drive = (floor(trial / 128) - 2*floor(trial / 256))*1.8
alter VB7 = $&drive
stop when time = 0.00086
resume
delete all
let endpoint = length(time)-1
let cmp = v(COMP)[endpoint]
let top = v(TOP)[endpoint]
let decision = 0
if cmp >= 0.9
let code = trial
let decision = 1
end
echo 47 2 $&trial $&cmp $&top 0.20859375 $&decision >> decisions.csv
let trial = code + 2
let drive = (floor(trial / 1) - 2*floor(trial / 2))*1.8
alter VB0 = $&drive
let drive = (floor(trial / 2) - 2*floor(trial / 4))*1.8
alter VB1 = $&drive
let drive = (floor(trial / 4) - 2*floor(trial / 8))*1.8
alter VB2 = $&drive
let drive = (floor(trial / 8) - 2*floor(trial / 16))*1.8
alter VB3 = $&drive
let drive = (floor(trial / 16) - 2*floor(trial / 32))*1.8
alter VB4 = $&drive
let drive = (floor(trial / 32) - 2*floor(trial / 64))*1.8
alter VB5 = $&drive
let drive = (floor(trial / 64) - 2*floor(trial / 128))*1.8
alter VB6 = $&drive
let drive = (floor(trial / 128) - 2*floor(trial / 256))*1.8
alter VB7 = $&drive
stop when time = 0.000862
resume
delete all
let endpoint = length(time)-1
let cmp = v(COMP)[endpoint]
let top = v(TOP)[endpoint]
let decision = 0
if cmp >= 0.9
let code = trial
let decision = 1
end
echo 47 1 $&trial $&cmp $&top 0.20859375 $&decision >> decisions.csv
let trial = code + 1
let drive = (floor(trial / 1) - 2*floor(trial / 2))*1.8
alter VB0 = $&drive
let drive = (floor(trial / 2) - 2*floor(trial / 4))*1.8
alter VB1 = $&drive
let drive = (floor(trial / 4) - 2*floor(trial / 8))*1.8
alter VB2 = $&drive
let drive = (floor(trial / 8) - 2*floor(trial / 16))*1.8
alter VB3 = $&drive
let drive = (floor(trial / 16) - 2*floor(trial / 32))*1.8
alter VB4 = $&drive
let drive = (floor(trial / 32) - 2*floor(trial / 64))*1.8
alter VB5 = $&drive
let drive = (floor(trial / 64) - 2*floor(trial / 128))*1.8
alter VB6 = $&drive
let drive = (floor(trial / 128) - 2*floor(trial / 256))*1.8
alter VB7 = $&drive
stop when time = 0.000864
resume
delete all
let endpoint = length(time)-1
let cmp = v(COMP)[endpoint]
let top = v(TOP)[endpoint]
let decision = 0
if cmp >= 0.9
let code = trial
let decision = 1
end
echo 47 0 $&trial $&cmp $&top 0.20859375 $&decision >> decisions.csv
alter VIN = 0.21328125
alter VSAMPLE = 1.8
alter VB0 = 0
alter VB1 = 0
alter VB2 = 0
alter VB3 = 0
alter VB4 = 0
alter VB5 = 0
alter VB6 = 0
alter VB7 = 0
let code = 0
stop when time = 0.000866
resume
delete all
alter VSAMPLE = 0
let trial = code + 128
let drive = (floor(trial / 1) - 2*floor(trial / 2))*1.8
alter VB0 = $&drive
let drive = (floor(trial / 2) - 2*floor(trial / 4))*1.8
alter VB1 = $&drive
let drive = (floor(trial / 4) - 2*floor(trial / 8))*1.8
alter VB2 = $&drive
let drive = (floor(trial / 8) - 2*floor(trial / 16))*1.8
alter VB3 = $&drive
let drive = (floor(trial / 16) - 2*floor(trial / 32))*1.8
alter VB4 = $&drive
let drive = (floor(trial / 32) - 2*floor(trial / 64))*1.8
alter VB5 = $&drive
let drive = (floor(trial / 64) - 2*floor(trial / 128))*1.8
alter VB6 = $&drive
let drive = (floor(trial / 128) - 2*floor(trial / 256))*1.8
alter VB7 = $&drive
stop when time = 0.000868
resume
delete all
let endpoint = length(time)-1
let cmp = v(COMP)[endpoint]
let top = v(TOP)[endpoint]
let decision = 0
if cmp >= 0.9
let code = trial
let decision = 1
end
echo 48 7 $&trial $&cmp $&top 0.21328125 $&decision >> decisions.csv
let trial = code + 64
let drive = (floor(trial / 1) - 2*floor(trial / 2))*1.8
alter VB0 = $&drive
let drive = (floor(trial / 2) - 2*floor(trial / 4))*1.8
alter VB1 = $&drive
let drive = (floor(trial / 4) - 2*floor(trial / 8))*1.8
alter VB2 = $&drive
let drive = (floor(trial / 8) - 2*floor(trial / 16))*1.8
alter VB3 = $&drive
let drive = (floor(trial / 16) - 2*floor(trial / 32))*1.8
alter VB4 = $&drive
let drive = (floor(trial / 32) - 2*floor(trial / 64))*1.8
alter VB5 = $&drive
let drive = (floor(trial / 64) - 2*floor(trial / 128))*1.8
alter VB6 = $&drive
let drive = (floor(trial / 128) - 2*floor(trial / 256))*1.8
alter VB7 = $&drive
stop when time = 0.00087
resume
delete all
let endpoint = length(time)-1
let cmp = v(COMP)[endpoint]
let top = v(TOP)[endpoint]
let decision = 0
if cmp >= 0.9
let code = trial
let decision = 1
end
echo 48 6 $&trial $&cmp $&top 0.21328125 $&decision >> decisions.csv
let trial = code + 32
let drive = (floor(trial / 1) - 2*floor(trial / 2))*1.8
alter VB0 = $&drive
let drive = (floor(trial / 2) - 2*floor(trial / 4))*1.8
alter VB1 = $&drive
let drive = (floor(trial / 4) - 2*floor(trial / 8))*1.8
alter VB2 = $&drive
let drive = (floor(trial / 8) - 2*floor(trial / 16))*1.8
alter VB3 = $&drive
let drive = (floor(trial / 16) - 2*floor(trial / 32))*1.8
alter VB4 = $&drive
let drive = (floor(trial / 32) - 2*floor(trial / 64))*1.8
alter VB5 = $&drive
let drive = (floor(trial / 64) - 2*floor(trial / 128))*1.8
alter VB6 = $&drive
let drive = (floor(trial / 128) - 2*floor(trial / 256))*1.8
alter VB7 = $&drive
stop when time = 0.000872
resume
delete all
let endpoint = length(time)-1
let cmp = v(COMP)[endpoint]
let top = v(TOP)[endpoint]
let decision = 0
if cmp >= 0.9
let code = trial
let decision = 1
end
echo 48 5 $&trial $&cmp $&top 0.21328125 $&decision >> decisions.csv
let trial = code + 16
let drive = (floor(trial / 1) - 2*floor(trial / 2))*1.8
alter VB0 = $&drive
let drive = (floor(trial / 2) - 2*floor(trial / 4))*1.8
alter VB1 = $&drive
let drive = (floor(trial / 4) - 2*floor(trial / 8))*1.8
alter VB2 = $&drive
let drive = (floor(trial / 8) - 2*floor(trial / 16))*1.8
alter VB3 = $&drive
let drive = (floor(trial / 16) - 2*floor(trial / 32))*1.8
alter VB4 = $&drive
let drive = (floor(trial / 32) - 2*floor(trial / 64))*1.8
alter VB5 = $&drive
let drive = (floor(trial / 64) - 2*floor(trial / 128))*1.8
alter VB6 = $&drive
let drive = (floor(trial / 128) - 2*floor(trial / 256))*1.8
alter VB7 = $&drive
stop when time = 0.000874
resume
delete all
let endpoint = length(time)-1
let cmp = v(COMP)[endpoint]
let top = v(TOP)[endpoint]
let decision = 0
if cmp >= 0.9
let code = trial
let decision = 1
end
echo 48 4 $&trial $&cmp $&top 0.21328125 $&decision >> decisions.csv
let trial = code + 8
let drive = (floor(trial / 1) - 2*floor(trial / 2))*1.8
alter VB0 = $&drive
let drive = (floor(trial / 2) - 2*floor(trial / 4))*1.8
alter VB1 = $&drive
let drive = (floor(trial / 4) - 2*floor(trial / 8))*1.8
alter VB2 = $&drive
let drive = (floor(trial / 8) - 2*floor(trial / 16))*1.8
alter VB3 = $&drive
let drive = (floor(trial / 16) - 2*floor(trial / 32))*1.8
alter VB4 = $&drive
let drive = (floor(trial / 32) - 2*floor(trial / 64))*1.8
alter VB5 = $&drive
let drive = (floor(trial / 64) - 2*floor(trial / 128))*1.8
alter VB6 = $&drive
let drive = (floor(trial / 128) - 2*floor(trial / 256))*1.8
alter VB7 = $&drive
stop when time = 0.000876
resume
delete all
let endpoint = length(time)-1
let cmp = v(COMP)[endpoint]
let top = v(TOP)[endpoint]
let decision = 0
if cmp >= 0.9
let code = trial
let decision = 1
end
echo 48 3 $&trial $&cmp $&top 0.21328125 $&decision >> decisions.csv
let trial = code + 4
let drive = (floor(trial / 1) - 2*floor(trial / 2))*1.8
alter VB0 = $&drive
let drive = (floor(trial / 2) - 2*floor(trial / 4))*1.8
alter VB1 = $&drive
let drive = (floor(trial / 4) - 2*floor(trial / 8))*1.8
alter VB2 = $&drive
let drive = (floor(trial / 8) - 2*floor(trial / 16))*1.8
alter VB3 = $&drive
let drive = (floor(trial / 16) - 2*floor(trial / 32))*1.8
alter VB4 = $&drive
let drive = (floor(trial / 32) - 2*floor(trial / 64))*1.8
alter VB5 = $&drive
let drive = (floor(trial / 64) - 2*floor(trial / 128))*1.8
alter VB6 = $&drive
let drive = (floor(trial / 128) - 2*floor(trial / 256))*1.8
alter VB7 = $&drive
stop when time = 0.000878
resume
delete all
let endpoint = length(time)-1
let cmp = v(COMP)[endpoint]
let top = v(TOP)[endpoint]
let decision = 0
if cmp >= 0.9
let code = trial
let decision = 1
end
echo 48 2 $&trial $&cmp $&top 0.21328125 $&decision >> decisions.csv
let trial = code + 2
let drive = (floor(trial / 1) - 2*floor(trial / 2))*1.8
alter VB0 = $&drive
let drive = (floor(trial / 2) - 2*floor(trial / 4))*1.8
alter VB1 = $&drive
let drive = (floor(trial / 4) - 2*floor(trial / 8))*1.8
alter VB2 = $&drive
let drive = (floor(trial / 8) - 2*floor(trial / 16))*1.8
alter VB3 = $&drive
let drive = (floor(trial / 16) - 2*floor(trial / 32))*1.8
alter VB4 = $&drive
let drive = (floor(trial / 32) - 2*floor(trial / 64))*1.8
alter VB5 = $&drive
let drive = (floor(trial / 64) - 2*floor(trial / 128))*1.8
alter VB6 = $&drive
let drive = (floor(trial / 128) - 2*floor(trial / 256))*1.8
alter VB7 = $&drive
stop when time = 0.00088
resume
delete all
let endpoint = length(time)-1
let cmp = v(COMP)[endpoint]
let top = v(TOP)[endpoint]
let decision = 0
if cmp >= 0.9
let code = trial
let decision = 1
end
echo 48 1 $&trial $&cmp $&top 0.21328125 $&decision >> decisions.csv
let trial = code + 1
let drive = (floor(trial / 1) - 2*floor(trial / 2))*1.8
alter VB0 = $&drive
let drive = (floor(trial / 2) - 2*floor(trial / 4))*1.8
alter VB1 = $&drive
let drive = (floor(trial / 4) - 2*floor(trial / 8))*1.8
alter VB2 = $&drive
let drive = (floor(trial / 8) - 2*floor(trial / 16))*1.8
alter VB3 = $&drive
let drive = (floor(trial / 16) - 2*floor(trial / 32))*1.8
alter VB4 = $&drive
let drive = (floor(trial / 32) - 2*floor(trial / 64))*1.8
alter VB5 = $&drive
let drive = (floor(trial / 64) - 2*floor(trial / 128))*1.8
alter VB6 = $&drive
let drive = (floor(trial / 128) - 2*floor(trial / 256))*1.8
alter VB7 = $&drive
stop when time = 0.000882
resume
delete all
let endpoint = length(time)-1
let cmp = v(COMP)[endpoint]
let top = v(TOP)[endpoint]
let decision = 0
if cmp >= 0.9
let code = trial
let decision = 1
end
echo 48 0 $&trial $&cmp $&top 0.21328125 $&decision >> decisions.csv
alter VIN = 0.21796875
alter VSAMPLE = 1.8
alter VB0 = 0
alter VB1 = 0
alter VB2 = 0
alter VB3 = 0
alter VB4 = 0
alter VB5 = 0
alter VB6 = 0
alter VB7 = 0
let code = 0
stop when time = 0.000884
resume
delete all
alter VSAMPLE = 0
let trial = code + 128
let drive = (floor(trial / 1) - 2*floor(trial / 2))*1.8
alter VB0 = $&drive
let drive = (floor(trial / 2) - 2*floor(trial / 4))*1.8
alter VB1 = $&drive
let drive = (floor(trial / 4) - 2*floor(trial / 8))*1.8
alter VB2 = $&drive
let drive = (floor(trial / 8) - 2*floor(trial / 16))*1.8
alter VB3 = $&drive
let drive = (floor(trial / 16) - 2*floor(trial / 32))*1.8
alter VB4 = $&drive
let drive = (floor(trial / 32) - 2*floor(trial / 64))*1.8
alter VB5 = $&drive
let drive = (floor(trial / 64) - 2*floor(trial / 128))*1.8
alter VB6 = $&drive
let drive = (floor(trial / 128) - 2*floor(trial / 256))*1.8
alter VB7 = $&drive
stop when time = 0.000886
resume
delete all
let endpoint = length(time)-1
let cmp = v(COMP)[endpoint]
let top = v(TOP)[endpoint]
let decision = 0
if cmp >= 0.9
let code = trial
let decision = 1
end
echo 49 7 $&trial $&cmp $&top 0.21796875 $&decision >> decisions.csv
let trial = code + 64
let drive = (floor(trial / 1) - 2*floor(trial / 2))*1.8
alter VB0 = $&drive
let drive = (floor(trial / 2) - 2*floor(trial / 4))*1.8
alter VB1 = $&drive
let drive = (floor(trial / 4) - 2*floor(trial / 8))*1.8
alter VB2 = $&drive
let drive = (floor(trial / 8) - 2*floor(trial / 16))*1.8
alter VB3 = $&drive
let drive = (floor(trial / 16) - 2*floor(trial / 32))*1.8
alter VB4 = $&drive
let drive = (floor(trial / 32) - 2*floor(trial / 64))*1.8
alter VB5 = $&drive
let drive = (floor(trial / 64) - 2*floor(trial / 128))*1.8
alter VB6 = $&drive
let drive = (floor(trial / 128) - 2*floor(trial / 256))*1.8
alter VB7 = $&drive
stop when time = 0.000888
resume
delete all
let endpoint = length(time)-1
let cmp = v(COMP)[endpoint]
let top = v(TOP)[endpoint]
let decision = 0
if cmp >= 0.9
let code = trial
let decision = 1
end
echo 49 6 $&trial $&cmp $&top 0.21796875 $&decision >> decisions.csv
let trial = code + 32
let drive = (floor(trial / 1) - 2*floor(trial / 2))*1.8
alter VB0 = $&drive
let drive = (floor(trial / 2) - 2*floor(trial / 4))*1.8
alter VB1 = $&drive
let drive = (floor(trial / 4) - 2*floor(trial / 8))*1.8
alter VB2 = $&drive
let drive = (floor(trial / 8) - 2*floor(trial / 16))*1.8
alter VB3 = $&drive
let drive = (floor(trial / 16) - 2*floor(trial / 32))*1.8
alter VB4 = $&drive
let drive = (floor(trial / 32) - 2*floor(trial / 64))*1.8
alter VB5 = $&drive
let drive = (floor(trial / 64) - 2*floor(trial / 128))*1.8
alter VB6 = $&drive
let drive = (floor(trial / 128) - 2*floor(trial / 256))*1.8
alter VB7 = $&drive
stop when time = 0.00089
resume
delete all
let endpoint = length(time)-1
let cmp = v(COMP)[endpoint]
let top = v(TOP)[endpoint]
let decision = 0
if cmp >= 0.9
let code = trial
let decision = 1
end
echo 49 5 $&trial $&cmp $&top 0.21796875 $&decision >> decisions.csv
let trial = code + 16
let drive = (floor(trial / 1) - 2*floor(trial / 2))*1.8
alter VB0 = $&drive
let drive = (floor(trial / 2) - 2*floor(trial / 4))*1.8
alter VB1 = $&drive
let drive = (floor(trial / 4) - 2*floor(trial / 8))*1.8
alter VB2 = $&drive
let drive = (floor(trial / 8) - 2*floor(trial / 16))*1.8
alter VB3 = $&drive
let drive = (floor(trial / 16) - 2*floor(trial / 32))*1.8
alter VB4 = $&drive
let drive = (floor(trial / 32) - 2*floor(trial / 64))*1.8
alter VB5 = $&drive
let drive = (floor(trial / 64) - 2*floor(trial / 128))*1.8
alter VB6 = $&drive
let drive = (floor(trial / 128) - 2*floor(trial / 256))*1.8
alter VB7 = $&drive
stop when time = 0.000892
resume
delete all
let endpoint = length(time)-1
let cmp = v(COMP)[endpoint]
let top = v(TOP)[endpoint]
let decision = 0
if cmp >= 0.9
let code = trial
let decision = 1
end
echo 49 4 $&trial $&cmp $&top 0.21796875 $&decision >> decisions.csv
let trial = code + 8
let drive = (floor(trial / 1) - 2*floor(trial / 2))*1.8
alter VB0 = $&drive
let drive = (floor(trial / 2) - 2*floor(trial / 4))*1.8
alter VB1 = $&drive
let drive = (floor(trial / 4) - 2*floor(trial / 8))*1.8
alter VB2 = $&drive
let drive = (floor(trial / 8) - 2*floor(trial / 16))*1.8
alter VB3 = $&drive
let drive = (floor(trial / 16) - 2*floor(trial / 32))*1.8
alter VB4 = $&drive
let drive = (floor(trial / 32) - 2*floor(trial / 64))*1.8
alter VB5 = $&drive
let drive = (floor(trial / 64) - 2*floor(trial / 128))*1.8
alter VB6 = $&drive
let drive = (floor(trial / 128) - 2*floor(trial / 256))*1.8
alter VB7 = $&drive
stop when time = 0.000894
resume
delete all
let endpoint = length(time)-1
let cmp = v(COMP)[endpoint]
let top = v(TOP)[endpoint]
let decision = 0
if cmp >= 0.9
let code = trial
let decision = 1
end
echo 49 3 $&trial $&cmp $&top 0.21796875 $&decision >> decisions.csv
let trial = code + 4
let drive = (floor(trial / 1) - 2*floor(trial / 2))*1.8
alter VB0 = $&drive
let drive = (floor(trial / 2) - 2*floor(trial / 4))*1.8
alter VB1 = $&drive
let drive = (floor(trial / 4) - 2*floor(trial / 8))*1.8
alter VB2 = $&drive
let drive = (floor(trial / 8) - 2*floor(trial / 16))*1.8
alter VB3 = $&drive
let drive = (floor(trial / 16) - 2*floor(trial / 32))*1.8
alter VB4 = $&drive
let drive = (floor(trial / 32) - 2*floor(trial / 64))*1.8
alter VB5 = $&drive
let drive = (floor(trial / 64) - 2*floor(trial / 128))*1.8
alter VB6 = $&drive
let drive = (floor(trial / 128) - 2*floor(trial / 256))*1.8
alter VB7 = $&drive
stop when time = 0.000896
resume
delete all
let endpoint = length(time)-1
let cmp = v(COMP)[endpoint]
let top = v(TOP)[endpoint]
let decision = 0
if cmp >= 0.9
let code = trial
let decision = 1
end
echo 49 2 $&trial $&cmp $&top 0.21796875 $&decision >> decisions.csv
let trial = code + 2
let drive = (floor(trial / 1) - 2*floor(trial / 2))*1.8
alter VB0 = $&drive
let drive = (floor(trial / 2) - 2*floor(trial / 4))*1.8
alter VB1 = $&drive
let drive = (floor(trial / 4) - 2*floor(trial / 8))*1.8
alter VB2 = $&drive
let drive = (floor(trial / 8) - 2*floor(trial / 16))*1.8
alter VB3 = $&drive
let drive = (floor(trial / 16) - 2*floor(trial / 32))*1.8
alter VB4 = $&drive
let drive = (floor(trial / 32) - 2*floor(trial / 64))*1.8
alter VB5 = $&drive
let drive = (floor(trial / 64) - 2*floor(trial / 128))*1.8
alter VB6 = $&drive
let drive = (floor(trial / 128) - 2*floor(trial / 256))*1.8
alter VB7 = $&drive
stop when time = 0.000898
resume
delete all
let endpoint = length(time)-1
let cmp = v(COMP)[endpoint]
let top = v(TOP)[endpoint]
let decision = 0
if cmp >= 0.9
let code = trial
let decision = 1
end
echo 49 1 $&trial $&cmp $&top 0.21796875 $&decision >> decisions.csv
let trial = code + 1
let drive = (floor(trial / 1) - 2*floor(trial / 2))*1.8
alter VB0 = $&drive
let drive = (floor(trial / 2) - 2*floor(trial / 4))*1.8
alter VB1 = $&drive
let drive = (floor(trial / 4) - 2*floor(trial / 8))*1.8
alter VB2 = $&drive
let drive = (floor(trial / 8) - 2*floor(trial / 16))*1.8
alter VB3 = $&drive
let drive = (floor(trial / 16) - 2*floor(trial / 32))*1.8
alter VB4 = $&drive
let drive = (floor(trial / 32) - 2*floor(trial / 64))*1.8
alter VB5 = $&drive
let drive = (floor(trial / 64) - 2*floor(trial / 128))*1.8
alter VB6 = $&drive
let drive = (floor(trial / 128) - 2*floor(trial / 256))*1.8
alter VB7 = $&drive
stop when time = 0.0009
resume
delete all
let endpoint = length(time)-1
let cmp = v(COMP)[endpoint]
let top = v(TOP)[endpoint]
let decision = 0
if cmp >= 0.9
let code = trial
let decision = 1
end
echo 49 0 $&trial $&cmp $&top 0.21796875 $&decision >> decisions.csv
alter VIN = 0.22265625
alter VSAMPLE = 1.8
alter VB0 = 0
alter VB1 = 0
alter VB2 = 0
alter VB3 = 0
alter VB4 = 0
alter VB5 = 0
alter VB6 = 0
alter VB7 = 0
let code = 0
stop when time = 0.000902
resume
delete all
alter VSAMPLE = 0
let trial = code + 128
let drive = (floor(trial / 1) - 2*floor(trial / 2))*1.8
alter VB0 = $&drive
let drive = (floor(trial / 2) - 2*floor(trial / 4))*1.8
alter VB1 = $&drive
let drive = (floor(trial / 4) - 2*floor(trial / 8))*1.8
alter VB2 = $&drive
let drive = (floor(trial / 8) - 2*floor(trial / 16))*1.8
alter VB3 = $&drive
let drive = (floor(trial / 16) - 2*floor(trial / 32))*1.8
alter VB4 = $&drive
let drive = (floor(trial / 32) - 2*floor(trial / 64))*1.8
alter VB5 = $&drive
let drive = (floor(trial / 64) - 2*floor(trial / 128))*1.8
alter VB6 = $&drive
let drive = (floor(trial / 128) - 2*floor(trial / 256))*1.8
alter VB7 = $&drive
stop when time = 0.000904
resume
delete all
let endpoint = length(time)-1
let cmp = v(COMP)[endpoint]
let top = v(TOP)[endpoint]
let decision = 0
if cmp >= 0.9
let code = trial
let decision = 1
end
echo 50 7 $&trial $&cmp $&top 0.22265625 $&decision >> decisions.csv
let trial = code + 64
let drive = (floor(trial / 1) - 2*floor(trial / 2))*1.8
alter VB0 = $&drive
let drive = (floor(trial / 2) - 2*floor(trial / 4))*1.8
alter VB1 = $&drive
let drive = (floor(trial / 4) - 2*floor(trial / 8))*1.8
alter VB2 = $&drive
let drive = (floor(trial / 8) - 2*floor(trial / 16))*1.8
alter VB3 = $&drive
let drive = (floor(trial / 16) - 2*floor(trial / 32))*1.8
alter VB4 = $&drive
let drive = (floor(trial / 32) - 2*floor(trial / 64))*1.8
alter VB5 = $&drive
let drive = (floor(trial / 64) - 2*floor(trial / 128))*1.8
alter VB6 = $&drive
let drive = (floor(trial / 128) - 2*floor(trial / 256))*1.8
alter VB7 = $&drive
stop when time = 0.000906
resume
delete all
let endpoint = length(time)-1
let cmp = v(COMP)[endpoint]
let top = v(TOP)[endpoint]
let decision = 0
if cmp >= 0.9
let code = trial
let decision = 1
end
echo 50 6 $&trial $&cmp $&top 0.22265625 $&decision >> decisions.csv
let trial = code + 32
let drive = (floor(trial / 1) - 2*floor(trial / 2))*1.8
alter VB0 = $&drive
let drive = (floor(trial / 2) - 2*floor(trial / 4))*1.8
alter VB1 = $&drive
let drive = (floor(trial / 4) - 2*floor(trial / 8))*1.8
alter VB2 = $&drive
let drive = (floor(trial / 8) - 2*floor(trial / 16))*1.8
alter VB3 = $&drive
let drive = (floor(trial / 16) - 2*floor(trial / 32))*1.8
alter VB4 = $&drive
let drive = (floor(trial / 32) - 2*floor(trial / 64))*1.8
alter VB5 = $&drive
let drive = (floor(trial / 64) - 2*floor(trial / 128))*1.8
alter VB6 = $&drive
let drive = (floor(trial / 128) - 2*floor(trial / 256))*1.8
alter VB7 = $&drive
stop when time = 0.000908
resume
delete all
let endpoint = length(time)-1
let cmp = v(COMP)[endpoint]
let top = v(TOP)[endpoint]
let decision = 0
if cmp >= 0.9
let code = trial
let decision = 1
end
echo 50 5 $&trial $&cmp $&top 0.22265625 $&decision >> decisions.csv
let trial = code + 16
let drive = (floor(trial / 1) - 2*floor(trial / 2))*1.8
alter VB0 = $&drive
let drive = (floor(trial / 2) - 2*floor(trial / 4))*1.8
alter VB1 = $&drive
let drive = (floor(trial / 4) - 2*floor(trial / 8))*1.8
alter VB2 = $&drive
let drive = (floor(trial / 8) - 2*floor(trial / 16))*1.8
alter VB3 = $&drive
let drive = (floor(trial / 16) - 2*floor(trial / 32))*1.8
alter VB4 = $&drive
let drive = (floor(trial / 32) - 2*floor(trial / 64))*1.8
alter VB5 = $&drive
let drive = (floor(trial / 64) - 2*floor(trial / 128))*1.8
alter VB6 = $&drive
let drive = (floor(trial / 128) - 2*floor(trial / 256))*1.8
alter VB7 = $&drive
stop when time = 0.00091
resume
delete all
let endpoint = length(time)-1
let cmp = v(COMP)[endpoint]
let top = v(TOP)[endpoint]
let decision = 0
if cmp >= 0.9
let code = trial
let decision = 1
end
echo 50 4 $&trial $&cmp $&top 0.22265625 $&decision >> decisions.csv
let trial = code + 8
let drive = (floor(trial / 1) - 2*floor(trial / 2))*1.8
alter VB0 = $&drive
let drive = (floor(trial / 2) - 2*floor(trial / 4))*1.8
alter VB1 = $&drive
let drive = (floor(trial / 4) - 2*floor(trial / 8))*1.8
alter VB2 = $&drive
let drive = (floor(trial / 8) - 2*floor(trial / 16))*1.8
alter VB3 = $&drive
let drive = (floor(trial / 16) - 2*floor(trial / 32))*1.8
alter VB4 = $&drive
let drive = (floor(trial / 32) - 2*floor(trial / 64))*1.8
alter VB5 = $&drive
let drive = (floor(trial / 64) - 2*floor(trial / 128))*1.8
alter VB6 = $&drive
let drive = (floor(trial / 128) - 2*floor(trial / 256))*1.8
alter VB7 = $&drive
stop when time = 0.000912
resume
delete all
let endpoint = length(time)-1
let cmp = v(COMP)[endpoint]
let top = v(TOP)[endpoint]
let decision = 0
if cmp >= 0.9
let code = trial
let decision = 1
end
echo 50 3 $&trial $&cmp $&top 0.22265625 $&decision >> decisions.csv
let trial = code + 4
let drive = (floor(trial / 1) - 2*floor(trial / 2))*1.8
alter VB0 = $&drive
let drive = (floor(trial / 2) - 2*floor(trial / 4))*1.8
alter VB1 = $&drive
let drive = (floor(trial / 4) - 2*floor(trial / 8))*1.8
alter VB2 = $&drive
let drive = (floor(trial / 8) - 2*floor(trial / 16))*1.8
alter VB3 = $&drive
let drive = (floor(trial / 16) - 2*floor(trial / 32))*1.8
alter VB4 = $&drive
let drive = (floor(trial / 32) - 2*floor(trial / 64))*1.8
alter VB5 = $&drive
let drive = (floor(trial / 64) - 2*floor(trial / 128))*1.8
alter VB6 = $&drive
let drive = (floor(trial / 128) - 2*floor(trial / 256))*1.8
alter VB7 = $&drive
stop when time = 0.000914
resume
delete all
let endpoint = length(time)-1
let cmp = v(COMP)[endpoint]
let top = v(TOP)[endpoint]
let decision = 0
if cmp >= 0.9
let code = trial
let decision = 1
end
echo 50 2 $&trial $&cmp $&top 0.22265625 $&decision >> decisions.csv
let trial = code + 2
let drive = (floor(trial / 1) - 2*floor(trial / 2))*1.8
alter VB0 = $&drive
let drive = (floor(trial / 2) - 2*floor(trial / 4))*1.8
alter VB1 = $&drive
let drive = (floor(trial / 4) - 2*floor(trial / 8))*1.8
alter VB2 = $&drive
let drive = (floor(trial / 8) - 2*floor(trial / 16))*1.8
alter VB3 = $&drive
let drive = (floor(trial / 16) - 2*floor(trial / 32))*1.8
alter VB4 = $&drive
let drive = (floor(trial / 32) - 2*floor(trial / 64))*1.8
alter VB5 = $&drive
let drive = (floor(trial / 64) - 2*floor(trial / 128))*1.8
alter VB6 = $&drive
let drive = (floor(trial / 128) - 2*floor(trial / 256))*1.8
alter VB7 = $&drive
stop when time = 0.000916
resume
delete all
let endpoint = length(time)-1
let cmp = v(COMP)[endpoint]
let top = v(TOP)[endpoint]
let decision = 0
if cmp >= 0.9
let code = trial
let decision = 1
end
echo 50 1 $&trial $&cmp $&top 0.22265625 $&decision >> decisions.csv
let trial = code + 1
let drive = (floor(trial / 1) - 2*floor(trial / 2))*1.8
alter VB0 = $&drive
let drive = (floor(trial / 2) - 2*floor(trial / 4))*1.8
alter VB1 = $&drive
let drive = (floor(trial / 4) - 2*floor(trial / 8))*1.8
alter VB2 = $&drive
let drive = (floor(trial / 8) - 2*floor(trial / 16))*1.8
alter VB3 = $&drive
let drive = (floor(trial / 16) - 2*floor(trial / 32))*1.8
alter VB4 = $&drive
let drive = (floor(trial / 32) - 2*floor(trial / 64))*1.8
alter VB5 = $&drive
let drive = (floor(trial / 64) - 2*floor(trial / 128))*1.8
alter VB6 = $&drive
let drive = (floor(trial / 128) - 2*floor(trial / 256))*1.8
alter VB7 = $&drive
stop when time = 0.000918
resume
delete all
let endpoint = length(time)-1
let cmp = v(COMP)[endpoint]
let top = v(TOP)[endpoint]
let decision = 0
if cmp >= 0.9
let code = trial
let decision = 1
end
echo 50 0 $&trial $&cmp $&top 0.22265625 $&decision >> decisions.csv
alter VIN = 0.22734375
alter VSAMPLE = 1.8
alter VB0 = 0
alter VB1 = 0
alter VB2 = 0
alter VB3 = 0
alter VB4 = 0
alter VB5 = 0
alter VB6 = 0
alter VB7 = 0
let code = 0
stop when time = 0.00092
resume
delete all
alter VSAMPLE = 0
let trial = code + 128
let drive = (floor(trial / 1) - 2*floor(trial / 2))*1.8
alter VB0 = $&drive
let drive = (floor(trial / 2) - 2*floor(trial / 4))*1.8
alter VB1 = $&drive
let drive = (floor(trial / 4) - 2*floor(trial / 8))*1.8
alter VB2 = $&drive
let drive = (floor(trial / 8) - 2*floor(trial / 16))*1.8
alter VB3 = $&drive
let drive = (floor(trial / 16) - 2*floor(trial / 32))*1.8
alter VB4 = $&drive
let drive = (floor(trial / 32) - 2*floor(trial / 64))*1.8
alter VB5 = $&drive
let drive = (floor(trial / 64) - 2*floor(trial / 128))*1.8
alter VB6 = $&drive
let drive = (floor(trial / 128) - 2*floor(trial / 256))*1.8
alter VB7 = $&drive
stop when time = 0.000922
resume
delete all
let endpoint = length(time)-1
let cmp = v(COMP)[endpoint]
let top = v(TOP)[endpoint]
let decision = 0
if cmp >= 0.9
let code = trial
let decision = 1
end
echo 51 7 $&trial $&cmp $&top 0.22734375 $&decision >> decisions.csv
let trial = code + 64
let drive = (floor(trial / 1) - 2*floor(trial / 2))*1.8
alter VB0 = $&drive
let drive = (floor(trial / 2) - 2*floor(trial / 4))*1.8
alter VB1 = $&drive
let drive = (floor(trial / 4) - 2*floor(trial / 8))*1.8
alter VB2 = $&drive
let drive = (floor(trial / 8) - 2*floor(trial / 16))*1.8
alter VB3 = $&drive
let drive = (floor(trial / 16) - 2*floor(trial / 32))*1.8
alter VB4 = $&drive
let drive = (floor(trial / 32) - 2*floor(trial / 64))*1.8
alter VB5 = $&drive
let drive = (floor(trial / 64) - 2*floor(trial / 128))*1.8
alter VB6 = $&drive
let drive = (floor(trial / 128) - 2*floor(trial / 256))*1.8
alter VB7 = $&drive
stop when time = 0.000924
resume
delete all
let endpoint = length(time)-1
let cmp = v(COMP)[endpoint]
let top = v(TOP)[endpoint]
let decision = 0
if cmp >= 0.9
let code = trial
let decision = 1
end
echo 51 6 $&trial $&cmp $&top 0.22734375 $&decision >> decisions.csv
let trial = code + 32
let drive = (floor(trial / 1) - 2*floor(trial / 2))*1.8
alter VB0 = $&drive
let drive = (floor(trial / 2) - 2*floor(trial / 4))*1.8
alter VB1 = $&drive
let drive = (floor(trial / 4) - 2*floor(trial / 8))*1.8
alter VB2 = $&drive
let drive = (floor(trial / 8) - 2*floor(trial / 16))*1.8
alter VB3 = $&drive
let drive = (floor(trial / 16) - 2*floor(trial / 32))*1.8
alter VB4 = $&drive
let drive = (floor(trial / 32) - 2*floor(trial / 64))*1.8
alter VB5 = $&drive
let drive = (floor(trial / 64) - 2*floor(trial / 128))*1.8
alter VB6 = $&drive
let drive = (floor(trial / 128) - 2*floor(trial / 256))*1.8
alter VB7 = $&drive
stop when time = 0.000926
resume
delete all
let endpoint = length(time)-1
let cmp = v(COMP)[endpoint]
let top = v(TOP)[endpoint]
let decision = 0
if cmp >= 0.9
let code = trial
let decision = 1
end
echo 51 5 $&trial $&cmp $&top 0.22734375 $&decision >> decisions.csv
let trial = code + 16
let drive = (floor(trial / 1) - 2*floor(trial / 2))*1.8
alter VB0 = $&drive
let drive = (floor(trial / 2) - 2*floor(trial / 4))*1.8
alter VB1 = $&drive
let drive = (floor(trial / 4) - 2*floor(trial / 8))*1.8
alter VB2 = $&drive
let drive = (floor(trial / 8) - 2*floor(trial / 16))*1.8
alter VB3 = $&drive
let drive = (floor(trial / 16) - 2*floor(trial / 32))*1.8
alter VB4 = $&drive
let drive = (floor(trial / 32) - 2*floor(trial / 64))*1.8
alter VB5 = $&drive
let drive = (floor(trial / 64) - 2*floor(trial / 128))*1.8
alter VB6 = $&drive
let drive = (floor(trial / 128) - 2*floor(trial / 256))*1.8
alter VB7 = $&drive
stop when time = 0.000928
resume
delete all
let endpoint = length(time)-1
let cmp = v(COMP)[endpoint]
let top = v(TOP)[endpoint]
let decision = 0
if cmp >= 0.9
let code = trial
let decision = 1
end
echo 51 4 $&trial $&cmp $&top 0.22734375 $&decision >> decisions.csv
let trial = code + 8
let drive = (floor(trial / 1) - 2*floor(trial / 2))*1.8
alter VB0 = $&drive
let drive = (floor(trial / 2) - 2*floor(trial / 4))*1.8
alter VB1 = $&drive
let drive = (floor(trial / 4) - 2*floor(trial / 8))*1.8
alter VB2 = $&drive
let drive = (floor(trial / 8) - 2*floor(trial / 16))*1.8
alter VB3 = $&drive
let drive = (floor(trial / 16) - 2*floor(trial / 32))*1.8
alter VB4 = $&drive
let drive = (floor(trial / 32) - 2*floor(trial / 64))*1.8
alter VB5 = $&drive
let drive = (floor(trial / 64) - 2*floor(trial / 128))*1.8
alter VB6 = $&drive
let drive = (floor(trial / 128) - 2*floor(trial / 256))*1.8
alter VB7 = $&drive
stop when time = 0.00093
resume
delete all
let endpoint = length(time)-1
let cmp = v(COMP)[endpoint]
let top = v(TOP)[endpoint]
let decision = 0
if cmp >= 0.9
let code = trial
let decision = 1
end
echo 51 3 $&trial $&cmp $&top 0.22734375 $&decision >> decisions.csv
let trial = code + 4
let drive = (floor(trial / 1) - 2*floor(trial / 2))*1.8
alter VB0 = $&drive
let drive = (floor(trial / 2) - 2*floor(trial / 4))*1.8
alter VB1 = $&drive
let drive = (floor(trial / 4) - 2*floor(trial / 8))*1.8
alter VB2 = $&drive
let drive = (floor(trial / 8) - 2*floor(trial / 16))*1.8
alter VB3 = $&drive
let drive = (floor(trial / 16) - 2*floor(trial / 32))*1.8
alter VB4 = $&drive
let drive = (floor(trial / 32) - 2*floor(trial / 64))*1.8
alter VB5 = $&drive
let drive = (floor(trial / 64) - 2*floor(trial / 128))*1.8
alter VB6 = $&drive
let drive = (floor(trial / 128) - 2*floor(trial / 256))*1.8
alter VB7 = $&drive
stop when time = 0.000932
resume
delete all
let endpoint = length(time)-1
let cmp = v(COMP)[endpoint]
let top = v(TOP)[endpoint]
let decision = 0
if cmp >= 0.9
let code = trial
let decision = 1
end
echo 51 2 $&trial $&cmp $&top 0.22734375 $&decision >> decisions.csv
let trial = code + 2
let drive = (floor(trial / 1) - 2*floor(trial / 2))*1.8
alter VB0 = $&drive
let drive = (floor(trial / 2) - 2*floor(trial / 4))*1.8
alter VB1 = $&drive
let drive = (floor(trial / 4) - 2*floor(trial / 8))*1.8
alter VB2 = $&drive
let drive = (floor(trial / 8) - 2*floor(trial / 16))*1.8
alter VB3 = $&drive
let drive = (floor(trial / 16) - 2*floor(trial / 32))*1.8
alter VB4 = $&drive
let drive = (floor(trial / 32) - 2*floor(trial / 64))*1.8
alter VB5 = $&drive
let drive = (floor(trial / 64) - 2*floor(trial / 128))*1.8
alter VB6 = $&drive
let drive = (floor(trial / 128) - 2*floor(trial / 256))*1.8
alter VB7 = $&drive
stop when time = 0.000934
resume
delete all
let endpoint = length(time)-1
let cmp = v(COMP)[endpoint]
let top = v(TOP)[endpoint]
let decision = 0
if cmp >= 0.9
let code = trial
let decision = 1
end
echo 51 1 $&trial $&cmp $&top 0.22734375 $&decision >> decisions.csv
let trial = code + 1
let drive = (floor(trial / 1) - 2*floor(trial / 2))*1.8
alter VB0 = $&drive
let drive = (floor(trial / 2) - 2*floor(trial / 4))*1.8
alter VB1 = $&drive
let drive = (floor(trial / 4) - 2*floor(trial / 8))*1.8
alter VB2 = $&drive
let drive = (floor(trial / 8) - 2*floor(trial / 16))*1.8
alter VB3 = $&drive
let drive = (floor(trial / 16) - 2*floor(trial / 32))*1.8
alter VB4 = $&drive
let drive = (floor(trial / 32) - 2*floor(trial / 64))*1.8
alter VB5 = $&drive
let drive = (floor(trial / 64) - 2*floor(trial / 128))*1.8
alter VB6 = $&drive
let drive = (floor(trial / 128) - 2*floor(trial / 256))*1.8
alter VB7 = $&drive
stop when time = 0.000936
resume
delete all
let endpoint = length(time)-1
let cmp = v(COMP)[endpoint]
let top = v(TOP)[endpoint]
let decision = 0
if cmp >= 0.9
let code = trial
let decision = 1
end
echo 51 0 $&trial $&cmp $&top 0.22734375 $&decision >> decisions.csv
alter VIN = 0.23203125
alter VSAMPLE = 1.8
alter VB0 = 0
alter VB1 = 0
alter VB2 = 0
alter VB3 = 0
alter VB4 = 0
alter VB5 = 0
alter VB6 = 0
alter VB7 = 0
let code = 0
stop when time = 0.000938
resume
delete all
alter VSAMPLE = 0
let trial = code + 128
let drive = (floor(trial / 1) - 2*floor(trial / 2))*1.8
alter VB0 = $&drive
let drive = (floor(trial / 2) - 2*floor(trial / 4))*1.8
alter VB1 = $&drive
let drive = (floor(trial / 4) - 2*floor(trial / 8))*1.8
alter VB2 = $&drive
let drive = (floor(trial / 8) - 2*floor(trial / 16))*1.8
alter VB3 = $&drive
let drive = (floor(trial / 16) - 2*floor(trial / 32))*1.8
alter VB4 = $&drive
let drive = (floor(trial / 32) - 2*floor(trial / 64))*1.8
alter VB5 = $&drive
let drive = (floor(trial / 64) - 2*floor(trial / 128))*1.8
alter VB6 = $&drive
let drive = (floor(trial / 128) - 2*floor(trial / 256))*1.8
alter VB7 = $&drive
stop when time = 0.00094
resume
delete all
let endpoint = length(time)-1
let cmp = v(COMP)[endpoint]
let top = v(TOP)[endpoint]
let decision = 0
if cmp >= 0.9
let code = trial
let decision = 1
end
echo 52 7 $&trial $&cmp $&top 0.23203125 $&decision >> decisions.csv
let trial = code + 64
let drive = (floor(trial / 1) - 2*floor(trial / 2))*1.8
alter VB0 = $&drive
let drive = (floor(trial / 2) - 2*floor(trial / 4))*1.8
alter VB1 = $&drive
let drive = (floor(trial / 4) - 2*floor(trial / 8))*1.8
alter VB2 = $&drive
let drive = (floor(trial / 8) - 2*floor(trial / 16))*1.8
alter VB3 = $&drive
let drive = (floor(trial / 16) - 2*floor(trial / 32))*1.8
alter VB4 = $&drive
let drive = (floor(trial / 32) - 2*floor(trial / 64))*1.8
alter VB5 = $&drive
let drive = (floor(trial / 64) - 2*floor(trial / 128))*1.8
alter VB6 = $&drive
let drive = (floor(trial / 128) - 2*floor(trial / 256))*1.8
alter VB7 = $&drive
stop when time = 0.000942
resume
delete all
let endpoint = length(time)-1
let cmp = v(COMP)[endpoint]
let top = v(TOP)[endpoint]
let decision = 0
if cmp >= 0.9
let code = trial
let decision = 1
end
echo 52 6 $&trial $&cmp $&top 0.23203125 $&decision >> decisions.csv
let trial = code + 32
let drive = (floor(trial / 1) - 2*floor(trial / 2))*1.8
alter VB0 = $&drive
let drive = (floor(trial / 2) - 2*floor(trial / 4))*1.8
alter VB1 = $&drive
let drive = (floor(trial / 4) - 2*floor(trial / 8))*1.8
alter VB2 = $&drive
let drive = (floor(trial / 8) - 2*floor(trial / 16))*1.8
alter VB3 = $&drive
let drive = (floor(trial / 16) - 2*floor(trial / 32))*1.8
alter VB4 = $&drive
let drive = (floor(trial / 32) - 2*floor(trial / 64))*1.8
alter VB5 = $&drive
let drive = (floor(trial / 64) - 2*floor(trial / 128))*1.8
alter VB6 = $&drive
let drive = (floor(trial / 128) - 2*floor(trial / 256))*1.8
alter VB7 = $&drive
stop when time = 0.000944
resume
delete all
let endpoint = length(time)-1
let cmp = v(COMP)[endpoint]
let top = v(TOP)[endpoint]
let decision = 0
if cmp >= 0.9
let code = trial
let decision = 1
end
echo 52 5 $&trial $&cmp $&top 0.23203125 $&decision >> decisions.csv
let trial = code + 16
let drive = (floor(trial / 1) - 2*floor(trial / 2))*1.8
alter VB0 = $&drive
let drive = (floor(trial / 2) - 2*floor(trial / 4))*1.8
alter VB1 = $&drive
let drive = (floor(trial / 4) - 2*floor(trial / 8))*1.8
alter VB2 = $&drive
let drive = (floor(trial / 8) - 2*floor(trial / 16))*1.8
alter VB3 = $&drive
let drive = (floor(trial / 16) - 2*floor(trial / 32))*1.8
alter VB4 = $&drive
let drive = (floor(trial / 32) - 2*floor(trial / 64))*1.8
alter VB5 = $&drive
let drive = (floor(trial / 64) - 2*floor(trial / 128))*1.8
alter VB6 = $&drive
let drive = (floor(trial / 128) - 2*floor(trial / 256))*1.8
alter VB7 = $&drive
stop when time = 0.000946
resume
delete all
let endpoint = length(time)-1
let cmp = v(COMP)[endpoint]
let top = v(TOP)[endpoint]
let decision = 0
if cmp >= 0.9
let code = trial
let decision = 1
end
echo 52 4 $&trial $&cmp $&top 0.23203125 $&decision >> decisions.csv
let trial = code + 8
let drive = (floor(trial / 1) - 2*floor(trial / 2))*1.8
alter VB0 = $&drive
let drive = (floor(trial / 2) - 2*floor(trial / 4))*1.8
alter VB1 = $&drive
let drive = (floor(trial / 4) - 2*floor(trial / 8))*1.8
alter VB2 = $&drive
let drive = (floor(trial / 8) - 2*floor(trial / 16))*1.8
alter VB3 = $&drive
let drive = (floor(trial / 16) - 2*floor(trial / 32))*1.8
alter VB4 = $&drive
let drive = (floor(trial / 32) - 2*floor(trial / 64))*1.8
alter VB5 = $&drive
let drive = (floor(trial / 64) - 2*floor(trial / 128))*1.8
alter VB6 = $&drive
let drive = (floor(trial / 128) - 2*floor(trial / 256))*1.8
alter VB7 = $&drive
stop when time = 0.000948
resume
delete all
let endpoint = length(time)-1
let cmp = v(COMP)[endpoint]
let top = v(TOP)[endpoint]
let decision = 0
if cmp >= 0.9
let code = trial
let decision = 1
end
echo 52 3 $&trial $&cmp $&top 0.23203125 $&decision >> decisions.csv
let trial = code + 4
let drive = (floor(trial / 1) - 2*floor(trial / 2))*1.8
alter VB0 = $&drive
let drive = (floor(trial / 2) - 2*floor(trial / 4))*1.8
alter VB1 = $&drive
let drive = (floor(trial / 4) - 2*floor(trial / 8))*1.8
alter VB2 = $&drive
let drive = (floor(trial / 8) - 2*floor(trial / 16))*1.8
alter VB3 = $&drive
let drive = (floor(trial / 16) - 2*floor(trial / 32))*1.8
alter VB4 = $&drive
let drive = (floor(trial / 32) - 2*floor(trial / 64))*1.8
alter VB5 = $&drive
let drive = (floor(trial / 64) - 2*floor(trial / 128))*1.8
alter VB6 = $&drive
let drive = (floor(trial / 128) - 2*floor(trial / 256))*1.8
alter VB7 = $&drive
stop when time = 0.00095
resume
delete all
let endpoint = length(time)-1
let cmp = v(COMP)[endpoint]
let top = v(TOP)[endpoint]
let decision = 0
if cmp >= 0.9
let code = trial
let decision = 1
end
echo 52 2 $&trial $&cmp $&top 0.23203125 $&decision >> decisions.csv
let trial = code + 2
let drive = (floor(trial / 1) - 2*floor(trial / 2))*1.8
alter VB0 = $&drive
let drive = (floor(trial / 2) - 2*floor(trial / 4))*1.8
alter VB1 = $&drive
let drive = (floor(trial / 4) - 2*floor(trial / 8))*1.8
alter VB2 = $&drive
let drive = (floor(trial / 8) - 2*floor(trial / 16))*1.8
alter VB3 = $&drive
let drive = (floor(trial / 16) - 2*floor(trial / 32))*1.8
alter VB4 = $&drive
let drive = (floor(trial / 32) - 2*floor(trial / 64))*1.8
alter VB5 = $&drive
let drive = (floor(trial / 64) - 2*floor(trial / 128))*1.8
alter VB6 = $&drive
let drive = (floor(trial / 128) - 2*floor(trial / 256))*1.8
alter VB7 = $&drive
stop when time = 0.000952
resume
delete all
let endpoint = length(time)-1
let cmp = v(COMP)[endpoint]
let top = v(TOP)[endpoint]
let decision = 0
if cmp >= 0.9
let code = trial
let decision = 1
end
echo 52 1 $&trial $&cmp $&top 0.23203125 $&decision >> decisions.csv
let trial = code + 1
let drive = (floor(trial / 1) - 2*floor(trial / 2))*1.8
alter VB0 = $&drive
let drive = (floor(trial / 2) - 2*floor(trial / 4))*1.8
alter VB1 = $&drive
let drive = (floor(trial / 4) - 2*floor(trial / 8))*1.8
alter VB2 = $&drive
let drive = (floor(trial / 8) - 2*floor(trial / 16))*1.8
alter VB3 = $&drive
let drive = (floor(trial / 16) - 2*floor(trial / 32))*1.8
alter VB4 = $&drive
let drive = (floor(trial / 32) - 2*floor(trial / 64))*1.8
alter VB5 = $&drive
let drive = (floor(trial / 64) - 2*floor(trial / 128))*1.8
alter VB6 = $&drive
let drive = (floor(trial / 128) - 2*floor(trial / 256))*1.8
alter VB7 = $&drive
stop when time = 0.000954
resume
delete all
let endpoint = length(time)-1
let cmp = v(COMP)[endpoint]
let top = v(TOP)[endpoint]
let decision = 0
if cmp >= 0.9
let code = trial
let decision = 1
end
echo 52 0 $&trial $&cmp $&top 0.23203125 $&decision >> decisions.csv
alter VIN = 0.23671875
alter VSAMPLE = 1.8
alter VB0 = 0
alter VB1 = 0
alter VB2 = 0
alter VB3 = 0
alter VB4 = 0
alter VB5 = 0
alter VB6 = 0
alter VB7 = 0
let code = 0
stop when time = 0.000956
resume
delete all
alter VSAMPLE = 0
let trial = code + 128
let drive = (floor(trial / 1) - 2*floor(trial / 2))*1.8
alter VB0 = $&drive
let drive = (floor(trial / 2) - 2*floor(trial / 4))*1.8
alter VB1 = $&drive
let drive = (floor(trial / 4) - 2*floor(trial / 8))*1.8
alter VB2 = $&drive
let drive = (floor(trial / 8) - 2*floor(trial / 16))*1.8
alter VB3 = $&drive
let drive = (floor(trial / 16) - 2*floor(trial / 32))*1.8
alter VB4 = $&drive
let drive = (floor(trial / 32) - 2*floor(trial / 64))*1.8
alter VB5 = $&drive
let drive = (floor(trial / 64) - 2*floor(trial / 128))*1.8
alter VB6 = $&drive
let drive = (floor(trial / 128) - 2*floor(trial / 256))*1.8
alter VB7 = $&drive
stop when time = 0.000958
resume
delete all
let endpoint = length(time)-1
let cmp = v(COMP)[endpoint]
let top = v(TOP)[endpoint]
let decision = 0
if cmp >= 0.9
let code = trial
let decision = 1
end
echo 53 7 $&trial $&cmp $&top 0.23671875 $&decision >> decisions.csv
let trial = code + 64
let drive = (floor(trial / 1) - 2*floor(trial / 2))*1.8
alter VB0 = $&drive
let drive = (floor(trial / 2) - 2*floor(trial / 4))*1.8
alter VB1 = $&drive
let drive = (floor(trial / 4) - 2*floor(trial / 8))*1.8
alter VB2 = $&drive
let drive = (floor(trial / 8) - 2*floor(trial / 16))*1.8
alter VB3 = $&drive
let drive = (floor(trial / 16) - 2*floor(trial / 32))*1.8
alter VB4 = $&drive
let drive = (floor(trial / 32) - 2*floor(trial / 64))*1.8
alter VB5 = $&drive
let drive = (floor(trial / 64) - 2*floor(trial / 128))*1.8
alter VB6 = $&drive
let drive = (floor(trial / 128) - 2*floor(trial / 256))*1.8
alter VB7 = $&drive
stop when time = 0.00096
resume
delete all
let endpoint = length(time)-1
let cmp = v(COMP)[endpoint]
let top = v(TOP)[endpoint]
let decision = 0
if cmp >= 0.9
let code = trial
let decision = 1
end
echo 53 6 $&trial $&cmp $&top 0.23671875 $&decision >> decisions.csv
let trial = code + 32
let drive = (floor(trial / 1) - 2*floor(trial / 2))*1.8
alter VB0 = $&drive
let drive = (floor(trial / 2) - 2*floor(trial / 4))*1.8
alter VB1 = $&drive
let drive = (floor(trial / 4) - 2*floor(trial / 8))*1.8
alter VB2 = $&drive
let drive = (floor(trial / 8) - 2*floor(trial / 16))*1.8
alter VB3 = $&drive
let drive = (floor(trial / 16) - 2*floor(trial / 32))*1.8
alter VB4 = $&drive
let drive = (floor(trial / 32) - 2*floor(trial / 64))*1.8
alter VB5 = $&drive
let drive = (floor(trial / 64) - 2*floor(trial / 128))*1.8
alter VB6 = $&drive
let drive = (floor(trial / 128) - 2*floor(trial / 256))*1.8
alter VB7 = $&drive
stop when time = 0.000962
resume
delete all
let endpoint = length(time)-1
let cmp = v(COMP)[endpoint]
let top = v(TOP)[endpoint]
let decision = 0
if cmp >= 0.9
let code = trial
let decision = 1
end
echo 53 5 $&trial $&cmp $&top 0.23671875 $&decision >> decisions.csv
let trial = code + 16
let drive = (floor(trial / 1) - 2*floor(trial / 2))*1.8
alter VB0 = $&drive
let drive = (floor(trial / 2) - 2*floor(trial / 4))*1.8
alter VB1 = $&drive
let drive = (floor(trial / 4) - 2*floor(trial / 8))*1.8
alter VB2 = $&drive
let drive = (floor(trial / 8) - 2*floor(trial / 16))*1.8
alter VB3 = $&drive
let drive = (floor(trial / 16) - 2*floor(trial / 32))*1.8
alter VB4 = $&drive
let drive = (floor(trial / 32) - 2*floor(trial / 64))*1.8
alter VB5 = $&drive
let drive = (floor(trial / 64) - 2*floor(trial / 128))*1.8
alter VB6 = $&drive
let drive = (floor(trial / 128) - 2*floor(trial / 256))*1.8
alter VB7 = $&drive
stop when time = 0.000964
resume
delete all
let endpoint = length(time)-1
let cmp = v(COMP)[endpoint]
let top = v(TOP)[endpoint]
let decision = 0
if cmp >= 0.9
let code = trial
let decision = 1
end
echo 53 4 $&trial $&cmp $&top 0.23671875 $&decision >> decisions.csv
let trial = code + 8
let drive = (floor(trial / 1) - 2*floor(trial / 2))*1.8
alter VB0 = $&drive
let drive = (floor(trial / 2) - 2*floor(trial / 4))*1.8
alter VB1 = $&drive
let drive = (floor(trial / 4) - 2*floor(trial / 8))*1.8
alter VB2 = $&drive
let drive = (floor(trial / 8) - 2*floor(trial / 16))*1.8
alter VB3 = $&drive
let drive = (floor(trial / 16) - 2*floor(trial / 32))*1.8
alter VB4 = $&drive
let drive = (floor(trial / 32) - 2*floor(trial / 64))*1.8
alter VB5 = $&drive
let drive = (floor(trial / 64) - 2*floor(trial / 128))*1.8
alter VB6 = $&drive
let drive = (floor(trial / 128) - 2*floor(trial / 256))*1.8
alter VB7 = $&drive
stop when time = 0.000966
resume
delete all
let endpoint = length(time)-1
let cmp = v(COMP)[endpoint]
let top = v(TOP)[endpoint]
let decision = 0
if cmp >= 0.9
let code = trial
let decision = 1
end
echo 53 3 $&trial $&cmp $&top 0.23671875 $&decision >> decisions.csv
let trial = code + 4
let drive = (floor(trial / 1) - 2*floor(trial / 2))*1.8
alter VB0 = $&drive
let drive = (floor(trial / 2) - 2*floor(trial / 4))*1.8
alter VB1 = $&drive
let drive = (floor(trial / 4) - 2*floor(trial / 8))*1.8
alter VB2 = $&drive
let drive = (floor(trial / 8) - 2*floor(trial / 16))*1.8
alter VB3 = $&drive
let drive = (floor(trial / 16) - 2*floor(trial / 32))*1.8
alter VB4 = $&drive
let drive = (floor(trial / 32) - 2*floor(trial / 64))*1.8
alter VB5 = $&drive
let drive = (floor(trial / 64) - 2*floor(trial / 128))*1.8
alter VB6 = $&drive
let drive = (floor(trial / 128) - 2*floor(trial / 256))*1.8
alter VB7 = $&drive
stop when time = 0.000968
resume
delete all
let endpoint = length(time)-1
let cmp = v(COMP)[endpoint]
let top = v(TOP)[endpoint]
let decision = 0
if cmp >= 0.9
let code = trial
let decision = 1
end
echo 53 2 $&trial $&cmp $&top 0.23671875 $&decision >> decisions.csv
let trial = code + 2
let drive = (floor(trial / 1) - 2*floor(trial / 2))*1.8
alter VB0 = $&drive
let drive = (floor(trial / 2) - 2*floor(trial / 4))*1.8
alter VB1 = $&drive
let drive = (floor(trial / 4) - 2*floor(trial / 8))*1.8
alter VB2 = $&drive
let drive = (floor(trial / 8) - 2*floor(trial / 16))*1.8
alter VB3 = $&drive
let drive = (floor(trial / 16) - 2*floor(trial / 32))*1.8
alter VB4 = $&drive
let drive = (floor(trial / 32) - 2*floor(trial / 64))*1.8
alter VB5 = $&drive
let drive = (floor(trial / 64) - 2*floor(trial / 128))*1.8
alter VB6 = $&drive
let drive = (floor(trial / 128) - 2*floor(trial / 256))*1.8
alter VB7 = $&drive
stop when time = 0.00097
resume
delete all
let endpoint = length(time)-1
let cmp = v(COMP)[endpoint]
let top = v(TOP)[endpoint]
let decision = 0
if cmp >= 0.9
let code = trial
let decision = 1
end
echo 53 1 $&trial $&cmp $&top 0.23671875 $&decision >> decisions.csv
let trial = code + 1
let drive = (floor(trial / 1) - 2*floor(trial / 2))*1.8
alter VB0 = $&drive
let drive = (floor(trial / 2) - 2*floor(trial / 4))*1.8
alter VB1 = $&drive
let drive = (floor(trial / 4) - 2*floor(trial / 8))*1.8
alter VB2 = $&drive
let drive = (floor(trial / 8) - 2*floor(trial / 16))*1.8
alter VB3 = $&drive
let drive = (floor(trial / 16) - 2*floor(trial / 32))*1.8
alter VB4 = $&drive
let drive = (floor(trial / 32) - 2*floor(trial / 64))*1.8
alter VB5 = $&drive
let drive = (floor(trial / 64) - 2*floor(trial / 128))*1.8
alter VB6 = $&drive
let drive = (floor(trial / 128) - 2*floor(trial / 256))*1.8
alter VB7 = $&drive
stop when time = 0.000972
resume
delete all
let endpoint = length(time)-1
let cmp = v(COMP)[endpoint]
let top = v(TOP)[endpoint]
let decision = 0
if cmp >= 0.9
let code = trial
let decision = 1
end
echo 53 0 $&trial $&cmp $&top 0.23671875 $&decision >> decisions.csv
alter VIN = 0.24140625
alter VSAMPLE = 1.8
alter VB0 = 0
alter VB1 = 0
alter VB2 = 0
alter VB3 = 0
alter VB4 = 0
alter VB5 = 0
alter VB6 = 0
alter VB7 = 0
let code = 0
stop when time = 0.000974
resume
delete all
alter VSAMPLE = 0
let trial = code + 128
let drive = (floor(trial / 1) - 2*floor(trial / 2))*1.8
alter VB0 = $&drive
let drive = (floor(trial / 2) - 2*floor(trial / 4))*1.8
alter VB1 = $&drive
let drive = (floor(trial / 4) - 2*floor(trial / 8))*1.8
alter VB2 = $&drive
let drive = (floor(trial / 8) - 2*floor(trial / 16))*1.8
alter VB3 = $&drive
let drive = (floor(trial / 16) - 2*floor(trial / 32))*1.8
alter VB4 = $&drive
let drive = (floor(trial / 32) - 2*floor(trial / 64))*1.8
alter VB5 = $&drive
let drive = (floor(trial / 64) - 2*floor(trial / 128))*1.8
alter VB6 = $&drive
let drive = (floor(trial / 128) - 2*floor(trial / 256))*1.8
alter VB7 = $&drive
stop when time = 0.000976
resume
delete all
let endpoint = length(time)-1
let cmp = v(COMP)[endpoint]
let top = v(TOP)[endpoint]
let decision = 0
if cmp >= 0.9
let code = trial
let decision = 1
end
echo 54 7 $&trial $&cmp $&top 0.24140625 $&decision >> decisions.csv
let trial = code + 64
let drive = (floor(trial / 1) - 2*floor(trial / 2))*1.8
alter VB0 = $&drive
let drive = (floor(trial / 2) - 2*floor(trial / 4))*1.8
alter VB1 = $&drive
let drive = (floor(trial / 4) - 2*floor(trial / 8))*1.8
alter VB2 = $&drive
let drive = (floor(trial / 8) - 2*floor(trial / 16))*1.8
alter VB3 = $&drive
let drive = (floor(trial / 16) - 2*floor(trial / 32))*1.8
alter VB4 = $&drive
let drive = (floor(trial / 32) - 2*floor(trial / 64))*1.8
alter VB5 = $&drive
let drive = (floor(trial / 64) - 2*floor(trial / 128))*1.8
alter VB6 = $&drive
let drive = (floor(trial / 128) - 2*floor(trial / 256))*1.8
alter VB7 = $&drive
stop when time = 0.000978
resume
delete all
let endpoint = length(time)-1
let cmp = v(COMP)[endpoint]
let top = v(TOP)[endpoint]
let decision = 0
if cmp >= 0.9
let code = trial
let decision = 1
end
echo 54 6 $&trial $&cmp $&top 0.24140625 $&decision >> decisions.csv
let trial = code + 32
let drive = (floor(trial / 1) - 2*floor(trial / 2))*1.8
alter VB0 = $&drive
let drive = (floor(trial / 2) - 2*floor(trial / 4))*1.8
alter VB1 = $&drive
let drive = (floor(trial / 4) - 2*floor(trial / 8))*1.8
alter VB2 = $&drive
let drive = (floor(trial / 8) - 2*floor(trial / 16))*1.8
alter VB3 = $&drive
let drive = (floor(trial / 16) - 2*floor(trial / 32))*1.8
alter VB4 = $&drive
let drive = (floor(trial / 32) - 2*floor(trial / 64))*1.8
alter VB5 = $&drive
let drive = (floor(trial / 64) - 2*floor(trial / 128))*1.8
alter VB6 = $&drive
let drive = (floor(trial / 128) - 2*floor(trial / 256))*1.8
alter VB7 = $&drive
stop when time = 0.00098
resume
delete all
let endpoint = length(time)-1
let cmp = v(COMP)[endpoint]
let top = v(TOP)[endpoint]
let decision = 0
if cmp >= 0.9
let code = trial
let decision = 1
end
echo 54 5 $&trial $&cmp $&top 0.24140625 $&decision >> decisions.csv
let trial = code + 16
let drive = (floor(trial / 1) - 2*floor(trial / 2))*1.8
alter VB0 = $&drive
let drive = (floor(trial / 2) - 2*floor(trial / 4))*1.8
alter VB1 = $&drive
let drive = (floor(trial / 4) - 2*floor(trial / 8))*1.8
alter VB2 = $&drive
let drive = (floor(trial / 8) - 2*floor(trial / 16))*1.8
alter VB3 = $&drive
let drive = (floor(trial / 16) - 2*floor(trial / 32))*1.8
alter VB4 = $&drive
let drive = (floor(trial / 32) - 2*floor(trial / 64))*1.8
alter VB5 = $&drive
let drive = (floor(trial / 64) - 2*floor(trial / 128))*1.8
alter VB6 = $&drive
let drive = (floor(trial / 128) - 2*floor(trial / 256))*1.8
alter VB7 = $&drive
stop when time = 0.000982
resume
delete all
let endpoint = length(time)-1
let cmp = v(COMP)[endpoint]
let top = v(TOP)[endpoint]
let decision = 0
if cmp >= 0.9
let code = trial
let decision = 1
end
echo 54 4 $&trial $&cmp $&top 0.24140625 $&decision >> decisions.csv
let trial = code + 8
let drive = (floor(trial / 1) - 2*floor(trial / 2))*1.8
alter VB0 = $&drive
let drive = (floor(trial / 2) - 2*floor(trial / 4))*1.8
alter VB1 = $&drive
let drive = (floor(trial / 4) - 2*floor(trial / 8))*1.8
alter VB2 = $&drive
let drive = (floor(trial / 8) - 2*floor(trial / 16))*1.8
alter VB3 = $&drive
let drive = (floor(trial / 16) - 2*floor(trial / 32))*1.8
alter VB4 = $&drive
let drive = (floor(trial / 32) - 2*floor(trial / 64))*1.8
alter VB5 = $&drive
let drive = (floor(trial / 64) - 2*floor(trial / 128))*1.8
alter VB6 = $&drive
let drive = (floor(trial / 128) - 2*floor(trial / 256))*1.8
alter VB7 = $&drive
stop when time = 0.000984
resume
delete all
let endpoint = length(time)-1
let cmp = v(COMP)[endpoint]
let top = v(TOP)[endpoint]
let decision = 0
if cmp >= 0.9
let code = trial
let decision = 1
end
echo 54 3 $&trial $&cmp $&top 0.24140625 $&decision >> decisions.csv
let trial = code + 4
let drive = (floor(trial / 1) - 2*floor(trial / 2))*1.8
alter VB0 = $&drive
let drive = (floor(trial / 2) - 2*floor(trial / 4))*1.8
alter VB1 = $&drive
let drive = (floor(trial / 4) - 2*floor(trial / 8))*1.8
alter VB2 = $&drive
let drive = (floor(trial / 8) - 2*floor(trial / 16))*1.8
alter VB3 = $&drive
let drive = (floor(trial / 16) - 2*floor(trial / 32))*1.8
alter VB4 = $&drive
let drive = (floor(trial / 32) - 2*floor(trial / 64))*1.8
alter VB5 = $&drive
let drive = (floor(trial / 64) - 2*floor(trial / 128))*1.8
alter VB6 = $&drive
let drive = (floor(trial / 128) - 2*floor(trial / 256))*1.8
alter VB7 = $&drive
stop when time = 0.000986
resume
delete all
let endpoint = length(time)-1
let cmp = v(COMP)[endpoint]
let top = v(TOP)[endpoint]
let decision = 0
if cmp >= 0.9
let code = trial
let decision = 1
end
echo 54 2 $&trial $&cmp $&top 0.24140625 $&decision >> decisions.csv
let trial = code + 2
let drive = (floor(trial / 1) - 2*floor(trial / 2))*1.8
alter VB0 = $&drive
let drive = (floor(trial / 2) - 2*floor(trial / 4))*1.8
alter VB1 = $&drive
let drive = (floor(trial / 4) - 2*floor(trial / 8))*1.8
alter VB2 = $&drive
let drive = (floor(trial / 8) - 2*floor(trial / 16))*1.8
alter VB3 = $&drive
let drive = (floor(trial / 16) - 2*floor(trial / 32))*1.8
alter VB4 = $&drive
let drive = (floor(trial / 32) - 2*floor(trial / 64))*1.8
alter VB5 = $&drive
let drive = (floor(trial / 64) - 2*floor(trial / 128))*1.8
alter VB6 = $&drive
let drive = (floor(trial / 128) - 2*floor(trial / 256))*1.8
alter VB7 = $&drive
stop when time = 0.000988
resume
delete all
let endpoint = length(time)-1
let cmp = v(COMP)[endpoint]
let top = v(TOP)[endpoint]
let decision = 0
if cmp >= 0.9
let code = trial
let decision = 1
end
echo 54 1 $&trial $&cmp $&top 0.24140625 $&decision >> decisions.csv
let trial = code + 1
let drive = (floor(trial / 1) - 2*floor(trial / 2))*1.8
alter VB0 = $&drive
let drive = (floor(trial / 2) - 2*floor(trial / 4))*1.8
alter VB1 = $&drive
let drive = (floor(trial / 4) - 2*floor(trial / 8))*1.8
alter VB2 = $&drive
let drive = (floor(trial / 8) - 2*floor(trial / 16))*1.8
alter VB3 = $&drive
let drive = (floor(trial / 16) - 2*floor(trial / 32))*1.8
alter VB4 = $&drive
let drive = (floor(trial / 32) - 2*floor(trial / 64))*1.8
alter VB5 = $&drive
let drive = (floor(trial / 64) - 2*floor(trial / 128))*1.8
alter VB6 = $&drive
let drive = (floor(trial / 128) - 2*floor(trial / 256))*1.8
alter VB7 = $&drive
stop when time = 0.00099
resume
delete all
let endpoint = length(time)-1
let cmp = v(COMP)[endpoint]
let top = v(TOP)[endpoint]
let decision = 0
if cmp >= 0.9
let code = trial
let decision = 1
end
echo 54 0 $&trial $&cmp $&top 0.24140625 $&decision >> decisions.csv
alter VIN = 0.24609375
alter VSAMPLE = 1.8
alter VB0 = 0
alter VB1 = 0
alter VB2 = 0
alter VB3 = 0
alter VB4 = 0
alter VB5 = 0
alter VB6 = 0
alter VB7 = 0
let code = 0
stop when time = 0.000992
resume
delete all
alter VSAMPLE = 0
let trial = code + 128
let drive = (floor(trial / 1) - 2*floor(trial / 2))*1.8
alter VB0 = $&drive
let drive = (floor(trial / 2) - 2*floor(trial / 4))*1.8
alter VB1 = $&drive
let drive = (floor(trial / 4) - 2*floor(trial / 8))*1.8
alter VB2 = $&drive
let drive = (floor(trial / 8) - 2*floor(trial / 16))*1.8
alter VB3 = $&drive
let drive = (floor(trial / 16) - 2*floor(trial / 32))*1.8
alter VB4 = $&drive
let drive = (floor(trial / 32) - 2*floor(trial / 64))*1.8
alter VB5 = $&drive
let drive = (floor(trial / 64) - 2*floor(trial / 128))*1.8
alter VB6 = $&drive
let drive = (floor(trial / 128) - 2*floor(trial / 256))*1.8
alter VB7 = $&drive
stop when time = 0.000994
resume
delete all
let endpoint = length(time)-1
let cmp = v(COMP)[endpoint]
let top = v(TOP)[endpoint]
let decision = 0
if cmp >= 0.9
let code = trial
let decision = 1
end
echo 55 7 $&trial $&cmp $&top 0.24609375 $&decision >> decisions.csv
let trial = code + 64
let drive = (floor(trial / 1) - 2*floor(trial / 2))*1.8
alter VB0 = $&drive
let drive = (floor(trial / 2) - 2*floor(trial / 4))*1.8
alter VB1 = $&drive
let drive = (floor(trial / 4) - 2*floor(trial / 8))*1.8
alter VB2 = $&drive
let drive = (floor(trial / 8) - 2*floor(trial / 16))*1.8
alter VB3 = $&drive
let drive = (floor(trial / 16) - 2*floor(trial / 32))*1.8
alter VB4 = $&drive
let drive = (floor(trial / 32) - 2*floor(trial / 64))*1.8
alter VB5 = $&drive
let drive = (floor(trial / 64) - 2*floor(trial / 128))*1.8
alter VB6 = $&drive
let drive = (floor(trial / 128) - 2*floor(trial / 256))*1.8
alter VB7 = $&drive
stop when time = 0.000996
resume
delete all
let endpoint = length(time)-1
let cmp = v(COMP)[endpoint]
let top = v(TOP)[endpoint]
let decision = 0
if cmp >= 0.9
let code = trial
let decision = 1
end
echo 55 6 $&trial $&cmp $&top 0.24609375 $&decision >> decisions.csv
let trial = code + 32
let drive = (floor(trial / 1) - 2*floor(trial / 2))*1.8
alter VB0 = $&drive
let drive = (floor(trial / 2) - 2*floor(trial / 4))*1.8
alter VB1 = $&drive
let drive = (floor(trial / 4) - 2*floor(trial / 8))*1.8
alter VB2 = $&drive
let drive = (floor(trial / 8) - 2*floor(trial / 16))*1.8
alter VB3 = $&drive
let drive = (floor(trial / 16) - 2*floor(trial / 32))*1.8
alter VB4 = $&drive
let drive = (floor(trial / 32) - 2*floor(trial / 64))*1.8
alter VB5 = $&drive
let drive = (floor(trial / 64) - 2*floor(trial / 128))*1.8
alter VB6 = $&drive
let drive = (floor(trial / 128) - 2*floor(trial / 256))*1.8
alter VB7 = $&drive
stop when time = 0.000998
resume
delete all
let endpoint = length(time)-1
let cmp = v(COMP)[endpoint]
let top = v(TOP)[endpoint]
let decision = 0
if cmp >= 0.9
let code = trial
let decision = 1
end
echo 55 5 $&trial $&cmp $&top 0.24609375 $&decision >> decisions.csv
let trial = code + 16
let drive = (floor(trial / 1) - 2*floor(trial / 2))*1.8
alter VB0 = $&drive
let drive = (floor(trial / 2) - 2*floor(trial / 4))*1.8
alter VB1 = $&drive
let drive = (floor(trial / 4) - 2*floor(trial / 8))*1.8
alter VB2 = $&drive
let drive = (floor(trial / 8) - 2*floor(trial / 16))*1.8
alter VB3 = $&drive
let drive = (floor(trial / 16) - 2*floor(trial / 32))*1.8
alter VB4 = $&drive
let drive = (floor(trial / 32) - 2*floor(trial / 64))*1.8
alter VB5 = $&drive
let drive = (floor(trial / 64) - 2*floor(trial / 128))*1.8
alter VB6 = $&drive
let drive = (floor(trial / 128) - 2*floor(trial / 256))*1.8
alter VB7 = $&drive
stop when time = 0.001
resume
delete all
let endpoint = length(time)-1
let cmp = v(COMP)[endpoint]
let top = v(TOP)[endpoint]
let decision = 0
if cmp >= 0.9
let code = trial
let decision = 1
end
echo 55 4 $&trial $&cmp $&top 0.24609375 $&decision >> decisions.csv
let trial = code + 8
let drive = (floor(trial / 1) - 2*floor(trial / 2))*1.8
alter VB0 = $&drive
let drive = (floor(trial / 2) - 2*floor(trial / 4))*1.8
alter VB1 = $&drive
let drive = (floor(trial / 4) - 2*floor(trial / 8))*1.8
alter VB2 = $&drive
let drive = (floor(trial / 8) - 2*floor(trial / 16))*1.8
alter VB3 = $&drive
let drive = (floor(trial / 16) - 2*floor(trial / 32))*1.8
alter VB4 = $&drive
let drive = (floor(trial / 32) - 2*floor(trial / 64))*1.8
alter VB5 = $&drive
let drive = (floor(trial / 64) - 2*floor(trial / 128))*1.8
alter VB6 = $&drive
let drive = (floor(trial / 128) - 2*floor(trial / 256))*1.8
alter VB7 = $&drive
stop when time = 0.001002
resume
delete all
let endpoint = length(time)-1
let cmp = v(COMP)[endpoint]
let top = v(TOP)[endpoint]
let decision = 0
if cmp >= 0.9
let code = trial
let decision = 1
end
echo 55 3 $&trial $&cmp $&top 0.24609375 $&decision >> decisions.csv
let trial = code + 4
let drive = (floor(trial / 1) - 2*floor(trial / 2))*1.8
alter VB0 = $&drive
let drive = (floor(trial / 2) - 2*floor(trial / 4))*1.8
alter VB1 = $&drive
let drive = (floor(trial / 4) - 2*floor(trial / 8))*1.8
alter VB2 = $&drive
let drive = (floor(trial / 8) - 2*floor(trial / 16))*1.8
alter VB3 = $&drive
let drive = (floor(trial / 16) - 2*floor(trial / 32))*1.8
alter VB4 = $&drive
let drive = (floor(trial / 32) - 2*floor(trial / 64))*1.8
alter VB5 = $&drive
let drive = (floor(trial / 64) - 2*floor(trial / 128))*1.8
alter VB6 = $&drive
let drive = (floor(trial / 128) - 2*floor(trial / 256))*1.8
alter VB7 = $&drive
stop when time = 0.001004
resume
delete all
let endpoint = length(time)-1
let cmp = v(COMP)[endpoint]
let top = v(TOP)[endpoint]
let decision = 0
if cmp >= 0.9
let code = trial
let decision = 1
end
echo 55 2 $&trial $&cmp $&top 0.24609375 $&decision >> decisions.csv
let trial = code + 2
let drive = (floor(trial / 1) - 2*floor(trial / 2))*1.8
alter VB0 = $&drive
let drive = (floor(trial / 2) - 2*floor(trial / 4))*1.8
alter VB1 = $&drive
let drive = (floor(trial / 4) - 2*floor(trial / 8))*1.8
alter VB2 = $&drive
let drive = (floor(trial / 8) - 2*floor(trial / 16))*1.8
alter VB3 = $&drive
let drive = (floor(trial / 16) - 2*floor(trial / 32))*1.8
alter VB4 = $&drive
let drive = (floor(trial / 32) - 2*floor(trial / 64))*1.8
alter VB5 = $&drive
let drive = (floor(trial / 64) - 2*floor(trial / 128))*1.8
alter VB6 = $&drive
let drive = (floor(trial / 128) - 2*floor(trial / 256))*1.8
alter VB7 = $&drive
stop when time = 0.001006
resume
delete all
let endpoint = length(time)-1
let cmp = v(COMP)[endpoint]
let top = v(TOP)[endpoint]
let decision = 0
if cmp >= 0.9
let code = trial
let decision = 1
end
echo 55 1 $&trial $&cmp $&top 0.24609375 $&decision >> decisions.csv
let trial = code + 1
let drive = (floor(trial / 1) - 2*floor(trial / 2))*1.8
alter VB0 = $&drive
let drive = (floor(trial / 2) - 2*floor(trial / 4))*1.8
alter VB1 = $&drive
let drive = (floor(trial / 4) - 2*floor(trial / 8))*1.8
alter VB2 = $&drive
let drive = (floor(trial / 8) - 2*floor(trial / 16))*1.8
alter VB3 = $&drive
let drive = (floor(trial / 16) - 2*floor(trial / 32))*1.8
alter VB4 = $&drive
let drive = (floor(trial / 32) - 2*floor(trial / 64))*1.8
alter VB5 = $&drive
let drive = (floor(trial / 64) - 2*floor(trial / 128))*1.8
alter VB6 = $&drive
let drive = (floor(trial / 128) - 2*floor(trial / 256))*1.8
alter VB7 = $&drive
stop when time = 0.001008
resume
delete all
let endpoint = length(time)-1
let cmp = v(COMP)[endpoint]
let top = v(TOP)[endpoint]
let decision = 0
if cmp >= 0.9
let code = trial
let decision = 1
end
echo 55 0 $&trial $&cmp $&top 0.24609375 $&decision >> decisions.csv
alter VIN = 0.25078125
alter VSAMPLE = 1.8
alter VB0 = 0
alter VB1 = 0
alter VB2 = 0
alter VB3 = 0
alter VB4 = 0
alter VB5 = 0
alter VB6 = 0
alter VB7 = 0
let code = 0
stop when time = 0.00101
resume
delete all
alter VSAMPLE = 0
let trial = code + 128
let drive = (floor(trial / 1) - 2*floor(trial / 2))*1.8
alter VB0 = $&drive
let drive = (floor(trial / 2) - 2*floor(trial / 4))*1.8
alter VB1 = $&drive
let drive = (floor(trial / 4) - 2*floor(trial / 8))*1.8
alter VB2 = $&drive
let drive = (floor(trial / 8) - 2*floor(trial / 16))*1.8
alter VB3 = $&drive
let drive = (floor(trial / 16) - 2*floor(trial / 32))*1.8
alter VB4 = $&drive
let drive = (floor(trial / 32) - 2*floor(trial / 64))*1.8
alter VB5 = $&drive
let drive = (floor(trial / 64) - 2*floor(trial / 128))*1.8
alter VB6 = $&drive
let drive = (floor(trial / 128) - 2*floor(trial / 256))*1.8
alter VB7 = $&drive
stop when time = 0.001012
resume
delete all
let endpoint = length(time)-1
let cmp = v(COMP)[endpoint]
let top = v(TOP)[endpoint]
let decision = 0
if cmp >= 0.9
let code = trial
let decision = 1
end
echo 56 7 $&trial $&cmp $&top 0.25078125 $&decision >> decisions.csv
let trial = code + 64
let drive = (floor(trial / 1) - 2*floor(trial / 2))*1.8
alter VB0 = $&drive
let drive = (floor(trial / 2) - 2*floor(trial / 4))*1.8
alter VB1 = $&drive
let drive = (floor(trial / 4) - 2*floor(trial / 8))*1.8
alter VB2 = $&drive
let drive = (floor(trial / 8) - 2*floor(trial / 16))*1.8
alter VB3 = $&drive
let drive = (floor(trial / 16) - 2*floor(trial / 32))*1.8
alter VB4 = $&drive
let drive = (floor(trial / 32) - 2*floor(trial / 64))*1.8
alter VB5 = $&drive
let drive = (floor(trial / 64) - 2*floor(trial / 128))*1.8
alter VB6 = $&drive
let drive = (floor(trial / 128) - 2*floor(trial / 256))*1.8
alter VB7 = $&drive
stop when time = 0.001014
resume
delete all
let endpoint = length(time)-1
let cmp = v(COMP)[endpoint]
let top = v(TOP)[endpoint]
let decision = 0
if cmp >= 0.9
let code = trial
let decision = 1
end
echo 56 6 $&trial $&cmp $&top 0.25078125 $&decision >> decisions.csv
let trial = code + 32
let drive = (floor(trial / 1) - 2*floor(trial / 2))*1.8
alter VB0 = $&drive
let drive = (floor(trial / 2) - 2*floor(trial / 4))*1.8
alter VB1 = $&drive
let drive = (floor(trial / 4) - 2*floor(trial / 8))*1.8
alter VB2 = $&drive
let drive = (floor(trial / 8) - 2*floor(trial / 16))*1.8
alter VB3 = $&drive
let drive = (floor(trial / 16) - 2*floor(trial / 32))*1.8
alter VB4 = $&drive
let drive = (floor(trial / 32) - 2*floor(trial / 64))*1.8
alter VB5 = $&drive
let drive = (floor(trial / 64) - 2*floor(trial / 128))*1.8
alter VB6 = $&drive
let drive = (floor(trial / 128) - 2*floor(trial / 256))*1.8
alter VB7 = $&drive
stop when time = 0.001016
resume
delete all
let endpoint = length(time)-1
let cmp = v(COMP)[endpoint]
let top = v(TOP)[endpoint]
let decision = 0
if cmp >= 0.9
let code = trial
let decision = 1
end
echo 56 5 $&trial $&cmp $&top 0.25078125 $&decision >> decisions.csv
let trial = code + 16
let drive = (floor(trial / 1) - 2*floor(trial / 2))*1.8
alter VB0 = $&drive
let drive = (floor(trial / 2) - 2*floor(trial / 4))*1.8
alter VB1 = $&drive
let drive = (floor(trial / 4) - 2*floor(trial / 8))*1.8
alter VB2 = $&drive
let drive = (floor(trial / 8) - 2*floor(trial / 16))*1.8
alter VB3 = $&drive
let drive = (floor(trial / 16) - 2*floor(trial / 32))*1.8
alter VB4 = $&drive
let drive = (floor(trial / 32) - 2*floor(trial / 64))*1.8
alter VB5 = $&drive
let drive = (floor(trial / 64) - 2*floor(trial / 128))*1.8
alter VB6 = $&drive
let drive = (floor(trial / 128) - 2*floor(trial / 256))*1.8
alter VB7 = $&drive
stop when time = 0.001018
resume
delete all
let endpoint = length(time)-1
let cmp = v(COMP)[endpoint]
let top = v(TOP)[endpoint]
let decision = 0
if cmp >= 0.9
let code = trial
let decision = 1
end
echo 56 4 $&trial $&cmp $&top 0.25078125 $&decision >> decisions.csv
let trial = code + 8
let drive = (floor(trial / 1) - 2*floor(trial / 2))*1.8
alter VB0 = $&drive
let drive = (floor(trial / 2) - 2*floor(trial / 4))*1.8
alter VB1 = $&drive
let drive = (floor(trial / 4) - 2*floor(trial / 8))*1.8
alter VB2 = $&drive
let drive = (floor(trial / 8) - 2*floor(trial / 16))*1.8
alter VB3 = $&drive
let drive = (floor(trial / 16) - 2*floor(trial / 32))*1.8
alter VB4 = $&drive
let drive = (floor(trial / 32) - 2*floor(trial / 64))*1.8
alter VB5 = $&drive
let drive = (floor(trial / 64) - 2*floor(trial / 128))*1.8
alter VB6 = $&drive
let drive = (floor(trial / 128) - 2*floor(trial / 256))*1.8
alter VB7 = $&drive
stop when time = 0.00102
resume
delete all
let endpoint = length(time)-1
let cmp = v(COMP)[endpoint]
let top = v(TOP)[endpoint]
let decision = 0
if cmp >= 0.9
let code = trial
let decision = 1
end
echo 56 3 $&trial $&cmp $&top 0.25078125 $&decision >> decisions.csv
let trial = code + 4
let drive = (floor(trial / 1) - 2*floor(trial / 2))*1.8
alter VB0 = $&drive
let drive = (floor(trial / 2) - 2*floor(trial / 4))*1.8
alter VB1 = $&drive
let drive = (floor(trial / 4) - 2*floor(trial / 8))*1.8
alter VB2 = $&drive
let drive = (floor(trial / 8) - 2*floor(trial / 16))*1.8
alter VB3 = $&drive
let drive = (floor(trial / 16) - 2*floor(trial / 32))*1.8
alter VB4 = $&drive
let drive = (floor(trial / 32) - 2*floor(trial / 64))*1.8
alter VB5 = $&drive
let drive = (floor(trial / 64) - 2*floor(trial / 128))*1.8
alter VB6 = $&drive
let drive = (floor(trial / 128) - 2*floor(trial / 256))*1.8
alter VB7 = $&drive
stop when time = 0.001022
resume
delete all
let endpoint = length(time)-1
let cmp = v(COMP)[endpoint]
let top = v(TOP)[endpoint]
let decision = 0
if cmp >= 0.9
let code = trial
let decision = 1
end
echo 56 2 $&trial $&cmp $&top 0.25078125 $&decision >> decisions.csv
let trial = code + 2
let drive = (floor(trial / 1) - 2*floor(trial / 2))*1.8
alter VB0 = $&drive
let drive = (floor(trial / 2) - 2*floor(trial / 4))*1.8
alter VB1 = $&drive
let drive = (floor(trial / 4) - 2*floor(trial / 8))*1.8
alter VB2 = $&drive
let drive = (floor(trial / 8) - 2*floor(trial / 16))*1.8
alter VB3 = $&drive
let drive = (floor(trial / 16) - 2*floor(trial / 32))*1.8
alter VB4 = $&drive
let drive = (floor(trial / 32) - 2*floor(trial / 64))*1.8
alter VB5 = $&drive
let drive = (floor(trial / 64) - 2*floor(trial / 128))*1.8
alter VB6 = $&drive
let drive = (floor(trial / 128) - 2*floor(trial / 256))*1.8
alter VB7 = $&drive
stop when time = 0.001024
resume
delete all
let endpoint = length(time)-1
let cmp = v(COMP)[endpoint]
let top = v(TOP)[endpoint]
let decision = 0
if cmp >= 0.9
let code = trial
let decision = 1
end
echo 56 1 $&trial $&cmp $&top 0.25078125 $&decision >> decisions.csv
let trial = code + 1
let drive = (floor(trial / 1) - 2*floor(trial / 2))*1.8
alter VB0 = $&drive
let drive = (floor(trial / 2) - 2*floor(trial / 4))*1.8
alter VB1 = $&drive
let drive = (floor(trial / 4) - 2*floor(trial / 8))*1.8
alter VB2 = $&drive
let drive = (floor(trial / 8) - 2*floor(trial / 16))*1.8
alter VB3 = $&drive
let drive = (floor(trial / 16) - 2*floor(trial / 32))*1.8
alter VB4 = $&drive
let drive = (floor(trial / 32) - 2*floor(trial / 64))*1.8
alter VB5 = $&drive
let drive = (floor(trial / 64) - 2*floor(trial / 128))*1.8
alter VB6 = $&drive
let drive = (floor(trial / 128) - 2*floor(trial / 256))*1.8
alter VB7 = $&drive
stop when time = 0.001026
resume
delete all
let endpoint = length(time)-1
let cmp = v(COMP)[endpoint]
let top = v(TOP)[endpoint]
let decision = 0
if cmp >= 0.9
let code = trial
let decision = 1
end
echo 56 0 $&trial $&cmp $&top 0.25078125 $&decision >> decisions.csv
alter VIN = 0.25546875
alter VSAMPLE = 1.8
alter VB0 = 0
alter VB1 = 0
alter VB2 = 0
alter VB3 = 0
alter VB4 = 0
alter VB5 = 0
alter VB6 = 0
alter VB7 = 0
let code = 0
stop when time = 0.001028
resume
delete all
alter VSAMPLE = 0
let trial = code + 128
let drive = (floor(trial / 1) - 2*floor(trial / 2))*1.8
alter VB0 = $&drive
let drive = (floor(trial / 2) - 2*floor(trial / 4))*1.8
alter VB1 = $&drive
let drive = (floor(trial / 4) - 2*floor(trial / 8))*1.8
alter VB2 = $&drive
let drive = (floor(trial / 8) - 2*floor(trial / 16))*1.8
alter VB3 = $&drive
let drive = (floor(trial / 16) - 2*floor(trial / 32))*1.8
alter VB4 = $&drive
let drive = (floor(trial / 32) - 2*floor(trial / 64))*1.8
alter VB5 = $&drive
let drive = (floor(trial / 64) - 2*floor(trial / 128))*1.8
alter VB6 = $&drive
let drive = (floor(trial / 128) - 2*floor(trial / 256))*1.8
alter VB7 = $&drive
stop when time = 0.00103
resume
delete all
let endpoint = length(time)-1
let cmp = v(COMP)[endpoint]
let top = v(TOP)[endpoint]
let decision = 0
if cmp >= 0.9
let code = trial
let decision = 1
end
echo 57 7 $&trial $&cmp $&top 0.25546875 $&decision >> decisions.csv
let trial = code + 64
let drive = (floor(trial / 1) - 2*floor(trial / 2))*1.8
alter VB0 = $&drive
let drive = (floor(trial / 2) - 2*floor(trial / 4))*1.8
alter VB1 = $&drive
let drive = (floor(trial / 4) - 2*floor(trial / 8))*1.8
alter VB2 = $&drive
let drive = (floor(trial / 8) - 2*floor(trial / 16))*1.8
alter VB3 = $&drive
let drive = (floor(trial / 16) - 2*floor(trial / 32))*1.8
alter VB4 = $&drive
let drive = (floor(trial / 32) - 2*floor(trial / 64))*1.8
alter VB5 = $&drive
let drive = (floor(trial / 64) - 2*floor(trial / 128))*1.8
alter VB6 = $&drive
let drive = (floor(trial / 128) - 2*floor(trial / 256))*1.8
alter VB7 = $&drive
stop when time = 0.001032
resume
delete all
let endpoint = length(time)-1
let cmp = v(COMP)[endpoint]
let top = v(TOP)[endpoint]
let decision = 0
if cmp >= 0.9
let code = trial
let decision = 1
end
echo 57 6 $&trial $&cmp $&top 0.25546875 $&decision >> decisions.csv
let trial = code + 32
let drive = (floor(trial / 1) - 2*floor(trial / 2))*1.8
alter VB0 = $&drive
let drive = (floor(trial / 2) - 2*floor(trial / 4))*1.8
alter VB1 = $&drive
let drive = (floor(trial / 4) - 2*floor(trial / 8))*1.8
alter VB2 = $&drive
let drive = (floor(trial / 8) - 2*floor(trial / 16))*1.8
alter VB3 = $&drive
let drive = (floor(trial / 16) - 2*floor(trial / 32))*1.8
alter VB4 = $&drive
let drive = (floor(trial / 32) - 2*floor(trial / 64))*1.8
alter VB5 = $&drive
let drive = (floor(trial / 64) - 2*floor(trial / 128))*1.8
alter VB6 = $&drive
let drive = (floor(trial / 128) - 2*floor(trial / 256))*1.8
alter VB7 = $&drive
stop when time = 0.001034
resume
delete all
let endpoint = length(time)-1
let cmp = v(COMP)[endpoint]
let top = v(TOP)[endpoint]
let decision = 0
if cmp >= 0.9
let code = trial
let decision = 1
end
echo 57 5 $&trial $&cmp $&top 0.25546875 $&decision >> decisions.csv
let trial = code + 16
let drive = (floor(trial / 1) - 2*floor(trial / 2))*1.8
alter VB0 = $&drive
let drive = (floor(trial / 2) - 2*floor(trial / 4))*1.8
alter VB1 = $&drive
let drive = (floor(trial / 4) - 2*floor(trial / 8))*1.8
alter VB2 = $&drive
let drive = (floor(trial / 8) - 2*floor(trial / 16))*1.8
alter VB3 = $&drive
let drive = (floor(trial / 16) - 2*floor(trial / 32))*1.8
alter VB4 = $&drive
let drive = (floor(trial / 32) - 2*floor(trial / 64))*1.8
alter VB5 = $&drive
let drive = (floor(trial / 64) - 2*floor(trial / 128))*1.8
alter VB6 = $&drive
let drive = (floor(trial / 128) - 2*floor(trial / 256))*1.8
alter VB7 = $&drive
stop when time = 0.001036
resume
delete all
let endpoint = length(time)-1
let cmp = v(COMP)[endpoint]
let top = v(TOP)[endpoint]
let decision = 0
if cmp >= 0.9
let code = trial
let decision = 1
end
echo 57 4 $&trial $&cmp $&top 0.25546875 $&decision >> decisions.csv
let trial = code + 8
let drive = (floor(trial / 1) - 2*floor(trial / 2))*1.8
alter VB0 = $&drive
let drive = (floor(trial / 2) - 2*floor(trial / 4))*1.8
alter VB1 = $&drive
let drive = (floor(trial / 4) - 2*floor(trial / 8))*1.8
alter VB2 = $&drive
let drive = (floor(trial / 8) - 2*floor(trial / 16))*1.8
alter VB3 = $&drive
let drive = (floor(trial / 16) - 2*floor(trial / 32))*1.8
alter VB4 = $&drive
let drive = (floor(trial / 32) - 2*floor(trial / 64))*1.8
alter VB5 = $&drive
let drive = (floor(trial / 64) - 2*floor(trial / 128))*1.8
alter VB6 = $&drive
let drive = (floor(trial / 128) - 2*floor(trial / 256))*1.8
alter VB7 = $&drive
stop when time = 0.001038
resume
delete all
let endpoint = length(time)-1
let cmp = v(COMP)[endpoint]
let top = v(TOP)[endpoint]
let decision = 0
if cmp >= 0.9
let code = trial
let decision = 1
end
echo 57 3 $&trial $&cmp $&top 0.25546875 $&decision >> decisions.csv
let trial = code + 4
let drive = (floor(trial / 1) - 2*floor(trial / 2))*1.8
alter VB0 = $&drive
let drive = (floor(trial / 2) - 2*floor(trial / 4))*1.8
alter VB1 = $&drive
let drive = (floor(trial / 4) - 2*floor(trial / 8))*1.8
alter VB2 = $&drive
let drive = (floor(trial / 8) - 2*floor(trial / 16))*1.8
alter VB3 = $&drive
let drive = (floor(trial / 16) - 2*floor(trial / 32))*1.8
alter VB4 = $&drive
let drive = (floor(trial / 32) - 2*floor(trial / 64))*1.8
alter VB5 = $&drive
let drive = (floor(trial / 64) - 2*floor(trial / 128))*1.8
alter VB6 = $&drive
let drive = (floor(trial / 128) - 2*floor(trial / 256))*1.8
alter VB7 = $&drive
stop when time = 0.00104
resume
delete all
let endpoint = length(time)-1
let cmp = v(COMP)[endpoint]
let top = v(TOP)[endpoint]
let decision = 0
if cmp >= 0.9
let code = trial
let decision = 1
end
echo 57 2 $&trial $&cmp $&top 0.25546875 $&decision >> decisions.csv
let trial = code + 2
let drive = (floor(trial / 1) - 2*floor(trial / 2))*1.8
alter VB0 = $&drive
let drive = (floor(trial / 2) - 2*floor(trial / 4))*1.8
alter VB1 = $&drive
let drive = (floor(trial / 4) - 2*floor(trial / 8))*1.8
alter VB2 = $&drive
let drive = (floor(trial / 8) - 2*floor(trial / 16))*1.8
alter VB3 = $&drive
let drive = (floor(trial / 16) - 2*floor(trial / 32))*1.8
alter VB4 = $&drive
let drive = (floor(trial / 32) - 2*floor(trial / 64))*1.8
alter VB5 = $&drive
let drive = (floor(trial / 64) - 2*floor(trial / 128))*1.8
alter VB6 = $&drive
let drive = (floor(trial / 128) - 2*floor(trial / 256))*1.8
alter VB7 = $&drive
stop when time = 0.001042
resume
delete all
let endpoint = length(time)-1
let cmp = v(COMP)[endpoint]
let top = v(TOP)[endpoint]
let decision = 0
if cmp >= 0.9
let code = trial
let decision = 1
end
echo 57 1 $&trial $&cmp $&top 0.25546875 $&decision >> decisions.csv
let trial = code + 1
let drive = (floor(trial / 1) - 2*floor(trial / 2))*1.8
alter VB0 = $&drive
let drive = (floor(trial / 2) - 2*floor(trial / 4))*1.8
alter VB1 = $&drive
let drive = (floor(trial / 4) - 2*floor(trial / 8))*1.8
alter VB2 = $&drive
let drive = (floor(trial / 8) - 2*floor(trial / 16))*1.8
alter VB3 = $&drive
let drive = (floor(trial / 16) - 2*floor(trial / 32))*1.8
alter VB4 = $&drive
let drive = (floor(trial / 32) - 2*floor(trial / 64))*1.8
alter VB5 = $&drive
let drive = (floor(trial / 64) - 2*floor(trial / 128))*1.8
alter VB6 = $&drive
let drive = (floor(trial / 128) - 2*floor(trial / 256))*1.8
alter VB7 = $&drive
stop when time = 0.001044
resume
delete all
let endpoint = length(time)-1
let cmp = v(COMP)[endpoint]
let top = v(TOP)[endpoint]
let decision = 0
if cmp >= 0.9
let code = trial
let decision = 1
end
echo 57 0 $&trial $&cmp $&top 0.25546875 $&decision >> decisions.csv
alter VIN = 0.26015625
alter VSAMPLE = 1.8
alter VB0 = 0
alter VB1 = 0
alter VB2 = 0
alter VB3 = 0
alter VB4 = 0
alter VB5 = 0
alter VB6 = 0
alter VB7 = 0
let code = 0
stop when time = 0.001046
resume
delete all
alter VSAMPLE = 0
let trial = code + 128
let drive = (floor(trial / 1) - 2*floor(trial / 2))*1.8
alter VB0 = $&drive
let drive = (floor(trial / 2) - 2*floor(trial / 4))*1.8
alter VB1 = $&drive
let drive = (floor(trial / 4) - 2*floor(trial / 8))*1.8
alter VB2 = $&drive
let drive = (floor(trial / 8) - 2*floor(trial / 16))*1.8
alter VB3 = $&drive
let drive = (floor(trial / 16) - 2*floor(trial / 32))*1.8
alter VB4 = $&drive
let drive = (floor(trial / 32) - 2*floor(trial / 64))*1.8
alter VB5 = $&drive
let drive = (floor(trial / 64) - 2*floor(trial / 128))*1.8
alter VB6 = $&drive
let drive = (floor(trial / 128) - 2*floor(trial / 256))*1.8
alter VB7 = $&drive
stop when time = 0.001048
resume
delete all
let endpoint = length(time)-1
let cmp = v(COMP)[endpoint]
let top = v(TOP)[endpoint]
let decision = 0
if cmp >= 0.9
let code = trial
let decision = 1
end
echo 58 7 $&trial $&cmp $&top 0.26015625 $&decision >> decisions.csv
let trial = code + 64
let drive = (floor(trial / 1) - 2*floor(trial / 2))*1.8
alter VB0 = $&drive
let drive = (floor(trial / 2) - 2*floor(trial / 4))*1.8
alter VB1 = $&drive
let drive = (floor(trial / 4) - 2*floor(trial / 8))*1.8
alter VB2 = $&drive
let drive = (floor(trial / 8) - 2*floor(trial / 16))*1.8
alter VB3 = $&drive
let drive = (floor(trial / 16) - 2*floor(trial / 32))*1.8
alter VB4 = $&drive
let drive = (floor(trial / 32) - 2*floor(trial / 64))*1.8
alter VB5 = $&drive
let drive = (floor(trial / 64) - 2*floor(trial / 128))*1.8
alter VB6 = $&drive
let drive = (floor(trial / 128) - 2*floor(trial / 256))*1.8
alter VB7 = $&drive
stop when time = 0.00105
resume
delete all
let endpoint = length(time)-1
let cmp = v(COMP)[endpoint]
let top = v(TOP)[endpoint]
let decision = 0
if cmp >= 0.9
let code = trial
let decision = 1
end
echo 58 6 $&trial $&cmp $&top 0.26015625 $&decision >> decisions.csv
let trial = code + 32
let drive = (floor(trial / 1) - 2*floor(trial / 2))*1.8
alter VB0 = $&drive
let drive = (floor(trial / 2) - 2*floor(trial / 4))*1.8
alter VB1 = $&drive
let drive = (floor(trial / 4) - 2*floor(trial / 8))*1.8
alter VB2 = $&drive
let drive = (floor(trial / 8) - 2*floor(trial / 16))*1.8
alter VB3 = $&drive
let drive = (floor(trial / 16) - 2*floor(trial / 32))*1.8
alter VB4 = $&drive
let drive = (floor(trial / 32) - 2*floor(trial / 64))*1.8
alter VB5 = $&drive
let drive = (floor(trial / 64) - 2*floor(trial / 128))*1.8
alter VB6 = $&drive
let drive = (floor(trial / 128) - 2*floor(trial / 256))*1.8
alter VB7 = $&drive
stop when time = 0.001052
resume
delete all
let endpoint = length(time)-1
let cmp = v(COMP)[endpoint]
let top = v(TOP)[endpoint]
let decision = 0
if cmp >= 0.9
let code = trial
let decision = 1
end
echo 58 5 $&trial $&cmp $&top 0.26015625 $&decision >> decisions.csv
let trial = code + 16
let drive = (floor(trial / 1) - 2*floor(trial / 2))*1.8
alter VB0 = $&drive
let drive = (floor(trial / 2) - 2*floor(trial / 4))*1.8
alter VB1 = $&drive
let drive = (floor(trial / 4) - 2*floor(trial / 8))*1.8
alter VB2 = $&drive
let drive = (floor(trial / 8) - 2*floor(trial / 16))*1.8
alter VB3 = $&drive
let drive = (floor(trial / 16) - 2*floor(trial / 32))*1.8
alter VB4 = $&drive
let drive = (floor(trial / 32) - 2*floor(trial / 64))*1.8
alter VB5 = $&drive
let drive = (floor(trial / 64) - 2*floor(trial / 128))*1.8
alter VB6 = $&drive
let drive = (floor(trial / 128) - 2*floor(trial / 256))*1.8
alter VB7 = $&drive
stop when time = 0.001054
resume
delete all
let endpoint = length(time)-1
let cmp = v(COMP)[endpoint]
let top = v(TOP)[endpoint]
let decision = 0
if cmp >= 0.9
let code = trial
let decision = 1
end
echo 58 4 $&trial $&cmp $&top 0.26015625 $&decision >> decisions.csv
let trial = code + 8
let drive = (floor(trial / 1) - 2*floor(trial / 2))*1.8
alter VB0 = $&drive
let drive = (floor(trial / 2) - 2*floor(trial / 4))*1.8
alter VB1 = $&drive
let drive = (floor(trial / 4) - 2*floor(trial / 8))*1.8
alter VB2 = $&drive
let drive = (floor(trial / 8) - 2*floor(trial / 16))*1.8
alter VB3 = $&drive
let drive = (floor(trial / 16) - 2*floor(trial / 32))*1.8
alter VB4 = $&drive
let drive = (floor(trial / 32) - 2*floor(trial / 64))*1.8
alter VB5 = $&drive
let drive = (floor(trial / 64) - 2*floor(trial / 128))*1.8
alter VB6 = $&drive
let drive = (floor(trial / 128) - 2*floor(trial / 256))*1.8
alter VB7 = $&drive
stop when time = 0.001056
resume
delete all
let endpoint = length(time)-1
let cmp = v(COMP)[endpoint]
let top = v(TOP)[endpoint]
let decision = 0
if cmp >= 0.9
let code = trial
let decision = 1
end
echo 58 3 $&trial $&cmp $&top 0.26015625 $&decision >> decisions.csv
let trial = code + 4
let drive = (floor(trial / 1) - 2*floor(trial / 2))*1.8
alter VB0 = $&drive
let drive = (floor(trial / 2) - 2*floor(trial / 4))*1.8
alter VB1 = $&drive
let drive = (floor(trial / 4) - 2*floor(trial / 8))*1.8
alter VB2 = $&drive
let drive = (floor(trial / 8) - 2*floor(trial / 16))*1.8
alter VB3 = $&drive
let drive = (floor(trial / 16) - 2*floor(trial / 32))*1.8
alter VB4 = $&drive
let drive = (floor(trial / 32) - 2*floor(trial / 64))*1.8
alter VB5 = $&drive
let drive = (floor(trial / 64) - 2*floor(trial / 128))*1.8
alter VB6 = $&drive
let drive = (floor(trial / 128) - 2*floor(trial / 256))*1.8
alter VB7 = $&drive
stop when time = 0.001058
resume
delete all
let endpoint = length(time)-1
let cmp = v(COMP)[endpoint]
let top = v(TOP)[endpoint]
let decision = 0
if cmp >= 0.9
let code = trial
let decision = 1
end
echo 58 2 $&trial $&cmp $&top 0.26015625 $&decision >> decisions.csv
let trial = code + 2
let drive = (floor(trial / 1) - 2*floor(trial / 2))*1.8
alter VB0 = $&drive
let drive = (floor(trial / 2) - 2*floor(trial / 4))*1.8
alter VB1 = $&drive
let drive = (floor(trial / 4) - 2*floor(trial / 8))*1.8
alter VB2 = $&drive
let drive = (floor(trial / 8) - 2*floor(trial / 16))*1.8
alter VB3 = $&drive
let drive = (floor(trial / 16) - 2*floor(trial / 32))*1.8
alter VB4 = $&drive
let drive = (floor(trial / 32) - 2*floor(trial / 64))*1.8
alter VB5 = $&drive
let drive = (floor(trial / 64) - 2*floor(trial / 128))*1.8
alter VB6 = $&drive
let drive = (floor(trial / 128) - 2*floor(trial / 256))*1.8
alter VB7 = $&drive
stop when time = 0.00106
resume
delete all
let endpoint = length(time)-1
let cmp = v(COMP)[endpoint]
let top = v(TOP)[endpoint]
let decision = 0
if cmp >= 0.9
let code = trial
let decision = 1
end
echo 58 1 $&trial $&cmp $&top 0.26015625 $&decision >> decisions.csv
let trial = code + 1
let drive = (floor(trial / 1) - 2*floor(trial / 2))*1.8
alter VB0 = $&drive
let drive = (floor(trial / 2) - 2*floor(trial / 4))*1.8
alter VB1 = $&drive
let drive = (floor(trial / 4) - 2*floor(trial / 8))*1.8
alter VB2 = $&drive
let drive = (floor(trial / 8) - 2*floor(trial / 16))*1.8
alter VB3 = $&drive
let drive = (floor(trial / 16) - 2*floor(trial / 32))*1.8
alter VB4 = $&drive
let drive = (floor(trial / 32) - 2*floor(trial / 64))*1.8
alter VB5 = $&drive
let drive = (floor(trial / 64) - 2*floor(trial / 128))*1.8
alter VB6 = $&drive
let drive = (floor(trial / 128) - 2*floor(trial / 256))*1.8
alter VB7 = $&drive
stop when time = 0.001062
resume
delete all
let endpoint = length(time)-1
let cmp = v(COMP)[endpoint]
let top = v(TOP)[endpoint]
let decision = 0
if cmp >= 0.9
let code = trial
let decision = 1
end
echo 58 0 $&trial $&cmp $&top 0.26015625 $&decision >> decisions.csv
alter VIN = 0.26484375
alter VSAMPLE = 1.8
alter VB0 = 0
alter VB1 = 0
alter VB2 = 0
alter VB3 = 0
alter VB4 = 0
alter VB5 = 0
alter VB6 = 0
alter VB7 = 0
let code = 0
stop when time = 0.001064
resume
delete all
alter VSAMPLE = 0
let trial = code + 128
let drive = (floor(trial / 1) - 2*floor(trial / 2))*1.8
alter VB0 = $&drive
let drive = (floor(trial / 2) - 2*floor(trial / 4))*1.8
alter VB1 = $&drive
let drive = (floor(trial / 4) - 2*floor(trial / 8))*1.8
alter VB2 = $&drive
let drive = (floor(trial / 8) - 2*floor(trial / 16))*1.8
alter VB3 = $&drive
let drive = (floor(trial / 16) - 2*floor(trial / 32))*1.8
alter VB4 = $&drive
let drive = (floor(trial / 32) - 2*floor(trial / 64))*1.8
alter VB5 = $&drive
let drive = (floor(trial / 64) - 2*floor(trial / 128))*1.8
alter VB6 = $&drive
let drive = (floor(trial / 128) - 2*floor(trial / 256))*1.8
alter VB7 = $&drive
stop when time = 0.001066
resume
delete all
let endpoint = length(time)-1
let cmp = v(COMP)[endpoint]
let top = v(TOP)[endpoint]
let decision = 0
if cmp >= 0.9
let code = trial
let decision = 1
end
echo 59 7 $&trial $&cmp $&top 0.26484375 $&decision >> decisions.csv
let trial = code + 64
let drive = (floor(trial / 1) - 2*floor(trial / 2))*1.8
alter VB0 = $&drive
let drive = (floor(trial / 2) - 2*floor(trial / 4))*1.8
alter VB1 = $&drive
let drive = (floor(trial / 4) - 2*floor(trial / 8))*1.8
alter VB2 = $&drive
let drive = (floor(trial / 8) - 2*floor(trial / 16))*1.8
alter VB3 = $&drive
let drive = (floor(trial / 16) - 2*floor(trial / 32))*1.8
alter VB4 = $&drive
let drive = (floor(trial / 32) - 2*floor(trial / 64))*1.8
alter VB5 = $&drive
let drive = (floor(trial / 64) - 2*floor(trial / 128))*1.8
alter VB6 = $&drive
let drive = (floor(trial / 128) - 2*floor(trial / 256))*1.8
alter VB7 = $&drive
stop when time = 0.001068
resume
delete all
let endpoint = length(time)-1
let cmp = v(COMP)[endpoint]
let top = v(TOP)[endpoint]
let decision = 0
if cmp >= 0.9
let code = trial
let decision = 1
end
echo 59 6 $&trial $&cmp $&top 0.26484375 $&decision >> decisions.csv
let trial = code + 32
let drive = (floor(trial / 1) - 2*floor(trial / 2))*1.8
alter VB0 = $&drive
let drive = (floor(trial / 2) - 2*floor(trial / 4))*1.8
alter VB1 = $&drive
let drive = (floor(trial / 4) - 2*floor(trial / 8))*1.8
alter VB2 = $&drive
let drive = (floor(trial / 8) - 2*floor(trial / 16))*1.8
alter VB3 = $&drive
let drive = (floor(trial / 16) - 2*floor(trial / 32))*1.8
alter VB4 = $&drive
let drive = (floor(trial / 32) - 2*floor(trial / 64))*1.8
alter VB5 = $&drive
let drive = (floor(trial / 64) - 2*floor(trial / 128))*1.8
alter VB6 = $&drive
let drive = (floor(trial / 128) - 2*floor(trial / 256))*1.8
alter VB7 = $&drive
stop when time = 0.00107
resume
delete all
let endpoint = length(time)-1
let cmp = v(COMP)[endpoint]
let top = v(TOP)[endpoint]
let decision = 0
if cmp >= 0.9
let code = trial
let decision = 1
end
echo 59 5 $&trial $&cmp $&top 0.26484375 $&decision >> decisions.csv
let trial = code + 16
let drive = (floor(trial / 1) - 2*floor(trial / 2))*1.8
alter VB0 = $&drive
let drive = (floor(trial / 2) - 2*floor(trial / 4))*1.8
alter VB1 = $&drive
let drive = (floor(trial / 4) - 2*floor(trial / 8))*1.8
alter VB2 = $&drive
let drive = (floor(trial / 8) - 2*floor(trial / 16))*1.8
alter VB3 = $&drive
let drive = (floor(trial / 16) - 2*floor(trial / 32))*1.8
alter VB4 = $&drive
let drive = (floor(trial / 32) - 2*floor(trial / 64))*1.8
alter VB5 = $&drive
let drive = (floor(trial / 64) - 2*floor(trial / 128))*1.8
alter VB6 = $&drive
let drive = (floor(trial / 128) - 2*floor(trial / 256))*1.8
alter VB7 = $&drive
stop when time = 0.001072
resume
delete all
let endpoint = length(time)-1
let cmp = v(COMP)[endpoint]
let top = v(TOP)[endpoint]
let decision = 0
if cmp >= 0.9
let code = trial
let decision = 1
end
echo 59 4 $&trial $&cmp $&top 0.26484375 $&decision >> decisions.csv
let trial = code + 8
let drive = (floor(trial / 1) - 2*floor(trial / 2))*1.8
alter VB0 = $&drive
let drive = (floor(trial / 2) - 2*floor(trial / 4))*1.8
alter VB1 = $&drive
let drive = (floor(trial / 4) - 2*floor(trial / 8))*1.8
alter VB2 = $&drive
let drive = (floor(trial / 8) - 2*floor(trial / 16))*1.8
alter VB3 = $&drive
let drive = (floor(trial / 16) - 2*floor(trial / 32))*1.8
alter VB4 = $&drive
let drive = (floor(trial / 32) - 2*floor(trial / 64))*1.8
alter VB5 = $&drive
let drive = (floor(trial / 64) - 2*floor(trial / 128))*1.8
alter VB6 = $&drive
let drive = (floor(trial / 128) - 2*floor(trial / 256))*1.8
alter VB7 = $&drive
stop when time = 0.001074
resume
delete all
let endpoint = length(time)-1
let cmp = v(COMP)[endpoint]
let top = v(TOP)[endpoint]
let decision = 0
if cmp >= 0.9
let code = trial
let decision = 1
end
echo 59 3 $&trial $&cmp $&top 0.26484375 $&decision >> decisions.csv
let trial = code + 4
let drive = (floor(trial / 1) - 2*floor(trial / 2))*1.8
alter VB0 = $&drive
let drive = (floor(trial / 2) - 2*floor(trial / 4))*1.8
alter VB1 = $&drive
let drive = (floor(trial / 4) - 2*floor(trial / 8))*1.8
alter VB2 = $&drive
let drive = (floor(trial / 8) - 2*floor(trial / 16))*1.8
alter VB3 = $&drive
let drive = (floor(trial / 16) - 2*floor(trial / 32))*1.8
alter VB4 = $&drive
let drive = (floor(trial / 32) - 2*floor(trial / 64))*1.8
alter VB5 = $&drive
let drive = (floor(trial / 64) - 2*floor(trial / 128))*1.8
alter VB6 = $&drive
let drive = (floor(trial / 128) - 2*floor(trial / 256))*1.8
alter VB7 = $&drive
stop when time = 0.001076
resume
delete all
let endpoint = length(time)-1
let cmp = v(COMP)[endpoint]
let top = v(TOP)[endpoint]
let decision = 0
if cmp >= 0.9
let code = trial
let decision = 1
end
echo 59 2 $&trial $&cmp $&top 0.26484375 $&decision >> decisions.csv
let trial = code + 2
let drive = (floor(trial / 1) - 2*floor(trial / 2))*1.8
alter VB0 = $&drive
let drive = (floor(trial / 2) - 2*floor(trial / 4))*1.8
alter VB1 = $&drive
let drive = (floor(trial / 4) - 2*floor(trial / 8))*1.8
alter VB2 = $&drive
let drive = (floor(trial / 8) - 2*floor(trial / 16))*1.8
alter VB3 = $&drive
let drive = (floor(trial / 16) - 2*floor(trial / 32))*1.8
alter VB4 = $&drive
let drive = (floor(trial / 32) - 2*floor(trial / 64))*1.8
alter VB5 = $&drive
let drive = (floor(trial / 64) - 2*floor(trial / 128))*1.8
alter VB6 = $&drive
let drive = (floor(trial / 128) - 2*floor(trial / 256))*1.8
alter VB7 = $&drive
stop when time = 0.001078
resume
delete all
let endpoint = length(time)-1
let cmp = v(COMP)[endpoint]
let top = v(TOP)[endpoint]
let decision = 0
if cmp >= 0.9
let code = trial
let decision = 1
end
echo 59 1 $&trial $&cmp $&top 0.26484375 $&decision >> decisions.csv
let trial = code + 1
let drive = (floor(trial / 1) - 2*floor(trial / 2))*1.8
alter VB0 = $&drive
let drive = (floor(trial / 2) - 2*floor(trial / 4))*1.8
alter VB1 = $&drive
let drive = (floor(trial / 4) - 2*floor(trial / 8))*1.8
alter VB2 = $&drive
let drive = (floor(trial / 8) - 2*floor(trial / 16))*1.8
alter VB3 = $&drive
let drive = (floor(trial / 16) - 2*floor(trial / 32))*1.8
alter VB4 = $&drive
let drive = (floor(trial / 32) - 2*floor(trial / 64))*1.8
alter VB5 = $&drive
let drive = (floor(trial / 64) - 2*floor(trial / 128))*1.8
alter VB6 = $&drive
let drive = (floor(trial / 128) - 2*floor(trial / 256))*1.8
alter VB7 = $&drive
stop when time = 0.00108
resume
delete all
let endpoint = length(time)-1
let cmp = v(COMP)[endpoint]
let top = v(TOP)[endpoint]
let decision = 0
if cmp >= 0.9
let code = trial
let decision = 1
end
echo 59 0 $&trial $&cmp $&top 0.26484375 $&decision >> decisions.csv
alter VIN = 0.26953125
alter VSAMPLE = 1.8
alter VB0 = 0
alter VB1 = 0
alter VB2 = 0
alter VB3 = 0
alter VB4 = 0
alter VB5 = 0
alter VB6 = 0
alter VB7 = 0
let code = 0
stop when time = 0.001082
resume
delete all
alter VSAMPLE = 0
let trial = code + 128
let drive = (floor(trial / 1) - 2*floor(trial / 2))*1.8
alter VB0 = $&drive
let drive = (floor(trial / 2) - 2*floor(trial / 4))*1.8
alter VB1 = $&drive
let drive = (floor(trial / 4) - 2*floor(trial / 8))*1.8
alter VB2 = $&drive
let drive = (floor(trial / 8) - 2*floor(trial / 16))*1.8
alter VB3 = $&drive
let drive = (floor(trial / 16) - 2*floor(trial / 32))*1.8
alter VB4 = $&drive
let drive = (floor(trial / 32) - 2*floor(trial / 64))*1.8
alter VB5 = $&drive
let drive = (floor(trial / 64) - 2*floor(trial / 128))*1.8
alter VB6 = $&drive
let drive = (floor(trial / 128) - 2*floor(trial / 256))*1.8
alter VB7 = $&drive
stop when time = 0.001084
resume
delete all
let endpoint = length(time)-1
let cmp = v(COMP)[endpoint]
let top = v(TOP)[endpoint]
let decision = 0
if cmp >= 0.9
let code = trial
let decision = 1
end
echo 60 7 $&trial $&cmp $&top 0.26953125 $&decision >> decisions.csv
let trial = code + 64
let drive = (floor(trial / 1) - 2*floor(trial / 2))*1.8
alter VB0 = $&drive
let drive = (floor(trial / 2) - 2*floor(trial / 4))*1.8
alter VB1 = $&drive
let drive = (floor(trial / 4) - 2*floor(trial / 8))*1.8
alter VB2 = $&drive
let drive = (floor(trial / 8) - 2*floor(trial / 16))*1.8
alter VB3 = $&drive
let drive = (floor(trial / 16) - 2*floor(trial / 32))*1.8
alter VB4 = $&drive
let drive = (floor(trial / 32) - 2*floor(trial / 64))*1.8
alter VB5 = $&drive
let drive = (floor(trial / 64) - 2*floor(trial / 128))*1.8
alter VB6 = $&drive
let drive = (floor(trial / 128) - 2*floor(trial / 256))*1.8
alter VB7 = $&drive
stop when time = 0.001086
resume
delete all
let endpoint = length(time)-1
let cmp = v(COMP)[endpoint]
let top = v(TOP)[endpoint]
let decision = 0
if cmp >= 0.9
let code = trial
let decision = 1
end
echo 60 6 $&trial $&cmp $&top 0.26953125 $&decision >> decisions.csv
let trial = code + 32
let drive = (floor(trial / 1) - 2*floor(trial / 2))*1.8
alter VB0 = $&drive
let drive = (floor(trial / 2) - 2*floor(trial / 4))*1.8
alter VB1 = $&drive
let drive = (floor(trial / 4) - 2*floor(trial / 8))*1.8
alter VB2 = $&drive
let drive = (floor(trial / 8) - 2*floor(trial / 16))*1.8
alter VB3 = $&drive
let drive = (floor(trial / 16) - 2*floor(trial / 32))*1.8
alter VB4 = $&drive
let drive = (floor(trial / 32) - 2*floor(trial / 64))*1.8
alter VB5 = $&drive
let drive = (floor(trial / 64) - 2*floor(trial / 128))*1.8
alter VB6 = $&drive
let drive = (floor(trial / 128) - 2*floor(trial / 256))*1.8
alter VB7 = $&drive
stop when time = 0.001088
resume
delete all
let endpoint = length(time)-1
let cmp = v(COMP)[endpoint]
let top = v(TOP)[endpoint]
let decision = 0
if cmp >= 0.9
let code = trial
let decision = 1
end
echo 60 5 $&trial $&cmp $&top 0.26953125 $&decision >> decisions.csv
let trial = code + 16
let drive = (floor(trial / 1) - 2*floor(trial / 2))*1.8
alter VB0 = $&drive
let drive = (floor(trial / 2) - 2*floor(trial / 4))*1.8
alter VB1 = $&drive
let drive = (floor(trial / 4) - 2*floor(trial / 8))*1.8
alter VB2 = $&drive
let drive = (floor(trial / 8) - 2*floor(trial / 16))*1.8
alter VB3 = $&drive
let drive = (floor(trial / 16) - 2*floor(trial / 32))*1.8
alter VB4 = $&drive
let drive = (floor(trial / 32) - 2*floor(trial / 64))*1.8
alter VB5 = $&drive
let drive = (floor(trial / 64) - 2*floor(trial / 128))*1.8
alter VB6 = $&drive
let drive = (floor(trial / 128) - 2*floor(trial / 256))*1.8
alter VB7 = $&drive
stop when time = 0.00109
resume
delete all
let endpoint = length(time)-1
let cmp = v(COMP)[endpoint]
let top = v(TOP)[endpoint]
let decision = 0
if cmp >= 0.9
let code = trial
let decision = 1
end
echo 60 4 $&trial $&cmp $&top 0.26953125 $&decision >> decisions.csv
let trial = code + 8
let drive = (floor(trial / 1) - 2*floor(trial / 2))*1.8
alter VB0 = $&drive
let drive = (floor(trial / 2) - 2*floor(trial / 4))*1.8
alter VB1 = $&drive
let drive = (floor(trial / 4) - 2*floor(trial / 8))*1.8
alter VB2 = $&drive
let drive = (floor(trial / 8) - 2*floor(trial / 16))*1.8
alter VB3 = $&drive
let drive = (floor(trial / 16) - 2*floor(trial / 32))*1.8
alter VB4 = $&drive
let drive = (floor(trial / 32) - 2*floor(trial / 64))*1.8
alter VB5 = $&drive
let drive = (floor(trial / 64) - 2*floor(trial / 128))*1.8
alter VB6 = $&drive
let drive = (floor(trial / 128) - 2*floor(trial / 256))*1.8
alter VB7 = $&drive
stop when time = 0.001092
resume
delete all
let endpoint = length(time)-1
let cmp = v(COMP)[endpoint]
let top = v(TOP)[endpoint]
let decision = 0
if cmp >= 0.9
let code = trial
let decision = 1
end
echo 60 3 $&trial $&cmp $&top 0.26953125 $&decision >> decisions.csv
let trial = code + 4
let drive = (floor(trial / 1) - 2*floor(trial / 2))*1.8
alter VB0 = $&drive
let drive = (floor(trial / 2) - 2*floor(trial / 4))*1.8
alter VB1 = $&drive
let drive = (floor(trial / 4) - 2*floor(trial / 8))*1.8
alter VB2 = $&drive
let drive = (floor(trial / 8) - 2*floor(trial / 16))*1.8
alter VB3 = $&drive
let drive = (floor(trial / 16) - 2*floor(trial / 32))*1.8
alter VB4 = $&drive
let drive = (floor(trial / 32) - 2*floor(trial / 64))*1.8
alter VB5 = $&drive
let drive = (floor(trial / 64) - 2*floor(trial / 128))*1.8
alter VB6 = $&drive
let drive = (floor(trial / 128) - 2*floor(trial / 256))*1.8
alter VB7 = $&drive
stop when time = 0.001094
resume
delete all
let endpoint = length(time)-1
let cmp = v(COMP)[endpoint]
let top = v(TOP)[endpoint]
let decision = 0
if cmp >= 0.9
let code = trial
let decision = 1
end
echo 60 2 $&trial $&cmp $&top 0.26953125 $&decision >> decisions.csv
let trial = code + 2
let drive = (floor(trial / 1) - 2*floor(trial / 2))*1.8
alter VB0 = $&drive
let drive = (floor(trial / 2) - 2*floor(trial / 4))*1.8
alter VB1 = $&drive
let drive = (floor(trial / 4) - 2*floor(trial / 8))*1.8
alter VB2 = $&drive
let drive = (floor(trial / 8) - 2*floor(trial / 16))*1.8
alter VB3 = $&drive
let drive = (floor(trial / 16) - 2*floor(trial / 32))*1.8
alter VB4 = $&drive
let drive = (floor(trial / 32) - 2*floor(trial / 64))*1.8
alter VB5 = $&drive
let drive = (floor(trial / 64) - 2*floor(trial / 128))*1.8
alter VB6 = $&drive
let drive = (floor(trial / 128) - 2*floor(trial / 256))*1.8
alter VB7 = $&drive
stop when time = 0.001096
resume
delete all
let endpoint = length(time)-1
let cmp = v(COMP)[endpoint]
let top = v(TOP)[endpoint]
let decision = 0
if cmp >= 0.9
let code = trial
let decision = 1
end
echo 60 1 $&trial $&cmp $&top 0.26953125 $&decision >> decisions.csv
let trial = code + 1
let drive = (floor(trial / 1) - 2*floor(trial / 2))*1.8
alter VB0 = $&drive
let drive = (floor(trial / 2) - 2*floor(trial / 4))*1.8
alter VB1 = $&drive
let drive = (floor(trial / 4) - 2*floor(trial / 8))*1.8
alter VB2 = $&drive
let drive = (floor(trial / 8) - 2*floor(trial / 16))*1.8
alter VB3 = $&drive
let drive = (floor(trial / 16) - 2*floor(trial / 32))*1.8
alter VB4 = $&drive
let drive = (floor(trial / 32) - 2*floor(trial / 64))*1.8
alter VB5 = $&drive
let drive = (floor(trial / 64) - 2*floor(trial / 128))*1.8
alter VB6 = $&drive
let drive = (floor(trial / 128) - 2*floor(trial / 256))*1.8
alter VB7 = $&drive
stop when time = 0.001098
resume
delete all
let endpoint = length(time)-1
let cmp = v(COMP)[endpoint]
let top = v(TOP)[endpoint]
let decision = 0
if cmp >= 0.9
let code = trial
let decision = 1
end
echo 60 0 $&trial $&cmp $&top 0.26953125 $&decision >> decisions.csv
alter VIN = 0.27421875
alter VSAMPLE = 1.8
alter VB0 = 0
alter VB1 = 0
alter VB2 = 0
alter VB3 = 0
alter VB4 = 0
alter VB5 = 0
alter VB6 = 0
alter VB7 = 0
let code = 0
stop when time = 0.0011
resume
delete all
alter VSAMPLE = 0
let trial = code + 128
let drive = (floor(trial / 1) - 2*floor(trial / 2))*1.8
alter VB0 = $&drive
let drive = (floor(trial / 2) - 2*floor(trial / 4))*1.8
alter VB1 = $&drive
let drive = (floor(trial / 4) - 2*floor(trial / 8))*1.8
alter VB2 = $&drive
let drive = (floor(trial / 8) - 2*floor(trial / 16))*1.8
alter VB3 = $&drive
let drive = (floor(trial / 16) - 2*floor(trial / 32))*1.8
alter VB4 = $&drive
let drive = (floor(trial / 32) - 2*floor(trial / 64))*1.8
alter VB5 = $&drive
let drive = (floor(trial / 64) - 2*floor(trial / 128))*1.8
alter VB6 = $&drive
let drive = (floor(trial / 128) - 2*floor(trial / 256))*1.8
alter VB7 = $&drive
stop when time = 0.001102
resume
delete all
let endpoint = length(time)-1
let cmp = v(COMP)[endpoint]
let top = v(TOP)[endpoint]
let decision = 0
if cmp >= 0.9
let code = trial
let decision = 1
end
echo 61 7 $&trial $&cmp $&top 0.27421875 $&decision >> decisions.csv
let trial = code + 64
let drive = (floor(trial / 1) - 2*floor(trial / 2))*1.8
alter VB0 = $&drive
let drive = (floor(trial / 2) - 2*floor(trial / 4))*1.8
alter VB1 = $&drive
let drive = (floor(trial / 4) - 2*floor(trial / 8))*1.8
alter VB2 = $&drive
let drive = (floor(trial / 8) - 2*floor(trial / 16))*1.8
alter VB3 = $&drive
let drive = (floor(trial / 16) - 2*floor(trial / 32))*1.8
alter VB4 = $&drive
let drive = (floor(trial / 32) - 2*floor(trial / 64))*1.8
alter VB5 = $&drive
let drive = (floor(trial / 64) - 2*floor(trial / 128))*1.8
alter VB6 = $&drive
let drive = (floor(trial / 128) - 2*floor(trial / 256))*1.8
alter VB7 = $&drive
stop when time = 0.001104
resume
delete all
let endpoint = length(time)-1
let cmp = v(COMP)[endpoint]
let top = v(TOP)[endpoint]
let decision = 0
if cmp >= 0.9
let code = trial
let decision = 1
end
echo 61 6 $&trial $&cmp $&top 0.27421875 $&decision >> decisions.csv
let trial = code + 32
let drive = (floor(trial / 1) - 2*floor(trial / 2))*1.8
alter VB0 = $&drive
let drive = (floor(trial / 2) - 2*floor(trial / 4))*1.8
alter VB1 = $&drive
let drive = (floor(trial / 4) - 2*floor(trial / 8))*1.8
alter VB2 = $&drive
let drive = (floor(trial / 8) - 2*floor(trial / 16))*1.8
alter VB3 = $&drive
let drive = (floor(trial / 16) - 2*floor(trial / 32))*1.8
alter VB4 = $&drive
let drive = (floor(trial / 32) - 2*floor(trial / 64))*1.8
alter VB5 = $&drive
let drive = (floor(trial / 64) - 2*floor(trial / 128))*1.8
alter VB6 = $&drive
let drive = (floor(trial / 128) - 2*floor(trial / 256))*1.8
alter VB7 = $&drive
stop when time = 0.001106
resume
delete all
let endpoint = length(time)-1
let cmp = v(COMP)[endpoint]
let top = v(TOP)[endpoint]
let decision = 0
if cmp >= 0.9
let code = trial
let decision = 1
end
echo 61 5 $&trial $&cmp $&top 0.27421875 $&decision >> decisions.csv
let trial = code + 16
let drive = (floor(trial / 1) - 2*floor(trial / 2))*1.8
alter VB0 = $&drive
let drive = (floor(trial / 2) - 2*floor(trial / 4))*1.8
alter VB1 = $&drive
let drive = (floor(trial / 4) - 2*floor(trial / 8))*1.8
alter VB2 = $&drive
let drive = (floor(trial / 8) - 2*floor(trial / 16))*1.8
alter VB3 = $&drive
let drive = (floor(trial / 16) - 2*floor(trial / 32))*1.8
alter VB4 = $&drive
let drive = (floor(trial / 32) - 2*floor(trial / 64))*1.8
alter VB5 = $&drive
let drive = (floor(trial / 64) - 2*floor(trial / 128))*1.8
alter VB6 = $&drive
let drive = (floor(trial / 128) - 2*floor(trial / 256))*1.8
alter VB7 = $&drive
stop when time = 0.001108
resume
delete all
let endpoint = length(time)-1
let cmp = v(COMP)[endpoint]
let top = v(TOP)[endpoint]
let decision = 0
if cmp >= 0.9
let code = trial
let decision = 1
end
echo 61 4 $&trial $&cmp $&top 0.27421875 $&decision >> decisions.csv
let trial = code + 8
let drive = (floor(trial / 1) - 2*floor(trial / 2))*1.8
alter VB0 = $&drive
let drive = (floor(trial / 2) - 2*floor(trial / 4))*1.8
alter VB1 = $&drive
let drive = (floor(trial / 4) - 2*floor(trial / 8))*1.8
alter VB2 = $&drive
let drive = (floor(trial / 8) - 2*floor(trial / 16))*1.8
alter VB3 = $&drive
let drive = (floor(trial / 16) - 2*floor(trial / 32))*1.8
alter VB4 = $&drive
let drive = (floor(trial / 32) - 2*floor(trial / 64))*1.8
alter VB5 = $&drive
let drive = (floor(trial / 64) - 2*floor(trial / 128))*1.8
alter VB6 = $&drive
let drive = (floor(trial / 128) - 2*floor(trial / 256))*1.8
alter VB7 = $&drive
stop when time = 0.00111
resume
delete all
let endpoint = length(time)-1
let cmp = v(COMP)[endpoint]
let top = v(TOP)[endpoint]
let decision = 0
if cmp >= 0.9
let code = trial
let decision = 1
end
echo 61 3 $&trial $&cmp $&top 0.27421875 $&decision >> decisions.csv
let trial = code + 4
let drive = (floor(trial / 1) - 2*floor(trial / 2))*1.8
alter VB0 = $&drive
let drive = (floor(trial / 2) - 2*floor(trial / 4))*1.8
alter VB1 = $&drive
let drive = (floor(trial / 4) - 2*floor(trial / 8))*1.8
alter VB2 = $&drive
let drive = (floor(trial / 8) - 2*floor(trial / 16))*1.8
alter VB3 = $&drive
let drive = (floor(trial / 16) - 2*floor(trial / 32))*1.8
alter VB4 = $&drive
let drive = (floor(trial / 32) - 2*floor(trial / 64))*1.8
alter VB5 = $&drive
let drive = (floor(trial / 64) - 2*floor(trial / 128))*1.8
alter VB6 = $&drive
let drive = (floor(trial / 128) - 2*floor(trial / 256))*1.8
alter VB7 = $&drive
stop when time = 0.001112
resume
delete all
let endpoint = length(time)-1
let cmp = v(COMP)[endpoint]
let top = v(TOP)[endpoint]
let decision = 0
if cmp >= 0.9
let code = trial
let decision = 1
end
echo 61 2 $&trial $&cmp $&top 0.27421875 $&decision >> decisions.csv
let trial = code + 2
let drive = (floor(trial / 1) - 2*floor(trial / 2))*1.8
alter VB0 = $&drive
let drive = (floor(trial / 2) - 2*floor(trial / 4))*1.8
alter VB1 = $&drive
let drive = (floor(trial / 4) - 2*floor(trial / 8))*1.8
alter VB2 = $&drive
let drive = (floor(trial / 8) - 2*floor(trial / 16))*1.8
alter VB3 = $&drive
let drive = (floor(trial / 16) - 2*floor(trial / 32))*1.8
alter VB4 = $&drive
let drive = (floor(trial / 32) - 2*floor(trial / 64))*1.8
alter VB5 = $&drive
let drive = (floor(trial / 64) - 2*floor(trial / 128))*1.8
alter VB6 = $&drive
let drive = (floor(trial / 128) - 2*floor(trial / 256))*1.8
alter VB7 = $&drive
stop when time = 0.001114
resume
delete all
let endpoint = length(time)-1
let cmp = v(COMP)[endpoint]
let top = v(TOP)[endpoint]
let decision = 0
if cmp >= 0.9
let code = trial
let decision = 1
end
echo 61 1 $&trial $&cmp $&top 0.27421875 $&decision >> decisions.csv
let trial = code + 1
let drive = (floor(trial / 1) - 2*floor(trial / 2))*1.8
alter VB0 = $&drive
let drive = (floor(trial / 2) - 2*floor(trial / 4))*1.8
alter VB1 = $&drive
let drive = (floor(trial / 4) - 2*floor(trial / 8))*1.8
alter VB2 = $&drive
let drive = (floor(trial / 8) - 2*floor(trial / 16))*1.8
alter VB3 = $&drive
let drive = (floor(trial / 16) - 2*floor(trial / 32))*1.8
alter VB4 = $&drive
let drive = (floor(trial / 32) - 2*floor(trial / 64))*1.8
alter VB5 = $&drive
let drive = (floor(trial / 64) - 2*floor(trial / 128))*1.8
alter VB6 = $&drive
let drive = (floor(trial / 128) - 2*floor(trial / 256))*1.8
alter VB7 = $&drive
stop when time = 0.001116
resume
delete all
let endpoint = length(time)-1
let cmp = v(COMP)[endpoint]
let top = v(TOP)[endpoint]
let decision = 0
if cmp >= 0.9
let code = trial
let decision = 1
end
echo 61 0 $&trial $&cmp $&top 0.27421875 $&decision >> decisions.csv
alter VIN = 0.27890625
alter VSAMPLE = 1.8
alter VB0 = 0
alter VB1 = 0
alter VB2 = 0
alter VB3 = 0
alter VB4 = 0
alter VB5 = 0
alter VB6 = 0
alter VB7 = 0
let code = 0
stop when time = 0.001118
resume
delete all
alter VSAMPLE = 0
let trial = code + 128
let drive = (floor(trial / 1) - 2*floor(trial / 2))*1.8
alter VB0 = $&drive
let drive = (floor(trial / 2) - 2*floor(trial / 4))*1.8
alter VB1 = $&drive
let drive = (floor(trial / 4) - 2*floor(trial / 8))*1.8
alter VB2 = $&drive
let drive = (floor(trial / 8) - 2*floor(trial / 16))*1.8
alter VB3 = $&drive
let drive = (floor(trial / 16) - 2*floor(trial / 32))*1.8
alter VB4 = $&drive
let drive = (floor(trial / 32) - 2*floor(trial / 64))*1.8
alter VB5 = $&drive
let drive = (floor(trial / 64) - 2*floor(trial / 128))*1.8
alter VB6 = $&drive
let drive = (floor(trial / 128) - 2*floor(trial / 256))*1.8
alter VB7 = $&drive
stop when time = 0.00112
resume
delete all
let endpoint = length(time)-1
let cmp = v(COMP)[endpoint]
let top = v(TOP)[endpoint]
let decision = 0
if cmp >= 0.9
let code = trial
let decision = 1
end
echo 62 7 $&trial $&cmp $&top 0.27890625 $&decision >> decisions.csv
let trial = code + 64
let drive = (floor(trial / 1) - 2*floor(trial / 2))*1.8
alter VB0 = $&drive
let drive = (floor(trial / 2) - 2*floor(trial / 4))*1.8
alter VB1 = $&drive
let drive = (floor(trial / 4) - 2*floor(trial / 8))*1.8
alter VB2 = $&drive
let drive = (floor(trial / 8) - 2*floor(trial / 16))*1.8
alter VB3 = $&drive
let drive = (floor(trial / 16) - 2*floor(trial / 32))*1.8
alter VB4 = $&drive
let drive = (floor(trial / 32) - 2*floor(trial / 64))*1.8
alter VB5 = $&drive
let drive = (floor(trial / 64) - 2*floor(trial / 128))*1.8
alter VB6 = $&drive
let drive = (floor(trial / 128) - 2*floor(trial / 256))*1.8
alter VB7 = $&drive
stop when time = 0.001122
resume
delete all
let endpoint = length(time)-1
let cmp = v(COMP)[endpoint]
let top = v(TOP)[endpoint]
let decision = 0
if cmp >= 0.9
let code = trial
let decision = 1
end
echo 62 6 $&trial $&cmp $&top 0.27890625 $&decision >> decisions.csv
let trial = code + 32
let drive = (floor(trial / 1) - 2*floor(trial / 2))*1.8
alter VB0 = $&drive
let drive = (floor(trial / 2) - 2*floor(trial / 4))*1.8
alter VB1 = $&drive
let drive = (floor(trial / 4) - 2*floor(trial / 8))*1.8
alter VB2 = $&drive
let drive = (floor(trial / 8) - 2*floor(trial / 16))*1.8
alter VB3 = $&drive
let drive = (floor(trial / 16) - 2*floor(trial / 32))*1.8
alter VB4 = $&drive
let drive = (floor(trial / 32) - 2*floor(trial / 64))*1.8
alter VB5 = $&drive
let drive = (floor(trial / 64) - 2*floor(trial / 128))*1.8
alter VB6 = $&drive
let drive = (floor(trial / 128) - 2*floor(trial / 256))*1.8
alter VB7 = $&drive
stop when time = 0.001124
resume
delete all
let endpoint = length(time)-1
let cmp = v(COMP)[endpoint]
let top = v(TOP)[endpoint]
let decision = 0
if cmp >= 0.9
let code = trial
let decision = 1
end
echo 62 5 $&trial $&cmp $&top 0.27890625 $&decision >> decisions.csv
let trial = code + 16
let drive = (floor(trial / 1) - 2*floor(trial / 2))*1.8
alter VB0 = $&drive
let drive = (floor(trial / 2) - 2*floor(trial / 4))*1.8
alter VB1 = $&drive
let drive = (floor(trial / 4) - 2*floor(trial / 8))*1.8
alter VB2 = $&drive
let drive = (floor(trial / 8) - 2*floor(trial / 16))*1.8
alter VB3 = $&drive
let drive = (floor(trial / 16) - 2*floor(trial / 32))*1.8
alter VB4 = $&drive
let drive = (floor(trial / 32) - 2*floor(trial / 64))*1.8
alter VB5 = $&drive
let drive = (floor(trial / 64) - 2*floor(trial / 128))*1.8
alter VB6 = $&drive
let drive = (floor(trial / 128) - 2*floor(trial / 256))*1.8
alter VB7 = $&drive
stop when time = 0.001126
resume
delete all
let endpoint = length(time)-1
let cmp = v(COMP)[endpoint]
let top = v(TOP)[endpoint]
let decision = 0
if cmp >= 0.9
let code = trial
let decision = 1
end
echo 62 4 $&trial $&cmp $&top 0.27890625 $&decision >> decisions.csv
let trial = code + 8
let drive = (floor(trial / 1) - 2*floor(trial / 2))*1.8
alter VB0 = $&drive
let drive = (floor(trial / 2) - 2*floor(trial / 4))*1.8
alter VB1 = $&drive
let drive = (floor(trial / 4) - 2*floor(trial / 8))*1.8
alter VB2 = $&drive
let drive = (floor(trial / 8) - 2*floor(trial / 16))*1.8
alter VB3 = $&drive
let drive = (floor(trial / 16) - 2*floor(trial / 32))*1.8
alter VB4 = $&drive
let drive = (floor(trial / 32) - 2*floor(trial / 64))*1.8
alter VB5 = $&drive
let drive = (floor(trial / 64) - 2*floor(trial / 128))*1.8
alter VB6 = $&drive
let drive = (floor(trial / 128) - 2*floor(trial / 256))*1.8
alter VB7 = $&drive
stop when time = 0.001128
resume
delete all
let endpoint = length(time)-1
let cmp = v(COMP)[endpoint]
let top = v(TOP)[endpoint]
let decision = 0
if cmp >= 0.9
let code = trial
let decision = 1
end
echo 62 3 $&trial $&cmp $&top 0.27890625 $&decision >> decisions.csv
let trial = code + 4
let drive = (floor(trial / 1) - 2*floor(trial / 2))*1.8
alter VB0 = $&drive
let drive = (floor(trial / 2) - 2*floor(trial / 4))*1.8
alter VB1 = $&drive
let drive = (floor(trial / 4) - 2*floor(trial / 8))*1.8
alter VB2 = $&drive
let drive = (floor(trial / 8) - 2*floor(trial / 16))*1.8
alter VB3 = $&drive
let drive = (floor(trial / 16) - 2*floor(trial / 32))*1.8
alter VB4 = $&drive
let drive = (floor(trial / 32) - 2*floor(trial / 64))*1.8
alter VB5 = $&drive
let drive = (floor(trial / 64) - 2*floor(trial / 128))*1.8
alter VB6 = $&drive
let drive = (floor(trial / 128) - 2*floor(trial / 256))*1.8
alter VB7 = $&drive
stop when time = 0.00113
resume
delete all
let endpoint = length(time)-1
let cmp = v(COMP)[endpoint]
let top = v(TOP)[endpoint]
let decision = 0
if cmp >= 0.9
let code = trial
let decision = 1
end
echo 62 2 $&trial $&cmp $&top 0.27890625 $&decision >> decisions.csv
let trial = code + 2
let drive = (floor(trial / 1) - 2*floor(trial / 2))*1.8
alter VB0 = $&drive
let drive = (floor(trial / 2) - 2*floor(trial / 4))*1.8
alter VB1 = $&drive
let drive = (floor(trial / 4) - 2*floor(trial / 8))*1.8
alter VB2 = $&drive
let drive = (floor(trial / 8) - 2*floor(trial / 16))*1.8
alter VB3 = $&drive
let drive = (floor(trial / 16) - 2*floor(trial / 32))*1.8
alter VB4 = $&drive
let drive = (floor(trial / 32) - 2*floor(trial / 64))*1.8
alter VB5 = $&drive
let drive = (floor(trial / 64) - 2*floor(trial / 128))*1.8
alter VB6 = $&drive
let drive = (floor(trial / 128) - 2*floor(trial / 256))*1.8
alter VB7 = $&drive
stop when time = 0.001132
resume
delete all
let endpoint = length(time)-1
let cmp = v(COMP)[endpoint]
let top = v(TOP)[endpoint]
let decision = 0
if cmp >= 0.9
let code = trial
let decision = 1
end
echo 62 1 $&trial $&cmp $&top 0.27890625 $&decision >> decisions.csv
let trial = code + 1
let drive = (floor(trial / 1) - 2*floor(trial / 2))*1.8
alter VB0 = $&drive
let drive = (floor(trial / 2) - 2*floor(trial / 4))*1.8
alter VB1 = $&drive
let drive = (floor(trial / 4) - 2*floor(trial / 8))*1.8
alter VB2 = $&drive
let drive = (floor(trial / 8) - 2*floor(trial / 16))*1.8
alter VB3 = $&drive
let drive = (floor(trial / 16) - 2*floor(trial / 32))*1.8
alter VB4 = $&drive
let drive = (floor(trial / 32) - 2*floor(trial / 64))*1.8
alter VB5 = $&drive
let drive = (floor(trial / 64) - 2*floor(trial / 128))*1.8
alter VB6 = $&drive
let drive = (floor(trial / 128) - 2*floor(trial / 256))*1.8
alter VB7 = $&drive
stop when time = 0.001134
resume
delete all
let endpoint = length(time)-1
let cmp = v(COMP)[endpoint]
let top = v(TOP)[endpoint]
let decision = 0
if cmp >= 0.9
let code = trial
let decision = 1
end
echo 62 0 $&trial $&cmp $&top 0.27890625 $&decision >> decisions.csv
alter VIN = 0.28359375
alter VSAMPLE = 1.8
alter VB0 = 0
alter VB1 = 0
alter VB2 = 0
alter VB3 = 0
alter VB4 = 0
alter VB5 = 0
alter VB6 = 0
alter VB7 = 0
let code = 0
stop when time = 0.001136
resume
delete all
alter VSAMPLE = 0
let trial = code + 128
let drive = (floor(trial / 1) - 2*floor(trial / 2))*1.8
alter VB0 = $&drive
let drive = (floor(trial / 2) - 2*floor(trial / 4))*1.8
alter VB1 = $&drive
let drive = (floor(trial / 4) - 2*floor(trial / 8))*1.8
alter VB2 = $&drive
let drive = (floor(trial / 8) - 2*floor(trial / 16))*1.8
alter VB3 = $&drive
let drive = (floor(trial / 16) - 2*floor(trial / 32))*1.8
alter VB4 = $&drive
let drive = (floor(trial / 32) - 2*floor(trial / 64))*1.8
alter VB5 = $&drive
let drive = (floor(trial / 64) - 2*floor(trial / 128))*1.8
alter VB6 = $&drive
let drive = (floor(trial / 128) - 2*floor(trial / 256))*1.8
alter VB7 = $&drive
stop when time = 0.001138
resume
delete all
let endpoint = length(time)-1
let cmp = v(COMP)[endpoint]
let top = v(TOP)[endpoint]
let decision = 0
if cmp >= 0.9
let code = trial
let decision = 1
end
echo 63 7 $&trial $&cmp $&top 0.28359375 $&decision >> decisions.csv
let trial = code + 64
let drive = (floor(trial / 1) - 2*floor(trial / 2))*1.8
alter VB0 = $&drive
let drive = (floor(trial / 2) - 2*floor(trial / 4))*1.8
alter VB1 = $&drive
let drive = (floor(trial / 4) - 2*floor(trial / 8))*1.8
alter VB2 = $&drive
let drive = (floor(trial / 8) - 2*floor(trial / 16))*1.8
alter VB3 = $&drive
let drive = (floor(trial / 16) - 2*floor(trial / 32))*1.8
alter VB4 = $&drive
let drive = (floor(trial / 32) - 2*floor(trial / 64))*1.8
alter VB5 = $&drive
let drive = (floor(trial / 64) - 2*floor(trial / 128))*1.8
alter VB6 = $&drive
let drive = (floor(trial / 128) - 2*floor(trial / 256))*1.8
alter VB7 = $&drive
stop when time = 0.00114
resume
delete all
let endpoint = length(time)-1
let cmp = v(COMP)[endpoint]
let top = v(TOP)[endpoint]
let decision = 0
if cmp >= 0.9
let code = trial
let decision = 1
end
echo 63 6 $&trial $&cmp $&top 0.28359375 $&decision >> decisions.csv
let trial = code + 32
let drive = (floor(trial / 1) - 2*floor(trial / 2))*1.8
alter VB0 = $&drive
let drive = (floor(trial / 2) - 2*floor(trial / 4))*1.8
alter VB1 = $&drive
let drive = (floor(trial / 4) - 2*floor(trial / 8))*1.8
alter VB2 = $&drive
let drive = (floor(trial / 8) - 2*floor(trial / 16))*1.8
alter VB3 = $&drive
let drive = (floor(trial / 16) - 2*floor(trial / 32))*1.8
alter VB4 = $&drive
let drive = (floor(trial / 32) - 2*floor(trial / 64))*1.8
alter VB5 = $&drive
let drive = (floor(trial / 64) - 2*floor(trial / 128))*1.8
alter VB6 = $&drive
let drive = (floor(trial / 128) - 2*floor(trial / 256))*1.8
alter VB7 = $&drive
stop when time = 0.001142
resume
delete all
let endpoint = length(time)-1
let cmp = v(COMP)[endpoint]
let top = v(TOP)[endpoint]
let decision = 0
if cmp >= 0.9
let code = trial
let decision = 1
end
echo 63 5 $&trial $&cmp $&top 0.28359375 $&decision >> decisions.csv
let trial = code + 16
let drive = (floor(trial / 1) - 2*floor(trial / 2))*1.8
alter VB0 = $&drive
let drive = (floor(trial / 2) - 2*floor(trial / 4))*1.8
alter VB1 = $&drive
let drive = (floor(trial / 4) - 2*floor(trial / 8))*1.8
alter VB2 = $&drive
let drive = (floor(trial / 8) - 2*floor(trial / 16))*1.8
alter VB3 = $&drive
let drive = (floor(trial / 16) - 2*floor(trial / 32))*1.8
alter VB4 = $&drive
let drive = (floor(trial / 32) - 2*floor(trial / 64))*1.8
alter VB5 = $&drive
let drive = (floor(trial / 64) - 2*floor(trial / 128))*1.8
alter VB6 = $&drive
let drive = (floor(trial / 128) - 2*floor(trial / 256))*1.8
alter VB7 = $&drive
stop when time = 0.001144
resume
delete all
let endpoint = length(time)-1
let cmp = v(COMP)[endpoint]
let top = v(TOP)[endpoint]
let decision = 0
if cmp >= 0.9
let code = trial
let decision = 1
end
echo 63 4 $&trial $&cmp $&top 0.28359375 $&decision >> decisions.csv
let trial = code + 8
let drive = (floor(trial / 1) - 2*floor(trial / 2))*1.8
alter VB0 = $&drive
let drive = (floor(trial / 2) - 2*floor(trial / 4))*1.8
alter VB1 = $&drive
let drive = (floor(trial / 4) - 2*floor(trial / 8))*1.8
alter VB2 = $&drive
let drive = (floor(trial / 8) - 2*floor(trial / 16))*1.8
alter VB3 = $&drive
let drive = (floor(trial / 16) - 2*floor(trial / 32))*1.8
alter VB4 = $&drive
let drive = (floor(trial / 32) - 2*floor(trial / 64))*1.8
alter VB5 = $&drive
let drive = (floor(trial / 64) - 2*floor(trial / 128))*1.8
alter VB6 = $&drive
let drive = (floor(trial / 128) - 2*floor(trial / 256))*1.8
alter VB7 = $&drive
stop when time = 0.001146
resume
delete all
let endpoint = length(time)-1
let cmp = v(COMP)[endpoint]
let top = v(TOP)[endpoint]
let decision = 0
if cmp >= 0.9
let code = trial
let decision = 1
end
echo 63 3 $&trial $&cmp $&top 0.28359375 $&decision >> decisions.csv
let trial = code + 4
let drive = (floor(trial / 1) - 2*floor(trial / 2))*1.8
alter VB0 = $&drive
let drive = (floor(trial / 2) - 2*floor(trial / 4))*1.8
alter VB1 = $&drive
let drive = (floor(trial / 4) - 2*floor(trial / 8))*1.8
alter VB2 = $&drive
let drive = (floor(trial / 8) - 2*floor(trial / 16))*1.8
alter VB3 = $&drive
let drive = (floor(trial / 16) - 2*floor(trial / 32))*1.8
alter VB4 = $&drive
let drive = (floor(trial / 32) - 2*floor(trial / 64))*1.8
alter VB5 = $&drive
let drive = (floor(trial / 64) - 2*floor(trial / 128))*1.8
alter VB6 = $&drive
let drive = (floor(trial / 128) - 2*floor(trial / 256))*1.8
alter VB7 = $&drive
stop when time = 0.001148
resume
delete all
let endpoint = length(time)-1
let cmp = v(COMP)[endpoint]
let top = v(TOP)[endpoint]
let decision = 0
if cmp >= 0.9
let code = trial
let decision = 1
end
echo 63 2 $&trial $&cmp $&top 0.28359375 $&decision >> decisions.csv
let trial = code + 2
let drive = (floor(trial / 1) - 2*floor(trial / 2))*1.8
alter VB0 = $&drive
let drive = (floor(trial / 2) - 2*floor(trial / 4))*1.8
alter VB1 = $&drive
let drive = (floor(trial / 4) - 2*floor(trial / 8))*1.8
alter VB2 = $&drive
let drive = (floor(trial / 8) - 2*floor(trial / 16))*1.8
alter VB3 = $&drive
let drive = (floor(trial / 16) - 2*floor(trial / 32))*1.8
alter VB4 = $&drive
let drive = (floor(trial / 32) - 2*floor(trial / 64))*1.8
alter VB5 = $&drive
let drive = (floor(trial / 64) - 2*floor(trial / 128))*1.8
alter VB6 = $&drive
let drive = (floor(trial / 128) - 2*floor(trial / 256))*1.8
alter VB7 = $&drive
stop when time = 0.00115
resume
delete all
let endpoint = length(time)-1
let cmp = v(COMP)[endpoint]
let top = v(TOP)[endpoint]
let decision = 0
if cmp >= 0.9
let code = trial
let decision = 1
end
echo 63 1 $&trial $&cmp $&top 0.28359375 $&decision >> decisions.csv
let trial = code + 1
let drive = (floor(trial / 1) - 2*floor(trial / 2))*1.8
alter VB0 = $&drive
let drive = (floor(trial / 2) - 2*floor(trial / 4))*1.8
alter VB1 = $&drive
let drive = (floor(trial / 4) - 2*floor(trial / 8))*1.8
alter VB2 = $&drive
let drive = (floor(trial / 8) - 2*floor(trial / 16))*1.8
alter VB3 = $&drive
let drive = (floor(trial / 16) - 2*floor(trial / 32))*1.8
alter VB4 = $&drive
let drive = (floor(trial / 32) - 2*floor(trial / 64))*1.8
alter VB5 = $&drive
let drive = (floor(trial / 64) - 2*floor(trial / 128))*1.8
alter VB6 = $&drive
let drive = (floor(trial / 128) - 2*floor(trial / 256))*1.8
alter VB7 = $&drive
stop when time = 0.001152
resume
delete all
let endpoint = length(time)-1
let cmp = v(COMP)[endpoint]
let top = v(TOP)[endpoint]
let decision = 0
if cmp >= 0.9
let code = trial
let decision = 1
end
echo 63 0 $&trial $&cmp $&top 0.28359375 $&decision >> decisions.csv
alter VIN = 0.28828125
alter VSAMPLE = 1.8
alter VB0 = 0
alter VB1 = 0
alter VB2 = 0
alter VB3 = 0
alter VB4 = 0
alter VB5 = 0
alter VB6 = 0
alter VB7 = 0
let code = 0
stop when time = 0.001154
resume
delete all
alter VSAMPLE = 0
let trial = code + 128
let drive = (floor(trial / 1) - 2*floor(trial / 2))*1.8
alter VB0 = $&drive
let drive = (floor(trial / 2) - 2*floor(trial / 4))*1.8
alter VB1 = $&drive
let drive = (floor(trial / 4) - 2*floor(trial / 8))*1.8
alter VB2 = $&drive
let drive = (floor(trial / 8) - 2*floor(trial / 16))*1.8
alter VB3 = $&drive
let drive = (floor(trial / 16) - 2*floor(trial / 32))*1.8
alter VB4 = $&drive
let drive = (floor(trial / 32) - 2*floor(trial / 64))*1.8
alter VB5 = $&drive
let drive = (floor(trial / 64) - 2*floor(trial / 128))*1.8
alter VB6 = $&drive
let drive = (floor(trial / 128) - 2*floor(trial / 256))*1.8
alter VB7 = $&drive
stop when time = 0.001156
resume
delete all
let endpoint = length(time)-1
let cmp = v(COMP)[endpoint]
let top = v(TOP)[endpoint]
let decision = 0
if cmp >= 0.9
let code = trial
let decision = 1
end
echo 64 7 $&trial $&cmp $&top 0.28828125 $&decision >> decisions.csv
let trial = code + 64
let drive = (floor(trial / 1) - 2*floor(trial / 2))*1.8
alter VB0 = $&drive
let drive = (floor(trial / 2) - 2*floor(trial / 4))*1.8
alter VB1 = $&drive
let drive = (floor(trial / 4) - 2*floor(trial / 8))*1.8
alter VB2 = $&drive
let drive = (floor(trial / 8) - 2*floor(trial / 16))*1.8
alter VB3 = $&drive
let drive = (floor(trial / 16) - 2*floor(trial / 32))*1.8
alter VB4 = $&drive
let drive = (floor(trial / 32) - 2*floor(trial / 64))*1.8
alter VB5 = $&drive
let drive = (floor(trial / 64) - 2*floor(trial / 128))*1.8
alter VB6 = $&drive
let drive = (floor(trial / 128) - 2*floor(trial / 256))*1.8
alter VB7 = $&drive
stop when time = 0.001158
resume
delete all
let endpoint = length(time)-1
let cmp = v(COMP)[endpoint]
let top = v(TOP)[endpoint]
let decision = 0
if cmp >= 0.9
let code = trial
let decision = 1
end
echo 64 6 $&trial $&cmp $&top 0.28828125 $&decision >> decisions.csv
let trial = code + 32
let drive = (floor(trial / 1) - 2*floor(trial / 2))*1.8
alter VB0 = $&drive
let drive = (floor(trial / 2) - 2*floor(trial / 4))*1.8
alter VB1 = $&drive
let drive = (floor(trial / 4) - 2*floor(trial / 8))*1.8
alter VB2 = $&drive
let drive = (floor(trial / 8) - 2*floor(trial / 16))*1.8
alter VB3 = $&drive
let drive = (floor(trial / 16) - 2*floor(trial / 32))*1.8
alter VB4 = $&drive
let drive = (floor(trial / 32) - 2*floor(trial / 64))*1.8
alter VB5 = $&drive
let drive = (floor(trial / 64) - 2*floor(trial / 128))*1.8
alter VB6 = $&drive
let drive = (floor(trial / 128) - 2*floor(trial / 256))*1.8
alter VB7 = $&drive
stop when time = 0.00116
resume
delete all
let endpoint = length(time)-1
let cmp = v(COMP)[endpoint]
let top = v(TOP)[endpoint]
let decision = 0
if cmp >= 0.9
let code = trial
let decision = 1
end
echo 64 5 $&trial $&cmp $&top 0.28828125 $&decision >> decisions.csv
let trial = code + 16
let drive = (floor(trial / 1) - 2*floor(trial / 2))*1.8
alter VB0 = $&drive
let drive = (floor(trial / 2) - 2*floor(trial / 4))*1.8
alter VB1 = $&drive
let drive = (floor(trial / 4) - 2*floor(trial / 8))*1.8
alter VB2 = $&drive
let drive = (floor(trial / 8) - 2*floor(trial / 16))*1.8
alter VB3 = $&drive
let drive = (floor(trial / 16) - 2*floor(trial / 32))*1.8
alter VB4 = $&drive
let drive = (floor(trial / 32) - 2*floor(trial / 64))*1.8
alter VB5 = $&drive
let drive = (floor(trial / 64) - 2*floor(trial / 128))*1.8
alter VB6 = $&drive
let drive = (floor(trial / 128) - 2*floor(trial / 256))*1.8
alter VB7 = $&drive
stop when time = 0.001162
resume
delete all
let endpoint = length(time)-1
let cmp = v(COMP)[endpoint]
let top = v(TOP)[endpoint]
let decision = 0
if cmp >= 0.9
let code = trial
let decision = 1
end
echo 64 4 $&trial $&cmp $&top 0.28828125 $&decision >> decisions.csv
let trial = code + 8
let drive = (floor(trial / 1) - 2*floor(trial / 2))*1.8
alter VB0 = $&drive
let drive = (floor(trial / 2) - 2*floor(trial / 4))*1.8
alter VB1 = $&drive
let drive = (floor(trial / 4) - 2*floor(trial / 8))*1.8
alter VB2 = $&drive
let drive = (floor(trial / 8) - 2*floor(trial / 16))*1.8
alter VB3 = $&drive
let drive = (floor(trial / 16) - 2*floor(trial / 32))*1.8
alter VB4 = $&drive
let drive = (floor(trial / 32) - 2*floor(trial / 64))*1.8
alter VB5 = $&drive
let drive = (floor(trial / 64) - 2*floor(trial / 128))*1.8
alter VB6 = $&drive
let drive = (floor(trial / 128) - 2*floor(trial / 256))*1.8
alter VB7 = $&drive
stop when time = 0.001164
resume
delete all
let endpoint = length(time)-1
let cmp = v(COMP)[endpoint]
let top = v(TOP)[endpoint]
let decision = 0
if cmp >= 0.9
let code = trial
let decision = 1
end
echo 64 3 $&trial $&cmp $&top 0.28828125 $&decision >> decisions.csv
let trial = code + 4
let drive = (floor(trial / 1) - 2*floor(trial / 2))*1.8
alter VB0 = $&drive
let drive = (floor(trial / 2) - 2*floor(trial / 4))*1.8
alter VB1 = $&drive
let drive = (floor(trial / 4) - 2*floor(trial / 8))*1.8
alter VB2 = $&drive
let drive = (floor(trial / 8) - 2*floor(trial / 16))*1.8
alter VB3 = $&drive
let drive = (floor(trial / 16) - 2*floor(trial / 32))*1.8
alter VB4 = $&drive
let drive = (floor(trial / 32) - 2*floor(trial / 64))*1.8
alter VB5 = $&drive
let drive = (floor(trial / 64) - 2*floor(trial / 128))*1.8
alter VB6 = $&drive
let drive = (floor(trial / 128) - 2*floor(trial / 256))*1.8
alter VB7 = $&drive
stop when time = 0.001166
resume
delete all
let endpoint = length(time)-1
let cmp = v(COMP)[endpoint]
let top = v(TOP)[endpoint]
let decision = 0
if cmp >= 0.9
let code = trial
let decision = 1
end
echo 64 2 $&trial $&cmp $&top 0.28828125 $&decision >> decisions.csv
let trial = code + 2
let drive = (floor(trial / 1) - 2*floor(trial / 2))*1.8
alter VB0 = $&drive
let drive = (floor(trial / 2) - 2*floor(trial / 4))*1.8
alter VB1 = $&drive
let drive = (floor(trial / 4) - 2*floor(trial / 8))*1.8
alter VB2 = $&drive
let drive = (floor(trial / 8) - 2*floor(trial / 16))*1.8
alter VB3 = $&drive
let drive = (floor(trial / 16) - 2*floor(trial / 32))*1.8
alter VB4 = $&drive
let drive = (floor(trial / 32) - 2*floor(trial / 64))*1.8
alter VB5 = $&drive
let drive = (floor(trial / 64) - 2*floor(trial / 128))*1.8
alter VB6 = $&drive
let drive = (floor(trial / 128) - 2*floor(trial / 256))*1.8
alter VB7 = $&drive
stop when time = 0.001168
resume
delete all
let endpoint = length(time)-1
let cmp = v(COMP)[endpoint]
let top = v(TOP)[endpoint]
let decision = 0
if cmp >= 0.9
let code = trial
let decision = 1
end
echo 64 1 $&trial $&cmp $&top 0.28828125 $&decision >> decisions.csv
let trial = code + 1
let drive = (floor(trial / 1) - 2*floor(trial / 2))*1.8
alter VB0 = $&drive
let drive = (floor(trial / 2) - 2*floor(trial / 4))*1.8
alter VB1 = $&drive
let drive = (floor(trial / 4) - 2*floor(trial / 8))*1.8
alter VB2 = $&drive
let drive = (floor(trial / 8) - 2*floor(trial / 16))*1.8
alter VB3 = $&drive
let drive = (floor(trial / 16) - 2*floor(trial / 32))*1.8
alter VB4 = $&drive
let drive = (floor(trial / 32) - 2*floor(trial / 64))*1.8
alter VB5 = $&drive
let drive = (floor(trial / 64) - 2*floor(trial / 128))*1.8
alter VB6 = $&drive
let drive = (floor(trial / 128) - 2*floor(trial / 256))*1.8
alter VB7 = $&drive
stop when time = 0.00117
resume
delete all
let endpoint = length(time)-1
let cmp = v(COMP)[endpoint]
let top = v(TOP)[endpoint]
let decision = 0
if cmp >= 0.9
let code = trial
let decision = 1
end
echo 64 0 $&trial $&cmp $&top 0.28828125 $&decision >> decisions.csv
alter VIN = 0.29296875
alter VSAMPLE = 1.8
alter VB0 = 0
alter VB1 = 0
alter VB2 = 0
alter VB3 = 0
alter VB4 = 0
alter VB5 = 0
alter VB6 = 0
alter VB7 = 0
let code = 0
stop when time = 0.001172
resume
delete all
alter VSAMPLE = 0
let trial = code + 128
let drive = (floor(trial / 1) - 2*floor(trial / 2))*1.8
alter VB0 = $&drive
let drive = (floor(trial / 2) - 2*floor(trial / 4))*1.8
alter VB1 = $&drive
let drive = (floor(trial / 4) - 2*floor(trial / 8))*1.8
alter VB2 = $&drive
let drive = (floor(trial / 8) - 2*floor(trial / 16))*1.8
alter VB3 = $&drive
let drive = (floor(trial / 16) - 2*floor(trial / 32))*1.8
alter VB4 = $&drive
let drive = (floor(trial / 32) - 2*floor(trial / 64))*1.8
alter VB5 = $&drive
let drive = (floor(trial / 64) - 2*floor(trial / 128))*1.8
alter VB6 = $&drive
let drive = (floor(trial / 128) - 2*floor(trial / 256))*1.8
alter VB7 = $&drive
stop when time = 0.001174
resume
delete all
let endpoint = length(time)-1
let cmp = v(COMP)[endpoint]
let top = v(TOP)[endpoint]
let decision = 0
if cmp >= 0.9
let code = trial
let decision = 1
end
echo 65 7 $&trial $&cmp $&top 0.29296875 $&decision >> decisions.csv
let trial = code + 64
let drive = (floor(trial / 1) - 2*floor(trial / 2))*1.8
alter VB0 = $&drive
let drive = (floor(trial / 2) - 2*floor(trial / 4))*1.8
alter VB1 = $&drive
let drive = (floor(trial / 4) - 2*floor(trial / 8))*1.8
alter VB2 = $&drive
let drive = (floor(trial / 8) - 2*floor(trial / 16))*1.8
alter VB3 = $&drive
let drive = (floor(trial / 16) - 2*floor(trial / 32))*1.8
alter VB4 = $&drive
let drive = (floor(trial / 32) - 2*floor(trial / 64))*1.8
alter VB5 = $&drive
let drive = (floor(trial / 64) - 2*floor(trial / 128))*1.8
alter VB6 = $&drive
let drive = (floor(trial / 128) - 2*floor(trial / 256))*1.8
alter VB7 = $&drive
stop when time = 0.001176
resume
delete all
let endpoint = length(time)-1
let cmp = v(COMP)[endpoint]
let top = v(TOP)[endpoint]
let decision = 0
if cmp >= 0.9
let code = trial
let decision = 1
end
echo 65 6 $&trial $&cmp $&top 0.29296875 $&decision >> decisions.csv
let trial = code + 32
let drive = (floor(trial / 1) - 2*floor(trial / 2))*1.8
alter VB0 = $&drive
let drive = (floor(trial / 2) - 2*floor(trial / 4))*1.8
alter VB1 = $&drive
let drive = (floor(trial / 4) - 2*floor(trial / 8))*1.8
alter VB2 = $&drive
let drive = (floor(trial / 8) - 2*floor(trial / 16))*1.8
alter VB3 = $&drive
let drive = (floor(trial / 16) - 2*floor(trial / 32))*1.8
alter VB4 = $&drive
let drive = (floor(trial / 32) - 2*floor(trial / 64))*1.8
alter VB5 = $&drive
let drive = (floor(trial / 64) - 2*floor(trial / 128))*1.8
alter VB6 = $&drive
let drive = (floor(trial / 128) - 2*floor(trial / 256))*1.8
alter VB7 = $&drive
stop when time = 0.001178
resume
delete all
let endpoint = length(time)-1
let cmp = v(COMP)[endpoint]
let top = v(TOP)[endpoint]
let decision = 0
if cmp >= 0.9
let code = trial
let decision = 1
end
echo 65 5 $&trial $&cmp $&top 0.29296875 $&decision >> decisions.csv
let trial = code + 16
let drive = (floor(trial / 1) - 2*floor(trial / 2))*1.8
alter VB0 = $&drive
let drive = (floor(trial / 2) - 2*floor(trial / 4))*1.8
alter VB1 = $&drive
let drive = (floor(trial / 4) - 2*floor(trial / 8))*1.8
alter VB2 = $&drive
let drive = (floor(trial / 8) - 2*floor(trial / 16))*1.8
alter VB3 = $&drive
let drive = (floor(trial / 16) - 2*floor(trial / 32))*1.8
alter VB4 = $&drive
let drive = (floor(trial / 32) - 2*floor(trial / 64))*1.8
alter VB5 = $&drive
let drive = (floor(trial / 64) - 2*floor(trial / 128))*1.8
alter VB6 = $&drive
let drive = (floor(trial / 128) - 2*floor(trial / 256))*1.8
alter VB7 = $&drive
stop when time = 0.00118
resume
delete all
let endpoint = length(time)-1
let cmp = v(COMP)[endpoint]
let top = v(TOP)[endpoint]
let decision = 0
if cmp >= 0.9
let code = trial
let decision = 1
end
echo 65 4 $&trial $&cmp $&top 0.29296875 $&decision >> decisions.csv
let trial = code + 8
let drive = (floor(trial / 1) - 2*floor(trial / 2))*1.8
alter VB0 = $&drive
let drive = (floor(trial / 2) - 2*floor(trial / 4))*1.8
alter VB1 = $&drive
let drive = (floor(trial / 4) - 2*floor(trial / 8))*1.8
alter VB2 = $&drive
let drive = (floor(trial / 8) - 2*floor(trial / 16))*1.8
alter VB3 = $&drive
let drive = (floor(trial / 16) - 2*floor(trial / 32))*1.8
alter VB4 = $&drive
let drive = (floor(trial / 32) - 2*floor(trial / 64))*1.8
alter VB5 = $&drive
let drive = (floor(trial / 64) - 2*floor(trial / 128))*1.8
alter VB6 = $&drive
let drive = (floor(trial / 128) - 2*floor(trial / 256))*1.8
alter VB7 = $&drive
stop when time = 0.001182
resume
delete all
let endpoint = length(time)-1
let cmp = v(COMP)[endpoint]
let top = v(TOP)[endpoint]
let decision = 0
if cmp >= 0.9
let code = trial
let decision = 1
end
echo 65 3 $&trial $&cmp $&top 0.29296875 $&decision >> decisions.csv
let trial = code + 4
let drive = (floor(trial / 1) - 2*floor(trial / 2))*1.8
alter VB0 = $&drive
let drive = (floor(trial / 2) - 2*floor(trial / 4))*1.8
alter VB1 = $&drive
let drive = (floor(trial / 4) - 2*floor(trial / 8))*1.8
alter VB2 = $&drive
let drive = (floor(trial / 8) - 2*floor(trial / 16))*1.8
alter VB3 = $&drive
let drive = (floor(trial / 16) - 2*floor(trial / 32))*1.8
alter VB4 = $&drive
let drive = (floor(trial / 32) - 2*floor(trial / 64))*1.8
alter VB5 = $&drive
let drive = (floor(trial / 64) - 2*floor(trial / 128))*1.8
alter VB6 = $&drive
let drive = (floor(trial / 128) - 2*floor(trial / 256))*1.8
alter VB7 = $&drive
stop when time = 0.001184
resume
delete all
let endpoint = length(time)-1
let cmp = v(COMP)[endpoint]
let top = v(TOP)[endpoint]
let decision = 0
if cmp >= 0.9
let code = trial
let decision = 1
end
echo 65 2 $&trial $&cmp $&top 0.29296875 $&decision >> decisions.csv
let trial = code + 2
let drive = (floor(trial / 1) - 2*floor(trial / 2))*1.8
alter VB0 = $&drive
let drive = (floor(trial / 2) - 2*floor(trial / 4))*1.8
alter VB1 = $&drive
let drive = (floor(trial / 4) - 2*floor(trial / 8))*1.8
alter VB2 = $&drive
let drive = (floor(trial / 8) - 2*floor(trial / 16))*1.8
alter VB3 = $&drive
let drive = (floor(trial / 16) - 2*floor(trial / 32))*1.8
alter VB4 = $&drive
let drive = (floor(trial / 32) - 2*floor(trial / 64))*1.8
alter VB5 = $&drive
let drive = (floor(trial / 64) - 2*floor(trial / 128))*1.8
alter VB6 = $&drive
let drive = (floor(trial / 128) - 2*floor(trial / 256))*1.8
alter VB7 = $&drive
stop when time = 0.001186
resume
delete all
let endpoint = length(time)-1
let cmp = v(COMP)[endpoint]
let top = v(TOP)[endpoint]
let decision = 0
if cmp >= 0.9
let code = trial
let decision = 1
end
echo 65 1 $&trial $&cmp $&top 0.29296875 $&decision >> decisions.csv
let trial = code + 1
let drive = (floor(trial / 1) - 2*floor(trial / 2))*1.8
alter VB0 = $&drive
let drive = (floor(trial / 2) - 2*floor(trial / 4))*1.8
alter VB1 = $&drive
let drive = (floor(trial / 4) - 2*floor(trial / 8))*1.8
alter VB2 = $&drive
let drive = (floor(trial / 8) - 2*floor(trial / 16))*1.8
alter VB3 = $&drive
let drive = (floor(trial / 16) - 2*floor(trial / 32))*1.8
alter VB4 = $&drive
let drive = (floor(trial / 32) - 2*floor(trial / 64))*1.8
alter VB5 = $&drive
let drive = (floor(trial / 64) - 2*floor(trial / 128))*1.8
alter VB6 = $&drive
let drive = (floor(trial / 128) - 2*floor(trial / 256))*1.8
alter VB7 = $&drive
stop when time = 0.001188
resume
delete all
let endpoint = length(time)-1
let cmp = v(COMP)[endpoint]
let top = v(TOP)[endpoint]
let decision = 0
if cmp >= 0.9
let code = trial
let decision = 1
end
echo 65 0 $&trial $&cmp $&top 0.29296875 $&decision >> decisions.csv
alter VIN = 0.29765625
alter VSAMPLE = 1.8
alter VB0 = 0
alter VB1 = 0
alter VB2 = 0
alter VB3 = 0
alter VB4 = 0
alter VB5 = 0
alter VB6 = 0
alter VB7 = 0
let code = 0
stop when time = 0.00119
resume
delete all
alter VSAMPLE = 0
let trial = code + 128
let drive = (floor(trial / 1) - 2*floor(trial / 2))*1.8
alter VB0 = $&drive
let drive = (floor(trial / 2) - 2*floor(trial / 4))*1.8
alter VB1 = $&drive
let drive = (floor(trial / 4) - 2*floor(trial / 8))*1.8
alter VB2 = $&drive
let drive = (floor(trial / 8) - 2*floor(trial / 16))*1.8
alter VB3 = $&drive
let drive = (floor(trial / 16) - 2*floor(trial / 32))*1.8
alter VB4 = $&drive
let drive = (floor(trial / 32) - 2*floor(trial / 64))*1.8
alter VB5 = $&drive
let drive = (floor(trial / 64) - 2*floor(trial / 128))*1.8
alter VB6 = $&drive
let drive = (floor(trial / 128) - 2*floor(trial / 256))*1.8
alter VB7 = $&drive
stop when time = 0.001192
resume
delete all
let endpoint = length(time)-1
let cmp = v(COMP)[endpoint]
let top = v(TOP)[endpoint]
let decision = 0
if cmp >= 0.9
let code = trial
let decision = 1
end
echo 66 7 $&trial $&cmp $&top 0.29765625 $&decision >> decisions.csv
let trial = code + 64
let drive = (floor(trial / 1) - 2*floor(trial / 2))*1.8
alter VB0 = $&drive
let drive = (floor(trial / 2) - 2*floor(trial / 4))*1.8
alter VB1 = $&drive
let drive = (floor(trial / 4) - 2*floor(trial / 8))*1.8
alter VB2 = $&drive
let drive = (floor(trial / 8) - 2*floor(trial / 16))*1.8
alter VB3 = $&drive
let drive = (floor(trial / 16) - 2*floor(trial / 32))*1.8
alter VB4 = $&drive
let drive = (floor(trial / 32) - 2*floor(trial / 64))*1.8
alter VB5 = $&drive
let drive = (floor(trial / 64) - 2*floor(trial / 128))*1.8
alter VB6 = $&drive
let drive = (floor(trial / 128) - 2*floor(trial / 256))*1.8
alter VB7 = $&drive
stop when time = 0.001194
resume
delete all
let endpoint = length(time)-1
let cmp = v(COMP)[endpoint]
let top = v(TOP)[endpoint]
let decision = 0
if cmp >= 0.9
let code = trial
let decision = 1
end
echo 66 6 $&trial $&cmp $&top 0.29765625 $&decision >> decisions.csv
let trial = code + 32
let drive = (floor(trial / 1) - 2*floor(trial / 2))*1.8
alter VB0 = $&drive
let drive = (floor(trial / 2) - 2*floor(trial / 4))*1.8
alter VB1 = $&drive
let drive = (floor(trial / 4) - 2*floor(trial / 8))*1.8
alter VB2 = $&drive
let drive = (floor(trial / 8) - 2*floor(trial / 16))*1.8
alter VB3 = $&drive
let drive = (floor(trial / 16) - 2*floor(trial / 32))*1.8
alter VB4 = $&drive
let drive = (floor(trial / 32) - 2*floor(trial / 64))*1.8
alter VB5 = $&drive
let drive = (floor(trial / 64) - 2*floor(trial / 128))*1.8
alter VB6 = $&drive
let drive = (floor(trial / 128) - 2*floor(trial / 256))*1.8
alter VB7 = $&drive
stop when time = 0.001196
resume
delete all
let endpoint = length(time)-1
let cmp = v(COMP)[endpoint]
let top = v(TOP)[endpoint]
let decision = 0
if cmp >= 0.9
let code = trial
let decision = 1
end
echo 66 5 $&trial $&cmp $&top 0.29765625 $&decision >> decisions.csv
let trial = code + 16
let drive = (floor(trial / 1) - 2*floor(trial / 2))*1.8
alter VB0 = $&drive
let drive = (floor(trial / 2) - 2*floor(trial / 4))*1.8
alter VB1 = $&drive
let drive = (floor(trial / 4) - 2*floor(trial / 8))*1.8
alter VB2 = $&drive
let drive = (floor(trial / 8) - 2*floor(trial / 16))*1.8
alter VB3 = $&drive
let drive = (floor(trial / 16) - 2*floor(trial / 32))*1.8
alter VB4 = $&drive
let drive = (floor(trial / 32) - 2*floor(trial / 64))*1.8
alter VB5 = $&drive
let drive = (floor(trial / 64) - 2*floor(trial / 128))*1.8
alter VB6 = $&drive
let drive = (floor(trial / 128) - 2*floor(trial / 256))*1.8
alter VB7 = $&drive
stop when time = 0.001198
resume
delete all
let endpoint = length(time)-1
let cmp = v(COMP)[endpoint]
let top = v(TOP)[endpoint]
let decision = 0
if cmp >= 0.9
let code = trial
let decision = 1
end
echo 66 4 $&trial $&cmp $&top 0.29765625 $&decision >> decisions.csv
let trial = code + 8
let drive = (floor(trial / 1) - 2*floor(trial / 2))*1.8
alter VB0 = $&drive
let drive = (floor(trial / 2) - 2*floor(trial / 4))*1.8
alter VB1 = $&drive
let drive = (floor(trial / 4) - 2*floor(trial / 8))*1.8
alter VB2 = $&drive
let drive = (floor(trial / 8) - 2*floor(trial / 16))*1.8
alter VB3 = $&drive
let drive = (floor(trial / 16) - 2*floor(trial / 32))*1.8
alter VB4 = $&drive
let drive = (floor(trial / 32) - 2*floor(trial / 64))*1.8
alter VB5 = $&drive
let drive = (floor(trial / 64) - 2*floor(trial / 128))*1.8
alter VB6 = $&drive
let drive = (floor(trial / 128) - 2*floor(trial / 256))*1.8
alter VB7 = $&drive
stop when time = 0.0012
resume
delete all
let endpoint = length(time)-1
let cmp = v(COMP)[endpoint]
let top = v(TOP)[endpoint]
let decision = 0
if cmp >= 0.9
let code = trial
let decision = 1
end
echo 66 3 $&trial $&cmp $&top 0.29765625 $&decision >> decisions.csv
let trial = code + 4
let drive = (floor(trial / 1) - 2*floor(trial / 2))*1.8
alter VB0 = $&drive
let drive = (floor(trial / 2) - 2*floor(trial / 4))*1.8
alter VB1 = $&drive
let drive = (floor(trial / 4) - 2*floor(trial / 8))*1.8
alter VB2 = $&drive
let drive = (floor(trial / 8) - 2*floor(trial / 16))*1.8
alter VB3 = $&drive
let drive = (floor(trial / 16) - 2*floor(trial / 32))*1.8
alter VB4 = $&drive
let drive = (floor(trial / 32) - 2*floor(trial / 64))*1.8
alter VB5 = $&drive
let drive = (floor(trial / 64) - 2*floor(trial / 128))*1.8
alter VB6 = $&drive
let drive = (floor(trial / 128) - 2*floor(trial / 256))*1.8
alter VB7 = $&drive
stop when time = 0.001202
resume
delete all
let endpoint = length(time)-1
let cmp = v(COMP)[endpoint]
let top = v(TOP)[endpoint]
let decision = 0
if cmp >= 0.9
let code = trial
let decision = 1
end
echo 66 2 $&trial $&cmp $&top 0.29765625 $&decision >> decisions.csv
let trial = code + 2
let drive = (floor(trial / 1) - 2*floor(trial / 2))*1.8
alter VB0 = $&drive
let drive = (floor(trial / 2) - 2*floor(trial / 4))*1.8
alter VB1 = $&drive
let drive = (floor(trial / 4) - 2*floor(trial / 8))*1.8
alter VB2 = $&drive
let drive = (floor(trial / 8) - 2*floor(trial / 16))*1.8
alter VB3 = $&drive
let drive = (floor(trial / 16) - 2*floor(trial / 32))*1.8
alter VB4 = $&drive
let drive = (floor(trial / 32) - 2*floor(trial / 64))*1.8
alter VB5 = $&drive
let drive = (floor(trial / 64) - 2*floor(trial / 128))*1.8
alter VB6 = $&drive
let drive = (floor(trial / 128) - 2*floor(trial / 256))*1.8
alter VB7 = $&drive
stop when time = 0.001204
resume
delete all
let endpoint = length(time)-1
let cmp = v(COMP)[endpoint]
let top = v(TOP)[endpoint]
let decision = 0
if cmp >= 0.9
let code = trial
let decision = 1
end
echo 66 1 $&trial $&cmp $&top 0.29765625 $&decision >> decisions.csv
let trial = code + 1
let drive = (floor(trial / 1) - 2*floor(trial / 2))*1.8
alter VB0 = $&drive
let drive = (floor(trial / 2) - 2*floor(trial / 4))*1.8
alter VB1 = $&drive
let drive = (floor(trial / 4) - 2*floor(trial / 8))*1.8
alter VB2 = $&drive
let drive = (floor(trial / 8) - 2*floor(trial / 16))*1.8
alter VB3 = $&drive
let drive = (floor(trial / 16) - 2*floor(trial / 32))*1.8
alter VB4 = $&drive
let drive = (floor(trial / 32) - 2*floor(trial / 64))*1.8
alter VB5 = $&drive
let drive = (floor(trial / 64) - 2*floor(trial / 128))*1.8
alter VB6 = $&drive
let drive = (floor(trial / 128) - 2*floor(trial / 256))*1.8
alter VB7 = $&drive
stop when time = 0.001206
resume
delete all
let endpoint = length(time)-1
let cmp = v(COMP)[endpoint]
let top = v(TOP)[endpoint]
let decision = 0
if cmp >= 0.9
let code = trial
let decision = 1
end
echo 66 0 $&trial $&cmp $&top 0.29765625 $&decision >> decisions.csv
alter VIN = 0.30234375
alter VSAMPLE = 1.8
alter VB0 = 0
alter VB1 = 0
alter VB2 = 0
alter VB3 = 0
alter VB4 = 0
alter VB5 = 0
alter VB6 = 0
alter VB7 = 0
let code = 0
stop when time = 0.001208
resume
delete all
alter VSAMPLE = 0
let trial = code + 128
let drive = (floor(trial / 1) - 2*floor(trial / 2))*1.8
alter VB0 = $&drive
let drive = (floor(trial / 2) - 2*floor(trial / 4))*1.8
alter VB1 = $&drive
let drive = (floor(trial / 4) - 2*floor(trial / 8))*1.8
alter VB2 = $&drive
let drive = (floor(trial / 8) - 2*floor(trial / 16))*1.8
alter VB3 = $&drive
let drive = (floor(trial / 16) - 2*floor(trial / 32))*1.8
alter VB4 = $&drive
let drive = (floor(trial / 32) - 2*floor(trial / 64))*1.8
alter VB5 = $&drive
let drive = (floor(trial / 64) - 2*floor(trial / 128))*1.8
alter VB6 = $&drive
let drive = (floor(trial / 128) - 2*floor(trial / 256))*1.8
alter VB7 = $&drive
stop when time = 0.00121
resume
delete all
let endpoint = length(time)-1
let cmp = v(COMP)[endpoint]
let top = v(TOP)[endpoint]
let decision = 0
if cmp >= 0.9
let code = trial
let decision = 1
end
echo 67 7 $&trial $&cmp $&top 0.30234375 $&decision >> decisions.csv
let trial = code + 64
let drive = (floor(trial / 1) - 2*floor(trial / 2))*1.8
alter VB0 = $&drive
let drive = (floor(trial / 2) - 2*floor(trial / 4))*1.8
alter VB1 = $&drive
let drive = (floor(trial / 4) - 2*floor(trial / 8))*1.8
alter VB2 = $&drive
let drive = (floor(trial / 8) - 2*floor(trial / 16))*1.8
alter VB3 = $&drive
let drive = (floor(trial / 16) - 2*floor(trial / 32))*1.8
alter VB4 = $&drive
let drive = (floor(trial / 32) - 2*floor(trial / 64))*1.8
alter VB5 = $&drive
let drive = (floor(trial / 64) - 2*floor(trial / 128))*1.8
alter VB6 = $&drive
let drive = (floor(trial / 128) - 2*floor(trial / 256))*1.8
alter VB7 = $&drive
stop when time = 0.001212
resume
delete all
let endpoint = length(time)-1
let cmp = v(COMP)[endpoint]
let top = v(TOP)[endpoint]
let decision = 0
if cmp >= 0.9
let code = trial
let decision = 1
end
echo 67 6 $&trial $&cmp $&top 0.30234375 $&decision >> decisions.csv
let trial = code + 32
let drive = (floor(trial / 1) - 2*floor(trial / 2))*1.8
alter VB0 = $&drive
let drive = (floor(trial / 2) - 2*floor(trial / 4))*1.8
alter VB1 = $&drive
let drive = (floor(trial / 4) - 2*floor(trial / 8))*1.8
alter VB2 = $&drive
let drive = (floor(trial / 8) - 2*floor(trial / 16))*1.8
alter VB3 = $&drive
let drive = (floor(trial / 16) - 2*floor(trial / 32))*1.8
alter VB4 = $&drive
let drive = (floor(trial / 32) - 2*floor(trial / 64))*1.8
alter VB5 = $&drive
let drive = (floor(trial / 64) - 2*floor(trial / 128))*1.8
alter VB6 = $&drive
let drive = (floor(trial / 128) - 2*floor(trial / 256))*1.8
alter VB7 = $&drive
stop when time = 0.001214
resume
delete all
let endpoint = length(time)-1
let cmp = v(COMP)[endpoint]
let top = v(TOP)[endpoint]
let decision = 0
if cmp >= 0.9
let code = trial
let decision = 1
end
echo 67 5 $&trial $&cmp $&top 0.30234375 $&decision >> decisions.csv
let trial = code + 16
let drive = (floor(trial / 1) - 2*floor(trial / 2))*1.8
alter VB0 = $&drive
let drive = (floor(trial / 2) - 2*floor(trial / 4))*1.8
alter VB1 = $&drive
let drive = (floor(trial / 4) - 2*floor(trial / 8))*1.8
alter VB2 = $&drive
let drive = (floor(trial / 8) - 2*floor(trial / 16))*1.8
alter VB3 = $&drive
let drive = (floor(trial / 16) - 2*floor(trial / 32))*1.8
alter VB4 = $&drive
let drive = (floor(trial / 32) - 2*floor(trial / 64))*1.8
alter VB5 = $&drive
let drive = (floor(trial / 64) - 2*floor(trial / 128))*1.8
alter VB6 = $&drive
let drive = (floor(trial / 128) - 2*floor(trial / 256))*1.8
alter VB7 = $&drive
stop when time = 0.001216
resume
delete all
let endpoint = length(time)-1
let cmp = v(COMP)[endpoint]
let top = v(TOP)[endpoint]
let decision = 0
if cmp >= 0.9
let code = trial
let decision = 1
end
echo 67 4 $&trial $&cmp $&top 0.30234375 $&decision >> decisions.csv
let trial = code + 8
let drive = (floor(trial / 1) - 2*floor(trial / 2))*1.8
alter VB0 = $&drive
let drive = (floor(trial / 2) - 2*floor(trial / 4))*1.8
alter VB1 = $&drive
let drive = (floor(trial / 4) - 2*floor(trial / 8))*1.8
alter VB2 = $&drive
let drive = (floor(trial / 8) - 2*floor(trial / 16))*1.8
alter VB3 = $&drive
let drive = (floor(trial / 16) - 2*floor(trial / 32))*1.8
alter VB4 = $&drive
let drive = (floor(trial / 32) - 2*floor(trial / 64))*1.8
alter VB5 = $&drive
let drive = (floor(trial / 64) - 2*floor(trial / 128))*1.8
alter VB6 = $&drive
let drive = (floor(trial / 128) - 2*floor(trial / 256))*1.8
alter VB7 = $&drive
stop when time = 0.001218
resume
delete all
let endpoint = length(time)-1
let cmp = v(COMP)[endpoint]
let top = v(TOP)[endpoint]
let decision = 0
if cmp >= 0.9
let code = trial
let decision = 1
end
echo 67 3 $&trial $&cmp $&top 0.30234375 $&decision >> decisions.csv
let trial = code + 4
let drive = (floor(trial / 1) - 2*floor(trial / 2))*1.8
alter VB0 = $&drive
let drive = (floor(trial / 2) - 2*floor(trial / 4))*1.8
alter VB1 = $&drive
let drive = (floor(trial / 4) - 2*floor(trial / 8))*1.8
alter VB2 = $&drive
let drive = (floor(trial / 8) - 2*floor(trial / 16))*1.8
alter VB3 = $&drive
let drive = (floor(trial / 16) - 2*floor(trial / 32))*1.8
alter VB4 = $&drive
let drive = (floor(trial / 32) - 2*floor(trial / 64))*1.8
alter VB5 = $&drive
let drive = (floor(trial / 64) - 2*floor(trial / 128))*1.8
alter VB6 = $&drive
let drive = (floor(trial / 128) - 2*floor(trial / 256))*1.8
alter VB7 = $&drive
stop when time = 0.00122
resume
delete all
let endpoint = length(time)-1
let cmp = v(COMP)[endpoint]
let top = v(TOP)[endpoint]
let decision = 0
if cmp >= 0.9
let code = trial
let decision = 1
end
echo 67 2 $&trial $&cmp $&top 0.30234375 $&decision >> decisions.csv
let trial = code + 2
let drive = (floor(trial / 1) - 2*floor(trial / 2))*1.8
alter VB0 = $&drive
let drive = (floor(trial / 2) - 2*floor(trial / 4))*1.8
alter VB1 = $&drive
let drive = (floor(trial / 4) - 2*floor(trial / 8))*1.8
alter VB2 = $&drive
let drive = (floor(trial / 8) - 2*floor(trial / 16))*1.8
alter VB3 = $&drive
let drive = (floor(trial / 16) - 2*floor(trial / 32))*1.8
alter VB4 = $&drive
let drive = (floor(trial / 32) - 2*floor(trial / 64))*1.8
alter VB5 = $&drive
let drive = (floor(trial / 64) - 2*floor(trial / 128))*1.8
alter VB6 = $&drive
let drive = (floor(trial / 128) - 2*floor(trial / 256))*1.8
alter VB7 = $&drive
stop when time = 0.001222
resume
delete all
let endpoint = length(time)-1
let cmp = v(COMP)[endpoint]
let top = v(TOP)[endpoint]
let decision = 0
if cmp >= 0.9
let code = trial
let decision = 1
end
echo 67 1 $&trial $&cmp $&top 0.30234375 $&decision >> decisions.csv
let trial = code + 1
let drive = (floor(trial / 1) - 2*floor(trial / 2))*1.8
alter VB0 = $&drive
let drive = (floor(trial / 2) - 2*floor(trial / 4))*1.8
alter VB1 = $&drive
let drive = (floor(trial / 4) - 2*floor(trial / 8))*1.8
alter VB2 = $&drive
let drive = (floor(trial / 8) - 2*floor(trial / 16))*1.8
alter VB3 = $&drive
let drive = (floor(trial / 16) - 2*floor(trial / 32))*1.8
alter VB4 = $&drive
let drive = (floor(trial / 32) - 2*floor(trial / 64))*1.8
alter VB5 = $&drive
let drive = (floor(trial / 64) - 2*floor(trial / 128))*1.8
alter VB6 = $&drive
let drive = (floor(trial / 128) - 2*floor(trial / 256))*1.8
alter VB7 = $&drive
stop when time = 0.001224
resume
delete all
let endpoint = length(time)-1
let cmp = v(COMP)[endpoint]
let top = v(TOP)[endpoint]
let decision = 0
if cmp >= 0.9
let code = trial
let decision = 1
end
echo 67 0 $&trial $&cmp $&top 0.30234375 $&decision >> decisions.csv
alter VIN = 0.30703125
alter VSAMPLE = 1.8
alter VB0 = 0
alter VB1 = 0
alter VB2 = 0
alter VB3 = 0
alter VB4 = 0
alter VB5 = 0
alter VB6 = 0
alter VB7 = 0
let code = 0
stop when time = 0.001226
resume
delete all
alter VSAMPLE = 0
let trial = code + 128
let drive = (floor(trial / 1) - 2*floor(trial / 2))*1.8
alter VB0 = $&drive
let drive = (floor(trial / 2) - 2*floor(trial / 4))*1.8
alter VB1 = $&drive
let drive = (floor(trial / 4) - 2*floor(trial / 8))*1.8
alter VB2 = $&drive
let drive = (floor(trial / 8) - 2*floor(trial / 16))*1.8
alter VB3 = $&drive
let drive = (floor(trial / 16) - 2*floor(trial / 32))*1.8
alter VB4 = $&drive
let drive = (floor(trial / 32) - 2*floor(trial / 64))*1.8
alter VB5 = $&drive
let drive = (floor(trial / 64) - 2*floor(trial / 128))*1.8
alter VB6 = $&drive
let drive = (floor(trial / 128) - 2*floor(trial / 256))*1.8
alter VB7 = $&drive
stop when time = 0.001228
resume
delete all
let endpoint = length(time)-1
let cmp = v(COMP)[endpoint]
let top = v(TOP)[endpoint]
let decision = 0
if cmp >= 0.9
let code = trial
let decision = 1
end
echo 68 7 $&trial $&cmp $&top 0.30703125 $&decision >> decisions.csv
let trial = code + 64
let drive = (floor(trial / 1) - 2*floor(trial / 2))*1.8
alter VB0 = $&drive
let drive = (floor(trial / 2) - 2*floor(trial / 4))*1.8
alter VB1 = $&drive
let drive = (floor(trial / 4) - 2*floor(trial / 8))*1.8
alter VB2 = $&drive
let drive = (floor(trial / 8) - 2*floor(trial / 16))*1.8
alter VB3 = $&drive
let drive = (floor(trial / 16) - 2*floor(trial / 32))*1.8
alter VB4 = $&drive
let drive = (floor(trial / 32) - 2*floor(trial / 64))*1.8
alter VB5 = $&drive
let drive = (floor(trial / 64) - 2*floor(trial / 128))*1.8
alter VB6 = $&drive
let drive = (floor(trial / 128) - 2*floor(trial / 256))*1.8
alter VB7 = $&drive
stop when time = 0.00123
resume
delete all
let endpoint = length(time)-1
let cmp = v(COMP)[endpoint]
let top = v(TOP)[endpoint]
let decision = 0
if cmp >= 0.9
let code = trial
let decision = 1
end
echo 68 6 $&trial $&cmp $&top 0.30703125 $&decision >> decisions.csv
let trial = code + 32
let drive = (floor(trial / 1) - 2*floor(trial / 2))*1.8
alter VB0 = $&drive
let drive = (floor(trial / 2) - 2*floor(trial / 4))*1.8
alter VB1 = $&drive
let drive = (floor(trial / 4) - 2*floor(trial / 8))*1.8
alter VB2 = $&drive
let drive = (floor(trial / 8) - 2*floor(trial / 16))*1.8
alter VB3 = $&drive
let drive = (floor(trial / 16) - 2*floor(trial / 32))*1.8
alter VB4 = $&drive
let drive = (floor(trial / 32) - 2*floor(trial / 64))*1.8
alter VB5 = $&drive
let drive = (floor(trial / 64) - 2*floor(trial / 128))*1.8
alter VB6 = $&drive
let drive = (floor(trial / 128) - 2*floor(trial / 256))*1.8
alter VB7 = $&drive
stop when time = 0.001232
resume
delete all
let endpoint = length(time)-1
let cmp = v(COMP)[endpoint]
let top = v(TOP)[endpoint]
let decision = 0
if cmp >= 0.9
let code = trial
let decision = 1
end
echo 68 5 $&trial $&cmp $&top 0.30703125 $&decision >> decisions.csv
let trial = code + 16
let drive = (floor(trial / 1) - 2*floor(trial / 2))*1.8
alter VB0 = $&drive
let drive = (floor(trial / 2) - 2*floor(trial / 4))*1.8
alter VB1 = $&drive
let drive = (floor(trial / 4) - 2*floor(trial / 8))*1.8
alter VB2 = $&drive
let drive = (floor(trial / 8) - 2*floor(trial / 16))*1.8
alter VB3 = $&drive
let drive = (floor(trial / 16) - 2*floor(trial / 32))*1.8
alter VB4 = $&drive
let drive = (floor(trial / 32) - 2*floor(trial / 64))*1.8
alter VB5 = $&drive
let drive = (floor(trial / 64) - 2*floor(trial / 128))*1.8
alter VB6 = $&drive
let drive = (floor(trial / 128) - 2*floor(trial / 256))*1.8
alter VB7 = $&drive
stop when time = 0.001234
resume
delete all
let endpoint = length(time)-1
let cmp = v(COMP)[endpoint]
let top = v(TOP)[endpoint]
let decision = 0
if cmp >= 0.9
let code = trial
let decision = 1
end
echo 68 4 $&trial $&cmp $&top 0.30703125 $&decision >> decisions.csv
let trial = code + 8
let drive = (floor(trial / 1) - 2*floor(trial / 2))*1.8
alter VB0 = $&drive
let drive = (floor(trial / 2) - 2*floor(trial / 4))*1.8
alter VB1 = $&drive
let drive = (floor(trial / 4) - 2*floor(trial / 8))*1.8
alter VB2 = $&drive
let drive = (floor(trial / 8) - 2*floor(trial / 16))*1.8
alter VB3 = $&drive
let drive = (floor(trial / 16) - 2*floor(trial / 32))*1.8
alter VB4 = $&drive
let drive = (floor(trial / 32) - 2*floor(trial / 64))*1.8
alter VB5 = $&drive
let drive = (floor(trial / 64) - 2*floor(trial / 128))*1.8
alter VB6 = $&drive
let drive = (floor(trial / 128) - 2*floor(trial / 256))*1.8
alter VB7 = $&drive
stop when time = 0.001236
resume
delete all
let endpoint = length(time)-1
let cmp = v(COMP)[endpoint]
let top = v(TOP)[endpoint]
let decision = 0
if cmp >= 0.9
let code = trial
let decision = 1
end
echo 68 3 $&trial $&cmp $&top 0.30703125 $&decision >> decisions.csv
let trial = code + 4
let drive = (floor(trial / 1) - 2*floor(trial / 2))*1.8
alter VB0 = $&drive
let drive = (floor(trial / 2) - 2*floor(trial / 4))*1.8
alter VB1 = $&drive
let drive = (floor(trial / 4) - 2*floor(trial / 8))*1.8
alter VB2 = $&drive
let drive = (floor(trial / 8) - 2*floor(trial / 16))*1.8
alter VB3 = $&drive
let drive = (floor(trial / 16) - 2*floor(trial / 32))*1.8
alter VB4 = $&drive
let drive = (floor(trial / 32) - 2*floor(trial / 64))*1.8
alter VB5 = $&drive
let drive = (floor(trial / 64) - 2*floor(trial / 128))*1.8
alter VB6 = $&drive
let drive = (floor(trial / 128) - 2*floor(trial / 256))*1.8
alter VB7 = $&drive
stop when time = 0.001238
resume
delete all
let endpoint = length(time)-1
let cmp = v(COMP)[endpoint]
let top = v(TOP)[endpoint]
let decision = 0
if cmp >= 0.9
let code = trial
let decision = 1
end
echo 68 2 $&trial $&cmp $&top 0.30703125 $&decision >> decisions.csv
let trial = code + 2
let drive = (floor(trial / 1) - 2*floor(trial / 2))*1.8
alter VB0 = $&drive
let drive = (floor(trial / 2) - 2*floor(trial / 4))*1.8
alter VB1 = $&drive
let drive = (floor(trial / 4) - 2*floor(trial / 8))*1.8
alter VB2 = $&drive
let drive = (floor(trial / 8) - 2*floor(trial / 16))*1.8
alter VB3 = $&drive
let drive = (floor(trial / 16) - 2*floor(trial / 32))*1.8
alter VB4 = $&drive
let drive = (floor(trial / 32) - 2*floor(trial / 64))*1.8
alter VB5 = $&drive
let drive = (floor(trial / 64) - 2*floor(trial / 128))*1.8
alter VB6 = $&drive
let drive = (floor(trial / 128) - 2*floor(trial / 256))*1.8
alter VB7 = $&drive
stop when time = 0.00124
resume
delete all
let endpoint = length(time)-1
let cmp = v(COMP)[endpoint]
let top = v(TOP)[endpoint]
let decision = 0
if cmp >= 0.9
let code = trial
let decision = 1
end
echo 68 1 $&trial $&cmp $&top 0.30703125 $&decision >> decisions.csv
let trial = code + 1
let drive = (floor(trial / 1) - 2*floor(trial / 2))*1.8
alter VB0 = $&drive
let drive = (floor(trial / 2) - 2*floor(trial / 4))*1.8
alter VB1 = $&drive
let drive = (floor(trial / 4) - 2*floor(trial / 8))*1.8
alter VB2 = $&drive
let drive = (floor(trial / 8) - 2*floor(trial / 16))*1.8
alter VB3 = $&drive
let drive = (floor(trial / 16) - 2*floor(trial / 32))*1.8
alter VB4 = $&drive
let drive = (floor(trial / 32) - 2*floor(trial / 64))*1.8
alter VB5 = $&drive
let drive = (floor(trial / 64) - 2*floor(trial / 128))*1.8
alter VB6 = $&drive
let drive = (floor(trial / 128) - 2*floor(trial / 256))*1.8
alter VB7 = $&drive
stop when time = 0.001242
resume
delete all
let endpoint = length(time)-1
let cmp = v(COMP)[endpoint]
let top = v(TOP)[endpoint]
let decision = 0
if cmp >= 0.9
let code = trial
let decision = 1
end
echo 68 0 $&trial $&cmp $&top 0.30703125 $&decision >> decisions.csv
alter VIN = 0.31171875
alter VSAMPLE = 1.8
alter VB0 = 0
alter VB1 = 0
alter VB2 = 0
alter VB3 = 0
alter VB4 = 0
alter VB5 = 0
alter VB6 = 0
alter VB7 = 0
let code = 0
stop when time = 0.001244
resume
delete all
alter VSAMPLE = 0
let trial = code + 128
let drive = (floor(trial / 1) - 2*floor(trial / 2))*1.8
alter VB0 = $&drive
let drive = (floor(trial / 2) - 2*floor(trial / 4))*1.8
alter VB1 = $&drive
let drive = (floor(trial / 4) - 2*floor(trial / 8))*1.8
alter VB2 = $&drive
let drive = (floor(trial / 8) - 2*floor(trial / 16))*1.8
alter VB3 = $&drive
let drive = (floor(trial / 16) - 2*floor(trial / 32))*1.8
alter VB4 = $&drive
let drive = (floor(trial / 32) - 2*floor(trial / 64))*1.8
alter VB5 = $&drive
let drive = (floor(trial / 64) - 2*floor(trial / 128))*1.8
alter VB6 = $&drive
let drive = (floor(trial / 128) - 2*floor(trial / 256))*1.8
alter VB7 = $&drive
stop when time = 0.001246
resume
delete all
let endpoint = length(time)-1
let cmp = v(COMP)[endpoint]
let top = v(TOP)[endpoint]
let decision = 0
if cmp >= 0.9
let code = trial
let decision = 1
end
echo 69 7 $&trial $&cmp $&top 0.31171875 $&decision >> decisions.csv
let trial = code + 64
let drive = (floor(trial / 1) - 2*floor(trial / 2))*1.8
alter VB0 = $&drive
let drive = (floor(trial / 2) - 2*floor(trial / 4))*1.8
alter VB1 = $&drive
let drive = (floor(trial / 4) - 2*floor(trial / 8))*1.8
alter VB2 = $&drive
let drive = (floor(trial / 8) - 2*floor(trial / 16))*1.8
alter VB3 = $&drive
let drive = (floor(trial / 16) - 2*floor(trial / 32))*1.8
alter VB4 = $&drive
let drive = (floor(trial / 32) - 2*floor(trial / 64))*1.8
alter VB5 = $&drive
let drive = (floor(trial / 64) - 2*floor(trial / 128))*1.8
alter VB6 = $&drive
let drive = (floor(trial / 128) - 2*floor(trial / 256))*1.8
alter VB7 = $&drive
stop when time = 0.001248
resume
delete all
let endpoint = length(time)-1
let cmp = v(COMP)[endpoint]
let top = v(TOP)[endpoint]
let decision = 0
if cmp >= 0.9
let code = trial
let decision = 1
end
echo 69 6 $&trial $&cmp $&top 0.31171875 $&decision >> decisions.csv
let trial = code + 32
let drive = (floor(trial / 1) - 2*floor(trial / 2))*1.8
alter VB0 = $&drive
let drive = (floor(trial / 2) - 2*floor(trial / 4))*1.8
alter VB1 = $&drive
let drive = (floor(trial / 4) - 2*floor(trial / 8))*1.8
alter VB2 = $&drive
let drive = (floor(trial / 8) - 2*floor(trial / 16))*1.8
alter VB3 = $&drive
let drive = (floor(trial / 16) - 2*floor(trial / 32))*1.8
alter VB4 = $&drive
let drive = (floor(trial / 32) - 2*floor(trial / 64))*1.8
alter VB5 = $&drive
let drive = (floor(trial / 64) - 2*floor(trial / 128))*1.8
alter VB6 = $&drive
let drive = (floor(trial / 128) - 2*floor(trial / 256))*1.8
alter VB7 = $&drive
stop when time = 0.00125
resume
delete all
let endpoint = length(time)-1
let cmp = v(COMP)[endpoint]
let top = v(TOP)[endpoint]
let decision = 0
if cmp >= 0.9
let code = trial
let decision = 1
end
echo 69 5 $&trial $&cmp $&top 0.31171875 $&decision >> decisions.csv
let trial = code + 16
let drive = (floor(trial / 1) - 2*floor(trial / 2))*1.8
alter VB0 = $&drive
let drive = (floor(trial / 2) - 2*floor(trial / 4))*1.8
alter VB1 = $&drive
let drive = (floor(trial / 4) - 2*floor(trial / 8))*1.8
alter VB2 = $&drive
let drive = (floor(trial / 8) - 2*floor(trial / 16))*1.8
alter VB3 = $&drive
let drive = (floor(trial / 16) - 2*floor(trial / 32))*1.8
alter VB4 = $&drive
let drive = (floor(trial / 32) - 2*floor(trial / 64))*1.8
alter VB5 = $&drive
let drive = (floor(trial / 64) - 2*floor(trial / 128))*1.8
alter VB6 = $&drive
let drive = (floor(trial / 128) - 2*floor(trial / 256))*1.8
alter VB7 = $&drive
stop when time = 0.001252
resume
delete all
let endpoint = length(time)-1
let cmp = v(COMP)[endpoint]
let top = v(TOP)[endpoint]
let decision = 0
if cmp >= 0.9
let code = trial
let decision = 1
end
echo 69 4 $&trial $&cmp $&top 0.31171875 $&decision >> decisions.csv
let trial = code + 8
let drive = (floor(trial / 1) - 2*floor(trial / 2))*1.8
alter VB0 = $&drive
let drive = (floor(trial / 2) - 2*floor(trial / 4))*1.8
alter VB1 = $&drive
let drive = (floor(trial / 4) - 2*floor(trial / 8))*1.8
alter VB2 = $&drive
let drive = (floor(trial / 8) - 2*floor(trial / 16))*1.8
alter VB3 = $&drive
let drive = (floor(trial / 16) - 2*floor(trial / 32))*1.8
alter VB4 = $&drive
let drive = (floor(trial / 32) - 2*floor(trial / 64))*1.8
alter VB5 = $&drive
let drive = (floor(trial / 64) - 2*floor(trial / 128))*1.8
alter VB6 = $&drive
let drive = (floor(trial / 128) - 2*floor(trial / 256))*1.8
alter VB7 = $&drive
stop when time = 0.001254
resume
delete all
let endpoint = length(time)-1
let cmp = v(COMP)[endpoint]
let top = v(TOP)[endpoint]
let decision = 0
if cmp >= 0.9
let code = trial
let decision = 1
end
echo 69 3 $&trial $&cmp $&top 0.31171875 $&decision >> decisions.csv
let trial = code + 4
let drive = (floor(trial / 1) - 2*floor(trial / 2))*1.8
alter VB0 = $&drive
let drive = (floor(trial / 2) - 2*floor(trial / 4))*1.8
alter VB1 = $&drive
let drive = (floor(trial / 4) - 2*floor(trial / 8))*1.8
alter VB2 = $&drive
let drive = (floor(trial / 8) - 2*floor(trial / 16))*1.8
alter VB3 = $&drive
let drive = (floor(trial / 16) - 2*floor(trial / 32))*1.8
alter VB4 = $&drive
let drive = (floor(trial / 32) - 2*floor(trial / 64))*1.8
alter VB5 = $&drive
let drive = (floor(trial / 64) - 2*floor(trial / 128))*1.8
alter VB6 = $&drive
let drive = (floor(trial / 128) - 2*floor(trial / 256))*1.8
alter VB7 = $&drive
stop when time = 0.001256
resume
delete all
let endpoint = length(time)-1
let cmp = v(COMP)[endpoint]
let top = v(TOP)[endpoint]
let decision = 0
if cmp >= 0.9
let code = trial
let decision = 1
end
echo 69 2 $&trial $&cmp $&top 0.31171875 $&decision >> decisions.csv
let trial = code + 2
let drive = (floor(trial / 1) - 2*floor(trial / 2))*1.8
alter VB0 = $&drive
let drive = (floor(trial / 2) - 2*floor(trial / 4))*1.8
alter VB1 = $&drive
let drive = (floor(trial / 4) - 2*floor(trial / 8))*1.8
alter VB2 = $&drive
let drive = (floor(trial / 8) - 2*floor(trial / 16))*1.8
alter VB3 = $&drive
let drive = (floor(trial / 16) - 2*floor(trial / 32))*1.8
alter VB4 = $&drive
let drive = (floor(trial / 32) - 2*floor(trial / 64))*1.8
alter VB5 = $&drive
let drive = (floor(trial / 64) - 2*floor(trial / 128))*1.8
alter VB6 = $&drive
let drive = (floor(trial / 128) - 2*floor(trial / 256))*1.8
alter VB7 = $&drive
stop when time = 0.001258
resume
delete all
let endpoint = length(time)-1
let cmp = v(COMP)[endpoint]
let top = v(TOP)[endpoint]
let decision = 0
if cmp >= 0.9
let code = trial
let decision = 1
end
echo 69 1 $&trial $&cmp $&top 0.31171875 $&decision >> decisions.csv
let trial = code + 1
let drive = (floor(trial / 1) - 2*floor(trial / 2))*1.8
alter VB0 = $&drive
let drive = (floor(trial / 2) - 2*floor(trial / 4))*1.8
alter VB1 = $&drive
let drive = (floor(trial / 4) - 2*floor(trial / 8))*1.8
alter VB2 = $&drive
let drive = (floor(trial / 8) - 2*floor(trial / 16))*1.8
alter VB3 = $&drive
let drive = (floor(trial / 16) - 2*floor(trial / 32))*1.8
alter VB4 = $&drive
let drive = (floor(trial / 32) - 2*floor(trial / 64))*1.8
alter VB5 = $&drive
let drive = (floor(trial / 64) - 2*floor(trial / 128))*1.8
alter VB6 = $&drive
let drive = (floor(trial / 128) - 2*floor(trial / 256))*1.8
alter VB7 = $&drive
stop when time = 0.00126
resume
delete all
let endpoint = length(time)-1
let cmp = v(COMP)[endpoint]
let top = v(TOP)[endpoint]
let decision = 0
if cmp >= 0.9
let code = trial
let decision = 1
end
echo 69 0 $&trial $&cmp $&top 0.31171875 $&decision >> decisions.csv
alter VIN = 0.31640625
alter VSAMPLE = 1.8
alter VB0 = 0
alter VB1 = 0
alter VB2 = 0
alter VB3 = 0
alter VB4 = 0
alter VB5 = 0
alter VB6 = 0
alter VB7 = 0
let code = 0
stop when time = 0.001262
resume
delete all
alter VSAMPLE = 0
let trial = code + 128
let drive = (floor(trial / 1) - 2*floor(trial / 2))*1.8
alter VB0 = $&drive
let drive = (floor(trial / 2) - 2*floor(trial / 4))*1.8
alter VB1 = $&drive
let drive = (floor(trial / 4) - 2*floor(trial / 8))*1.8
alter VB2 = $&drive
let drive = (floor(trial / 8) - 2*floor(trial / 16))*1.8
alter VB3 = $&drive
let drive = (floor(trial / 16) - 2*floor(trial / 32))*1.8
alter VB4 = $&drive
let drive = (floor(trial / 32) - 2*floor(trial / 64))*1.8
alter VB5 = $&drive
let drive = (floor(trial / 64) - 2*floor(trial / 128))*1.8
alter VB6 = $&drive
let drive = (floor(trial / 128) - 2*floor(trial / 256))*1.8
alter VB7 = $&drive
stop when time = 0.001264
resume
delete all
let endpoint = length(time)-1
let cmp = v(COMP)[endpoint]
let top = v(TOP)[endpoint]
let decision = 0
if cmp >= 0.9
let code = trial
let decision = 1
end
echo 70 7 $&trial $&cmp $&top 0.31640625 $&decision >> decisions.csv
let trial = code + 64
let drive = (floor(trial / 1) - 2*floor(trial / 2))*1.8
alter VB0 = $&drive
let drive = (floor(trial / 2) - 2*floor(trial / 4))*1.8
alter VB1 = $&drive
let drive = (floor(trial / 4) - 2*floor(trial / 8))*1.8
alter VB2 = $&drive
let drive = (floor(trial / 8) - 2*floor(trial / 16))*1.8
alter VB3 = $&drive
let drive = (floor(trial / 16) - 2*floor(trial / 32))*1.8
alter VB4 = $&drive
let drive = (floor(trial / 32) - 2*floor(trial / 64))*1.8
alter VB5 = $&drive
let drive = (floor(trial / 64) - 2*floor(trial / 128))*1.8
alter VB6 = $&drive
let drive = (floor(trial / 128) - 2*floor(trial / 256))*1.8
alter VB7 = $&drive
stop when time = 0.001266
resume
delete all
let endpoint = length(time)-1
let cmp = v(COMP)[endpoint]
let top = v(TOP)[endpoint]
let decision = 0
if cmp >= 0.9
let code = trial
let decision = 1
end
echo 70 6 $&trial $&cmp $&top 0.31640625 $&decision >> decisions.csv
let trial = code + 32
let drive = (floor(trial / 1) - 2*floor(trial / 2))*1.8
alter VB0 = $&drive
let drive = (floor(trial / 2) - 2*floor(trial / 4))*1.8
alter VB1 = $&drive
let drive = (floor(trial / 4) - 2*floor(trial / 8))*1.8
alter VB2 = $&drive
let drive = (floor(trial / 8) - 2*floor(trial / 16))*1.8
alter VB3 = $&drive
let drive = (floor(trial / 16) - 2*floor(trial / 32))*1.8
alter VB4 = $&drive
let drive = (floor(trial / 32) - 2*floor(trial / 64))*1.8
alter VB5 = $&drive
let drive = (floor(trial / 64) - 2*floor(trial / 128))*1.8
alter VB6 = $&drive
let drive = (floor(trial / 128) - 2*floor(trial / 256))*1.8
alter VB7 = $&drive
stop when time = 0.001268
resume
delete all
let endpoint = length(time)-1
let cmp = v(COMP)[endpoint]
let top = v(TOP)[endpoint]
let decision = 0
if cmp >= 0.9
let code = trial
let decision = 1
end
echo 70 5 $&trial $&cmp $&top 0.31640625 $&decision >> decisions.csv
let trial = code + 16
let drive = (floor(trial / 1) - 2*floor(trial / 2))*1.8
alter VB0 = $&drive
let drive = (floor(trial / 2) - 2*floor(trial / 4))*1.8
alter VB1 = $&drive
let drive = (floor(trial / 4) - 2*floor(trial / 8))*1.8
alter VB2 = $&drive
let drive = (floor(trial / 8) - 2*floor(trial / 16))*1.8
alter VB3 = $&drive
let drive = (floor(trial / 16) - 2*floor(trial / 32))*1.8
alter VB4 = $&drive
let drive = (floor(trial / 32) - 2*floor(trial / 64))*1.8
alter VB5 = $&drive
let drive = (floor(trial / 64) - 2*floor(trial / 128))*1.8
alter VB6 = $&drive
let drive = (floor(trial / 128) - 2*floor(trial / 256))*1.8
alter VB7 = $&drive
stop when time = 0.00127
resume
delete all
let endpoint = length(time)-1
let cmp = v(COMP)[endpoint]
let top = v(TOP)[endpoint]
let decision = 0
if cmp >= 0.9
let code = trial
let decision = 1
end
echo 70 4 $&trial $&cmp $&top 0.31640625 $&decision >> decisions.csv
let trial = code + 8
let drive = (floor(trial / 1) - 2*floor(trial / 2))*1.8
alter VB0 = $&drive
let drive = (floor(trial / 2) - 2*floor(trial / 4))*1.8
alter VB1 = $&drive
let drive = (floor(trial / 4) - 2*floor(trial / 8))*1.8
alter VB2 = $&drive
let drive = (floor(trial / 8) - 2*floor(trial / 16))*1.8
alter VB3 = $&drive
let drive = (floor(trial / 16) - 2*floor(trial / 32))*1.8
alter VB4 = $&drive
let drive = (floor(trial / 32) - 2*floor(trial / 64))*1.8
alter VB5 = $&drive
let drive = (floor(trial / 64) - 2*floor(trial / 128))*1.8
alter VB6 = $&drive
let drive = (floor(trial / 128) - 2*floor(trial / 256))*1.8
alter VB7 = $&drive
stop when time = 0.001272
resume
delete all
let endpoint = length(time)-1
let cmp = v(COMP)[endpoint]
let top = v(TOP)[endpoint]
let decision = 0
if cmp >= 0.9
let code = trial
let decision = 1
end
echo 70 3 $&trial $&cmp $&top 0.31640625 $&decision >> decisions.csv
let trial = code + 4
let drive = (floor(trial / 1) - 2*floor(trial / 2))*1.8
alter VB0 = $&drive
let drive = (floor(trial / 2) - 2*floor(trial / 4))*1.8
alter VB1 = $&drive
let drive = (floor(trial / 4) - 2*floor(trial / 8))*1.8
alter VB2 = $&drive
let drive = (floor(trial / 8) - 2*floor(trial / 16))*1.8
alter VB3 = $&drive
let drive = (floor(trial / 16) - 2*floor(trial / 32))*1.8
alter VB4 = $&drive
let drive = (floor(trial / 32) - 2*floor(trial / 64))*1.8
alter VB5 = $&drive
let drive = (floor(trial / 64) - 2*floor(trial / 128))*1.8
alter VB6 = $&drive
let drive = (floor(trial / 128) - 2*floor(trial / 256))*1.8
alter VB7 = $&drive
stop when time = 0.001274
resume
delete all
let endpoint = length(time)-1
let cmp = v(COMP)[endpoint]
let top = v(TOP)[endpoint]
let decision = 0
if cmp >= 0.9
let code = trial
let decision = 1
end
echo 70 2 $&trial $&cmp $&top 0.31640625 $&decision >> decisions.csv
let trial = code + 2
let drive = (floor(trial / 1) - 2*floor(trial / 2))*1.8
alter VB0 = $&drive
let drive = (floor(trial / 2) - 2*floor(trial / 4))*1.8
alter VB1 = $&drive
let drive = (floor(trial / 4) - 2*floor(trial / 8))*1.8
alter VB2 = $&drive
let drive = (floor(trial / 8) - 2*floor(trial / 16))*1.8
alter VB3 = $&drive
let drive = (floor(trial / 16) - 2*floor(trial / 32))*1.8
alter VB4 = $&drive
let drive = (floor(trial / 32) - 2*floor(trial / 64))*1.8
alter VB5 = $&drive
let drive = (floor(trial / 64) - 2*floor(trial / 128))*1.8
alter VB6 = $&drive
let drive = (floor(trial / 128) - 2*floor(trial / 256))*1.8
alter VB7 = $&drive
stop when time = 0.001276
resume
delete all
let endpoint = length(time)-1
let cmp = v(COMP)[endpoint]
let top = v(TOP)[endpoint]
let decision = 0
if cmp >= 0.9
let code = trial
let decision = 1
end
echo 70 1 $&trial $&cmp $&top 0.31640625 $&decision >> decisions.csv
let trial = code + 1
let drive = (floor(trial / 1) - 2*floor(trial / 2))*1.8
alter VB0 = $&drive
let drive = (floor(trial / 2) - 2*floor(trial / 4))*1.8
alter VB1 = $&drive
let drive = (floor(trial / 4) - 2*floor(trial / 8))*1.8
alter VB2 = $&drive
let drive = (floor(trial / 8) - 2*floor(trial / 16))*1.8
alter VB3 = $&drive
let drive = (floor(trial / 16) - 2*floor(trial / 32))*1.8
alter VB4 = $&drive
let drive = (floor(trial / 32) - 2*floor(trial / 64))*1.8
alter VB5 = $&drive
let drive = (floor(trial / 64) - 2*floor(trial / 128))*1.8
alter VB6 = $&drive
let drive = (floor(trial / 128) - 2*floor(trial / 256))*1.8
alter VB7 = $&drive
stop when time = 0.001278
resume
delete all
let endpoint = length(time)-1
let cmp = v(COMP)[endpoint]
let top = v(TOP)[endpoint]
let decision = 0
if cmp >= 0.9
let code = trial
let decision = 1
end
echo 70 0 $&trial $&cmp $&top 0.31640625 $&decision >> decisions.csv
alter VIN = 0.32109375
alter VSAMPLE = 1.8
alter VB0 = 0
alter VB1 = 0
alter VB2 = 0
alter VB3 = 0
alter VB4 = 0
alter VB5 = 0
alter VB6 = 0
alter VB7 = 0
let code = 0
stop when time = 0.00128
resume
delete all
alter VSAMPLE = 0
let trial = code + 128
let drive = (floor(trial / 1) - 2*floor(trial / 2))*1.8
alter VB0 = $&drive
let drive = (floor(trial / 2) - 2*floor(trial / 4))*1.8
alter VB1 = $&drive
let drive = (floor(trial / 4) - 2*floor(trial / 8))*1.8
alter VB2 = $&drive
let drive = (floor(trial / 8) - 2*floor(trial / 16))*1.8
alter VB3 = $&drive
let drive = (floor(trial / 16) - 2*floor(trial / 32))*1.8
alter VB4 = $&drive
let drive = (floor(trial / 32) - 2*floor(trial / 64))*1.8
alter VB5 = $&drive
let drive = (floor(trial / 64) - 2*floor(trial / 128))*1.8
alter VB6 = $&drive
let drive = (floor(trial / 128) - 2*floor(trial / 256))*1.8
alter VB7 = $&drive
stop when time = 0.001282
resume
delete all
let endpoint = length(time)-1
let cmp = v(COMP)[endpoint]
let top = v(TOP)[endpoint]
let decision = 0
if cmp >= 0.9
let code = trial
let decision = 1
end
echo 71 7 $&trial $&cmp $&top 0.32109375 $&decision >> decisions.csv
let trial = code + 64
let drive = (floor(trial / 1) - 2*floor(trial / 2))*1.8
alter VB0 = $&drive
let drive = (floor(trial / 2) - 2*floor(trial / 4))*1.8
alter VB1 = $&drive
let drive = (floor(trial / 4) - 2*floor(trial / 8))*1.8
alter VB2 = $&drive
let drive = (floor(trial / 8) - 2*floor(trial / 16))*1.8
alter VB3 = $&drive
let drive = (floor(trial / 16) - 2*floor(trial / 32))*1.8
alter VB4 = $&drive
let drive = (floor(trial / 32) - 2*floor(trial / 64))*1.8
alter VB5 = $&drive
let drive = (floor(trial / 64) - 2*floor(trial / 128))*1.8
alter VB6 = $&drive
let drive = (floor(trial / 128) - 2*floor(trial / 256))*1.8
alter VB7 = $&drive
stop when time = 0.001284
resume
delete all
let endpoint = length(time)-1
let cmp = v(COMP)[endpoint]
let top = v(TOP)[endpoint]
let decision = 0
if cmp >= 0.9
let code = trial
let decision = 1
end
echo 71 6 $&trial $&cmp $&top 0.32109375 $&decision >> decisions.csv
let trial = code + 32
let drive = (floor(trial / 1) - 2*floor(trial / 2))*1.8
alter VB0 = $&drive
let drive = (floor(trial / 2) - 2*floor(trial / 4))*1.8
alter VB1 = $&drive
let drive = (floor(trial / 4) - 2*floor(trial / 8))*1.8
alter VB2 = $&drive
let drive = (floor(trial / 8) - 2*floor(trial / 16))*1.8
alter VB3 = $&drive
let drive = (floor(trial / 16) - 2*floor(trial / 32))*1.8
alter VB4 = $&drive
let drive = (floor(trial / 32) - 2*floor(trial / 64))*1.8
alter VB5 = $&drive
let drive = (floor(trial / 64) - 2*floor(trial / 128))*1.8
alter VB6 = $&drive
let drive = (floor(trial / 128) - 2*floor(trial / 256))*1.8
alter VB7 = $&drive
stop when time = 0.001286
resume
delete all
let endpoint = length(time)-1
let cmp = v(COMP)[endpoint]
let top = v(TOP)[endpoint]
let decision = 0
if cmp >= 0.9
let code = trial
let decision = 1
end
echo 71 5 $&trial $&cmp $&top 0.32109375 $&decision >> decisions.csv
let trial = code + 16
let drive = (floor(trial / 1) - 2*floor(trial / 2))*1.8
alter VB0 = $&drive
let drive = (floor(trial / 2) - 2*floor(trial / 4))*1.8
alter VB1 = $&drive
let drive = (floor(trial / 4) - 2*floor(trial / 8))*1.8
alter VB2 = $&drive
let drive = (floor(trial / 8) - 2*floor(trial / 16))*1.8
alter VB3 = $&drive
let drive = (floor(trial / 16) - 2*floor(trial / 32))*1.8
alter VB4 = $&drive
let drive = (floor(trial / 32) - 2*floor(trial / 64))*1.8
alter VB5 = $&drive
let drive = (floor(trial / 64) - 2*floor(trial / 128))*1.8
alter VB6 = $&drive
let drive = (floor(trial / 128) - 2*floor(trial / 256))*1.8
alter VB7 = $&drive
stop when time = 0.001288
resume
delete all
let endpoint = length(time)-1
let cmp = v(COMP)[endpoint]
let top = v(TOP)[endpoint]
let decision = 0
if cmp >= 0.9
let code = trial
let decision = 1
end
echo 71 4 $&trial $&cmp $&top 0.32109375 $&decision >> decisions.csv
let trial = code + 8
let drive = (floor(trial / 1) - 2*floor(trial / 2))*1.8
alter VB0 = $&drive
let drive = (floor(trial / 2) - 2*floor(trial / 4))*1.8
alter VB1 = $&drive
let drive = (floor(trial / 4) - 2*floor(trial / 8))*1.8
alter VB2 = $&drive
let drive = (floor(trial / 8) - 2*floor(trial / 16))*1.8
alter VB3 = $&drive
let drive = (floor(trial / 16) - 2*floor(trial / 32))*1.8
alter VB4 = $&drive
let drive = (floor(trial / 32) - 2*floor(trial / 64))*1.8
alter VB5 = $&drive
let drive = (floor(trial / 64) - 2*floor(trial / 128))*1.8
alter VB6 = $&drive
let drive = (floor(trial / 128) - 2*floor(trial / 256))*1.8
alter VB7 = $&drive
stop when time = 0.00129
resume
delete all
let endpoint = length(time)-1
let cmp = v(COMP)[endpoint]
let top = v(TOP)[endpoint]
let decision = 0
if cmp >= 0.9
let code = trial
let decision = 1
end
echo 71 3 $&trial $&cmp $&top 0.32109375 $&decision >> decisions.csv
let trial = code + 4
let drive = (floor(trial / 1) - 2*floor(trial / 2))*1.8
alter VB0 = $&drive
let drive = (floor(trial / 2) - 2*floor(trial / 4))*1.8
alter VB1 = $&drive
let drive = (floor(trial / 4) - 2*floor(trial / 8))*1.8
alter VB2 = $&drive
let drive = (floor(trial / 8) - 2*floor(trial / 16))*1.8
alter VB3 = $&drive
let drive = (floor(trial / 16) - 2*floor(trial / 32))*1.8
alter VB4 = $&drive
let drive = (floor(trial / 32) - 2*floor(trial / 64))*1.8
alter VB5 = $&drive
let drive = (floor(trial / 64) - 2*floor(trial / 128))*1.8
alter VB6 = $&drive
let drive = (floor(trial / 128) - 2*floor(trial / 256))*1.8
alter VB7 = $&drive
stop when time = 0.001292
resume
delete all
let endpoint = length(time)-1
let cmp = v(COMP)[endpoint]
let top = v(TOP)[endpoint]
let decision = 0
if cmp >= 0.9
let code = trial
let decision = 1
end
echo 71 2 $&trial $&cmp $&top 0.32109375 $&decision >> decisions.csv
let trial = code + 2
let drive = (floor(trial / 1) - 2*floor(trial / 2))*1.8
alter VB0 = $&drive
let drive = (floor(trial / 2) - 2*floor(trial / 4))*1.8
alter VB1 = $&drive
let drive = (floor(trial / 4) - 2*floor(trial / 8))*1.8
alter VB2 = $&drive
let drive = (floor(trial / 8) - 2*floor(trial / 16))*1.8
alter VB3 = $&drive
let drive = (floor(trial / 16) - 2*floor(trial / 32))*1.8
alter VB4 = $&drive
let drive = (floor(trial / 32) - 2*floor(trial / 64))*1.8
alter VB5 = $&drive
let drive = (floor(trial / 64) - 2*floor(trial / 128))*1.8
alter VB6 = $&drive
let drive = (floor(trial / 128) - 2*floor(trial / 256))*1.8
alter VB7 = $&drive
stop when time = 0.001294
resume
delete all
let endpoint = length(time)-1
let cmp = v(COMP)[endpoint]
let top = v(TOP)[endpoint]
let decision = 0
if cmp >= 0.9
let code = trial
let decision = 1
end
echo 71 1 $&trial $&cmp $&top 0.32109375 $&decision >> decisions.csv
let trial = code + 1
let drive = (floor(trial / 1) - 2*floor(trial / 2))*1.8
alter VB0 = $&drive
let drive = (floor(trial / 2) - 2*floor(trial / 4))*1.8
alter VB1 = $&drive
let drive = (floor(trial / 4) - 2*floor(trial / 8))*1.8
alter VB2 = $&drive
let drive = (floor(trial / 8) - 2*floor(trial / 16))*1.8
alter VB3 = $&drive
let drive = (floor(trial / 16) - 2*floor(trial / 32))*1.8
alter VB4 = $&drive
let drive = (floor(trial / 32) - 2*floor(trial / 64))*1.8
alter VB5 = $&drive
let drive = (floor(trial / 64) - 2*floor(trial / 128))*1.8
alter VB6 = $&drive
let drive = (floor(trial / 128) - 2*floor(trial / 256))*1.8
alter VB7 = $&drive
stop when time = 0.001296
resume
delete all
let endpoint = length(time)-1
let cmp = v(COMP)[endpoint]
let top = v(TOP)[endpoint]
let decision = 0
if cmp >= 0.9
let code = trial
let decision = 1
end
echo 71 0 $&trial $&cmp $&top 0.32109375 $&decision >> decisions.csv
alter VIN = 0.32578125
alter VSAMPLE = 1.8
alter VB0 = 0
alter VB1 = 0
alter VB2 = 0
alter VB3 = 0
alter VB4 = 0
alter VB5 = 0
alter VB6 = 0
alter VB7 = 0
let code = 0
stop when time = 0.001298
resume
delete all
alter VSAMPLE = 0
let trial = code + 128
let drive = (floor(trial / 1) - 2*floor(trial / 2))*1.8
alter VB0 = $&drive
let drive = (floor(trial / 2) - 2*floor(trial / 4))*1.8
alter VB1 = $&drive
let drive = (floor(trial / 4) - 2*floor(trial / 8))*1.8
alter VB2 = $&drive
let drive = (floor(trial / 8) - 2*floor(trial / 16))*1.8
alter VB3 = $&drive
let drive = (floor(trial / 16) - 2*floor(trial / 32))*1.8
alter VB4 = $&drive
let drive = (floor(trial / 32) - 2*floor(trial / 64))*1.8
alter VB5 = $&drive
let drive = (floor(trial / 64) - 2*floor(trial / 128))*1.8
alter VB6 = $&drive
let drive = (floor(trial / 128) - 2*floor(trial / 256))*1.8
alter VB7 = $&drive
stop when time = 0.0013
resume
delete all
let endpoint = length(time)-1
let cmp = v(COMP)[endpoint]
let top = v(TOP)[endpoint]
let decision = 0
if cmp >= 0.9
let code = trial
let decision = 1
end
echo 72 7 $&trial $&cmp $&top 0.32578125 $&decision >> decisions.csv
let trial = code + 64
let drive = (floor(trial / 1) - 2*floor(trial / 2))*1.8
alter VB0 = $&drive
let drive = (floor(trial / 2) - 2*floor(trial / 4))*1.8
alter VB1 = $&drive
let drive = (floor(trial / 4) - 2*floor(trial / 8))*1.8
alter VB2 = $&drive
let drive = (floor(trial / 8) - 2*floor(trial / 16))*1.8
alter VB3 = $&drive
let drive = (floor(trial / 16) - 2*floor(trial / 32))*1.8
alter VB4 = $&drive
let drive = (floor(trial / 32) - 2*floor(trial / 64))*1.8
alter VB5 = $&drive
let drive = (floor(trial / 64) - 2*floor(trial / 128))*1.8
alter VB6 = $&drive
let drive = (floor(trial / 128) - 2*floor(trial / 256))*1.8
alter VB7 = $&drive
stop when time = 0.001302
resume
delete all
let endpoint = length(time)-1
let cmp = v(COMP)[endpoint]
let top = v(TOP)[endpoint]
let decision = 0
if cmp >= 0.9
let code = trial
let decision = 1
end
echo 72 6 $&trial $&cmp $&top 0.32578125 $&decision >> decisions.csv
let trial = code + 32
let drive = (floor(trial / 1) - 2*floor(trial / 2))*1.8
alter VB0 = $&drive
let drive = (floor(trial / 2) - 2*floor(trial / 4))*1.8
alter VB1 = $&drive
let drive = (floor(trial / 4) - 2*floor(trial / 8))*1.8
alter VB2 = $&drive
let drive = (floor(trial / 8) - 2*floor(trial / 16))*1.8
alter VB3 = $&drive
let drive = (floor(trial / 16) - 2*floor(trial / 32))*1.8
alter VB4 = $&drive
let drive = (floor(trial / 32) - 2*floor(trial / 64))*1.8
alter VB5 = $&drive
let drive = (floor(trial / 64) - 2*floor(trial / 128))*1.8
alter VB6 = $&drive
let drive = (floor(trial / 128) - 2*floor(trial / 256))*1.8
alter VB7 = $&drive
stop when time = 0.001304
resume
delete all
let endpoint = length(time)-1
let cmp = v(COMP)[endpoint]
let top = v(TOP)[endpoint]
let decision = 0
if cmp >= 0.9
let code = trial
let decision = 1
end
echo 72 5 $&trial $&cmp $&top 0.32578125 $&decision >> decisions.csv
let trial = code + 16
let drive = (floor(trial / 1) - 2*floor(trial / 2))*1.8
alter VB0 = $&drive
let drive = (floor(trial / 2) - 2*floor(trial / 4))*1.8
alter VB1 = $&drive
let drive = (floor(trial / 4) - 2*floor(trial / 8))*1.8
alter VB2 = $&drive
let drive = (floor(trial / 8) - 2*floor(trial / 16))*1.8
alter VB3 = $&drive
let drive = (floor(trial / 16) - 2*floor(trial / 32))*1.8
alter VB4 = $&drive
let drive = (floor(trial / 32) - 2*floor(trial / 64))*1.8
alter VB5 = $&drive
let drive = (floor(trial / 64) - 2*floor(trial / 128))*1.8
alter VB6 = $&drive
let drive = (floor(trial / 128) - 2*floor(trial / 256))*1.8
alter VB7 = $&drive
stop when time = 0.001306
resume
delete all
let endpoint = length(time)-1
let cmp = v(COMP)[endpoint]
let top = v(TOP)[endpoint]
let decision = 0
if cmp >= 0.9
let code = trial
let decision = 1
end
echo 72 4 $&trial $&cmp $&top 0.32578125 $&decision >> decisions.csv
let trial = code + 8
let drive = (floor(trial / 1) - 2*floor(trial / 2))*1.8
alter VB0 = $&drive
let drive = (floor(trial / 2) - 2*floor(trial / 4))*1.8
alter VB1 = $&drive
let drive = (floor(trial / 4) - 2*floor(trial / 8))*1.8
alter VB2 = $&drive
let drive = (floor(trial / 8) - 2*floor(trial / 16))*1.8
alter VB3 = $&drive
let drive = (floor(trial / 16) - 2*floor(trial / 32))*1.8
alter VB4 = $&drive
let drive = (floor(trial / 32) - 2*floor(trial / 64))*1.8
alter VB5 = $&drive
let drive = (floor(trial / 64) - 2*floor(trial / 128))*1.8
alter VB6 = $&drive
let drive = (floor(trial / 128) - 2*floor(trial / 256))*1.8
alter VB7 = $&drive
stop when time = 0.001308
resume
delete all
let endpoint = length(time)-1
let cmp = v(COMP)[endpoint]
let top = v(TOP)[endpoint]
let decision = 0
if cmp >= 0.9
let code = trial
let decision = 1
end
echo 72 3 $&trial $&cmp $&top 0.32578125 $&decision >> decisions.csv
let trial = code + 4
let drive = (floor(trial / 1) - 2*floor(trial / 2))*1.8
alter VB0 = $&drive
let drive = (floor(trial / 2) - 2*floor(trial / 4))*1.8
alter VB1 = $&drive
let drive = (floor(trial / 4) - 2*floor(trial / 8))*1.8
alter VB2 = $&drive
let drive = (floor(trial / 8) - 2*floor(trial / 16))*1.8
alter VB3 = $&drive
let drive = (floor(trial / 16) - 2*floor(trial / 32))*1.8
alter VB4 = $&drive
let drive = (floor(trial / 32) - 2*floor(trial / 64))*1.8
alter VB5 = $&drive
let drive = (floor(trial / 64) - 2*floor(trial / 128))*1.8
alter VB6 = $&drive
let drive = (floor(trial / 128) - 2*floor(trial / 256))*1.8
alter VB7 = $&drive
stop when time = 0.00131
resume
delete all
let endpoint = length(time)-1
let cmp = v(COMP)[endpoint]
let top = v(TOP)[endpoint]
let decision = 0
if cmp >= 0.9
let code = trial
let decision = 1
end
echo 72 2 $&trial $&cmp $&top 0.32578125 $&decision >> decisions.csv
let trial = code + 2
let drive = (floor(trial / 1) - 2*floor(trial / 2))*1.8
alter VB0 = $&drive
let drive = (floor(trial / 2) - 2*floor(trial / 4))*1.8
alter VB1 = $&drive
let drive = (floor(trial / 4) - 2*floor(trial / 8))*1.8
alter VB2 = $&drive
let drive = (floor(trial / 8) - 2*floor(trial / 16))*1.8
alter VB3 = $&drive
let drive = (floor(trial / 16) - 2*floor(trial / 32))*1.8
alter VB4 = $&drive
let drive = (floor(trial / 32) - 2*floor(trial / 64))*1.8
alter VB5 = $&drive
let drive = (floor(trial / 64) - 2*floor(trial / 128))*1.8
alter VB6 = $&drive
let drive = (floor(trial / 128) - 2*floor(trial / 256))*1.8
alter VB7 = $&drive
stop when time = 0.001312
resume
delete all
let endpoint = length(time)-1
let cmp = v(COMP)[endpoint]
let top = v(TOP)[endpoint]
let decision = 0
if cmp >= 0.9
let code = trial
let decision = 1
end
echo 72 1 $&trial $&cmp $&top 0.32578125 $&decision >> decisions.csv
let trial = code + 1
let drive = (floor(trial / 1) - 2*floor(trial / 2))*1.8
alter VB0 = $&drive
let drive = (floor(trial / 2) - 2*floor(trial / 4))*1.8
alter VB1 = $&drive
let drive = (floor(trial / 4) - 2*floor(trial / 8))*1.8
alter VB2 = $&drive
let drive = (floor(trial / 8) - 2*floor(trial / 16))*1.8
alter VB3 = $&drive
let drive = (floor(trial / 16) - 2*floor(trial / 32))*1.8
alter VB4 = $&drive
let drive = (floor(trial / 32) - 2*floor(trial / 64))*1.8
alter VB5 = $&drive
let drive = (floor(trial / 64) - 2*floor(trial / 128))*1.8
alter VB6 = $&drive
let drive = (floor(trial / 128) - 2*floor(trial / 256))*1.8
alter VB7 = $&drive
stop when time = 0.001314
resume
delete all
let endpoint = length(time)-1
let cmp = v(COMP)[endpoint]
let top = v(TOP)[endpoint]
let decision = 0
if cmp >= 0.9
let code = trial
let decision = 1
end
echo 72 0 $&trial $&cmp $&top 0.32578125 $&decision >> decisions.csv
alter VIN = 0.33046875
alter VSAMPLE = 1.8
alter VB0 = 0
alter VB1 = 0
alter VB2 = 0
alter VB3 = 0
alter VB4 = 0
alter VB5 = 0
alter VB6 = 0
alter VB7 = 0
let code = 0
stop when time = 0.001316
resume
delete all
alter VSAMPLE = 0
let trial = code + 128
let drive = (floor(trial / 1) - 2*floor(trial / 2))*1.8
alter VB0 = $&drive
let drive = (floor(trial / 2) - 2*floor(trial / 4))*1.8
alter VB1 = $&drive
let drive = (floor(trial / 4) - 2*floor(trial / 8))*1.8
alter VB2 = $&drive
let drive = (floor(trial / 8) - 2*floor(trial / 16))*1.8
alter VB3 = $&drive
let drive = (floor(trial / 16) - 2*floor(trial / 32))*1.8
alter VB4 = $&drive
let drive = (floor(trial / 32) - 2*floor(trial / 64))*1.8
alter VB5 = $&drive
let drive = (floor(trial / 64) - 2*floor(trial / 128))*1.8
alter VB6 = $&drive
let drive = (floor(trial / 128) - 2*floor(trial / 256))*1.8
alter VB7 = $&drive
stop when time = 0.001318
resume
delete all
let endpoint = length(time)-1
let cmp = v(COMP)[endpoint]
let top = v(TOP)[endpoint]
let decision = 0
if cmp >= 0.9
let code = trial
let decision = 1
end
echo 73 7 $&trial $&cmp $&top 0.33046875 $&decision >> decisions.csv
let trial = code + 64
let drive = (floor(trial / 1) - 2*floor(trial / 2))*1.8
alter VB0 = $&drive
let drive = (floor(trial / 2) - 2*floor(trial / 4))*1.8
alter VB1 = $&drive
let drive = (floor(trial / 4) - 2*floor(trial / 8))*1.8
alter VB2 = $&drive
let drive = (floor(trial / 8) - 2*floor(trial / 16))*1.8
alter VB3 = $&drive
let drive = (floor(trial / 16) - 2*floor(trial / 32))*1.8
alter VB4 = $&drive
let drive = (floor(trial / 32) - 2*floor(trial / 64))*1.8
alter VB5 = $&drive
let drive = (floor(trial / 64) - 2*floor(trial / 128))*1.8
alter VB6 = $&drive
let drive = (floor(trial / 128) - 2*floor(trial / 256))*1.8
alter VB7 = $&drive
stop when time = 0.00132
resume
delete all
let endpoint = length(time)-1
let cmp = v(COMP)[endpoint]
let top = v(TOP)[endpoint]
let decision = 0
if cmp >= 0.9
let code = trial
let decision = 1
end
echo 73 6 $&trial $&cmp $&top 0.33046875 $&decision >> decisions.csv
let trial = code + 32
let drive = (floor(trial / 1) - 2*floor(trial / 2))*1.8
alter VB0 = $&drive
let drive = (floor(trial / 2) - 2*floor(trial / 4))*1.8
alter VB1 = $&drive
let drive = (floor(trial / 4) - 2*floor(trial / 8))*1.8
alter VB2 = $&drive
let drive = (floor(trial / 8) - 2*floor(trial / 16))*1.8
alter VB3 = $&drive
let drive = (floor(trial / 16) - 2*floor(trial / 32))*1.8
alter VB4 = $&drive
let drive = (floor(trial / 32) - 2*floor(trial / 64))*1.8
alter VB5 = $&drive
let drive = (floor(trial / 64) - 2*floor(trial / 128))*1.8
alter VB6 = $&drive
let drive = (floor(trial / 128) - 2*floor(trial / 256))*1.8
alter VB7 = $&drive
stop when time = 0.001322
resume
delete all
let endpoint = length(time)-1
let cmp = v(COMP)[endpoint]
let top = v(TOP)[endpoint]
let decision = 0
if cmp >= 0.9
let code = trial
let decision = 1
end
echo 73 5 $&trial $&cmp $&top 0.33046875 $&decision >> decisions.csv
let trial = code + 16
let drive = (floor(trial / 1) - 2*floor(trial / 2))*1.8
alter VB0 = $&drive
let drive = (floor(trial / 2) - 2*floor(trial / 4))*1.8
alter VB1 = $&drive
let drive = (floor(trial / 4) - 2*floor(trial / 8))*1.8
alter VB2 = $&drive
let drive = (floor(trial / 8) - 2*floor(trial / 16))*1.8
alter VB3 = $&drive
let drive = (floor(trial / 16) - 2*floor(trial / 32))*1.8
alter VB4 = $&drive
let drive = (floor(trial / 32) - 2*floor(trial / 64))*1.8
alter VB5 = $&drive
let drive = (floor(trial / 64) - 2*floor(trial / 128))*1.8
alter VB6 = $&drive
let drive = (floor(trial / 128) - 2*floor(trial / 256))*1.8
alter VB7 = $&drive
stop when time = 0.001324
resume
delete all
let endpoint = length(time)-1
let cmp = v(COMP)[endpoint]
let top = v(TOP)[endpoint]
let decision = 0
if cmp >= 0.9
let code = trial
let decision = 1
end
echo 73 4 $&trial $&cmp $&top 0.33046875 $&decision >> decisions.csv
let trial = code + 8
let drive = (floor(trial / 1) - 2*floor(trial / 2))*1.8
alter VB0 = $&drive
let drive = (floor(trial / 2) - 2*floor(trial / 4))*1.8
alter VB1 = $&drive
let drive = (floor(trial / 4) - 2*floor(trial / 8))*1.8
alter VB2 = $&drive
let drive = (floor(trial / 8) - 2*floor(trial / 16))*1.8
alter VB3 = $&drive
let drive = (floor(trial / 16) - 2*floor(trial / 32))*1.8
alter VB4 = $&drive
let drive = (floor(trial / 32) - 2*floor(trial / 64))*1.8
alter VB5 = $&drive
let drive = (floor(trial / 64) - 2*floor(trial / 128))*1.8
alter VB6 = $&drive
let drive = (floor(trial / 128) - 2*floor(trial / 256))*1.8
alter VB7 = $&drive
stop when time = 0.001326
resume
delete all
let endpoint = length(time)-1
let cmp = v(COMP)[endpoint]
let top = v(TOP)[endpoint]
let decision = 0
if cmp >= 0.9
let code = trial
let decision = 1
end
echo 73 3 $&trial $&cmp $&top 0.33046875 $&decision >> decisions.csv
let trial = code + 4
let drive = (floor(trial / 1) - 2*floor(trial / 2))*1.8
alter VB0 = $&drive
let drive = (floor(trial / 2) - 2*floor(trial / 4))*1.8
alter VB1 = $&drive
let drive = (floor(trial / 4) - 2*floor(trial / 8))*1.8
alter VB2 = $&drive
let drive = (floor(trial / 8) - 2*floor(trial / 16))*1.8
alter VB3 = $&drive
let drive = (floor(trial / 16) - 2*floor(trial / 32))*1.8
alter VB4 = $&drive
let drive = (floor(trial / 32) - 2*floor(trial / 64))*1.8
alter VB5 = $&drive
let drive = (floor(trial / 64) - 2*floor(trial / 128))*1.8
alter VB6 = $&drive
let drive = (floor(trial / 128) - 2*floor(trial / 256))*1.8
alter VB7 = $&drive
stop when time = 0.001328
resume
delete all
let endpoint = length(time)-1
let cmp = v(COMP)[endpoint]
let top = v(TOP)[endpoint]
let decision = 0
if cmp >= 0.9
let code = trial
let decision = 1
end
echo 73 2 $&trial $&cmp $&top 0.33046875 $&decision >> decisions.csv
let trial = code + 2
let drive = (floor(trial / 1) - 2*floor(trial / 2))*1.8
alter VB0 = $&drive
let drive = (floor(trial / 2) - 2*floor(trial / 4))*1.8
alter VB1 = $&drive
let drive = (floor(trial / 4) - 2*floor(trial / 8))*1.8
alter VB2 = $&drive
let drive = (floor(trial / 8) - 2*floor(trial / 16))*1.8
alter VB3 = $&drive
let drive = (floor(trial / 16) - 2*floor(trial / 32))*1.8
alter VB4 = $&drive
let drive = (floor(trial / 32) - 2*floor(trial / 64))*1.8
alter VB5 = $&drive
let drive = (floor(trial / 64) - 2*floor(trial / 128))*1.8
alter VB6 = $&drive
let drive = (floor(trial / 128) - 2*floor(trial / 256))*1.8
alter VB7 = $&drive
stop when time = 0.00133
resume
delete all
let endpoint = length(time)-1
let cmp = v(COMP)[endpoint]
let top = v(TOP)[endpoint]
let decision = 0
if cmp >= 0.9
let code = trial
let decision = 1
end
echo 73 1 $&trial $&cmp $&top 0.33046875 $&decision >> decisions.csv
let trial = code + 1
let drive = (floor(trial / 1) - 2*floor(trial / 2))*1.8
alter VB0 = $&drive
let drive = (floor(trial / 2) - 2*floor(trial / 4))*1.8
alter VB1 = $&drive
let drive = (floor(trial / 4) - 2*floor(trial / 8))*1.8
alter VB2 = $&drive
let drive = (floor(trial / 8) - 2*floor(trial / 16))*1.8
alter VB3 = $&drive
let drive = (floor(trial / 16) - 2*floor(trial / 32))*1.8
alter VB4 = $&drive
let drive = (floor(trial / 32) - 2*floor(trial / 64))*1.8
alter VB5 = $&drive
let drive = (floor(trial / 64) - 2*floor(trial / 128))*1.8
alter VB6 = $&drive
let drive = (floor(trial / 128) - 2*floor(trial / 256))*1.8
alter VB7 = $&drive
stop when time = 0.001332
resume
delete all
let endpoint = length(time)-1
let cmp = v(COMP)[endpoint]
let top = v(TOP)[endpoint]
let decision = 0
if cmp >= 0.9
let code = trial
let decision = 1
end
echo 73 0 $&trial $&cmp $&top 0.33046875 $&decision >> decisions.csv
alter VIN = 0.33515625
alter VSAMPLE = 1.8
alter VB0 = 0
alter VB1 = 0
alter VB2 = 0
alter VB3 = 0
alter VB4 = 0
alter VB5 = 0
alter VB6 = 0
alter VB7 = 0
let code = 0
stop when time = 0.001334
resume
delete all
alter VSAMPLE = 0
let trial = code + 128
let drive = (floor(trial / 1) - 2*floor(trial / 2))*1.8
alter VB0 = $&drive
let drive = (floor(trial / 2) - 2*floor(trial / 4))*1.8
alter VB1 = $&drive
let drive = (floor(trial / 4) - 2*floor(trial / 8))*1.8
alter VB2 = $&drive
let drive = (floor(trial / 8) - 2*floor(trial / 16))*1.8
alter VB3 = $&drive
let drive = (floor(trial / 16) - 2*floor(trial / 32))*1.8
alter VB4 = $&drive
let drive = (floor(trial / 32) - 2*floor(trial / 64))*1.8
alter VB5 = $&drive
let drive = (floor(trial / 64) - 2*floor(trial / 128))*1.8
alter VB6 = $&drive
let drive = (floor(trial / 128) - 2*floor(trial / 256))*1.8
alter VB7 = $&drive
stop when time = 0.001336
resume
delete all
let endpoint = length(time)-1
let cmp = v(COMP)[endpoint]
let top = v(TOP)[endpoint]
let decision = 0
if cmp >= 0.9
let code = trial
let decision = 1
end
echo 74 7 $&trial $&cmp $&top 0.33515625 $&decision >> decisions.csv
let trial = code + 64
let drive = (floor(trial / 1) - 2*floor(trial / 2))*1.8
alter VB0 = $&drive
let drive = (floor(trial / 2) - 2*floor(trial / 4))*1.8
alter VB1 = $&drive
let drive = (floor(trial / 4) - 2*floor(trial / 8))*1.8
alter VB2 = $&drive
let drive = (floor(trial / 8) - 2*floor(trial / 16))*1.8
alter VB3 = $&drive
let drive = (floor(trial / 16) - 2*floor(trial / 32))*1.8
alter VB4 = $&drive
let drive = (floor(trial / 32) - 2*floor(trial / 64))*1.8
alter VB5 = $&drive
let drive = (floor(trial / 64) - 2*floor(trial / 128))*1.8
alter VB6 = $&drive
let drive = (floor(trial / 128) - 2*floor(trial / 256))*1.8
alter VB7 = $&drive
stop when time = 0.001338
resume
delete all
let endpoint = length(time)-1
let cmp = v(COMP)[endpoint]
let top = v(TOP)[endpoint]
let decision = 0
if cmp >= 0.9
let code = trial
let decision = 1
end
echo 74 6 $&trial $&cmp $&top 0.33515625 $&decision >> decisions.csv
let trial = code + 32
let drive = (floor(trial / 1) - 2*floor(trial / 2))*1.8
alter VB0 = $&drive
let drive = (floor(trial / 2) - 2*floor(trial / 4))*1.8
alter VB1 = $&drive
let drive = (floor(trial / 4) - 2*floor(trial / 8))*1.8
alter VB2 = $&drive
let drive = (floor(trial / 8) - 2*floor(trial / 16))*1.8
alter VB3 = $&drive
let drive = (floor(trial / 16) - 2*floor(trial / 32))*1.8
alter VB4 = $&drive
let drive = (floor(trial / 32) - 2*floor(trial / 64))*1.8
alter VB5 = $&drive
let drive = (floor(trial / 64) - 2*floor(trial / 128))*1.8
alter VB6 = $&drive
let drive = (floor(trial / 128) - 2*floor(trial / 256))*1.8
alter VB7 = $&drive
stop when time = 0.00134
resume
delete all
let endpoint = length(time)-1
let cmp = v(COMP)[endpoint]
let top = v(TOP)[endpoint]
let decision = 0
if cmp >= 0.9
let code = trial
let decision = 1
end
echo 74 5 $&trial $&cmp $&top 0.33515625 $&decision >> decisions.csv
let trial = code + 16
let drive = (floor(trial / 1) - 2*floor(trial / 2))*1.8
alter VB0 = $&drive
let drive = (floor(trial / 2) - 2*floor(trial / 4))*1.8
alter VB1 = $&drive
let drive = (floor(trial / 4) - 2*floor(trial / 8))*1.8
alter VB2 = $&drive
let drive = (floor(trial / 8) - 2*floor(trial / 16))*1.8
alter VB3 = $&drive
let drive = (floor(trial / 16) - 2*floor(trial / 32))*1.8
alter VB4 = $&drive
let drive = (floor(trial / 32) - 2*floor(trial / 64))*1.8
alter VB5 = $&drive
let drive = (floor(trial / 64) - 2*floor(trial / 128))*1.8
alter VB6 = $&drive
let drive = (floor(trial / 128) - 2*floor(trial / 256))*1.8
alter VB7 = $&drive
stop when time = 0.001342
resume
delete all
let endpoint = length(time)-1
let cmp = v(COMP)[endpoint]
let top = v(TOP)[endpoint]
let decision = 0
if cmp >= 0.9
let code = trial
let decision = 1
end
echo 74 4 $&trial $&cmp $&top 0.33515625 $&decision >> decisions.csv
let trial = code + 8
let drive = (floor(trial / 1) - 2*floor(trial / 2))*1.8
alter VB0 = $&drive
let drive = (floor(trial / 2) - 2*floor(trial / 4))*1.8
alter VB1 = $&drive
let drive = (floor(trial / 4) - 2*floor(trial / 8))*1.8
alter VB2 = $&drive
let drive = (floor(trial / 8) - 2*floor(trial / 16))*1.8
alter VB3 = $&drive
let drive = (floor(trial / 16) - 2*floor(trial / 32))*1.8
alter VB4 = $&drive
let drive = (floor(trial / 32) - 2*floor(trial / 64))*1.8
alter VB5 = $&drive
let drive = (floor(trial / 64) - 2*floor(trial / 128))*1.8
alter VB6 = $&drive
let drive = (floor(trial / 128) - 2*floor(trial / 256))*1.8
alter VB7 = $&drive
stop when time = 0.001344
resume
delete all
let endpoint = length(time)-1
let cmp = v(COMP)[endpoint]
let top = v(TOP)[endpoint]
let decision = 0
if cmp >= 0.9
let code = trial
let decision = 1
end
echo 74 3 $&trial $&cmp $&top 0.33515625 $&decision >> decisions.csv
let trial = code + 4
let drive = (floor(trial / 1) - 2*floor(trial / 2))*1.8
alter VB0 = $&drive
let drive = (floor(trial / 2) - 2*floor(trial / 4))*1.8
alter VB1 = $&drive
let drive = (floor(trial / 4) - 2*floor(trial / 8))*1.8
alter VB2 = $&drive
let drive = (floor(trial / 8) - 2*floor(trial / 16))*1.8
alter VB3 = $&drive
let drive = (floor(trial / 16) - 2*floor(trial / 32))*1.8
alter VB4 = $&drive
let drive = (floor(trial / 32) - 2*floor(trial / 64))*1.8
alter VB5 = $&drive
let drive = (floor(trial / 64) - 2*floor(trial / 128))*1.8
alter VB6 = $&drive
let drive = (floor(trial / 128) - 2*floor(trial / 256))*1.8
alter VB7 = $&drive
stop when time = 0.001346
resume
delete all
let endpoint = length(time)-1
let cmp = v(COMP)[endpoint]
let top = v(TOP)[endpoint]
let decision = 0
if cmp >= 0.9
let code = trial
let decision = 1
end
echo 74 2 $&trial $&cmp $&top 0.33515625 $&decision >> decisions.csv
let trial = code + 2
let drive = (floor(trial / 1) - 2*floor(trial / 2))*1.8
alter VB0 = $&drive
let drive = (floor(trial / 2) - 2*floor(trial / 4))*1.8
alter VB1 = $&drive
let drive = (floor(trial / 4) - 2*floor(trial / 8))*1.8
alter VB2 = $&drive
let drive = (floor(trial / 8) - 2*floor(trial / 16))*1.8
alter VB3 = $&drive
let drive = (floor(trial / 16) - 2*floor(trial / 32))*1.8
alter VB4 = $&drive
let drive = (floor(trial / 32) - 2*floor(trial / 64))*1.8
alter VB5 = $&drive
let drive = (floor(trial / 64) - 2*floor(trial / 128))*1.8
alter VB6 = $&drive
let drive = (floor(trial / 128) - 2*floor(trial / 256))*1.8
alter VB7 = $&drive
stop when time = 0.001348
resume
delete all
let endpoint = length(time)-1
let cmp = v(COMP)[endpoint]
let top = v(TOP)[endpoint]
let decision = 0
if cmp >= 0.9
let code = trial
let decision = 1
end
echo 74 1 $&trial $&cmp $&top 0.33515625 $&decision >> decisions.csv
let trial = code + 1
let drive = (floor(trial / 1) - 2*floor(trial / 2))*1.8
alter VB0 = $&drive
let drive = (floor(trial / 2) - 2*floor(trial / 4))*1.8
alter VB1 = $&drive
let drive = (floor(trial / 4) - 2*floor(trial / 8))*1.8
alter VB2 = $&drive
let drive = (floor(trial / 8) - 2*floor(trial / 16))*1.8
alter VB3 = $&drive
let drive = (floor(trial / 16) - 2*floor(trial / 32))*1.8
alter VB4 = $&drive
let drive = (floor(trial / 32) - 2*floor(trial / 64))*1.8
alter VB5 = $&drive
let drive = (floor(trial / 64) - 2*floor(trial / 128))*1.8
alter VB6 = $&drive
let drive = (floor(trial / 128) - 2*floor(trial / 256))*1.8
alter VB7 = $&drive
stop when time = 0.00135
resume
delete all
let endpoint = length(time)-1
let cmp = v(COMP)[endpoint]
let top = v(TOP)[endpoint]
let decision = 0
if cmp >= 0.9
let code = trial
let decision = 1
end
echo 74 0 $&trial $&cmp $&top 0.33515625 $&decision >> decisions.csv
alter VIN = 0.33984375
alter VSAMPLE = 1.8
alter VB0 = 0
alter VB1 = 0
alter VB2 = 0
alter VB3 = 0
alter VB4 = 0
alter VB5 = 0
alter VB6 = 0
alter VB7 = 0
let code = 0
stop when time = 0.001352
resume
delete all
alter VSAMPLE = 0
let trial = code + 128
let drive = (floor(trial / 1) - 2*floor(trial / 2))*1.8
alter VB0 = $&drive
let drive = (floor(trial / 2) - 2*floor(trial / 4))*1.8
alter VB1 = $&drive
let drive = (floor(trial / 4) - 2*floor(trial / 8))*1.8
alter VB2 = $&drive
let drive = (floor(trial / 8) - 2*floor(trial / 16))*1.8
alter VB3 = $&drive
let drive = (floor(trial / 16) - 2*floor(trial / 32))*1.8
alter VB4 = $&drive
let drive = (floor(trial / 32) - 2*floor(trial / 64))*1.8
alter VB5 = $&drive
let drive = (floor(trial / 64) - 2*floor(trial / 128))*1.8
alter VB6 = $&drive
let drive = (floor(trial / 128) - 2*floor(trial / 256))*1.8
alter VB7 = $&drive
stop when time = 0.001354
resume
delete all
let endpoint = length(time)-1
let cmp = v(COMP)[endpoint]
let top = v(TOP)[endpoint]
let decision = 0
if cmp >= 0.9
let code = trial
let decision = 1
end
echo 75 7 $&trial $&cmp $&top 0.33984375 $&decision >> decisions.csv
let trial = code + 64
let drive = (floor(trial / 1) - 2*floor(trial / 2))*1.8
alter VB0 = $&drive
let drive = (floor(trial / 2) - 2*floor(trial / 4))*1.8
alter VB1 = $&drive
let drive = (floor(trial / 4) - 2*floor(trial / 8))*1.8
alter VB2 = $&drive
let drive = (floor(trial / 8) - 2*floor(trial / 16))*1.8
alter VB3 = $&drive
let drive = (floor(trial / 16) - 2*floor(trial / 32))*1.8
alter VB4 = $&drive
let drive = (floor(trial / 32) - 2*floor(trial / 64))*1.8
alter VB5 = $&drive
let drive = (floor(trial / 64) - 2*floor(trial / 128))*1.8
alter VB6 = $&drive
let drive = (floor(trial / 128) - 2*floor(trial / 256))*1.8
alter VB7 = $&drive
stop when time = 0.001356
resume
delete all
let endpoint = length(time)-1
let cmp = v(COMP)[endpoint]
let top = v(TOP)[endpoint]
let decision = 0
if cmp >= 0.9
let code = trial
let decision = 1
end
echo 75 6 $&trial $&cmp $&top 0.33984375 $&decision >> decisions.csv
let trial = code + 32
let drive = (floor(trial / 1) - 2*floor(trial / 2))*1.8
alter VB0 = $&drive
let drive = (floor(trial / 2) - 2*floor(trial / 4))*1.8
alter VB1 = $&drive
let drive = (floor(trial / 4) - 2*floor(trial / 8))*1.8
alter VB2 = $&drive
let drive = (floor(trial / 8) - 2*floor(trial / 16))*1.8
alter VB3 = $&drive
let drive = (floor(trial / 16) - 2*floor(trial / 32))*1.8
alter VB4 = $&drive
let drive = (floor(trial / 32) - 2*floor(trial / 64))*1.8
alter VB5 = $&drive
let drive = (floor(trial / 64) - 2*floor(trial / 128))*1.8
alter VB6 = $&drive
let drive = (floor(trial / 128) - 2*floor(trial / 256))*1.8
alter VB7 = $&drive
stop when time = 0.001358
resume
delete all
let endpoint = length(time)-1
let cmp = v(COMP)[endpoint]
let top = v(TOP)[endpoint]
let decision = 0
if cmp >= 0.9
let code = trial
let decision = 1
end
echo 75 5 $&trial $&cmp $&top 0.33984375 $&decision >> decisions.csv
let trial = code + 16
let drive = (floor(trial / 1) - 2*floor(trial / 2))*1.8
alter VB0 = $&drive
let drive = (floor(trial / 2) - 2*floor(trial / 4))*1.8
alter VB1 = $&drive
let drive = (floor(trial / 4) - 2*floor(trial / 8))*1.8
alter VB2 = $&drive
let drive = (floor(trial / 8) - 2*floor(trial / 16))*1.8
alter VB3 = $&drive
let drive = (floor(trial / 16) - 2*floor(trial / 32))*1.8
alter VB4 = $&drive
let drive = (floor(trial / 32) - 2*floor(trial / 64))*1.8
alter VB5 = $&drive
let drive = (floor(trial / 64) - 2*floor(trial / 128))*1.8
alter VB6 = $&drive
let drive = (floor(trial / 128) - 2*floor(trial / 256))*1.8
alter VB7 = $&drive
stop when time = 0.00136
resume
delete all
let endpoint = length(time)-1
let cmp = v(COMP)[endpoint]
let top = v(TOP)[endpoint]
let decision = 0
if cmp >= 0.9
let code = trial
let decision = 1
end
echo 75 4 $&trial $&cmp $&top 0.33984375 $&decision >> decisions.csv
let trial = code + 8
let drive = (floor(trial / 1) - 2*floor(trial / 2))*1.8
alter VB0 = $&drive
let drive = (floor(trial / 2) - 2*floor(trial / 4))*1.8
alter VB1 = $&drive
let drive = (floor(trial / 4) - 2*floor(trial / 8))*1.8
alter VB2 = $&drive
let drive = (floor(trial / 8) - 2*floor(trial / 16))*1.8
alter VB3 = $&drive
let drive = (floor(trial / 16) - 2*floor(trial / 32))*1.8
alter VB4 = $&drive
let drive = (floor(trial / 32) - 2*floor(trial / 64))*1.8
alter VB5 = $&drive
let drive = (floor(trial / 64) - 2*floor(trial / 128))*1.8
alter VB6 = $&drive
let drive = (floor(trial / 128) - 2*floor(trial / 256))*1.8
alter VB7 = $&drive
stop when time = 0.001362
resume
delete all
let endpoint = length(time)-1
let cmp = v(COMP)[endpoint]
let top = v(TOP)[endpoint]
let decision = 0
if cmp >= 0.9
let code = trial
let decision = 1
end
echo 75 3 $&trial $&cmp $&top 0.33984375 $&decision >> decisions.csv
let trial = code + 4
let drive = (floor(trial / 1) - 2*floor(trial / 2))*1.8
alter VB0 = $&drive
let drive = (floor(trial / 2) - 2*floor(trial / 4))*1.8
alter VB1 = $&drive
let drive = (floor(trial / 4) - 2*floor(trial / 8))*1.8
alter VB2 = $&drive
let drive = (floor(trial / 8) - 2*floor(trial / 16))*1.8
alter VB3 = $&drive
let drive = (floor(trial / 16) - 2*floor(trial / 32))*1.8
alter VB4 = $&drive
let drive = (floor(trial / 32) - 2*floor(trial / 64))*1.8
alter VB5 = $&drive
let drive = (floor(trial / 64) - 2*floor(trial / 128))*1.8
alter VB6 = $&drive
let drive = (floor(trial / 128) - 2*floor(trial / 256))*1.8
alter VB7 = $&drive
stop when time = 0.001364
resume
delete all
let endpoint = length(time)-1
let cmp = v(COMP)[endpoint]
let top = v(TOP)[endpoint]
let decision = 0
if cmp >= 0.9
let code = trial
let decision = 1
end
echo 75 2 $&trial $&cmp $&top 0.33984375 $&decision >> decisions.csv
let trial = code + 2
let drive = (floor(trial / 1) - 2*floor(trial / 2))*1.8
alter VB0 = $&drive
let drive = (floor(trial / 2) - 2*floor(trial / 4))*1.8
alter VB1 = $&drive
let drive = (floor(trial / 4) - 2*floor(trial / 8))*1.8
alter VB2 = $&drive
let drive = (floor(trial / 8) - 2*floor(trial / 16))*1.8
alter VB3 = $&drive
let drive = (floor(trial / 16) - 2*floor(trial / 32))*1.8
alter VB4 = $&drive
let drive = (floor(trial / 32) - 2*floor(trial / 64))*1.8
alter VB5 = $&drive
let drive = (floor(trial / 64) - 2*floor(trial / 128))*1.8
alter VB6 = $&drive
let drive = (floor(trial / 128) - 2*floor(trial / 256))*1.8
alter VB7 = $&drive
stop when time = 0.001366
resume
delete all
let endpoint = length(time)-1
let cmp = v(COMP)[endpoint]
let top = v(TOP)[endpoint]
let decision = 0
if cmp >= 0.9
let code = trial
let decision = 1
end
echo 75 1 $&trial $&cmp $&top 0.33984375 $&decision >> decisions.csv
let trial = code + 1
let drive = (floor(trial / 1) - 2*floor(trial / 2))*1.8
alter VB0 = $&drive
let drive = (floor(trial / 2) - 2*floor(trial / 4))*1.8
alter VB1 = $&drive
let drive = (floor(trial / 4) - 2*floor(trial / 8))*1.8
alter VB2 = $&drive
let drive = (floor(trial / 8) - 2*floor(trial / 16))*1.8
alter VB3 = $&drive
let drive = (floor(trial / 16) - 2*floor(trial / 32))*1.8
alter VB4 = $&drive
let drive = (floor(trial / 32) - 2*floor(trial / 64))*1.8
alter VB5 = $&drive
let drive = (floor(trial / 64) - 2*floor(trial / 128))*1.8
alter VB6 = $&drive
let drive = (floor(trial / 128) - 2*floor(trial / 256))*1.8
alter VB7 = $&drive
stop when time = 0.001368
resume
delete all
let endpoint = length(time)-1
let cmp = v(COMP)[endpoint]
let top = v(TOP)[endpoint]
let decision = 0
if cmp >= 0.9
let code = trial
let decision = 1
end
echo 75 0 $&trial $&cmp $&top 0.33984375 $&decision >> decisions.csv
alter VIN = 0.34453125
alter VSAMPLE = 1.8
alter VB0 = 0
alter VB1 = 0
alter VB2 = 0
alter VB3 = 0
alter VB4 = 0
alter VB5 = 0
alter VB6 = 0
alter VB7 = 0
let code = 0
stop when time = 0.00137
resume
delete all
alter VSAMPLE = 0
let trial = code + 128
let drive = (floor(trial / 1) - 2*floor(trial / 2))*1.8
alter VB0 = $&drive
let drive = (floor(trial / 2) - 2*floor(trial / 4))*1.8
alter VB1 = $&drive
let drive = (floor(trial / 4) - 2*floor(trial / 8))*1.8
alter VB2 = $&drive
let drive = (floor(trial / 8) - 2*floor(trial / 16))*1.8
alter VB3 = $&drive
let drive = (floor(trial / 16) - 2*floor(trial / 32))*1.8
alter VB4 = $&drive
let drive = (floor(trial / 32) - 2*floor(trial / 64))*1.8
alter VB5 = $&drive
let drive = (floor(trial / 64) - 2*floor(trial / 128))*1.8
alter VB6 = $&drive
let drive = (floor(trial / 128) - 2*floor(trial / 256))*1.8
alter VB7 = $&drive
stop when time = 0.001372
resume
delete all
let endpoint = length(time)-1
let cmp = v(COMP)[endpoint]
let top = v(TOP)[endpoint]
let decision = 0
if cmp >= 0.9
let code = trial
let decision = 1
end
echo 76 7 $&trial $&cmp $&top 0.34453125 $&decision >> decisions.csv
let trial = code + 64
let drive = (floor(trial / 1) - 2*floor(trial / 2))*1.8
alter VB0 = $&drive
let drive = (floor(trial / 2) - 2*floor(trial / 4))*1.8
alter VB1 = $&drive
let drive = (floor(trial / 4) - 2*floor(trial / 8))*1.8
alter VB2 = $&drive
let drive = (floor(trial / 8) - 2*floor(trial / 16))*1.8
alter VB3 = $&drive
let drive = (floor(trial / 16) - 2*floor(trial / 32))*1.8
alter VB4 = $&drive
let drive = (floor(trial / 32) - 2*floor(trial / 64))*1.8
alter VB5 = $&drive
let drive = (floor(trial / 64) - 2*floor(trial / 128))*1.8
alter VB6 = $&drive
let drive = (floor(trial / 128) - 2*floor(trial / 256))*1.8
alter VB7 = $&drive
stop when time = 0.001374
resume
delete all
let endpoint = length(time)-1
let cmp = v(COMP)[endpoint]
let top = v(TOP)[endpoint]
let decision = 0
if cmp >= 0.9
let code = trial
let decision = 1
end
echo 76 6 $&trial $&cmp $&top 0.34453125 $&decision >> decisions.csv
let trial = code + 32
let drive = (floor(trial / 1) - 2*floor(trial / 2))*1.8
alter VB0 = $&drive
let drive = (floor(trial / 2) - 2*floor(trial / 4))*1.8
alter VB1 = $&drive
let drive = (floor(trial / 4) - 2*floor(trial / 8))*1.8
alter VB2 = $&drive
let drive = (floor(trial / 8) - 2*floor(trial / 16))*1.8
alter VB3 = $&drive
let drive = (floor(trial / 16) - 2*floor(trial / 32))*1.8
alter VB4 = $&drive
let drive = (floor(trial / 32) - 2*floor(trial / 64))*1.8
alter VB5 = $&drive
let drive = (floor(trial / 64) - 2*floor(trial / 128))*1.8
alter VB6 = $&drive
let drive = (floor(trial / 128) - 2*floor(trial / 256))*1.8
alter VB7 = $&drive
stop when time = 0.001376
resume
delete all
let endpoint = length(time)-1
let cmp = v(COMP)[endpoint]
let top = v(TOP)[endpoint]
let decision = 0
if cmp >= 0.9
let code = trial
let decision = 1
end
echo 76 5 $&trial $&cmp $&top 0.34453125 $&decision >> decisions.csv
let trial = code + 16
let drive = (floor(trial / 1) - 2*floor(trial / 2))*1.8
alter VB0 = $&drive
let drive = (floor(trial / 2) - 2*floor(trial / 4))*1.8
alter VB1 = $&drive
let drive = (floor(trial / 4) - 2*floor(trial / 8))*1.8
alter VB2 = $&drive
let drive = (floor(trial / 8) - 2*floor(trial / 16))*1.8
alter VB3 = $&drive
let drive = (floor(trial / 16) - 2*floor(trial / 32))*1.8
alter VB4 = $&drive
let drive = (floor(trial / 32) - 2*floor(trial / 64))*1.8
alter VB5 = $&drive
let drive = (floor(trial / 64) - 2*floor(trial / 128))*1.8
alter VB6 = $&drive
let drive = (floor(trial / 128) - 2*floor(trial / 256))*1.8
alter VB7 = $&drive
stop when time = 0.001378
resume
delete all
let endpoint = length(time)-1
let cmp = v(COMP)[endpoint]
let top = v(TOP)[endpoint]
let decision = 0
if cmp >= 0.9
let code = trial
let decision = 1
end
echo 76 4 $&trial $&cmp $&top 0.34453125 $&decision >> decisions.csv
let trial = code + 8
let drive = (floor(trial / 1) - 2*floor(trial / 2))*1.8
alter VB0 = $&drive
let drive = (floor(trial / 2) - 2*floor(trial / 4))*1.8
alter VB1 = $&drive
let drive = (floor(trial / 4) - 2*floor(trial / 8))*1.8
alter VB2 = $&drive
let drive = (floor(trial / 8) - 2*floor(trial / 16))*1.8
alter VB3 = $&drive
let drive = (floor(trial / 16) - 2*floor(trial / 32))*1.8
alter VB4 = $&drive
let drive = (floor(trial / 32) - 2*floor(trial / 64))*1.8
alter VB5 = $&drive
let drive = (floor(trial / 64) - 2*floor(trial / 128))*1.8
alter VB6 = $&drive
let drive = (floor(trial / 128) - 2*floor(trial / 256))*1.8
alter VB7 = $&drive
stop when time = 0.00138
resume
delete all
let endpoint = length(time)-1
let cmp = v(COMP)[endpoint]
let top = v(TOP)[endpoint]
let decision = 0
if cmp >= 0.9
let code = trial
let decision = 1
end
echo 76 3 $&trial $&cmp $&top 0.34453125 $&decision >> decisions.csv
let trial = code + 4
let drive = (floor(trial / 1) - 2*floor(trial / 2))*1.8
alter VB0 = $&drive
let drive = (floor(trial / 2) - 2*floor(trial / 4))*1.8
alter VB1 = $&drive
let drive = (floor(trial / 4) - 2*floor(trial / 8))*1.8
alter VB2 = $&drive
let drive = (floor(trial / 8) - 2*floor(trial / 16))*1.8
alter VB3 = $&drive
let drive = (floor(trial / 16) - 2*floor(trial / 32))*1.8
alter VB4 = $&drive
let drive = (floor(trial / 32) - 2*floor(trial / 64))*1.8
alter VB5 = $&drive
let drive = (floor(trial / 64) - 2*floor(trial / 128))*1.8
alter VB6 = $&drive
let drive = (floor(trial / 128) - 2*floor(trial / 256))*1.8
alter VB7 = $&drive
stop when time = 0.001382
resume
delete all
let endpoint = length(time)-1
let cmp = v(COMP)[endpoint]
let top = v(TOP)[endpoint]
let decision = 0
if cmp >= 0.9
let code = trial
let decision = 1
end
echo 76 2 $&trial $&cmp $&top 0.34453125 $&decision >> decisions.csv
let trial = code + 2
let drive = (floor(trial / 1) - 2*floor(trial / 2))*1.8
alter VB0 = $&drive
let drive = (floor(trial / 2) - 2*floor(trial / 4))*1.8
alter VB1 = $&drive
let drive = (floor(trial / 4) - 2*floor(trial / 8))*1.8
alter VB2 = $&drive
let drive = (floor(trial / 8) - 2*floor(trial / 16))*1.8
alter VB3 = $&drive
let drive = (floor(trial / 16) - 2*floor(trial / 32))*1.8
alter VB4 = $&drive
let drive = (floor(trial / 32) - 2*floor(trial / 64))*1.8
alter VB5 = $&drive
let drive = (floor(trial / 64) - 2*floor(trial / 128))*1.8
alter VB6 = $&drive
let drive = (floor(trial / 128) - 2*floor(trial / 256))*1.8
alter VB7 = $&drive
stop when time = 0.001384
resume
delete all
let endpoint = length(time)-1
let cmp = v(COMP)[endpoint]
let top = v(TOP)[endpoint]
let decision = 0
if cmp >= 0.9
let code = trial
let decision = 1
end
echo 76 1 $&trial $&cmp $&top 0.34453125 $&decision >> decisions.csv
let trial = code + 1
let drive = (floor(trial / 1) - 2*floor(trial / 2))*1.8
alter VB0 = $&drive
let drive = (floor(trial / 2) - 2*floor(trial / 4))*1.8
alter VB1 = $&drive
let drive = (floor(trial / 4) - 2*floor(trial / 8))*1.8
alter VB2 = $&drive
let drive = (floor(trial / 8) - 2*floor(trial / 16))*1.8
alter VB3 = $&drive
let drive = (floor(trial / 16) - 2*floor(trial / 32))*1.8
alter VB4 = $&drive
let drive = (floor(trial / 32) - 2*floor(trial / 64))*1.8
alter VB5 = $&drive
let drive = (floor(trial / 64) - 2*floor(trial / 128))*1.8
alter VB6 = $&drive
let drive = (floor(trial / 128) - 2*floor(trial / 256))*1.8
alter VB7 = $&drive
stop when time = 0.001386
resume
delete all
let endpoint = length(time)-1
let cmp = v(COMP)[endpoint]
let top = v(TOP)[endpoint]
let decision = 0
if cmp >= 0.9
let code = trial
let decision = 1
end
echo 76 0 $&trial $&cmp $&top 0.34453125 $&decision >> decisions.csv
alter VIN = 0.34921875
alter VSAMPLE = 1.8
alter VB0 = 0
alter VB1 = 0
alter VB2 = 0
alter VB3 = 0
alter VB4 = 0
alter VB5 = 0
alter VB6 = 0
alter VB7 = 0
let code = 0
stop when time = 0.001388
resume
delete all
alter VSAMPLE = 0
let trial = code + 128
let drive = (floor(trial / 1) - 2*floor(trial / 2))*1.8
alter VB0 = $&drive
let drive = (floor(trial / 2) - 2*floor(trial / 4))*1.8
alter VB1 = $&drive
let drive = (floor(trial / 4) - 2*floor(trial / 8))*1.8
alter VB2 = $&drive
let drive = (floor(trial / 8) - 2*floor(trial / 16))*1.8
alter VB3 = $&drive
let drive = (floor(trial / 16) - 2*floor(trial / 32))*1.8
alter VB4 = $&drive
let drive = (floor(trial / 32) - 2*floor(trial / 64))*1.8
alter VB5 = $&drive
let drive = (floor(trial / 64) - 2*floor(trial / 128))*1.8
alter VB6 = $&drive
let drive = (floor(trial / 128) - 2*floor(trial / 256))*1.8
alter VB7 = $&drive
stop when time = 0.00139
resume
delete all
let endpoint = length(time)-1
let cmp = v(COMP)[endpoint]
let top = v(TOP)[endpoint]
let decision = 0
if cmp >= 0.9
let code = trial
let decision = 1
end
echo 77 7 $&trial $&cmp $&top 0.34921875 $&decision >> decisions.csv
let trial = code + 64
let drive = (floor(trial / 1) - 2*floor(trial / 2))*1.8
alter VB0 = $&drive
let drive = (floor(trial / 2) - 2*floor(trial / 4))*1.8
alter VB1 = $&drive
let drive = (floor(trial / 4) - 2*floor(trial / 8))*1.8
alter VB2 = $&drive
let drive = (floor(trial / 8) - 2*floor(trial / 16))*1.8
alter VB3 = $&drive
let drive = (floor(trial / 16) - 2*floor(trial / 32))*1.8
alter VB4 = $&drive
let drive = (floor(trial / 32) - 2*floor(trial / 64))*1.8
alter VB5 = $&drive
let drive = (floor(trial / 64) - 2*floor(trial / 128))*1.8
alter VB6 = $&drive
let drive = (floor(trial / 128) - 2*floor(trial / 256))*1.8
alter VB7 = $&drive
stop when time = 0.001392
resume
delete all
let endpoint = length(time)-1
let cmp = v(COMP)[endpoint]
let top = v(TOP)[endpoint]
let decision = 0
if cmp >= 0.9
let code = trial
let decision = 1
end
echo 77 6 $&trial $&cmp $&top 0.34921875 $&decision >> decisions.csv
let trial = code + 32
let drive = (floor(trial / 1) - 2*floor(trial / 2))*1.8
alter VB0 = $&drive
let drive = (floor(trial / 2) - 2*floor(trial / 4))*1.8
alter VB1 = $&drive
let drive = (floor(trial / 4) - 2*floor(trial / 8))*1.8
alter VB2 = $&drive
let drive = (floor(trial / 8) - 2*floor(trial / 16))*1.8
alter VB3 = $&drive
let drive = (floor(trial / 16) - 2*floor(trial / 32))*1.8
alter VB4 = $&drive
let drive = (floor(trial / 32) - 2*floor(trial / 64))*1.8
alter VB5 = $&drive
let drive = (floor(trial / 64) - 2*floor(trial / 128))*1.8
alter VB6 = $&drive
let drive = (floor(trial / 128) - 2*floor(trial / 256))*1.8
alter VB7 = $&drive
stop when time = 0.001394
resume
delete all
let endpoint = length(time)-1
let cmp = v(COMP)[endpoint]
let top = v(TOP)[endpoint]
let decision = 0
if cmp >= 0.9
let code = trial
let decision = 1
end
echo 77 5 $&trial $&cmp $&top 0.34921875 $&decision >> decisions.csv
let trial = code + 16
let drive = (floor(trial / 1) - 2*floor(trial / 2))*1.8
alter VB0 = $&drive
let drive = (floor(trial / 2) - 2*floor(trial / 4))*1.8
alter VB1 = $&drive
let drive = (floor(trial / 4) - 2*floor(trial / 8))*1.8
alter VB2 = $&drive
let drive = (floor(trial / 8) - 2*floor(trial / 16))*1.8
alter VB3 = $&drive
let drive = (floor(trial / 16) - 2*floor(trial / 32))*1.8
alter VB4 = $&drive
let drive = (floor(trial / 32) - 2*floor(trial / 64))*1.8
alter VB5 = $&drive
let drive = (floor(trial / 64) - 2*floor(trial / 128))*1.8
alter VB6 = $&drive
let drive = (floor(trial / 128) - 2*floor(trial / 256))*1.8
alter VB7 = $&drive
stop when time = 0.001396
resume
delete all
let endpoint = length(time)-1
let cmp = v(COMP)[endpoint]
let top = v(TOP)[endpoint]
let decision = 0
if cmp >= 0.9
let code = trial
let decision = 1
end
echo 77 4 $&trial $&cmp $&top 0.34921875 $&decision >> decisions.csv
let trial = code + 8
let drive = (floor(trial / 1) - 2*floor(trial / 2))*1.8
alter VB0 = $&drive
let drive = (floor(trial / 2) - 2*floor(trial / 4))*1.8
alter VB1 = $&drive
let drive = (floor(trial / 4) - 2*floor(trial / 8))*1.8
alter VB2 = $&drive
let drive = (floor(trial / 8) - 2*floor(trial / 16))*1.8
alter VB3 = $&drive
let drive = (floor(trial / 16) - 2*floor(trial / 32))*1.8
alter VB4 = $&drive
let drive = (floor(trial / 32) - 2*floor(trial / 64))*1.8
alter VB5 = $&drive
let drive = (floor(trial / 64) - 2*floor(trial / 128))*1.8
alter VB6 = $&drive
let drive = (floor(trial / 128) - 2*floor(trial / 256))*1.8
alter VB7 = $&drive
stop when time = 0.001398
resume
delete all
let endpoint = length(time)-1
let cmp = v(COMP)[endpoint]
let top = v(TOP)[endpoint]
let decision = 0
if cmp >= 0.9
let code = trial
let decision = 1
end
echo 77 3 $&trial $&cmp $&top 0.34921875 $&decision >> decisions.csv
let trial = code + 4
let drive = (floor(trial / 1) - 2*floor(trial / 2))*1.8
alter VB0 = $&drive
let drive = (floor(trial / 2) - 2*floor(trial / 4))*1.8
alter VB1 = $&drive
let drive = (floor(trial / 4) - 2*floor(trial / 8))*1.8
alter VB2 = $&drive
let drive = (floor(trial / 8) - 2*floor(trial / 16))*1.8
alter VB3 = $&drive
let drive = (floor(trial / 16) - 2*floor(trial / 32))*1.8
alter VB4 = $&drive
let drive = (floor(trial / 32) - 2*floor(trial / 64))*1.8
alter VB5 = $&drive
let drive = (floor(trial / 64) - 2*floor(trial / 128))*1.8
alter VB6 = $&drive
let drive = (floor(trial / 128) - 2*floor(trial / 256))*1.8
alter VB7 = $&drive
stop when time = 0.0014
resume
delete all
let endpoint = length(time)-1
let cmp = v(COMP)[endpoint]
let top = v(TOP)[endpoint]
let decision = 0
if cmp >= 0.9
let code = trial
let decision = 1
end
echo 77 2 $&trial $&cmp $&top 0.34921875 $&decision >> decisions.csv
let trial = code + 2
let drive = (floor(trial / 1) - 2*floor(trial / 2))*1.8
alter VB0 = $&drive
let drive = (floor(trial / 2) - 2*floor(trial / 4))*1.8
alter VB1 = $&drive
let drive = (floor(trial / 4) - 2*floor(trial / 8))*1.8
alter VB2 = $&drive
let drive = (floor(trial / 8) - 2*floor(trial / 16))*1.8
alter VB3 = $&drive
let drive = (floor(trial / 16) - 2*floor(trial / 32))*1.8
alter VB4 = $&drive
let drive = (floor(trial / 32) - 2*floor(trial / 64))*1.8
alter VB5 = $&drive
let drive = (floor(trial / 64) - 2*floor(trial / 128))*1.8
alter VB6 = $&drive
let drive = (floor(trial / 128) - 2*floor(trial / 256))*1.8
alter VB7 = $&drive
stop when time = 0.001402
resume
delete all
let endpoint = length(time)-1
let cmp = v(COMP)[endpoint]
let top = v(TOP)[endpoint]
let decision = 0
if cmp >= 0.9
let code = trial
let decision = 1
end
echo 77 1 $&trial $&cmp $&top 0.34921875 $&decision >> decisions.csv
let trial = code + 1
let drive = (floor(trial / 1) - 2*floor(trial / 2))*1.8
alter VB0 = $&drive
let drive = (floor(trial / 2) - 2*floor(trial / 4))*1.8
alter VB1 = $&drive
let drive = (floor(trial / 4) - 2*floor(trial / 8))*1.8
alter VB2 = $&drive
let drive = (floor(trial / 8) - 2*floor(trial / 16))*1.8
alter VB3 = $&drive
let drive = (floor(trial / 16) - 2*floor(trial / 32))*1.8
alter VB4 = $&drive
let drive = (floor(trial / 32) - 2*floor(trial / 64))*1.8
alter VB5 = $&drive
let drive = (floor(trial / 64) - 2*floor(trial / 128))*1.8
alter VB6 = $&drive
let drive = (floor(trial / 128) - 2*floor(trial / 256))*1.8
alter VB7 = $&drive
stop when time = 0.001404
resume
delete all
let endpoint = length(time)-1
let cmp = v(COMP)[endpoint]
let top = v(TOP)[endpoint]
let decision = 0
if cmp >= 0.9
let code = trial
let decision = 1
end
echo 77 0 $&trial $&cmp $&top 0.34921875 $&decision >> decisions.csv
alter VIN = 0.35390625
alter VSAMPLE = 1.8
alter VB0 = 0
alter VB1 = 0
alter VB2 = 0
alter VB3 = 0
alter VB4 = 0
alter VB5 = 0
alter VB6 = 0
alter VB7 = 0
let code = 0
stop when time = 0.001406
resume
delete all
alter VSAMPLE = 0
let trial = code + 128
let drive = (floor(trial / 1) - 2*floor(trial / 2))*1.8
alter VB0 = $&drive
let drive = (floor(trial / 2) - 2*floor(trial / 4))*1.8
alter VB1 = $&drive
let drive = (floor(trial / 4) - 2*floor(trial / 8))*1.8
alter VB2 = $&drive
let drive = (floor(trial / 8) - 2*floor(trial / 16))*1.8
alter VB3 = $&drive
let drive = (floor(trial / 16) - 2*floor(trial / 32))*1.8
alter VB4 = $&drive
let drive = (floor(trial / 32) - 2*floor(trial / 64))*1.8
alter VB5 = $&drive
let drive = (floor(trial / 64) - 2*floor(trial / 128))*1.8
alter VB6 = $&drive
let drive = (floor(trial / 128) - 2*floor(trial / 256))*1.8
alter VB7 = $&drive
stop when time = 0.001408
resume
delete all
let endpoint = length(time)-1
let cmp = v(COMP)[endpoint]
let top = v(TOP)[endpoint]
let decision = 0
if cmp >= 0.9
let code = trial
let decision = 1
end
echo 78 7 $&trial $&cmp $&top 0.35390625 $&decision >> decisions.csv
let trial = code + 64
let drive = (floor(trial / 1) - 2*floor(trial / 2))*1.8
alter VB0 = $&drive
let drive = (floor(trial / 2) - 2*floor(trial / 4))*1.8
alter VB1 = $&drive
let drive = (floor(trial / 4) - 2*floor(trial / 8))*1.8
alter VB2 = $&drive
let drive = (floor(trial / 8) - 2*floor(trial / 16))*1.8
alter VB3 = $&drive
let drive = (floor(trial / 16) - 2*floor(trial / 32))*1.8
alter VB4 = $&drive
let drive = (floor(trial / 32) - 2*floor(trial / 64))*1.8
alter VB5 = $&drive
let drive = (floor(trial / 64) - 2*floor(trial / 128))*1.8
alter VB6 = $&drive
let drive = (floor(trial / 128) - 2*floor(trial / 256))*1.8
alter VB7 = $&drive
stop when time = 0.00141
resume
delete all
let endpoint = length(time)-1
let cmp = v(COMP)[endpoint]
let top = v(TOP)[endpoint]
let decision = 0
if cmp >= 0.9
let code = trial
let decision = 1
end
echo 78 6 $&trial $&cmp $&top 0.35390625 $&decision >> decisions.csv
let trial = code + 32
let drive = (floor(trial / 1) - 2*floor(trial / 2))*1.8
alter VB0 = $&drive
let drive = (floor(trial / 2) - 2*floor(trial / 4))*1.8
alter VB1 = $&drive
let drive = (floor(trial / 4) - 2*floor(trial / 8))*1.8
alter VB2 = $&drive
let drive = (floor(trial / 8) - 2*floor(trial / 16))*1.8
alter VB3 = $&drive
let drive = (floor(trial / 16) - 2*floor(trial / 32))*1.8
alter VB4 = $&drive
let drive = (floor(trial / 32) - 2*floor(trial / 64))*1.8
alter VB5 = $&drive
let drive = (floor(trial / 64) - 2*floor(trial / 128))*1.8
alter VB6 = $&drive
let drive = (floor(trial / 128) - 2*floor(trial / 256))*1.8
alter VB7 = $&drive
stop when time = 0.001412
resume
delete all
let endpoint = length(time)-1
let cmp = v(COMP)[endpoint]
let top = v(TOP)[endpoint]
let decision = 0
if cmp >= 0.9
let code = trial
let decision = 1
end
echo 78 5 $&trial $&cmp $&top 0.35390625 $&decision >> decisions.csv
let trial = code + 16
let drive = (floor(trial / 1) - 2*floor(trial / 2))*1.8
alter VB0 = $&drive
let drive = (floor(trial / 2) - 2*floor(trial / 4))*1.8
alter VB1 = $&drive
let drive = (floor(trial / 4) - 2*floor(trial / 8))*1.8
alter VB2 = $&drive
let drive = (floor(trial / 8) - 2*floor(trial / 16))*1.8
alter VB3 = $&drive
let drive = (floor(trial / 16) - 2*floor(trial / 32))*1.8
alter VB4 = $&drive
let drive = (floor(trial / 32) - 2*floor(trial / 64))*1.8
alter VB5 = $&drive
let drive = (floor(trial / 64) - 2*floor(trial / 128))*1.8
alter VB6 = $&drive
let drive = (floor(trial / 128) - 2*floor(trial / 256))*1.8
alter VB7 = $&drive
stop when time = 0.001414
resume
delete all
let endpoint = length(time)-1
let cmp = v(COMP)[endpoint]
let top = v(TOP)[endpoint]
let decision = 0
if cmp >= 0.9
let code = trial
let decision = 1
end
echo 78 4 $&trial $&cmp $&top 0.35390625 $&decision >> decisions.csv
let trial = code + 8
let drive = (floor(trial / 1) - 2*floor(trial / 2))*1.8
alter VB0 = $&drive
let drive = (floor(trial / 2) - 2*floor(trial / 4))*1.8
alter VB1 = $&drive
let drive = (floor(trial / 4) - 2*floor(trial / 8))*1.8
alter VB2 = $&drive
let drive = (floor(trial / 8) - 2*floor(trial / 16))*1.8
alter VB3 = $&drive
let drive = (floor(trial / 16) - 2*floor(trial / 32))*1.8
alter VB4 = $&drive
let drive = (floor(trial / 32) - 2*floor(trial / 64))*1.8
alter VB5 = $&drive
let drive = (floor(trial / 64) - 2*floor(trial / 128))*1.8
alter VB6 = $&drive
let drive = (floor(trial / 128) - 2*floor(trial / 256))*1.8
alter VB7 = $&drive
stop when time = 0.001416
resume
delete all
let endpoint = length(time)-1
let cmp = v(COMP)[endpoint]
let top = v(TOP)[endpoint]
let decision = 0
if cmp >= 0.9
let code = trial
let decision = 1
end
echo 78 3 $&trial $&cmp $&top 0.35390625 $&decision >> decisions.csv
let trial = code + 4
let drive = (floor(trial / 1) - 2*floor(trial / 2))*1.8
alter VB0 = $&drive
let drive = (floor(trial / 2) - 2*floor(trial / 4))*1.8
alter VB1 = $&drive
let drive = (floor(trial / 4) - 2*floor(trial / 8))*1.8
alter VB2 = $&drive
let drive = (floor(trial / 8) - 2*floor(trial / 16))*1.8
alter VB3 = $&drive
let drive = (floor(trial / 16) - 2*floor(trial / 32))*1.8
alter VB4 = $&drive
let drive = (floor(trial / 32) - 2*floor(trial / 64))*1.8
alter VB5 = $&drive
let drive = (floor(trial / 64) - 2*floor(trial / 128))*1.8
alter VB6 = $&drive
let drive = (floor(trial / 128) - 2*floor(trial / 256))*1.8
alter VB7 = $&drive
stop when time = 0.001418
resume
delete all
let endpoint = length(time)-1
let cmp = v(COMP)[endpoint]
let top = v(TOP)[endpoint]
let decision = 0
if cmp >= 0.9
let code = trial
let decision = 1
end
echo 78 2 $&trial $&cmp $&top 0.35390625 $&decision >> decisions.csv
let trial = code + 2
let drive = (floor(trial / 1) - 2*floor(trial / 2))*1.8
alter VB0 = $&drive
let drive = (floor(trial / 2) - 2*floor(trial / 4))*1.8
alter VB1 = $&drive
let drive = (floor(trial / 4) - 2*floor(trial / 8))*1.8
alter VB2 = $&drive
let drive = (floor(trial / 8) - 2*floor(trial / 16))*1.8
alter VB3 = $&drive
let drive = (floor(trial / 16) - 2*floor(trial / 32))*1.8
alter VB4 = $&drive
let drive = (floor(trial / 32) - 2*floor(trial / 64))*1.8
alter VB5 = $&drive
let drive = (floor(trial / 64) - 2*floor(trial / 128))*1.8
alter VB6 = $&drive
let drive = (floor(trial / 128) - 2*floor(trial / 256))*1.8
alter VB7 = $&drive
stop when time = 0.00142
resume
delete all
let endpoint = length(time)-1
let cmp = v(COMP)[endpoint]
let top = v(TOP)[endpoint]
let decision = 0
if cmp >= 0.9
let code = trial
let decision = 1
end
echo 78 1 $&trial $&cmp $&top 0.35390625 $&decision >> decisions.csv
let trial = code + 1
let drive = (floor(trial / 1) - 2*floor(trial / 2))*1.8
alter VB0 = $&drive
let drive = (floor(trial / 2) - 2*floor(trial / 4))*1.8
alter VB1 = $&drive
let drive = (floor(trial / 4) - 2*floor(trial / 8))*1.8
alter VB2 = $&drive
let drive = (floor(trial / 8) - 2*floor(trial / 16))*1.8
alter VB3 = $&drive
let drive = (floor(trial / 16) - 2*floor(trial / 32))*1.8
alter VB4 = $&drive
let drive = (floor(trial / 32) - 2*floor(trial / 64))*1.8
alter VB5 = $&drive
let drive = (floor(trial / 64) - 2*floor(trial / 128))*1.8
alter VB6 = $&drive
let drive = (floor(trial / 128) - 2*floor(trial / 256))*1.8
alter VB7 = $&drive
stop when time = 0.001422
resume
delete all
let endpoint = length(time)-1
let cmp = v(COMP)[endpoint]
let top = v(TOP)[endpoint]
let decision = 0
if cmp >= 0.9
let code = trial
let decision = 1
end
echo 78 0 $&trial $&cmp $&top 0.35390625 $&decision >> decisions.csv
alter VIN = 0.35859375
alter VSAMPLE = 1.8
alter VB0 = 0
alter VB1 = 0
alter VB2 = 0
alter VB3 = 0
alter VB4 = 0
alter VB5 = 0
alter VB6 = 0
alter VB7 = 0
let code = 0
stop when time = 0.001424
resume
delete all
alter VSAMPLE = 0
let trial = code + 128
let drive = (floor(trial / 1) - 2*floor(trial / 2))*1.8
alter VB0 = $&drive
let drive = (floor(trial / 2) - 2*floor(trial / 4))*1.8
alter VB1 = $&drive
let drive = (floor(trial / 4) - 2*floor(trial / 8))*1.8
alter VB2 = $&drive
let drive = (floor(trial / 8) - 2*floor(trial / 16))*1.8
alter VB3 = $&drive
let drive = (floor(trial / 16) - 2*floor(trial / 32))*1.8
alter VB4 = $&drive
let drive = (floor(trial / 32) - 2*floor(trial / 64))*1.8
alter VB5 = $&drive
let drive = (floor(trial / 64) - 2*floor(trial / 128))*1.8
alter VB6 = $&drive
let drive = (floor(trial / 128) - 2*floor(trial / 256))*1.8
alter VB7 = $&drive
stop when time = 0.001426
resume
delete all
let endpoint = length(time)-1
let cmp = v(COMP)[endpoint]
let top = v(TOP)[endpoint]
let decision = 0
if cmp >= 0.9
let code = trial
let decision = 1
end
echo 79 7 $&trial $&cmp $&top 0.35859375 $&decision >> decisions.csv
let trial = code + 64
let drive = (floor(trial / 1) - 2*floor(trial / 2))*1.8
alter VB0 = $&drive
let drive = (floor(trial / 2) - 2*floor(trial / 4))*1.8
alter VB1 = $&drive
let drive = (floor(trial / 4) - 2*floor(trial / 8))*1.8
alter VB2 = $&drive
let drive = (floor(trial / 8) - 2*floor(trial / 16))*1.8
alter VB3 = $&drive
let drive = (floor(trial / 16) - 2*floor(trial / 32))*1.8
alter VB4 = $&drive
let drive = (floor(trial / 32) - 2*floor(trial / 64))*1.8
alter VB5 = $&drive
let drive = (floor(trial / 64) - 2*floor(trial / 128))*1.8
alter VB6 = $&drive
let drive = (floor(trial / 128) - 2*floor(trial / 256))*1.8
alter VB7 = $&drive
stop when time = 0.001428
resume
delete all
let endpoint = length(time)-1
let cmp = v(COMP)[endpoint]
let top = v(TOP)[endpoint]
let decision = 0
if cmp >= 0.9
let code = trial
let decision = 1
end
echo 79 6 $&trial $&cmp $&top 0.35859375 $&decision >> decisions.csv
let trial = code + 32
let drive = (floor(trial / 1) - 2*floor(trial / 2))*1.8
alter VB0 = $&drive
let drive = (floor(trial / 2) - 2*floor(trial / 4))*1.8
alter VB1 = $&drive
let drive = (floor(trial / 4) - 2*floor(trial / 8))*1.8
alter VB2 = $&drive
let drive = (floor(trial / 8) - 2*floor(trial / 16))*1.8
alter VB3 = $&drive
let drive = (floor(trial / 16) - 2*floor(trial / 32))*1.8
alter VB4 = $&drive
let drive = (floor(trial / 32) - 2*floor(trial / 64))*1.8
alter VB5 = $&drive
let drive = (floor(trial / 64) - 2*floor(trial / 128))*1.8
alter VB6 = $&drive
let drive = (floor(trial / 128) - 2*floor(trial / 256))*1.8
alter VB7 = $&drive
stop when time = 0.00143
resume
delete all
let endpoint = length(time)-1
let cmp = v(COMP)[endpoint]
let top = v(TOP)[endpoint]
let decision = 0
if cmp >= 0.9
let code = trial
let decision = 1
end
echo 79 5 $&trial $&cmp $&top 0.35859375 $&decision >> decisions.csv
let trial = code + 16
let drive = (floor(trial / 1) - 2*floor(trial / 2))*1.8
alter VB0 = $&drive
let drive = (floor(trial / 2) - 2*floor(trial / 4))*1.8
alter VB1 = $&drive
let drive = (floor(trial / 4) - 2*floor(trial / 8))*1.8
alter VB2 = $&drive
let drive = (floor(trial / 8) - 2*floor(trial / 16))*1.8
alter VB3 = $&drive
let drive = (floor(trial / 16) - 2*floor(trial / 32))*1.8
alter VB4 = $&drive
let drive = (floor(trial / 32) - 2*floor(trial / 64))*1.8
alter VB5 = $&drive
let drive = (floor(trial / 64) - 2*floor(trial / 128))*1.8
alter VB6 = $&drive
let drive = (floor(trial / 128) - 2*floor(trial / 256))*1.8
alter VB7 = $&drive
stop when time = 0.001432
resume
delete all
let endpoint = length(time)-1
let cmp = v(COMP)[endpoint]
let top = v(TOP)[endpoint]
let decision = 0
if cmp >= 0.9
let code = trial
let decision = 1
end
echo 79 4 $&trial $&cmp $&top 0.35859375 $&decision >> decisions.csv
let trial = code + 8
let drive = (floor(trial / 1) - 2*floor(trial / 2))*1.8
alter VB0 = $&drive
let drive = (floor(trial / 2) - 2*floor(trial / 4))*1.8
alter VB1 = $&drive
let drive = (floor(trial / 4) - 2*floor(trial / 8))*1.8
alter VB2 = $&drive
let drive = (floor(trial / 8) - 2*floor(trial / 16))*1.8
alter VB3 = $&drive
let drive = (floor(trial / 16) - 2*floor(trial / 32))*1.8
alter VB4 = $&drive
let drive = (floor(trial / 32) - 2*floor(trial / 64))*1.8
alter VB5 = $&drive
let drive = (floor(trial / 64) - 2*floor(trial / 128))*1.8
alter VB6 = $&drive
let drive = (floor(trial / 128) - 2*floor(trial / 256))*1.8
alter VB7 = $&drive
stop when time = 0.001434
resume
delete all
let endpoint = length(time)-1
let cmp = v(COMP)[endpoint]
let top = v(TOP)[endpoint]
let decision = 0
if cmp >= 0.9
let code = trial
let decision = 1
end
echo 79 3 $&trial $&cmp $&top 0.35859375 $&decision >> decisions.csv
let trial = code + 4
let drive = (floor(trial / 1) - 2*floor(trial / 2))*1.8
alter VB0 = $&drive
let drive = (floor(trial / 2) - 2*floor(trial / 4))*1.8
alter VB1 = $&drive
let drive = (floor(trial / 4) - 2*floor(trial / 8))*1.8
alter VB2 = $&drive
let drive = (floor(trial / 8) - 2*floor(trial / 16))*1.8
alter VB3 = $&drive
let drive = (floor(trial / 16) - 2*floor(trial / 32))*1.8
alter VB4 = $&drive
let drive = (floor(trial / 32) - 2*floor(trial / 64))*1.8
alter VB5 = $&drive
let drive = (floor(trial / 64) - 2*floor(trial / 128))*1.8
alter VB6 = $&drive
let drive = (floor(trial / 128) - 2*floor(trial / 256))*1.8
alter VB7 = $&drive
stop when time = 0.001436
resume
delete all
let endpoint = length(time)-1
let cmp = v(COMP)[endpoint]
let top = v(TOP)[endpoint]
let decision = 0
if cmp >= 0.9
let code = trial
let decision = 1
end
echo 79 2 $&trial $&cmp $&top 0.35859375 $&decision >> decisions.csv
let trial = code + 2
let drive = (floor(trial / 1) - 2*floor(trial / 2))*1.8
alter VB0 = $&drive
let drive = (floor(trial / 2) - 2*floor(trial / 4))*1.8
alter VB1 = $&drive
let drive = (floor(trial / 4) - 2*floor(trial / 8))*1.8
alter VB2 = $&drive
let drive = (floor(trial / 8) - 2*floor(trial / 16))*1.8
alter VB3 = $&drive
let drive = (floor(trial / 16) - 2*floor(trial / 32))*1.8
alter VB4 = $&drive
let drive = (floor(trial / 32) - 2*floor(trial / 64))*1.8
alter VB5 = $&drive
let drive = (floor(trial / 64) - 2*floor(trial / 128))*1.8
alter VB6 = $&drive
let drive = (floor(trial / 128) - 2*floor(trial / 256))*1.8
alter VB7 = $&drive
stop when time = 0.001438
resume
delete all
let endpoint = length(time)-1
let cmp = v(COMP)[endpoint]
let top = v(TOP)[endpoint]
let decision = 0
if cmp >= 0.9
let code = trial
let decision = 1
end
echo 79 1 $&trial $&cmp $&top 0.35859375 $&decision >> decisions.csv
let trial = code + 1
let drive = (floor(trial / 1) - 2*floor(trial / 2))*1.8
alter VB0 = $&drive
let drive = (floor(trial / 2) - 2*floor(trial / 4))*1.8
alter VB1 = $&drive
let drive = (floor(trial / 4) - 2*floor(trial / 8))*1.8
alter VB2 = $&drive
let drive = (floor(trial / 8) - 2*floor(trial / 16))*1.8
alter VB3 = $&drive
let drive = (floor(trial / 16) - 2*floor(trial / 32))*1.8
alter VB4 = $&drive
let drive = (floor(trial / 32) - 2*floor(trial / 64))*1.8
alter VB5 = $&drive
let drive = (floor(trial / 64) - 2*floor(trial / 128))*1.8
alter VB6 = $&drive
let drive = (floor(trial / 128) - 2*floor(trial / 256))*1.8
alter VB7 = $&drive
stop when time = 0.00144
resume
delete all
let endpoint = length(time)-1
let cmp = v(COMP)[endpoint]
let top = v(TOP)[endpoint]
let decision = 0
if cmp >= 0.9
let code = trial
let decision = 1
end
echo 79 0 $&trial $&cmp $&top 0.35859375 $&decision >> decisions.csv
alter VIN = 0.36328125
alter VSAMPLE = 1.8
alter VB0 = 0
alter VB1 = 0
alter VB2 = 0
alter VB3 = 0
alter VB4 = 0
alter VB5 = 0
alter VB6 = 0
alter VB7 = 0
let code = 0
stop when time = 0.001442
resume
delete all
alter VSAMPLE = 0
let trial = code + 128
let drive = (floor(trial / 1) - 2*floor(trial / 2))*1.8
alter VB0 = $&drive
let drive = (floor(trial / 2) - 2*floor(trial / 4))*1.8
alter VB1 = $&drive
let drive = (floor(trial / 4) - 2*floor(trial / 8))*1.8
alter VB2 = $&drive
let drive = (floor(trial / 8) - 2*floor(trial / 16))*1.8
alter VB3 = $&drive
let drive = (floor(trial / 16) - 2*floor(trial / 32))*1.8
alter VB4 = $&drive
let drive = (floor(trial / 32) - 2*floor(trial / 64))*1.8
alter VB5 = $&drive
let drive = (floor(trial / 64) - 2*floor(trial / 128))*1.8
alter VB6 = $&drive
let drive = (floor(trial / 128) - 2*floor(trial / 256))*1.8
alter VB7 = $&drive
stop when time = 0.001444
resume
delete all
let endpoint = length(time)-1
let cmp = v(COMP)[endpoint]
let top = v(TOP)[endpoint]
let decision = 0
if cmp >= 0.9
let code = trial
let decision = 1
end
echo 80 7 $&trial $&cmp $&top 0.36328125 $&decision >> decisions.csv
let trial = code + 64
let drive = (floor(trial / 1) - 2*floor(trial / 2))*1.8
alter VB0 = $&drive
let drive = (floor(trial / 2) - 2*floor(trial / 4))*1.8
alter VB1 = $&drive
let drive = (floor(trial / 4) - 2*floor(trial / 8))*1.8
alter VB2 = $&drive
let drive = (floor(trial / 8) - 2*floor(trial / 16))*1.8
alter VB3 = $&drive
let drive = (floor(trial / 16) - 2*floor(trial / 32))*1.8
alter VB4 = $&drive
let drive = (floor(trial / 32) - 2*floor(trial / 64))*1.8
alter VB5 = $&drive
let drive = (floor(trial / 64) - 2*floor(trial / 128))*1.8
alter VB6 = $&drive
let drive = (floor(trial / 128) - 2*floor(trial / 256))*1.8
alter VB7 = $&drive
stop when time = 0.001446
resume
delete all
let endpoint = length(time)-1
let cmp = v(COMP)[endpoint]
let top = v(TOP)[endpoint]
let decision = 0
if cmp >= 0.9
let code = trial
let decision = 1
end
echo 80 6 $&trial $&cmp $&top 0.36328125 $&decision >> decisions.csv
let trial = code + 32
let drive = (floor(trial / 1) - 2*floor(trial / 2))*1.8
alter VB0 = $&drive
let drive = (floor(trial / 2) - 2*floor(trial / 4))*1.8
alter VB1 = $&drive
let drive = (floor(trial / 4) - 2*floor(trial / 8))*1.8
alter VB2 = $&drive
let drive = (floor(trial / 8) - 2*floor(trial / 16))*1.8
alter VB3 = $&drive
let drive = (floor(trial / 16) - 2*floor(trial / 32))*1.8
alter VB4 = $&drive
let drive = (floor(trial / 32) - 2*floor(trial / 64))*1.8
alter VB5 = $&drive
let drive = (floor(trial / 64) - 2*floor(trial / 128))*1.8
alter VB6 = $&drive
let drive = (floor(trial / 128) - 2*floor(trial / 256))*1.8
alter VB7 = $&drive
stop when time = 0.001448
resume
delete all
let endpoint = length(time)-1
let cmp = v(COMP)[endpoint]
let top = v(TOP)[endpoint]
let decision = 0
if cmp >= 0.9
let code = trial
let decision = 1
end
echo 80 5 $&trial $&cmp $&top 0.36328125 $&decision >> decisions.csv
let trial = code + 16
let drive = (floor(trial / 1) - 2*floor(trial / 2))*1.8
alter VB0 = $&drive
let drive = (floor(trial / 2) - 2*floor(trial / 4))*1.8
alter VB1 = $&drive
let drive = (floor(trial / 4) - 2*floor(trial / 8))*1.8
alter VB2 = $&drive
let drive = (floor(trial / 8) - 2*floor(trial / 16))*1.8
alter VB3 = $&drive
let drive = (floor(trial / 16) - 2*floor(trial / 32))*1.8
alter VB4 = $&drive
let drive = (floor(trial / 32) - 2*floor(trial / 64))*1.8
alter VB5 = $&drive
let drive = (floor(trial / 64) - 2*floor(trial / 128))*1.8
alter VB6 = $&drive
let drive = (floor(trial / 128) - 2*floor(trial / 256))*1.8
alter VB7 = $&drive
stop when time = 0.00145
resume
delete all
let endpoint = length(time)-1
let cmp = v(COMP)[endpoint]
let top = v(TOP)[endpoint]
let decision = 0
if cmp >= 0.9
let code = trial
let decision = 1
end
echo 80 4 $&trial $&cmp $&top 0.36328125 $&decision >> decisions.csv
let trial = code + 8
let drive = (floor(trial / 1) - 2*floor(trial / 2))*1.8
alter VB0 = $&drive
let drive = (floor(trial / 2) - 2*floor(trial / 4))*1.8
alter VB1 = $&drive
let drive = (floor(trial / 4) - 2*floor(trial / 8))*1.8
alter VB2 = $&drive
let drive = (floor(trial / 8) - 2*floor(trial / 16))*1.8
alter VB3 = $&drive
let drive = (floor(trial / 16) - 2*floor(trial / 32))*1.8
alter VB4 = $&drive
let drive = (floor(trial / 32) - 2*floor(trial / 64))*1.8
alter VB5 = $&drive
let drive = (floor(trial / 64) - 2*floor(trial / 128))*1.8
alter VB6 = $&drive
let drive = (floor(trial / 128) - 2*floor(trial / 256))*1.8
alter VB7 = $&drive
stop when time = 0.001452
resume
delete all
let endpoint = length(time)-1
let cmp = v(COMP)[endpoint]
let top = v(TOP)[endpoint]
let decision = 0
if cmp >= 0.9
let code = trial
let decision = 1
end
echo 80 3 $&trial $&cmp $&top 0.36328125 $&decision >> decisions.csv
let trial = code + 4
let drive = (floor(trial / 1) - 2*floor(trial / 2))*1.8
alter VB0 = $&drive
let drive = (floor(trial / 2) - 2*floor(trial / 4))*1.8
alter VB1 = $&drive
let drive = (floor(trial / 4) - 2*floor(trial / 8))*1.8
alter VB2 = $&drive
let drive = (floor(trial / 8) - 2*floor(trial / 16))*1.8
alter VB3 = $&drive
let drive = (floor(trial / 16) - 2*floor(trial / 32))*1.8
alter VB4 = $&drive
let drive = (floor(trial / 32) - 2*floor(trial / 64))*1.8
alter VB5 = $&drive
let drive = (floor(trial / 64) - 2*floor(trial / 128))*1.8
alter VB6 = $&drive
let drive = (floor(trial / 128) - 2*floor(trial / 256))*1.8
alter VB7 = $&drive
stop when time = 0.001454
resume
delete all
let endpoint = length(time)-1
let cmp = v(COMP)[endpoint]
let top = v(TOP)[endpoint]
let decision = 0
if cmp >= 0.9
let code = trial
let decision = 1
end
echo 80 2 $&trial $&cmp $&top 0.36328125 $&decision >> decisions.csv
let trial = code + 2
let drive = (floor(trial / 1) - 2*floor(trial / 2))*1.8
alter VB0 = $&drive
let drive = (floor(trial / 2) - 2*floor(trial / 4))*1.8
alter VB1 = $&drive
let drive = (floor(trial / 4) - 2*floor(trial / 8))*1.8
alter VB2 = $&drive
let drive = (floor(trial / 8) - 2*floor(trial / 16))*1.8
alter VB3 = $&drive
let drive = (floor(trial / 16) - 2*floor(trial / 32))*1.8
alter VB4 = $&drive
let drive = (floor(trial / 32) - 2*floor(trial / 64))*1.8
alter VB5 = $&drive
let drive = (floor(trial / 64) - 2*floor(trial / 128))*1.8
alter VB6 = $&drive
let drive = (floor(trial / 128) - 2*floor(trial / 256))*1.8
alter VB7 = $&drive
stop when time = 0.001456
resume
delete all
let endpoint = length(time)-1
let cmp = v(COMP)[endpoint]
let top = v(TOP)[endpoint]
let decision = 0
if cmp >= 0.9
let code = trial
let decision = 1
end
echo 80 1 $&trial $&cmp $&top 0.36328125 $&decision >> decisions.csv
let trial = code + 1
let drive = (floor(trial / 1) - 2*floor(trial / 2))*1.8
alter VB0 = $&drive
let drive = (floor(trial / 2) - 2*floor(trial / 4))*1.8
alter VB1 = $&drive
let drive = (floor(trial / 4) - 2*floor(trial / 8))*1.8
alter VB2 = $&drive
let drive = (floor(trial / 8) - 2*floor(trial / 16))*1.8
alter VB3 = $&drive
let drive = (floor(trial / 16) - 2*floor(trial / 32))*1.8
alter VB4 = $&drive
let drive = (floor(trial / 32) - 2*floor(trial / 64))*1.8
alter VB5 = $&drive
let drive = (floor(trial / 64) - 2*floor(trial / 128))*1.8
alter VB6 = $&drive
let drive = (floor(trial / 128) - 2*floor(trial / 256))*1.8
alter VB7 = $&drive
stop when time = 0.001458
resume
delete all
let endpoint = length(time)-1
let cmp = v(COMP)[endpoint]
let top = v(TOP)[endpoint]
let decision = 0
if cmp >= 0.9
let code = trial
let decision = 1
end
echo 80 0 $&trial $&cmp $&top 0.36328125 $&decision >> decisions.csv
alter VIN = 0.36796875
alter VSAMPLE = 1.8
alter VB0 = 0
alter VB1 = 0
alter VB2 = 0
alter VB3 = 0
alter VB4 = 0
alter VB5 = 0
alter VB6 = 0
alter VB7 = 0
let code = 0
stop when time = 0.00146
resume
delete all
alter VSAMPLE = 0
let trial = code + 128
let drive = (floor(trial / 1) - 2*floor(trial / 2))*1.8
alter VB0 = $&drive
let drive = (floor(trial / 2) - 2*floor(trial / 4))*1.8
alter VB1 = $&drive
let drive = (floor(trial / 4) - 2*floor(trial / 8))*1.8
alter VB2 = $&drive
let drive = (floor(trial / 8) - 2*floor(trial / 16))*1.8
alter VB3 = $&drive
let drive = (floor(trial / 16) - 2*floor(trial / 32))*1.8
alter VB4 = $&drive
let drive = (floor(trial / 32) - 2*floor(trial / 64))*1.8
alter VB5 = $&drive
let drive = (floor(trial / 64) - 2*floor(trial / 128))*1.8
alter VB6 = $&drive
let drive = (floor(trial / 128) - 2*floor(trial / 256))*1.8
alter VB7 = $&drive
stop when time = 0.001462
resume
delete all
let endpoint = length(time)-1
let cmp = v(COMP)[endpoint]
let top = v(TOP)[endpoint]
let decision = 0
if cmp >= 0.9
let code = trial
let decision = 1
end
echo 81 7 $&trial $&cmp $&top 0.36796875 $&decision >> decisions.csv
let trial = code + 64
let drive = (floor(trial / 1) - 2*floor(trial / 2))*1.8
alter VB0 = $&drive
let drive = (floor(trial / 2) - 2*floor(trial / 4))*1.8
alter VB1 = $&drive
let drive = (floor(trial / 4) - 2*floor(trial / 8))*1.8
alter VB2 = $&drive
let drive = (floor(trial / 8) - 2*floor(trial / 16))*1.8
alter VB3 = $&drive
let drive = (floor(trial / 16) - 2*floor(trial / 32))*1.8
alter VB4 = $&drive
let drive = (floor(trial / 32) - 2*floor(trial / 64))*1.8
alter VB5 = $&drive
let drive = (floor(trial / 64) - 2*floor(trial / 128))*1.8
alter VB6 = $&drive
let drive = (floor(trial / 128) - 2*floor(trial / 256))*1.8
alter VB7 = $&drive
stop when time = 0.001464
resume
delete all
let endpoint = length(time)-1
let cmp = v(COMP)[endpoint]
let top = v(TOP)[endpoint]
let decision = 0
if cmp >= 0.9
let code = trial
let decision = 1
end
echo 81 6 $&trial $&cmp $&top 0.36796875 $&decision >> decisions.csv
let trial = code + 32
let drive = (floor(trial / 1) - 2*floor(trial / 2))*1.8
alter VB0 = $&drive
let drive = (floor(trial / 2) - 2*floor(trial / 4))*1.8
alter VB1 = $&drive
let drive = (floor(trial / 4) - 2*floor(trial / 8))*1.8
alter VB2 = $&drive
let drive = (floor(trial / 8) - 2*floor(trial / 16))*1.8
alter VB3 = $&drive
let drive = (floor(trial / 16) - 2*floor(trial / 32))*1.8
alter VB4 = $&drive
let drive = (floor(trial / 32) - 2*floor(trial / 64))*1.8
alter VB5 = $&drive
let drive = (floor(trial / 64) - 2*floor(trial / 128))*1.8
alter VB6 = $&drive
let drive = (floor(trial / 128) - 2*floor(trial / 256))*1.8
alter VB7 = $&drive
stop when time = 0.001466
resume
delete all
let endpoint = length(time)-1
let cmp = v(COMP)[endpoint]
let top = v(TOP)[endpoint]
let decision = 0
if cmp >= 0.9
let code = trial
let decision = 1
end
echo 81 5 $&trial $&cmp $&top 0.36796875 $&decision >> decisions.csv
let trial = code + 16
let drive = (floor(trial / 1) - 2*floor(trial / 2))*1.8
alter VB0 = $&drive
let drive = (floor(trial / 2) - 2*floor(trial / 4))*1.8
alter VB1 = $&drive
let drive = (floor(trial / 4) - 2*floor(trial / 8))*1.8
alter VB2 = $&drive
let drive = (floor(trial / 8) - 2*floor(trial / 16))*1.8
alter VB3 = $&drive
let drive = (floor(trial / 16) - 2*floor(trial / 32))*1.8
alter VB4 = $&drive
let drive = (floor(trial / 32) - 2*floor(trial / 64))*1.8
alter VB5 = $&drive
let drive = (floor(trial / 64) - 2*floor(trial / 128))*1.8
alter VB6 = $&drive
let drive = (floor(trial / 128) - 2*floor(trial / 256))*1.8
alter VB7 = $&drive
stop when time = 0.001468
resume
delete all
let endpoint = length(time)-1
let cmp = v(COMP)[endpoint]
let top = v(TOP)[endpoint]
let decision = 0
if cmp >= 0.9
let code = trial
let decision = 1
end
echo 81 4 $&trial $&cmp $&top 0.36796875 $&decision >> decisions.csv
let trial = code + 8
let drive = (floor(trial / 1) - 2*floor(trial / 2))*1.8
alter VB0 = $&drive
let drive = (floor(trial / 2) - 2*floor(trial / 4))*1.8
alter VB1 = $&drive
let drive = (floor(trial / 4) - 2*floor(trial / 8))*1.8
alter VB2 = $&drive
let drive = (floor(trial / 8) - 2*floor(trial / 16))*1.8
alter VB3 = $&drive
let drive = (floor(trial / 16) - 2*floor(trial / 32))*1.8
alter VB4 = $&drive
let drive = (floor(trial / 32) - 2*floor(trial / 64))*1.8
alter VB5 = $&drive
let drive = (floor(trial / 64) - 2*floor(trial / 128))*1.8
alter VB6 = $&drive
let drive = (floor(trial / 128) - 2*floor(trial / 256))*1.8
alter VB7 = $&drive
stop when time = 0.00147
resume
delete all
let endpoint = length(time)-1
let cmp = v(COMP)[endpoint]
let top = v(TOP)[endpoint]
let decision = 0
if cmp >= 0.9
let code = trial
let decision = 1
end
echo 81 3 $&trial $&cmp $&top 0.36796875 $&decision >> decisions.csv
let trial = code + 4
let drive = (floor(trial / 1) - 2*floor(trial / 2))*1.8
alter VB0 = $&drive
let drive = (floor(trial / 2) - 2*floor(trial / 4))*1.8
alter VB1 = $&drive
let drive = (floor(trial / 4) - 2*floor(trial / 8))*1.8
alter VB2 = $&drive
let drive = (floor(trial / 8) - 2*floor(trial / 16))*1.8
alter VB3 = $&drive
let drive = (floor(trial / 16) - 2*floor(trial / 32))*1.8
alter VB4 = $&drive
let drive = (floor(trial / 32) - 2*floor(trial / 64))*1.8
alter VB5 = $&drive
let drive = (floor(trial / 64) - 2*floor(trial / 128))*1.8
alter VB6 = $&drive
let drive = (floor(trial / 128) - 2*floor(trial / 256))*1.8
alter VB7 = $&drive
stop when time = 0.001472
resume
delete all
let endpoint = length(time)-1
let cmp = v(COMP)[endpoint]
let top = v(TOP)[endpoint]
let decision = 0
if cmp >= 0.9
let code = trial
let decision = 1
end
echo 81 2 $&trial $&cmp $&top 0.36796875 $&decision >> decisions.csv
let trial = code + 2
let drive = (floor(trial / 1) - 2*floor(trial / 2))*1.8
alter VB0 = $&drive
let drive = (floor(trial / 2) - 2*floor(trial / 4))*1.8
alter VB1 = $&drive
let drive = (floor(trial / 4) - 2*floor(trial / 8))*1.8
alter VB2 = $&drive
let drive = (floor(trial / 8) - 2*floor(trial / 16))*1.8
alter VB3 = $&drive
let drive = (floor(trial / 16) - 2*floor(trial / 32))*1.8
alter VB4 = $&drive
let drive = (floor(trial / 32) - 2*floor(trial / 64))*1.8
alter VB5 = $&drive
let drive = (floor(trial / 64) - 2*floor(trial / 128))*1.8
alter VB6 = $&drive
let drive = (floor(trial / 128) - 2*floor(trial / 256))*1.8
alter VB7 = $&drive
stop when time = 0.001474
resume
delete all
let endpoint = length(time)-1
let cmp = v(COMP)[endpoint]
let top = v(TOP)[endpoint]
let decision = 0
if cmp >= 0.9
let code = trial
let decision = 1
end
echo 81 1 $&trial $&cmp $&top 0.36796875 $&decision >> decisions.csv
let trial = code + 1
let drive = (floor(trial / 1) - 2*floor(trial / 2))*1.8
alter VB0 = $&drive
let drive = (floor(trial / 2) - 2*floor(trial / 4))*1.8
alter VB1 = $&drive
let drive = (floor(trial / 4) - 2*floor(trial / 8))*1.8
alter VB2 = $&drive
let drive = (floor(trial / 8) - 2*floor(trial / 16))*1.8
alter VB3 = $&drive
let drive = (floor(trial / 16) - 2*floor(trial / 32))*1.8
alter VB4 = $&drive
let drive = (floor(trial / 32) - 2*floor(trial / 64))*1.8
alter VB5 = $&drive
let drive = (floor(trial / 64) - 2*floor(trial / 128))*1.8
alter VB6 = $&drive
let drive = (floor(trial / 128) - 2*floor(trial / 256))*1.8
alter VB7 = $&drive
stop when time = 0.001476
resume
delete all
let endpoint = length(time)-1
let cmp = v(COMP)[endpoint]
let top = v(TOP)[endpoint]
let decision = 0
if cmp >= 0.9
let code = trial
let decision = 1
end
echo 81 0 $&trial $&cmp $&top 0.36796875 $&decision >> decisions.csv
alter VIN = 0.37265625
alter VSAMPLE = 1.8
alter VB0 = 0
alter VB1 = 0
alter VB2 = 0
alter VB3 = 0
alter VB4 = 0
alter VB5 = 0
alter VB6 = 0
alter VB7 = 0
let code = 0
stop when time = 0.001478
resume
delete all
alter VSAMPLE = 0
let trial = code + 128
let drive = (floor(trial / 1) - 2*floor(trial / 2))*1.8
alter VB0 = $&drive
let drive = (floor(trial / 2) - 2*floor(trial / 4))*1.8
alter VB1 = $&drive
let drive = (floor(trial / 4) - 2*floor(trial / 8))*1.8
alter VB2 = $&drive
let drive = (floor(trial / 8) - 2*floor(trial / 16))*1.8
alter VB3 = $&drive
let drive = (floor(trial / 16) - 2*floor(trial / 32))*1.8
alter VB4 = $&drive
let drive = (floor(trial / 32) - 2*floor(trial / 64))*1.8
alter VB5 = $&drive
let drive = (floor(trial / 64) - 2*floor(trial / 128))*1.8
alter VB6 = $&drive
let drive = (floor(trial / 128) - 2*floor(trial / 256))*1.8
alter VB7 = $&drive
stop when time = 0.00148
resume
delete all
let endpoint = length(time)-1
let cmp = v(COMP)[endpoint]
let top = v(TOP)[endpoint]
let decision = 0
if cmp >= 0.9
let code = trial
let decision = 1
end
echo 82 7 $&trial $&cmp $&top 0.37265625 $&decision >> decisions.csv
let trial = code + 64
let drive = (floor(trial / 1) - 2*floor(trial / 2))*1.8
alter VB0 = $&drive
let drive = (floor(trial / 2) - 2*floor(trial / 4))*1.8
alter VB1 = $&drive
let drive = (floor(trial / 4) - 2*floor(trial / 8))*1.8
alter VB2 = $&drive
let drive = (floor(trial / 8) - 2*floor(trial / 16))*1.8
alter VB3 = $&drive
let drive = (floor(trial / 16) - 2*floor(trial / 32))*1.8
alter VB4 = $&drive
let drive = (floor(trial / 32) - 2*floor(trial / 64))*1.8
alter VB5 = $&drive
let drive = (floor(trial / 64) - 2*floor(trial / 128))*1.8
alter VB6 = $&drive
let drive = (floor(trial / 128) - 2*floor(trial / 256))*1.8
alter VB7 = $&drive
stop when time = 0.001482
resume
delete all
let endpoint = length(time)-1
let cmp = v(COMP)[endpoint]
let top = v(TOP)[endpoint]
let decision = 0
if cmp >= 0.9
let code = trial
let decision = 1
end
echo 82 6 $&trial $&cmp $&top 0.37265625 $&decision >> decisions.csv
let trial = code + 32
let drive = (floor(trial / 1) - 2*floor(trial / 2))*1.8
alter VB0 = $&drive
let drive = (floor(trial / 2) - 2*floor(trial / 4))*1.8
alter VB1 = $&drive
let drive = (floor(trial / 4) - 2*floor(trial / 8))*1.8
alter VB2 = $&drive
let drive = (floor(trial / 8) - 2*floor(trial / 16))*1.8
alter VB3 = $&drive
let drive = (floor(trial / 16) - 2*floor(trial / 32))*1.8
alter VB4 = $&drive
let drive = (floor(trial / 32) - 2*floor(trial / 64))*1.8
alter VB5 = $&drive
let drive = (floor(trial / 64) - 2*floor(trial / 128))*1.8
alter VB6 = $&drive
let drive = (floor(trial / 128) - 2*floor(trial / 256))*1.8
alter VB7 = $&drive
stop when time = 0.001484
resume
delete all
let endpoint = length(time)-1
let cmp = v(COMP)[endpoint]
let top = v(TOP)[endpoint]
let decision = 0
if cmp >= 0.9
let code = trial
let decision = 1
end
echo 82 5 $&trial $&cmp $&top 0.37265625 $&decision >> decisions.csv
let trial = code + 16
let drive = (floor(trial / 1) - 2*floor(trial / 2))*1.8
alter VB0 = $&drive
let drive = (floor(trial / 2) - 2*floor(trial / 4))*1.8
alter VB1 = $&drive
let drive = (floor(trial / 4) - 2*floor(trial / 8))*1.8
alter VB2 = $&drive
let drive = (floor(trial / 8) - 2*floor(trial / 16))*1.8
alter VB3 = $&drive
let drive = (floor(trial / 16) - 2*floor(trial / 32))*1.8
alter VB4 = $&drive
let drive = (floor(trial / 32) - 2*floor(trial / 64))*1.8
alter VB5 = $&drive
let drive = (floor(trial / 64) - 2*floor(trial / 128))*1.8
alter VB6 = $&drive
let drive = (floor(trial / 128) - 2*floor(trial / 256))*1.8
alter VB7 = $&drive
stop when time = 0.001486
resume
delete all
let endpoint = length(time)-1
let cmp = v(COMP)[endpoint]
let top = v(TOP)[endpoint]
let decision = 0
if cmp >= 0.9
let code = trial
let decision = 1
end
echo 82 4 $&trial $&cmp $&top 0.37265625 $&decision >> decisions.csv
let trial = code + 8
let drive = (floor(trial / 1) - 2*floor(trial / 2))*1.8
alter VB0 = $&drive
let drive = (floor(trial / 2) - 2*floor(trial / 4))*1.8
alter VB1 = $&drive
let drive = (floor(trial / 4) - 2*floor(trial / 8))*1.8
alter VB2 = $&drive
let drive = (floor(trial / 8) - 2*floor(trial / 16))*1.8
alter VB3 = $&drive
let drive = (floor(trial / 16) - 2*floor(trial / 32))*1.8
alter VB4 = $&drive
let drive = (floor(trial / 32) - 2*floor(trial / 64))*1.8
alter VB5 = $&drive
let drive = (floor(trial / 64) - 2*floor(trial / 128))*1.8
alter VB6 = $&drive
let drive = (floor(trial / 128) - 2*floor(trial / 256))*1.8
alter VB7 = $&drive
stop when time = 0.001488
resume
delete all
let endpoint = length(time)-1
let cmp = v(COMP)[endpoint]
let top = v(TOP)[endpoint]
let decision = 0
if cmp >= 0.9
let code = trial
let decision = 1
end
echo 82 3 $&trial $&cmp $&top 0.37265625 $&decision >> decisions.csv
let trial = code + 4
let drive = (floor(trial / 1) - 2*floor(trial / 2))*1.8
alter VB0 = $&drive
let drive = (floor(trial / 2) - 2*floor(trial / 4))*1.8
alter VB1 = $&drive
let drive = (floor(trial / 4) - 2*floor(trial / 8))*1.8
alter VB2 = $&drive
let drive = (floor(trial / 8) - 2*floor(trial / 16))*1.8
alter VB3 = $&drive
let drive = (floor(trial / 16) - 2*floor(trial / 32))*1.8
alter VB4 = $&drive
let drive = (floor(trial / 32) - 2*floor(trial / 64))*1.8
alter VB5 = $&drive
let drive = (floor(trial / 64) - 2*floor(trial / 128))*1.8
alter VB6 = $&drive
let drive = (floor(trial / 128) - 2*floor(trial / 256))*1.8
alter VB7 = $&drive
stop when time = 0.00149
resume
delete all
let endpoint = length(time)-1
let cmp = v(COMP)[endpoint]
let top = v(TOP)[endpoint]
let decision = 0
if cmp >= 0.9
let code = trial
let decision = 1
end
echo 82 2 $&trial $&cmp $&top 0.37265625 $&decision >> decisions.csv
let trial = code + 2
let drive = (floor(trial / 1) - 2*floor(trial / 2))*1.8
alter VB0 = $&drive
let drive = (floor(trial / 2) - 2*floor(trial / 4))*1.8
alter VB1 = $&drive
let drive = (floor(trial / 4) - 2*floor(trial / 8))*1.8
alter VB2 = $&drive
let drive = (floor(trial / 8) - 2*floor(trial / 16))*1.8
alter VB3 = $&drive
let drive = (floor(trial / 16) - 2*floor(trial / 32))*1.8
alter VB4 = $&drive
let drive = (floor(trial / 32) - 2*floor(trial / 64))*1.8
alter VB5 = $&drive
let drive = (floor(trial / 64) - 2*floor(trial / 128))*1.8
alter VB6 = $&drive
let drive = (floor(trial / 128) - 2*floor(trial / 256))*1.8
alter VB7 = $&drive
stop when time = 0.001492
resume
delete all
let endpoint = length(time)-1
let cmp = v(COMP)[endpoint]
let top = v(TOP)[endpoint]
let decision = 0
if cmp >= 0.9
let code = trial
let decision = 1
end
echo 82 1 $&trial $&cmp $&top 0.37265625 $&decision >> decisions.csv
let trial = code + 1
let drive = (floor(trial / 1) - 2*floor(trial / 2))*1.8
alter VB0 = $&drive
let drive = (floor(trial / 2) - 2*floor(trial / 4))*1.8
alter VB1 = $&drive
let drive = (floor(trial / 4) - 2*floor(trial / 8))*1.8
alter VB2 = $&drive
let drive = (floor(trial / 8) - 2*floor(trial / 16))*1.8
alter VB3 = $&drive
let drive = (floor(trial / 16) - 2*floor(trial / 32))*1.8
alter VB4 = $&drive
let drive = (floor(trial / 32) - 2*floor(trial / 64))*1.8
alter VB5 = $&drive
let drive = (floor(trial / 64) - 2*floor(trial / 128))*1.8
alter VB6 = $&drive
let drive = (floor(trial / 128) - 2*floor(trial / 256))*1.8
alter VB7 = $&drive
stop when time = 0.001494
resume
delete all
let endpoint = length(time)-1
let cmp = v(COMP)[endpoint]
let top = v(TOP)[endpoint]
let decision = 0
if cmp >= 0.9
let code = trial
let decision = 1
end
echo 82 0 $&trial $&cmp $&top 0.37265625 $&decision >> decisions.csv
alter VIN = 0.37734375
alter VSAMPLE = 1.8
alter VB0 = 0
alter VB1 = 0
alter VB2 = 0
alter VB3 = 0
alter VB4 = 0
alter VB5 = 0
alter VB6 = 0
alter VB7 = 0
let code = 0
stop when time = 0.001496
resume
delete all
alter VSAMPLE = 0
let trial = code + 128
let drive = (floor(trial / 1) - 2*floor(trial / 2))*1.8
alter VB0 = $&drive
let drive = (floor(trial / 2) - 2*floor(trial / 4))*1.8
alter VB1 = $&drive
let drive = (floor(trial / 4) - 2*floor(trial / 8))*1.8
alter VB2 = $&drive
let drive = (floor(trial / 8) - 2*floor(trial / 16))*1.8
alter VB3 = $&drive
let drive = (floor(trial / 16) - 2*floor(trial / 32))*1.8
alter VB4 = $&drive
let drive = (floor(trial / 32) - 2*floor(trial / 64))*1.8
alter VB5 = $&drive
let drive = (floor(trial / 64) - 2*floor(trial / 128))*1.8
alter VB6 = $&drive
let drive = (floor(trial / 128) - 2*floor(trial / 256))*1.8
alter VB7 = $&drive
stop when time = 0.001498
resume
delete all
let endpoint = length(time)-1
let cmp = v(COMP)[endpoint]
let top = v(TOP)[endpoint]
let decision = 0
if cmp >= 0.9
let code = trial
let decision = 1
end
echo 83 7 $&trial $&cmp $&top 0.37734375 $&decision >> decisions.csv
let trial = code + 64
let drive = (floor(trial / 1) - 2*floor(trial / 2))*1.8
alter VB0 = $&drive
let drive = (floor(trial / 2) - 2*floor(trial / 4))*1.8
alter VB1 = $&drive
let drive = (floor(trial / 4) - 2*floor(trial / 8))*1.8
alter VB2 = $&drive
let drive = (floor(trial / 8) - 2*floor(trial / 16))*1.8
alter VB3 = $&drive
let drive = (floor(trial / 16) - 2*floor(trial / 32))*1.8
alter VB4 = $&drive
let drive = (floor(trial / 32) - 2*floor(trial / 64))*1.8
alter VB5 = $&drive
let drive = (floor(trial / 64) - 2*floor(trial / 128))*1.8
alter VB6 = $&drive
let drive = (floor(trial / 128) - 2*floor(trial / 256))*1.8
alter VB7 = $&drive
stop when time = 0.0015
resume
delete all
let endpoint = length(time)-1
let cmp = v(COMP)[endpoint]
let top = v(TOP)[endpoint]
let decision = 0
if cmp >= 0.9
let code = trial
let decision = 1
end
echo 83 6 $&trial $&cmp $&top 0.37734375 $&decision >> decisions.csv
let trial = code + 32
let drive = (floor(trial / 1) - 2*floor(trial / 2))*1.8
alter VB0 = $&drive
let drive = (floor(trial / 2) - 2*floor(trial / 4))*1.8
alter VB1 = $&drive
let drive = (floor(trial / 4) - 2*floor(trial / 8))*1.8
alter VB2 = $&drive
let drive = (floor(trial / 8) - 2*floor(trial / 16))*1.8
alter VB3 = $&drive
let drive = (floor(trial / 16) - 2*floor(trial / 32))*1.8
alter VB4 = $&drive
let drive = (floor(trial / 32) - 2*floor(trial / 64))*1.8
alter VB5 = $&drive
let drive = (floor(trial / 64) - 2*floor(trial / 128))*1.8
alter VB6 = $&drive
let drive = (floor(trial / 128) - 2*floor(trial / 256))*1.8
alter VB7 = $&drive
stop when time = 0.001502
resume
delete all
let endpoint = length(time)-1
let cmp = v(COMP)[endpoint]
let top = v(TOP)[endpoint]
let decision = 0
if cmp >= 0.9
let code = trial
let decision = 1
end
echo 83 5 $&trial $&cmp $&top 0.37734375 $&decision >> decisions.csv
let trial = code + 16
let drive = (floor(trial / 1) - 2*floor(trial / 2))*1.8
alter VB0 = $&drive
let drive = (floor(trial / 2) - 2*floor(trial / 4))*1.8
alter VB1 = $&drive
let drive = (floor(trial / 4) - 2*floor(trial / 8))*1.8
alter VB2 = $&drive
let drive = (floor(trial / 8) - 2*floor(trial / 16))*1.8
alter VB3 = $&drive
let drive = (floor(trial / 16) - 2*floor(trial / 32))*1.8
alter VB4 = $&drive
let drive = (floor(trial / 32) - 2*floor(trial / 64))*1.8
alter VB5 = $&drive
let drive = (floor(trial / 64) - 2*floor(trial / 128))*1.8
alter VB6 = $&drive
let drive = (floor(trial / 128) - 2*floor(trial / 256))*1.8
alter VB7 = $&drive
stop when time = 0.001504
resume
delete all
let endpoint = length(time)-1
let cmp = v(COMP)[endpoint]
let top = v(TOP)[endpoint]
let decision = 0
if cmp >= 0.9
let code = trial
let decision = 1
end
echo 83 4 $&trial $&cmp $&top 0.37734375 $&decision >> decisions.csv
let trial = code + 8
let drive = (floor(trial / 1) - 2*floor(trial / 2))*1.8
alter VB0 = $&drive
let drive = (floor(trial / 2) - 2*floor(trial / 4))*1.8
alter VB1 = $&drive
let drive = (floor(trial / 4) - 2*floor(trial / 8))*1.8
alter VB2 = $&drive
let drive = (floor(trial / 8) - 2*floor(trial / 16))*1.8
alter VB3 = $&drive
let drive = (floor(trial / 16) - 2*floor(trial / 32))*1.8
alter VB4 = $&drive
let drive = (floor(trial / 32) - 2*floor(trial / 64))*1.8
alter VB5 = $&drive
let drive = (floor(trial / 64) - 2*floor(trial / 128))*1.8
alter VB6 = $&drive
let drive = (floor(trial / 128) - 2*floor(trial / 256))*1.8
alter VB7 = $&drive
stop when time = 0.001506
resume
delete all
let endpoint = length(time)-1
let cmp = v(COMP)[endpoint]
let top = v(TOP)[endpoint]
let decision = 0
if cmp >= 0.9
let code = trial
let decision = 1
end
echo 83 3 $&trial $&cmp $&top 0.37734375 $&decision >> decisions.csv
let trial = code + 4
let drive = (floor(trial / 1) - 2*floor(trial / 2))*1.8
alter VB0 = $&drive
let drive = (floor(trial / 2) - 2*floor(trial / 4))*1.8
alter VB1 = $&drive
let drive = (floor(trial / 4) - 2*floor(trial / 8))*1.8
alter VB2 = $&drive
let drive = (floor(trial / 8) - 2*floor(trial / 16))*1.8
alter VB3 = $&drive
let drive = (floor(trial / 16) - 2*floor(trial / 32))*1.8
alter VB4 = $&drive
let drive = (floor(trial / 32) - 2*floor(trial / 64))*1.8
alter VB5 = $&drive
let drive = (floor(trial / 64) - 2*floor(trial / 128))*1.8
alter VB6 = $&drive
let drive = (floor(trial / 128) - 2*floor(trial / 256))*1.8
alter VB7 = $&drive
stop when time = 0.001508
resume
delete all
let endpoint = length(time)-1
let cmp = v(COMP)[endpoint]
let top = v(TOP)[endpoint]
let decision = 0
if cmp >= 0.9
let code = trial
let decision = 1
end
echo 83 2 $&trial $&cmp $&top 0.37734375 $&decision >> decisions.csv
let trial = code + 2
let drive = (floor(trial / 1) - 2*floor(trial / 2))*1.8
alter VB0 = $&drive
let drive = (floor(trial / 2) - 2*floor(trial / 4))*1.8
alter VB1 = $&drive
let drive = (floor(trial / 4) - 2*floor(trial / 8))*1.8
alter VB2 = $&drive
let drive = (floor(trial / 8) - 2*floor(trial / 16))*1.8
alter VB3 = $&drive
let drive = (floor(trial / 16) - 2*floor(trial / 32))*1.8
alter VB4 = $&drive
let drive = (floor(trial / 32) - 2*floor(trial / 64))*1.8
alter VB5 = $&drive
let drive = (floor(trial / 64) - 2*floor(trial / 128))*1.8
alter VB6 = $&drive
let drive = (floor(trial / 128) - 2*floor(trial / 256))*1.8
alter VB7 = $&drive
stop when time = 0.00151
resume
delete all
let endpoint = length(time)-1
let cmp = v(COMP)[endpoint]
let top = v(TOP)[endpoint]
let decision = 0
if cmp >= 0.9
let code = trial
let decision = 1
end
echo 83 1 $&trial $&cmp $&top 0.37734375 $&decision >> decisions.csv
let trial = code + 1
let drive = (floor(trial / 1) - 2*floor(trial / 2))*1.8
alter VB0 = $&drive
let drive = (floor(trial / 2) - 2*floor(trial / 4))*1.8
alter VB1 = $&drive
let drive = (floor(trial / 4) - 2*floor(trial / 8))*1.8
alter VB2 = $&drive
let drive = (floor(trial / 8) - 2*floor(trial / 16))*1.8
alter VB3 = $&drive
let drive = (floor(trial / 16) - 2*floor(trial / 32))*1.8
alter VB4 = $&drive
let drive = (floor(trial / 32) - 2*floor(trial / 64))*1.8
alter VB5 = $&drive
let drive = (floor(trial / 64) - 2*floor(trial / 128))*1.8
alter VB6 = $&drive
let drive = (floor(trial / 128) - 2*floor(trial / 256))*1.8
alter VB7 = $&drive
stop when time = 0.001512
resume
delete all
let endpoint = length(time)-1
let cmp = v(COMP)[endpoint]
let top = v(TOP)[endpoint]
let decision = 0
if cmp >= 0.9
let code = trial
let decision = 1
end
echo 83 0 $&trial $&cmp $&top 0.37734375 $&decision >> decisions.csv
alter VIN = 0.38203125
alter VSAMPLE = 1.8
alter VB0 = 0
alter VB1 = 0
alter VB2 = 0
alter VB3 = 0
alter VB4 = 0
alter VB5 = 0
alter VB6 = 0
alter VB7 = 0
let code = 0
stop when time = 0.001514
resume
delete all
alter VSAMPLE = 0
let trial = code + 128
let drive = (floor(trial / 1) - 2*floor(trial / 2))*1.8
alter VB0 = $&drive
let drive = (floor(trial / 2) - 2*floor(trial / 4))*1.8
alter VB1 = $&drive
let drive = (floor(trial / 4) - 2*floor(trial / 8))*1.8
alter VB2 = $&drive
let drive = (floor(trial / 8) - 2*floor(trial / 16))*1.8
alter VB3 = $&drive
let drive = (floor(trial / 16) - 2*floor(trial / 32))*1.8
alter VB4 = $&drive
let drive = (floor(trial / 32) - 2*floor(trial / 64))*1.8
alter VB5 = $&drive
let drive = (floor(trial / 64) - 2*floor(trial / 128))*1.8
alter VB6 = $&drive
let drive = (floor(trial / 128) - 2*floor(trial / 256))*1.8
alter VB7 = $&drive
stop when time = 0.001516
resume
delete all
let endpoint = length(time)-1
let cmp = v(COMP)[endpoint]
let top = v(TOP)[endpoint]
let decision = 0
if cmp >= 0.9
let code = trial
let decision = 1
end
echo 84 7 $&trial $&cmp $&top 0.38203125 $&decision >> decisions.csv
let trial = code + 64
let drive = (floor(trial / 1) - 2*floor(trial / 2))*1.8
alter VB0 = $&drive
let drive = (floor(trial / 2) - 2*floor(trial / 4))*1.8
alter VB1 = $&drive
let drive = (floor(trial / 4) - 2*floor(trial / 8))*1.8
alter VB2 = $&drive
let drive = (floor(trial / 8) - 2*floor(trial / 16))*1.8
alter VB3 = $&drive
let drive = (floor(trial / 16) - 2*floor(trial / 32))*1.8
alter VB4 = $&drive
let drive = (floor(trial / 32) - 2*floor(trial / 64))*1.8
alter VB5 = $&drive
let drive = (floor(trial / 64) - 2*floor(trial / 128))*1.8
alter VB6 = $&drive
let drive = (floor(trial / 128) - 2*floor(trial / 256))*1.8
alter VB7 = $&drive
stop when time = 0.001518
resume
delete all
let endpoint = length(time)-1
let cmp = v(COMP)[endpoint]
let top = v(TOP)[endpoint]
let decision = 0
if cmp >= 0.9
let code = trial
let decision = 1
end
echo 84 6 $&trial $&cmp $&top 0.38203125 $&decision >> decisions.csv
let trial = code + 32
let drive = (floor(trial / 1) - 2*floor(trial / 2))*1.8
alter VB0 = $&drive
let drive = (floor(trial / 2) - 2*floor(trial / 4))*1.8
alter VB1 = $&drive
let drive = (floor(trial / 4) - 2*floor(trial / 8))*1.8
alter VB2 = $&drive
let drive = (floor(trial / 8) - 2*floor(trial / 16))*1.8
alter VB3 = $&drive
let drive = (floor(trial / 16) - 2*floor(trial / 32))*1.8
alter VB4 = $&drive
let drive = (floor(trial / 32) - 2*floor(trial / 64))*1.8
alter VB5 = $&drive
let drive = (floor(trial / 64) - 2*floor(trial / 128))*1.8
alter VB6 = $&drive
let drive = (floor(trial / 128) - 2*floor(trial / 256))*1.8
alter VB7 = $&drive
stop when time = 0.00152
resume
delete all
let endpoint = length(time)-1
let cmp = v(COMP)[endpoint]
let top = v(TOP)[endpoint]
let decision = 0
if cmp >= 0.9
let code = trial
let decision = 1
end
echo 84 5 $&trial $&cmp $&top 0.38203125 $&decision >> decisions.csv
let trial = code + 16
let drive = (floor(trial / 1) - 2*floor(trial / 2))*1.8
alter VB0 = $&drive
let drive = (floor(trial / 2) - 2*floor(trial / 4))*1.8
alter VB1 = $&drive
let drive = (floor(trial / 4) - 2*floor(trial / 8))*1.8
alter VB2 = $&drive
let drive = (floor(trial / 8) - 2*floor(trial / 16))*1.8
alter VB3 = $&drive
let drive = (floor(trial / 16) - 2*floor(trial / 32))*1.8
alter VB4 = $&drive
let drive = (floor(trial / 32) - 2*floor(trial / 64))*1.8
alter VB5 = $&drive
let drive = (floor(trial / 64) - 2*floor(trial / 128))*1.8
alter VB6 = $&drive
let drive = (floor(trial / 128) - 2*floor(trial / 256))*1.8
alter VB7 = $&drive
stop when time = 0.001522
resume
delete all
let endpoint = length(time)-1
let cmp = v(COMP)[endpoint]
let top = v(TOP)[endpoint]
let decision = 0
if cmp >= 0.9
let code = trial
let decision = 1
end
echo 84 4 $&trial $&cmp $&top 0.38203125 $&decision >> decisions.csv
let trial = code + 8
let drive = (floor(trial / 1) - 2*floor(trial / 2))*1.8
alter VB0 = $&drive
let drive = (floor(trial / 2) - 2*floor(trial / 4))*1.8
alter VB1 = $&drive
let drive = (floor(trial / 4) - 2*floor(trial / 8))*1.8
alter VB2 = $&drive
let drive = (floor(trial / 8) - 2*floor(trial / 16))*1.8
alter VB3 = $&drive
let drive = (floor(trial / 16) - 2*floor(trial / 32))*1.8
alter VB4 = $&drive
let drive = (floor(trial / 32) - 2*floor(trial / 64))*1.8
alter VB5 = $&drive
let drive = (floor(trial / 64) - 2*floor(trial / 128))*1.8
alter VB6 = $&drive
let drive = (floor(trial / 128) - 2*floor(trial / 256))*1.8
alter VB7 = $&drive
stop when time = 0.001524
resume
delete all
let endpoint = length(time)-1
let cmp = v(COMP)[endpoint]
let top = v(TOP)[endpoint]
let decision = 0
if cmp >= 0.9
let code = trial
let decision = 1
end
echo 84 3 $&trial $&cmp $&top 0.38203125 $&decision >> decisions.csv
let trial = code + 4
let drive = (floor(trial / 1) - 2*floor(trial / 2))*1.8
alter VB0 = $&drive
let drive = (floor(trial / 2) - 2*floor(trial / 4))*1.8
alter VB1 = $&drive
let drive = (floor(trial / 4) - 2*floor(trial / 8))*1.8
alter VB2 = $&drive
let drive = (floor(trial / 8) - 2*floor(trial / 16))*1.8
alter VB3 = $&drive
let drive = (floor(trial / 16) - 2*floor(trial / 32))*1.8
alter VB4 = $&drive
let drive = (floor(trial / 32) - 2*floor(trial / 64))*1.8
alter VB5 = $&drive
let drive = (floor(trial / 64) - 2*floor(trial / 128))*1.8
alter VB6 = $&drive
let drive = (floor(trial / 128) - 2*floor(trial / 256))*1.8
alter VB7 = $&drive
stop when time = 0.001526
resume
delete all
let endpoint = length(time)-1
let cmp = v(COMP)[endpoint]
let top = v(TOP)[endpoint]
let decision = 0
if cmp >= 0.9
let code = trial
let decision = 1
end
echo 84 2 $&trial $&cmp $&top 0.38203125 $&decision >> decisions.csv
let trial = code + 2
let drive = (floor(trial / 1) - 2*floor(trial / 2))*1.8
alter VB0 = $&drive
let drive = (floor(trial / 2) - 2*floor(trial / 4))*1.8
alter VB1 = $&drive
let drive = (floor(trial / 4) - 2*floor(trial / 8))*1.8
alter VB2 = $&drive
let drive = (floor(trial / 8) - 2*floor(trial / 16))*1.8
alter VB3 = $&drive
let drive = (floor(trial / 16) - 2*floor(trial / 32))*1.8
alter VB4 = $&drive
let drive = (floor(trial / 32) - 2*floor(trial / 64))*1.8
alter VB5 = $&drive
let drive = (floor(trial / 64) - 2*floor(trial / 128))*1.8
alter VB6 = $&drive
let drive = (floor(trial / 128) - 2*floor(trial / 256))*1.8
alter VB7 = $&drive
stop when time = 0.001528
resume
delete all
let endpoint = length(time)-1
let cmp = v(COMP)[endpoint]
let top = v(TOP)[endpoint]
let decision = 0
if cmp >= 0.9
let code = trial
let decision = 1
end
echo 84 1 $&trial $&cmp $&top 0.38203125 $&decision >> decisions.csv
let trial = code + 1
let drive = (floor(trial / 1) - 2*floor(trial / 2))*1.8
alter VB0 = $&drive
let drive = (floor(trial / 2) - 2*floor(trial / 4))*1.8
alter VB1 = $&drive
let drive = (floor(trial / 4) - 2*floor(trial / 8))*1.8
alter VB2 = $&drive
let drive = (floor(trial / 8) - 2*floor(trial / 16))*1.8
alter VB3 = $&drive
let drive = (floor(trial / 16) - 2*floor(trial / 32))*1.8
alter VB4 = $&drive
let drive = (floor(trial / 32) - 2*floor(trial / 64))*1.8
alter VB5 = $&drive
let drive = (floor(trial / 64) - 2*floor(trial / 128))*1.8
alter VB6 = $&drive
let drive = (floor(trial / 128) - 2*floor(trial / 256))*1.8
alter VB7 = $&drive
stop when time = 0.00153
resume
delete all
let endpoint = length(time)-1
let cmp = v(COMP)[endpoint]
let top = v(TOP)[endpoint]
let decision = 0
if cmp >= 0.9
let code = trial
let decision = 1
end
echo 84 0 $&trial $&cmp $&top 0.38203125 $&decision >> decisions.csv
alter VIN = 0.38671875
alter VSAMPLE = 1.8
alter VB0 = 0
alter VB1 = 0
alter VB2 = 0
alter VB3 = 0
alter VB4 = 0
alter VB5 = 0
alter VB6 = 0
alter VB7 = 0
let code = 0
stop when time = 0.001532
resume
delete all
alter VSAMPLE = 0
let trial = code + 128
let drive = (floor(trial / 1) - 2*floor(trial / 2))*1.8
alter VB0 = $&drive
let drive = (floor(trial / 2) - 2*floor(trial / 4))*1.8
alter VB1 = $&drive
let drive = (floor(trial / 4) - 2*floor(trial / 8))*1.8
alter VB2 = $&drive
let drive = (floor(trial / 8) - 2*floor(trial / 16))*1.8
alter VB3 = $&drive
let drive = (floor(trial / 16) - 2*floor(trial / 32))*1.8
alter VB4 = $&drive
let drive = (floor(trial / 32) - 2*floor(trial / 64))*1.8
alter VB5 = $&drive
let drive = (floor(trial / 64) - 2*floor(trial / 128))*1.8
alter VB6 = $&drive
let drive = (floor(trial / 128) - 2*floor(trial / 256))*1.8
alter VB7 = $&drive
stop when time = 0.001534
resume
delete all
let endpoint = length(time)-1
let cmp = v(COMP)[endpoint]
let top = v(TOP)[endpoint]
let decision = 0
if cmp >= 0.9
let code = trial
let decision = 1
end
echo 85 7 $&trial $&cmp $&top 0.38671875 $&decision >> decisions.csv
let trial = code + 64
let drive = (floor(trial / 1) - 2*floor(trial / 2))*1.8
alter VB0 = $&drive
let drive = (floor(trial / 2) - 2*floor(trial / 4))*1.8
alter VB1 = $&drive
let drive = (floor(trial / 4) - 2*floor(trial / 8))*1.8
alter VB2 = $&drive
let drive = (floor(trial / 8) - 2*floor(trial / 16))*1.8
alter VB3 = $&drive
let drive = (floor(trial / 16) - 2*floor(trial / 32))*1.8
alter VB4 = $&drive
let drive = (floor(trial / 32) - 2*floor(trial / 64))*1.8
alter VB5 = $&drive
let drive = (floor(trial / 64) - 2*floor(trial / 128))*1.8
alter VB6 = $&drive
let drive = (floor(trial / 128) - 2*floor(trial / 256))*1.8
alter VB7 = $&drive
stop when time = 0.001536
resume
delete all
let endpoint = length(time)-1
let cmp = v(COMP)[endpoint]
let top = v(TOP)[endpoint]
let decision = 0
if cmp >= 0.9
let code = trial
let decision = 1
end
echo 85 6 $&trial $&cmp $&top 0.38671875 $&decision >> decisions.csv
let trial = code + 32
let drive = (floor(trial / 1) - 2*floor(trial / 2))*1.8
alter VB0 = $&drive
let drive = (floor(trial / 2) - 2*floor(trial / 4))*1.8
alter VB1 = $&drive
let drive = (floor(trial / 4) - 2*floor(trial / 8))*1.8
alter VB2 = $&drive
let drive = (floor(trial / 8) - 2*floor(trial / 16))*1.8
alter VB3 = $&drive
let drive = (floor(trial / 16) - 2*floor(trial / 32))*1.8
alter VB4 = $&drive
let drive = (floor(trial / 32) - 2*floor(trial / 64))*1.8
alter VB5 = $&drive
let drive = (floor(trial / 64) - 2*floor(trial / 128))*1.8
alter VB6 = $&drive
let drive = (floor(trial / 128) - 2*floor(trial / 256))*1.8
alter VB7 = $&drive
stop when time = 0.001538
resume
delete all
let endpoint = length(time)-1
let cmp = v(COMP)[endpoint]
let top = v(TOP)[endpoint]
let decision = 0
if cmp >= 0.9
let code = trial
let decision = 1
end
echo 85 5 $&trial $&cmp $&top 0.38671875 $&decision >> decisions.csv
let trial = code + 16
let drive = (floor(trial / 1) - 2*floor(trial / 2))*1.8
alter VB0 = $&drive
let drive = (floor(trial / 2) - 2*floor(trial / 4))*1.8
alter VB1 = $&drive
let drive = (floor(trial / 4) - 2*floor(trial / 8))*1.8
alter VB2 = $&drive
let drive = (floor(trial / 8) - 2*floor(trial / 16))*1.8
alter VB3 = $&drive
let drive = (floor(trial / 16) - 2*floor(trial / 32))*1.8
alter VB4 = $&drive
let drive = (floor(trial / 32) - 2*floor(trial / 64))*1.8
alter VB5 = $&drive
let drive = (floor(trial / 64) - 2*floor(trial / 128))*1.8
alter VB6 = $&drive
let drive = (floor(trial / 128) - 2*floor(trial / 256))*1.8
alter VB7 = $&drive
stop when time = 0.00154
resume
delete all
let endpoint = length(time)-1
let cmp = v(COMP)[endpoint]
let top = v(TOP)[endpoint]
let decision = 0
if cmp >= 0.9
let code = trial
let decision = 1
end
echo 85 4 $&trial $&cmp $&top 0.38671875 $&decision >> decisions.csv
let trial = code + 8
let drive = (floor(trial / 1) - 2*floor(trial / 2))*1.8
alter VB0 = $&drive
let drive = (floor(trial / 2) - 2*floor(trial / 4))*1.8
alter VB1 = $&drive
let drive = (floor(trial / 4) - 2*floor(trial / 8))*1.8
alter VB2 = $&drive
let drive = (floor(trial / 8) - 2*floor(trial / 16))*1.8
alter VB3 = $&drive
let drive = (floor(trial / 16) - 2*floor(trial / 32))*1.8
alter VB4 = $&drive
let drive = (floor(trial / 32) - 2*floor(trial / 64))*1.8
alter VB5 = $&drive
let drive = (floor(trial / 64) - 2*floor(trial / 128))*1.8
alter VB6 = $&drive
let drive = (floor(trial / 128) - 2*floor(trial / 256))*1.8
alter VB7 = $&drive
stop when time = 0.001542
resume
delete all
let endpoint = length(time)-1
let cmp = v(COMP)[endpoint]
let top = v(TOP)[endpoint]
let decision = 0
if cmp >= 0.9
let code = trial
let decision = 1
end
echo 85 3 $&trial $&cmp $&top 0.38671875 $&decision >> decisions.csv
let trial = code + 4
let drive = (floor(trial / 1) - 2*floor(trial / 2))*1.8
alter VB0 = $&drive
let drive = (floor(trial / 2) - 2*floor(trial / 4))*1.8
alter VB1 = $&drive
let drive = (floor(trial / 4) - 2*floor(trial / 8))*1.8
alter VB2 = $&drive
let drive = (floor(trial / 8) - 2*floor(trial / 16))*1.8
alter VB3 = $&drive
let drive = (floor(trial / 16) - 2*floor(trial / 32))*1.8
alter VB4 = $&drive
let drive = (floor(trial / 32) - 2*floor(trial / 64))*1.8
alter VB5 = $&drive
let drive = (floor(trial / 64) - 2*floor(trial / 128))*1.8
alter VB6 = $&drive
let drive = (floor(trial / 128) - 2*floor(trial / 256))*1.8
alter VB7 = $&drive
stop when time = 0.001544
resume
delete all
let endpoint = length(time)-1
let cmp = v(COMP)[endpoint]
let top = v(TOP)[endpoint]
let decision = 0
if cmp >= 0.9
let code = trial
let decision = 1
end
echo 85 2 $&trial $&cmp $&top 0.38671875 $&decision >> decisions.csv
let trial = code + 2
let drive = (floor(trial / 1) - 2*floor(trial / 2))*1.8
alter VB0 = $&drive
let drive = (floor(trial / 2) - 2*floor(trial / 4))*1.8
alter VB1 = $&drive
let drive = (floor(trial / 4) - 2*floor(trial / 8))*1.8
alter VB2 = $&drive
let drive = (floor(trial / 8) - 2*floor(trial / 16))*1.8
alter VB3 = $&drive
let drive = (floor(trial / 16) - 2*floor(trial / 32))*1.8
alter VB4 = $&drive
let drive = (floor(trial / 32) - 2*floor(trial / 64))*1.8
alter VB5 = $&drive
let drive = (floor(trial / 64) - 2*floor(trial / 128))*1.8
alter VB6 = $&drive
let drive = (floor(trial / 128) - 2*floor(trial / 256))*1.8
alter VB7 = $&drive
stop when time = 0.001546
resume
delete all
let endpoint = length(time)-1
let cmp = v(COMP)[endpoint]
let top = v(TOP)[endpoint]
let decision = 0
if cmp >= 0.9
let code = trial
let decision = 1
end
echo 85 1 $&trial $&cmp $&top 0.38671875 $&decision >> decisions.csv
let trial = code + 1
let drive = (floor(trial / 1) - 2*floor(trial / 2))*1.8
alter VB0 = $&drive
let drive = (floor(trial / 2) - 2*floor(trial / 4))*1.8
alter VB1 = $&drive
let drive = (floor(trial / 4) - 2*floor(trial / 8))*1.8
alter VB2 = $&drive
let drive = (floor(trial / 8) - 2*floor(trial / 16))*1.8
alter VB3 = $&drive
let drive = (floor(trial / 16) - 2*floor(trial / 32))*1.8
alter VB4 = $&drive
let drive = (floor(trial / 32) - 2*floor(trial / 64))*1.8
alter VB5 = $&drive
let drive = (floor(trial / 64) - 2*floor(trial / 128))*1.8
alter VB6 = $&drive
let drive = (floor(trial / 128) - 2*floor(trial / 256))*1.8
alter VB7 = $&drive
stop when time = 0.001548
resume
delete all
let endpoint = length(time)-1
let cmp = v(COMP)[endpoint]
let top = v(TOP)[endpoint]
let decision = 0
if cmp >= 0.9
let code = trial
let decision = 1
end
echo 85 0 $&trial $&cmp $&top 0.38671875 $&decision >> decisions.csv
alter VIN = 0.39140625
alter VSAMPLE = 1.8
alter VB0 = 0
alter VB1 = 0
alter VB2 = 0
alter VB3 = 0
alter VB4 = 0
alter VB5 = 0
alter VB6 = 0
alter VB7 = 0
let code = 0
stop when time = 0.00155
resume
delete all
alter VSAMPLE = 0
let trial = code + 128
let drive = (floor(trial / 1) - 2*floor(trial / 2))*1.8
alter VB0 = $&drive
let drive = (floor(trial / 2) - 2*floor(trial / 4))*1.8
alter VB1 = $&drive
let drive = (floor(trial / 4) - 2*floor(trial / 8))*1.8
alter VB2 = $&drive
let drive = (floor(trial / 8) - 2*floor(trial / 16))*1.8
alter VB3 = $&drive
let drive = (floor(trial / 16) - 2*floor(trial / 32))*1.8
alter VB4 = $&drive
let drive = (floor(trial / 32) - 2*floor(trial / 64))*1.8
alter VB5 = $&drive
let drive = (floor(trial / 64) - 2*floor(trial / 128))*1.8
alter VB6 = $&drive
let drive = (floor(trial / 128) - 2*floor(trial / 256))*1.8
alter VB7 = $&drive
stop when time = 0.001552
resume
delete all
let endpoint = length(time)-1
let cmp = v(COMP)[endpoint]
let top = v(TOP)[endpoint]
let decision = 0
if cmp >= 0.9
let code = trial
let decision = 1
end
echo 86 7 $&trial $&cmp $&top 0.39140625 $&decision >> decisions.csv
let trial = code + 64
let drive = (floor(trial / 1) - 2*floor(trial / 2))*1.8
alter VB0 = $&drive
let drive = (floor(trial / 2) - 2*floor(trial / 4))*1.8
alter VB1 = $&drive
let drive = (floor(trial / 4) - 2*floor(trial / 8))*1.8
alter VB2 = $&drive
let drive = (floor(trial / 8) - 2*floor(trial / 16))*1.8
alter VB3 = $&drive
let drive = (floor(trial / 16) - 2*floor(trial / 32))*1.8
alter VB4 = $&drive
let drive = (floor(trial / 32) - 2*floor(trial / 64))*1.8
alter VB5 = $&drive
let drive = (floor(trial / 64) - 2*floor(trial / 128))*1.8
alter VB6 = $&drive
let drive = (floor(trial / 128) - 2*floor(trial / 256))*1.8
alter VB7 = $&drive
stop when time = 0.001554
resume
delete all
let endpoint = length(time)-1
let cmp = v(COMP)[endpoint]
let top = v(TOP)[endpoint]
let decision = 0
if cmp >= 0.9
let code = trial
let decision = 1
end
echo 86 6 $&trial $&cmp $&top 0.39140625 $&decision >> decisions.csv
let trial = code + 32
let drive = (floor(trial / 1) - 2*floor(trial / 2))*1.8
alter VB0 = $&drive
let drive = (floor(trial / 2) - 2*floor(trial / 4))*1.8
alter VB1 = $&drive
let drive = (floor(trial / 4) - 2*floor(trial / 8))*1.8
alter VB2 = $&drive
let drive = (floor(trial / 8) - 2*floor(trial / 16))*1.8
alter VB3 = $&drive
let drive = (floor(trial / 16) - 2*floor(trial / 32))*1.8
alter VB4 = $&drive
let drive = (floor(trial / 32) - 2*floor(trial / 64))*1.8
alter VB5 = $&drive
let drive = (floor(trial / 64) - 2*floor(trial / 128))*1.8
alter VB6 = $&drive
let drive = (floor(trial / 128) - 2*floor(trial / 256))*1.8
alter VB7 = $&drive
stop when time = 0.001556
resume
delete all
let endpoint = length(time)-1
let cmp = v(COMP)[endpoint]
let top = v(TOP)[endpoint]
let decision = 0
if cmp >= 0.9
let code = trial
let decision = 1
end
echo 86 5 $&trial $&cmp $&top 0.39140625 $&decision >> decisions.csv
let trial = code + 16
let drive = (floor(trial / 1) - 2*floor(trial / 2))*1.8
alter VB0 = $&drive
let drive = (floor(trial / 2) - 2*floor(trial / 4))*1.8
alter VB1 = $&drive
let drive = (floor(trial / 4) - 2*floor(trial / 8))*1.8
alter VB2 = $&drive
let drive = (floor(trial / 8) - 2*floor(trial / 16))*1.8
alter VB3 = $&drive
let drive = (floor(trial / 16) - 2*floor(trial / 32))*1.8
alter VB4 = $&drive
let drive = (floor(trial / 32) - 2*floor(trial / 64))*1.8
alter VB5 = $&drive
let drive = (floor(trial / 64) - 2*floor(trial / 128))*1.8
alter VB6 = $&drive
let drive = (floor(trial / 128) - 2*floor(trial / 256))*1.8
alter VB7 = $&drive
stop when time = 0.001558
resume
delete all
let endpoint = length(time)-1
let cmp = v(COMP)[endpoint]
let top = v(TOP)[endpoint]
let decision = 0
if cmp >= 0.9
let code = trial
let decision = 1
end
echo 86 4 $&trial $&cmp $&top 0.39140625 $&decision >> decisions.csv
let trial = code + 8
let drive = (floor(trial / 1) - 2*floor(trial / 2))*1.8
alter VB0 = $&drive
let drive = (floor(trial / 2) - 2*floor(trial / 4))*1.8
alter VB1 = $&drive
let drive = (floor(trial / 4) - 2*floor(trial / 8))*1.8
alter VB2 = $&drive
let drive = (floor(trial / 8) - 2*floor(trial / 16))*1.8
alter VB3 = $&drive
let drive = (floor(trial / 16) - 2*floor(trial / 32))*1.8
alter VB4 = $&drive
let drive = (floor(trial / 32) - 2*floor(trial / 64))*1.8
alter VB5 = $&drive
let drive = (floor(trial / 64) - 2*floor(trial / 128))*1.8
alter VB6 = $&drive
let drive = (floor(trial / 128) - 2*floor(trial / 256))*1.8
alter VB7 = $&drive
stop when time = 0.00156
resume
delete all
let endpoint = length(time)-1
let cmp = v(COMP)[endpoint]
let top = v(TOP)[endpoint]
let decision = 0
if cmp >= 0.9
let code = trial
let decision = 1
end
echo 86 3 $&trial $&cmp $&top 0.39140625 $&decision >> decisions.csv
let trial = code + 4
let drive = (floor(trial / 1) - 2*floor(trial / 2))*1.8
alter VB0 = $&drive
let drive = (floor(trial / 2) - 2*floor(trial / 4))*1.8
alter VB1 = $&drive
let drive = (floor(trial / 4) - 2*floor(trial / 8))*1.8
alter VB2 = $&drive
let drive = (floor(trial / 8) - 2*floor(trial / 16))*1.8
alter VB3 = $&drive
let drive = (floor(trial / 16) - 2*floor(trial / 32))*1.8
alter VB4 = $&drive
let drive = (floor(trial / 32) - 2*floor(trial / 64))*1.8
alter VB5 = $&drive
let drive = (floor(trial / 64) - 2*floor(trial / 128))*1.8
alter VB6 = $&drive
let drive = (floor(trial / 128) - 2*floor(trial / 256))*1.8
alter VB7 = $&drive
stop when time = 0.001562
resume
delete all
let endpoint = length(time)-1
let cmp = v(COMP)[endpoint]
let top = v(TOP)[endpoint]
let decision = 0
if cmp >= 0.9
let code = trial
let decision = 1
end
echo 86 2 $&trial $&cmp $&top 0.39140625 $&decision >> decisions.csv
let trial = code + 2
let drive = (floor(trial / 1) - 2*floor(trial / 2))*1.8
alter VB0 = $&drive
let drive = (floor(trial / 2) - 2*floor(trial / 4))*1.8
alter VB1 = $&drive
let drive = (floor(trial / 4) - 2*floor(trial / 8))*1.8
alter VB2 = $&drive
let drive = (floor(trial / 8) - 2*floor(trial / 16))*1.8
alter VB3 = $&drive
let drive = (floor(trial / 16) - 2*floor(trial / 32))*1.8
alter VB4 = $&drive
let drive = (floor(trial / 32) - 2*floor(trial / 64))*1.8
alter VB5 = $&drive
let drive = (floor(trial / 64) - 2*floor(trial / 128))*1.8
alter VB6 = $&drive
let drive = (floor(trial / 128) - 2*floor(trial / 256))*1.8
alter VB7 = $&drive
stop when time = 0.001564
resume
delete all
let endpoint = length(time)-1
let cmp = v(COMP)[endpoint]
let top = v(TOP)[endpoint]
let decision = 0
if cmp >= 0.9
let code = trial
let decision = 1
end
echo 86 1 $&trial $&cmp $&top 0.39140625 $&decision >> decisions.csv
let trial = code + 1
let drive = (floor(trial / 1) - 2*floor(trial / 2))*1.8
alter VB0 = $&drive
let drive = (floor(trial / 2) - 2*floor(trial / 4))*1.8
alter VB1 = $&drive
let drive = (floor(trial / 4) - 2*floor(trial / 8))*1.8
alter VB2 = $&drive
let drive = (floor(trial / 8) - 2*floor(trial / 16))*1.8
alter VB3 = $&drive
let drive = (floor(trial / 16) - 2*floor(trial / 32))*1.8
alter VB4 = $&drive
let drive = (floor(trial / 32) - 2*floor(trial / 64))*1.8
alter VB5 = $&drive
let drive = (floor(trial / 64) - 2*floor(trial / 128))*1.8
alter VB6 = $&drive
let drive = (floor(trial / 128) - 2*floor(trial / 256))*1.8
alter VB7 = $&drive
stop when time = 0.001566
resume
delete all
let endpoint = length(time)-1
let cmp = v(COMP)[endpoint]
let top = v(TOP)[endpoint]
let decision = 0
if cmp >= 0.9
let code = trial
let decision = 1
end
echo 86 0 $&trial $&cmp $&top 0.39140625 $&decision >> decisions.csv
alter VIN = 0.39609375
alter VSAMPLE = 1.8
alter VB0 = 0
alter VB1 = 0
alter VB2 = 0
alter VB3 = 0
alter VB4 = 0
alter VB5 = 0
alter VB6 = 0
alter VB7 = 0
let code = 0
stop when time = 0.001568
resume
delete all
alter VSAMPLE = 0
let trial = code + 128
let drive = (floor(trial / 1) - 2*floor(trial / 2))*1.8
alter VB0 = $&drive
let drive = (floor(trial / 2) - 2*floor(trial / 4))*1.8
alter VB1 = $&drive
let drive = (floor(trial / 4) - 2*floor(trial / 8))*1.8
alter VB2 = $&drive
let drive = (floor(trial / 8) - 2*floor(trial / 16))*1.8
alter VB3 = $&drive
let drive = (floor(trial / 16) - 2*floor(trial / 32))*1.8
alter VB4 = $&drive
let drive = (floor(trial / 32) - 2*floor(trial / 64))*1.8
alter VB5 = $&drive
let drive = (floor(trial / 64) - 2*floor(trial / 128))*1.8
alter VB6 = $&drive
let drive = (floor(trial / 128) - 2*floor(trial / 256))*1.8
alter VB7 = $&drive
stop when time = 0.00157
resume
delete all
let endpoint = length(time)-1
let cmp = v(COMP)[endpoint]
let top = v(TOP)[endpoint]
let decision = 0
if cmp >= 0.9
let code = trial
let decision = 1
end
echo 87 7 $&trial $&cmp $&top 0.39609375 $&decision >> decisions.csv
let trial = code + 64
let drive = (floor(trial / 1) - 2*floor(trial / 2))*1.8
alter VB0 = $&drive
let drive = (floor(trial / 2) - 2*floor(trial / 4))*1.8
alter VB1 = $&drive
let drive = (floor(trial / 4) - 2*floor(trial / 8))*1.8
alter VB2 = $&drive
let drive = (floor(trial / 8) - 2*floor(trial / 16))*1.8
alter VB3 = $&drive
let drive = (floor(trial / 16) - 2*floor(trial / 32))*1.8
alter VB4 = $&drive
let drive = (floor(trial / 32) - 2*floor(trial / 64))*1.8
alter VB5 = $&drive
let drive = (floor(trial / 64) - 2*floor(trial / 128))*1.8
alter VB6 = $&drive
let drive = (floor(trial / 128) - 2*floor(trial / 256))*1.8
alter VB7 = $&drive
stop when time = 0.001572
resume
delete all
let endpoint = length(time)-1
let cmp = v(COMP)[endpoint]
let top = v(TOP)[endpoint]
let decision = 0
if cmp >= 0.9
let code = trial
let decision = 1
end
echo 87 6 $&trial $&cmp $&top 0.39609375 $&decision >> decisions.csv
let trial = code + 32
let drive = (floor(trial / 1) - 2*floor(trial / 2))*1.8
alter VB0 = $&drive
let drive = (floor(trial / 2) - 2*floor(trial / 4))*1.8
alter VB1 = $&drive
let drive = (floor(trial / 4) - 2*floor(trial / 8))*1.8
alter VB2 = $&drive
let drive = (floor(trial / 8) - 2*floor(trial / 16))*1.8
alter VB3 = $&drive
let drive = (floor(trial / 16) - 2*floor(trial / 32))*1.8
alter VB4 = $&drive
let drive = (floor(trial / 32) - 2*floor(trial / 64))*1.8
alter VB5 = $&drive
let drive = (floor(trial / 64) - 2*floor(trial / 128))*1.8
alter VB6 = $&drive
let drive = (floor(trial / 128) - 2*floor(trial / 256))*1.8
alter VB7 = $&drive
stop when time = 0.001574
resume
delete all
let endpoint = length(time)-1
let cmp = v(COMP)[endpoint]
let top = v(TOP)[endpoint]
let decision = 0
if cmp >= 0.9
let code = trial
let decision = 1
end
echo 87 5 $&trial $&cmp $&top 0.39609375 $&decision >> decisions.csv
let trial = code + 16
let drive = (floor(trial / 1) - 2*floor(trial / 2))*1.8
alter VB0 = $&drive
let drive = (floor(trial / 2) - 2*floor(trial / 4))*1.8
alter VB1 = $&drive
let drive = (floor(trial / 4) - 2*floor(trial / 8))*1.8
alter VB2 = $&drive
let drive = (floor(trial / 8) - 2*floor(trial / 16))*1.8
alter VB3 = $&drive
let drive = (floor(trial / 16) - 2*floor(trial / 32))*1.8
alter VB4 = $&drive
let drive = (floor(trial / 32) - 2*floor(trial / 64))*1.8
alter VB5 = $&drive
let drive = (floor(trial / 64) - 2*floor(trial / 128))*1.8
alter VB6 = $&drive
let drive = (floor(trial / 128) - 2*floor(trial / 256))*1.8
alter VB7 = $&drive
stop when time = 0.001576
resume
delete all
let endpoint = length(time)-1
let cmp = v(COMP)[endpoint]
let top = v(TOP)[endpoint]
let decision = 0
if cmp >= 0.9
let code = trial
let decision = 1
end
echo 87 4 $&trial $&cmp $&top 0.39609375 $&decision >> decisions.csv
let trial = code + 8
let drive = (floor(trial / 1) - 2*floor(trial / 2))*1.8
alter VB0 = $&drive
let drive = (floor(trial / 2) - 2*floor(trial / 4))*1.8
alter VB1 = $&drive
let drive = (floor(trial / 4) - 2*floor(trial / 8))*1.8
alter VB2 = $&drive
let drive = (floor(trial / 8) - 2*floor(trial / 16))*1.8
alter VB3 = $&drive
let drive = (floor(trial / 16) - 2*floor(trial / 32))*1.8
alter VB4 = $&drive
let drive = (floor(trial / 32) - 2*floor(trial / 64))*1.8
alter VB5 = $&drive
let drive = (floor(trial / 64) - 2*floor(trial / 128))*1.8
alter VB6 = $&drive
let drive = (floor(trial / 128) - 2*floor(trial / 256))*1.8
alter VB7 = $&drive
stop when time = 0.001578
resume
delete all
let endpoint = length(time)-1
let cmp = v(COMP)[endpoint]
let top = v(TOP)[endpoint]
let decision = 0
if cmp >= 0.9
let code = trial
let decision = 1
end
echo 87 3 $&trial $&cmp $&top 0.39609375 $&decision >> decisions.csv
let trial = code + 4
let drive = (floor(trial / 1) - 2*floor(trial / 2))*1.8
alter VB0 = $&drive
let drive = (floor(trial / 2) - 2*floor(trial / 4))*1.8
alter VB1 = $&drive
let drive = (floor(trial / 4) - 2*floor(trial / 8))*1.8
alter VB2 = $&drive
let drive = (floor(trial / 8) - 2*floor(trial / 16))*1.8
alter VB3 = $&drive
let drive = (floor(trial / 16) - 2*floor(trial / 32))*1.8
alter VB4 = $&drive
let drive = (floor(trial / 32) - 2*floor(trial / 64))*1.8
alter VB5 = $&drive
let drive = (floor(trial / 64) - 2*floor(trial / 128))*1.8
alter VB6 = $&drive
let drive = (floor(trial / 128) - 2*floor(trial / 256))*1.8
alter VB7 = $&drive
stop when time = 0.00158
resume
delete all
let endpoint = length(time)-1
let cmp = v(COMP)[endpoint]
let top = v(TOP)[endpoint]
let decision = 0
if cmp >= 0.9
let code = trial
let decision = 1
end
echo 87 2 $&trial $&cmp $&top 0.39609375 $&decision >> decisions.csv
let trial = code + 2
let drive = (floor(trial / 1) - 2*floor(trial / 2))*1.8
alter VB0 = $&drive
let drive = (floor(trial / 2) - 2*floor(trial / 4))*1.8
alter VB1 = $&drive
let drive = (floor(trial / 4) - 2*floor(trial / 8))*1.8
alter VB2 = $&drive
let drive = (floor(trial / 8) - 2*floor(trial / 16))*1.8
alter VB3 = $&drive
let drive = (floor(trial / 16) - 2*floor(trial / 32))*1.8
alter VB4 = $&drive
let drive = (floor(trial / 32) - 2*floor(trial / 64))*1.8
alter VB5 = $&drive
let drive = (floor(trial / 64) - 2*floor(trial / 128))*1.8
alter VB6 = $&drive
let drive = (floor(trial / 128) - 2*floor(trial / 256))*1.8
alter VB7 = $&drive
stop when time = 0.001582
resume
delete all
let endpoint = length(time)-1
let cmp = v(COMP)[endpoint]
let top = v(TOP)[endpoint]
let decision = 0
if cmp >= 0.9
let code = trial
let decision = 1
end
echo 87 1 $&trial $&cmp $&top 0.39609375 $&decision >> decisions.csv
let trial = code + 1
let drive = (floor(trial / 1) - 2*floor(trial / 2))*1.8
alter VB0 = $&drive
let drive = (floor(trial / 2) - 2*floor(trial / 4))*1.8
alter VB1 = $&drive
let drive = (floor(trial / 4) - 2*floor(trial / 8))*1.8
alter VB2 = $&drive
let drive = (floor(trial / 8) - 2*floor(trial / 16))*1.8
alter VB3 = $&drive
let drive = (floor(trial / 16) - 2*floor(trial / 32))*1.8
alter VB4 = $&drive
let drive = (floor(trial / 32) - 2*floor(trial / 64))*1.8
alter VB5 = $&drive
let drive = (floor(trial / 64) - 2*floor(trial / 128))*1.8
alter VB6 = $&drive
let drive = (floor(trial / 128) - 2*floor(trial / 256))*1.8
alter VB7 = $&drive
stop when time = 0.001584
resume
delete all
let endpoint = length(time)-1
let cmp = v(COMP)[endpoint]
let top = v(TOP)[endpoint]
let decision = 0
if cmp >= 0.9
let code = trial
let decision = 1
end
echo 87 0 $&trial $&cmp $&top 0.39609375 $&decision >> decisions.csv
alter VIN = 0.40078125
alter VSAMPLE = 1.8
alter VB0 = 0
alter VB1 = 0
alter VB2 = 0
alter VB3 = 0
alter VB4 = 0
alter VB5 = 0
alter VB6 = 0
alter VB7 = 0
let code = 0
stop when time = 0.001586
resume
delete all
alter VSAMPLE = 0
let trial = code + 128
let drive = (floor(trial / 1) - 2*floor(trial / 2))*1.8
alter VB0 = $&drive
let drive = (floor(trial / 2) - 2*floor(trial / 4))*1.8
alter VB1 = $&drive
let drive = (floor(trial / 4) - 2*floor(trial / 8))*1.8
alter VB2 = $&drive
let drive = (floor(trial / 8) - 2*floor(trial / 16))*1.8
alter VB3 = $&drive
let drive = (floor(trial / 16) - 2*floor(trial / 32))*1.8
alter VB4 = $&drive
let drive = (floor(trial / 32) - 2*floor(trial / 64))*1.8
alter VB5 = $&drive
let drive = (floor(trial / 64) - 2*floor(trial / 128))*1.8
alter VB6 = $&drive
let drive = (floor(trial / 128) - 2*floor(trial / 256))*1.8
alter VB7 = $&drive
stop when time = 0.001588
resume
delete all
let endpoint = length(time)-1
let cmp = v(COMP)[endpoint]
let top = v(TOP)[endpoint]
let decision = 0
if cmp >= 0.9
let code = trial
let decision = 1
end
echo 88 7 $&trial $&cmp $&top 0.40078125 $&decision >> decisions.csv
let trial = code + 64
let drive = (floor(trial / 1) - 2*floor(trial / 2))*1.8
alter VB0 = $&drive
let drive = (floor(trial / 2) - 2*floor(trial / 4))*1.8
alter VB1 = $&drive
let drive = (floor(trial / 4) - 2*floor(trial / 8))*1.8
alter VB2 = $&drive
let drive = (floor(trial / 8) - 2*floor(trial / 16))*1.8
alter VB3 = $&drive
let drive = (floor(trial / 16) - 2*floor(trial / 32))*1.8
alter VB4 = $&drive
let drive = (floor(trial / 32) - 2*floor(trial / 64))*1.8
alter VB5 = $&drive
let drive = (floor(trial / 64) - 2*floor(trial / 128))*1.8
alter VB6 = $&drive
let drive = (floor(trial / 128) - 2*floor(trial / 256))*1.8
alter VB7 = $&drive
stop when time = 0.00159
resume
delete all
let endpoint = length(time)-1
let cmp = v(COMP)[endpoint]
let top = v(TOP)[endpoint]
let decision = 0
if cmp >= 0.9
let code = trial
let decision = 1
end
echo 88 6 $&trial $&cmp $&top 0.40078125 $&decision >> decisions.csv
let trial = code + 32
let drive = (floor(trial / 1) - 2*floor(trial / 2))*1.8
alter VB0 = $&drive
let drive = (floor(trial / 2) - 2*floor(trial / 4))*1.8
alter VB1 = $&drive
let drive = (floor(trial / 4) - 2*floor(trial / 8))*1.8
alter VB2 = $&drive
let drive = (floor(trial / 8) - 2*floor(trial / 16))*1.8
alter VB3 = $&drive
let drive = (floor(trial / 16) - 2*floor(trial / 32))*1.8
alter VB4 = $&drive
let drive = (floor(trial / 32) - 2*floor(trial / 64))*1.8
alter VB5 = $&drive
let drive = (floor(trial / 64) - 2*floor(trial / 128))*1.8
alter VB6 = $&drive
let drive = (floor(trial / 128) - 2*floor(trial / 256))*1.8
alter VB7 = $&drive
stop when time = 0.001592
resume
delete all
let endpoint = length(time)-1
let cmp = v(COMP)[endpoint]
let top = v(TOP)[endpoint]
let decision = 0
if cmp >= 0.9
let code = trial
let decision = 1
end
echo 88 5 $&trial $&cmp $&top 0.40078125 $&decision >> decisions.csv
let trial = code + 16
let drive = (floor(trial / 1) - 2*floor(trial / 2))*1.8
alter VB0 = $&drive
let drive = (floor(trial / 2) - 2*floor(trial / 4))*1.8
alter VB1 = $&drive
let drive = (floor(trial / 4) - 2*floor(trial / 8))*1.8
alter VB2 = $&drive
let drive = (floor(trial / 8) - 2*floor(trial / 16))*1.8
alter VB3 = $&drive
let drive = (floor(trial / 16) - 2*floor(trial / 32))*1.8
alter VB4 = $&drive
let drive = (floor(trial / 32) - 2*floor(trial / 64))*1.8
alter VB5 = $&drive
let drive = (floor(trial / 64) - 2*floor(trial / 128))*1.8
alter VB6 = $&drive
let drive = (floor(trial / 128) - 2*floor(trial / 256))*1.8
alter VB7 = $&drive
stop when time = 0.001594
resume
delete all
let endpoint = length(time)-1
let cmp = v(COMP)[endpoint]
let top = v(TOP)[endpoint]
let decision = 0
if cmp >= 0.9
let code = trial
let decision = 1
end
echo 88 4 $&trial $&cmp $&top 0.40078125 $&decision >> decisions.csv
let trial = code + 8
let drive = (floor(trial / 1) - 2*floor(trial / 2))*1.8
alter VB0 = $&drive
let drive = (floor(trial / 2) - 2*floor(trial / 4))*1.8
alter VB1 = $&drive
let drive = (floor(trial / 4) - 2*floor(trial / 8))*1.8
alter VB2 = $&drive
let drive = (floor(trial / 8) - 2*floor(trial / 16))*1.8
alter VB3 = $&drive
let drive = (floor(trial / 16) - 2*floor(trial / 32))*1.8
alter VB4 = $&drive
let drive = (floor(trial / 32) - 2*floor(trial / 64))*1.8
alter VB5 = $&drive
let drive = (floor(trial / 64) - 2*floor(trial / 128))*1.8
alter VB6 = $&drive
let drive = (floor(trial / 128) - 2*floor(trial / 256))*1.8
alter VB7 = $&drive
stop when time = 0.001596
resume
delete all
let endpoint = length(time)-1
let cmp = v(COMP)[endpoint]
let top = v(TOP)[endpoint]
let decision = 0
if cmp >= 0.9
let code = trial
let decision = 1
end
echo 88 3 $&trial $&cmp $&top 0.40078125 $&decision >> decisions.csv
let trial = code + 4
let drive = (floor(trial / 1) - 2*floor(trial / 2))*1.8
alter VB0 = $&drive
let drive = (floor(trial / 2) - 2*floor(trial / 4))*1.8
alter VB1 = $&drive
let drive = (floor(trial / 4) - 2*floor(trial / 8))*1.8
alter VB2 = $&drive
let drive = (floor(trial / 8) - 2*floor(trial / 16))*1.8
alter VB3 = $&drive
let drive = (floor(trial / 16) - 2*floor(trial / 32))*1.8
alter VB4 = $&drive
let drive = (floor(trial / 32) - 2*floor(trial / 64))*1.8
alter VB5 = $&drive
let drive = (floor(trial / 64) - 2*floor(trial / 128))*1.8
alter VB6 = $&drive
let drive = (floor(trial / 128) - 2*floor(trial / 256))*1.8
alter VB7 = $&drive
stop when time = 0.001598
resume
delete all
let endpoint = length(time)-1
let cmp = v(COMP)[endpoint]
let top = v(TOP)[endpoint]
let decision = 0
if cmp >= 0.9
let code = trial
let decision = 1
end
echo 88 2 $&trial $&cmp $&top 0.40078125 $&decision >> decisions.csv
let trial = code + 2
let drive = (floor(trial / 1) - 2*floor(trial / 2))*1.8
alter VB0 = $&drive
let drive = (floor(trial / 2) - 2*floor(trial / 4))*1.8
alter VB1 = $&drive
let drive = (floor(trial / 4) - 2*floor(trial / 8))*1.8
alter VB2 = $&drive
let drive = (floor(trial / 8) - 2*floor(trial / 16))*1.8
alter VB3 = $&drive
let drive = (floor(trial / 16) - 2*floor(trial / 32))*1.8
alter VB4 = $&drive
let drive = (floor(trial / 32) - 2*floor(trial / 64))*1.8
alter VB5 = $&drive
let drive = (floor(trial / 64) - 2*floor(trial / 128))*1.8
alter VB6 = $&drive
let drive = (floor(trial / 128) - 2*floor(trial / 256))*1.8
alter VB7 = $&drive
stop when time = 0.0016
resume
delete all
let endpoint = length(time)-1
let cmp = v(COMP)[endpoint]
let top = v(TOP)[endpoint]
let decision = 0
if cmp >= 0.9
let code = trial
let decision = 1
end
echo 88 1 $&trial $&cmp $&top 0.40078125 $&decision >> decisions.csv
let trial = code + 1
let drive = (floor(trial / 1) - 2*floor(trial / 2))*1.8
alter VB0 = $&drive
let drive = (floor(trial / 2) - 2*floor(trial / 4))*1.8
alter VB1 = $&drive
let drive = (floor(trial / 4) - 2*floor(trial / 8))*1.8
alter VB2 = $&drive
let drive = (floor(trial / 8) - 2*floor(trial / 16))*1.8
alter VB3 = $&drive
let drive = (floor(trial / 16) - 2*floor(trial / 32))*1.8
alter VB4 = $&drive
let drive = (floor(trial / 32) - 2*floor(trial / 64))*1.8
alter VB5 = $&drive
let drive = (floor(trial / 64) - 2*floor(trial / 128))*1.8
alter VB6 = $&drive
let drive = (floor(trial / 128) - 2*floor(trial / 256))*1.8
alter VB7 = $&drive
stop when time = 0.001602
resume
delete all
let endpoint = length(time)-1
let cmp = v(COMP)[endpoint]
let top = v(TOP)[endpoint]
let decision = 0
if cmp >= 0.9
let code = trial
let decision = 1
end
echo 88 0 $&trial $&cmp $&top 0.40078125 $&decision >> decisions.csv
alter VIN = 0.40546875
alter VSAMPLE = 1.8
alter VB0 = 0
alter VB1 = 0
alter VB2 = 0
alter VB3 = 0
alter VB4 = 0
alter VB5 = 0
alter VB6 = 0
alter VB7 = 0
let code = 0
stop when time = 0.001604
resume
delete all
alter VSAMPLE = 0
let trial = code + 128
let drive = (floor(trial / 1) - 2*floor(trial / 2))*1.8
alter VB0 = $&drive
let drive = (floor(trial / 2) - 2*floor(trial / 4))*1.8
alter VB1 = $&drive
let drive = (floor(trial / 4) - 2*floor(trial / 8))*1.8
alter VB2 = $&drive
let drive = (floor(trial / 8) - 2*floor(trial / 16))*1.8
alter VB3 = $&drive
let drive = (floor(trial / 16) - 2*floor(trial / 32))*1.8
alter VB4 = $&drive
let drive = (floor(trial / 32) - 2*floor(trial / 64))*1.8
alter VB5 = $&drive
let drive = (floor(trial / 64) - 2*floor(trial / 128))*1.8
alter VB6 = $&drive
let drive = (floor(trial / 128) - 2*floor(trial / 256))*1.8
alter VB7 = $&drive
stop when time = 0.001606
resume
delete all
let endpoint = length(time)-1
let cmp = v(COMP)[endpoint]
let top = v(TOP)[endpoint]
let decision = 0
if cmp >= 0.9
let code = trial
let decision = 1
end
echo 89 7 $&trial $&cmp $&top 0.40546875 $&decision >> decisions.csv
let trial = code + 64
let drive = (floor(trial / 1) - 2*floor(trial / 2))*1.8
alter VB0 = $&drive
let drive = (floor(trial / 2) - 2*floor(trial / 4))*1.8
alter VB1 = $&drive
let drive = (floor(trial / 4) - 2*floor(trial / 8))*1.8
alter VB2 = $&drive
let drive = (floor(trial / 8) - 2*floor(trial / 16))*1.8
alter VB3 = $&drive
let drive = (floor(trial / 16) - 2*floor(trial / 32))*1.8
alter VB4 = $&drive
let drive = (floor(trial / 32) - 2*floor(trial / 64))*1.8
alter VB5 = $&drive
let drive = (floor(trial / 64) - 2*floor(trial / 128))*1.8
alter VB6 = $&drive
let drive = (floor(trial / 128) - 2*floor(trial / 256))*1.8
alter VB7 = $&drive
stop when time = 0.001608
resume
delete all
let endpoint = length(time)-1
let cmp = v(COMP)[endpoint]
let top = v(TOP)[endpoint]
let decision = 0
if cmp >= 0.9
let code = trial
let decision = 1
end
echo 89 6 $&trial $&cmp $&top 0.40546875 $&decision >> decisions.csv
let trial = code + 32
let drive = (floor(trial / 1) - 2*floor(trial / 2))*1.8
alter VB0 = $&drive
let drive = (floor(trial / 2) - 2*floor(trial / 4))*1.8
alter VB1 = $&drive
let drive = (floor(trial / 4) - 2*floor(trial / 8))*1.8
alter VB2 = $&drive
let drive = (floor(trial / 8) - 2*floor(trial / 16))*1.8
alter VB3 = $&drive
let drive = (floor(trial / 16) - 2*floor(trial / 32))*1.8
alter VB4 = $&drive
let drive = (floor(trial / 32) - 2*floor(trial / 64))*1.8
alter VB5 = $&drive
let drive = (floor(trial / 64) - 2*floor(trial / 128))*1.8
alter VB6 = $&drive
let drive = (floor(trial / 128) - 2*floor(trial / 256))*1.8
alter VB7 = $&drive
stop when time = 0.00161
resume
delete all
let endpoint = length(time)-1
let cmp = v(COMP)[endpoint]
let top = v(TOP)[endpoint]
let decision = 0
if cmp >= 0.9
let code = trial
let decision = 1
end
echo 89 5 $&trial $&cmp $&top 0.40546875 $&decision >> decisions.csv
let trial = code + 16
let drive = (floor(trial / 1) - 2*floor(trial / 2))*1.8
alter VB0 = $&drive
let drive = (floor(trial / 2) - 2*floor(trial / 4))*1.8
alter VB1 = $&drive
let drive = (floor(trial / 4) - 2*floor(trial / 8))*1.8
alter VB2 = $&drive
let drive = (floor(trial / 8) - 2*floor(trial / 16))*1.8
alter VB3 = $&drive
let drive = (floor(trial / 16) - 2*floor(trial / 32))*1.8
alter VB4 = $&drive
let drive = (floor(trial / 32) - 2*floor(trial / 64))*1.8
alter VB5 = $&drive
let drive = (floor(trial / 64) - 2*floor(trial / 128))*1.8
alter VB6 = $&drive
let drive = (floor(trial / 128) - 2*floor(trial / 256))*1.8
alter VB7 = $&drive
stop when time = 0.001612
resume
delete all
let endpoint = length(time)-1
let cmp = v(COMP)[endpoint]
let top = v(TOP)[endpoint]
let decision = 0
if cmp >= 0.9
let code = trial
let decision = 1
end
echo 89 4 $&trial $&cmp $&top 0.40546875 $&decision >> decisions.csv
let trial = code + 8
let drive = (floor(trial / 1) - 2*floor(trial / 2))*1.8
alter VB0 = $&drive
let drive = (floor(trial / 2) - 2*floor(trial / 4))*1.8
alter VB1 = $&drive
let drive = (floor(trial / 4) - 2*floor(trial / 8))*1.8
alter VB2 = $&drive
let drive = (floor(trial / 8) - 2*floor(trial / 16))*1.8
alter VB3 = $&drive
let drive = (floor(trial / 16) - 2*floor(trial / 32))*1.8
alter VB4 = $&drive
let drive = (floor(trial / 32) - 2*floor(trial / 64))*1.8
alter VB5 = $&drive
let drive = (floor(trial / 64) - 2*floor(trial / 128))*1.8
alter VB6 = $&drive
let drive = (floor(trial / 128) - 2*floor(trial / 256))*1.8
alter VB7 = $&drive
stop when time = 0.001614
resume
delete all
let endpoint = length(time)-1
let cmp = v(COMP)[endpoint]
let top = v(TOP)[endpoint]
let decision = 0
if cmp >= 0.9
let code = trial
let decision = 1
end
echo 89 3 $&trial $&cmp $&top 0.40546875 $&decision >> decisions.csv
let trial = code + 4
let drive = (floor(trial / 1) - 2*floor(trial / 2))*1.8
alter VB0 = $&drive
let drive = (floor(trial / 2) - 2*floor(trial / 4))*1.8
alter VB1 = $&drive
let drive = (floor(trial / 4) - 2*floor(trial / 8))*1.8
alter VB2 = $&drive
let drive = (floor(trial / 8) - 2*floor(trial / 16))*1.8
alter VB3 = $&drive
let drive = (floor(trial / 16) - 2*floor(trial / 32))*1.8
alter VB4 = $&drive
let drive = (floor(trial / 32) - 2*floor(trial / 64))*1.8
alter VB5 = $&drive
let drive = (floor(trial / 64) - 2*floor(trial / 128))*1.8
alter VB6 = $&drive
let drive = (floor(trial / 128) - 2*floor(trial / 256))*1.8
alter VB7 = $&drive
stop when time = 0.001616
resume
delete all
let endpoint = length(time)-1
let cmp = v(COMP)[endpoint]
let top = v(TOP)[endpoint]
let decision = 0
if cmp >= 0.9
let code = trial
let decision = 1
end
echo 89 2 $&trial $&cmp $&top 0.40546875 $&decision >> decisions.csv
let trial = code + 2
let drive = (floor(trial / 1) - 2*floor(trial / 2))*1.8
alter VB0 = $&drive
let drive = (floor(trial / 2) - 2*floor(trial / 4))*1.8
alter VB1 = $&drive
let drive = (floor(trial / 4) - 2*floor(trial / 8))*1.8
alter VB2 = $&drive
let drive = (floor(trial / 8) - 2*floor(trial / 16))*1.8
alter VB3 = $&drive
let drive = (floor(trial / 16) - 2*floor(trial / 32))*1.8
alter VB4 = $&drive
let drive = (floor(trial / 32) - 2*floor(trial / 64))*1.8
alter VB5 = $&drive
let drive = (floor(trial / 64) - 2*floor(trial / 128))*1.8
alter VB6 = $&drive
let drive = (floor(trial / 128) - 2*floor(trial / 256))*1.8
alter VB7 = $&drive
stop when time = 0.001618
resume
delete all
let endpoint = length(time)-1
let cmp = v(COMP)[endpoint]
let top = v(TOP)[endpoint]
let decision = 0
if cmp >= 0.9
let code = trial
let decision = 1
end
echo 89 1 $&trial $&cmp $&top 0.40546875 $&decision >> decisions.csv
let trial = code + 1
let drive = (floor(trial / 1) - 2*floor(trial / 2))*1.8
alter VB0 = $&drive
let drive = (floor(trial / 2) - 2*floor(trial / 4))*1.8
alter VB1 = $&drive
let drive = (floor(trial / 4) - 2*floor(trial / 8))*1.8
alter VB2 = $&drive
let drive = (floor(trial / 8) - 2*floor(trial / 16))*1.8
alter VB3 = $&drive
let drive = (floor(trial / 16) - 2*floor(trial / 32))*1.8
alter VB4 = $&drive
let drive = (floor(trial / 32) - 2*floor(trial / 64))*1.8
alter VB5 = $&drive
let drive = (floor(trial / 64) - 2*floor(trial / 128))*1.8
alter VB6 = $&drive
let drive = (floor(trial / 128) - 2*floor(trial / 256))*1.8
alter VB7 = $&drive
stop when time = 0.00162
resume
delete all
let endpoint = length(time)-1
let cmp = v(COMP)[endpoint]
let top = v(TOP)[endpoint]
let decision = 0
if cmp >= 0.9
let code = trial
let decision = 1
end
echo 89 0 $&trial $&cmp $&top 0.40546875 $&decision >> decisions.csv
alter VIN = 0.41015625
alter VSAMPLE = 1.8
alter VB0 = 0
alter VB1 = 0
alter VB2 = 0
alter VB3 = 0
alter VB4 = 0
alter VB5 = 0
alter VB6 = 0
alter VB7 = 0
let code = 0
stop when time = 0.001622
resume
delete all
alter VSAMPLE = 0
let trial = code + 128
let drive = (floor(trial / 1) - 2*floor(trial / 2))*1.8
alter VB0 = $&drive
let drive = (floor(trial / 2) - 2*floor(trial / 4))*1.8
alter VB1 = $&drive
let drive = (floor(trial / 4) - 2*floor(trial / 8))*1.8
alter VB2 = $&drive
let drive = (floor(trial / 8) - 2*floor(trial / 16))*1.8
alter VB3 = $&drive
let drive = (floor(trial / 16) - 2*floor(trial / 32))*1.8
alter VB4 = $&drive
let drive = (floor(trial / 32) - 2*floor(trial / 64))*1.8
alter VB5 = $&drive
let drive = (floor(trial / 64) - 2*floor(trial / 128))*1.8
alter VB6 = $&drive
let drive = (floor(trial / 128) - 2*floor(trial / 256))*1.8
alter VB7 = $&drive
stop when time = 0.001624
resume
delete all
let endpoint = length(time)-1
let cmp = v(COMP)[endpoint]
let top = v(TOP)[endpoint]
let decision = 0
if cmp >= 0.9
let code = trial
let decision = 1
end
echo 90 7 $&trial $&cmp $&top 0.41015625 $&decision >> decisions.csv
let trial = code + 64
let drive = (floor(trial / 1) - 2*floor(trial / 2))*1.8
alter VB0 = $&drive
let drive = (floor(trial / 2) - 2*floor(trial / 4))*1.8
alter VB1 = $&drive
let drive = (floor(trial / 4) - 2*floor(trial / 8))*1.8
alter VB2 = $&drive
let drive = (floor(trial / 8) - 2*floor(trial / 16))*1.8
alter VB3 = $&drive
let drive = (floor(trial / 16) - 2*floor(trial / 32))*1.8
alter VB4 = $&drive
let drive = (floor(trial / 32) - 2*floor(trial / 64))*1.8
alter VB5 = $&drive
let drive = (floor(trial / 64) - 2*floor(trial / 128))*1.8
alter VB6 = $&drive
let drive = (floor(trial / 128) - 2*floor(trial / 256))*1.8
alter VB7 = $&drive
stop when time = 0.001626
resume
delete all
let endpoint = length(time)-1
let cmp = v(COMP)[endpoint]
let top = v(TOP)[endpoint]
let decision = 0
if cmp >= 0.9
let code = trial
let decision = 1
end
echo 90 6 $&trial $&cmp $&top 0.41015625 $&decision >> decisions.csv
let trial = code + 32
let drive = (floor(trial / 1) - 2*floor(trial / 2))*1.8
alter VB0 = $&drive
let drive = (floor(trial / 2) - 2*floor(trial / 4))*1.8
alter VB1 = $&drive
let drive = (floor(trial / 4) - 2*floor(trial / 8))*1.8
alter VB2 = $&drive
let drive = (floor(trial / 8) - 2*floor(trial / 16))*1.8
alter VB3 = $&drive
let drive = (floor(trial / 16) - 2*floor(trial / 32))*1.8
alter VB4 = $&drive
let drive = (floor(trial / 32) - 2*floor(trial / 64))*1.8
alter VB5 = $&drive
let drive = (floor(trial / 64) - 2*floor(trial / 128))*1.8
alter VB6 = $&drive
let drive = (floor(trial / 128) - 2*floor(trial / 256))*1.8
alter VB7 = $&drive
stop when time = 0.001628
resume
delete all
let endpoint = length(time)-1
let cmp = v(COMP)[endpoint]
let top = v(TOP)[endpoint]
let decision = 0
if cmp >= 0.9
let code = trial
let decision = 1
end
echo 90 5 $&trial $&cmp $&top 0.41015625 $&decision >> decisions.csv
let trial = code + 16
let drive = (floor(trial / 1) - 2*floor(trial / 2))*1.8
alter VB0 = $&drive
let drive = (floor(trial / 2) - 2*floor(trial / 4))*1.8
alter VB1 = $&drive
let drive = (floor(trial / 4) - 2*floor(trial / 8))*1.8
alter VB2 = $&drive
let drive = (floor(trial / 8) - 2*floor(trial / 16))*1.8
alter VB3 = $&drive
let drive = (floor(trial / 16) - 2*floor(trial / 32))*1.8
alter VB4 = $&drive
let drive = (floor(trial / 32) - 2*floor(trial / 64))*1.8
alter VB5 = $&drive
let drive = (floor(trial / 64) - 2*floor(trial / 128))*1.8
alter VB6 = $&drive
let drive = (floor(trial / 128) - 2*floor(trial / 256))*1.8
alter VB7 = $&drive
stop when time = 0.00163
resume
delete all
let endpoint = length(time)-1
let cmp = v(COMP)[endpoint]
let top = v(TOP)[endpoint]
let decision = 0
if cmp >= 0.9
let code = trial
let decision = 1
end
echo 90 4 $&trial $&cmp $&top 0.41015625 $&decision >> decisions.csv
let trial = code + 8
let drive = (floor(trial / 1) - 2*floor(trial / 2))*1.8
alter VB0 = $&drive
let drive = (floor(trial / 2) - 2*floor(trial / 4))*1.8
alter VB1 = $&drive
let drive = (floor(trial / 4) - 2*floor(trial / 8))*1.8
alter VB2 = $&drive
let drive = (floor(trial / 8) - 2*floor(trial / 16))*1.8
alter VB3 = $&drive
let drive = (floor(trial / 16) - 2*floor(trial / 32))*1.8
alter VB4 = $&drive
let drive = (floor(trial / 32) - 2*floor(trial / 64))*1.8
alter VB5 = $&drive
let drive = (floor(trial / 64) - 2*floor(trial / 128))*1.8
alter VB6 = $&drive
let drive = (floor(trial / 128) - 2*floor(trial / 256))*1.8
alter VB7 = $&drive
stop when time = 0.001632
resume
delete all
let endpoint = length(time)-1
let cmp = v(COMP)[endpoint]
let top = v(TOP)[endpoint]
let decision = 0
if cmp >= 0.9
let code = trial
let decision = 1
end
echo 90 3 $&trial $&cmp $&top 0.41015625 $&decision >> decisions.csv
let trial = code + 4
let drive = (floor(trial / 1) - 2*floor(trial / 2))*1.8
alter VB0 = $&drive
let drive = (floor(trial / 2) - 2*floor(trial / 4))*1.8
alter VB1 = $&drive
let drive = (floor(trial / 4) - 2*floor(trial / 8))*1.8
alter VB2 = $&drive
let drive = (floor(trial / 8) - 2*floor(trial / 16))*1.8
alter VB3 = $&drive
let drive = (floor(trial / 16) - 2*floor(trial / 32))*1.8
alter VB4 = $&drive
let drive = (floor(trial / 32) - 2*floor(trial / 64))*1.8
alter VB5 = $&drive
let drive = (floor(trial / 64) - 2*floor(trial / 128))*1.8
alter VB6 = $&drive
let drive = (floor(trial / 128) - 2*floor(trial / 256))*1.8
alter VB7 = $&drive
stop when time = 0.001634
resume
delete all
let endpoint = length(time)-1
let cmp = v(COMP)[endpoint]
let top = v(TOP)[endpoint]
let decision = 0
if cmp >= 0.9
let code = trial
let decision = 1
end
echo 90 2 $&trial $&cmp $&top 0.41015625 $&decision >> decisions.csv
let trial = code + 2
let drive = (floor(trial / 1) - 2*floor(trial / 2))*1.8
alter VB0 = $&drive
let drive = (floor(trial / 2) - 2*floor(trial / 4))*1.8
alter VB1 = $&drive
let drive = (floor(trial / 4) - 2*floor(trial / 8))*1.8
alter VB2 = $&drive
let drive = (floor(trial / 8) - 2*floor(trial / 16))*1.8
alter VB3 = $&drive
let drive = (floor(trial / 16) - 2*floor(trial / 32))*1.8
alter VB4 = $&drive
let drive = (floor(trial / 32) - 2*floor(trial / 64))*1.8
alter VB5 = $&drive
let drive = (floor(trial / 64) - 2*floor(trial / 128))*1.8
alter VB6 = $&drive
let drive = (floor(trial / 128) - 2*floor(trial / 256))*1.8
alter VB7 = $&drive
stop when time = 0.001636
resume
delete all
let endpoint = length(time)-1
let cmp = v(COMP)[endpoint]
let top = v(TOP)[endpoint]
let decision = 0
if cmp >= 0.9
let code = trial
let decision = 1
end
echo 90 1 $&trial $&cmp $&top 0.41015625 $&decision >> decisions.csv
let trial = code + 1
let drive = (floor(trial / 1) - 2*floor(trial / 2))*1.8
alter VB0 = $&drive
let drive = (floor(trial / 2) - 2*floor(trial / 4))*1.8
alter VB1 = $&drive
let drive = (floor(trial / 4) - 2*floor(trial / 8))*1.8
alter VB2 = $&drive
let drive = (floor(trial / 8) - 2*floor(trial / 16))*1.8
alter VB3 = $&drive
let drive = (floor(trial / 16) - 2*floor(trial / 32))*1.8
alter VB4 = $&drive
let drive = (floor(trial / 32) - 2*floor(trial / 64))*1.8
alter VB5 = $&drive
let drive = (floor(trial / 64) - 2*floor(trial / 128))*1.8
alter VB6 = $&drive
let drive = (floor(trial / 128) - 2*floor(trial / 256))*1.8
alter VB7 = $&drive
stop when time = 0.001638
resume
delete all
let endpoint = length(time)-1
let cmp = v(COMP)[endpoint]
let top = v(TOP)[endpoint]
let decision = 0
if cmp >= 0.9
let code = trial
let decision = 1
end
echo 90 0 $&trial $&cmp $&top 0.41015625 $&decision >> decisions.csv
alter VIN = 0.41484375
alter VSAMPLE = 1.8
alter VB0 = 0
alter VB1 = 0
alter VB2 = 0
alter VB3 = 0
alter VB4 = 0
alter VB5 = 0
alter VB6 = 0
alter VB7 = 0
let code = 0
stop when time = 0.00164
resume
delete all
alter VSAMPLE = 0
let trial = code + 128
let drive = (floor(trial / 1) - 2*floor(trial / 2))*1.8
alter VB0 = $&drive
let drive = (floor(trial / 2) - 2*floor(trial / 4))*1.8
alter VB1 = $&drive
let drive = (floor(trial / 4) - 2*floor(trial / 8))*1.8
alter VB2 = $&drive
let drive = (floor(trial / 8) - 2*floor(trial / 16))*1.8
alter VB3 = $&drive
let drive = (floor(trial / 16) - 2*floor(trial / 32))*1.8
alter VB4 = $&drive
let drive = (floor(trial / 32) - 2*floor(trial / 64))*1.8
alter VB5 = $&drive
let drive = (floor(trial / 64) - 2*floor(trial / 128))*1.8
alter VB6 = $&drive
let drive = (floor(trial / 128) - 2*floor(trial / 256))*1.8
alter VB7 = $&drive
stop when time = 0.001642
resume
delete all
let endpoint = length(time)-1
let cmp = v(COMP)[endpoint]
let top = v(TOP)[endpoint]
let decision = 0
if cmp >= 0.9
let code = trial
let decision = 1
end
echo 91 7 $&trial $&cmp $&top 0.41484375 $&decision >> decisions.csv
let trial = code + 64
let drive = (floor(trial / 1) - 2*floor(trial / 2))*1.8
alter VB0 = $&drive
let drive = (floor(trial / 2) - 2*floor(trial / 4))*1.8
alter VB1 = $&drive
let drive = (floor(trial / 4) - 2*floor(trial / 8))*1.8
alter VB2 = $&drive
let drive = (floor(trial / 8) - 2*floor(trial / 16))*1.8
alter VB3 = $&drive
let drive = (floor(trial / 16) - 2*floor(trial / 32))*1.8
alter VB4 = $&drive
let drive = (floor(trial / 32) - 2*floor(trial / 64))*1.8
alter VB5 = $&drive
let drive = (floor(trial / 64) - 2*floor(trial / 128))*1.8
alter VB6 = $&drive
let drive = (floor(trial / 128) - 2*floor(trial / 256))*1.8
alter VB7 = $&drive
stop when time = 0.001644
resume
delete all
let endpoint = length(time)-1
let cmp = v(COMP)[endpoint]
let top = v(TOP)[endpoint]
let decision = 0
if cmp >= 0.9
let code = trial
let decision = 1
end
echo 91 6 $&trial $&cmp $&top 0.41484375 $&decision >> decisions.csv
let trial = code + 32
let drive = (floor(trial / 1) - 2*floor(trial / 2))*1.8
alter VB0 = $&drive
let drive = (floor(trial / 2) - 2*floor(trial / 4))*1.8
alter VB1 = $&drive
let drive = (floor(trial / 4) - 2*floor(trial / 8))*1.8
alter VB2 = $&drive
let drive = (floor(trial / 8) - 2*floor(trial / 16))*1.8
alter VB3 = $&drive
let drive = (floor(trial / 16) - 2*floor(trial / 32))*1.8
alter VB4 = $&drive
let drive = (floor(trial / 32) - 2*floor(trial / 64))*1.8
alter VB5 = $&drive
let drive = (floor(trial / 64) - 2*floor(trial / 128))*1.8
alter VB6 = $&drive
let drive = (floor(trial / 128) - 2*floor(trial / 256))*1.8
alter VB7 = $&drive
stop when time = 0.001646
resume
delete all
let endpoint = length(time)-1
let cmp = v(COMP)[endpoint]
let top = v(TOP)[endpoint]
let decision = 0
if cmp >= 0.9
let code = trial
let decision = 1
end
echo 91 5 $&trial $&cmp $&top 0.41484375 $&decision >> decisions.csv
let trial = code + 16
let drive = (floor(trial / 1) - 2*floor(trial / 2))*1.8
alter VB0 = $&drive
let drive = (floor(trial / 2) - 2*floor(trial / 4))*1.8
alter VB1 = $&drive
let drive = (floor(trial / 4) - 2*floor(trial / 8))*1.8
alter VB2 = $&drive
let drive = (floor(trial / 8) - 2*floor(trial / 16))*1.8
alter VB3 = $&drive
let drive = (floor(trial / 16) - 2*floor(trial / 32))*1.8
alter VB4 = $&drive
let drive = (floor(trial / 32) - 2*floor(trial / 64))*1.8
alter VB5 = $&drive
let drive = (floor(trial / 64) - 2*floor(trial / 128))*1.8
alter VB6 = $&drive
let drive = (floor(trial / 128) - 2*floor(trial / 256))*1.8
alter VB7 = $&drive
stop when time = 0.001648
resume
delete all
let endpoint = length(time)-1
let cmp = v(COMP)[endpoint]
let top = v(TOP)[endpoint]
let decision = 0
if cmp >= 0.9
let code = trial
let decision = 1
end
echo 91 4 $&trial $&cmp $&top 0.41484375 $&decision >> decisions.csv
let trial = code + 8
let drive = (floor(trial / 1) - 2*floor(trial / 2))*1.8
alter VB0 = $&drive
let drive = (floor(trial / 2) - 2*floor(trial / 4))*1.8
alter VB1 = $&drive
let drive = (floor(trial / 4) - 2*floor(trial / 8))*1.8
alter VB2 = $&drive
let drive = (floor(trial / 8) - 2*floor(trial / 16))*1.8
alter VB3 = $&drive
let drive = (floor(trial / 16) - 2*floor(trial / 32))*1.8
alter VB4 = $&drive
let drive = (floor(trial / 32) - 2*floor(trial / 64))*1.8
alter VB5 = $&drive
let drive = (floor(trial / 64) - 2*floor(trial / 128))*1.8
alter VB6 = $&drive
let drive = (floor(trial / 128) - 2*floor(trial / 256))*1.8
alter VB7 = $&drive
stop when time = 0.00165
resume
delete all
let endpoint = length(time)-1
let cmp = v(COMP)[endpoint]
let top = v(TOP)[endpoint]
let decision = 0
if cmp >= 0.9
let code = trial
let decision = 1
end
echo 91 3 $&trial $&cmp $&top 0.41484375 $&decision >> decisions.csv
let trial = code + 4
let drive = (floor(trial / 1) - 2*floor(trial / 2))*1.8
alter VB0 = $&drive
let drive = (floor(trial / 2) - 2*floor(trial / 4))*1.8
alter VB1 = $&drive
let drive = (floor(trial / 4) - 2*floor(trial / 8))*1.8
alter VB2 = $&drive
let drive = (floor(trial / 8) - 2*floor(trial / 16))*1.8
alter VB3 = $&drive
let drive = (floor(trial / 16) - 2*floor(trial / 32))*1.8
alter VB4 = $&drive
let drive = (floor(trial / 32) - 2*floor(trial / 64))*1.8
alter VB5 = $&drive
let drive = (floor(trial / 64) - 2*floor(trial / 128))*1.8
alter VB6 = $&drive
let drive = (floor(trial / 128) - 2*floor(trial / 256))*1.8
alter VB7 = $&drive
stop when time = 0.001652
resume
delete all
let endpoint = length(time)-1
let cmp = v(COMP)[endpoint]
let top = v(TOP)[endpoint]
let decision = 0
if cmp >= 0.9
let code = trial
let decision = 1
end
echo 91 2 $&trial $&cmp $&top 0.41484375 $&decision >> decisions.csv
let trial = code + 2
let drive = (floor(trial / 1) - 2*floor(trial / 2))*1.8
alter VB0 = $&drive
let drive = (floor(trial / 2) - 2*floor(trial / 4))*1.8
alter VB1 = $&drive
let drive = (floor(trial / 4) - 2*floor(trial / 8))*1.8
alter VB2 = $&drive
let drive = (floor(trial / 8) - 2*floor(trial / 16))*1.8
alter VB3 = $&drive
let drive = (floor(trial / 16) - 2*floor(trial / 32))*1.8
alter VB4 = $&drive
let drive = (floor(trial / 32) - 2*floor(trial / 64))*1.8
alter VB5 = $&drive
let drive = (floor(trial / 64) - 2*floor(trial / 128))*1.8
alter VB6 = $&drive
let drive = (floor(trial / 128) - 2*floor(trial / 256))*1.8
alter VB7 = $&drive
stop when time = 0.001654
resume
delete all
let endpoint = length(time)-1
let cmp = v(COMP)[endpoint]
let top = v(TOP)[endpoint]
let decision = 0
if cmp >= 0.9
let code = trial
let decision = 1
end
echo 91 1 $&trial $&cmp $&top 0.41484375 $&decision >> decisions.csv
let trial = code + 1
let drive = (floor(trial / 1) - 2*floor(trial / 2))*1.8
alter VB0 = $&drive
let drive = (floor(trial / 2) - 2*floor(trial / 4))*1.8
alter VB1 = $&drive
let drive = (floor(trial / 4) - 2*floor(trial / 8))*1.8
alter VB2 = $&drive
let drive = (floor(trial / 8) - 2*floor(trial / 16))*1.8
alter VB3 = $&drive
let drive = (floor(trial / 16) - 2*floor(trial / 32))*1.8
alter VB4 = $&drive
let drive = (floor(trial / 32) - 2*floor(trial / 64))*1.8
alter VB5 = $&drive
let drive = (floor(trial / 64) - 2*floor(trial / 128))*1.8
alter VB6 = $&drive
let drive = (floor(trial / 128) - 2*floor(trial / 256))*1.8
alter VB7 = $&drive
stop when time = 0.001656
resume
delete all
let endpoint = length(time)-1
let cmp = v(COMP)[endpoint]
let top = v(TOP)[endpoint]
let decision = 0
if cmp >= 0.9
let code = trial
let decision = 1
end
echo 91 0 $&trial $&cmp $&top 0.41484375 $&decision >> decisions.csv
alter VIN = 0.41953125
alter VSAMPLE = 1.8
alter VB0 = 0
alter VB1 = 0
alter VB2 = 0
alter VB3 = 0
alter VB4 = 0
alter VB5 = 0
alter VB6 = 0
alter VB7 = 0
let code = 0
stop when time = 0.001658
resume
delete all
alter VSAMPLE = 0
let trial = code + 128
let drive = (floor(trial / 1) - 2*floor(trial / 2))*1.8
alter VB0 = $&drive
let drive = (floor(trial / 2) - 2*floor(trial / 4))*1.8
alter VB1 = $&drive
let drive = (floor(trial / 4) - 2*floor(trial / 8))*1.8
alter VB2 = $&drive
let drive = (floor(trial / 8) - 2*floor(trial / 16))*1.8
alter VB3 = $&drive
let drive = (floor(trial / 16) - 2*floor(trial / 32))*1.8
alter VB4 = $&drive
let drive = (floor(trial / 32) - 2*floor(trial / 64))*1.8
alter VB5 = $&drive
let drive = (floor(trial / 64) - 2*floor(trial / 128))*1.8
alter VB6 = $&drive
let drive = (floor(trial / 128) - 2*floor(trial / 256))*1.8
alter VB7 = $&drive
stop when time = 0.00166
resume
delete all
let endpoint = length(time)-1
let cmp = v(COMP)[endpoint]
let top = v(TOP)[endpoint]
let decision = 0
if cmp >= 0.9
let code = trial
let decision = 1
end
echo 92 7 $&trial $&cmp $&top 0.41953125 $&decision >> decisions.csv
let trial = code + 64
let drive = (floor(trial / 1) - 2*floor(trial / 2))*1.8
alter VB0 = $&drive
let drive = (floor(trial / 2) - 2*floor(trial / 4))*1.8
alter VB1 = $&drive
let drive = (floor(trial / 4) - 2*floor(trial / 8))*1.8
alter VB2 = $&drive
let drive = (floor(trial / 8) - 2*floor(trial / 16))*1.8
alter VB3 = $&drive
let drive = (floor(trial / 16) - 2*floor(trial / 32))*1.8
alter VB4 = $&drive
let drive = (floor(trial / 32) - 2*floor(trial / 64))*1.8
alter VB5 = $&drive
let drive = (floor(trial / 64) - 2*floor(trial / 128))*1.8
alter VB6 = $&drive
let drive = (floor(trial / 128) - 2*floor(trial / 256))*1.8
alter VB7 = $&drive
stop when time = 0.001662
resume
delete all
let endpoint = length(time)-1
let cmp = v(COMP)[endpoint]
let top = v(TOP)[endpoint]
let decision = 0
if cmp >= 0.9
let code = trial
let decision = 1
end
echo 92 6 $&trial $&cmp $&top 0.41953125 $&decision >> decisions.csv
let trial = code + 32
let drive = (floor(trial / 1) - 2*floor(trial / 2))*1.8
alter VB0 = $&drive
let drive = (floor(trial / 2) - 2*floor(trial / 4))*1.8
alter VB1 = $&drive
let drive = (floor(trial / 4) - 2*floor(trial / 8))*1.8
alter VB2 = $&drive
let drive = (floor(trial / 8) - 2*floor(trial / 16))*1.8
alter VB3 = $&drive
let drive = (floor(trial / 16) - 2*floor(trial / 32))*1.8
alter VB4 = $&drive
let drive = (floor(trial / 32) - 2*floor(trial / 64))*1.8
alter VB5 = $&drive
let drive = (floor(trial / 64) - 2*floor(trial / 128))*1.8
alter VB6 = $&drive
let drive = (floor(trial / 128) - 2*floor(trial / 256))*1.8
alter VB7 = $&drive
stop when time = 0.001664
resume
delete all
let endpoint = length(time)-1
let cmp = v(COMP)[endpoint]
let top = v(TOP)[endpoint]
let decision = 0
if cmp >= 0.9
let code = trial
let decision = 1
end
echo 92 5 $&trial $&cmp $&top 0.41953125 $&decision >> decisions.csv
let trial = code + 16
let drive = (floor(trial / 1) - 2*floor(trial / 2))*1.8
alter VB0 = $&drive
let drive = (floor(trial / 2) - 2*floor(trial / 4))*1.8
alter VB1 = $&drive
let drive = (floor(trial / 4) - 2*floor(trial / 8))*1.8
alter VB2 = $&drive
let drive = (floor(trial / 8) - 2*floor(trial / 16))*1.8
alter VB3 = $&drive
let drive = (floor(trial / 16) - 2*floor(trial / 32))*1.8
alter VB4 = $&drive
let drive = (floor(trial / 32) - 2*floor(trial / 64))*1.8
alter VB5 = $&drive
let drive = (floor(trial / 64) - 2*floor(trial / 128))*1.8
alter VB6 = $&drive
let drive = (floor(trial / 128) - 2*floor(trial / 256))*1.8
alter VB7 = $&drive
stop when time = 0.001666
resume
delete all
let endpoint = length(time)-1
let cmp = v(COMP)[endpoint]
let top = v(TOP)[endpoint]
let decision = 0
if cmp >= 0.9
let code = trial
let decision = 1
end
echo 92 4 $&trial $&cmp $&top 0.41953125 $&decision >> decisions.csv
let trial = code + 8
let drive = (floor(trial / 1) - 2*floor(trial / 2))*1.8
alter VB0 = $&drive
let drive = (floor(trial / 2) - 2*floor(trial / 4))*1.8
alter VB1 = $&drive
let drive = (floor(trial / 4) - 2*floor(trial / 8))*1.8
alter VB2 = $&drive
let drive = (floor(trial / 8) - 2*floor(trial / 16))*1.8
alter VB3 = $&drive
let drive = (floor(trial / 16) - 2*floor(trial / 32))*1.8
alter VB4 = $&drive
let drive = (floor(trial / 32) - 2*floor(trial / 64))*1.8
alter VB5 = $&drive
let drive = (floor(trial / 64) - 2*floor(trial / 128))*1.8
alter VB6 = $&drive
let drive = (floor(trial / 128) - 2*floor(trial / 256))*1.8
alter VB7 = $&drive
stop when time = 0.001668
resume
delete all
let endpoint = length(time)-1
let cmp = v(COMP)[endpoint]
let top = v(TOP)[endpoint]
let decision = 0
if cmp >= 0.9
let code = trial
let decision = 1
end
echo 92 3 $&trial $&cmp $&top 0.41953125 $&decision >> decisions.csv
let trial = code + 4
let drive = (floor(trial / 1) - 2*floor(trial / 2))*1.8
alter VB0 = $&drive
let drive = (floor(trial / 2) - 2*floor(trial / 4))*1.8
alter VB1 = $&drive
let drive = (floor(trial / 4) - 2*floor(trial / 8))*1.8
alter VB2 = $&drive
let drive = (floor(trial / 8) - 2*floor(trial / 16))*1.8
alter VB3 = $&drive
let drive = (floor(trial / 16) - 2*floor(trial / 32))*1.8
alter VB4 = $&drive
let drive = (floor(trial / 32) - 2*floor(trial / 64))*1.8
alter VB5 = $&drive
let drive = (floor(trial / 64) - 2*floor(trial / 128))*1.8
alter VB6 = $&drive
let drive = (floor(trial / 128) - 2*floor(trial / 256))*1.8
alter VB7 = $&drive
stop when time = 0.00167
resume
delete all
let endpoint = length(time)-1
let cmp = v(COMP)[endpoint]
let top = v(TOP)[endpoint]
let decision = 0
if cmp >= 0.9
let code = trial
let decision = 1
end
echo 92 2 $&trial $&cmp $&top 0.41953125 $&decision >> decisions.csv
let trial = code + 2
let drive = (floor(trial / 1) - 2*floor(trial / 2))*1.8
alter VB0 = $&drive
let drive = (floor(trial / 2) - 2*floor(trial / 4))*1.8
alter VB1 = $&drive
let drive = (floor(trial / 4) - 2*floor(trial / 8))*1.8
alter VB2 = $&drive
let drive = (floor(trial / 8) - 2*floor(trial / 16))*1.8
alter VB3 = $&drive
let drive = (floor(trial / 16) - 2*floor(trial / 32))*1.8
alter VB4 = $&drive
let drive = (floor(trial / 32) - 2*floor(trial / 64))*1.8
alter VB5 = $&drive
let drive = (floor(trial / 64) - 2*floor(trial / 128))*1.8
alter VB6 = $&drive
let drive = (floor(trial / 128) - 2*floor(trial / 256))*1.8
alter VB7 = $&drive
stop when time = 0.001672
resume
delete all
let endpoint = length(time)-1
let cmp = v(COMP)[endpoint]
let top = v(TOP)[endpoint]
let decision = 0
if cmp >= 0.9
let code = trial
let decision = 1
end
echo 92 1 $&trial $&cmp $&top 0.41953125 $&decision >> decisions.csv
let trial = code + 1
let drive = (floor(trial / 1) - 2*floor(trial / 2))*1.8
alter VB0 = $&drive
let drive = (floor(trial / 2) - 2*floor(trial / 4))*1.8
alter VB1 = $&drive
let drive = (floor(trial / 4) - 2*floor(trial / 8))*1.8
alter VB2 = $&drive
let drive = (floor(trial / 8) - 2*floor(trial / 16))*1.8
alter VB3 = $&drive
let drive = (floor(trial / 16) - 2*floor(trial / 32))*1.8
alter VB4 = $&drive
let drive = (floor(trial / 32) - 2*floor(trial / 64))*1.8
alter VB5 = $&drive
let drive = (floor(trial / 64) - 2*floor(trial / 128))*1.8
alter VB6 = $&drive
let drive = (floor(trial / 128) - 2*floor(trial / 256))*1.8
alter VB7 = $&drive
stop when time = 0.001674
resume
delete all
let endpoint = length(time)-1
let cmp = v(COMP)[endpoint]
let top = v(TOP)[endpoint]
let decision = 0
if cmp >= 0.9
let code = trial
let decision = 1
end
echo 92 0 $&trial $&cmp $&top 0.41953125 $&decision >> decisions.csv
alter VIN = 0.42421875
alter VSAMPLE = 1.8
alter VB0 = 0
alter VB1 = 0
alter VB2 = 0
alter VB3 = 0
alter VB4 = 0
alter VB5 = 0
alter VB6 = 0
alter VB7 = 0
let code = 0
stop when time = 0.001676
resume
delete all
alter VSAMPLE = 0
let trial = code + 128
let drive = (floor(trial / 1) - 2*floor(trial / 2))*1.8
alter VB0 = $&drive
let drive = (floor(trial / 2) - 2*floor(trial / 4))*1.8
alter VB1 = $&drive
let drive = (floor(trial / 4) - 2*floor(trial / 8))*1.8
alter VB2 = $&drive
let drive = (floor(trial / 8) - 2*floor(trial / 16))*1.8
alter VB3 = $&drive
let drive = (floor(trial / 16) - 2*floor(trial / 32))*1.8
alter VB4 = $&drive
let drive = (floor(trial / 32) - 2*floor(trial / 64))*1.8
alter VB5 = $&drive
let drive = (floor(trial / 64) - 2*floor(trial / 128))*1.8
alter VB6 = $&drive
let drive = (floor(trial / 128) - 2*floor(trial / 256))*1.8
alter VB7 = $&drive
stop when time = 0.001678
resume
delete all
let endpoint = length(time)-1
let cmp = v(COMP)[endpoint]
let top = v(TOP)[endpoint]
let decision = 0
if cmp >= 0.9
let code = trial
let decision = 1
end
echo 93 7 $&trial $&cmp $&top 0.42421875 $&decision >> decisions.csv
let trial = code + 64
let drive = (floor(trial / 1) - 2*floor(trial / 2))*1.8
alter VB0 = $&drive
let drive = (floor(trial / 2) - 2*floor(trial / 4))*1.8
alter VB1 = $&drive
let drive = (floor(trial / 4) - 2*floor(trial / 8))*1.8
alter VB2 = $&drive
let drive = (floor(trial / 8) - 2*floor(trial / 16))*1.8
alter VB3 = $&drive
let drive = (floor(trial / 16) - 2*floor(trial / 32))*1.8
alter VB4 = $&drive
let drive = (floor(trial / 32) - 2*floor(trial / 64))*1.8
alter VB5 = $&drive
let drive = (floor(trial / 64) - 2*floor(trial / 128))*1.8
alter VB6 = $&drive
let drive = (floor(trial / 128) - 2*floor(trial / 256))*1.8
alter VB7 = $&drive
stop when time = 0.00168
resume
delete all
let endpoint = length(time)-1
let cmp = v(COMP)[endpoint]
let top = v(TOP)[endpoint]
let decision = 0
if cmp >= 0.9
let code = trial
let decision = 1
end
echo 93 6 $&trial $&cmp $&top 0.42421875 $&decision >> decisions.csv
let trial = code + 32
let drive = (floor(trial / 1) - 2*floor(trial / 2))*1.8
alter VB0 = $&drive
let drive = (floor(trial / 2) - 2*floor(trial / 4))*1.8
alter VB1 = $&drive
let drive = (floor(trial / 4) - 2*floor(trial / 8))*1.8
alter VB2 = $&drive
let drive = (floor(trial / 8) - 2*floor(trial / 16))*1.8
alter VB3 = $&drive
let drive = (floor(trial / 16) - 2*floor(trial / 32))*1.8
alter VB4 = $&drive
let drive = (floor(trial / 32) - 2*floor(trial / 64))*1.8
alter VB5 = $&drive
let drive = (floor(trial / 64) - 2*floor(trial / 128))*1.8
alter VB6 = $&drive
let drive = (floor(trial / 128) - 2*floor(trial / 256))*1.8
alter VB7 = $&drive
stop when time = 0.001682
resume
delete all
let endpoint = length(time)-1
let cmp = v(COMP)[endpoint]
let top = v(TOP)[endpoint]
let decision = 0
if cmp >= 0.9
let code = trial
let decision = 1
end
echo 93 5 $&trial $&cmp $&top 0.42421875 $&decision >> decisions.csv
let trial = code + 16
let drive = (floor(trial / 1) - 2*floor(trial / 2))*1.8
alter VB0 = $&drive
let drive = (floor(trial / 2) - 2*floor(trial / 4))*1.8
alter VB1 = $&drive
let drive = (floor(trial / 4) - 2*floor(trial / 8))*1.8
alter VB2 = $&drive
let drive = (floor(trial / 8) - 2*floor(trial / 16))*1.8
alter VB3 = $&drive
let drive = (floor(trial / 16) - 2*floor(trial / 32))*1.8
alter VB4 = $&drive
let drive = (floor(trial / 32) - 2*floor(trial / 64))*1.8
alter VB5 = $&drive
let drive = (floor(trial / 64) - 2*floor(trial / 128))*1.8
alter VB6 = $&drive
let drive = (floor(trial / 128) - 2*floor(trial / 256))*1.8
alter VB7 = $&drive
stop when time = 0.001684
resume
delete all
let endpoint = length(time)-1
let cmp = v(COMP)[endpoint]
let top = v(TOP)[endpoint]
let decision = 0
if cmp >= 0.9
let code = trial
let decision = 1
end
echo 93 4 $&trial $&cmp $&top 0.42421875 $&decision >> decisions.csv
let trial = code + 8
let drive = (floor(trial / 1) - 2*floor(trial / 2))*1.8
alter VB0 = $&drive
let drive = (floor(trial / 2) - 2*floor(trial / 4))*1.8
alter VB1 = $&drive
let drive = (floor(trial / 4) - 2*floor(trial / 8))*1.8
alter VB2 = $&drive
let drive = (floor(trial / 8) - 2*floor(trial / 16))*1.8
alter VB3 = $&drive
let drive = (floor(trial / 16) - 2*floor(trial / 32))*1.8
alter VB4 = $&drive
let drive = (floor(trial / 32) - 2*floor(trial / 64))*1.8
alter VB5 = $&drive
let drive = (floor(trial / 64) - 2*floor(trial / 128))*1.8
alter VB6 = $&drive
let drive = (floor(trial / 128) - 2*floor(trial / 256))*1.8
alter VB7 = $&drive
stop when time = 0.001686
resume
delete all
let endpoint = length(time)-1
let cmp = v(COMP)[endpoint]
let top = v(TOP)[endpoint]
let decision = 0
if cmp >= 0.9
let code = trial
let decision = 1
end
echo 93 3 $&trial $&cmp $&top 0.42421875 $&decision >> decisions.csv
let trial = code + 4
let drive = (floor(trial / 1) - 2*floor(trial / 2))*1.8
alter VB0 = $&drive
let drive = (floor(trial / 2) - 2*floor(trial / 4))*1.8
alter VB1 = $&drive
let drive = (floor(trial / 4) - 2*floor(trial / 8))*1.8
alter VB2 = $&drive
let drive = (floor(trial / 8) - 2*floor(trial / 16))*1.8
alter VB3 = $&drive
let drive = (floor(trial / 16) - 2*floor(trial / 32))*1.8
alter VB4 = $&drive
let drive = (floor(trial / 32) - 2*floor(trial / 64))*1.8
alter VB5 = $&drive
let drive = (floor(trial / 64) - 2*floor(trial / 128))*1.8
alter VB6 = $&drive
let drive = (floor(trial / 128) - 2*floor(trial / 256))*1.8
alter VB7 = $&drive
stop when time = 0.001688
resume
delete all
let endpoint = length(time)-1
let cmp = v(COMP)[endpoint]
let top = v(TOP)[endpoint]
let decision = 0
if cmp >= 0.9
let code = trial
let decision = 1
end
echo 93 2 $&trial $&cmp $&top 0.42421875 $&decision >> decisions.csv
let trial = code + 2
let drive = (floor(trial / 1) - 2*floor(trial / 2))*1.8
alter VB0 = $&drive
let drive = (floor(trial / 2) - 2*floor(trial / 4))*1.8
alter VB1 = $&drive
let drive = (floor(trial / 4) - 2*floor(trial / 8))*1.8
alter VB2 = $&drive
let drive = (floor(trial / 8) - 2*floor(trial / 16))*1.8
alter VB3 = $&drive
let drive = (floor(trial / 16) - 2*floor(trial / 32))*1.8
alter VB4 = $&drive
let drive = (floor(trial / 32) - 2*floor(trial / 64))*1.8
alter VB5 = $&drive
let drive = (floor(trial / 64) - 2*floor(trial / 128))*1.8
alter VB6 = $&drive
let drive = (floor(trial / 128) - 2*floor(trial / 256))*1.8
alter VB7 = $&drive
stop when time = 0.00169
resume
delete all
let endpoint = length(time)-1
let cmp = v(COMP)[endpoint]
let top = v(TOP)[endpoint]
let decision = 0
if cmp >= 0.9
let code = trial
let decision = 1
end
echo 93 1 $&trial $&cmp $&top 0.42421875 $&decision >> decisions.csv
let trial = code + 1
let drive = (floor(trial / 1) - 2*floor(trial / 2))*1.8
alter VB0 = $&drive
let drive = (floor(trial / 2) - 2*floor(trial / 4))*1.8
alter VB1 = $&drive
let drive = (floor(trial / 4) - 2*floor(trial / 8))*1.8
alter VB2 = $&drive
let drive = (floor(trial / 8) - 2*floor(trial / 16))*1.8
alter VB3 = $&drive
let drive = (floor(trial / 16) - 2*floor(trial / 32))*1.8
alter VB4 = $&drive
let drive = (floor(trial / 32) - 2*floor(trial / 64))*1.8
alter VB5 = $&drive
let drive = (floor(trial / 64) - 2*floor(trial / 128))*1.8
alter VB6 = $&drive
let drive = (floor(trial / 128) - 2*floor(trial / 256))*1.8
alter VB7 = $&drive
stop when time = 0.001692
resume
delete all
let endpoint = length(time)-1
let cmp = v(COMP)[endpoint]
let top = v(TOP)[endpoint]
let decision = 0
if cmp >= 0.9
let code = trial
let decision = 1
end
echo 93 0 $&trial $&cmp $&top 0.42421875 $&decision >> decisions.csv
alter VIN = 0.42890625
alter VSAMPLE = 1.8
alter VB0 = 0
alter VB1 = 0
alter VB2 = 0
alter VB3 = 0
alter VB4 = 0
alter VB5 = 0
alter VB6 = 0
alter VB7 = 0
let code = 0
stop when time = 0.001694
resume
delete all
alter VSAMPLE = 0
let trial = code + 128
let drive = (floor(trial / 1) - 2*floor(trial / 2))*1.8
alter VB0 = $&drive
let drive = (floor(trial / 2) - 2*floor(trial / 4))*1.8
alter VB1 = $&drive
let drive = (floor(trial / 4) - 2*floor(trial / 8))*1.8
alter VB2 = $&drive
let drive = (floor(trial / 8) - 2*floor(trial / 16))*1.8
alter VB3 = $&drive
let drive = (floor(trial / 16) - 2*floor(trial / 32))*1.8
alter VB4 = $&drive
let drive = (floor(trial / 32) - 2*floor(trial / 64))*1.8
alter VB5 = $&drive
let drive = (floor(trial / 64) - 2*floor(trial / 128))*1.8
alter VB6 = $&drive
let drive = (floor(trial / 128) - 2*floor(trial / 256))*1.8
alter VB7 = $&drive
stop when time = 0.001696
resume
delete all
let endpoint = length(time)-1
let cmp = v(COMP)[endpoint]
let top = v(TOP)[endpoint]
let decision = 0
if cmp >= 0.9
let code = trial
let decision = 1
end
echo 94 7 $&trial $&cmp $&top 0.42890625 $&decision >> decisions.csv
let trial = code + 64
let drive = (floor(trial / 1) - 2*floor(trial / 2))*1.8
alter VB0 = $&drive
let drive = (floor(trial / 2) - 2*floor(trial / 4))*1.8
alter VB1 = $&drive
let drive = (floor(trial / 4) - 2*floor(trial / 8))*1.8
alter VB2 = $&drive
let drive = (floor(trial / 8) - 2*floor(trial / 16))*1.8
alter VB3 = $&drive
let drive = (floor(trial / 16) - 2*floor(trial / 32))*1.8
alter VB4 = $&drive
let drive = (floor(trial / 32) - 2*floor(trial / 64))*1.8
alter VB5 = $&drive
let drive = (floor(trial / 64) - 2*floor(trial / 128))*1.8
alter VB6 = $&drive
let drive = (floor(trial / 128) - 2*floor(trial / 256))*1.8
alter VB7 = $&drive
stop when time = 0.001698
resume
delete all
let endpoint = length(time)-1
let cmp = v(COMP)[endpoint]
let top = v(TOP)[endpoint]
let decision = 0
if cmp >= 0.9
let code = trial
let decision = 1
end
echo 94 6 $&trial $&cmp $&top 0.42890625 $&decision >> decisions.csv
let trial = code + 32
let drive = (floor(trial / 1) - 2*floor(trial / 2))*1.8
alter VB0 = $&drive
let drive = (floor(trial / 2) - 2*floor(trial / 4))*1.8
alter VB1 = $&drive
let drive = (floor(trial / 4) - 2*floor(trial / 8))*1.8
alter VB2 = $&drive
let drive = (floor(trial / 8) - 2*floor(trial / 16))*1.8
alter VB3 = $&drive
let drive = (floor(trial / 16) - 2*floor(trial / 32))*1.8
alter VB4 = $&drive
let drive = (floor(trial / 32) - 2*floor(trial / 64))*1.8
alter VB5 = $&drive
let drive = (floor(trial / 64) - 2*floor(trial / 128))*1.8
alter VB6 = $&drive
let drive = (floor(trial / 128) - 2*floor(trial / 256))*1.8
alter VB7 = $&drive
stop when time = 0.0017
resume
delete all
let endpoint = length(time)-1
let cmp = v(COMP)[endpoint]
let top = v(TOP)[endpoint]
let decision = 0
if cmp >= 0.9
let code = trial
let decision = 1
end
echo 94 5 $&trial $&cmp $&top 0.42890625 $&decision >> decisions.csv
let trial = code + 16
let drive = (floor(trial / 1) - 2*floor(trial / 2))*1.8
alter VB0 = $&drive
let drive = (floor(trial / 2) - 2*floor(trial / 4))*1.8
alter VB1 = $&drive
let drive = (floor(trial / 4) - 2*floor(trial / 8))*1.8
alter VB2 = $&drive
let drive = (floor(trial / 8) - 2*floor(trial / 16))*1.8
alter VB3 = $&drive
let drive = (floor(trial / 16) - 2*floor(trial / 32))*1.8
alter VB4 = $&drive
let drive = (floor(trial / 32) - 2*floor(trial / 64))*1.8
alter VB5 = $&drive
let drive = (floor(trial / 64) - 2*floor(trial / 128))*1.8
alter VB6 = $&drive
let drive = (floor(trial / 128) - 2*floor(trial / 256))*1.8
alter VB7 = $&drive
stop when time = 0.001702
resume
delete all
let endpoint = length(time)-1
let cmp = v(COMP)[endpoint]
let top = v(TOP)[endpoint]
let decision = 0
if cmp >= 0.9
let code = trial
let decision = 1
end
echo 94 4 $&trial $&cmp $&top 0.42890625 $&decision >> decisions.csv
let trial = code + 8
let drive = (floor(trial / 1) - 2*floor(trial / 2))*1.8
alter VB0 = $&drive
let drive = (floor(trial / 2) - 2*floor(trial / 4))*1.8
alter VB1 = $&drive
let drive = (floor(trial / 4) - 2*floor(trial / 8))*1.8
alter VB2 = $&drive
let drive = (floor(trial / 8) - 2*floor(trial / 16))*1.8
alter VB3 = $&drive
let drive = (floor(trial / 16) - 2*floor(trial / 32))*1.8
alter VB4 = $&drive
let drive = (floor(trial / 32) - 2*floor(trial / 64))*1.8
alter VB5 = $&drive
let drive = (floor(trial / 64) - 2*floor(trial / 128))*1.8
alter VB6 = $&drive
let drive = (floor(trial / 128) - 2*floor(trial / 256))*1.8
alter VB7 = $&drive
stop when time = 0.001704
resume
delete all
let endpoint = length(time)-1
let cmp = v(COMP)[endpoint]
let top = v(TOP)[endpoint]
let decision = 0
if cmp >= 0.9
let code = trial
let decision = 1
end
echo 94 3 $&trial $&cmp $&top 0.42890625 $&decision >> decisions.csv
let trial = code + 4
let drive = (floor(trial / 1) - 2*floor(trial / 2))*1.8
alter VB0 = $&drive
let drive = (floor(trial / 2) - 2*floor(trial / 4))*1.8
alter VB1 = $&drive
let drive = (floor(trial / 4) - 2*floor(trial / 8))*1.8
alter VB2 = $&drive
let drive = (floor(trial / 8) - 2*floor(trial / 16))*1.8
alter VB3 = $&drive
let drive = (floor(trial / 16) - 2*floor(trial / 32))*1.8
alter VB4 = $&drive
let drive = (floor(trial / 32) - 2*floor(trial / 64))*1.8
alter VB5 = $&drive
let drive = (floor(trial / 64) - 2*floor(trial / 128))*1.8
alter VB6 = $&drive
let drive = (floor(trial / 128) - 2*floor(trial / 256))*1.8
alter VB7 = $&drive
stop when time = 0.001706
resume
delete all
let endpoint = length(time)-1
let cmp = v(COMP)[endpoint]
let top = v(TOP)[endpoint]
let decision = 0
if cmp >= 0.9
let code = trial
let decision = 1
end
echo 94 2 $&trial $&cmp $&top 0.42890625 $&decision >> decisions.csv
let trial = code + 2
let drive = (floor(trial / 1) - 2*floor(trial / 2))*1.8
alter VB0 = $&drive
let drive = (floor(trial / 2) - 2*floor(trial / 4))*1.8
alter VB1 = $&drive
let drive = (floor(trial / 4) - 2*floor(trial / 8))*1.8
alter VB2 = $&drive
let drive = (floor(trial / 8) - 2*floor(trial / 16))*1.8
alter VB3 = $&drive
let drive = (floor(trial / 16) - 2*floor(trial / 32))*1.8
alter VB4 = $&drive
let drive = (floor(trial / 32) - 2*floor(trial / 64))*1.8
alter VB5 = $&drive
let drive = (floor(trial / 64) - 2*floor(trial / 128))*1.8
alter VB6 = $&drive
let drive = (floor(trial / 128) - 2*floor(trial / 256))*1.8
alter VB7 = $&drive
stop when time = 0.001708
resume
delete all
let endpoint = length(time)-1
let cmp = v(COMP)[endpoint]
let top = v(TOP)[endpoint]
let decision = 0
if cmp >= 0.9
let code = trial
let decision = 1
end
echo 94 1 $&trial $&cmp $&top 0.42890625 $&decision >> decisions.csv
let trial = code + 1
let drive = (floor(trial / 1) - 2*floor(trial / 2))*1.8
alter VB0 = $&drive
let drive = (floor(trial / 2) - 2*floor(trial / 4))*1.8
alter VB1 = $&drive
let drive = (floor(trial / 4) - 2*floor(trial / 8))*1.8
alter VB2 = $&drive
let drive = (floor(trial / 8) - 2*floor(trial / 16))*1.8
alter VB3 = $&drive
let drive = (floor(trial / 16) - 2*floor(trial / 32))*1.8
alter VB4 = $&drive
let drive = (floor(trial / 32) - 2*floor(trial / 64))*1.8
alter VB5 = $&drive
let drive = (floor(trial / 64) - 2*floor(trial / 128))*1.8
alter VB6 = $&drive
let drive = (floor(trial / 128) - 2*floor(trial / 256))*1.8
alter VB7 = $&drive
stop when time = 0.00171
resume
delete all
let endpoint = length(time)-1
let cmp = v(COMP)[endpoint]
let top = v(TOP)[endpoint]
let decision = 0
if cmp >= 0.9
let code = trial
let decision = 1
end
echo 94 0 $&trial $&cmp $&top 0.42890625 $&decision >> decisions.csv
alter VIN = 0.43359375
alter VSAMPLE = 1.8
alter VB0 = 0
alter VB1 = 0
alter VB2 = 0
alter VB3 = 0
alter VB4 = 0
alter VB5 = 0
alter VB6 = 0
alter VB7 = 0
let code = 0
stop when time = 0.001712
resume
delete all
alter VSAMPLE = 0
let trial = code + 128
let drive = (floor(trial / 1) - 2*floor(trial / 2))*1.8
alter VB0 = $&drive
let drive = (floor(trial / 2) - 2*floor(trial / 4))*1.8
alter VB1 = $&drive
let drive = (floor(trial / 4) - 2*floor(trial / 8))*1.8
alter VB2 = $&drive
let drive = (floor(trial / 8) - 2*floor(trial / 16))*1.8
alter VB3 = $&drive
let drive = (floor(trial / 16) - 2*floor(trial / 32))*1.8
alter VB4 = $&drive
let drive = (floor(trial / 32) - 2*floor(trial / 64))*1.8
alter VB5 = $&drive
let drive = (floor(trial / 64) - 2*floor(trial / 128))*1.8
alter VB6 = $&drive
let drive = (floor(trial / 128) - 2*floor(trial / 256))*1.8
alter VB7 = $&drive
stop when time = 0.001714
resume
delete all
let endpoint = length(time)-1
let cmp = v(COMP)[endpoint]
let top = v(TOP)[endpoint]
let decision = 0
if cmp >= 0.9
let code = trial
let decision = 1
end
echo 95 7 $&trial $&cmp $&top 0.43359375 $&decision >> decisions.csv
let trial = code + 64
let drive = (floor(trial / 1) - 2*floor(trial / 2))*1.8
alter VB0 = $&drive
let drive = (floor(trial / 2) - 2*floor(trial / 4))*1.8
alter VB1 = $&drive
let drive = (floor(trial / 4) - 2*floor(trial / 8))*1.8
alter VB2 = $&drive
let drive = (floor(trial / 8) - 2*floor(trial / 16))*1.8
alter VB3 = $&drive
let drive = (floor(trial / 16) - 2*floor(trial / 32))*1.8
alter VB4 = $&drive
let drive = (floor(trial / 32) - 2*floor(trial / 64))*1.8
alter VB5 = $&drive
let drive = (floor(trial / 64) - 2*floor(trial / 128))*1.8
alter VB6 = $&drive
let drive = (floor(trial / 128) - 2*floor(trial / 256))*1.8
alter VB7 = $&drive
stop when time = 0.001716
resume
delete all
let endpoint = length(time)-1
let cmp = v(COMP)[endpoint]
let top = v(TOP)[endpoint]
let decision = 0
if cmp >= 0.9
let code = trial
let decision = 1
end
echo 95 6 $&trial $&cmp $&top 0.43359375 $&decision >> decisions.csv
let trial = code + 32
let drive = (floor(trial / 1) - 2*floor(trial / 2))*1.8
alter VB0 = $&drive
let drive = (floor(trial / 2) - 2*floor(trial / 4))*1.8
alter VB1 = $&drive
let drive = (floor(trial / 4) - 2*floor(trial / 8))*1.8
alter VB2 = $&drive
let drive = (floor(trial / 8) - 2*floor(trial / 16))*1.8
alter VB3 = $&drive
let drive = (floor(trial / 16) - 2*floor(trial / 32))*1.8
alter VB4 = $&drive
let drive = (floor(trial / 32) - 2*floor(trial / 64))*1.8
alter VB5 = $&drive
let drive = (floor(trial / 64) - 2*floor(trial / 128))*1.8
alter VB6 = $&drive
let drive = (floor(trial / 128) - 2*floor(trial / 256))*1.8
alter VB7 = $&drive
stop when time = 0.001718
resume
delete all
let endpoint = length(time)-1
let cmp = v(COMP)[endpoint]
let top = v(TOP)[endpoint]
let decision = 0
if cmp >= 0.9
let code = trial
let decision = 1
end
echo 95 5 $&trial $&cmp $&top 0.43359375 $&decision >> decisions.csv
let trial = code + 16
let drive = (floor(trial / 1) - 2*floor(trial / 2))*1.8
alter VB0 = $&drive
let drive = (floor(trial / 2) - 2*floor(trial / 4))*1.8
alter VB1 = $&drive
let drive = (floor(trial / 4) - 2*floor(trial / 8))*1.8
alter VB2 = $&drive
let drive = (floor(trial / 8) - 2*floor(trial / 16))*1.8
alter VB3 = $&drive
let drive = (floor(trial / 16) - 2*floor(trial / 32))*1.8
alter VB4 = $&drive
let drive = (floor(trial / 32) - 2*floor(trial / 64))*1.8
alter VB5 = $&drive
let drive = (floor(trial / 64) - 2*floor(trial / 128))*1.8
alter VB6 = $&drive
let drive = (floor(trial / 128) - 2*floor(trial / 256))*1.8
alter VB7 = $&drive
stop when time = 0.00172
resume
delete all
let endpoint = length(time)-1
let cmp = v(COMP)[endpoint]
let top = v(TOP)[endpoint]
let decision = 0
if cmp >= 0.9
let code = trial
let decision = 1
end
echo 95 4 $&trial $&cmp $&top 0.43359375 $&decision >> decisions.csv
let trial = code + 8
let drive = (floor(trial / 1) - 2*floor(trial / 2))*1.8
alter VB0 = $&drive
let drive = (floor(trial / 2) - 2*floor(trial / 4))*1.8
alter VB1 = $&drive
let drive = (floor(trial / 4) - 2*floor(trial / 8))*1.8
alter VB2 = $&drive
let drive = (floor(trial / 8) - 2*floor(trial / 16))*1.8
alter VB3 = $&drive
let drive = (floor(trial / 16) - 2*floor(trial / 32))*1.8
alter VB4 = $&drive
let drive = (floor(trial / 32) - 2*floor(trial / 64))*1.8
alter VB5 = $&drive
let drive = (floor(trial / 64) - 2*floor(trial / 128))*1.8
alter VB6 = $&drive
let drive = (floor(trial / 128) - 2*floor(trial / 256))*1.8
alter VB7 = $&drive
stop when time = 0.001722
resume
delete all
let endpoint = length(time)-1
let cmp = v(COMP)[endpoint]
let top = v(TOP)[endpoint]
let decision = 0
if cmp >= 0.9
let code = trial
let decision = 1
end
echo 95 3 $&trial $&cmp $&top 0.43359375 $&decision >> decisions.csv
let trial = code + 4
let drive = (floor(trial / 1) - 2*floor(trial / 2))*1.8
alter VB0 = $&drive
let drive = (floor(trial / 2) - 2*floor(trial / 4))*1.8
alter VB1 = $&drive
let drive = (floor(trial / 4) - 2*floor(trial / 8))*1.8
alter VB2 = $&drive
let drive = (floor(trial / 8) - 2*floor(trial / 16))*1.8
alter VB3 = $&drive
let drive = (floor(trial / 16) - 2*floor(trial / 32))*1.8
alter VB4 = $&drive
let drive = (floor(trial / 32) - 2*floor(trial / 64))*1.8
alter VB5 = $&drive
let drive = (floor(trial / 64) - 2*floor(trial / 128))*1.8
alter VB6 = $&drive
let drive = (floor(trial / 128) - 2*floor(trial / 256))*1.8
alter VB7 = $&drive
stop when time = 0.001724
resume
delete all
let endpoint = length(time)-1
let cmp = v(COMP)[endpoint]
let top = v(TOP)[endpoint]
let decision = 0
if cmp >= 0.9
let code = trial
let decision = 1
end
echo 95 2 $&trial $&cmp $&top 0.43359375 $&decision >> decisions.csv
let trial = code + 2
let drive = (floor(trial / 1) - 2*floor(trial / 2))*1.8
alter VB0 = $&drive
let drive = (floor(trial / 2) - 2*floor(trial / 4))*1.8
alter VB1 = $&drive
let drive = (floor(trial / 4) - 2*floor(trial / 8))*1.8
alter VB2 = $&drive
let drive = (floor(trial / 8) - 2*floor(trial / 16))*1.8
alter VB3 = $&drive
let drive = (floor(trial / 16) - 2*floor(trial / 32))*1.8
alter VB4 = $&drive
let drive = (floor(trial / 32) - 2*floor(trial / 64))*1.8
alter VB5 = $&drive
let drive = (floor(trial / 64) - 2*floor(trial / 128))*1.8
alter VB6 = $&drive
let drive = (floor(trial / 128) - 2*floor(trial / 256))*1.8
alter VB7 = $&drive
stop when time = 0.001726
resume
delete all
let endpoint = length(time)-1
let cmp = v(COMP)[endpoint]
let top = v(TOP)[endpoint]
let decision = 0
if cmp >= 0.9
let code = trial
let decision = 1
end
echo 95 1 $&trial $&cmp $&top 0.43359375 $&decision >> decisions.csv
let trial = code + 1
let drive = (floor(trial / 1) - 2*floor(trial / 2))*1.8
alter VB0 = $&drive
let drive = (floor(trial / 2) - 2*floor(trial / 4))*1.8
alter VB1 = $&drive
let drive = (floor(trial / 4) - 2*floor(trial / 8))*1.8
alter VB2 = $&drive
let drive = (floor(trial / 8) - 2*floor(trial / 16))*1.8
alter VB3 = $&drive
let drive = (floor(trial / 16) - 2*floor(trial / 32))*1.8
alter VB4 = $&drive
let drive = (floor(trial / 32) - 2*floor(trial / 64))*1.8
alter VB5 = $&drive
let drive = (floor(trial / 64) - 2*floor(trial / 128))*1.8
alter VB6 = $&drive
let drive = (floor(trial / 128) - 2*floor(trial / 256))*1.8
alter VB7 = $&drive
stop when time = 0.001728
resume
delete all
let endpoint = length(time)-1
let cmp = v(COMP)[endpoint]
let top = v(TOP)[endpoint]
let decision = 0
if cmp >= 0.9
let code = trial
let decision = 1
end
echo 95 0 $&trial $&cmp $&top 0.43359375 $&decision >> decisions.csv
alter VIN = 0.43828125
alter VSAMPLE = 1.8
alter VB0 = 0
alter VB1 = 0
alter VB2 = 0
alter VB3 = 0
alter VB4 = 0
alter VB5 = 0
alter VB6 = 0
alter VB7 = 0
let code = 0
stop when time = 0.00173
resume
delete all
alter VSAMPLE = 0
let trial = code + 128
let drive = (floor(trial / 1) - 2*floor(trial / 2))*1.8
alter VB0 = $&drive
let drive = (floor(trial / 2) - 2*floor(trial / 4))*1.8
alter VB1 = $&drive
let drive = (floor(trial / 4) - 2*floor(trial / 8))*1.8
alter VB2 = $&drive
let drive = (floor(trial / 8) - 2*floor(trial / 16))*1.8
alter VB3 = $&drive
let drive = (floor(trial / 16) - 2*floor(trial / 32))*1.8
alter VB4 = $&drive
let drive = (floor(trial / 32) - 2*floor(trial / 64))*1.8
alter VB5 = $&drive
let drive = (floor(trial / 64) - 2*floor(trial / 128))*1.8
alter VB6 = $&drive
let drive = (floor(trial / 128) - 2*floor(trial / 256))*1.8
alter VB7 = $&drive
stop when time = 0.001732
resume
delete all
let endpoint = length(time)-1
let cmp = v(COMP)[endpoint]
let top = v(TOP)[endpoint]
let decision = 0
if cmp >= 0.9
let code = trial
let decision = 1
end
echo 96 7 $&trial $&cmp $&top 0.43828125 $&decision >> decisions.csv
let trial = code + 64
let drive = (floor(trial / 1) - 2*floor(trial / 2))*1.8
alter VB0 = $&drive
let drive = (floor(trial / 2) - 2*floor(trial / 4))*1.8
alter VB1 = $&drive
let drive = (floor(trial / 4) - 2*floor(trial / 8))*1.8
alter VB2 = $&drive
let drive = (floor(trial / 8) - 2*floor(trial / 16))*1.8
alter VB3 = $&drive
let drive = (floor(trial / 16) - 2*floor(trial / 32))*1.8
alter VB4 = $&drive
let drive = (floor(trial / 32) - 2*floor(trial / 64))*1.8
alter VB5 = $&drive
let drive = (floor(trial / 64) - 2*floor(trial / 128))*1.8
alter VB6 = $&drive
let drive = (floor(trial / 128) - 2*floor(trial / 256))*1.8
alter VB7 = $&drive
stop when time = 0.001734
resume
delete all
let endpoint = length(time)-1
let cmp = v(COMP)[endpoint]
let top = v(TOP)[endpoint]
let decision = 0
if cmp >= 0.9
let code = trial
let decision = 1
end
echo 96 6 $&trial $&cmp $&top 0.43828125 $&decision >> decisions.csv
let trial = code + 32
let drive = (floor(trial / 1) - 2*floor(trial / 2))*1.8
alter VB0 = $&drive
let drive = (floor(trial / 2) - 2*floor(trial / 4))*1.8
alter VB1 = $&drive
let drive = (floor(trial / 4) - 2*floor(trial / 8))*1.8
alter VB2 = $&drive
let drive = (floor(trial / 8) - 2*floor(trial / 16))*1.8
alter VB3 = $&drive
let drive = (floor(trial / 16) - 2*floor(trial / 32))*1.8
alter VB4 = $&drive
let drive = (floor(trial / 32) - 2*floor(trial / 64))*1.8
alter VB5 = $&drive
let drive = (floor(trial / 64) - 2*floor(trial / 128))*1.8
alter VB6 = $&drive
let drive = (floor(trial / 128) - 2*floor(trial / 256))*1.8
alter VB7 = $&drive
stop when time = 0.001736
resume
delete all
let endpoint = length(time)-1
let cmp = v(COMP)[endpoint]
let top = v(TOP)[endpoint]
let decision = 0
if cmp >= 0.9
let code = trial
let decision = 1
end
echo 96 5 $&trial $&cmp $&top 0.43828125 $&decision >> decisions.csv
let trial = code + 16
let drive = (floor(trial / 1) - 2*floor(trial / 2))*1.8
alter VB0 = $&drive
let drive = (floor(trial / 2) - 2*floor(trial / 4))*1.8
alter VB1 = $&drive
let drive = (floor(trial / 4) - 2*floor(trial / 8))*1.8
alter VB2 = $&drive
let drive = (floor(trial / 8) - 2*floor(trial / 16))*1.8
alter VB3 = $&drive
let drive = (floor(trial / 16) - 2*floor(trial / 32))*1.8
alter VB4 = $&drive
let drive = (floor(trial / 32) - 2*floor(trial / 64))*1.8
alter VB5 = $&drive
let drive = (floor(trial / 64) - 2*floor(trial / 128))*1.8
alter VB6 = $&drive
let drive = (floor(trial / 128) - 2*floor(trial / 256))*1.8
alter VB7 = $&drive
stop when time = 0.001738
resume
delete all
let endpoint = length(time)-1
let cmp = v(COMP)[endpoint]
let top = v(TOP)[endpoint]
let decision = 0
if cmp >= 0.9
let code = trial
let decision = 1
end
echo 96 4 $&trial $&cmp $&top 0.43828125 $&decision >> decisions.csv
let trial = code + 8
let drive = (floor(trial / 1) - 2*floor(trial / 2))*1.8
alter VB0 = $&drive
let drive = (floor(trial / 2) - 2*floor(trial / 4))*1.8
alter VB1 = $&drive
let drive = (floor(trial / 4) - 2*floor(trial / 8))*1.8
alter VB2 = $&drive
let drive = (floor(trial / 8) - 2*floor(trial / 16))*1.8
alter VB3 = $&drive
let drive = (floor(trial / 16) - 2*floor(trial / 32))*1.8
alter VB4 = $&drive
let drive = (floor(trial / 32) - 2*floor(trial / 64))*1.8
alter VB5 = $&drive
let drive = (floor(trial / 64) - 2*floor(trial / 128))*1.8
alter VB6 = $&drive
let drive = (floor(trial / 128) - 2*floor(trial / 256))*1.8
alter VB7 = $&drive
stop when time = 0.00174
resume
delete all
let endpoint = length(time)-1
let cmp = v(COMP)[endpoint]
let top = v(TOP)[endpoint]
let decision = 0
if cmp >= 0.9
let code = trial
let decision = 1
end
echo 96 3 $&trial $&cmp $&top 0.43828125 $&decision >> decisions.csv
let trial = code + 4
let drive = (floor(trial / 1) - 2*floor(trial / 2))*1.8
alter VB0 = $&drive
let drive = (floor(trial / 2) - 2*floor(trial / 4))*1.8
alter VB1 = $&drive
let drive = (floor(trial / 4) - 2*floor(trial / 8))*1.8
alter VB2 = $&drive
let drive = (floor(trial / 8) - 2*floor(trial / 16))*1.8
alter VB3 = $&drive
let drive = (floor(trial / 16) - 2*floor(trial / 32))*1.8
alter VB4 = $&drive
let drive = (floor(trial / 32) - 2*floor(trial / 64))*1.8
alter VB5 = $&drive
let drive = (floor(trial / 64) - 2*floor(trial / 128))*1.8
alter VB6 = $&drive
let drive = (floor(trial / 128) - 2*floor(trial / 256))*1.8
alter VB7 = $&drive
stop when time = 0.001742
resume
delete all
let endpoint = length(time)-1
let cmp = v(COMP)[endpoint]
let top = v(TOP)[endpoint]
let decision = 0
if cmp >= 0.9
let code = trial
let decision = 1
end
echo 96 2 $&trial $&cmp $&top 0.43828125 $&decision >> decisions.csv
let trial = code + 2
let drive = (floor(trial / 1) - 2*floor(trial / 2))*1.8
alter VB0 = $&drive
let drive = (floor(trial / 2) - 2*floor(trial / 4))*1.8
alter VB1 = $&drive
let drive = (floor(trial / 4) - 2*floor(trial / 8))*1.8
alter VB2 = $&drive
let drive = (floor(trial / 8) - 2*floor(trial / 16))*1.8
alter VB3 = $&drive
let drive = (floor(trial / 16) - 2*floor(trial / 32))*1.8
alter VB4 = $&drive
let drive = (floor(trial / 32) - 2*floor(trial / 64))*1.8
alter VB5 = $&drive
let drive = (floor(trial / 64) - 2*floor(trial / 128))*1.8
alter VB6 = $&drive
let drive = (floor(trial / 128) - 2*floor(trial / 256))*1.8
alter VB7 = $&drive
stop when time = 0.001744
resume
delete all
let endpoint = length(time)-1
let cmp = v(COMP)[endpoint]
let top = v(TOP)[endpoint]
let decision = 0
if cmp >= 0.9
let code = trial
let decision = 1
end
echo 96 1 $&trial $&cmp $&top 0.43828125 $&decision >> decisions.csv
let trial = code + 1
let drive = (floor(trial / 1) - 2*floor(trial / 2))*1.8
alter VB0 = $&drive
let drive = (floor(trial / 2) - 2*floor(trial / 4))*1.8
alter VB1 = $&drive
let drive = (floor(trial / 4) - 2*floor(trial / 8))*1.8
alter VB2 = $&drive
let drive = (floor(trial / 8) - 2*floor(trial / 16))*1.8
alter VB3 = $&drive
let drive = (floor(trial / 16) - 2*floor(trial / 32))*1.8
alter VB4 = $&drive
let drive = (floor(trial / 32) - 2*floor(trial / 64))*1.8
alter VB5 = $&drive
let drive = (floor(trial / 64) - 2*floor(trial / 128))*1.8
alter VB6 = $&drive
let drive = (floor(trial / 128) - 2*floor(trial / 256))*1.8
alter VB7 = $&drive
stop when time = 0.001746
resume
delete all
let endpoint = length(time)-1
let cmp = v(COMP)[endpoint]
let top = v(TOP)[endpoint]
let decision = 0
if cmp >= 0.9
let code = trial
let decision = 1
end
echo 96 0 $&trial $&cmp $&top 0.43828125 $&decision >> decisions.csv
alter VIN = 0.44296875
alter VSAMPLE = 1.8
alter VB0 = 0
alter VB1 = 0
alter VB2 = 0
alter VB3 = 0
alter VB4 = 0
alter VB5 = 0
alter VB6 = 0
alter VB7 = 0
let code = 0
stop when time = 0.001748
resume
delete all
alter VSAMPLE = 0
let trial = code + 128
let drive = (floor(trial / 1) - 2*floor(trial / 2))*1.8
alter VB0 = $&drive
let drive = (floor(trial / 2) - 2*floor(trial / 4))*1.8
alter VB1 = $&drive
let drive = (floor(trial / 4) - 2*floor(trial / 8))*1.8
alter VB2 = $&drive
let drive = (floor(trial / 8) - 2*floor(trial / 16))*1.8
alter VB3 = $&drive
let drive = (floor(trial / 16) - 2*floor(trial / 32))*1.8
alter VB4 = $&drive
let drive = (floor(trial / 32) - 2*floor(trial / 64))*1.8
alter VB5 = $&drive
let drive = (floor(trial / 64) - 2*floor(trial / 128))*1.8
alter VB6 = $&drive
let drive = (floor(trial / 128) - 2*floor(trial / 256))*1.8
alter VB7 = $&drive
stop when time = 0.00175
resume
delete all
let endpoint = length(time)-1
let cmp = v(COMP)[endpoint]
let top = v(TOP)[endpoint]
let decision = 0
if cmp >= 0.9
let code = trial
let decision = 1
end
echo 97 7 $&trial $&cmp $&top 0.44296875 $&decision >> decisions.csv
let trial = code + 64
let drive = (floor(trial / 1) - 2*floor(trial / 2))*1.8
alter VB0 = $&drive
let drive = (floor(trial / 2) - 2*floor(trial / 4))*1.8
alter VB1 = $&drive
let drive = (floor(trial / 4) - 2*floor(trial / 8))*1.8
alter VB2 = $&drive
let drive = (floor(trial / 8) - 2*floor(trial / 16))*1.8
alter VB3 = $&drive
let drive = (floor(trial / 16) - 2*floor(trial / 32))*1.8
alter VB4 = $&drive
let drive = (floor(trial / 32) - 2*floor(trial / 64))*1.8
alter VB5 = $&drive
let drive = (floor(trial / 64) - 2*floor(trial / 128))*1.8
alter VB6 = $&drive
let drive = (floor(trial / 128) - 2*floor(trial / 256))*1.8
alter VB7 = $&drive
stop when time = 0.001752
resume
delete all
let endpoint = length(time)-1
let cmp = v(COMP)[endpoint]
let top = v(TOP)[endpoint]
let decision = 0
if cmp >= 0.9
let code = trial
let decision = 1
end
echo 97 6 $&trial $&cmp $&top 0.44296875 $&decision >> decisions.csv
let trial = code + 32
let drive = (floor(trial / 1) - 2*floor(trial / 2))*1.8
alter VB0 = $&drive
let drive = (floor(trial / 2) - 2*floor(trial / 4))*1.8
alter VB1 = $&drive
let drive = (floor(trial / 4) - 2*floor(trial / 8))*1.8
alter VB2 = $&drive
let drive = (floor(trial / 8) - 2*floor(trial / 16))*1.8
alter VB3 = $&drive
let drive = (floor(trial / 16) - 2*floor(trial / 32))*1.8
alter VB4 = $&drive
let drive = (floor(trial / 32) - 2*floor(trial / 64))*1.8
alter VB5 = $&drive
let drive = (floor(trial / 64) - 2*floor(trial / 128))*1.8
alter VB6 = $&drive
let drive = (floor(trial / 128) - 2*floor(trial / 256))*1.8
alter VB7 = $&drive
stop when time = 0.001754
resume
delete all
let endpoint = length(time)-1
let cmp = v(COMP)[endpoint]
let top = v(TOP)[endpoint]
let decision = 0
if cmp >= 0.9
let code = trial
let decision = 1
end
echo 97 5 $&trial $&cmp $&top 0.44296875 $&decision >> decisions.csv
let trial = code + 16
let drive = (floor(trial / 1) - 2*floor(trial / 2))*1.8
alter VB0 = $&drive
let drive = (floor(trial / 2) - 2*floor(trial / 4))*1.8
alter VB1 = $&drive
let drive = (floor(trial / 4) - 2*floor(trial / 8))*1.8
alter VB2 = $&drive
let drive = (floor(trial / 8) - 2*floor(trial / 16))*1.8
alter VB3 = $&drive
let drive = (floor(trial / 16) - 2*floor(trial / 32))*1.8
alter VB4 = $&drive
let drive = (floor(trial / 32) - 2*floor(trial / 64))*1.8
alter VB5 = $&drive
let drive = (floor(trial / 64) - 2*floor(trial / 128))*1.8
alter VB6 = $&drive
let drive = (floor(trial / 128) - 2*floor(trial / 256))*1.8
alter VB7 = $&drive
stop when time = 0.001756
resume
delete all
let endpoint = length(time)-1
let cmp = v(COMP)[endpoint]
let top = v(TOP)[endpoint]
let decision = 0
if cmp >= 0.9
let code = trial
let decision = 1
end
echo 97 4 $&trial $&cmp $&top 0.44296875 $&decision >> decisions.csv
let trial = code + 8
let drive = (floor(trial / 1) - 2*floor(trial / 2))*1.8
alter VB0 = $&drive
let drive = (floor(trial / 2) - 2*floor(trial / 4))*1.8
alter VB1 = $&drive
let drive = (floor(trial / 4) - 2*floor(trial / 8))*1.8
alter VB2 = $&drive
let drive = (floor(trial / 8) - 2*floor(trial / 16))*1.8
alter VB3 = $&drive
let drive = (floor(trial / 16) - 2*floor(trial / 32))*1.8
alter VB4 = $&drive
let drive = (floor(trial / 32) - 2*floor(trial / 64))*1.8
alter VB5 = $&drive
let drive = (floor(trial / 64) - 2*floor(trial / 128))*1.8
alter VB6 = $&drive
let drive = (floor(trial / 128) - 2*floor(trial / 256))*1.8
alter VB7 = $&drive
stop when time = 0.001758
resume
delete all
let endpoint = length(time)-1
let cmp = v(COMP)[endpoint]
let top = v(TOP)[endpoint]
let decision = 0
if cmp >= 0.9
let code = trial
let decision = 1
end
echo 97 3 $&trial $&cmp $&top 0.44296875 $&decision >> decisions.csv
let trial = code + 4
let drive = (floor(trial / 1) - 2*floor(trial / 2))*1.8
alter VB0 = $&drive
let drive = (floor(trial / 2) - 2*floor(trial / 4))*1.8
alter VB1 = $&drive
let drive = (floor(trial / 4) - 2*floor(trial / 8))*1.8
alter VB2 = $&drive
let drive = (floor(trial / 8) - 2*floor(trial / 16))*1.8
alter VB3 = $&drive
let drive = (floor(trial / 16) - 2*floor(trial / 32))*1.8
alter VB4 = $&drive
let drive = (floor(trial / 32) - 2*floor(trial / 64))*1.8
alter VB5 = $&drive
let drive = (floor(trial / 64) - 2*floor(trial / 128))*1.8
alter VB6 = $&drive
let drive = (floor(trial / 128) - 2*floor(trial / 256))*1.8
alter VB7 = $&drive
stop when time = 0.00176
resume
delete all
let endpoint = length(time)-1
let cmp = v(COMP)[endpoint]
let top = v(TOP)[endpoint]
let decision = 0
if cmp >= 0.9
let code = trial
let decision = 1
end
echo 97 2 $&trial $&cmp $&top 0.44296875 $&decision >> decisions.csv
let trial = code + 2
let drive = (floor(trial / 1) - 2*floor(trial / 2))*1.8
alter VB0 = $&drive
let drive = (floor(trial / 2) - 2*floor(trial / 4))*1.8
alter VB1 = $&drive
let drive = (floor(trial / 4) - 2*floor(trial / 8))*1.8
alter VB2 = $&drive
let drive = (floor(trial / 8) - 2*floor(trial / 16))*1.8
alter VB3 = $&drive
let drive = (floor(trial / 16) - 2*floor(trial / 32))*1.8
alter VB4 = $&drive
let drive = (floor(trial / 32) - 2*floor(trial / 64))*1.8
alter VB5 = $&drive
let drive = (floor(trial / 64) - 2*floor(trial / 128))*1.8
alter VB6 = $&drive
let drive = (floor(trial / 128) - 2*floor(trial / 256))*1.8
alter VB7 = $&drive
stop when time = 0.001762
resume
delete all
let endpoint = length(time)-1
let cmp = v(COMP)[endpoint]
let top = v(TOP)[endpoint]
let decision = 0
if cmp >= 0.9
let code = trial
let decision = 1
end
echo 97 1 $&trial $&cmp $&top 0.44296875 $&decision >> decisions.csv
let trial = code + 1
let drive = (floor(trial / 1) - 2*floor(trial / 2))*1.8
alter VB0 = $&drive
let drive = (floor(trial / 2) - 2*floor(trial / 4))*1.8
alter VB1 = $&drive
let drive = (floor(trial / 4) - 2*floor(trial / 8))*1.8
alter VB2 = $&drive
let drive = (floor(trial / 8) - 2*floor(trial / 16))*1.8
alter VB3 = $&drive
let drive = (floor(trial / 16) - 2*floor(trial / 32))*1.8
alter VB4 = $&drive
let drive = (floor(trial / 32) - 2*floor(trial / 64))*1.8
alter VB5 = $&drive
let drive = (floor(trial / 64) - 2*floor(trial / 128))*1.8
alter VB6 = $&drive
let drive = (floor(trial / 128) - 2*floor(trial / 256))*1.8
alter VB7 = $&drive
stop when time = 0.001764
resume
delete all
let endpoint = length(time)-1
let cmp = v(COMP)[endpoint]
let top = v(TOP)[endpoint]
let decision = 0
if cmp >= 0.9
let code = trial
let decision = 1
end
echo 97 0 $&trial $&cmp $&top 0.44296875 $&decision >> decisions.csv
alter VIN = 0.44765625
alter VSAMPLE = 1.8
alter VB0 = 0
alter VB1 = 0
alter VB2 = 0
alter VB3 = 0
alter VB4 = 0
alter VB5 = 0
alter VB6 = 0
alter VB7 = 0
let code = 0
stop when time = 0.001766
resume
delete all
alter VSAMPLE = 0
let trial = code + 128
let drive = (floor(trial / 1) - 2*floor(trial / 2))*1.8
alter VB0 = $&drive
let drive = (floor(trial / 2) - 2*floor(trial / 4))*1.8
alter VB1 = $&drive
let drive = (floor(trial / 4) - 2*floor(trial / 8))*1.8
alter VB2 = $&drive
let drive = (floor(trial / 8) - 2*floor(trial / 16))*1.8
alter VB3 = $&drive
let drive = (floor(trial / 16) - 2*floor(trial / 32))*1.8
alter VB4 = $&drive
let drive = (floor(trial / 32) - 2*floor(trial / 64))*1.8
alter VB5 = $&drive
let drive = (floor(trial / 64) - 2*floor(trial / 128))*1.8
alter VB6 = $&drive
let drive = (floor(trial / 128) - 2*floor(trial / 256))*1.8
alter VB7 = $&drive
stop when time = 0.001768
resume
delete all
let endpoint = length(time)-1
let cmp = v(COMP)[endpoint]
let top = v(TOP)[endpoint]
let decision = 0
if cmp >= 0.9
let code = trial
let decision = 1
end
echo 98 7 $&trial $&cmp $&top 0.44765625 $&decision >> decisions.csv
let trial = code + 64
let drive = (floor(trial / 1) - 2*floor(trial / 2))*1.8
alter VB0 = $&drive
let drive = (floor(trial / 2) - 2*floor(trial / 4))*1.8
alter VB1 = $&drive
let drive = (floor(trial / 4) - 2*floor(trial / 8))*1.8
alter VB2 = $&drive
let drive = (floor(trial / 8) - 2*floor(trial / 16))*1.8
alter VB3 = $&drive
let drive = (floor(trial / 16) - 2*floor(trial / 32))*1.8
alter VB4 = $&drive
let drive = (floor(trial / 32) - 2*floor(trial / 64))*1.8
alter VB5 = $&drive
let drive = (floor(trial / 64) - 2*floor(trial / 128))*1.8
alter VB6 = $&drive
let drive = (floor(trial / 128) - 2*floor(trial / 256))*1.8
alter VB7 = $&drive
stop when time = 0.00177
resume
delete all
let endpoint = length(time)-1
let cmp = v(COMP)[endpoint]
let top = v(TOP)[endpoint]
let decision = 0
if cmp >= 0.9
let code = trial
let decision = 1
end
echo 98 6 $&trial $&cmp $&top 0.44765625 $&decision >> decisions.csv
let trial = code + 32
let drive = (floor(trial / 1) - 2*floor(trial / 2))*1.8
alter VB0 = $&drive
let drive = (floor(trial / 2) - 2*floor(trial / 4))*1.8
alter VB1 = $&drive
let drive = (floor(trial / 4) - 2*floor(trial / 8))*1.8
alter VB2 = $&drive
let drive = (floor(trial / 8) - 2*floor(trial / 16))*1.8
alter VB3 = $&drive
let drive = (floor(trial / 16) - 2*floor(trial / 32))*1.8
alter VB4 = $&drive
let drive = (floor(trial / 32) - 2*floor(trial / 64))*1.8
alter VB5 = $&drive
let drive = (floor(trial / 64) - 2*floor(trial / 128))*1.8
alter VB6 = $&drive
let drive = (floor(trial / 128) - 2*floor(trial / 256))*1.8
alter VB7 = $&drive
stop when time = 0.001772
resume
delete all
let endpoint = length(time)-1
let cmp = v(COMP)[endpoint]
let top = v(TOP)[endpoint]
let decision = 0
if cmp >= 0.9
let code = trial
let decision = 1
end
echo 98 5 $&trial $&cmp $&top 0.44765625 $&decision >> decisions.csv
let trial = code + 16
let drive = (floor(trial / 1) - 2*floor(trial / 2))*1.8
alter VB0 = $&drive
let drive = (floor(trial / 2) - 2*floor(trial / 4))*1.8
alter VB1 = $&drive
let drive = (floor(trial / 4) - 2*floor(trial / 8))*1.8
alter VB2 = $&drive
let drive = (floor(trial / 8) - 2*floor(trial / 16))*1.8
alter VB3 = $&drive
let drive = (floor(trial / 16) - 2*floor(trial / 32))*1.8
alter VB4 = $&drive
let drive = (floor(trial / 32) - 2*floor(trial / 64))*1.8
alter VB5 = $&drive
let drive = (floor(trial / 64) - 2*floor(trial / 128))*1.8
alter VB6 = $&drive
let drive = (floor(trial / 128) - 2*floor(trial / 256))*1.8
alter VB7 = $&drive
stop when time = 0.001774
resume
delete all
let endpoint = length(time)-1
let cmp = v(COMP)[endpoint]
let top = v(TOP)[endpoint]
let decision = 0
if cmp >= 0.9
let code = trial
let decision = 1
end
echo 98 4 $&trial $&cmp $&top 0.44765625 $&decision >> decisions.csv
let trial = code + 8
let drive = (floor(trial / 1) - 2*floor(trial / 2))*1.8
alter VB0 = $&drive
let drive = (floor(trial / 2) - 2*floor(trial / 4))*1.8
alter VB1 = $&drive
let drive = (floor(trial / 4) - 2*floor(trial / 8))*1.8
alter VB2 = $&drive
let drive = (floor(trial / 8) - 2*floor(trial / 16))*1.8
alter VB3 = $&drive
let drive = (floor(trial / 16) - 2*floor(trial / 32))*1.8
alter VB4 = $&drive
let drive = (floor(trial / 32) - 2*floor(trial / 64))*1.8
alter VB5 = $&drive
let drive = (floor(trial / 64) - 2*floor(trial / 128))*1.8
alter VB6 = $&drive
let drive = (floor(trial / 128) - 2*floor(trial / 256))*1.8
alter VB7 = $&drive
stop when time = 0.001776
resume
delete all
let endpoint = length(time)-1
let cmp = v(COMP)[endpoint]
let top = v(TOP)[endpoint]
let decision = 0
if cmp >= 0.9
let code = trial
let decision = 1
end
echo 98 3 $&trial $&cmp $&top 0.44765625 $&decision >> decisions.csv
let trial = code + 4
let drive = (floor(trial / 1) - 2*floor(trial / 2))*1.8
alter VB0 = $&drive
let drive = (floor(trial / 2) - 2*floor(trial / 4))*1.8
alter VB1 = $&drive
let drive = (floor(trial / 4) - 2*floor(trial / 8))*1.8
alter VB2 = $&drive
let drive = (floor(trial / 8) - 2*floor(trial / 16))*1.8
alter VB3 = $&drive
let drive = (floor(trial / 16) - 2*floor(trial / 32))*1.8
alter VB4 = $&drive
let drive = (floor(trial / 32) - 2*floor(trial / 64))*1.8
alter VB5 = $&drive
let drive = (floor(trial / 64) - 2*floor(trial / 128))*1.8
alter VB6 = $&drive
let drive = (floor(trial / 128) - 2*floor(trial / 256))*1.8
alter VB7 = $&drive
stop when time = 0.001778
resume
delete all
let endpoint = length(time)-1
let cmp = v(COMP)[endpoint]
let top = v(TOP)[endpoint]
let decision = 0
if cmp >= 0.9
let code = trial
let decision = 1
end
echo 98 2 $&trial $&cmp $&top 0.44765625 $&decision >> decisions.csv
let trial = code + 2
let drive = (floor(trial / 1) - 2*floor(trial / 2))*1.8
alter VB0 = $&drive
let drive = (floor(trial / 2) - 2*floor(trial / 4))*1.8
alter VB1 = $&drive
let drive = (floor(trial / 4) - 2*floor(trial / 8))*1.8
alter VB2 = $&drive
let drive = (floor(trial / 8) - 2*floor(trial / 16))*1.8
alter VB3 = $&drive
let drive = (floor(trial / 16) - 2*floor(trial / 32))*1.8
alter VB4 = $&drive
let drive = (floor(trial / 32) - 2*floor(trial / 64))*1.8
alter VB5 = $&drive
let drive = (floor(trial / 64) - 2*floor(trial / 128))*1.8
alter VB6 = $&drive
let drive = (floor(trial / 128) - 2*floor(trial / 256))*1.8
alter VB7 = $&drive
stop when time = 0.00178
resume
delete all
let endpoint = length(time)-1
let cmp = v(COMP)[endpoint]
let top = v(TOP)[endpoint]
let decision = 0
if cmp >= 0.9
let code = trial
let decision = 1
end
echo 98 1 $&trial $&cmp $&top 0.44765625 $&decision >> decisions.csv
let trial = code + 1
let drive = (floor(trial / 1) - 2*floor(trial / 2))*1.8
alter VB0 = $&drive
let drive = (floor(trial / 2) - 2*floor(trial / 4))*1.8
alter VB1 = $&drive
let drive = (floor(trial / 4) - 2*floor(trial / 8))*1.8
alter VB2 = $&drive
let drive = (floor(trial / 8) - 2*floor(trial / 16))*1.8
alter VB3 = $&drive
let drive = (floor(trial / 16) - 2*floor(trial / 32))*1.8
alter VB4 = $&drive
let drive = (floor(trial / 32) - 2*floor(trial / 64))*1.8
alter VB5 = $&drive
let drive = (floor(trial / 64) - 2*floor(trial / 128))*1.8
alter VB6 = $&drive
let drive = (floor(trial / 128) - 2*floor(trial / 256))*1.8
alter VB7 = $&drive
stop when time = 0.001782
resume
delete all
let endpoint = length(time)-1
let cmp = v(COMP)[endpoint]
let top = v(TOP)[endpoint]
let decision = 0
if cmp >= 0.9
let code = trial
let decision = 1
end
echo 98 0 $&trial $&cmp $&top 0.44765625 $&decision >> decisions.csv
alter VIN = 0.45234375
alter VSAMPLE = 1.8
alter VB0 = 0
alter VB1 = 0
alter VB2 = 0
alter VB3 = 0
alter VB4 = 0
alter VB5 = 0
alter VB6 = 0
alter VB7 = 0
let code = 0
stop when time = 0.001784
resume
delete all
alter VSAMPLE = 0
let trial = code + 128
let drive = (floor(trial / 1) - 2*floor(trial / 2))*1.8
alter VB0 = $&drive
let drive = (floor(trial / 2) - 2*floor(trial / 4))*1.8
alter VB1 = $&drive
let drive = (floor(trial / 4) - 2*floor(trial / 8))*1.8
alter VB2 = $&drive
let drive = (floor(trial / 8) - 2*floor(trial / 16))*1.8
alter VB3 = $&drive
let drive = (floor(trial / 16) - 2*floor(trial / 32))*1.8
alter VB4 = $&drive
let drive = (floor(trial / 32) - 2*floor(trial / 64))*1.8
alter VB5 = $&drive
let drive = (floor(trial / 64) - 2*floor(trial / 128))*1.8
alter VB6 = $&drive
let drive = (floor(trial / 128) - 2*floor(trial / 256))*1.8
alter VB7 = $&drive
stop when time = 0.001786
resume
delete all
let endpoint = length(time)-1
let cmp = v(COMP)[endpoint]
let top = v(TOP)[endpoint]
let decision = 0
if cmp >= 0.9
let code = trial
let decision = 1
end
echo 99 7 $&trial $&cmp $&top 0.45234375 $&decision >> decisions.csv
let trial = code + 64
let drive = (floor(trial / 1) - 2*floor(trial / 2))*1.8
alter VB0 = $&drive
let drive = (floor(trial / 2) - 2*floor(trial / 4))*1.8
alter VB1 = $&drive
let drive = (floor(trial / 4) - 2*floor(trial / 8))*1.8
alter VB2 = $&drive
let drive = (floor(trial / 8) - 2*floor(trial / 16))*1.8
alter VB3 = $&drive
let drive = (floor(trial / 16) - 2*floor(trial / 32))*1.8
alter VB4 = $&drive
let drive = (floor(trial / 32) - 2*floor(trial / 64))*1.8
alter VB5 = $&drive
let drive = (floor(trial / 64) - 2*floor(trial / 128))*1.8
alter VB6 = $&drive
let drive = (floor(trial / 128) - 2*floor(trial / 256))*1.8
alter VB7 = $&drive
stop when time = 0.001788
resume
delete all
let endpoint = length(time)-1
let cmp = v(COMP)[endpoint]
let top = v(TOP)[endpoint]
let decision = 0
if cmp >= 0.9
let code = trial
let decision = 1
end
echo 99 6 $&trial $&cmp $&top 0.45234375 $&decision >> decisions.csv
let trial = code + 32
let drive = (floor(trial / 1) - 2*floor(trial / 2))*1.8
alter VB0 = $&drive
let drive = (floor(trial / 2) - 2*floor(trial / 4))*1.8
alter VB1 = $&drive
let drive = (floor(trial / 4) - 2*floor(trial / 8))*1.8
alter VB2 = $&drive
let drive = (floor(trial / 8) - 2*floor(trial / 16))*1.8
alter VB3 = $&drive
let drive = (floor(trial / 16) - 2*floor(trial / 32))*1.8
alter VB4 = $&drive
let drive = (floor(trial / 32) - 2*floor(trial / 64))*1.8
alter VB5 = $&drive
let drive = (floor(trial / 64) - 2*floor(trial / 128))*1.8
alter VB6 = $&drive
let drive = (floor(trial / 128) - 2*floor(trial / 256))*1.8
alter VB7 = $&drive
stop when time = 0.00179
resume
delete all
let endpoint = length(time)-1
let cmp = v(COMP)[endpoint]
let top = v(TOP)[endpoint]
let decision = 0
if cmp >= 0.9
let code = trial
let decision = 1
end
echo 99 5 $&trial $&cmp $&top 0.45234375 $&decision >> decisions.csv
let trial = code + 16
let drive = (floor(trial / 1) - 2*floor(trial / 2))*1.8
alter VB0 = $&drive
let drive = (floor(trial / 2) - 2*floor(trial / 4))*1.8
alter VB1 = $&drive
let drive = (floor(trial / 4) - 2*floor(trial / 8))*1.8
alter VB2 = $&drive
let drive = (floor(trial / 8) - 2*floor(trial / 16))*1.8
alter VB3 = $&drive
let drive = (floor(trial / 16) - 2*floor(trial / 32))*1.8
alter VB4 = $&drive
let drive = (floor(trial / 32) - 2*floor(trial / 64))*1.8
alter VB5 = $&drive
let drive = (floor(trial / 64) - 2*floor(trial / 128))*1.8
alter VB6 = $&drive
let drive = (floor(trial / 128) - 2*floor(trial / 256))*1.8
alter VB7 = $&drive
stop when time = 0.001792
resume
delete all
let endpoint = length(time)-1
let cmp = v(COMP)[endpoint]
let top = v(TOP)[endpoint]
let decision = 0
if cmp >= 0.9
let code = trial
let decision = 1
end
echo 99 4 $&trial $&cmp $&top 0.45234375 $&decision >> decisions.csv
let trial = code + 8
let drive = (floor(trial / 1) - 2*floor(trial / 2))*1.8
alter VB0 = $&drive
let drive = (floor(trial / 2) - 2*floor(trial / 4))*1.8
alter VB1 = $&drive
let drive = (floor(trial / 4) - 2*floor(trial / 8))*1.8
alter VB2 = $&drive
let drive = (floor(trial / 8) - 2*floor(trial / 16))*1.8
alter VB3 = $&drive
let drive = (floor(trial / 16) - 2*floor(trial / 32))*1.8
alter VB4 = $&drive
let drive = (floor(trial / 32) - 2*floor(trial / 64))*1.8
alter VB5 = $&drive
let drive = (floor(trial / 64) - 2*floor(trial / 128))*1.8
alter VB6 = $&drive
let drive = (floor(trial / 128) - 2*floor(trial / 256))*1.8
alter VB7 = $&drive
stop when time = 0.001794
resume
delete all
let endpoint = length(time)-1
let cmp = v(COMP)[endpoint]
let top = v(TOP)[endpoint]
let decision = 0
if cmp >= 0.9
let code = trial
let decision = 1
end
echo 99 3 $&trial $&cmp $&top 0.45234375 $&decision >> decisions.csv
let trial = code + 4
let drive = (floor(trial / 1) - 2*floor(trial / 2))*1.8
alter VB0 = $&drive
let drive = (floor(trial / 2) - 2*floor(trial / 4))*1.8
alter VB1 = $&drive
let drive = (floor(trial / 4) - 2*floor(trial / 8))*1.8
alter VB2 = $&drive
let drive = (floor(trial / 8) - 2*floor(trial / 16))*1.8
alter VB3 = $&drive
let drive = (floor(trial / 16) - 2*floor(trial / 32))*1.8
alter VB4 = $&drive
let drive = (floor(trial / 32) - 2*floor(trial / 64))*1.8
alter VB5 = $&drive
let drive = (floor(trial / 64) - 2*floor(trial / 128))*1.8
alter VB6 = $&drive
let drive = (floor(trial / 128) - 2*floor(trial / 256))*1.8
alter VB7 = $&drive
stop when time = 0.001796
resume
delete all
let endpoint = length(time)-1
let cmp = v(COMP)[endpoint]
let top = v(TOP)[endpoint]
let decision = 0
if cmp >= 0.9
let code = trial
let decision = 1
end
echo 99 2 $&trial $&cmp $&top 0.45234375 $&decision >> decisions.csv
let trial = code + 2
let drive = (floor(trial / 1) - 2*floor(trial / 2))*1.8
alter VB0 = $&drive
let drive = (floor(trial / 2) - 2*floor(trial / 4))*1.8
alter VB1 = $&drive
let drive = (floor(trial / 4) - 2*floor(trial / 8))*1.8
alter VB2 = $&drive
let drive = (floor(trial / 8) - 2*floor(trial / 16))*1.8
alter VB3 = $&drive
let drive = (floor(trial / 16) - 2*floor(trial / 32))*1.8
alter VB4 = $&drive
let drive = (floor(trial / 32) - 2*floor(trial / 64))*1.8
alter VB5 = $&drive
let drive = (floor(trial / 64) - 2*floor(trial / 128))*1.8
alter VB6 = $&drive
let drive = (floor(trial / 128) - 2*floor(trial / 256))*1.8
alter VB7 = $&drive
stop when time = 0.001798
resume
delete all
let endpoint = length(time)-1
let cmp = v(COMP)[endpoint]
let top = v(TOP)[endpoint]
let decision = 0
if cmp >= 0.9
let code = trial
let decision = 1
end
echo 99 1 $&trial $&cmp $&top 0.45234375 $&decision >> decisions.csv
let trial = code + 1
let drive = (floor(trial / 1) - 2*floor(trial / 2))*1.8
alter VB0 = $&drive
let drive = (floor(trial / 2) - 2*floor(trial / 4))*1.8
alter VB1 = $&drive
let drive = (floor(trial / 4) - 2*floor(trial / 8))*1.8
alter VB2 = $&drive
let drive = (floor(trial / 8) - 2*floor(trial / 16))*1.8
alter VB3 = $&drive
let drive = (floor(trial / 16) - 2*floor(trial / 32))*1.8
alter VB4 = $&drive
let drive = (floor(trial / 32) - 2*floor(trial / 64))*1.8
alter VB5 = $&drive
let drive = (floor(trial / 64) - 2*floor(trial / 128))*1.8
alter VB6 = $&drive
let drive = (floor(trial / 128) - 2*floor(trial / 256))*1.8
alter VB7 = $&drive
stop when time = 0.0018
resume
delete all
let endpoint = length(time)-1
let cmp = v(COMP)[endpoint]
let top = v(TOP)[endpoint]
let decision = 0
if cmp >= 0.9
let code = trial
let decision = 1
end
echo 99 0 $&trial $&cmp $&top 0.45234375 $&decision >> decisions.csv
alter VIN = 0.45703125
alter VSAMPLE = 1.8
alter VB0 = 0
alter VB1 = 0
alter VB2 = 0
alter VB3 = 0
alter VB4 = 0
alter VB5 = 0
alter VB6 = 0
alter VB7 = 0
let code = 0
stop when time = 0.001802
resume
delete all
alter VSAMPLE = 0
let trial = code + 128
let drive = (floor(trial / 1) - 2*floor(trial / 2))*1.8
alter VB0 = $&drive
let drive = (floor(trial / 2) - 2*floor(trial / 4))*1.8
alter VB1 = $&drive
let drive = (floor(trial / 4) - 2*floor(trial / 8))*1.8
alter VB2 = $&drive
let drive = (floor(trial / 8) - 2*floor(trial / 16))*1.8
alter VB3 = $&drive
let drive = (floor(trial / 16) - 2*floor(trial / 32))*1.8
alter VB4 = $&drive
let drive = (floor(trial / 32) - 2*floor(trial / 64))*1.8
alter VB5 = $&drive
let drive = (floor(trial / 64) - 2*floor(trial / 128))*1.8
alter VB6 = $&drive
let drive = (floor(trial / 128) - 2*floor(trial / 256))*1.8
alter VB7 = $&drive
stop when time = 0.001804
resume
delete all
let endpoint = length(time)-1
let cmp = v(COMP)[endpoint]
let top = v(TOP)[endpoint]
let decision = 0
if cmp >= 0.9
let code = trial
let decision = 1
end
echo 100 7 $&trial $&cmp $&top 0.45703125 $&decision >> decisions.csv
let trial = code + 64
let drive = (floor(trial / 1) - 2*floor(trial / 2))*1.8
alter VB0 = $&drive
let drive = (floor(trial / 2) - 2*floor(trial / 4))*1.8
alter VB1 = $&drive
let drive = (floor(trial / 4) - 2*floor(trial / 8))*1.8
alter VB2 = $&drive
let drive = (floor(trial / 8) - 2*floor(trial / 16))*1.8
alter VB3 = $&drive
let drive = (floor(trial / 16) - 2*floor(trial / 32))*1.8
alter VB4 = $&drive
let drive = (floor(trial / 32) - 2*floor(trial / 64))*1.8
alter VB5 = $&drive
let drive = (floor(trial / 64) - 2*floor(trial / 128))*1.8
alter VB6 = $&drive
let drive = (floor(trial / 128) - 2*floor(trial / 256))*1.8
alter VB7 = $&drive
stop when time = 0.001806
resume
delete all
let endpoint = length(time)-1
let cmp = v(COMP)[endpoint]
let top = v(TOP)[endpoint]
let decision = 0
if cmp >= 0.9
let code = trial
let decision = 1
end
echo 100 6 $&trial $&cmp $&top 0.45703125 $&decision >> decisions.csv
let trial = code + 32
let drive = (floor(trial / 1) - 2*floor(trial / 2))*1.8
alter VB0 = $&drive
let drive = (floor(trial / 2) - 2*floor(trial / 4))*1.8
alter VB1 = $&drive
let drive = (floor(trial / 4) - 2*floor(trial / 8))*1.8
alter VB2 = $&drive
let drive = (floor(trial / 8) - 2*floor(trial / 16))*1.8
alter VB3 = $&drive
let drive = (floor(trial / 16) - 2*floor(trial / 32))*1.8
alter VB4 = $&drive
let drive = (floor(trial / 32) - 2*floor(trial / 64))*1.8
alter VB5 = $&drive
let drive = (floor(trial / 64) - 2*floor(trial / 128))*1.8
alter VB6 = $&drive
let drive = (floor(trial / 128) - 2*floor(trial / 256))*1.8
alter VB7 = $&drive
stop when time = 0.001808
resume
delete all
let endpoint = length(time)-1
let cmp = v(COMP)[endpoint]
let top = v(TOP)[endpoint]
let decision = 0
if cmp >= 0.9
let code = trial
let decision = 1
end
echo 100 5 $&trial $&cmp $&top 0.45703125 $&decision >> decisions.csv
let trial = code + 16
let drive = (floor(trial / 1) - 2*floor(trial / 2))*1.8
alter VB0 = $&drive
let drive = (floor(trial / 2) - 2*floor(trial / 4))*1.8
alter VB1 = $&drive
let drive = (floor(trial / 4) - 2*floor(trial / 8))*1.8
alter VB2 = $&drive
let drive = (floor(trial / 8) - 2*floor(trial / 16))*1.8
alter VB3 = $&drive
let drive = (floor(trial / 16) - 2*floor(trial / 32))*1.8
alter VB4 = $&drive
let drive = (floor(trial / 32) - 2*floor(trial / 64))*1.8
alter VB5 = $&drive
let drive = (floor(trial / 64) - 2*floor(trial / 128))*1.8
alter VB6 = $&drive
let drive = (floor(trial / 128) - 2*floor(trial / 256))*1.8
alter VB7 = $&drive
stop when time = 0.00181
resume
delete all
let endpoint = length(time)-1
let cmp = v(COMP)[endpoint]
let top = v(TOP)[endpoint]
let decision = 0
if cmp >= 0.9
let code = trial
let decision = 1
end
echo 100 4 $&trial $&cmp $&top 0.45703125 $&decision >> decisions.csv
let trial = code + 8
let drive = (floor(trial / 1) - 2*floor(trial / 2))*1.8
alter VB0 = $&drive
let drive = (floor(trial / 2) - 2*floor(trial / 4))*1.8
alter VB1 = $&drive
let drive = (floor(trial / 4) - 2*floor(trial / 8))*1.8
alter VB2 = $&drive
let drive = (floor(trial / 8) - 2*floor(trial / 16))*1.8
alter VB3 = $&drive
let drive = (floor(trial / 16) - 2*floor(trial / 32))*1.8
alter VB4 = $&drive
let drive = (floor(trial / 32) - 2*floor(trial / 64))*1.8
alter VB5 = $&drive
let drive = (floor(trial / 64) - 2*floor(trial / 128))*1.8
alter VB6 = $&drive
let drive = (floor(trial / 128) - 2*floor(trial / 256))*1.8
alter VB7 = $&drive
stop when time = 0.001812
resume
delete all
let endpoint = length(time)-1
let cmp = v(COMP)[endpoint]
let top = v(TOP)[endpoint]
let decision = 0
if cmp >= 0.9
let code = trial
let decision = 1
end
echo 100 3 $&trial $&cmp $&top 0.45703125 $&decision >> decisions.csv
let trial = code + 4
let drive = (floor(trial / 1) - 2*floor(trial / 2))*1.8
alter VB0 = $&drive
let drive = (floor(trial / 2) - 2*floor(trial / 4))*1.8
alter VB1 = $&drive
let drive = (floor(trial / 4) - 2*floor(trial / 8))*1.8
alter VB2 = $&drive
let drive = (floor(trial / 8) - 2*floor(trial / 16))*1.8
alter VB3 = $&drive
let drive = (floor(trial / 16) - 2*floor(trial / 32))*1.8
alter VB4 = $&drive
let drive = (floor(trial / 32) - 2*floor(trial / 64))*1.8
alter VB5 = $&drive
let drive = (floor(trial / 64) - 2*floor(trial / 128))*1.8
alter VB6 = $&drive
let drive = (floor(trial / 128) - 2*floor(trial / 256))*1.8
alter VB7 = $&drive
stop when time = 0.001814
resume
delete all
let endpoint = length(time)-1
let cmp = v(COMP)[endpoint]
let top = v(TOP)[endpoint]
let decision = 0
if cmp >= 0.9
let code = trial
let decision = 1
end
echo 100 2 $&trial $&cmp $&top 0.45703125 $&decision >> decisions.csv
let trial = code + 2
let drive = (floor(trial / 1) - 2*floor(trial / 2))*1.8
alter VB0 = $&drive
let drive = (floor(trial / 2) - 2*floor(trial / 4))*1.8
alter VB1 = $&drive
let drive = (floor(trial / 4) - 2*floor(trial / 8))*1.8
alter VB2 = $&drive
let drive = (floor(trial / 8) - 2*floor(trial / 16))*1.8
alter VB3 = $&drive
let drive = (floor(trial / 16) - 2*floor(trial / 32))*1.8
alter VB4 = $&drive
let drive = (floor(trial / 32) - 2*floor(trial / 64))*1.8
alter VB5 = $&drive
let drive = (floor(trial / 64) - 2*floor(trial / 128))*1.8
alter VB6 = $&drive
let drive = (floor(trial / 128) - 2*floor(trial / 256))*1.8
alter VB7 = $&drive
stop when time = 0.001816
resume
delete all
let endpoint = length(time)-1
let cmp = v(COMP)[endpoint]
let top = v(TOP)[endpoint]
let decision = 0
if cmp >= 0.9
let code = trial
let decision = 1
end
echo 100 1 $&trial $&cmp $&top 0.45703125 $&decision >> decisions.csv
let trial = code + 1
let drive = (floor(trial / 1) - 2*floor(trial / 2))*1.8
alter VB0 = $&drive
let drive = (floor(trial / 2) - 2*floor(trial / 4))*1.8
alter VB1 = $&drive
let drive = (floor(trial / 4) - 2*floor(trial / 8))*1.8
alter VB2 = $&drive
let drive = (floor(trial / 8) - 2*floor(trial / 16))*1.8
alter VB3 = $&drive
let drive = (floor(trial / 16) - 2*floor(trial / 32))*1.8
alter VB4 = $&drive
let drive = (floor(trial / 32) - 2*floor(trial / 64))*1.8
alter VB5 = $&drive
let drive = (floor(trial / 64) - 2*floor(trial / 128))*1.8
alter VB6 = $&drive
let drive = (floor(trial / 128) - 2*floor(trial / 256))*1.8
alter VB7 = $&drive
stop when time = 0.001818
resume
delete all
let endpoint = length(time)-1
let cmp = v(COMP)[endpoint]
let top = v(TOP)[endpoint]
let decision = 0
if cmp >= 0.9
let code = trial
let decision = 1
end
echo 100 0 $&trial $&cmp $&top 0.45703125 $&decision >> decisions.csv
alter VIN = 0.46171875
alter VSAMPLE = 1.8
alter VB0 = 0
alter VB1 = 0
alter VB2 = 0
alter VB3 = 0
alter VB4 = 0
alter VB5 = 0
alter VB6 = 0
alter VB7 = 0
let code = 0
stop when time = 0.00182
resume
delete all
alter VSAMPLE = 0
let trial = code + 128
let drive = (floor(trial / 1) - 2*floor(trial / 2))*1.8
alter VB0 = $&drive
let drive = (floor(trial / 2) - 2*floor(trial / 4))*1.8
alter VB1 = $&drive
let drive = (floor(trial / 4) - 2*floor(trial / 8))*1.8
alter VB2 = $&drive
let drive = (floor(trial / 8) - 2*floor(trial / 16))*1.8
alter VB3 = $&drive
let drive = (floor(trial / 16) - 2*floor(trial / 32))*1.8
alter VB4 = $&drive
let drive = (floor(trial / 32) - 2*floor(trial / 64))*1.8
alter VB5 = $&drive
let drive = (floor(trial / 64) - 2*floor(trial / 128))*1.8
alter VB6 = $&drive
let drive = (floor(trial / 128) - 2*floor(trial / 256))*1.8
alter VB7 = $&drive
stop when time = 0.001822
resume
delete all
let endpoint = length(time)-1
let cmp = v(COMP)[endpoint]
let top = v(TOP)[endpoint]
let decision = 0
if cmp >= 0.9
let code = trial
let decision = 1
end
echo 101 7 $&trial $&cmp $&top 0.46171875 $&decision >> decisions.csv
let trial = code + 64
let drive = (floor(trial / 1) - 2*floor(trial / 2))*1.8
alter VB0 = $&drive
let drive = (floor(trial / 2) - 2*floor(trial / 4))*1.8
alter VB1 = $&drive
let drive = (floor(trial / 4) - 2*floor(trial / 8))*1.8
alter VB2 = $&drive
let drive = (floor(trial / 8) - 2*floor(trial / 16))*1.8
alter VB3 = $&drive
let drive = (floor(trial / 16) - 2*floor(trial / 32))*1.8
alter VB4 = $&drive
let drive = (floor(trial / 32) - 2*floor(trial / 64))*1.8
alter VB5 = $&drive
let drive = (floor(trial / 64) - 2*floor(trial / 128))*1.8
alter VB6 = $&drive
let drive = (floor(trial / 128) - 2*floor(trial / 256))*1.8
alter VB7 = $&drive
stop when time = 0.001824
resume
delete all
let endpoint = length(time)-1
let cmp = v(COMP)[endpoint]
let top = v(TOP)[endpoint]
let decision = 0
if cmp >= 0.9
let code = trial
let decision = 1
end
echo 101 6 $&trial $&cmp $&top 0.46171875 $&decision >> decisions.csv
let trial = code + 32
let drive = (floor(trial / 1) - 2*floor(trial / 2))*1.8
alter VB0 = $&drive
let drive = (floor(trial / 2) - 2*floor(trial / 4))*1.8
alter VB1 = $&drive
let drive = (floor(trial / 4) - 2*floor(trial / 8))*1.8
alter VB2 = $&drive
let drive = (floor(trial / 8) - 2*floor(trial / 16))*1.8
alter VB3 = $&drive
let drive = (floor(trial / 16) - 2*floor(trial / 32))*1.8
alter VB4 = $&drive
let drive = (floor(trial / 32) - 2*floor(trial / 64))*1.8
alter VB5 = $&drive
let drive = (floor(trial / 64) - 2*floor(trial / 128))*1.8
alter VB6 = $&drive
let drive = (floor(trial / 128) - 2*floor(trial / 256))*1.8
alter VB7 = $&drive
stop when time = 0.001826
resume
delete all
let endpoint = length(time)-1
let cmp = v(COMP)[endpoint]
let top = v(TOP)[endpoint]
let decision = 0
if cmp >= 0.9
let code = trial
let decision = 1
end
echo 101 5 $&trial $&cmp $&top 0.46171875 $&decision >> decisions.csv
let trial = code + 16
let drive = (floor(trial / 1) - 2*floor(trial / 2))*1.8
alter VB0 = $&drive
let drive = (floor(trial / 2) - 2*floor(trial / 4))*1.8
alter VB1 = $&drive
let drive = (floor(trial / 4) - 2*floor(trial / 8))*1.8
alter VB2 = $&drive
let drive = (floor(trial / 8) - 2*floor(trial / 16))*1.8
alter VB3 = $&drive
let drive = (floor(trial / 16) - 2*floor(trial / 32))*1.8
alter VB4 = $&drive
let drive = (floor(trial / 32) - 2*floor(trial / 64))*1.8
alter VB5 = $&drive
let drive = (floor(trial / 64) - 2*floor(trial / 128))*1.8
alter VB6 = $&drive
let drive = (floor(trial / 128) - 2*floor(trial / 256))*1.8
alter VB7 = $&drive
stop when time = 0.001828
resume
delete all
let endpoint = length(time)-1
let cmp = v(COMP)[endpoint]
let top = v(TOP)[endpoint]
let decision = 0
if cmp >= 0.9
let code = trial
let decision = 1
end
echo 101 4 $&trial $&cmp $&top 0.46171875 $&decision >> decisions.csv
let trial = code + 8
let drive = (floor(trial / 1) - 2*floor(trial / 2))*1.8
alter VB0 = $&drive
let drive = (floor(trial / 2) - 2*floor(trial / 4))*1.8
alter VB1 = $&drive
let drive = (floor(trial / 4) - 2*floor(trial / 8))*1.8
alter VB2 = $&drive
let drive = (floor(trial / 8) - 2*floor(trial / 16))*1.8
alter VB3 = $&drive
let drive = (floor(trial / 16) - 2*floor(trial / 32))*1.8
alter VB4 = $&drive
let drive = (floor(trial / 32) - 2*floor(trial / 64))*1.8
alter VB5 = $&drive
let drive = (floor(trial / 64) - 2*floor(trial / 128))*1.8
alter VB6 = $&drive
let drive = (floor(trial / 128) - 2*floor(trial / 256))*1.8
alter VB7 = $&drive
stop when time = 0.00183
resume
delete all
let endpoint = length(time)-1
let cmp = v(COMP)[endpoint]
let top = v(TOP)[endpoint]
let decision = 0
if cmp >= 0.9
let code = trial
let decision = 1
end
echo 101 3 $&trial $&cmp $&top 0.46171875 $&decision >> decisions.csv
let trial = code + 4
let drive = (floor(trial / 1) - 2*floor(trial / 2))*1.8
alter VB0 = $&drive
let drive = (floor(trial / 2) - 2*floor(trial / 4))*1.8
alter VB1 = $&drive
let drive = (floor(trial / 4) - 2*floor(trial / 8))*1.8
alter VB2 = $&drive
let drive = (floor(trial / 8) - 2*floor(trial / 16))*1.8
alter VB3 = $&drive
let drive = (floor(trial / 16) - 2*floor(trial / 32))*1.8
alter VB4 = $&drive
let drive = (floor(trial / 32) - 2*floor(trial / 64))*1.8
alter VB5 = $&drive
let drive = (floor(trial / 64) - 2*floor(trial / 128))*1.8
alter VB6 = $&drive
let drive = (floor(trial / 128) - 2*floor(trial / 256))*1.8
alter VB7 = $&drive
stop when time = 0.001832
resume
delete all
let endpoint = length(time)-1
let cmp = v(COMP)[endpoint]
let top = v(TOP)[endpoint]
let decision = 0
if cmp >= 0.9
let code = trial
let decision = 1
end
echo 101 2 $&trial $&cmp $&top 0.46171875 $&decision >> decisions.csv
let trial = code + 2
let drive = (floor(trial / 1) - 2*floor(trial / 2))*1.8
alter VB0 = $&drive
let drive = (floor(trial / 2) - 2*floor(trial / 4))*1.8
alter VB1 = $&drive
let drive = (floor(trial / 4) - 2*floor(trial / 8))*1.8
alter VB2 = $&drive
let drive = (floor(trial / 8) - 2*floor(trial / 16))*1.8
alter VB3 = $&drive
let drive = (floor(trial / 16) - 2*floor(trial / 32))*1.8
alter VB4 = $&drive
let drive = (floor(trial / 32) - 2*floor(trial / 64))*1.8
alter VB5 = $&drive
let drive = (floor(trial / 64) - 2*floor(trial / 128))*1.8
alter VB6 = $&drive
let drive = (floor(trial / 128) - 2*floor(trial / 256))*1.8
alter VB7 = $&drive
stop when time = 0.001834
resume
delete all
let endpoint = length(time)-1
let cmp = v(COMP)[endpoint]
let top = v(TOP)[endpoint]
let decision = 0
if cmp >= 0.9
let code = trial
let decision = 1
end
echo 101 1 $&trial $&cmp $&top 0.46171875 $&decision >> decisions.csv
let trial = code + 1
let drive = (floor(trial / 1) - 2*floor(trial / 2))*1.8
alter VB0 = $&drive
let drive = (floor(trial / 2) - 2*floor(trial / 4))*1.8
alter VB1 = $&drive
let drive = (floor(trial / 4) - 2*floor(trial / 8))*1.8
alter VB2 = $&drive
let drive = (floor(trial / 8) - 2*floor(trial / 16))*1.8
alter VB3 = $&drive
let drive = (floor(trial / 16) - 2*floor(trial / 32))*1.8
alter VB4 = $&drive
let drive = (floor(trial / 32) - 2*floor(trial / 64))*1.8
alter VB5 = $&drive
let drive = (floor(trial / 64) - 2*floor(trial / 128))*1.8
alter VB6 = $&drive
let drive = (floor(trial / 128) - 2*floor(trial / 256))*1.8
alter VB7 = $&drive
stop when time = 0.001836
resume
delete all
let endpoint = length(time)-1
let cmp = v(COMP)[endpoint]
let top = v(TOP)[endpoint]
let decision = 0
if cmp >= 0.9
let code = trial
let decision = 1
end
echo 101 0 $&trial $&cmp $&top 0.46171875 $&decision >> decisions.csv
alter VIN = 0.46640625
alter VSAMPLE = 1.8
alter VB0 = 0
alter VB1 = 0
alter VB2 = 0
alter VB3 = 0
alter VB4 = 0
alter VB5 = 0
alter VB6 = 0
alter VB7 = 0
let code = 0
stop when time = 0.001838
resume
delete all
alter VSAMPLE = 0
let trial = code + 128
let drive = (floor(trial / 1) - 2*floor(trial / 2))*1.8
alter VB0 = $&drive
let drive = (floor(trial / 2) - 2*floor(trial / 4))*1.8
alter VB1 = $&drive
let drive = (floor(trial / 4) - 2*floor(trial / 8))*1.8
alter VB2 = $&drive
let drive = (floor(trial / 8) - 2*floor(trial / 16))*1.8
alter VB3 = $&drive
let drive = (floor(trial / 16) - 2*floor(trial / 32))*1.8
alter VB4 = $&drive
let drive = (floor(trial / 32) - 2*floor(trial / 64))*1.8
alter VB5 = $&drive
let drive = (floor(trial / 64) - 2*floor(trial / 128))*1.8
alter VB6 = $&drive
let drive = (floor(trial / 128) - 2*floor(trial / 256))*1.8
alter VB7 = $&drive
stop when time = 0.00184
resume
delete all
let endpoint = length(time)-1
let cmp = v(COMP)[endpoint]
let top = v(TOP)[endpoint]
let decision = 0
if cmp >= 0.9
let code = trial
let decision = 1
end
echo 102 7 $&trial $&cmp $&top 0.46640625 $&decision >> decisions.csv
let trial = code + 64
let drive = (floor(trial / 1) - 2*floor(trial / 2))*1.8
alter VB0 = $&drive
let drive = (floor(trial / 2) - 2*floor(trial / 4))*1.8
alter VB1 = $&drive
let drive = (floor(trial / 4) - 2*floor(trial / 8))*1.8
alter VB2 = $&drive
let drive = (floor(trial / 8) - 2*floor(trial / 16))*1.8
alter VB3 = $&drive
let drive = (floor(trial / 16) - 2*floor(trial / 32))*1.8
alter VB4 = $&drive
let drive = (floor(trial / 32) - 2*floor(trial / 64))*1.8
alter VB5 = $&drive
let drive = (floor(trial / 64) - 2*floor(trial / 128))*1.8
alter VB6 = $&drive
let drive = (floor(trial / 128) - 2*floor(trial / 256))*1.8
alter VB7 = $&drive
stop when time = 0.001842
resume
delete all
let endpoint = length(time)-1
let cmp = v(COMP)[endpoint]
let top = v(TOP)[endpoint]
let decision = 0
if cmp >= 0.9
let code = trial
let decision = 1
end
echo 102 6 $&trial $&cmp $&top 0.46640625 $&decision >> decisions.csv
let trial = code + 32
let drive = (floor(trial / 1) - 2*floor(trial / 2))*1.8
alter VB0 = $&drive
let drive = (floor(trial / 2) - 2*floor(trial / 4))*1.8
alter VB1 = $&drive
let drive = (floor(trial / 4) - 2*floor(trial / 8))*1.8
alter VB2 = $&drive
let drive = (floor(trial / 8) - 2*floor(trial / 16))*1.8
alter VB3 = $&drive
let drive = (floor(trial / 16) - 2*floor(trial / 32))*1.8
alter VB4 = $&drive
let drive = (floor(trial / 32) - 2*floor(trial / 64))*1.8
alter VB5 = $&drive
let drive = (floor(trial / 64) - 2*floor(trial / 128))*1.8
alter VB6 = $&drive
let drive = (floor(trial / 128) - 2*floor(trial / 256))*1.8
alter VB7 = $&drive
stop when time = 0.001844
resume
delete all
let endpoint = length(time)-1
let cmp = v(COMP)[endpoint]
let top = v(TOP)[endpoint]
let decision = 0
if cmp >= 0.9
let code = trial
let decision = 1
end
echo 102 5 $&trial $&cmp $&top 0.46640625 $&decision >> decisions.csv
let trial = code + 16
let drive = (floor(trial / 1) - 2*floor(trial / 2))*1.8
alter VB0 = $&drive
let drive = (floor(trial / 2) - 2*floor(trial / 4))*1.8
alter VB1 = $&drive
let drive = (floor(trial / 4) - 2*floor(trial / 8))*1.8
alter VB2 = $&drive
let drive = (floor(trial / 8) - 2*floor(trial / 16))*1.8
alter VB3 = $&drive
let drive = (floor(trial / 16) - 2*floor(trial / 32))*1.8
alter VB4 = $&drive
let drive = (floor(trial / 32) - 2*floor(trial / 64))*1.8
alter VB5 = $&drive
let drive = (floor(trial / 64) - 2*floor(trial / 128))*1.8
alter VB6 = $&drive
let drive = (floor(trial / 128) - 2*floor(trial / 256))*1.8
alter VB7 = $&drive
stop when time = 0.001846
resume
delete all
let endpoint = length(time)-1
let cmp = v(COMP)[endpoint]
let top = v(TOP)[endpoint]
let decision = 0
if cmp >= 0.9
let code = trial
let decision = 1
end
echo 102 4 $&trial $&cmp $&top 0.46640625 $&decision >> decisions.csv
let trial = code + 8
let drive = (floor(trial / 1) - 2*floor(trial / 2))*1.8
alter VB0 = $&drive
let drive = (floor(trial / 2) - 2*floor(trial / 4))*1.8
alter VB1 = $&drive
let drive = (floor(trial / 4) - 2*floor(trial / 8))*1.8
alter VB2 = $&drive
let drive = (floor(trial / 8) - 2*floor(trial / 16))*1.8
alter VB3 = $&drive
let drive = (floor(trial / 16) - 2*floor(trial / 32))*1.8
alter VB4 = $&drive
let drive = (floor(trial / 32) - 2*floor(trial / 64))*1.8
alter VB5 = $&drive
let drive = (floor(trial / 64) - 2*floor(trial / 128))*1.8
alter VB6 = $&drive
let drive = (floor(trial / 128) - 2*floor(trial / 256))*1.8
alter VB7 = $&drive
stop when time = 0.001848
resume
delete all
let endpoint = length(time)-1
let cmp = v(COMP)[endpoint]
let top = v(TOP)[endpoint]
let decision = 0
if cmp >= 0.9
let code = trial
let decision = 1
end
echo 102 3 $&trial $&cmp $&top 0.46640625 $&decision >> decisions.csv
let trial = code + 4
let drive = (floor(trial / 1) - 2*floor(trial / 2))*1.8
alter VB0 = $&drive
let drive = (floor(trial / 2) - 2*floor(trial / 4))*1.8
alter VB1 = $&drive
let drive = (floor(trial / 4) - 2*floor(trial / 8))*1.8
alter VB2 = $&drive
let drive = (floor(trial / 8) - 2*floor(trial / 16))*1.8
alter VB3 = $&drive
let drive = (floor(trial / 16) - 2*floor(trial / 32))*1.8
alter VB4 = $&drive
let drive = (floor(trial / 32) - 2*floor(trial / 64))*1.8
alter VB5 = $&drive
let drive = (floor(trial / 64) - 2*floor(trial / 128))*1.8
alter VB6 = $&drive
let drive = (floor(trial / 128) - 2*floor(trial / 256))*1.8
alter VB7 = $&drive
stop when time = 0.00185
resume
delete all
let endpoint = length(time)-1
let cmp = v(COMP)[endpoint]
let top = v(TOP)[endpoint]
let decision = 0
if cmp >= 0.9
let code = trial
let decision = 1
end
echo 102 2 $&trial $&cmp $&top 0.46640625 $&decision >> decisions.csv
let trial = code + 2
let drive = (floor(trial / 1) - 2*floor(trial / 2))*1.8
alter VB0 = $&drive
let drive = (floor(trial / 2) - 2*floor(trial / 4))*1.8
alter VB1 = $&drive
let drive = (floor(trial / 4) - 2*floor(trial / 8))*1.8
alter VB2 = $&drive
let drive = (floor(trial / 8) - 2*floor(trial / 16))*1.8
alter VB3 = $&drive
let drive = (floor(trial / 16) - 2*floor(trial / 32))*1.8
alter VB4 = $&drive
let drive = (floor(trial / 32) - 2*floor(trial / 64))*1.8
alter VB5 = $&drive
let drive = (floor(trial / 64) - 2*floor(trial / 128))*1.8
alter VB6 = $&drive
let drive = (floor(trial / 128) - 2*floor(trial / 256))*1.8
alter VB7 = $&drive
stop when time = 0.001852
resume
delete all
let endpoint = length(time)-1
let cmp = v(COMP)[endpoint]
let top = v(TOP)[endpoint]
let decision = 0
if cmp >= 0.9
let code = trial
let decision = 1
end
echo 102 1 $&trial $&cmp $&top 0.46640625 $&decision >> decisions.csv
let trial = code + 1
let drive = (floor(trial / 1) - 2*floor(trial / 2))*1.8
alter VB0 = $&drive
let drive = (floor(trial / 2) - 2*floor(trial / 4))*1.8
alter VB1 = $&drive
let drive = (floor(trial / 4) - 2*floor(trial / 8))*1.8
alter VB2 = $&drive
let drive = (floor(trial / 8) - 2*floor(trial / 16))*1.8
alter VB3 = $&drive
let drive = (floor(trial / 16) - 2*floor(trial / 32))*1.8
alter VB4 = $&drive
let drive = (floor(trial / 32) - 2*floor(trial / 64))*1.8
alter VB5 = $&drive
let drive = (floor(trial / 64) - 2*floor(trial / 128))*1.8
alter VB6 = $&drive
let drive = (floor(trial / 128) - 2*floor(trial / 256))*1.8
alter VB7 = $&drive
stop when time = 0.001854
resume
delete all
let endpoint = length(time)-1
let cmp = v(COMP)[endpoint]
let top = v(TOP)[endpoint]
let decision = 0
if cmp >= 0.9
let code = trial
let decision = 1
end
echo 102 0 $&trial $&cmp $&top 0.46640625 $&decision >> decisions.csv
alter VIN = 0.47109375
alter VSAMPLE = 1.8
alter VB0 = 0
alter VB1 = 0
alter VB2 = 0
alter VB3 = 0
alter VB4 = 0
alter VB5 = 0
alter VB6 = 0
alter VB7 = 0
let code = 0
stop when time = 0.001856
resume
delete all
alter VSAMPLE = 0
let trial = code + 128
let drive = (floor(trial / 1) - 2*floor(trial / 2))*1.8
alter VB0 = $&drive
let drive = (floor(trial / 2) - 2*floor(trial / 4))*1.8
alter VB1 = $&drive
let drive = (floor(trial / 4) - 2*floor(trial / 8))*1.8
alter VB2 = $&drive
let drive = (floor(trial / 8) - 2*floor(trial / 16))*1.8
alter VB3 = $&drive
let drive = (floor(trial / 16) - 2*floor(trial / 32))*1.8
alter VB4 = $&drive
let drive = (floor(trial / 32) - 2*floor(trial / 64))*1.8
alter VB5 = $&drive
let drive = (floor(trial / 64) - 2*floor(trial / 128))*1.8
alter VB6 = $&drive
let drive = (floor(trial / 128) - 2*floor(trial / 256))*1.8
alter VB7 = $&drive
stop when time = 0.001858
resume
delete all
let endpoint = length(time)-1
let cmp = v(COMP)[endpoint]
let top = v(TOP)[endpoint]
let decision = 0
if cmp >= 0.9
let code = trial
let decision = 1
end
echo 103 7 $&trial $&cmp $&top 0.47109375 $&decision >> decisions.csv
let trial = code + 64
let drive = (floor(trial / 1) - 2*floor(trial / 2))*1.8
alter VB0 = $&drive
let drive = (floor(trial / 2) - 2*floor(trial / 4))*1.8
alter VB1 = $&drive
let drive = (floor(trial / 4) - 2*floor(trial / 8))*1.8
alter VB2 = $&drive
let drive = (floor(trial / 8) - 2*floor(trial / 16))*1.8
alter VB3 = $&drive
let drive = (floor(trial / 16) - 2*floor(trial / 32))*1.8
alter VB4 = $&drive
let drive = (floor(trial / 32) - 2*floor(trial / 64))*1.8
alter VB5 = $&drive
let drive = (floor(trial / 64) - 2*floor(trial / 128))*1.8
alter VB6 = $&drive
let drive = (floor(trial / 128) - 2*floor(trial / 256))*1.8
alter VB7 = $&drive
stop when time = 0.00186
resume
delete all
let endpoint = length(time)-1
let cmp = v(COMP)[endpoint]
let top = v(TOP)[endpoint]
let decision = 0
if cmp >= 0.9
let code = trial
let decision = 1
end
echo 103 6 $&trial $&cmp $&top 0.47109375 $&decision >> decisions.csv
let trial = code + 32
let drive = (floor(trial / 1) - 2*floor(trial / 2))*1.8
alter VB0 = $&drive
let drive = (floor(trial / 2) - 2*floor(trial / 4))*1.8
alter VB1 = $&drive
let drive = (floor(trial / 4) - 2*floor(trial / 8))*1.8
alter VB2 = $&drive
let drive = (floor(trial / 8) - 2*floor(trial / 16))*1.8
alter VB3 = $&drive
let drive = (floor(trial / 16) - 2*floor(trial / 32))*1.8
alter VB4 = $&drive
let drive = (floor(trial / 32) - 2*floor(trial / 64))*1.8
alter VB5 = $&drive
let drive = (floor(trial / 64) - 2*floor(trial / 128))*1.8
alter VB6 = $&drive
let drive = (floor(trial / 128) - 2*floor(trial / 256))*1.8
alter VB7 = $&drive
stop when time = 0.001862
resume
delete all
let endpoint = length(time)-1
let cmp = v(COMP)[endpoint]
let top = v(TOP)[endpoint]
let decision = 0
if cmp >= 0.9
let code = trial
let decision = 1
end
echo 103 5 $&trial $&cmp $&top 0.47109375 $&decision >> decisions.csv
let trial = code + 16
let drive = (floor(trial / 1) - 2*floor(trial / 2))*1.8
alter VB0 = $&drive
let drive = (floor(trial / 2) - 2*floor(trial / 4))*1.8
alter VB1 = $&drive
let drive = (floor(trial / 4) - 2*floor(trial / 8))*1.8
alter VB2 = $&drive
let drive = (floor(trial / 8) - 2*floor(trial / 16))*1.8
alter VB3 = $&drive
let drive = (floor(trial / 16) - 2*floor(trial / 32))*1.8
alter VB4 = $&drive
let drive = (floor(trial / 32) - 2*floor(trial / 64))*1.8
alter VB5 = $&drive
let drive = (floor(trial / 64) - 2*floor(trial / 128))*1.8
alter VB6 = $&drive
let drive = (floor(trial / 128) - 2*floor(trial / 256))*1.8
alter VB7 = $&drive
stop when time = 0.001864
resume
delete all
let endpoint = length(time)-1
let cmp = v(COMP)[endpoint]
let top = v(TOP)[endpoint]
let decision = 0
if cmp >= 0.9
let code = trial
let decision = 1
end
echo 103 4 $&trial $&cmp $&top 0.47109375 $&decision >> decisions.csv
let trial = code + 8
let drive = (floor(trial / 1) - 2*floor(trial / 2))*1.8
alter VB0 = $&drive
let drive = (floor(trial / 2) - 2*floor(trial / 4))*1.8
alter VB1 = $&drive
let drive = (floor(trial / 4) - 2*floor(trial / 8))*1.8
alter VB2 = $&drive
let drive = (floor(trial / 8) - 2*floor(trial / 16))*1.8
alter VB3 = $&drive
let drive = (floor(trial / 16) - 2*floor(trial / 32))*1.8
alter VB4 = $&drive
let drive = (floor(trial / 32) - 2*floor(trial / 64))*1.8
alter VB5 = $&drive
let drive = (floor(trial / 64) - 2*floor(trial / 128))*1.8
alter VB6 = $&drive
let drive = (floor(trial / 128) - 2*floor(trial / 256))*1.8
alter VB7 = $&drive
stop when time = 0.001866
resume
delete all
let endpoint = length(time)-1
let cmp = v(COMP)[endpoint]
let top = v(TOP)[endpoint]
let decision = 0
if cmp >= 0.9
let code = trial
let decision = 1
end
echo 103 3 $&trial $&cmp $&top 0.47109375 $&decision >> decisions.csv
let trial = code + 4
let drive = (floor(trial / 1) - 2*floor(trial / 2))*1.8
alter VB0 = $&drive
let drive = (floor(trial / 2) - 2*floor(trial / 4))*1.8
alter VB1 = $&drive
let drive = (floor(trial / 4) - 2*floor(trial / 8))*1.8
alter VB2 = $&drive
let drive = (floor(trial / 8) - 2*floor(trial / 16))*1.8
alter VB3 = $&drive
let drive = (floor(trial / 16) - 2*floor(trial / 32))*1.8
alter VB4 = $&drive
let drive = (floor(trial / 32) - 2*floor(trial / 64))*1.8
alter VB5 = $&drive
let drive = (floor(trial / 64) - 2*floor(trial / 128))*1.8
alter VB6 = $&drive
let drive = (floor(trial / 128) - 2*floor(trial / 256))*1.8
alter VB7 = $&drive
stop when time = 0.001868
resume
delete all
let endpoint = length(time)-1
let cmp = v(COMP)[endpoint]
let top = v(TOP)[endpoint]
let decision = 0
if cmp >= 0.9
let code = trial
let decision = 1
end
echo 103 2 $&trial $&cmp $&top 0.47109375 $&decision >> decisions.csv
let trial = code + 2
let drive = (floor(trial / 1) - 2*floor(trial / 2))*1.8
alter VB0 = $&drive
let drive = (floor(trial / 2) - 2*floor(trial / 4))*1.8
alter VB1 = $&drive
let drive = (floor(trial / 4) - 2*floor(trial / 8))*1.8
alter VB2 = $&drive
let drive = (floor(trial / 8) - 2*floor(trial / 16))*1.8
alter VB3 = $&drive
let drive = (floor(trial / 16) - 2*floor(trial / 32))*1.8
alter VB4 = $&drive
let drive = (floor(trial / 32) - 2*floor(trial / 64))*1.8
alter VB5 = $&drive
let drive = (floor(trial / 64) - 2*floor(trial / 128))*1.8
alter VB6 = $&drive
let drive = (floor(trial / 128) - 2*floor(trial / 256))*1.8
alter VB7 = $&drive
stop when time = 0.00187
resume
delete all
let endpoint = length(time)-1
let cmp = v(COMP)[endpoint]
let top = v(TOP)[endpoint]
let decision = 0
if cmp >= 0.9
let code = trial
let decision = 1
end
echo 103 1 $&trial $&cmp $&top 0.47109375 $&decision >> decisions.csv
let trial = code + 1
let drive = (floor(trial / 1) - 2*floor(trial / 2))*1.8
alter VB0 = $&drive
let drive = (floor(trial / 2) - 2*floor(trial / 4))*1.8
alter VB1 = $&drive
let drive = (floor(trial / 4) - 2*floor(trial / 8))*1.8
alter VB2 = $&drive
let drive = (floor(trial / 8) - 2*floor(trial / 16))*1.8
alter VB3 = $&drive
let drive = (floor(trial / 16) - 2*floor(trial / 32))*1.8
alter VB4 = $&drive
let drive = (floor(trial / 32) - 2*floor(trial / 64))*1.8
alter VB5 = $&drive
let drive = (floor(trial / 64) - 2*floor(trial / 128))*1.8
alter VB6 = $&drive
let drive = (floor(trial / 128) - 2*floor(trial / 256))*1.8
alter VB7 = $&drive
stop when time = 0.001872
resume
delete all
let endpoint = length(time)-1
let cmp = v(COMP)[endpoint]
let top = v(TOP)[endpoint]
let decision = 0
if cmp >= 0.9
let code = trial
let decision = 1
end
echo 103 0 $&trial $&cmp $&top 0.47109375 $&decision >> decisions.csv
alter VIN = 0.47578125
alter VSAMPLE = 1.8
alter VB0 = 0
alter VB1 = 0
alter VB2 = 0
alter VB3 = 0
alter VB4 = 0
alter VB5 = 0
alter VB6 = 0
alter VB7 = 0
let code = 0
stop when time = 0.001874
resume
delete all
alter VSAMPLE = 0
let trial = code + 128
let drive = (floor(trial / 1) - 2*floor(trial / 2))*1.8
alter VB0 = $&drive
let drive = (floor(trial / 2) - 2*floor(trial / 4))*1.8
alter VB1 = $&drive
let drive = (floor(trial / 4) - 2*floor(trial / 8))*1.8
alter VB2 = $&drive
let drive = (floor(trial / 8) - 2*floor(trial / 16))*1.8
alter VB3 = $&drive
let drive = (floor(trial / 16) - 2*floor(trial / 32))*1.8
alter VB4 = $&drive
let drive = (floor(trial / 32) - 2*floor(trial / 64))*1.8
alter VB5 = $&drive
let drive = (floor(trial / 64) - 2*floor(trial / 128))*1.8
alter VB6 = $&drive
let drive = (floor(trial / 128) - 2*floor(trial / 256))*1.8
alter VB7 = $&drive
stop when time = 0.001876
resume
delete all
let endpoint = length(time)-1
let cmp = v(COMP)[endpoint]
let top = v(TOP)[endpoint]
let decision = 0
if cmp >= 0.9
let code = trial
let decision = 1
end
echo 104 7 $&trial $&cmp $&top 0.47578125 $&decision >> decisions.csv
let trial = code + 64
let drive = (floor(trial / 1) - 2*floor(trial / 2))*1.8
alter VB0 = $&drive
let drive = (floor(trial / 2) - 2*floor(trial / 4))*1.8
alter VB1 = $&drive
let drive = (floor(trial / 4) - 2*floor(trial / 8))*1.8
alter VB2 = $&drive
let drive = (floor(trial / 8) - 2*floor(trial / 16))*1.8
alter VB3 = $&drive
let drive = (floor(trial / 16) - 2*floor(trial / 32))*1.8
alter VB4 = $&drive
let drive = (floor(trial / 32) - 2*floor(trial / 64))*1.8
alter VB5 = $&drive
let drive = (floor(trial / 64) - 2*floor(trial / 128))*1.8
alter VB6 = $&drive
let drive = (floor(trial / 128) - 2*floor(trial / 256))*1.8
alter VB7 = $&drive
stop when time = 0.001878
resume
delete all
let endpoint = length(time)-1
let cmp = v(COMP)[endpoint]
let top = v(TOP)[endpoint]
let decision = 0
if cmp >= 0.9
let code = trial
let decision = 1
end
echo 104 6 $&trial $&cmp $&top 0.47578125 $&decision >> decisions.csv
let trial = code + 32
let drive = (floor(trial / 1) - 2*floor(trial / 2))*1.8
alter VB0 = $&drive
let drive = (floor(trial / 2) - 2*floor(trial / 4))*1.8
alter VB1 = $&drive
let drive = (floor(trial / 4) - 2*floor(trial / 8))*1.8
alter VB2 = $&drive
let drive = (floor(trial / 8) - 2*floor(trial / 16))*1.8
alter VB3 = $&drive
let drive = (floor(trial / 16) - 2*floor(trial / 32))*1.8
alter VB4 = $&drive
let drive = (floor(trial / 32) - 2*floor(trial / 64))*1.8
alter VB5 = $&drive
let drive = (floor(trial / 64) - 2*floor(trial / 128))*1.8
alter VB6 = $&drive
let drive = (floor(trial / 128) - 2*floor(trial / 256))*1.8
alter VB7 = $&drive
stop when time = 0.00188
resume
delete all
let endpoint = length(time)-1
let cmp = v(COMP)[endpoint]
let top = v(TOP)[endpoint]
let decision = 0
if cmp >= 0.9
let code = trial
let decision = 1
end
echo 104 5 $&trial $&cmp $&top 0.47578125 $&decision >> decisions.csv
let trial = code + 16
let drive = (floor(trial / 1) - 2*floor(trial / 2))*1.8
alter VB0 = $&drive
let drive = (floor(trial / 2) - 2*floor(trial / 4))*1.8
alter VB1 = $&drive
let drive = (floor(trial / 4) - 2*floor(trial / 8))*1.8
alter VB2 = $&drive
let drive = (floor(trial / 8) - 2*floor(trial / 16))*1.8
alter VB3 = $&drive
let drive = (floor(trial / 16) - 2*floor(trial / 32))*1.8
alter VB4 = $&drive
let drive = (floor(trial / 32) - 2*floor(trial / 64))*1.8
alter VB5 = $&drive
let drive = (floor(trial / 64) - 2*floor(trial / 128))*1.8
alter VB6 = $&drive
let drive = (floor(trial / 128) - 2*floor(trial / 256))*1.8
alter VB7 = $&drive
stop when time = 0.001882
resume
delete all
let endpoint = length(time)-1
let cmp = v(COMP)[endpoint]
let top = v(TOP)[endpoint]
let decision = 0
if cmp >= 0.9
let code = trial
let decision = 1
end
echo 104 4 $&trial $&cmp $&top 0.47578125 $&decision >> decisions.csv
let trial = code + 8
let drive = (floor(trial / 1) - 2*floor(trial / 2))*1.8
alter VB0 = $&drive
let drive = (floor(trial / 2) - 2*floor(trial / 4))*1.8
alter VB1 = $&drive
let drive = (floor(trial / 4) - 2*floor(trial / 8))*1.8
alter VB2 = $&drive
let drive = (floor(trial / 8) - 2*floor(trial / 16))*1.8
alter VB3 = $&drive
let drive = (floor(trial / 16) - 2*floor(trial / 32))*1.8
alter VB4 = $&drive
let drive = (floor(trial / 32) - 2*floor(trial / 64))*1.8
alter VB5 = $&drive
let drive = (floor(trial / 64) - 2*floor(trial / 128))*1.8
alter VB6 = $&drive
let drive = (floor(trial / 128) - 2*floor(trial / 256))*1.8
alter VB7 = $&drive
stop when time = 0.001884
resume
delete all
let endpoint = length(time)-1
let cmp = v(COMP)[endpoint]
let top = v(TOP)[endpoint]
let decision = 0
if cmp >= 0.9
let code = trial
let decision = 1
end
echo 104 3 $&trial $&cmp $&top 0.47578125 $&decision >> decisions.csv
let trial = code + 4
let drive = (floor(trial / 1) - 2*floor(trial / 2))*1.8
alter VB0 = $&drive
let drive = (floor(trial / 2) - 2*floor(trial / 4))*1.8
alter VB1 = $&drive
let drive = (floor(trial / 4) - 2*floor(trial / 8))*1.8
alter VB2 = $&drive
let drive = (floor(trial / 8) - 2*floor(trial / 16))*1.8
alter VB3 = $&drive
let drive = (floor(trial / 16) - 2*floor(trial / 32))*1.8
alter VB4 = $&drive
let drive = (floor(trial / 32) - 2*floor(trial / 64))*1.8
alter VB5 = $&drive
let drive = (floor(trial / 64) - 2*floor(trial / 128))*1.8
alter VB6 = $&drive
let drive = (floor(trial / 128) - 2*floor(trial / 256))*1.8
alter VB7 = $&drive
stop when time = 0.001886
resume
delete all
let endpoint = length(time)-1
let cmp = v(COMP)[endpoint]
let top = v(TOP)[endpoint]
let decision = 0
if cmp >= 0.9
let code = trial
let decision = 1
end
echo 104 2 $&trial $&cmp $&top 0.47578125 $&decision >> decisions.csv
let trial = code + 2
let drive = (floor(trial / 1) - 2*floor(trial / 2))*1.8
alter VB0 = $&drive
let drive = (floor(trial / 2) - 2*floor(trial / 4))*1.8
alter VB1 = $&drive
let drive = (floor(trial / 4) - 2*floor(trial / 8))*1.8
alter VB2 = $&drive
let drive = (floor(trial / 8) - 2*floor(trial / 16))*1.8
alter VB3 = $&drive
let drive = (floor(trial / 16) - 2*floor(trial / 32))*1.8
alter VB4 = $&drive
let drive = (floor(trial / 32) - 2*floor(trial / 64))*1.8
alter VB5 = $&drive
let drive = (floor(trial / 64) - 2*floor(trial / 128))*1.8
alter VB6 = $&drive
let drive = (floor(trial / 128) - 2*floor(trial / 256))*1.8
alter VB7 = $&drive
stop when time = 0.001888
resume
delete all
let endpoint = length(time)-1
let cmp = v(COMP)[endpoint]
let top = v(TOP)[endpoint]
let decision = 0
if cmp >= 0.9
let code = trial
let decision = 1
end
echo 104 1 $&trial $&cmp $&top 0.47578125 $&decision >> decisions.csv
let trial = code + 1
let drive = (floor(trial / 1) - 2*floor(trial / 2))*1.8
alter VB0 = $&drive
let drive = (floor(trial / 2) - 2*floor(trial / 4))*1.8
alter VB1 = $&drive
let drive = (floor(trial / 4) - 2*floor(trial / 8))*1.8
alter VB2 = $&drive
let drive = (floor(trial / 8) - 2*floor(trial / 16))*1.8
alter VB3 = $&drive
let drive = (floor(trial / 16) - 2*floor(trial / 32))*1.8
alter VB4 = $&drive
let drive = (floor(trial / 32) - 2*floor(trial / 64))*1.8
alter VB5 = $&drive
let drive = (floor(trial / 64) - 2*floor(trial / 128))*1.8
alter VB6 = $&drive
let drive = (floor(trial / 128) - 2*floor(trial / 256))*1.8
alter VB7 = $&drive
stop when time = 0.00189
resume
delete all
let endpoint = length(time)-1
let cmp = v(COMP)[endpoint]
let top = v(TOP)[endpoint]
let decision = 0
if cmp >= 0.9
let code = trial
let decision = 1
end
echo 104 0 $&trial $&cmp $&top 0.47578125 $&decision >> decisions.csv
alter VIN = 0.48046875
alter VSAMPLE = 1.8
alter VB0 = 0
alter VB1 = 0
alter VB2 = 0
alter VB3 = 0
alter VB4 = 0
alter VB5 = 0
alter VB6 = 0
alter VB7 = 0
let code = 0
stop when time = 0.001892
resume
delete all
alter VSAMPLE = 0
let trial = code + 128
let drive = (floor(trial / 1) - 2*floor(trial / 2))*1.8
alter VB0 = $&drive
let drive = (floor(trial / 2) - 2*floor(trial / 4))*1.8
alter VB1 = $&drive
let drive = (floor(trial / 4) - 2*floor(trial / 8))*1.8
alter VB2 = $&drive
let drive = (floor(trial / 8) - 2*floor(trial / 16))*1.8
alter VB3 = $&drive
let drive = (floor(trial / 16) - 2*floor(trial / 32))*1.8
alter VB4 = $&drive
let drive = (floor(trial / 32) - 2*floor(trial / 64))*1.8
alter VB5 = $&drive
let drive = (floor(trial / 64) - 2*floor(trial / 128))*1.8
alter VB6 = $&drive
let drive = (floor(trial / 128) - 2*floor(trial / 256))*1.8
alter VB7 = $&drive
stop when time = 0.001894
resume
delete all
let endpoint = length(time)-1
let cmp = v(COMP)[endpoint]
let top = v(TOP)[endpoint]
let decision = 0
if cmp >= 0.9
let code = trial
let decision = 1
end
echo 105 7 $&trial $&cmp $&top 0.48046875 $&decision >> decisions.csv
let trial = code + 64
let drive = (floor(trial / 1) - 2*floor(trial / 2))*1.8
alter VB0 = $&drive
let drive = (floor(trial / 2) - 2*floor(trial / 4))*1.8
alter VB1 = $&drive
let drive = (floor(trial / 4) - 2*floor(trial / 8))*1.8
alter VB2 = $&drive
let drive = (floor(trial / 8) - 2*floor(trial / 16))*1.8
alter VB3 = $&drive
let drive = (floor(trial / 16) - 2*floor(trial / 32))*1.8
alter VB4 = $&drive
let drive = (floor(trial / 32) - 2*floor(trial / 64))*1.8
alter VB5 = $&drive
let drive = (floor(trial / 64) - 2*floor(trial / 128))*1.8
alter VB6 = $&drive
let drive = (floor(trial / 128) - 2*floor(trial / 256))*1.8
alter VB7 = $&drive
stop when time = 0.001896
resume
delete all
let endpoint = length(time)-1
let cmp = v(COMP)[endpoint]
let top = v(TOP)[endpoint]
let decision = 0
if cmp >= 0.9
let code = trial
let decision = 1
end
echo 105 6 $&trial $&cmp $&top 0.48046875 $&decision >> decisions.csv
let trial = code + 32
let drive = (floor(trial / 1) - 2*floor(trial / 2))*1.8
alter VB0 = $&drive
let drive = (floor(trial / 2) - 2*floor(trial / 4))*1.8
alter VB1 = $&drive
let drive = (floor(trial / 4) - 2*floor(trial / 8))*1.8
alter VB2 = $&drive
let drive = (floor(trial / 8) - 2*floor(trial / 16))*1.8
alter VB3 = $&drive
let drive = (floor(trial / 16) - 2*floor(trial / 32))*1.8
alter VB4 = $&drive
let drive = (floor(trial / 32) - 2*floor(trial / 64))*1.8
alter VB5 = $&drive
let drive = (floor(trial / 64) - 2*floor(trial / 128))*1.8
alter VB6 = $&drive
let drive = (floor(trial / 128) - 2*floor(trial / 256))*1.8
alter VB7 = $&drive
stop when time = 0.001898
resume
delete all
let endpoint = length(time)-1
let cmp = v(COMP)[endpoint]
let top = v(TOP)[endpoint]
let decision = 0
if cmp >= 0.9
let code = trial
let decision = 1
end
echo 105 5 $&trial $&cmp $&top 0.48046875 $&decision >> decisions.csv
let trial = code + 16
let drive = (floor(trial / 1) - 2*floor(trial / 2))*1.8
alter VB0 = $&drive
let drive = (floor(trial / 2) - 2*floor(trial / 4))*1.8
alter VB1 = $&drive
let drive = (floor(trial / 4) - 2*floor(trial / 8))*1.8
alter VB2 = $&drive
let drive = (floor(trial / 8) - 2*floor(trial / 16))*1.8
alter VB3 = $&drive
let drive = (floor(trial / 16) - 2*floor(trial / 32))*1.8
alter VB4 = $&drive
let drive = (floor(trial / 32) - 2*floor(trial / 64))*1.8
alter VB5 = $&drive
let drive = (floor(trial / 64) - 2*floor(trial / 128))*1.8
alter VB6 = $&drive
let drive = (floor(trial / 128) - 2*floor(trial / 256))*1.8
alter VB7 = $&drive
stop when time = 0.0019
resume
delete all
let endpoint = length(time)-1
let cmp = v(COMP)[endpoint]
let top = v(TOP)[endpoint]
let decision = 0
if cmp >= 0.9
let code = trial
let decision = 1
end
echo 105 4 $&trial $&cmp $&top 0.48046875 $&decision >> decisions.csv
let trial = code + 8
let drive = (floor(trial / 1) - 2*floor(trial / 2))*1.8
alter VB0 = $&drive
let drive = (floor(trial / 2) - 2*floor(trial / 4))*1.8
alter VB1 = $&drive
let drive = (floor(trial / 4) - 2*floor(trial / 8))*1.8
alter VB2 = $&drive
let drive = (floor(trial / 8) - 2*floor(trial / 16))*1.8
alter VB3 = $&drive
let drive = (floor(trial / 16) - 2*floor(trial / 32))*1.8
alter VB4 = $&drive
let drive = (floor(trial / 32) - 2*floor(trial / 64))*1.8
alter VB5 = $&drive
let drive = (floor(trial / 64) - 2*floor(trial / 128))*1.8
alter VB6 = $&drive
let drive = (floor(trial / 128) - 2*floor(trial / 256))*1.8
alter VB7 = $&drive
stop when time = 0.001902
resume
delete all
let endpoint = length(time)-1
let cmp = v(COMP)[endpoint]
let top = v(TOP)[endpoint]
let decision = 0
if cmp >= 0.9
let code = trial
let decision = 1
end
echo 105 3 $&trial $&cmp $&top 0.48046875 $&decision >> decisions.csv
let trial = code + 4
let drive = (floor(trial / 1) - 2*floor(trial / 2))*1.8
alter VB0 = $&drive
let drive = (floor(trial / 2) - 2*floor(trial / 4))*1.8
alter VB1 = $&drive
let drive = (floor(trial / 4) - 2*floor(trial / 8))*1.8
alter VB2 = $&drive
let drive = (floor(trial / 8) - 2*floor(trial / 16))*1.8
alter VB3 = $&drive
let drive = (floor(trial / 16) - 2*floor(trial / 32))*1.8
alter VB4 = $&drive
let drive = (floor(trial / 32) - 2*floor(trial / 64))*1.8
alter VB5 = $&drive
let drive = (floor(trial / 64) - 2*floor(trial / 128))*1.8
alter VB6 = $&drive
let drive = (floor(trial / 128) - 2*floor(trial / 256))*1.8
alter VB7 = $&drive
stop when time = 0.001904
resume
delete all
let endpoint = length(time)-1
let cmp = v(COMP)[endpoint]
let top = v(TOP)[endpoint]
let decision = 0
if cmp >= 0.9
let code = trial
let decision = 1
end
echo 105 2 $&trial $&cmp $&top 0.48046875 $&decision >> decisions.csv
let trial = code + 2
let drive = (floor(trial / 1) - 2*floor(trial / 2))*1.8
alter VB0 = $&drive
let drive = (floor(trial / 2) - 2*floor(trial / 4))*1.8
alter VB1 = $&drive
let drive = (floor(trial / 4) - 2*floor(trial / 8))*1.8
alter VB2 = $&drive
let drive = (floor(trial / 8) - 2*floor(trial / 16))*1.8
alter VB3 = $&drive
let drive = (floor(trial / 16) - 2*floor(trial / 32))*1.8
alter VB4 = $&drive
let drive = (floor(trial / 32) - 2*floor(trial / 64))*1.8
alter VB5 = $&drive
let drive = (floor(trial / 64) - 2*floor(trial / 128))*1.8
alter VB6 = $&drive
let drive = (floor(trial / 128) - 2*floor(trial / 256))*1.8
alter VB7 = $&drive
stop when time = 0.001906
resume
delete all
let endpoint = length(time)-1
let cmp = v(COMP)[endpoint]
let top = v(TOP)[endpoint]
let decision = 0
if cmp >= 0.9
let code = trial
let decision = 1
end
echo 105 1 $&trial $&cmp $&top 0.48046875 $&decision >> decisions.csv
let trial = code + 1
let drive = (floor(trial / 1) - 2*floor(trial / 2))*1.8
alter VB0 = $&drive
let drive = (floor(trial / 2) - 2*floor(trial / 4))*1.8
alter VB1 = $&drive
let drive = (floor(trial / 4) - 2*floor(trial / 8))*1.8
alter VB2 = $&drive
let drive = (floor(trial / 8) - 2*floor(trial / 16))*1.8
alter VB3 = $&drive
let drive = (floor(trial / 16) - 2*floor(trial / 32))*1.8
alter VB4 = $&drive
let drive = (floor(trial / 32) - 2*floor(trial / 64))*1.8
alter VB5 = $&drive
let drive = (floor(trial / 64) - 2*floor(trial / 128))*1.8
alter VB6 = $&drive
let drive = (floor(trial / 128) - 2*floor(trial / 256))*1.8
alter VB7 = $&drive
stop when time = 0.001908
resume
delete all
let endpoint = length(time)-1
let cmp = v(COMP)[endpoint]
let top = v(TOP)[endpoint]
let decision = 0
if cmp >= 0.9
let code = trial
let decision = 1
end
echo 105 0 $&trial $&cmp $&top 0.48046875 $&decision >> decisions.csv
alter VIN = 0.48515625
alter VSAMPLE = 1.8
alter VB0 = 0
alter VB1 = 0
alter VB2 = 0
alter VB3 = 0
alter VB4 = 0
alter VB5 = 0
alter VB6 = 0
alter VB7 = 0
let code = 0
stop when time = 0.00191
resume
delete all
alter VSAMPLE = 0
let trial = code + 128
let drive = (floor(trial / 1) - 2*floor(trial / 2))*1.8
alter VB0 = $&drive
let drive = (floor(trial / 2) - 2*floor(trial / 4))*1.8
alter VB1 = $&drive
let drive = (floor(trial / 4) - 2*floor(trial / 8))*1.8
alter VB2 = $&drive
let drive = (floor(trial / 8) - 2*floor(trial / 16))*1.8
alter VB3 = $&drive
let drive = (floor(trial / 16) - 2*floor(trial / 32))*1.8
alter VB4 = $&drive
let drive = (floor(trial / 32) - 2*floor(trial / 64))*1.8
alter VB5 = $&drive
let drive = (floor(trial / 64) - 2*floor(trial / 128))*1.8
alter VB6 = $&drive
let drive = (floor(trial / 128) - 2*floor(trial / 256))*1.8
alter VB7 = $&drive
stop when time = 0.001912
resume
delete all
let endpoint = length(time)-1
let cmp = v(COMP)[endpoint]
let top = v(TOP)[endpoint]
let decision = 0
if cmp >= 0.9
let code = trial
let decision = 1
end
echo 106 7 $&trial $&cmp $&top 0.48515625 $&decision >> decisions.csv
let trial = code + 64
let drive = (floor(trial / 1) - 2*floor(trial / 2))*1.8
alter VB0 = $&drive
let drive = (floor(trial / 2) - 2*floor(trial / 4))*1.8
alter VB1 = $&drive
let drive = (floor(trial / 4) - 2*floor(trial / 8))*1.8
alter VB2 = $&drive
let drive = (floor(trial / 8) - 2*floor(trial / 16))*1.8
alter VB3 = $&drive
let drive = (floor(trial / 16) - 2*floor(trial / 32))*1.8
alter VB4 = $&drive
let drive = (floor(trial / 32) - 2*floor(trial / 64))*1.8
alter VB5 = $&drive
let drive = (floor(trial / 64) - 2*floor(trial / 128))*1.8
alter VB6 = $&drive
let drive = (floor(trial / 128) - 2*floor(trial / 256))*1.8
alter VB7 = $&drive
stop when time = 0.001914
resume
delete all
let endpoint = length(time)-1
let cmp = v(COMP)[endpoint]
let top = v(TOP)[endpoint]
let decision = 0
if cmp >= 0.9
let code = trial
let decision = 1
end
echo 106 6 $&trial $&cmp $&top 0.48515625 $&decision >> decisions.csv
let trial = code + 32
let drive = (floor(trial / 1) - 2*floor(trial / 2))*1.8
alter VB0 = $&drive
let drive = (floor(trial / 2) - 2*floor(trial / 4))*1.8
alter VB1 = $&drive
let drive = (floor(trial / 4) - 2*floor(trial / 8))*1.8
alter VB2 = $&drive
let drive = (floor(trial / 8) - 2*floor(trial / 16))*1.8
alter VB3 = $&drive
let drive = (floor(trial / 16) - 2*floor(trial / 32))*1.8
alter VB4 = $&drive
let drive = (floor(trial / 32) - 2*floor(trial / 64))*1.8
alter VB5 = $&drive
let drive = (floor(trial / 64) - 2*floor(trial / 128))*1.8
alter VB6 = $&drive
let drive = (floor(trial / 128) - 2*floor(trial / 256))*1.8
alter VB7 = $&drive
stop when time = 0.001916
resume
delete all
let endpoint = length(time)-1
let cmp = v(COMP)[endpoint]
let top = v(TOP)[endpoint]
let decision = 0
if cmp >= 0.9
let code = trial
let decision = 1
end
echo 106 5 $&trial $&cmp $&top 0.48515625 $&decision >> decisions.csv
let trial = code + 16
let drive = (floor(trial / 1) - 2*floor(trial / 2))*1.8
alter VB0 = $&drive
let drive = (floor(trial / 2) - 2*floor(trial / 4))*1.8
alter VB1 = $&drive
let drive = (floor(trial / 4) - 2*floor(trial / 8))*1.8
alter VB2 = $&drive
let drive = (floor(trial / 8) - 2*floor(trial / 16))*1.8
alter VB3 = $&drive
let drive = (floor(trial / 16) - 2*floor(trial / 32))*1.8
alter VB4 = $&drive
let drive = (floor(trial / 32) - 2*floor(trial / 64))*1.8
alter VB5 = $&drive
let drive = (floor(trial / 64) - 2*floor(trial / 128))*1.8
alter VB6 = $&drive
let drive = (floor(trial / 128) - 2*floor(trial / 256))*1.8
alter VB7 = $&drive
stop when time = 0.001918
resume
delete all
let endpoint = length(time)-1
let cmp = v(COMP)[endpoint]
let top = v(TOP)[endpoint]
let decision = 0
if cmp >= 0.9
let code = trial
let decision = 1
end
echo 106 4 $&trial $&cmp $&top 0.48515625 $&decision >> decisions.csv
let trial = code + 8
let drive = (floor(trial / 1) - 2*floor(trial / 2))*1.8
alter VB0 = $&drive
let drive = (floor(trial / 2) - 2*floor(trial / 4))*1.8
alter VB1 = $&drive
let drive = (floor(trial / 4) - 2*floor(trial / 8))*1.8
alter VB2 = $&drive
let drive = (floor(trial / 8) - 2*floor(trial / 16))*1.8
alter VB3 = $&drive
let drive = (floor(trial / 16) - 2*floor(trial / 32))*1.8
alter VB4 = $&drive
let drive = (floor(trial / 32) - 2*floor(trial / 64))*1.8
alter VB5 = $&drive
let drive = (floor(trial / 64) - 2*floor(trial / 128))*1.8
alter VB6 = $&drive
let drive = (floor(trial / 128) - 2*floor(trial / 256))*1.8
alter VB7 = $&drive
stop when time = 0.00192
resume
delete all
let endpoint = length(time)-1
let cmp = v(COMP)[endpoint]
let top = v(TOP)[endpoint]
let decision = 0
if cmp >= 0.9
let code = trial
let decision = 1
end
echo 106 3 $&trial $&cmp $&top 0.48515625 $&decision >> decisions.csv
let trial = code + 4
let drive = (floor(trial / 1) - 2*floor(trial / 2))*1.8
alter VB0 = $&drive
let drive = (floor(trial / 2) - 2*floor(trial / 4))*1.8
alter VB1 = $&drive
let drive = (floor(trial / 4) - 2*floor(trial / 8))*1.8
alter VB2 = $&drive
let drive = (floor(trial / 8) - 2*floor(trial / 16))*1.8
alter VB3 = $&drive
let drive = (floor(trial / 16) - 2*floor(trial / 32))*1.8
alter VB4 = $&drive
let drive = (floor(trial / 32) - 2*floor(trial / 64))*1.8
alter VB5 = $&drive
let drive = (floor(trial / 64) - 2*floor(trial / 128))*1.8
alter VB6 = $&drive
let drive = (floor(trial / 128) - 2*floor(trial / 256))*1.8
alter VB7 = $&drive
stop when time = 0.001922
resume
delete all
let endpoint = length(time)-1
let cmp = v(COMP)[endpoint]
let top = v(TOP)[endpoint]
let decision = 0
if cmp >= 0.9
let code = trial
let decision = 1
end
echo 106 2 $&trial $&cmp $&top 0.48515625 $&decision >> decisions.csv
let trial = code + 2
let drive = (floor(trial / 1) - 2*floor(trial / 2))*1.8
alter VB0 = $&drive
let drive = (floor(trial / 2) - 2*floor(trial / 4))*1.8
alter VB1 = $&drive
let drive = (floor(trial / 4) - 2*floor(trial / 8))*1.8
alter VB2 = $&drive
let drive = (floor(trial / 8) - 2*floor(trial / 16))*1.8
alter VB3 = $&drive
let drive = (floor(trial / 16) - 2*floor(trial / 32))*1.8
alter VB4 = $&drive
let drive = (floor(trial / 32) - 2*floor(trial / 64))*1.8
alter VB5 = $&drive
let drive = (floor(trial / 64) - 2*floor(trial / 128))*1.8
alter VB6 = $&drive
let drive = (floor(trial / 128) - 2*floor(trial / 256))*1.8
alter VB7 = $&drive
stop when time = 0.001924
resume
delete all
let endpoint = length(time)-1
let cmp = v(COMP)[endpoint]
let top = v(TOP)[endpoint]
let decision = 0
if cmp >= 0.9
let code = trial
let decision = 1
end
echo 106 1 $&trial $&cmp $&top 0.48515625 $&decision >> decisions.csv
let trial = code + 1
let drive = (floor(trial / 1) - 2*floor(trial / 2))*1.8
alter VB0 = $&drive
let drive = (floor(trial / 2) - 2*floor(trial / 4))*1.8
alter VB1 = $&drive
let drive = (floor(trial / 4) - 2*floor(trial / 8))*1.8
alter VB2 = $&drive
let drive = (floor(trial / 8) - 2*floor(trial / 16))*1.8
alter VB3 = $&drive
let drive = (floor(trial / 16) - 2*floor(trial / 32))*1.8
alter VB4 = $&drive
let drive = (floor(trial / 32) - 2*floor(trial / 64))*1.8
alter VB5 = $&drive
let drive = (floor(trial / 64) - 2*floor(trial / 128))*1.8
alter VB6 = $&drive
let drive = (floor(trial / 128) - 2*floor(trial / 256))*1.8
alter VB7 = $&drive
stop when time = 0.001926
resume
delete all
let endpoint = length(time)-1
let cmp = v(COMP)[endpoint]
let top = v(TOP)[endpoint]
let decision = 0
if cmp >= 0.9
let code = trial
let decision = 1
end
echo 106 0 $&trial $&cmp $&top 0.48515625 $&decision >> decisions.csv
alter VIN = 0.48984375
alter VSAMPLE = 1.8
alter VB0 = 0
alter VB1 = 0
alter VB2 = 0
alter VB3 = 0
alter VB4 = 0
alter VB5 = 0
alter VB6 = 0
alter VB7 = 0
let code = 0
stop when time = 0.001928
resume
delete all
alter VSAMPLE = 0
let trial = code + 128
let drive = (floor(trial / 1) - 2*floor(trial / 2))*1.8
alter VB0 = $&drive
let drive = (floor(trial / 2) - 2*floor(trial / 4))*1.8
alter VB1 = $&drive
let drive = (floor(trial / 4) - 2*floor(trial / 8))*1.8
alter VB2 = $&drive
let drive = (floor(trial / 8) - 2*floor(trial / 16))*1.8
alter VB3 = $&drive
let drive = (floor(trial / 16) - 2*floor(trial / 32))*1.8
alter VB4 = $&drive
let drive = (floor(trial / 32) - 2*floor(trial / 64))*1.8
alter VB5 = $&drive
let drive = (floor(trial / 64) - 2*floor(trial / 128))*1.8
alter VB6 = $&drive
let drive = (floor(trial / 128) - 2*floor(trial / 256))*1.8
alter VB7 = $&drive
stop when time = 0.00193
resume
delete all
let endpoint = length(time)-1
let cmp = v(COMP)[endpoint]
let top = v(TOP)[endpoint]
let decision = 0
if cmp >= 0.9
let code = trial
let decision = 1
end
echo 107 7 $&trial $&cmp $&top 0.48984375 $&decision >> decisions.csv
let trial = code + 64
let drive = (floor(trial / 1) - 2*floor(trial / 2))*1.8
alter VB0 = $&drive
let drive = (floor(trial / 2) - 2*floor(trial / 4))*1.8
alter VB1 = $&drive
let drive = (floor(trial / 4) - 2*floor(trial / 8))*1.8
alter VB2 = $&drive
let drive = (floor(trial / 8) - 2*floor(trial / 16))*1.8
alter VB3 = $&drive
let drive = (floor(trial / 16) - 2*floor(trial / 32))*1.8
alter VB4 = $&drive
let drive = (floor(trial / 32) - 2*floor(trial / 64))*1.8
alter VB5 = $&drive
let drive = (floor(trial / 64) - 2*floor(trial / 128))*1.8
alter VB6 = $&drive
let drive = (floor(trial / 128) - 2*floor(trial / 256))*1.8
alter VB7 = $&drive
stop when time = 0.001932
resume
delete all
let endpoint = length(time)-1
let cmp = v(COMP)[endpoint]
let top = v(TOP)[endpoint]
let decision = 0
if cmp >= 0.9
let code = trial
let decision = 1
end
echo 107 6 $&trial $&cmp $&top 0.48984375 $&decision >> decisions.csv
let trial = code + 32
let drive = (floor(trial / 1) - 2*floor(trial / 2))*1.8
alter VB0 = $&drive
let drive = (floor(trial / 2) - 2*floor(trial / 4))*1.8
alter VB1 = $&drive
let drive = (floor(trial / 4) - 2*floor(trial / 8))*1.8
alter VB2 = $&drive
let drive = (floor(trial / 8) - 2*floor(trial / 16))*1.8
alter VB3 = $&drive
let drive = (floor(trial / 16) - 2*floor(trial / 32))*1.8
alter VB4 = $&drive
let drive = (floor(trial / 32) - 2*floor(trial / 64))*1.8
alter VB5 = $&drive
let drive = (floor(trial / 64) - 2*floor(trial / 128))*1.8
alter VB6 = $&drive
let drive = (floor(trial / 128) - 2*floor(trial / 256))*1.8
alter VB7 = $&drive
stop when time = 0.001934
resume
delete all
let endpoint = length(time)-1
let cmp = v(COMP)[endpoint]
let top = v(TOP)[endpoint]
let decision = 0
if cmp >= 0.9
let code = trial
let decision = 1
end
echo 107 5 $&trial $&cmp $&top 0.48984375 $&decision >> decisions.csv
let trial = code + 16
let drive = (floor(trial / 1) - 2*floor(trial / 2))*1.8
alter VB0 = $&drive
let drive = (floor(trial / 2) - 2*floor(trial / 4))*1.8
alter VB1 = $&drive
let drive = (floor(trial / 4) - 2*floor(trial / 8))*1.8
alter VB2 = $&drive
let drive = (floor(trial / 8) - 2*floor(trial / 16))*1.8
alter VB3 = $&drive
let drive = (floor(trial / 16) - 2*floor(trial / 32))*1.8
alter VB4 = $&drive
let drive = (floor(trial / 32) - 2*floor(trial / 64))*1.8
alter VB5 = $&drive
let drive = (floor(trial / 64) - 2*floor(trial / 128))*1.8
alter VB6 = $&drive
let drive = (floor(trial / 128) - 2*floor(trial / 256))*1.8
alter VB7 = $&drive
stop when time = 0.001936
resume
delete all
let endpoint = length(time)-1
let cmp = v(COMP)[endpoint]
let top = v(TOP)[endpoint]
let decision = 0
if cmp >= 0.9
let code = trial
let decision = 1
end
echo 107 4 $&trial $&cmp $&top 0.48984375 $&decision >> decisions.csv
let trial = code + 8
let drive = (floor(trial / 1) - 2*floor(trial / 2))*1.8
alter VB0 = $&drive
let drive = (floor(trial / 2) - 2*floor(trial / 4))*1.8
alter VB1 = $&drive
let drive = (floor(trial / 4) - 2*floor(trial / 8))*1.8
alter VB2 = $&drive
let drive = (floor(trial / 8) - 2*floor(trial / 16))*1.8
alter VB3 = $&drive
let drive = (floor(trial / 16) - 2*floor(trial / 32))*1.8
alter VB4 = $&drive
let drive = (floor(trial / 32) - 2*floor(trial / 64))*1.8
alter VB5 = $&drive
let drive = (floor(trial / 64) - 2*floor(trial / 128))*1.8
alter VB6 = $&drive
let drive = (floor(trial / 128) - 2*floor(trial / 256))*1.8
alter VB7 = $&drive
stop when time = 0.001938
resume
delete all
let endpoint = length(time)-1
let cmp = v(COMP)[endpoint]
let top = v(TOP)[endpoint]
let decision = 0
if cmp >= 0.9
let code = trial
let decision = 1
end
echo 107 3 $&trial $&cmp $&top 0.48984375 $&decision >> decisions.csv
let trial = code + 4
let drive = (floor(trial / 1) - 2*floor(trial / 2))*1.8
alter VB0 = $&drive
let drive = (floor(trial / 2) - 2*floor(trial / 4))*1.8
alter VB1 = $&drive
let drive = (floor(trial / 4) - 2*floor(trial / 8))*1.8
alter VB2 = $&drive
let drive = (floor(trial / 8) - 2*floor(trial / 16))*1.8
alter VB3 = $&drive
let drive = (floor(trial / 16) - 2*floor(trial / 32))*1.8
alter VB4 = $&drive
let drive = (floor(trial / 32) - 2*floor(trial / 64))*1.8
alter VB5 = $&drive
let drive = (floor(trial / 64) - 2*floor(trial / 128))*1.8
alter VB6 = $&drive
let drive = (floor(trial / 128) - 2*floor(trial / 256))*1.8
alter VB7 = $&drive
stop when time = 0.00194
resume
delete all
let endpoint = length(time)-1
let cmp = v(COMP)[endpoint]
let top = v(TOP)[endpoint]
let decision = 0
if cmp >= 0.9
let code = trial
let decision = 1
end
echo 107 2 $&trial $&cmp $&top 0.48984375 $&decision >> decisions.csv
let trial = code + 2
let drive = (floor(trial / 1) - 2*floor(trial / 2))*1.8
alter VB0 = $&drive
let drive = (floor(trial / 2) - 2*floor(trial / 4))*1.8
alter VB1 = $&drive
let drive = (floor(trial / 4) - 2*floor(trial / 8))*1.8
alter VB2 = $&drive
let drive = (floor(trial / 8) - 2*floor(trial / 16))*1.8
alter VB3 = $&drive
let drive = (floor(trial / 16) - 2*floor(trial / 32))*1.8
alter VB4 = $&drive
let drive = (floor(trial / 32) - 2*floor(trial / 64))*1.8
alter VB5 = $&drive
let drive = (floor(trial / 64) - 2*floor(trial / 128))*1.8
alter VB6 = $&drive
let drive = (floor(trial / 128) - 2*floor(trial / 256))*1.8
alter VB7 = $&drive
stop when time = 0.001942
resume
delete all
let endpoint = length(time)-1
let cmp = v(COMP)[endpoint]
let top = v(TOP)[endpoint]
let decision = 0
if cmp >= 0.9
let code = trial
let decision = 1
end
echo 107 1 $&trial $&cmp $&top 0.48984375 $&decision >> decisions.csv
let trial = code + 1
let drive = (floor(trial / 1) - 2*floor(trial / 2))*1.8
alter VB0 = $&drive
let drive = (floor(trial / 2) - 2*floor(trial / 4))*1.8
alter VB1 = $&drive
let drive = (floor(trial / 4) - 2*floor(trial / 8))*1.8
alter VB2 = $&drive
let drive = (floor(trial / 8) - 2*floor(trial / 16))*1.8
alter VB3 = $&drive
let drive = (floor(trial / 16) - 2*floor(trial / 32))*1.8
alter VB4 = $&drive
let drive = (floor(trial / 32) - 2*floor(trial / 64))*1.8
alter VB5 = $&drive
let drive = (floor(trial / 64) - 2*floor(trial / 128))*1.8
alter VB6 = $&drive
let drive = (floor(trial / 128) - 2*floor(trial / 256))*1.8
alter VB7 = $&drive
stop when time = 0.001944
resume
delete all
let endpoint = length(time)-1
let cmp = v(COMP)[endpoint]
let top = v(TOP)[endpoint]
let decision = 0
if cmp >= 0.9
let code = trial
let decision = 1
end
echo 107 0 $&trial $&cmp $&top 0.48984375 $&decision >> decisions.csv
alter VIN = 0.49453125
alter VSAMPLE = 1.8
alter VB0 = 0
alter VB1 = 0
alter VB2 = 0
alter VB3 = 0
alter VB4 = 0
alter VB5 = 0
alter VB6 = 0
alter VB7 = 0
let code = 0
stop when time = 0.001946
resume
delete all
alter VSAMPLE = 0
let trial = code + 128
let drive = (floor(trial / 1) - 2*floor(trial / 2))*1.8
alter VB0 = $&drive
let drive = (floor(trial / 2) - 2*floor(trial / 4))*1.8
alter VB1 = $&drive
let drive = (floor(trial / 4) - 2*floor(trial / 8))*1.8
alter VB2 = $&drive
let drive = (floor(trial / 8) - 2*floor(trial / 16))*1.8
alter VB3 = $&drive
let drive = (floor(trial / 16) - 2*floor(trial / 32))*1.8
alter VB4 = $&drive
let drive = (floor(trial / 32) - 2*floor(trial / 64))*1.8
alter VB5 = $&drive
let drive = (floor(trial / 64) - 2*floor(trial / 128))*1.8
alter VB6 = $&drive
let drive = (floor(trial / 128) - 2*floor(trial / 256))*1.8
alter VB7 = $&drive
stop when time = 0.001948
resume
delete all
let endpoint = length(time)-1
let cmp = v(COMP)[endpoint]
let top = v(TOP)[endpoint]
let decision = 0
if cmp >= 0.9
let code = trial
let decision = 1
end
echo 108 7 $&trial $&cmp $&top 0.49453125 $&decision >> decisions.csv
let trial = code + 64
let drive = (floor(trial / 1) - 2*floor(trial / 2))*1.8
alter VB0 = $&drive
let drive = (floor(trial / 2) - 2*floor(trial / 4))*1.8
alter VB1 = $&drive
let drive = (floor(trial / 4) - 2*floor(trial / 8))*1.8
alter VB2 = $&drive
let drive = (floor(trial / 8) - 2*floor(trial / 16))*1.8
alter VB3 = $&drive
let drive = (floor(trial / 16) - 2*floor(trial / 32))*1.8
alter VB4 = $&drive
let drive = (floor(trial / 32) - 2*floor(trial / 64))*1.8
alter VB5 = $&drive
let drive = (floor(trial / 64) - 2*floor(trial / 128))*1.8
alter VB6 = $&drive
let drive = (floor(trial / 128) - 2*floor(trial / 256))*1.8
alter VB7 = $&drive
stop when time = 0.00195
resume
delete all
let endpoint = length(time)-1
let cmp = v(COMP)[endpoint]
let top = v(TOP)[endpoint]
let decision = 0
if cmp >= 0.9
let code = trial
let decision = 1
end
echo 108 6 $&trial $&cmp $&top 0.49453125 $&decision >> decisions.csv
let trial = code + 32
let drive = (floor(trial / 1) - 2*floor(trial / 2))*1.8
alter VB0 = $&drive
let drive = (floor(trial / 2) - 2*floor(trial / 4))*1.8
alter VB1 = $&drive
let drive = (floor(trial / 4) - 2*floor(trial / 8))*1.8
alter VB2 = $&drive
let drive = (floor(trial / 8) - 2*floor(trial / 16))*1.8
alter VB3 = $&drive
let drive = (floor(trial / 16) - 2*floor(trial / 32))*1.8
alter VB4 = $&drive
let drive = (floor(trial / 32) - 2*floor(trial / 64))*1.8
alter VB5 = $&drive
let drive = (floor(trial / 64) - 2*floor(trial / 128))*1.8
alter VB6 = $&drive
let drive = (floor(trial / 128) - 2*floor(trial / 256))*1.8
alter VB7 = $&drive
stop when time = 0.001952
resume
delete all
let endpoint = length(time)-1
let cmp = v(COMP)[endpoint]
let top = v(TOP)[endpoint]
let decision = 0
if cmp >= 0.9
let code = trial
let decision = 1
end
echo 108 5 $&trial $&cmp $&top 0.49453125 $&decision >> decisions.csv
let trial = code + 16
let drive = (floor(trial / 1) - 2*floor(trial / 2))*1.8
alter VB0 = $&drive
let drive = (floor(trial / 2) - 2*floor(trial / 4))*1.8
alter VB1 = $&drive
let drive = (floor(trial / 4) - 2*floor(trial / 8))*1.8
alter VB2 = $&drive
let drive = (floor(trial / 8) - 2*floor(trial / 16))*1.8
alter VB3 = $&drive
let drive = (floor(trial / 16) - 2*floor(trial / 32))*1.8
alter VB4 = $&drive
let drive = (floor(trial / 32) - 2*floor(trial / 64))*1.8
alter VB5 = $&drive
let drive = (floor(trial / 64) - 2*floor(trial / 128))*1.8
alter VB6 = $&drive
let drive = (floor(trial / 128) - 2*floor(trial / 256))*1.8
alter VB7 = $&drive
stop when time = 0.001954
resume
delete all
let endpoint = length(time)-1
let cmp = v(COMP)[endpoint]
let top = v(TOP)[endpoint]
let decision = 0
if cmp >= 0.9
let code = trial
let decision = 1
end
echo 108 4 $&trial $&cmp $&top 0.49453125 $&decision >> decisions.csv
let trial = code + 8
let drive = (floor(trial / 1) - 2*floor(trial / 2))*1.8
alter VB0 = $&drive
let drive = (floor(trial / 2) - 2*floor(trial / 4))*1.8
alter VB1 = $&drive
let drive = (floor(trial / 4) - 2*floor(trial / 8))*1.8
alter VB2 = $&drive
let drive = (floor(trial / 8) - 2*floor(trial / 16))*1.8
alter VB3 = $&drive
let drive = (floor(trial / 16) - 2*floor(trial / 32))*1.8
alter VB4 = $&drive
let drive = (floor(trial / 32) - 2*floor(trial / 64))*1.8
alter VB5 = $&drive
let drive = (floor(trial / 64) - 2*floor(trial / 128))*1.8
alter VB6 = $&drive
let drive = (floor(trial / 128) - 2*floor(trial / 256))*1.8
alter VB7 = $&drive
stop when time = 0.001956
resume
delete all
let endpoint = length(time)-1
let cmp = v(COMP)[endpoint]
let top = v(TOP)[endpoint]
let decision = 0
if cmp >= 0.9
let code = trial
let decision = 1
end
echo 108 3 $&trial $&cmp $&top 0.49453125 $&decision >> decisions.csv
let trial = code + 4
let drive = (floor(trial / 1) - 2*floor(trial / 2))*1.8
alter VB0 = $&drive
let drive = (floor(trial / 2) - 2*floor(trial / 4))*1.8
alter VB1 = $&drive
let drive = (floor(trial / 4) - 2*floor(trial / 8))*1.8
alter VB2 = $&drive
let drive = (floor(trial / 8) - 2*floor(trial / 16))*1.8
alter VB3 = $&drive
let drive = (floor(trial / 16) - 2*floor(trial / 32))*1.8
alter VB4 = $&drive
let drive = (floor(trial / 32) - 2*floor(trial / 64))*1.8
alter VB5 = $&drive
let drive = (floor(trial / 64) - 2*floor(trial / 128))*1.8
alter VB6 = $&drive
let drive = (floor(trial / 128) - 2*floor(trial / 256))*1.8
alter VB7 = $&drive
stop when time = 0.001958
resume
delete all
let endpoint = length(time)-1
let cmp = v(COMP)[endpoint]
let top = v(TOP)[endpoint]
let decision = 0
if cmp >= 0.9
let code = trial
let decision = 1
end
echo 108 2 $&trial $&cmp $&top 0.49453125 $&decision >> decisions.csv
let trial = code + 2
let drive = (floor(trial / 1) - 2*floor(trial / 2))*1.8
alter VB0 = $&drive
let drive = (floor(trial / 2) - 2*floor(trial / 4))*1.8
alter VB1 = $&drive
let drive = (floor(trial / 4) - 2*floor(trial / 8))*1.8
alter VB2 = $&drive
let drive = (floor(trial / 8) - 2*floor(trial / 16))*1.8
alter VB3 = $&drive
let drive = (floor(trial / 16) - 2*floor(trial / 32))*1.8
alter VB4 = $&drive
let drive = (floor(trial / 32) - 2*floor(trial / 64))*1.8
alter VB5 = $&drive
let drive = (floor(trial / 64) - 2*floor(trial / 128))*1.8
alter VB6 = $&drive
let drive = (floor(trial / 128) - 2*floor(trial / 256))*1.8
alter VB7 = $&drive
stop when time = 0.00196
resume
delete all
let endpoint = length(time)-1
let cmp = v(COMP)[endpoint]
let top = v(TOP)[endpoint]
let decision = 0
if cmp >= 0.9
let code = trial
let decision = 1
end
echo 108 1 $&trial $&cmp $&top 0.49453125 $&decision >> decisions.csv
let trial = code + 1
let drive = (floor(trial / 1) - 2*floor(trial / 2))*1.8
alter VB0 = $&drive
let drive = (floor(trial / 2) - 2*floor(trial / 4))*1.8
alter VB1 = $&drive
let drive = (floor(trial / 4) - 2*floor(trial / 8))*1.8
alter VB2 = $&drive
let drive = (floor(trial / 8) - 2*floor(trial / 16))*1.8
alter VB3 = $&drive
let drive = (floor(trial / 16) - 2*floor(trial / 32))*1.8
alter VB4 = $&drive
let drive = (floor(trial / 32) - 2*floor(trial / 64))*1.8
alter VB5 = $&drive
let drive = (floor(trial / 64) - 2*floor(trial / 128))*1.8
alter VB6 = $&drive
let drive = (floor(trial / 128) - 2*floor(trial / 256))*1.8
alter VB7 = $&drive
stop when time = 0.001962
resume
delete all
let endpoint = length(time)-1
let cmp = v(COMP)[endpoint]
let top = v(TOP)[endpoint]
let decision = 0
if cmp >= 0.9
let code = trial
let decision = 1
end
echo 108 0 $&trial $&cmp $&top 0.49453125 $&decision >> decisions.csv
alter VIN = 0.49921875
alter VSAMPLE = 1.8
alter VB0 = 0
alter VB1 = 0
alter VB2 = 0
alter VB3 = 0
alter VB4 = 0
alter VB5 = 0
alter VB6 = 0
alter VB7 = 0
let code = 0
stop when time = 0.001964
resume
delete all
alter VSAMPLE = 0
let trial = code + 128
let drive = (floor(trial / 1) - 2*floor(trial / 2))*1.8
alter VB0 = $&drive
let drive = (floor(trial / 2) - 2*floor(trial / 4))*1.8
alter VB1 = $&drive
let drive = (floor(trial / 4) - 2*floor(trial / 8))*1.8
alter VB2 = $&drive
let drive = (floor(trial / 8) - 2*floor(trial / 16))*1.8
alter VB3 = $&drive
let drive = (floor(trial / 16) - 2*floor(trial / 32))*1.8
alter VB4 = $&drive
let drive = (floor(trial / 32) - 2*floor(trial / 64))*1.8
alter VB5 = $&drive
let drive = (floor(trial / 64) - 2*floor(trial / 128))*1.8
alter VB6 = $&drive
let drive = (floor(trial / 128) - 2*floor(trial / 256))*1.8
alter VB7 = $&drive
stop when time = 0.001966
resume
delete all
let endpoint = length(time)-1
let cmp = v(COMP)[endpoint]
let top = v(TOP)[endpoint]
let decision = 0
if cmp >= 0.9
let code = trial
let decision = 1
end
echo 109 7 $&trial $&cmp $&top 0.49921875 $&decision >> decisions.csv
let trial = code + 64
let drive = (floor(trial / 1) - 2*floor(trial / 2))*1.8
alter VB0 = $&drive
let drive = (floor(trial / 2) - 2*floor(trial / 4))*1.8
alter VB1 = $&drive
let drive = (floor(trial / 4) - 2*floor(trial / 8))*1.8
alter VB2 = $&drive
let drive = (floor(trial / 8) - 2*floor(trial / 16))*1.8
alter VB3 = $&drive
let drive = (floor(trial / 16) - 2*floor(trial / 32))*1.8
alter VB4 = $&drive
let drive = (floor(trial / 32) - 2*floor(trial / 64))*1.8
alter VB5 = $&drive
let drive = (floor(trial / 64) - 2*floor(trial / 128))*1.8
alter VB6 = $&drive
let drive = (floor(trial / 128) - 2*floor(trial / 256))*1.8
alter VB7 = $&drive
stop when time = 0.001968
resume
delete all
let endpoint = length(time)-1
let cmp = v(COMP)[endpoint]
let top = v(TOP)[endpoint]
let decision = 0
if cmp >= 0.9
let code = trial
let decision = 1
end
echo 109 6 $&trial $&cmp $&top 0.49921875 $&decision >> decisions.csv
let trial = code + 32
let drive = (floor(trial / 1) - 2*floor(trial / 2))*1.8
alter VB0 = $&drive
let drive = (floor(trial / 2) - 2*floor(trial / 4))*1.8
alter VB1 = $&drive
let drive = (floor(trial / 4) - 2*floor(trial / 8))*1.8
alter VB2 = $&drive
let drive = (floor(trial / 8) - 2*floor(trial / 16))*1.8
alter VB3 = $&drive
let drive = (floor(trial / 16) - 2*floor(trial / 32))*1.8
alter VB4 = $&drive
let drive = (floor(trial / 32) - 2*floor(trial / 64))*1.8
alter VB5 = $&drive
let drive = (floor(trial / 64) - 2*floor(trial / 128))*1.8
alter VB6 = $&drive
let drive = (floor(trial / 128) - 2*floor(trial / 256))*1.8
alter VB7 = $&drive
stop when time = 0.00197
resume
delete all
let endpoint = length(time)-1
let cmp = v(COMP)[endpoint]
let top = v(TOP)[endpoint]
let decision = 0
if cmp >= 0.9
let code = trial
let decision = 1
end
echo 109 5 $&trial $&cmp $&top 0.49921875 $&decision >> decisions.csv
let trial = code + 16
let drive = (floor(trial / 1) - 2*floor(trial / 2))*1.8
alter VB0 = $&drive
let drive = (floor(trial / 2) - 2*floor(trial / 4))*1.8
alter VB1 = $&drive
let drive = (floor(trial / 4) - 2*floor(trial / 8))*1.8
alter VB2 = $&drive
let drive = (floor(trial / 8) - 2*floor(trial / 16))*1.8
alter VB3 = $&drive
let drive = (floor(trial / 16) - 2*floor(trial / 32))*1.8
alter VB4 = $&drive
let drive = (floor(trial / 32) - 2*floor(trial / 64))*1.8
alter VB5 = $&drive
let drive = (floor(trial / 64) - 2*floor(trial / 128))*1.8
alter VB6 = $&drive
let drive = (floor(trial / 128) - 2*floor(trial / 256))*1.8
alter VB7 = $&drive
stop when time = 0.001972
resume
delete all
let endpoint = length(time)-1
let cmp = v(COMP)[endpoint]
let top = v(TOP)[endpoint]
let decision = 0
if cmp >= 0.9
let code = trial
let decision = 1
end
echo 109 4 $&trial $&cmp $&top 0.49921875 $&decision >> decisions.csv
let trial = code + 8
let drive = (floor(trial / 1) - 2*floor(trial / 2))*1.8
alter VB0 = $&drive
let drive = (floor(trial / 2) - 2*floor(trial / 4))*1.8
alter VB1 = $&drive
let drive = (floor(trial / 4) - 2*floor(trial / 8))*1.8
alter VB2 = $&drive
let drive = (floor(trial / 8) - 2*floor(trial / 16))*1.8
alter VB3 = $&drive
let drive = (floor(trial / 16) - 2*floor(trial / 32))*1.8
alter VB4 = $&drive
let drive = (floor(trial / 32) - 2*floor(trial / 64))*1.8
alter VB5 = $&drive
let drive = (floor(trial / 64) - 2*floor(trial / 128))*1.8
alter VB6 = $&drive
let drive = (floor(trial / 128) - 2*floor(trial / 256))*1.8
alter VB7 = $&drive
stop when time = 0.001974
resume
delete all
let endpoint = length(time)-1
let cmp = v(COMP)[endpoint]
let top = v(TOP)[endpoint]
let decision = 0
if cmp >= 0.9
let code = trial
let decision = 1
end
echo 109 3 $&trial $&cmp $&top 0.49921875 $&decision >> decisions.csv
let trial = code + 4
let drive = (floor(trial / 1) - 2*floor(trial / 2))*1.8
alter VB0 = $&drive
let drive = (floor(trial / 2) - 2*floor(trial / 4))*1.8
alter VB1 = $&drive
let drive = (floor(trial / 4) - 2*floor(trial / 8))*1.8
alter VB2 = $&drive
let drive = (floor(trial / 8) - 2*floor(trial / 16))*1.8
alter VB3 = $&drive
let drive = (floor(trial / 16) - 2*floor(trial / 32))*1.8
alter VB4 = $&drive
let drive = (floor(trial / 32) - 2*floor(trial / 64))*1.8
alter VB5 = $&drive
let drive = (floor(trial / 64) - 2*floor(trial / 128))*1.8
alter VB6 = $&drive
let drive = (floor(trial / 128) - 2*floor(trial / 256))*1.8
alter VB7 = $&drive
stop when time = 0.001976
resume
delete all
let endpoint = length(time)-1
let cmp = v(COMP)[endpoint]
let top = v(TOP)[endpoint]
let decision = 0
if cmp >= 0.9
let code = trial
let decision = 1
end
echo 109 2 $&trial $&cmp $&top 0.49921875 $&decision >> decisions.csv
let trial = code + 2
let drive = (floor(trial / 1) - 2*floor(trial / 2))*1.8
alter VB0 = $&drive
let drive = (floor(trial / 2) - 2*floor(trial / 4))*1.8
alter VB1 = $&drive
let drive = (floor(trial / 4) - 2*floor(trial / 8))*1.8
alter VB2 = $&drive
let drive = (floor(trial / 8) - 2*floor(trial / 16))*1.8
alter VB3 = $&drive
let drive = (floor(trial / 16) - 2*floor(trial / 32))*1.8
alter VB4 = $&drive
let drive = (floor(trial / 32) - 2*floor(trial / 64))*1.8
alter VB5 = $&drive
let drive = (floor(trial / 64) - 2*floor(trial / 128))*1.8
alter VB6 = $&drive
let drive = (floor(trial / 128) - 2*floor(trial / 256))*1.8
alter VB7 = $&drive
stop when time = 0.001978
resume
delete all
let endpoint = length(time)-1
let cmp = v(COMP)[endpoint]
let top = v(TOP)[endpoint]
let decision = 0
if cmp >= 0.9
let code = trial
let decision = 1
end
echo 109 1 $&trial $&cmp $&top 0.49921875 $&decision >> decisions.csv
let trial = code + 1
let drive = (floor(trial / 1) - 2*floor(trial / 2))*1.8
alter VB0 = $&drive
let drive = (floor(trial / 2) - 2*floor(trial / 4))*1.8
alter VB1 = $&drive
let drive = (floor(trial / 4) - 2*floor(trial / 8))*1.8
alter VB2 = $&drive
let drive = (floor(trial / 8) - 2*floor(trial / 16))*1.8
alter VB3 = $&drive
let drive = (floor(trial / 16) - 2*floor(trial / 32))*1.8
alter VB4 = $&drive
let drive = (floor(trial / 32) - 2*floor(trial / 64))*1.8
alter VB5 = $&drive
let drive = (floor(trial / 64) - 2*floor(trial / 128))*1.8
alter VB6 = $&drive
let drive = (floor(trial / 128) - 2*floor(trial / 256))*1.8
alter VB7 = $&drive
stop when time = 0.00198
resume
delete all
let endpoint = length(time)-1
let cmp = v(COMP)[endpoint]
let top = v(TOP)[endpoint]
let decision = 0
if cmp >= 0.9
let code = trial
let decision = 1
end
echo 109 0 $&trial $&cmp $&top 0.49921875 $&decision >> decisions.csv
alter VIN = 0.50390625
alter VSAMPLE = 1.8
alter VB0 = 0
alter VB1 = 0
alter VB2 = 0
alter VB3 = 0
alter VB4 = 0
alter VB5 = 0
alter VB6 = 0
alter VB7 = 0
let code = 0
stop when time = 0.001982
resume
delete all
alter VSAMPLE = 0
let trial = code + 128
let drive = (floor(trial / 1) - 2*floor(trial / 2))*1.8
alter VB0 = $&drive
let drive = (floor(trial / 2) - 2*floor(trial / 4))*1.8
alter VB1 = $&drive
let drive = (floor(trial / 4) - 2*floor(trial / 8))*1.8
alter VB2 = $&drive
let drive = (floor(trial / 8) - 2*floor(trial / 16))*1.8
alter VB3 = $&drive
let drive = (floor(trial / 16) - 2*floor(trial / 32))*1.8
alter VB4 = $&drive
let drive = (floor(trial / 32) - 2*floor(trial / 64))*1.8
alter VB5 = $&drive
let drive = (floor(trial / 64) - 2*floor(trial / 128))*1.8
alter VB6 = $&drive
let drive = (floor(trial / 128) - 2*floor(trial / 256))*1.8
alter VB7 = $&drive
stop when time = 0.001984
resume
delete all
let endpoint = length(time)-1
let cmp = v(COMP)[endpoint]
let top = v(TOP)[endpoint]
let decision = 0
if cmp >= 0.9
let code = trial
let decision = 1
end
echo 110 7 $&trial $&cmp $&top 0.50390625 $&decision >> decisions.csv
let trial = code + 64
let drive = (floor(trial / 1) - 2*floor(trial / 2))*1.8
alter VB0 = $&drive
let drive = (floor(trial / 2) - 2*floor(trial / 4))*1.8
alter VB1 = $&drive
let drive = (floor(trial / 4) - 2*floor(trial / 8))*1.8
alter VB2 = $&drive
let drive = (floor(trial / 8) - 2*floor(trial / 16))*1.8
alter VB3 = $&drive
let drive = (floor(trial / 16) - 2*floor(trial / 32))*1.8
alter VB4 = $&drive
let drive = (floor(trial / 32) - 2*floor(trial / 64))*1.8
alter VB5 = $&drive
let drive = (floor(trial / 64) - 2*floor(trial / 128))*1.8
alter VB6 = $&drive
let drive = (floor(trial / 128) - 2*floor(trial / 256))*1.8
alter VB7 = $&drive
stop when time = 0.001986
resume
delete all
let endpoint = length(time)-1
let cmp = v(COMP)[endpoint]
let top = v(TOP)[endpoint]
let decision = 0
if cmp >= 0.9
let code = trial
let decision = 1
end
echo 110 6 $&trial $&cmp $&top 0.50390625 $&decision >> decisions.csv
let trial = code + 32
let drive = (floor(trial / 1) - 2*floor(trial / 2))*1.8
alter VB0 = $&drive
let drive = (floor(trial / 2) - 2*floor(trial / 4))*1.8
alter VB1 = $&drive
let drive = (floor(trial / 4) - 2*floor(trial / 8))*1.8
alter VB2 = $&drive
let drive = (floor(trial / 8) - 2*floor(trial / 16))*1.8
alter VB3 = $&drive
let drive = (floor(trial / 16) - 2*floor(trial / 32))*1.8
alter VB4 = $&drive
let drive = (floor(trial / 32) - 2*floor(trial / 64))*1.8
alter VB5 = $&drive
let drive = (floor(trial / 64) - 2*floor(trial / 128))*1.8
alter VB6 = $&drive
let drive = (floor(trial / 128) - 2*floor(trial / 256))*1.8
alter VB7 = $&drive
stop when time = 0.001988
resume
delete all
let endpoint = length(time)-1
let cmp = v(COMP)[endpoint]
let top = v(TOP)[endpoint]
let decision = 0
if cmp >= 0.9
let code = trial
let decision = 1
end
echo 110 5 $&trial $&cmp $&top 0.50390625 $&decision >> decisions.csv
let trial = code + 16
let drive = (floor(trial / 1) - 2*floor(trial / 2))*1.8
alter VB0 = $&drive
let drive = (floor(trial / 2) - 2*floor(trial / 4))*1.8
alter VB1 = $&drive
let drive = (floor(trial / 4) - 2*floor(trial / 8))*1.8
alter VB2 = $&drive
let drive = (floor(trial / 8) - 2*floor(trial / 16))*1.8
alter VB3 = $&drive
let drive = (floor(trial / 16) - 2*floor(trial / 32))*1.8
alter VB4 = $&drive
let drive = (floor(trial / 32) - 2*floor(trial / 64))*1.8
alter VB5 = $&drive
let drive = (floor(trial / 64) - 2*floor(trial / 128))*1.8
alter VB6 = $&drive
let drive = (floor(trial / 128) - 2*floor(trial / 256))*1.8
alter VB7 = $&drive
stop when time = 0.00199
resume
delete all
let endpoint = length(time)-1
let cmp = v(COMP)[endpoint]
let top = v(TOP)[endpoint]
let decision = 0
if cmp >= 0.9
let code = trial
let decision = 1
end
echo 110 4 $&trial $&cmp $&top 0.50390625 $&decision >> decisions.csv
let trial = code + 8
let drive = (floor(trial / 1) - 2*floor(trial / 2))*1.8
alter VB0 = $&drive
let drive = (floor(trial / 2) - 2*floor(trial / 4))*1.8
alter VB1 = $&drive
let drive = (floor(trial / 4) - 2*floor(trial / 8))*1.8
alter VB2 = $&drive
let drive = (floor(trial / 8) - 2*floor(trial / 16))*1.8
alter VB3 = $&drive
let drive = (floor(trial / 16) - 2*floor(trial / 32))*1.8
alter VB4 = $&drive
let drive = (floor(trial / 32) - 2*floor(trial / 64))*1.8
alter VB5 = $&drive
let drive = (floor(trial / 64) - 2*floor(trial / 128))*1.8
alter VB6 = $&drive
let drive = (floor(trial / 128) - 2*floor(trial / 256))*1.8
alter VB7 = $&drive
stop when time = 0.001992
resume
delete all
let endpoint = length(time)-1
let cmp = v(COMP)[endpoint]
let top = v(TOP)[endpoint]
let decision = 0
if cmp >= 0.9
let code = trial
let decision = 1
end
echo 110 3 $&trial $&cmp $&top 0.50390625 $&decision >> decisions.csv
let trial = code + 4
let drive = (floor(trial / 1) - 2*floor(trial / 2))*1.8
alter VB0 = $&drive
let drive = (floor(trial / 2) - 2*floor(trial / 4))*1.8
alter VB1 = $&drive
let drive = (floor(trial / 4) - 2*floor(trial / 8))*1.8
alter VB2 = $&drive
let drive = (floor(trial / 8) - 2*floor(trial / 16))*1.8
alter VB3 = $&drive
let drive = (floor(trial / 16) - 2*floor(trial / 32))*1.8
alter VB4 = $&drive
let drive = (floor(trial / 32) - 2*floor(trial / 64))*1.8
alter VB5 = $&drive
let drive = (floor(trial / 64) - 2*floor(trial / 128))*1.8
alter VB6 = $&drive
let drive = (floor(trial / 128) - 2*floor(trial / 256))*1.8
alter VB7 = $&drive
stop when time = 0.001994
resume
delete all
let endpoint = length(time)-1
let cmp = v(COMP)[endpoint]
let top = v(TOP)[endpoint]
let decision = 0
if cmp >= 0.9
let code = trial
let decision = 1
end
echo 110 2 $&trial $&cmp $&top 0.50390625 $&decision >> decisions.csv
let trial = code + 2
let drive = (floor(trial / 1) - 2*floor(trial / 2))*1.8
alter VB0 = $&drive
let drive = (floor(trial / 2) - 2*floor(trial / 4))*1.8
alter VB1 = $&drive
let drive = (floor(trial / 4) - 2*floor(trial / 8))*1.8
alter VB2 = $&drive
let drive = (floor(trial / 8) - 2*floor(trial / 16))*1.8
alter VB3 = $&drive
let drive = (floor(trial / 16) - 2*floor(trial / 32))*1.8
alter VB4 = $&drive
let drive = (floor(trial / 32) - 2*floor(trial / 64))*1.8
alter VB5 = $&drive
let drive = (floor(trial / 64) - 2*floor(trial / 128))*1.8
alter VB6 = $&drive
let drive = (floor(trial / 128) - 2*floor(trial / 256))*1.8
alter VB7 = $&drive
stop when time = 0.001996
resume
delete all
let endpoint = length(time)-1
let cmp = v(COMP)[endpoint]
let top = v(TOP)[endpoint]
let decision = 0
if cmp >= 0.9
let code = trial
let decision = 1
end
echo 110 1 $&trial $&cmp $&top 0.50390625 $&decision >> decisions.csv
let trial = code + 1
let drive = (floor(trial / 1) - 2*floor(trial / 2))*1.8
alter VB0 = $&drive
let drive = (floor(trial / 2) - 2*floor(trial / 4))*1.8
alter VB1 = $&drive
let drive = (floor(trial / 4) - 2*floor(trial / 8))*1.8
alter VB2 = $&drive
let drive = (floor(trial / 8) - 2*floor(trial / 16))*1.8
alter VB3 = $&drive
let drive = (floor(trial / 16) - 2*floor(trial / 32))*1.8
alter VB4 = $&drive
let drive = (floor(trial / 32) - 2*floor(trial / 64))*1.8
alter VB5 = $&drive
let drive = (floor(trial / 64) - 2*floor(trial / 128))*1.8
alter VB6 = $&drive
let drive = (floor(trial / 128) - 2*floor(trial / 256))*1.8
alter VB7 = $&drive
stop when time = 0.001998
resume
delete all
let endpoint = length(time)-1
let cmp = v(COMP)[endpoint]
let top = v(TOP)[endpoint]
let decision = 0
if cmp >= 0.9
let code = trial
let decision = 1
end
echo 110 0 $&trial $&cmp $&top 0.50390625 $&decision >> decisions.csv
alter VIN = 0.50859375
alter VSAMPLE = 1.8
alter VB0 = 0
alter VB1 = 0
alter VB2 = 0
alter VB3 = 0
alter VB4 = 0
alter VB5 = 0
alter VB6 = 0
alter VB7 = 0
let code = 0
stop when time = 0.002
resume
delete all
alter VSAMPLE = 0
let trial = code + 128
let drive = (floor(trial / 1) - 2*floor(trial / 2))*1.8
alter VB0 = $&drive
let drive = (floor(trial / 2) - 2*floor(trial / 4))*1.8
alter VB1 = $&drive
let drive = (floor(trial / 4) - 2*floor(trial / 8))*1.8
alter VB2 = $&drive
let drive = (floor(trial / 8) - 2*floor(trial / 16))*1.8
alter VB3 = $&drive
let drive = (floor(trial / 16) - 2*floor(trial / 32))*1.8
alter VB4 = $&drive
let drive = (floor(trial / 32) - 2*floor(trial / 64))*1.8
alter VB5 = $&drive
let drive = (floor(trial / 64) - 2*floor(trial / 128))*1.8
alter VB6 = $&drive
let drive = (floor(trial / 128) - 2*floor(trial / 256))*1.8
alter VB7 = $&drive
stop when time = 0.002002
resume
delete all
let endpoint = length(time)-1
let cmp = v(COMP)[endpoint]
let top = v(TOP)[endpoint]
let decision = 0
if cmp >= 0.9
let code = trial
let decision = 1
end
echo 111 7 $&trial $&cmp $&top 0.50859375 $&decision >> decisions.csv
let trial = code + 64
let drive = (floor(trial / 1) - 2*floor(trial / 2))*1.8
alter VB0 = $&drive
let drive = (floor(trial / 2) - 2*floor(trial / 4))*1.8
alter VB1 = $&drive
let drive = (floor(trial / 4) - 2*floor(trial / 8))*1.8
alter VB2 = $&drive
let drive = (floor(trial / 8) - 2*floor(trial / 16))*1.8
alter VB3 = $&drive
let drive = (floor(trial / 16) - 2*floor(trial / 32))*1.8
alter VB4 = $&drive
let drive = (floor(trial / 32) - 2*floor(trial / 64))*1.8
alter VB5 = $&drive
let drive = (floor(trial / 64) - 2*floor(trial / 128))*1.8
alter VB6 = $&drive
let drive = (floor(trial / 128) - 2*floor(trial / 256))*1.8
alter VB7 = $&drive
stop when time = 0.002004
resume
delete all
let endpoint = length(time)-1
let cmp = v(COMP)[endpoint]
let top = v(TOP)[endpoint]
let decision = 0
if cmp >= 0.9
let code = trial
let decision = 1
end
echo 111 6 $&trial $&cmp $&top 0.50859375 $&decision >> decisions.csv
let trial = code + 32
let drive = (floor(trial / 1) - 2*floor(trial / 2))*1.8
alter VB0 = $&drive
let drive = (floor(trial / 2) - 2*floor(trial / 4))*1.8
alter VB1 = $&drive
let drive = (floor(trial / 4) - 2*floor(trial / 8))*1.8
alter VB2 = $&drive
let drive = (floor(trial / 8) - 2*floor(trial / 16))*1.8
alter VB3 = $&drive
let drive = (floor(trial / 16) - 2*floor(trial / 32))*1.8
alter VB4 = $&drive
let drive = (floor(trial / 32) - 2*floor(trial / 64))*1.8
alter VB5 = $&drive
let drive = (floor(trial / 64) - 2*floor(trial / 128))*1.8
alter VB6 = $&drive
let drive = (floor(trial / 128) - 2*floor(trial / 256))*1.8
alter VB7 = $&drive
stop when time = 0.002006
resume
delete all
let endpoint = length(time)-1
let cmp = v(COMP)[endpoint]
let top = v(TOP)[endpoint]
let decision = 0
if cmp >= 0.9
let code = trial
let decision = 1
end
echo 111 5 $&trial $&cmp $&top 0.50859375 $&decision >> decisions.csv
let trial = code + 16
let drive = (floor(trial / 1) - 2*floor(trial / 2))*1.8
alter VB0 = $&drive
let drive = (floor(trial / 2) - 2*floor(trial / 4))*1.8
alter VB1 = $&drive
let drive = (floor(trial / 4) - 2*floor(trial / 8))*1.8
alter VB2 = $&drive
let drive = (floor(trial / 8) - 2*floor(trial / 16))*1.8
alter VB3 = $&drive
let drive = (floor(trial / 16) - 2*floor(trial / 32))*1.8
alter VB4 = $&drive
let drive = (floor(trial / 32) - 2*floor(trial / 64))*1.8
alter VB5 = $&drive
let drive = (floor(trial / 64) - 2*floor(trial / 128))*1.8
alter VB6 = $&drive
let drive = (floor(trial / 128) - 2*floor(trial / 256))*1.8
alter VB7 = $&drive
stop when time = 0.002008
resume
delete all
let endpoint = length(time)-1
let cmp = v(COMP)[endpoint]
let top = v(TOP)[endpoint]
let decision = 0
if cmp >= 0.9
let code = trial
let decision = 1
end
echo 111 4 $&trial $&cmp $&top 0.50859375 $&decision >> decisions.csv
let trial = code + 8
let drive = (floor(trial / 1) - 2*floor(trial / 2))*1.8
alter VB0 = $&drive
let drive = (floor(trial / 2) - 2*floor(trial / 4))*1.8
alter VB1 = $&drive
let drive = (floor(trial / 4) - 2*floor(trial / 8))*1.8
alter VB2 = $&drive
let drive = (floor(trial / 8) - 2*floor(trial / 16))*1.8
alter VB3 = $&drive
let drive = (floor(trial / 16) - 2*floor(trial / 32))*1.8
alter VB4 = $&drive
let drive = (floor(trial / 32) - 2*floor(trial / 64))*1.8
alter VB5 = $&drive
let drive = (floor(trial / 64) - 2*floor(trial / 128))*1.8
alter VB6 = $&drive
let drive = (floor(trial / 128) - 2*floor(trial / 256))*1.8
alter VB7 = $&drive
stop when time = 0.00201
resume
delete all
let endpoint = length(time)-1
let cmp = v(COMP)[endpoint]
let top = v(TOP)[endpoint]
let decision = 0
if cmp >= 0.9
let code = trial
let decision = 1
end
echo 111 3 $&trial $&cmp $&top 0.50859375 $&decision >> decisions.csv
let trial = code + 4
let drive = (floor(trial / 1) - 2*floor(trial / 2))*1.8
alter VB0 = $&drive
let drive = (floor(trial / 2) - 2*floor(trial / 4))*1.8
alter VB1 = $&drive
let drive = (floor(trial / 4) - 2*floor(trial / 8))*1.8
alter VB2 = $&drive
let drive = (floor(trial / 8) - 2*floor(trial / 16))*1.8
alter VB3 = $&drive
let drive = (floor(trial / 16) - 2*floor(trial / 32))*1.8
alter VB4 = $&drive
let drive = (floor(trial / 32) - 2*floor(trial / 64))*1.8
alter VB5 = $&drive
let drive = (floor(trial / 64) - 2*floor(trial / 128))*1.8
alter VB6 = $&drive
let drive = (floor(trial / 128) - 2*floor(trial / 256))*1.8
alter VB7 = $&drive
stop when time = 0.002012
resume
delete all
let endpoint = length(time)-1
let cmp = v(COMP)[endpoint]
let top = v(TOP)[endpoint]
let decision = 0
if cmp >= 0.9
let code = trial
let decision = 1
end
echo 111 2 $&trial $&cmp $&top 0.50859375 $&decision >> decisions.csv
let trial = code + 2
let drive = (floor(trial / 1) - 2*floor(trial / 2))*1.8
alter VB0 = $&drive
let drive = (floor(trial / 2) - 2*floor(trial / 4))*1.8
alter VB1 = $&drive
let drive = (floor(trial / 4) - 2*floor(trial / 8))*1.8
alter VB2 = $&drive
let drive = (floor(trial / 8) - 2*floor(trial / 16))*1.8
alter VB3 = $&drive
let drive = (floor(trial / 16) - 2*floor(trial / 32))*1.8
alter VB4 = $&drive
let drive = (floor(trial / 32) - 2*floor(trial / 64))*1.8
alter VB5 = $&drive
let drive = (floor(trial / 64) - 2*floor(trial / 128))*1.8
alter VB6 = $&drive
let drive = (floor(trial / 128) - 2*floor(trial / 256))*1.8
alter VB7 = $&drive
stop when time = 0.002014
resume
delete all
let endpoint = length(time)-1
let cmp = v(COMP)[endpoint]
let top = v(TOP)[endpoint]
let decision = 0
if cmp >= 0.9
let code = trial
let decision = 1
end
echo 111 1 $&trial $&cmp $&top 0.50859375 $&decision >> decisions.csv
let trial = code + 1
let drive = (floor(trial / 1) - 2*floor(trial / 2))*1.8
alter VB0 = $&drive
let drive = (floor(trial / 2) - 2*floor(trial / 4))*1.8
alter VB1 = $&drive
let drive = (floor(trial / 4) - 2*floor(trial / 8))*1.8
alter VB2 = $&drive
let drive = (floor(trial / 8) - 2*floor(trial / 16))*1.8
alter VB3 = $&drive
let drive = (floor(trial / 16) - 2*floor(trial / 32))*1.8
alter VB4 = $&drive
let drive = (floor(trial / 32) - 2*floor(trial / 64))*1.8
alter VB5 = $&drive
let drive = (floor(trial / 64) - 2*floor(trial / 128))*1.8
alter VB6 = $&drive
let drive = (floor(trial / 128) - 2*floor(trial / 256))*1.8
alter VB7 = $&drive
stop when time = 0.002016
resume
delete all
let endpoint = length(time)-1
let cmp = v(COMP)[endpoint]
let top = v(TOP)[endpoint]
let decision = 0
if cmp >= 0.9
let code = trial
let decision = 1
end
echo 111 0 $&trial $&cmp $&top 0.50859375 $&decision >> decisions.csv
alter VIN = 0.51328125
alter VSAMPLE = 1.8
alter VB0 = 0
alter VB1 = 0
alter VB2 = 0
alter VB3 = 0
alter VB4 = 0
alter VB5 = 0
alter VB6 = 0
alter VB7 = 0
let code = 0
stop when time = 0.002018
resume
delete all
alter VSAMPLE = 0
let trial = code + 128
let drive = (floor(trial / 1) - 2*floor(trial / 2))*1.8
alter VB0 = $&drive
let drive = (floor(trial / 2) - 2*floor(trial / 4))*1.8
alter VB1 = $&drive
let drive = (floor(trial / 4) - 2*floor(trial / 8))*1.8
alter VB2 = $&drive
let drive = (floor(trial / 8) - 2*floor(trial / 16))*1.8
alter VB3 = $&drive
let drive = (floor(trial / 16) - 2*floor(trial / 32))*1.8
alter VB4 = $&drive
let drive = (floor(trial / 32) - 2*floor(trial / 64))*1.8
alter VB5 = $&drive
let drive = (floor(trial / 64) - 2*floor(trial / 128))*1.8
alter VB6 = $&drive
let drive = (floor(trial / 128) - 2*floor(trial / 256))*1.8
alter VB7 = $&drive
stop when time = 0.00202
resume
delete all
let endpoint = length(time)-1
let cmp = v(COMP)[endpoint]
let top = v(TOP)[endpoint]
let decision = 0
if cmp >= 0.9
let code = trial
let decision = 1
end
echo 112 7 $&trial $&cmp $&top 0.51328125 $&decision >> decisions.csv
let trial = code + 64
let drive = (floor(trial / 1) - 2*floor(trial / 2))*1.8
alter VB0 = $&drive
let drive = (floor(trial / 2) - 2*floor(trial / 4))*1.8
alter VB1 = $&drive
let drive = (floor(trial / 4) - 2*floor(trial / 8))*1.8
alter VB2 = $&drive
let drive = (floor(trial / 8) - 2*floor(trial / 16))*1.8
alter VB3 = $&drive
let drive = (floor(trial / 16) - 2*floor(trial / 32))*1.8
alter VB4 = $&drive
let drive = (floor(trial / 32) - 2*floor(trial / 64))*1.8
alter VB5 = $&drive
let drive = (floor(trial / 64) - 2*floor(trial / 128))*1.8
alter VB6 = $&drive
let drive = (floor(trial / 128) - 2*floor(trial / 256))*1.8
alter VB7 = $&drive
stop when time = 0.002022
resume
delete all
let endpoint = length(time)-1
let cmp = v(COMP)[endpoint]
let top = v(TOP)[endpoint]
let decision = 0
if cmp >= 0.9
let code = trial
let decision = 1
end
echo 112 6 $&trial $&cmp $&top 0.51328125 $&decision >> decisions.csv
let trial = code + 32
let drive = (floor(trial / 1) - 2*floor(trial / 2))*1.8
alter VB0 = $&drive
let drive = (floor(trial / 2) - 2*floor(trial / 4))*1.8
alter VB1 = $&drive
let drive = (floor(trial / 4) - 2*floor(trial / 8))*1.8
alter VB2 = $&drive
let drive = (floor(trial / 8) - 2*floor(trial / 16))*1.8
alter VB3 = $&drive
let drive = (floor(trial / 16) - 2*floor(trial / 32))*1.8
alter VB4 = $&drive
let drive = (floor(trial / 32) - 2*floor(trial / 64))*1.8
alter VB5 = $&drive
let drive = (floor(trial / 64) - 2*floor(trial / 128))*1.8
alter VB6 = $&drive
let drive = (floor(trial / 128) - 2*floor(trial / 256))*1.8
alter VB7 = $&drive
stop when time = 0.002024
resume
delete all
let endpoint = length(time)-1
let cmp = v(COMP)[endpoint]
let top = v(TOP)[endpoint]
let decision = 0
if cmp >= 0.9
let code = trial
let decision = 1
end
echo 112 5 $&trial $&cmp $&top 0.51328125 $&decision >> decisions.csv
let trial = code + 16
let drive = (floor(trial / 1) - 2*floor(trial / 2))*1.8
alter VB0 = $&drive
let drive = (floor(trial / 2) - 2*floor(trial / 4))*1.8
alter VB1 = $&drive
let drive = (floor(trial / 4) - 2*floor(trial / 8))*1.8
alter VB2 = $&drive
let drive = (floor(trial / 8) - 2*floor(trial / 16))*1.8
alter VB3 = $&drive
let drive = (floor(trial / 16) - 2*floor(trial / 32))*1.8
alter VB4 = $&drive
let drive = (floor(trial / 32) - 2*floor(trial / 64))*1.8
alter VB5 = $&drive
let drive = (floor(trial / 64) - 2*floor(trial / 128))*1.8
alter VB6 = $&drive
let drive = (floor(trial / 128) - 2*floor(trial / 256))*1.8
alter VB7 = $&drive
stop when time = 0.002026
resume
delete all
let endpoint = length(time)-1
let cmp = v(COMP)[endpoint]
let top = v(TOP)[endpoint]
let decision = 0
if cmp >= 0.9
let code = trial
let decision = 1
end
echo 112 4 $&trial $&cmp $&top 0.51328125 $&decision >> decisions.csv
let trial = code + 8
let drive = (floor(trial / 1) - 2*floor(trial / 2))*1.8
alter VB0 = $&drive
let drive = (floor(trial / 2) - 2*floor(trial / 4))*1.8
alter VB1 = $&drive
let drive = (floor(trial / 4) - 2*floor(trial / 8))*1.8
alter VB2 = $&drive
let drive = (floor(trial / 8) - 2*floor(trial / 16))*1.8
alter VB3 = $&drive
let drive = (floor(trial / 16) - 2*floor(trial / 32))*1.8
alter VB4 = $&drive
let drive = (floor(trial / 32) - 2*floor(trial / 64))*1.8
alter VB5 = $&drive
let drive = (floor(trial / 64) - 2*floor(trial / 128))*1.8
alter VB6 = $&drive
let drive = (floor(trial / 128) - 2*floor(trial / 256))*1.8
alter VB7 = $&drive
stop when time = 0.002028
resume
delete all
let endpoint = length(time)-1
let cmp = v(COMP)[endpoint]
let top = v(TOP)[endpoint]
let decision = 0
if cmp >= 0.9
let code = trial
let decision = 1
end
echo 112 3 $&trial $&cmp $&top 0.51328125 $&decision >> decisions.csv
let trial = code + 4
let drive = (floor(trial / 1) - 2*floor(trial / 2))*1.8
alter VB0 = $&drive
let drive = (floor(trial / 2) - 2*floor(trial / 4))*1.8
alter VB1 = $&drive
let drive = (floor(trial / 4) - 2*floor(trial / 8))*1.8
alter VB2 = $&drive
let drive = (floor(trial / 8) - 2*floor(trial / 16))*1.8
alter VB3 = $&drive
let drive = (floor(trial / 16) - 2*floor(trial / 32))*1.8
alter VB4 = $&drive
let drive = (floor(trial / 32) - 2*floor(trial / 64))*1.8
alter VB5 = $&drive
let drive = (floor(trial / 64) - 2*floor(trial / 128))*1.8
alter VB6 = $&drive
let drive = (floor(trial / 128) - 2*floor(trial / 256))*1.8
alter VB7 = $&drive
stop when time = 0.00203
resume
delete all
let endpoint = length(time)-1
let cmp = v(COMP)[endpoint]
let top = v(TOP)[endpoint]
let decision = 0
if cmp >= 0.9
let code = trial
let decision = 1
end
echo 112 2 $&trial $&cmp $&top 0.51328125 $&decision >> decisions.csv
let trial = code + 2
let drive = (floor(trial / 1) - 2*floor(trial / 2))*1.8
alter VB0 = $&drive
let drive = (floor(trial / 2) - 2*floor(trial / 4))*1.8
alter VB1 = $&drive
let drive = (floor(trial / 4) - 2*floor(trial / 8))*1.8
alter VB2 = $&drive
let drive = (floor(trial / 8) - 2*floor(trial / 16))*1.8
alter VB3 = $&drive
let drive = (floor(trial / 16) - 2*floor(trial / 32))*1.8
alter VB4 = $&drive
let drive = (floor(trial / 32) - 2*floor(trial / 64))*1.8
alter VB5 = $&drive
let drive = (floor(trial / 64) - 2*floor(trial / 128))*1.8
alter VB6 = $&drive
let drive = (floor(trial / 128) - 2*floor(trial / 256))*1.8
alter VB7 = $&drive
stop when time = 0.002032
resume
delete all
let endpoint = length(time)-1
let cmp = v(COMP)[endpoint]
let top = v(TOP)[endpoint]
let decision = 0
if cmp >= 0.9
let code = trial
let decision = 1
end
echo 112 1 $&trial $&cmp $&top 0.51328125 $&decision >> decisions.csv
let trial = code + 1
let drive = (floor(trial / 1) - 2*floor(trial / 2))*1.8
alter VB0 = $&drive
let drive = (floor(trial / 2) - 2*floor(trial / 4))*1.8
alter VB1 = $&drive
let drive = (floor(trial / 4) - 2*floor(trial / 8))*1.8
alter VB2 = $&drive
let drive = (floor(trial / 8) - 2*floor(trial / 16))*1.8
alter VB3 = $&drive
let drive = (floor(trial / 16) - 2*floor(trial / 32))*1.8
alter VB4 = $&drive
let drive = (floor(trial / 32) - 2*floor(trial / 64))*1.8
alter VB5 = $&drive
let drive = (floor(trial / 64) - 2*floor(trial / 128))*1.8
alter VB6 = $&drive
let drive = (floor(trial / 128) - 2*floor(trial / 256))*1.8
alter VB7 = $&drive
stop when time = 0.002034
resume
delete all
let endpoint = length(time)-1
let cmp = v(COMP)[endpoint]
let top = v(TOP)[endpoint]
let decision = 0
if cmp >= 0.9
let code = trial
let decision = 1
end
echo 112 0 $&trial $&cmp $&top 0.51328125 $&decision >> decisions.csv
alter VIN = 0.51796875
alter VSAMPLE = 1.8
alter VB0 = 0
alter VB1 = 0
alter VB2 = 0
alter VB3 = 0
alter VB4 = 0
alter VB5 = 0
alter VB6 = 0
alter VB7 = 0
let code = 0
stop when time = 0.002036
resume
delete all
alter VSAMPLE = 0
let trial = code + 128
let drive = (floor(trial / 1) - 2*floor(trial / 2))*1.8
alter VB0 = $&drive
let drive = (floor(trial / 2) - 2*floor(trial / 4))*1.8
alter VB1 = $&drive
let drive = (floor(trial / 4) - 2*floor(trial / 8))*1.8
alter VB2 = $&drive
let drive = (floor(trial / 8) - 2*floor(trial / 16))*1.8
alter VB3 = $&drive
let drive = (floor(trial / 16) - 2*floor(trial / 32))*1.8
alter VB4 = $&drive
let drive = (floor(trial / 32) - 2*floor(trial / 64))*1.8
alter VB5 = $&drive
let drive = (floor(trial / 64) - 2*floor(trial / 128))*1.8
alter VB6 = $&drive
let drive = (floor(trial / 128) - 2*floor(trial / 256))*1.8
alter VB7 = $&drive
stop when time = 0.002038
resume
delete all
let endpoint = length(time)-1
let cmp = v(COMP)[endpoint]
let top = v(TOP)[endpoint]
let decision = 0
if cmp >= 0.9
let code = trial
let decision = 1
end
echo 113 7 $&trial $&cmp $&top 0.51796875 $&decision >> decisions.csv
let trial = code + 64
let drive = (floor(trial / 1) - 2*floor(trial / 2))*1.8
alter VB0 = $&drive
let drive = (floor(trial / 2) - 2*floor(trial / 4))*1.8
alter VB1 = $&drive
let drive = (floor(trial / 4) - 2*floor(trial / 8))*1.8
alter VB2 = $&drive
let drive = (floor(trial / 8) - 2*floor(trial / 16))*1.8
alter VB3 = $&drive
let drive = (floor(trial / 16) - 2*floor(trial / 32))*1.8
alter VB4 = $&drive
let drive = (floor(trial / 32) - 2*floor(trial / 64))*1.8
alter VB5 = $&drive
let drive = (floor(trial / 64) - 2*floor(trial / 128))*1.8
alter VB6 = $&drive
let drive = (floor(trial / 128) - 2*floor(trial / 256))*1.8
alter VB7 = $&drive
stop when time = 0.00204
resume
delete all
let endpoint = length(time)-1
let cmp = v(COMP)[endpoint]
let top = v(TOP)[endpoint]
let decision = 0
if cmp >= 0.9
let code = trial
let decision = 1
end
echo 113 6 $&trial $&cmp $&top 0.51796875 $&decision >> decisions.csv
let trial = code + 32
let drive = (floor(trial / 1) - 2*floor(trial / 2))*1.8
alter VB0 = $&drive
let drive = (floor(trial / 2) - 2*floor(trial / 4))*1.8
alter VB1 = $&drive
let drive = (floor(trial / 4) - 2*floor(trial / 8))*1.8
alter VB2 = $&drive
let drive = (floor(trial / 8) - 2*floor(trial / 16))*1.8
alter VB3 = $&drive
let drive = (floor(trial / 16) - 2*floor(trial / 32))*1.8
alter VB4 = $&drive
let drive = (floor(trial / 32) - 2*floor(trial / 64))*1.8
alter VB5 = $&drive
let drive = (floor(trial / 64) - 2*floor(trial / 128))*1.8
alter VB6 = $&drive
let drive = (floor(trial / 128) - 2*floor(trial / 256))*1.8
alter VB7 = $&drive
stop when time = 0.002042
resume
delete all
let endpoint = length(time)-1
let cmp = v(COMP)[endpoint]
let top = v(TOP)[endpoint]
let decision = 0
if cmp >= 0.9
let code = trial
let decision = 1
end
echo 113 5 $&trial $&cmp $&top 0.51796875 $&decision >> decisions.csv
let trial = code + 16
let drive = (floor(trial / 1) - 2*floor(trial / 2))*1.8
alter VB0 = $&drive
let drive = (floor(trial / 2) - 2*floor(trial / 4))*1.8
alter VB1 = $&drive
let drive = (floor(trial / 4) - 2*floor(trial / 8))*1.8
alter VB2 = $&drive
let drive = (floor(trial / 8) - 2*floor(trial / 16))*1.8
alter VB3 = $&drive
let drive = (floor(trial / 16) - 2*floor(trial / 32))*1.8
alter VB4 = $&drive
let drive = (floor(trial / 32) - 2*floor(trial / 64))*1.8
alter VB5 = $&drive
let drive = (floor(trial / 64) - 2*floor(trial / 128))*1.8
alter VB6 = $&drive
let drive = (floor(trial / 128) - 2*floor(trial / 256))*1.8
alter VB7 = $&drive
stop when time = 0.002044
resume
delete all
let endpoint = length(time)-1
let cmp = v(COMP)[endpoint]
let top = v(TOP)[endpoint]
let decision = 0
if cmp >= 0.9
let code = trial
let decision = 1
end
echo 113 4 $&trial $&cmp $&top 0.51796875 $&decision >> decisions.csv
let trial = code + 8
let drive = (floor(trial / 1) - 2*floor(trial / 2))*1.8
alter VB0 = $&drive
let drive = (floor(trial / 2) - 2*floor(trial / 4))*1.8
alter VB1 = $&drive
let drive = (floor(trial / 4) - 2*floor(trial / 8))*1.8
alter VB2 = $&drive
let drive = (floor(trial / 8) - 2*floor(trial / 16))*1.8
alter VB3 = $&drive
let drive = (floor(trial / 16) - 2*floor(trial / 32))*1.8
alter VB4 = $&drive
let drive = (floor(trial / 32) - 2*floor(trial / 64))*1.8
alter VB5 = $&drive
let drive = (floor(trial / 64) - 2*floor(trial / 128))*1.8
alter VB6 = $&drive
let drive = (floor(trial / 128) - 2*floor(trial / 256))*1.8
alter VB7 = $&drive
stop when time = 0.002046
resume
delete all
let endpoint = length(time)-1
let cmp = v(COMP)[endpoint]
let top = v(TOP)[endpoint]
let decision = 0
if cmp >= 0.9
let code = trial
let decision = 1
end
echo 113 3 $&trial $&cmp $&top 0.51796875 $&decision >> decisions.csv
let trial = code + 4
let drive = (floor(trial / 1) - 2*floor(trial / 2))*1.8
alter VB0 = $&drive
let drive = (floor(trial / 2) - 2*floor(trial / 4))*1.8
alter VB1 = $&drive
let drive = (floor(trial / 4) - 2*floor(trial / 8))*1.8
alter VB2 = $&drive
let drive = (floor(trial / 8) - 2*floor(trial / 16))*1.8
alter VB3 = $&drive
let drive = (floor(trial / 16) - 2*floor(trial / 32))*1.8
alter VB4 = $&drive
let drive = (floor(trial / 32) - 2*floor(trial / 64))*1.8
alter VB5 = $&drive
let drive = (floor(trial / 64) - 2*floor(trial / 128))*1.8
alter VB6 = $&drive
let drive = (floor(trial / 128) - 2*floor(trial / 256))*1.8
alter VB7 = $&drive
stop when time = 0.002048
resume
delete all
let endpoint = length(time)-1
let cmp = v(COMP)[endpoint]
let top = v(TOP)[endpoint]
let decision = 0
if cmp >= 0.9
let code = trial
let decision = 1
end
echo 113 2 $&trial $&cmp $&top 0.51796875 $&decision >> decisions.csv
let trial = code + 2
let drive = (floor(trial / 1) - 2*floor(trial / 2))*1.8
alter VB0 = $&drive
let drive = (floor(trial / 2) - 2*floor(trial / 4))*1.8
alter VB1 = $&drive
let drive = (floor(trial / 4) - 2*floor(trial / 8))*1.8
alter VB2 = $&drive
let drive = (floor(trial / 8) - 2*floor(trial / 16))*1.8
alter VB3 = $&drive
let drive = (floor(trial / 16) - 2*floor(trial / 32))*1.8
alter VB4 = $&drive
let drive = (floor(trial / 32) - 2*floor(trial / 64))*1.8
alter VB5 = $&drive
let drive = (floor(trial / 64) - 2*floor(trial / 128))*1.8
alter VB6 = $&drive
let drive = (floor(trial / 128) - 2*floor(trial / 256))*1.8
alter VB7 = $&drive
stop when time = 0.00205
resume
delete all
let endpoint = length(time)-1
let cmp = v(COMP)[endpoint]
let top = v(TOP)[endpoint]
let decision = 0
if cmp >= 0.9
let code = trial
let decision = 1
end
echo 113 1 $&trial $&cmp $&top 0.51796875 $&decision >> decisions.csv
let trial = code + 1
let drive = (floor(trial / 1) - 2*floor(trial / 2))*1.8
alter VB0 = $&drive
let drive = (floor(trial / 2) - 2*floor(trial / 4))*1.8
alter VB1 = $&drive
let drive = (floor(trial / 4) - 2*floor(trial / 8))*1.8
alter VB2 = $&drive
let drive = (floor(trial / 8) - 2*floor(trial / 16))*1.8
alter VB3 = $&drive
let drive = (floor(trial / 16) - 2*floor(trial / 32))*1.8
alter VB4 = $&drive
let drive = (floor(trial / 32) - 2*floor(trial / 64))*1.8
alter VB5 = $&drive
let drive = (floor(trial / 64) - 2*floor(trial / 128))*1.8
alter VB6 = $&drive
let drive = (floor(trial / 128) - 2*floor(trial / 256))*1.8
alter VB7 = $&drive
stop when time = 0.002052
resume
delete all
let endpoint = length(time)-1
let cmp = v(COMP)[endpoint]
let top = v(TOP)[endpoint]
let decision = 0
if cmp >= 0.9
let code = trial
let decision = 1
end
echo 113 0 $&trial $&cmp $&top 0.51796875 $&decision >> decisions.csv
alter VIN = 0.52265625
alter VSAMPLE = 1.8
alter VB0 = 0
alter VB1 = 0
alter VB2 = 0
alter VB3 = 0
alter VB4 = 0
alter VB5 = 0
alter VB6 = 0
alter VB7 = 0
let code = 0
stop when time = 0.002054
resume
delete all
alter VSAMPLE = 0
let trial = code + 128
let drive = (floor(trial / 1) - 2*floor(trial / 2))*1.8
alter VB0 = $&drive
let drive = (floor(trial / 2) - 2*floor(trial / 4))*1.8
alter VB1 = $&drive
let drive = (floor(trial / 4) - 2*floor(trial / 8))*1.8
alter VB2 = $&drive
let drive = (floor(trial / 8) - 2*floor(trial / 16))*1.8
alter VB3 = $&drive
let drive = (floor(trial / 16) - 2*floor(trial / 32))*1.8
alter VB4 = $&drive
let drive = (floor(trial / 32) - 2*floor(trial / 64))*1.8
alter VB5 = $&drive
let drive = (floor(trial / 64) - 2*floor(trial / 128))*1.8
alter VB6 = $&drive
let drive = (floor(trial / 128) - 2*floor(trial / 256))*1.8
alter VB7 = $&drive
stop when time = 0.002056
resume
delete all
let endpoint = length(time)-1
let cmp = v(COMP)[endpoint]
let top = v(TOP)[endpoint]
let decision = 0
if cmp >= 0.9
let code = trial
let decision = 1
end
echo 114 7 $&trial $&cmp $&top 0.52265625 $&decision >> decisions.csv
let trial = code + 64
let drive = (floor(trial / 1) - 2*floor(trial / 2))*1.8
alter VB0 = $&drive
let drive = (floor(trial / 2) - 2*floor(trial / 4))*1.8
alter VB1 = $&drive
let drive = (floor(trial / 4) - 2*floor(trial / 8))*1.8
alter VB2 = $&drive
let drive = (floor(trial / 8) - 2*floor(trial / 16))*1.8
alter VB3 = $&drive
let drive = (floor(trial / 16) - 2*floor(trial / 32))*1.8
alter VB4 = $&drive
let drive = (floor(trial / 32) - 2*floor(trial / 64))*1.8
alter VB5 = $&drive
let drive = (floor(trial / 64) - 2*floor(trial / 128))*1.8
alter VB6 = $&drive
let drive = (floor(trial / 128) - 2*floor(trial / 256))*1.8
alter VB7 = $&drive
stop when time = 0.002058
resume
delete all
let endpoint = length(time)-1
let cmp = v(COMP)[endpoint]
let top = v(TOP)[endpoint]
let decision = 0
if cmp >= 0.9
let code = trial
let decision = 1
end
echo 114 6 $&trial $&cmp $&top 0.52265625 $&decision >> decisions.csv
let trial = code + 32
let drive = (floor(trial / 1) - 2*floor(trial / 2))*1.8
alter VB0 = $&drive
let drive = (floor(trial / 2) - 2*floor(trial / 4))*1.8
alter VB1 = $&drive
let drive = (floor(trial / 4) - 2*floor(trial / 8))*1.8
alter VB2 = $&drive
let drive = (floor(trial / 8) - 2*floor(trial / 16))*1.8
alter VB3 = $&drive
let drive = (floor(trial / 16) - 2*floor(trial / 32))*1.8
alter VB4 = $&drive
let drive = (floor(trial / 32) - 2*floor(trial / 64))*1.8
alter VB5 = $&drive
let drive = (floor(trial / 64) - 2*floor(trial / 128))*1.8
alter VB6 = $&drive
let drive = (floor(trial / 128) - 2*floor(trial / 256))*1.8
alter VB7 = $&drive
stop when time = 0.00206
resume
delete all
let endpoint = length(time)-1
let cmp = v(COMP)[endpoint]
let top = v(TOP)[endpoint]
let decision = 0
if cmp >= 0.9
let code = trial
let decision = 1
end
echo 114 5 $&trial $&cmp $&top 0.52265625 $&decision >> decisions.csv
let trial = code + 16
let drive = (floor(trial / 1) - 2*floor(trial / 2))*1.8
alter VB0 = $&drive
let drive = (floor(trial / 2) - 2*floor(trial / 4))*1.8
alter VB1 = $&drive
let drive = (floor(trial / 4) - 2*floor(trial / 8))*1.8
alter VB2 = $&drive
let drive = (floor(trial / 8) - 2*floor(trial / 16))*1.8
alter VB3 = $&drive
let drive = (floor(trial / 16) - 2*floor(trial / 32))*1.8
alter VB4 = $&drive
let drive = (floor(trial / 32) - 2*floor(trial / 64))*1.8
alter VB5 = $&drive
let drive = (floor(trial / 64) - 2*floor(trial / 128))*1.8
alter VB6 = $&drive
let drive = (floor(trial / 128) - 2*floor(trial / 256))*1.8
alter VB7 = $&drive
stop when time = 0.002062
resume
delete all
let endpoint = length(time)-1
let cmp = v(COMP)[endpoint]
let top = v(TOP)[endpoint]
let decision = 0
if cmp >= 0.9
let code = trial
let decision = 1
end
echo 114 4 $&trial $&cmp $&top 0.52265625 $&decision >> decisions.csv
let trial = code + 8
let drive = (floor(trial / 1) - 2*floor(trial / 2))*1.8
alter VB0 = $&drive
let drive = (floor(trial / 2) - 2*floor(trial / 4))*1.8
alter VB1 = $&drive
let drive = (floor(trial / 4) - 2*floor(trial / 8))*1.8
alter VB2 = $&drive
let drive = (floor(trial / 8) - 2*floor(trial / 16))*1.8
alter VB3 = $&drive
let drive = (floor(trial / 16) - 2*floor(trial / 32))*1.8
alter VB4 = $&drive
let drive = (floor(trial / 32) - 2*floor(trial / 64))*1.8
alter VB5 = $&drive
let drive = (floor(trial / 64) - 2*floor(trial / 128))*1.8
alter VB6 = $&drive
let drive = (floor(trial / 128) - 2*floor(trial / 256))*1.8
alter VB7 = $&drive
stop when time = 0.002064
resume
delete all
let endpoint = length(time)-1
let cmp = v(COMP)[endpoint]
let top = v(TOP)[endpoint]
let decision = 0
if cmp >= 0.9
let code = trial
let decision = 1
end
echo 114 3 $&trial $&cmp $&top 0.52265625 $&decision >> decisions.csv
let trial = code + 4
let drive = (floor(trial / 1) - 2*floor(trial / 2))*1.8
alter VB0 = $&drive
let drive = (floor(trial / 2) - 2*floor(trial / 4))*1.8
alter VB1 = $&drive
let drive = (floor(trial / 4) - 2*floor(trial / 8))*1.8
alter VB2 = $&drive
let drive = (floor(trial / 8) - 2*floor(trial / 16))*1.8
alter VB3 = $&drive
let drive = (floor(trial / 16) - 2*floor(trial / 32))*1.8
alter VB4 = $&drive
let drive = (floor(trial / 32) - 2*floor(trial / 64))*1.8
alter VB5 = $&drive
let drive = (floor(trial / 64) - 2*floor(trial / 128))*1.8
alter VB6 = $&drive
let drive = (floor(trial / 128) - 2*floor(trial / 256))*1.8
alter VB7 = $&drive
stop when time = 0.002066
resume
delete all
let endpoint = length(time)-1
let cmp = v(COMP)[endpoint]
let top = v(TOP)[endpoint]
let decision = 0
if cmp >= 0.9
let code = trial
let decision = 1
end
echo 114 2 $&trial $&cmp $&top 0.52265625 $&decision >> decisions.csv
let trial = code + 2
let drive = (floor(trial / 1) - 2*floor(trial / 2))*1.8
alter VB0 = $&drive
let drive = (floor(trial / 2) - 2*floor(trial / 4))*1.8
alter VB1 = $&drive
let drive = (floor(trial / 4) - 2*floor(trial / 8))*1.8
alter VB2 = $&drive
let drive = (floor(trial / 8) - 2*floor(trial / 16))*1.8
alter VB3 = $&drive
let drive = (floor(trial / 16) - 2*floor(trial / 32))*1.8
alter VB4 = $&drive
let drive = (floor(trial / 32) - 2*floor(trial / 64))*1.8
alter VB5 = $&drive
let drive = (floor(trial / 64) - 2*floor(trial / 128))*1.8
alter VB6 = $&drive
let drive = (floor(trial / 128) - 2*floor(trial / 256))*1.8
alter VB7 = $&drive
stop when time = 0.002068
resume
delete all
let endpoint = length(time)-1
let cmp = v(COMP)[endpoint]
let top = v(TOP)[endpoint]
let decision = 0
if cmp >= 0.9
let code = trial
let decision = 1
end
echo 114 1 $&trial $&cmp $&top 0.52265625 $&decision >> decisions.csv
let trial = code + 1
let drive = (floor(trial / 1) - 2*floor(trial / 2))*1.8
alter VB0 = $&drive
let drive = (floor(trial / 2) - 2*floor(trial / 4))*1.8
alter VB1 = $&drive
let drive = (floor(trial / 4) - 2*floor(trial / 8))*1.8
alter VB2 = $&drive
let drive = (floor(trial / 8) - 2*floor(trial / 16))*1.8
alter VB3 = $&drive
let drive = (floor(trial / 16) - 2*floor(trial / 32))*1.8
alter VB4 = $&drive
let drive = (floor(trial / 32) - 2*floor(trial / 64))*1.8
alter VB5 = $&drive
let drive = (floor(trial / 64) - 2*floor(trial / 128))*1.8
alter VB6 = $&drive
let drive = (floor(trial / 128) - 2*floor(trial / 256))*1.8
alter VB7 = $&drive
stop when time = 0.00207
resume
delete all
let endpoint = length(time)-1
let cmp = v(COMP)[endpoint]
let top = v(TOP)[endpoint]
let decision = 0
if cmp >= 0.9
let code = trial
let decision = 1
end
echo 114 0 $&trial $&cmp $&top 0.52265625 $&decision >> decisions.csv
alter VIN = 0.52734375
alter VSAMPLE = 1.8
alter VB0 = 0
alter VB1 = 0
alter VB2 = 0
alter VB3 = 0
alter VB4 = 0
alter VB5 = 0
alter VB6 = 0
alter VB7 = 0
let code = 0
stop when time = 0.002072
resume
delete all
alter VSAMPLE = 0
let trial = code + 128
let drive = (floor(trial / 1) - 2*floor(trial / 2))*1.8
alter VB0 = $&drive
let drive = (floor(trial / 2) - 2*floor(trial / 4))*1.8
alter VB1 = $&drive
let drive = (floor(trial / 4) - 2*floor(trial / 8))*1.8
alter VB2 = $&drive
let drive = (floor(trial / 8) - 2*floor(trial / 16))*1.8
alter VB3 = $&drive
let drive = (floor(trial / 16) - 2*floor(trial / 32))*1.8
alter VB4 = $&drive
let drive = (floor(trial / 32) - 2*floor(trial / 64))*1.8
alter VB5 = $&drive
let drive = (floor(trial / 64) - 2*floor(trial / 128))*1.8
alter VB6 = $&drive
let drive = (floor(trial / 128) - 2*floor(trial / 256))*1.8
alter VB7 = $&drive
stop when time = 0.002074
resume
delete all
let endpoint = length(time)-1
let cmp = v(COMP)[endpoint]
let top = v(TOP)[endpoint]
let decision = 0
if cmp >= 0.9
let code = trial
let decision = 1
end
echo 115 7 $&trial $&cmp $&top 0.52734375 $&decision >> decisions.csv
let trial = code + 64
let drive = (floor(trial / 1) - 2*floor(trial / 2))*1.8
alter VB0 = $&drive
let drive = (floor(trial / 2) - 2*floor(trial / 4))*1.8
alter VB1 = $&drive
let drive = (floor(trial / 4) - 2*floor(trial / 8))*1.8
alter VB2 = $&drive
let drive = (floor(trial / 8) - 2*floor(trial / 16))*1.8
alter VB3 = $&drive
let drive = (floor(trial / 16) - 2*floor(trial / 32))*1.8
alter VB4 = $&drive
let drive = (floor(trial / 32) - 2*floor(trial / 64))*1.8
alter VB5 = $&drive
let drive = (floor(trial / 64) - 2*floor(trial / 128))*1.8
alter VB6 = $&drive
let drive = (floor(trial / 128) - 2*floor(trial / 256))*1.8
alter VB7 = $&drive
stop when time = 0.002076
resume
delete all
let endpoint = length(time)-1
let cmp = v(COMP)[endpoint]
let top = v(TOP)[endpoint]
let decision = 0
if cmp >= 0.9
let code = trial
let decision = 1
end
echo 115 6 $&trial $&cmp $&top 0.52734375 $&decision >> decisions.csv
let trial = code + 32
let drive = (floor(trial / 1) - 2*floor(trial / 2))*1.8
alter VB0 = $&drive
let drive = (floor(trial / 2) - 2*floor(trial / 4))*1.8
alter VB1 = $&drive
let drive = (floor(trial / 4) - 2*floor(trial / 8))*1.8
alter VB2 = $&drive
let drive = (floor(trial / 8) - 2*floor(trial / 16))*1.8
alter VB3 = $&drive
let drive = (floor(trial / 16) - 2*floor(trial / 32))*1.8
alter VB4 = $&drive
let drive = (floor(trial / 32) - 2*floor(trial / 64))*1.8
alter VB5 = $&drive
let drive = (floor(trial / 64) - 2*floor(trial / 128))*1.8
alter VB6 = $&drive
let drive = (floor(trial / 128) - 2*floor(trial / 256))*1.8
alter VB7 = $&drive
stop when time = 0.002078
resume
delete all
let endpoint = length(time)-1
let cmp = v(COMP)[endpoint]
let top = v(TOP)[endpoint]
let decision = 0
if cmp >= 0.9
let code = trial
let decision = 1
end
echo 115 5 $&trial $&cmp $&top 0.52734375 $&decision >> decisions.csv
let trial = code + 16
let drive = (floor(trial / 1) - 2*floor(trial / 2))*1.8
alter VB0 = $&drive
let drive = (floor(trial / 2) - 2*floor(trial / 4))*1.8
alter VB1 = $&drive
let drive = (floor(trial / 4) - 2*floor(trial / 8))*1.8
alter VB2 = $&drive
let drive = (floor(trial / 8) - 2*floor(trial / 16))*1.8
alter VB3 = $&drive
let drive = (floor(trial / 16) - 2*floor(trial / 32))*1.8
alter VB4 = $&drive
let drive = (floor(trial / 32) - 2*floor(trial / 64))*1.8
alter VB5 = $&drive
let drive = (floor(trial / 64) - 2*floor(trial / 128))*1.8
alter VB6 = $&drive
let drive = (floor(trial / 128) - 2*floor(trial / 256))*1.8
alter VB7 = $&drive
stop when time = 0.00208
resume
delete all
let endpoint = length(time)-1
let cmp = v(COMP)[endpoint]
let top = v(TOP)[endpoint]
let decision = 0
if cmp >= 0.9
let code = trial
let decision = 1
end
echo 115 4 $&trial $&cmp $&top 0.52734375 $&decision >> decisions.csv
let trial = code + 8
let drive = (floor(trial / 1) - 2*floor(trial / 2))*1.8
alter VB0 = $&drive
let drive = (floor(trial / 2) - 2*floor(trial / 4))*1.8
alter VB1 = $&drive
let drive = (floor(trial / 4) - 2*floor(trial / 8))*1.8
alter VB2 = $&drive
let drive = (floor(trial / 8) - 2*floor(trial / 16))*1.8
alter VB3 = $&drive
let drive = (floor(trial / 16) - 2*floor(trial / 32))*1.8
alter VB4 = $&drive
let drive = (floor(trial / 32) - 2*floor(trial / 64))*1.8
alter VB5 = $&drive
let drive = (floor(trial / 64) - 2*floor(trial / 128))*1.8
alter VB6 = $&drive
let drive = (floor(trial / 128) - 2*floor(trial / 256))*1.8
alter VB7 = $&drive
stop when time = 0.002082
resume
delete all
let endpoint = length(time)-1
let cmp = v(COMP)[endpoint]
let top = v(TOP)[endpoint]
let decision = 0
if cmp >= 0.9
let code = trial
let decision = 1
end
echo 115 3 $&trial $&cmp $&top 0.52734375 $&decision >> decisions.csv
let trial = code + 4
let drive = (floor(trial / 1) - 2*floor(trial / 2))*1.8
alter VB0 = $&drive
let drive = (floor(trial / 2) - 2*floor(trial / 4))*1.8
alter VB1 = $&drive
let drive = (floor(trial / 4) - 2*floor(trial / 8))*1.8
alter VB2 = $&drive
let drive = (floor(trial / 8) - 2*floor(trial / 16))*1.8
alter VB3 = $&drive
let drive = (floor(trial / 16) - 2*floor(trial / 32))*1.8
alter VB4 = $&drive
let drive = (floor(trial / 32) - 2*floor(trial / 64))*1.8
alter VB5 = $&drive
let drive = (floor(trial / 64) - 2*floor(trial / 128))*1.8
alter VB6 = $&drive
let drive = (floor(trial / 128) - 2*floor(trial / 256))*1.8
alter VB7 = $&drive
stop when time = 0.002084
resume
delete all
let endpoint = length(time)-1
let cmp = v(COMP)[endpoint]
let top = v(TOP)[endpoint]
let decision = 0
if cmp >= 0.9
let code = trial
let decision = 1
end
echo 115 2 $&trial $&cmp $&top 0.52734375 $&decision >> decisions.csv
let trial = code + 2
let drive = (floor(trial / 1) - 2*floor(trial / 2))*1.8
alter VB0 = $&drive
let drive = (floor(trial / 2) - 2*floor(trial / 4))*1.8
alter VB1 = $&drive
let drive = (floor(trial / 4) - 2*floor(trial / 8))*1.8
alter VB2 = $&drive
let drive = (floor(trial / 8) - 2*floor(trial / 16))*1.8
alter VB3 = $&drive
let drive = (floor(trial / 16) - 2*floor(trial / 32))*1.8
alter VB4 = $&drive
let drive = (floor(trial / 32) - 2*floor(trial / 64))*1.8
alter VB5 = $&drive
let drive = (floor(trial / 64) - 2*floor(trial / 128))*1.8
alter VB6 = $&drive
let drive = (floor(trial / 128) - 2*floor(trial / 256))*1.8
alter VB7 = $&drive
stop when time = 0.002086
resume
delete all
let endpoint = length(time)-1
let cmp = v(COMP)[endpoint]
let top = v(TOP)[endpoint]
let decision = 0
if cmp >= 0.9
let code = trial
let decision = 1
end
echo 115 1 $&trial $&cmp $&top 0.52734375 $&decision >> decisions.csv
let trial = code + 1
let drive = (floor(trial / 1) - 2*floor(trial / 2))*1.8
alter VB0 = $&drive
let drive = (floor(trial / 2) - 2*floor(trial / 4))*1.8
alter VB1 = $&drive
let drive = (floor(trial / 4) - 2*floor(trial / 8))*1.8
alter VB2 = $&drive
let drive = (floor(trial / 8) - 2*floor(trial / 16))*1.8
alter VB3 = $&drive
let drive = (floor(trial / 16) - 2*floor(trial / 32))*1.8
alter VB4 = $&drive
let drive = (floor(trial / 32) - 2*floor(trial / 64))*1.8
alter VB5 = $&drive
let drive = (floor(trial / 64) - 2*floor(trial / 128))*1.8
alter VB6 = $&drive
let drive = (floor(trial / 128) - 2*floor(trial / 256))*1.8
alter VB7 = $&drive
stop when time = 0.002088
resume
delete all
let endpoint = length(time)-1
let cmp = v(COMP)[endpoint]
let top = v(TOP)[endpoint]
let decision = 0
if cmp >= 0.9
let code = trial
let decision = 1
end
echo 115 0 $&trial $&cmp $&top 0.52734375 $&decision >> decisions.csv
alter VIN = 0.53203125
alter VSAMPLE = 1.8
alter VB0 = 0
alter VB1 = 0
alter VB2 = 0
alter VB3 = 0
alter VB4 = 0
alter VB5 = 0
alter VB6 = 0
alter VB7 = 0
let code = 0
stop when time = 0.00209
resume
delete all
alter VSAMPLE = 0
let trial = code + 128
let drive = (floor(trial / 1) - 2*floor(trial / 2))*1.8
alter VB0 = $&drive
let drive = (floor(trial / 2) - 2*floor(trial / 4))*1.8
alter VB1 = $&drive
let drive = (floor(trial / 4) - 2*floor(trial / 8))*1.8
alter VB2 = $&drive
let drive = (floor(trial / 8) - 2*floor(trial / 16))*1.8
alter VB3 = $&drive
let drive = (floor(trial / 16) - 2*floor(trial / 32))*1.8
alter VB4 = $&drive
let drive = (floor(trial / 32) - 2*floor(trial / 64))*1.8
alter VB5 = $&drive
let drive = (floor(trial / 64) - 2*floor(trial / 128))*1.8
alter VB6 = $&drive
let drive = (floor(trial / 128) - 2*floor(trial / 256))*1.8
alter VB7 = $&drive
stop when time = 0.002092
resume
delete all
let endpoint = length(time)-1
let cmp = v(COMP)[endpoint]
let top = v(TOP)[endpoint]
let decision = 0
if cmp >= 0.9
let code = trial
let decision = 1
end
echo 116 7 $&trial $&cmp $&top 0.53203125 $&decision >> decisions.csv
let trial = code + 64
let drive = (floor(trial / 1) - 2*floor(trial / 2))*1.8
alter VB0 = $&drive
let drive = (floor(trial / 2) - 2*floor(trial / 4))*1.8
alter VB1 = $&drive
let drive = (floor(trial / 4) - 2*floor(trial / 8))*1.8
alter VB2 = $&drive
let drive = (floor(trial / 8) - 2*floor(trial / 16))*1.8
alter VB3 = $&drive
let drive = (floor(trial / 16) - 2*floor(trial / 32))*1.8
alter VB4 = $&drive
let drive = (floor(trial / 32) - 2*floor(trial / 64))*1.8
alter VB5 = $&drive
let drive = (floor(trial / 64) - 2*floor(trial / 128))*1.8
alter VB6 = $&drive
let drive = (floor(trial / 128) - 2*floor(trial / 256))*1.8
alter VB7 = $&drive
stop when time = 0.002094
resume
delete all
let endpoint = length(time)-1
let cmp = v(COMP)[endpoint]
let top = v(TOP)[endpoint]
let decision = 0
if cmp >= 0.9
let code = trial
let decision = 1
end
echo 116 6 $&trial $&cmp $&top 0.53203125 $&decision >> decisions.csv
let trial = code + 32
let drive = (floor(trial / 1) - 2*floor(trial / 2))*1.8
alter VB0 = $&drive
let drive = (floor(trial / 2) - 2*floor(trial / 4))*1.8
alter VB1 = $&drive
let drive = (floor(trial / 4) - 2*floor(trial / 8))*1.8
alter VB2 = $&drive
let drive = (floor(trial / 8) - 2*floor(trial / 16))*1.8
alter VB3 = $&drive
let drive = (floor(trial / 16) - 2*floor(trial / 32))*1.8
alter VB4 = $&drive
let drive = (floor(trial / 32) - 2*floor(trial / 64))*1.8
alter VB5 = $&drive
let drive = (floor(trial / 64) - 2*floor(trial / 128))*1.8
alter VB6 = $&drive
let drive = (floor(trial / 128) - 2*floor(trial / 256))*1.8
alter VB7 = $&drive
stop when time = 0.002096
resume
delete all
let endpoint = length(time)-1
let cmp = v(COMP)[endpoint]
let top = v(TOP)[endpoint]
let decision = 0
if cmp >= 0.9
let code = trial
let decision = 1
end
echo 116 5 $&trial $&cmp $&top 0.53203125 $&decision >> decisions.csv
let trial = code + 16
let drive = (floor(trial / 1) - 2*floor(trial / 2))*1.8
alter VB0 = $&drive
let drive = (floor(trial / 2) - 2*floor(trial / 4))*1.8
alter VB1 = $&drive
let drive = (floor(trial / 4) - 2*floor(trial / 8))*1.8
alter VB2 = $&drive
let drive = (floor(trial / 8) - 2*floor(trial / 16))*1.8
alter VB3 = $&drive
let drive = (floor(trial / 16) - 2*floor(trial / 32))*1.8
alter VB4 = $&drive
let drive = (floor(trial / 32) - 2*floor(trial / 64))*1.8
alter VB5 = $&drive
let drive = (floor(trial / 64) - 2*floor(trial / 128))*1.8
alter VB6 = $&drive
let drive = (floor(trial / 128) - 2*floor(trial / 256))*1.8
alter VB7 = $&drive
stop when time = 0.002098
resume
delete all
let endpoint = length(time)-1
let cmp = v(COMP)[endpoint]
let top = v(TOP)[endpoint]
let decision = 0
if cmp >= 0.9
let code = trial
let decision = 1
end
echo 116 4 $&trial $&cmp $&top 0.53203125 $&decision >> decisions.csv
let trial = code + 8
let drive = (floor(trial / 1) - 2*floor(trial / 2))*1.8
alter VB0 = $&drive
let drive = (floor(trial / 2) - 2*floor(trial / 4))*1.8
alter VB1 = $&drive
let drive = (floor(trial / 4) - 2*floor(trial / 8))*1.8
alter VB2 = $&drive
let drive = (floor(trial / 8) - 2*floor(trial / 16))*1.8
alter VB3 = $&drive
let drive = (floor(trial / 16) - 2*floor(trial / 32))*1.8
alter VB4 = $&drive
let drive = (floor(trial / 32) - 2*floor(trial / 64))*1.8
alter VB5 = $&drive
let drive = (floor(trial / 64) - 2*floor(trial / 128))*1.8
alter VB6 = $&drive
let drive = (floor(trial / 128) - 2*floor(trial / 256))*1.8
alter VB7 = $&drive
stop when time = 0.0021
resume
delete all
let endpoint = length(time)-1
let cmp = v(COMP)[endpoint]
let top = v(TOP)[endpoint]
let decision = 0
if cmp >= 0.9
let code = trial
let decision = 1
end
echo 116 3 $&trial $&cmp $&top 0.53203125 $&decision >> decisions.csv
let trial = code + 4
let drive = (floor(trial / 1) - 2*floor(trial / 2))*1.8
alter VB0 = $&drive
let drive = (floor(trial / 2) - 2*floor(trial / 4))*1.8
alter VB1 = $&drive
let drive = (floor(trial / 4) - 2*floor(trial / 8))*1.8
alter VB2 = $&drive
let drive = (floor(trial / 8) - 2*floor(trial / 16))*1.8
alter VB3 = $&drive
let drive = (floor(trial / 16) - 2*floor(trial / 32))*1.8
alter VB4 = $&drive
let drive = (floor(trial / 32) - 2*floor(trial / 64))*1.8
alter VB5 = $&drive
let drive = (floor(trial / 64) - 2*floor(trial / 128))*1.8
alter VB6 = $&drive
let drive = (floor(trial / 128) - 2*floor(trial / 256))*1.8
alter VB7 = $&drive
stop when time = 0.002102
resume
delete all
let endpoint = length(time)-1
let cmp = v(COMP)[endpoint]
let top = v(TOP)[endpoint]
let decision = 0
if cmp >= 0.9
let code = trial
let decision = 1
end
echo 116 2 $&trial $&cmp $&top 0.53203125 $&decision >> decisions.csv
let trial = code + 2
let drive = (floor(trial / 1) - 2*floor(trial / 2))*1.8
alter VB0 = $&drive
let drive = (floor(trial / 2) - 2*floor(trial / 4))*1.8
alter VB1 = $&drive
let drive = (floor(trial / 4) - 2*floor(trial / 8))*1.8
alter VB2 = $&drive
let drive = (floor(trial / 8) - 2*floor(trial / 16))*1.8
alter VB3 = $&drive
let drive = (floor(trial / 16) - 2*floor(trial / 32))*1.8
alter VB4 = $&drive
let drive = (floor(trial / 32) - 2*floor(trial / 64))*1.8
alter VB5 = $&drive
let drive = (floor(trial / 64) - 2*floor(trial / 128))*1.8
alter VB6 = $&drive
let drive = (floor(trial / 128) - 2*floor(trial / 256))*1.8
alter VB7 = $&drive
stop when time = 0.002104
resume
delete all
let endpoint = length(time)-1
let cmp = v(COMP)[endpoint]
let top = v(TOP)[endpoint]
let decision = 0
if cmp >= 0.9
let code = trial
let decision = 1
end
echo 116 1 $&trial $&cmp $&top 0.53203125 $&decision >> decisions.csv
let trial = code + 1
let drive = (floor(trial / 1) - 2*floor(trial / 2))*1.8
alter VB0 = $&drive
let drive = (floor(trial / 2) - 2*floor(trial / 4))*1.8
alter VB1 = $&drive
let drive = (floor(trial / 4) - 2*floor(trial / 8))*1.8
alter VB2 = $&drive
let drive = (floor(trial / 8) - 2*floor(trial / 16))*1.8
alter VB3 = $&drive
let drive = (floor(trial / 16) - 2*floor(trial / 32))*1.8
alter VB4 = $&drive
let drive = (floor(trial / 32) - 2*floor(trial / 64))*1.8
alter VB5 = $&drive
let drive = (floor(trial / 64) - 2*floor(trial / 128))*1.8
alter VB6 = $&drive
let drive = (floor(trial / 128) - 2*floor(trial / 256))*1.8
alter VB7 = $&drive
stop when time = 0.002106
resume
delete all
let endpoint = length(time)-1
let cmp = v(COMP)[endpoint]
let top = v(TOP)[endpoint]
let decision = 0
if cmp >= 0.9
let code = trial
let decision = 1
end
echo 116 0 $&trial $&cmp $&top 0.53203125 $&decision >> decisions.csv
alter VIN = 0.53671875
alter VSAMPLE = 1.8
alter VB0 = 0
alter VB1 = 0
alter VB2 = 0
alter VB3 = 0
alter VB4 = 0
alter VB5 = 0
alter VB6 = 0
alter VB7 = 0
let code = 0
stop when time = 0.002108
resume
delete all
alter VSAMPLE = 0
let trial = code + 128
let drive = (floor(trial / 1) - 2*floor(trial / 2))*1.8
alter VB0 = $&drive
let drive = (floor(trial / 2) - 2*floor(trial / 4))*1.8
alter VB1 = $&drive
let drive = (floor(trial / 4) - 2*floor(trial / 8))*1.8
alter VB2 = $&drive
let drive = (floor(trial / 8) - 2*floor(trial / 16))*1.8
alter VB3 = $&drive
let drive = (floor(trial / 16) - 2*floor(trial / 32))*1.8
alter VB4 = $&drive
let drive = (floor(trial / 32) - 2*floor(trial / 64))*1.8
alter VB5 = $&drive
let drive = (floor(trial / 64) - 2*floor(trial / 128))*1.8
alter VB6 = $&drive
let drive = (floor(trial / 128) - 2*floor(trial / 256))*1.8
alter VB7 = $&drive
stop when time = 0.00211
resume
delete all
let endpoint = length(time)-1
let cmp = v(COMP)[endpoint]
let top = v(TOP)[endpoint]
let decision = 0
if cmp >= 0.9
let code = trial
let decision = 1
end
echo 117 7 $&trial $&cmp $&top 0.53671875 $&decision >> decisions.csv
let trial = code + 64
let drive = (floor(trial / 1) - 2*floor(trial / 2))*1.8
alter VB0 = $&drive
let drive = (floor(trial / 2) - 2*floor(trial / 4))*1.8
alter VB1 = $&drive
let drive = (floor(trial / 4) - 2*floor(trial / 8))*1.8
alter VB2 = $&drive
let drive = (floor(trial / 8) - 2*floor(trial / 16))*1.8
alter VB3 = $&drive
let drive = (floor(trial / 16) - 2*floor(trial / 32))*1.8
alter VB4 = $&drive
let drive = (floor(trial / 32) - 2*floor(trial / 64))*1.8
alter VB5 = $&drive
let drive = (floor(trial / 64) - 2*floor(trial / 128))*1.8
alter VB6 = $&drive
let drive = (floor(trial / 128) - 2*floor(trial / 256))*1.8
alter VB7 = $&drive
stop when time = 0.002112
resume
delete all
let endpoint = length(time)-1
let cmp = v(COMP)[endpoint]
let top = v(TOP)[endpoint]
let decision = 0
if cmp >= 0.9
let code = trial
let decision = 1
end
echo 117 6 $&trial $&cmp $&top 0.53671875 $&decision >> decisions.csv
let trial = code + 32
let drive = (floor(trial / 1) - 2*floor(trial / 2))*1.8
alter VB0 = $&drive
let drive = (floor(trial / 2) - 2*floor(trial / 4))*1.8
alter VB1 = $&drive
let drive = (floor(trial / 4) - 2*floor(trial / 8))*1.8
alter VB2 = $&drive
let drive = (floor(trial / 8) - 2*floor(trial / 16))*1.8
alter VB3 = $&drive
let drive = (floor(trial / 16) - 2*floor(trial / 32))*1.8
alter VB4 = $&drive
let drive = (floor(trial / 32) - 2*floor(trial / 64))*1.8
alter VB5 = $&drive
let drive = (floor(trial / 64) - 2*floor(trial / 128))*1.8
alter VB6 = $&drive
let drive = (floor(trial / 128) - 2*floor(trial / 256))*1.8
alter VB7 = $&drive
stop when time = 0.002114
resume
delete all
let endpoint = length(time)-1
let cmp = v(COMP)[endpoint]
let top = v(TOP)[endpoint]
let decision = 0
if cmp >= 0.9
let code = trial
let decision = 1
end
echo 117 5 $&trial $&cmp $&top 0.53671875 $&decision >> decisions.csv
let trial = code + 16
let drive = (floor(trial / 1) - 2*floor(trial / 2))*1.8
alter VB0 = $&drive
let drive = (floor(trial / 2) - 2*floor(trial / 4))*1.8
alter VB1 = $&drive
let drive = (floor(trial / 4) - 2*floor(trial / 8))*1.8
alter VB2 = $&drive
let drive = (floor(trial / 8) - 2*floor(trial / 16))*1.8
alter VB3 = $&drive
let drive = (floor(trial / 16) - 2*floor(trial / 32))*1.8
alter VB4 = $&drive
let drive = (floor(trial / 32) - 2*floor(trial / 64))*1.8
alter VB5 = $&drive
let drive = (floor(trial / 64) - 2*floor(trial / 128))*1.8
alter VB6 = $&drive
let drive = (floor(trial / 128) - 2*floor(trial / 256))*1.8
alter VB7 = $&drive
stop when time = 0.002116
resume
delete all
let endpoint = length(time)-1
let cmp = v(COMP)[endpoint]
let top = v(TOP)[endpoint]
let decision = 0
if cmp >= 0.9
let code = trial
let decision = 1
end
echo 117 4 $&trial $&cmp $&top 0.53671875 $&decision >> decisions.csv
let trial = code + 8
let drive = (floor(trial / 1) - 2*floor(trial / 2))*1.8
alter VB0 = $&drive
let drive = (floor(trial / 2) - 2*floor(trial / 4))*1.8
alter VB1 = $&drive
let drive = (floor(trial / 4) - 2*floor(trial / 8))*1.8
alter VB2 = $&drive
let drive = (floor(trial / 8) - 2*floor(trial / 16))*1.8
alter VB3 = $&drive
let drive = (floor(trial / 16) - 2*floor(trial / 32))*1.8
alter VB4 = $&drive
let drive = (floor(trial / 32) - 2*floor(trial / 64))*1.8
alter VB5 = $&drive
let drive = (floor(trial / 64) - 2*floor(trial / 128))*1.8
alter VB6 = $&drive
let drive = (floor(trial / 128) - 2*floor(trial / 256))*1.8
alter VB7 = $&drive
stop when time = 0.002118
resume
delete all
let endpoint = length(time)-1
let cmp = v(COMP)[endpoint]
let top = v(TOP)[endpoint]
let decision = 0
if cmp >= 0.9
let code = trial
let decision = 1
end
echo 117 3 $&trial $&cmp $&top 0.53671875 $&decision >> decisions.csv
let trial = code + 4
let drive = (floor(trial / 1) - 2*floor(trial / 2))*1.8
alter VB0 = $&drive
let drive = (floor(trial / 2) - 2*floor(trial / 4))*1.8
alter VB1 = $&drive
let drive = (floor(trial / 4) - 2*floor(trial / 8))*1.8
alter VB2 = $&drive
let drive = (floor(trial / 8) - 2*floor(trial / 16))*1.8
alter VB3 = $&drive
let drive = (floor(trial / 16) - 2*floor(trial / 32))*1.8
alter VB4 = $&drive
let drive = (floor(trial / 32) - 2*floor(trial / 64))*1.8
alter VB5 = $&drive
let drive = (floor(trial / 64) - 2*floor(trial / 128))*1.8
alter VB6 = $&drive
let drive = (floor(trial / 128) - 2*floor(trial / 256))*1.8
alter VB7 = $&drive
stop when time = 0.00212
resume
delete all
let endpoint = length(time)-1
let cmp = v(COMP)[endpoint]
let top = v(TOP)[endpoint]
let decision = 0
if cmp >= 0.9
let code = trial
let decision = 1
end
echo 117 2 $&trial $&cmp $&top 0.53671875 $&decision >> decisions.csv
let trial = code + 2
let drive = (floor(trial / 1) - 2*floor(trial / 2))*1.8
alter VB0 = $&drive
let drive = (floor(trial / 2) - 2*floor(trial / 4))*1.8
alter VB1 = $&drive
let drive = (floor(trial / 4) - 2*floor(trial / 8))*1.8
alter VB2 = $&drive
let drive = (floor(trial / 8) - 2*floor(trial / 16))*1.8
alter VB3 = $&drive
let drive = (floor(trial / 16) - 2*floor(trial / 32))*1.8
alter VB4 = $&drive
let drive = (floor(trial / 32) - 2*floor(trial / 64))*1.8
alter VB5 = $&drive
let drive = (floor(trial / 64) - 2*floor(trial / 128))*1.8
alter VB6 = $&drive
let drive = (floor(trial / 128) - 2*floor(trial / 256))*1.8
alter VB7 = $&drive
stop when time = 0.002122
resume
delete all
let endpoint = length(time)-1
let cmp = v(COMP)[endpoint]
let top = v(TOP)[endpoint]
let decision = 0
if cmp >= 0.9
let code = trial
let decision = 1
end
echo 117 1 $&trial $&cmp $&top 0.53671875 $&decision >> decisions.csv
let trial = code + 1
let drive = (floor(trial / 1) - 2*floor(trial / 2))*1.8
alter VB0 = $&drive
let drive = (floor(trial / 2) - 2*floor(trial / 4))*1.8
alter VB1 = $&drive
let drive = (floor(trial / 4) - 2*floor(trial / 8))*1.8
alter VB2 = $&drive
let drive = (floor(trial / 8) - 2*floor(trial / 16))*1.8
alter VB3 = $&drive
let drive = (floor(trial / 16) - 2*floor(trial / 32))*1.8
alter VB4 = $&drive
let drive = (floor(trial / 32) - 2*floor(trial / 64))*1.8
alter VB5 = $&drive
let drive = (floor(trial / 64) - 2*floor(trial / 128))*1.8
alter VB6 = $&drive
let drive = (floor(trial / 128) - 2*floor(trial / 256))*1.8
alter VB7 = $&drive
stop when time = 0.002124
resume
delete all
let endpoint = length(time)-1
let cmp = v(COMP)[endpoint]
let top = v(TOP)[endpoint]
let decision = 0
if cmp >= 0.9
let code = trial
let decision = 1
end
echo 117 0 $&trial $&cmp $&top 0.53671875 $&decision >> decisions.csv
alter VIN = 0.54140625
alter VSAMPLE = 1.8
alter VB0 = 0
alter VB1 = 0
alter VB2 = 0
alter VB3 = 0
alter VB4 = 0
alter VB5 = 0
alter VB6 = 0
alter VB7 = 0
let code = 0
stop when time = 0.002126
resume
delete all
alter VSAMPLE = 0
let trial = code + 128
let drive = (floor(trial / 1) - 2*floor(trial / 2))*1.8
alter VB0 = $&drive
let drive = (floor(trial / 2) - 2*floor(trial / 4))*1.8
alter VB1 = $&drive
let drive = (floor(trial / 4) - 2*floor(trial / 8))*1.8
alter VB2 = $&drive
let drive = (floor(trial / 8) - 2*floor(trial / 16))*1.8
alter VB3 = $&drive
let drive = (floor(trial / 16) - 2*floor(trial / 32))*1.8
alter VB4 = $&drive
let drive = (floor(trial / 32) - 2*floor(trial / 64))*1.8
alter VB5 = $&drive
let drive = (floor(trial / 64) - 2*floor(trial / 128))*1.8
alter VB6 = $&drive
let drive = (floor(trial / 128) - 2*floor(trial / 256))*1.8
alter VB7 = $&drive
stop when time = 0.002128
resume
delete all
let endpoint = length(time)-1
let cmp = v(COMP)[endpoint]
let top = v(TOP)[endpoint]
let decision = 0
if cmp >= 0.9
let code = trial
let decision = 1
end
echo 118 7 $&trial $&cmp $&top 0.54140625 $&decision >> decisions.csv
let trial = code + 64
let drive = (floor(trial / 1) - 2*floor(trial / 2))*1.8
alter VB0 = $&drive
let drive = (floor(trial / 2) - 2*floor(trial / 4))*1.8
alter VB1 = $&drive
let drive = (floor(trial / 4) - 2*floor(trial / 8))*1.8
alter VB2 = $&drive
let drive = (floor(trial / 8) - 2*floor(trial / 16))*1.8
alter VB3 = $&drive
let drive = (floor(trial / 16) - 2*floor(trial / 32))*1.8
alter VB4 = $&drive
let drive = (floor(trial / 32) - 2*floor(trial / 64))*1.8
alter VB5 = $&drive
let drive = (floor(trial / 64) - 2*floor(trial / 128))*1.8
alter VB6 = $&drive
let drive = (floor(trial / 128) - 2*floor(trial / 256))*1.8
alter VB7 = $&drive
stop when time = 0.00213
resume
delete all
let endpoint = length(time)-1
let cmp = v(COMP)[endpoint]
let top = v(TOP)[endpoint]
let decision = 0
if cmp >= 0.9
let code = trial
let decision = 1
end
echo 118 6 $&trial $&cmp $&top 0.54140625 $&decision >> decisions.csv
let trial = code + 32
let drive = (floor(trial / 1) - 2*floor(trial / 2))*1.8
alter VB0 = $&drive
let drive = (floor(trial / 2) - 2*floor(trial / 4))*1.8
alter VB1 = $&drive
let drive = (floor(trial / 4) - 2*floor(trial / 8))*1.8
alter VB2 = $&drive
let drive = (floor(trial / 8) - 2*floor(trial / 16))*1.8
alter VB3 = $&drive
let drive = (floor(trial / 16) - 2*floor(trial / 32))*1.8
alter VB4 = $&drive
let drive = (floor(trial / 32) - 2*floor(trial / 64))*1.8
alter VB5 = $&drive
let drive = (floor(trial / 64) - 2*floor(trial / 128))*1.8
alter VB6 = $&drive
let drive = (floor(trial / 128) - 2*floor(trial / 256))*1.8
alter VB7 = $&drive
stop when time = 0.002132
resume
delete all
let endpoint = length(time)-1
let cmp = v(COMP)[endpoint]
let top = v(TOP)[endpoint]
let decision = 0
if cmp >= 0.9
let code = trial
let decision = 1
end
echo 118 5 $&trial $&cmp $&top 0.54140625 $&decision >> decisions.csv
let trial = code + 16
let drive = (floor(trial / 1) - 2*floor(trial / 2))*1.8
alter VB0 = $&drive
let drive = (floor(trial / 2) - 2*floor(trial / 4))*1.8
alter VB1 = $&drive
let drive = (floor(trial / 4) - 2*floor(trial / 8))*1.8
alter VB2 = $&drive
let drive = (floor(trial / 8) - 2*floor(trial / 16))*1.8
alter VB3 = $&drive
let drive = (floor(trial / 16) - 2*floor(trial / 32))*1.8
alter VB4 = $&drive
let drive = (floor(trial / 32) - 2*floor(trial / 64))*1.8
alter VB5 = $&drive
let drive = (floor(trial / 64) - 2*floor(trial / 128))*1.8
alter VB6 = $&drive
let drive = (floor(trial / 128) - 2*floor(trial / 256))*1.8
alter VB7 = $&drive
stop when time = 0.002134
resume
delete all
let endpoint = length(time)-1
let cmp = v(COMP)[endpoint]
let top = v(TOP)[endpoint]
let decision = 0
if cmp >= 0.9
let code = trial
let decision = 1
end
echo 118 4 $&trial $&cmp $&top 0.54140625 $&decision >> decisions.csv
let trial = code + 8
let drive = (floor(trial / 1) - 2*floor(trial / 2))*1.8
alter VB0 = $&drive
let drive = (floor(trial / 2) - 2*floor(trial / 4))*1.8
alter VB1 = $&drive
let drive = (floor(trial / 4) - 2*floor(trial / 8))*1.8
alter VB2 = $&drive
let drive = (floor(trial / 8) - 2*floor(trial / 16))*1.8
alter VB3 = $&drive
let drive = (floor(trial / 16) - 2*floor(trial / 32))*1.8
alter VB4 = $&drive
let drive = (floor(trial / 32) - 2*floor(trial / 64))*1.8
alter VB5 = $&drive
let drive = (floor(trial / 64) - 2*floor(trial / 128))*1.8
alter VB6 = $&drive
let drive = (floor(trial / 128) - 2*floor(trial / 256))*1.8
alter VB7 = $&drive
stop when time = 0.002136
resume
delete all
let endpoint = length(time)-1
let cmp = v(COMP)[endpoint]
let top = v(TOP)[endpoint]
let decision = 0
if cmp >= 0.9
let code = trial
let decision = 1
end
echo 118 3 $&trial $&cmp $&top 0.54140625 $&decision >> decisions.csv
let trial = code + 4
let drive = (floor(trial / 1) - 2*floor(trial / 2))*1.8
alter VB0 = $&drive
let drive = (floor(trial / 2) - 2*floor(trial / 4))*1.8
alter VB1 = $&drive
let drive = (floor(trial / 4) - 2*floor(trial / 8))*1.8
alter VB2 = $&drive
let drive = (floor(trial / 8) - 2*floor(trial / 16))*1.8
alter VB3 = $&drive
let drive = (floor(trial / 16) - 2*floor(trial / 32))*1.8
alter VB4 = $&drive
let drive = (floor(trial / 32) - 2*floor(trial / 64))*1.8
alter VB5 = $&drive
let drive = (floor(trial / 64) - 2*floor(trial / 128))*1.8
alter VB6 = $&drive
let drive = (floor(trial / 128) - 2*floor(trial / 256))*1.8
alter VB7 = $&drive
stop when time = 0.002138
resume
delete all
let endpoint = length(time)-1
let cmp = v(COMP)[endpoint]
let top = v(TOP)[endpoint]
let decision = 0
if cmp >= 0.9
let code = trial
let decision = 1
end
echo 118 2 $&trial $&cmp $&top 0.54140625 $&decision >> decisions.csv
let trial = code + 2
let drive = (floor(trial / 1) - 2*floor(trial / 2))*1.8
alter VB0 = $&drive
let drive = (floor(trial / 2) - 2*floor(trial / 4))*1.8
alter VB1 = $&drive
let drive = (floor(trial / 4) - 2*floor(trial / 8))*1.8
alter VB2 = $&drive
let drive = (floor(trial / 8) - 2*floor(trial / 16))*1.8
alter VB3 = $&drive
let drive = (floor(trial / 16) - 2*floor(trial / 32))*1.8
alter VB4 = $&drive
let drive = (floor(trial / 32) - 2*floor(trial / 64))*1.8
alter VB5 = $&drive
let drive = (floor(trial / 64) - 2*floor(trial / 128))*1.8
alter VB6 = $&drive
let drive = (floor(trial / 128) - 2*floor(trial / 256))*1.8
alter VB7 = $&drive
stop when time = 0.00214
resume
delete all
let endpoint = length(time)-1
let cmp = v(COMP)[endpoint]
let top = v(TOP)[endpoint]
let decision = 0
if cmp >= 0.9
let code = trial
let decision = 1
end
echo 118 1 $&trial $&cmp $&top 0.54140625 $&decision >> decisions.csv
let trial = code + 1
let drive = (floor(trial / 1) - 2*floor(trial / 2))*1.8
alter VB0 = $&drive
let drive = (floor(trial / 2) - 2*floor(trial / 4))*1.8
alter VB1 = $&drive
let drive = (floor(trial / 4) - 2*floor(trial / 8))*1.8
alter VB2 = $&drive
let drive = (floor(trial / 8) - 2*floor(trial / 16))*1.8
alter VB3 = $&drive
let drive = (floor(trial / 16) - 2*floor(trial / 32))*1.8
alter VB4 = $&drive
let drive = (floor(trial / 32) - 2*floor(trial / 64))*1.8
alter VB5 = $&drive
let drive = (floor(trial / 64) - 2*floor(trial / 128))*1.8
alter VB6 = $&drive
let drive = (floor(trial / 128) - 2*floor(trial / 256))*1.8
alter VB7 = $&drive
stop when time = 0.002142
resume
delete all
let endpoint = length(time)-1
let cmp = v(COMP)[endpoint]
let top = v(TOP)[endpoint]
let decision = 0
if cmp >= 0.9
let code = trial
let decision = 1
end
echo 118 0 $&trial $&cmp $&top 0.54140625 $&decision >> decisions.csv
alter VIN = 0.54609375
alter VSAMPLE = 1.8
alter VB0 = 0
alter VB1 = 0
alter VB2 = 0
alter VB3 = 0
alter VB4 = 0
alter VB5 = 0
alter VB6 = 0
alter VB7 = 0
let code = 0
stop when time = 0.002144
resume
delete all
alter VSAMPLE = 0
let trial = code + 128
let drive = (floor(trial / 1) - 2*floor(trial / 2))*1.8
alter VB0 = $&drive
let drive = (floor(trial / 2) - 2*floor(trial / 4))*1.8
alter VB1 = $&drive
let drive = (floor(trial / 4) - 2*floor(trial / 8))*1.8
alter VB2 = $&drive
let drive = (floor(trial / 8) - 2*floor(trial / 16))*1.8
alter VB3 = $&drive
let drive = (floor(trial / 16) - 2*floor(trial / 32))*1.8
alter VB4 = $&drive
let drive = (floor(trial / 32) - 2*floor(trial / 64))*1.8
alter VB5 = $&drive
let drive = (floor(trial / 64) - 2*floor(trial / 128))*1.8
alter VB6 = $&drive
let drive = (floor(trial / 128) - 2*floor(trial / 256))*1.8
alter VB7 = $&drive
stop when time = 0.002146
resume
delete all
let endpoint = length(time)-1
let cmp = v(COMP)[endpoint]
let top = v(TOP)[endpoint]
let decision = 0
if cmp >= 0.9
let code = trial
let decision = 1
end
echo 119 7 $&trial $&cmp $&top 0.54609375 $&decision >> decisions.csv
let trial = code + 64
let drive = (floor(trial / 1) - 2*floor(trial / 2))*1.8
alter VB0 = $&drive
let drive = (floor(trial / 2) - 2*floor(trial / 4))*1.8
alter VB1 = $&drive
let drive = (floor(trial / 4) - 2*floor(trial / 8))*1.8
alter VB2 = $&drive
let drive = (floor(trial / 8) - 2*floor(trial / 16))*1.8
alter VB3 = $&drive
let drive = (floor(trial / 16) - 2*floor(trial / 32))*1.8
alter VB4 = $&drive
let drive = (floor(trial / 32) - 2*floor(trial / 64))*1.8
alter VB5 = $&drive
let drive = (floor(trial / 64) - 2*floor(trial / 128))*1.8
alter VB6 = $&drive
let drive = (floor(trial / 128) - 2*floor(trial / 256))*1.8
alter VB7 = $&drive
stop when time = 0.002148
resume
delete all
let endpoint = length(time)-1
let cmp = v(COMP)[endpoint]
let top = v(TOP)[endpoint]
let decision = 0
if cmp >= 0.9
let code = trial
let decision = 1
end
echo 119 6 $&trial $&cmp $&top 0.54609375 $&decision >> decisions.csv
let trial = code + 32
let drive = (floor(trial / 1) - 2*floor(trial / 2))*1.8
alter VB0 = $&drive
let drive = (floor(trial / 2) - 2*floor(trial / 4))*1.8
alter VB1 = $&drive
let drive = (floor(trial / 4) - 2*floor(trial / 8))*1.8
alter VB2 = $&drive
let drive = (floor(trial / 8) - 2*floor(trial / 16))*1.8
alter VB3 = $&drive
let drive = (floor(trial / 16) - 2*floor(trial / 32))*1.8
alter VB4 = $&drive
let drive = (floor(trial / 32) - 2*floor(trial / 64))*1.8
alter VB5 = $&drive
let drive = (floor(trial / 64) - 2*floor(trial / 128))*1.8
alter VB6 = $&drive
let drive = (floor(trial / 128) - 2*floor(trial / 256))*1.8
alter VB7 = $&drive
stop when time = 0.00215
resume
delete all
let endpoint = length(time)-1
let cmp = v(COMP)[endpoint]
let top = v(TOP)[endpoint]
let decision = 0
if cmp >= 0.9
let code = trial
let decision = 1
end
echo 119 5 $&trial $&cmp $&top 0.54609375 $&decision >> decisions.csv
let trial = code + 16
let drive = (floor(trial / 1) - 2*floor(trial / 2))*1.8
alter VB0 = $&drive
let drive = (floor(trial / 2) - 2*floor(trial / 4))*1.8
alter VB1 = $&drive
let drive = (floor(trial / 4) - 2*floor(trial / 8))*1.8
alter VB2 = $&drive
let drive = (floor(trial / 8) - 2*floor(trial / 16))*1.8
alter VB3 = $&drive
let drive = (floor(trial / 16) - 2*floor(trial / 32))*1.8
alter VB4 = $&drive
let drive = (floor(trial / 32) - 2*floor(trial / 64))*1.8
alter VB5 = $&drive
let drive = (floor(trial / 64) - 2*floor(trial / 128))*1.8
alter VB6 = $&drive
let drive = (floor(trial / 128) - 2*floor(trial / 256))*1.8
alter VB7 = $&drive
stop when time = 0.002152
resume
delete all
let endpoint = length(time)-1
let cmp = v(COMP)[endpoint]
let top = v(TOP)[endpoint]
let decision = 0
if cmp >= 0.9
let code = trial
let decision = 1
end
echo 119 4 $&trial $&cmp $&top 0.54609375 $&decision >> decisions.csv
let trial = code + 8
let drive = (floor(trial / 1) - 2*floor(trial / 2))*1.8
alter VB0 = $&drive
let drive = (floor(trial / 2) - 2*floor(trial / 4))*1.8
alter VB1 = $&drive
let drive = (floor(trial / 4) - 2*floor(trial / 8))*1.8
alter VB2 = $&drive
let drive = (floor(trial / 8) - 2*floor(trial / 16))*1.8
alter VB3 = $&drive
let drive = (floor(trial / 16) - 2*floor(trial / 32))*1.8
alter VB4 = $&drive
let drive = (floor(trial / 32) - 2*floor(trial / 64))*1.8
alter VB5 = $&drive
let drive = (floor(trial / 64) - 2*floor(trial / 128))*1.8
alter VB6 = $&drive
let drive = (floor(trial / 128) - 2*floor(trial / 256))*1.8
alter VB7 = $&drive
stop when time = 0.002154
resume
delete all
let endpoint = length(time)-1
let cmp = v(COMP)[endpoint]
let top = v(TOP)[endpoint]
let decision = 0
if cmp >= 0.9
let code = trial
let decision = 1
end
echo 119 3 $&trial $&cmp $&top 0.54609375 $&decision >> decisions.csv
let trial = code + 4
let drive = (floor(trial / 1) - 2*floor(trial / 2))*1.8
alter VB0 = $&drive
let drive = (floor(trial / 2) - 2*floor(trial / 4))*1.8
alter VB1 = $&drive
let drive = (floor(trial / 4) - 2*floor(trial / 8))*1.8
alter VB2 = $&drive
let drive = (floor(trial / 8) - 2*floor(trial / 16))*1.8
alter VB3 = $&drive
let drive = (floor(trial / 16) - 2*floor(trial / 32))*1.8
alter VB4 = $&drive
let drive = (floor(trial / 32) - 2*floor(trial / 64))*1.8
alter VB5 = $&drive
let drive = (floor(trial / 64) - 2*floor(trial / 128))*1.8
alter VB6 = $&drive
let drive = (floor(trial / 128) - 2*floor(trial / 256))*1.8
alter VB7 = $&drive
stop when time = 0.002156
resume
delete all
let endpoint = length(time)-1
let cmp = v(COMP)[endpoint]
let top = v(TOP)[endpoint]
let decision = 0
if cmp >= 0.9
let code = trial
let decision = 1
end
echo 119 2 $&trial $&cmp $&top 0.54609375 $&decision >> decisions.csv
let trial = code + 2
let drive = (floor(trial / 1) - 2*floor(trial / 2))*1.8
alter VB0 = $&drive
let drive = (floor(trial / 2) - 2*floor(trial / 4))*1.8
alter VB1 = $&drive
let drive = (floor(trial / 4) - 2*floor(trial / 8))*1.8
alter VB2 = $&drive
let drive = (floor(trial / 8) - 2*floor(trial / 16))*1.8
alter VB3 = $&drive
let drive = (floor(trial / 16) - 2*floor(trial / 32))*1.8
alter VB4 = $&drive
let drive = (floor(trial / 32) - 2*floor(trial / 64))*1.8
alter VB5 = $&drive
let drive = (floor(trial / 64) - 2*floor(trial / 128))*1.8
alter VB6 = $&drive
let drive = (floor(trial / 128) - 2*floor(trial / 256))*1.8
alter VB7 = $&drive
stop when time = 0.002158
resume
delete all
let endpoint = length(time)-1
let cmp = v(COMP)[endpoint]
let top = v(TOP)[endpoint]
let decision = 0
if cmp >= 0.9
let code = trial
let decision = 1
end
echo 119 1 $&trial $&cmp $&top 0.54609375 $&decision >> decisions.csv
let trial = code + 1
let drive = (floor(trial / 1) - 2*floor(trial / 2))*1.8
alter VB0 = $&drive
let drive = (floor(trial / 2) - 2*floor(trial / 4))*1.8
alter VB1 = $&drive
let drive = (floor(trial / 4) - 2*floor(trial / 8))*1.8
alter VB2 = $&drive
let drive = (floor(trial / 8) - 2*floor(trial / 16))*1.8
alter VB3 = $&drive
let drive = (floor(trial / 16) - 2*floor(trial / 32))*1.8
alter VB4 = $&drive
let drive = (floor(trial / 32) - 2*floor(trial / 64))*1.8
alter VB5 = $&drive
let drive = (floor(trial / 64) - 2*floor(trial / 128))*1.8
alter VB6 = $&drive
let drive = (floor(trial / 128) - 2*floor(trial / 256))*1.8
alter VB7 = $&drive
stop when time = 0.00216
resume
delete all
let endpoint = length(time)-1
let cmp = v(COMP)[endpoint]
let top = v(TOP)[endpoint]
let decision = 0
if cmp >= 0.9
let code = trial
let decision = 1
end
echo 119 0 $&trial $&cmp $&top 0.54609375 $&decision >> decisions.csv
alter VIN = 0.55078125
alter VSAMPLE = 1.8
alter VB0 = 0
alter VB1 = 0
alter VB2 = 0
alter VB3 = 0
alter VB4 = 0
alter VB5 = 0
alter VB6 = 0
alter VB7 = 0
let code = 0
stop when time = 0.002162
resume
delete all
alter VSAMPLE = 0
let trial = code + 128
let drive = (floor(trial / 1) - 2*floor(trial / 2))*1.8
alter VB0 = $&drive
let drive = (floor(trial / 2) - 2*floor(trial / 4))*1.8
alter VB1 = $&drive
let drive = (floor(trial / 4) - 2*floor(trial / 8))*1.8
alter VB2 = $&drive
let drive = (floor(trial / 8) - 2*floor(trial / 16))*1.8
alter VB3 = $&drive
let drive = (floor(trial / 16) - 2*floor(trial / 32))*1.8
alter VB4 = $&drive
let drive = (floor(trial / 32) - 2*floor(trial / 64))*1.8
alter VB5 = $&drive
let drive = (floor(trial / 64) - 2*floor(trial / 128))*1.8
alter VB6 = $&drive
let drive = (floor(trial / 128) - 2*floor(trial / 256))*1.8
alter VB7 = $&drive
stop when time = 0.002164
resume
delete all
let endpoint = length(time)-1
let cmp = v(COMP)[endpoint]
let top = v(TOP)[endpoint]
let decision = 0
if cmp >= 0.9
let code = trial
let decision = 1
end
echo 120 7 $&trial $&cmp $&top 0.55078125 $&decision >> decisions.csv
let trial = code + 64
let drive = (floor(trial / 1) - 2*floor(trial / 2))*1.8
alter VB0 = $&drive
let drive = (floor(trial / 2) - 2*floor(trial / 4))*1.8
alter VB1 = $&drive
let drive = (floor(trial / 4) - 2*floor(trial / 8))*1.8
alter VB2 = $&drive
let drive = (floor(trial / 8) - 2*floor(trial / 16))*1.8
alter VB3 = $&drive
let drive = (floor(trial / 16) - 2*floor(trial / 32))*1.8
alter VB4 = $&drive
let drive = (floor(trial / 32) - 2*floor(trial / 64))*1.8
alter VB5 = $&drive
let drive = (floor(trial / 64) - 2*floor(trial / 128))*1.8
alter VB6 = $&drive
let drive = (floor(trial / 128) - 2*floor(trial / 256))*1.8
alter VB7 = $&drive
stop when time = 0.002166
resume
delete all
let endpoint = length(time)-1
let cmp = v(COMP)[endpoint]
let top = v(TOP)[endpoint]
let decision = 0
if cmp >= 0.9
let code = trial
let decision = 1
end
echo 120 6 $&trial $&cmp $&top 0.55078125 $&decision >> decisions.csv
let trial = code + 32
let drive = (floor(trial / 1) - 2*floor(trial / 2))*1.8
alter VB0 = $&drive
let drive = (floor(trial / 2) - 2*floor(trial / 4))*1.8
alter VB1 = $&drive
let drive = (floor(trial / 4) - 2*floor(trial / 8))*1.8
alter VB2 = $&drive
let drive = (floor(trial / 8) - 2*floor(trial / 16))*1.8
alter VB3 = $&drive
let drive = (floor(trial / 16) - 2*floor(trial / 32))*1.8
alter VB4 = $&drive
let drive = (floor(trial / 32) - 2*floor(trial / 64))*1.8
alter VB5 = $&drive
let drive = (floor(trial / 64) - 2*floor(trial / 128))*1.8
alter VB6 = $&drive
let drive = (floor(trial / 128) - 2*floor(trial / 256))*1.8
alter VB7 = $&drive
stop when time = 0.002168
resume
delete all
let endpoint = length(time)-1
let cmp = v(COMP)[endpoint]
let top = v(TOP)[endpoint]
let decision = 0
if cmp >= 0.9
let code = trial
let decision = 1
end
echo 120 5 $&trial $&cmp $&top 0.55078125 $&decision >> decisions.csv
let trial = code + 16
let drive = (floor(trial / 1) - 2*floor(trial / 2))*1.8
alter VB0 = $&drive
let drive = (floor(trial / 2) - 2*floor(trial / 4))*1.8
alter VB1 = $&drive
let drive = (floor(trial / 4) - 2*floor(trial / 8))*1.8
alter VB2 = $&drive
let drive = (floor(trial / 8) - 2*floor(trial / 16))*1.8
alter VB3 = $&drive
let drive = (floor(trial / 16) - 2*floor(trial / 32))*1.8
alter VB4 = $&drive
let drive = (floor(trial / 32) - 2*floor(trial / 64))*1.8
alter VB5 = $&drive
let drive = (floor(trial / 64) - 2*floor(trial / 128))*1.8
alter VB6 = $&drive
let drive = (floor(trial / 128) - 2*floor(trial / 256))*1.8
alter VB7 = $&drive
stop when time = 0.00217
resume
delete all
let endpoint = length(time)-1
let cmp = v(COMP)[endpoint]
let top = v(TOP)[endpoint]
let decision = 0
if cmp >= 0.9
let code = trial
let decision = 1
end
echo 120 4 $&trial $&cmp $&top 0.55078125 $&decision >> decisions.csv
let trial = code + 8
let drive = (floor(trial / 1) - 2*floor(trial / 2))*1.8
alter VB0 = $&drive
let drive = (floor(trial / 2) - 2*floor(trial / 4))*1.8
alter VB1 = $&drive
let drive = (floor(trial / 4) - 2*floor(trial / 8))*1.8
alter VB2 = $&drive
let drive = (floor(trial / 8) - 2*floor(trial / 16))*1.8
alter VB3 = $&drive
let drive = (floor(trial / 16) - 2*floor(trial / 32))*1.8
alter VB4 = $&drive
let drive = (floor(trial / 32) - 2*floor(trial / 64))*1.8
alter VB5 = $&drive
let drive = (floor(trial / 64) - 2*floor(trial / 128))*1.8
alter VB6 = $&drive
let drive = (floor(trial / 128) - 2*floor(trial / 256))*1.8
alter VB7 = $&drive
stop when time = 0.002172
resume
delete all
let endpoint = length(time)-1
let cmp = v(COMP)[endpoint]
let top = v(TOP)[endpoint]
let decision = 0
if cmp >= 0.9
let code = trial
let decision = 1
end
echo 120 3 $&trial $&cmp $&top 0.55078125 $&decision >> decisions.csv
let trial = code + 4
let drive = (floor(trial / 1) - 2*floor(trial / 2))*1.8
alter VB0 = $&drive
let drive = (floor(trial / 2) - 2*floor(trial / 4))*1.8
alter VB1 = $&drive
let drive = (floor(trial / 4) - 2*floor(trial / 8))*1.8
alter VB2 = $&drive
let drive = (floor(trial / 8) - 2*floor(trial / 16))*1.8
alter VB3 = $&drive
let drive = (floor(trial / 16) - 2*floor(trial / 32))*1.8
alter VB4 = $&drive
let drive = (floor(trial / 32) - 2*floor(trial / 64))*1.8
alter VB5 = $&drive
let drive = (floor(trial / 64) - 2*floor(trial / 128))*1.8
alter VB6 = $&drive
let drive = (floor(trial / 128) - 2*floor(trial / 256))*1.8
alter VB7 = $&drive
stop when time = 0.002174
resume
delete all
let endpoint = length(time)-1
let cmp = v(COMP)[endpoint]
let top = v(TOP)[endpoint]
let decision = 0
if cmp >= 0.9
let code = trial
let decision = 1
end
echo 120 2 $&trial $&cmp $&top 0.55078125 $&decision >> decisions.csv
let trial = code + 2
let drive = (floor(trial / 1) - 2*floor(trial / 2))*1.8
alter VB0 = $&drive
let drive = (floor(trial / 2) - 2*floor(trial / 4))*1.8
alter VB1 = $&drive
let drive = (floor(trial / 4) - 2*floor(trial / 8))*1.8
alter VB2 = $&drive
let drive = (floor(trial / 8) - 2*floor(trial / 16))*1.8
alter VB3 = $&drive
let drive = (floor(trial / 16) - 2*floor(trial / 32))*1.8
alter VB4 = $&drive
let drive = (floor(trial / 32) - 2*floor(trial / 64))*1.8
alter VB5 = $&drive
let drive = (floor(trial / 64) - 2*floor(trial / 128))*1.8
alter VB6 = $&drive
let drive = (floor(trial / 128) - 2*floor(trial / 256))*1.8
alter VB7 = $&drive
stop when time = 0.002176
resume
delete all
let endpoint = length(time)-1
let cmp = v(COMP)[endpoint]
let top = v(TOP)[endpoint]
let decision = 0
if cmp >= 0.9
let code = trial
let decision = 1
end
echo 120 1 $&trial $&cmp $&top 0.55078125 $&decision >> decisions.csv
let trial = code + 1
let drive = (floor(trial / 1) - 2*floor(trial / 2))*1.8
alter VB0 = $&drive
let drive = (floor(trial / 2) - 2*floor(trial / 4))*1.8
alter VB1 = $&drive
let drive = (floor(trial / 4) - 2*floor(trial / 8))*1.8
alter VB2 = $&drive
let drive = (floor(trial / 8) - 2*floor(trial / 16))*1.8
alter VB3 = $&drive
let drive = (floor(trial / 16) - 2*floor(trial / 32))*1.8
alter VB4 = $&drive
let drive = (floor(trial / 32) - 2*floor(trial / 64))*1.8
alter VB5 = $&drive
let drive = (floor(trial / 64) - 2*floor(trial / 128))*1.8
alter VB6 = $&drive
let drive = (floor(trial / 128) - 2*floor(trial / 256))*1.8
alter VB7 = $&drive
stop when time = 0.002178
resume
delete all
let endpoint = length(time)-1
let cmp = v(COMP)[endpoint]
let top = v(TOP)[endpoint]
let decision = 0
if cmp >= 0.9
let code = trial
let decision = 1
end
echo 120 0 $&trial $&cmp $&top 0.55078125 $&decision >> decisions.csv
alter VIN = 0.55546875
alter VSAMPLE = 1.8
alter VB0 = 0
alter VB1 = 0
alter VB2 = 0
alter VB3 = 0
alter VB4 = 0
alter VB5 = 0
alter VB6 = 0
alter VB7 = 0
let code = 0
stop when time = 0.00218
resume
delete all
alter VSAMPLE = 0
let trial = code + 128
let drive = (floor(trial / 1) - 2*floor(trial / 2))*1.8
alter VB0 = $&drive
let drive = (floor(trial / 2) - 2*floor(trial / 4))*1.8
alter VB1 = $&drive
let drive = (floor(trial / 4) - 2*floor(trial / 8))*1.8
alter VB2 = $&drive
let drive = (floor(trial / 8) - 2*floor(trial / 16))*1.8
alter VB3 = $&drive
let drive = (floor(trial / 16) - 2*floor(trial / 32))*1.8
alter VB4 = $&drive
let drive = (floor(trial / 32) - 2*floor(trial / 64))*1.8
alter VB5 = $&drive
let drive = (floor(trial / 64) - 2*floor(trial / 128))*1.8
alter VB6 = $&drive
let drive = (floor(trial / 128) - 2*floor(trial / 256))*1.8
alter VB7 = $&drive
stop when time = 0.002182
resume
delete all
let endpoint = length(time)-1
let cmp = v(COMP)[endpoint]
let top = v(TOP)[endpoint]
let decision = 0
if cmp >= 0.9
let code = trial
let decision = 1
end
echo 121 7 $&trial $&cmp $&top 0.55546875 $&decision >> decisions.csv
let trial = code + 64
let drive = (floor(trial / 1) - 2*floor(trial / 2))*1.8
alter VB0 = $&drive
let drive = (floor(trial / 2) - 2*floor(trial / 4))*1.8
alter VB1 = $&drive
let drive = (floor(trial / 4) - 2*floor(trial / 8))*1.8
alter VB2 = $&drive
let drive = (floor(trial / 8) - 2*floor(trial / 16))*1.8
alter VB3 = $&drive
let drive = (floor(trial / 16) - 2*floor(trial / 32))*1.8
alter VB4 = $&drive
let drive = (floor(trial / 32) - 2*floor(trial / 64))*1.8
alter VB5 = $&drive
let drive = (floor(trial / 64) - 2*floor(trial / 128))*1.8
alter VB6 = $&drive
let drive = (floor(trial / 128) - 2*floor(trial / 256))*1.8
alter VB7 = $&drive
stop when time = 0.002184
resume
delete all
let endpoint = length(time)-1
let cmp = v(COMP)[endpoint]
let top = v(TOP)[endpoint]
let decision = 0
if cmp >= 0.9
let code = trial
let decision = 1
end
echo 121 6 $&trial $&cmp $&top 0.55546875 $&decision >> decisions.csv
let trial = code + 32
let drive = (floor(trial / 1) - 2*floor(trial / 2))*1.8
alter VB0 = $&drive
let drive = (floor(trial / 2) - 2*floor(trial / 4))*1.8
alter VB1 = $&drive
let drive = (floor(trial / 4) - 2*floor(trial / 8))*1.8
alter VB2 = $&drive
let drive = (floor(trial / 8) - 2*floor(trial / 16))*1.8
alter VB3 = $&drive
let drive = (floor(trial / 16) - 2*floor(trial / 32))*1.8
alter VB4 = $&drive
let drive = (floor(trial / 32) - 2*floor(trial / 64))*1.8
alter VB5 = $&drive
let drive = (floor(trial / 64) - 2*floor(trial / 128))*1.8
alter VB6 = $&drive
let drive = (floor(trial / 128) - 2*floor(trial / 256))*1.8
alter VB7 = $&drive
stop when time = 0.002186
resume
delete all
let endpoint = length(time)-1
let cmp = v(COMP)[endpoint]
let top = v(TOP)[endpoint]
let decision = 0
if cmp >= 0.9
let code = trial
let decision = 1
end
echo 121 5 $&trial $&cmp $&top 0.55546875 $&decision >> decisions.csv
let trial = code + 16
let drive = (floor(trial / 1) - 2*floor(trial / 2))*1.8
alter VB0 = $&drive
let drive = (floor(trial / 2) - 2*floor(trial / 4))*1.8
alter VB1 = $&drive
let drive = (floor(trial / 4) - 2*floor(trial / 8))*1.8
alter VB2 = $&drive
let drive = (floor(trial / 8) - 2*floor(trial / 16))*1.8
alter VB3 = $&drive
let drive = (floor(trial / 16) - 2*floor(trial / 32))*1.8
alter VB4 = $&drive
let drive = (floor(trial / 32) - 2*floor(trial / 64))*1.8
alter VB5 = $&drive
let drive = (floor(trial / 64) - 2*floor(trial / 128))*1.8
alter VB6 = $&drive
let drive = (floor(trial / 128) - 2*floor(trial / 256))*1.8
alter VB7 = $&drive
stop when time = 0.002188
resume
delete all
let endpoint = length(time)-1
let cmp = v(COMP)[endpoint]
let top = v(TOP)[endpoint]
let decision = 0
if cmp >= 0.9
let code = trial
let decision = 1
end
echo 121 4 $&trial $&cmp $&top 0.55546875 $&decision >> decisions.csv
let trial = code + 8
let drive = (floor(trial / 1) - 2*floor(trial / 2))*1.8
alter VB0 = $&drive
let drive = (floor(trial / 2) - 2*floor(trial / 4))*1.8
alter VB1 = $&drive
let drive = (floor(trial / 4) - 2*floor(trial / 8))*1.8
alter VB2 = $&drive
let drive = (floor(trial / 8) - 2*floor(trial / 16))*1.8
alter VB3 = $&drive
let drive = (floor(trial / 16) - 2*floor(trial / 32))*1.8
alter VB4 = $&drive
let drive = (floor(trial / 32) - 2*floor(trial / 64))*1.8
alter VB5 = $&drive
let drive = (floor(trial / 64) - 2*floor(trial / 128))*1.8
alter VB6 = $&drive
let drive = (floor(trial / 128) - 2*floor(trial / 256))*1.8
alter VB7 = $&drive
stop when time = 0.00219
resume
delete all
let endpoint = length(time)-1
let cmp = v(COMP)[endpoint]
let top = v(TOP)[endpoint]
let decision = 0
if cmp >= 0.9
let code = trial
let decision = 1
end
echo 121 3 $&trial $&cmp $&top 0.55546875 $&decision >> decisions.csv
let trial = code + 4
let drive = (floor(trial / 1) - 2*floor(trial / 2))*1.8
alter VB0 = $&drive
let drive = (floor(trial / 2) - 2*floor(trial / 4))*1.8
alter VB1 = $&drive
let drive = (floor(trial / 4) - 2*floor(trial / 8))*1.8
alter VB2 = $&drive
let drive = (floor(trial / 8) - 2*floor(trial / 16))*1.8
alter VB3 = $&drive
let drive = (floor(trial / 16) - 2*floor(trial / 32))*1.8
alter VB4 = $&drive
let drive = (floor(trial / 32) - 2*floor(trial / 64))*1.8
alter VB5 = $&drive
let drive = (floor(trial / 64) - 2*floor(trial / 128))*1.8
alter VB6 = $&drive
let drive = (floor(trial / 128) - 2*floor(trial / 256))*1.8
alter VB7 = $&drive
stop when time = 0.002192
resume
delete all
let endpoint = length(time)-1
let cmp = v(COMP)[endpoint]
let top = v(TOP)[endpoint]
let decision = 0
if cmp >= 0.9
let code = trial
let decision = 1
end
echo 121 2 $&trial $&cmp $&top 0.55546875 $&decision >> decisions.csv
let trial = code + 2
let drive = (floor(trial / 1) - 2*floor(trial / 2))*1.8
alter VB0 = $&drive
let drive = (floor(trial / 2) - 2*floor(trial / 4))*1.8
alter VB1 = $&drive
let drive = (floor(trial / 4) - 2*floor(trial / 8))*1.8
alter VB2 = $&drive
let drive = (floor(trial / 8) - 2*floor(trial / 16))*1.8
alter VB3 = $&drive
let drive = (floor(trial / 16) - 2*floor(trial / 32))*1.8
alter VB4 = $&drive
let drive = (floor(trial / 32) - 2*floor(trial / 64))*1.8
alter VB5 = $&drive
let drive = (floor(trial / 64) - 2*floor(trial / 128))*1.8
alter VB6 = $&drive
let drive = (floor(trial / 128) - 2*floor(trial / 256))*1.8
alter VB7 = $&drive
stop when time = 0.002194
resume
delete all
let endpoint = length(time)-1
let cmp = v(COMP)[endpoint]
let top = v(TOP)[endpoint]
let decision = 0
if cmp >= 0.9
let code = trial
let decision = 1
end
echo 121 1 $&trial $&cmp $&top 0.55546875 $&decision >> decisions.csv
let trial = code + 1
let drive = (floor(trial / 1) - 2*floor(trial / 2))*1.8
alter VB0 = $&drive
let drive = (floor(trial / 2) - 2*floor(trial / 4))*1.8
alter VB1 = $&drive
let drive = (floor(trial / 4) - 2*floor(trial / 8))*1.8
alter VB2 = $&drive
let drive = (floor(trial / 8) - 2*floor(trial / 16))*1.8
alter VB3 = $&drive
let drive = (floor(trial / 16) - 2*floor(trial / 32))*1.8
alter VB4 = $&drive
let drive = (floor(trial / 32) - 2*floor(trial / 64))*1.8
alter VB5 = $&drive
let drive = (floor(trial / 64) - 2*floor(trial / 128))*1.8
alter VB6 = $&drive
let drive = (floor(trial / 128) - 2*floor(trial / 256))*1.8
alter VB7 = $&drive
stop when time = 0.002196
resume
delete all
let endpoint = length(time)-1
let cmp = v(COMP)[endpoint]
let top = v(TOP)[endpoint]
let decision = 0
if cmp >= 0.9
let code = trial
let decision = 1
end
echo 121 0 $&trial $&cmp $&top 0.55546875 $&decision >> decisions.csv
alter VIN = 0.56015625
alter VSAMPLE = 1.8
alter VB0 = 0
alter VB1 = 0
alter VB2 = 0
alter VB3 = 0
alter VB4 = 0
alter VB5 = 0
alter VB6 = 0
alter VB7 = 0
let code = 0
stop when time = 0.002198
resume
delete all
alter VSAMPLE = 0
let trial = code + 128
let drive = (floor(trial / 1) - 2*floor(trial / 2))*1.8
alter VB0 = $&drive
let drive = (floor(trial / 2) - 2*floor(trial / 4))*1.8
alter VB1 = $&drive
let drive = (floor(trial / 4) - 2*floor(trial / 8))*1.8
alter VB2 = $&drive
let drive = (floor(trial / 8) - 2*floor(trial / 16))*1.8
alter VB3 = $&drive
let drive = (floor(trial / 16) - 2*floor(trial / 32))*1.8
alter VB4 = $&drive
let drive = (floor(trial / 32) - 2*floor(trial / 64))*1.8
alter VB5 = $&drive
let drive = (floor(trial / 64) - 2*floor(trial / 128))*1.8
alter VB6 = $&drive
let drive = (floor(trial / 128) - 2*floor(trial / 256))*1.8
alter VB7 = $&drive
stop when time = 0.0022
resume
delete all
let endpoint = length(time)-1
let cmp = v(COMP)[endpoint]
let top = v(TOP)[endpoint]
let decision = 0
if cmp >= 0.9
let code = trial
let decision = 1
end
echo 122 7 $&trial $&cmp $&top 0.56015625 $&decision >> decisions.csv
let trial = code + 64
let drive = (floor(trial / 1) - 2*floor(trial / 2))*1.8
alter VB0 = $&drive
let drive = (floor(trial / 2) - 2*floor(trial / 4))*1.8
alter VB1 = $&drive
let drive = (floor(trial / 4) - 2*floor(trial / 8))*1.8
alter VB2 = $&drive
let drive = (floor(trial / 8) - 2*floor(trial / 16))*1.8
alter VB3 = $&drive
let drive = (floor(trial / 16) - 2*floor(trial / 32))*1.8
alter VB4 = $&drive
let drive = (floor(trial / 32) - 2*floor(trial / 64))*1.8
alter VB5 = $&drive
let drive = (floor(trial / 64) - 2*floor(trial / 128))*1.8
alter VB6 = $&drive
let drive = (floor(trial / 128) - 2*floor(trial / 256))*1.8
alter VB7 = $&drive
stop when time = 0.002202
resume
delete all
let endpoint = length(time)-1
let cmp = v(COMP)[endpoint]
let top = v(TOP)[endpoint]
let decision = 0
if cmp >= 0.9
let code = trial
let decision = 1
end
echo 122 6 $&trial $&cmp $&top 0.56015625 $&decision >> decisions.csv
let trial = code + 32
let drive = (floor(trial / 1) - 2*floor(trial / 2))*1.8
alter VB0 = $&drive
let drive = (floor(trial / 2) - 2*floor(trial / 4))*1.8
alter VB1 = $&drive
let drive = (floor(trial / 4) - 2*floor(trial / 8))*1.8
alter VB2 = $&drive
let drive = (floor(trial / 8) - 2*floor(trial / 16))*1.8
alter VB3 = $&drive
let drive = (floor(trial / 16) - 2*floor(trial / 32))*1.8
alter VB4 = $&drive
let drive = (floor(trial / 32) - 2*floor(trial / 64))*1.8
alter VB5 = $&drive
let drive = (floor(trial / 64) - 2*floor(trial / 128))*1.8
alter VB6 = $&drive
let drive = (floor(trial / 128) - 2*floor(trial / 256))*1.8
alter VB7 = $&drive
stop when time = 0.002204
resume
delete all
let endpoint = length(time)-1
let cmp = v(COMP)[endpoint]
let top = v(TOP)[endpoint]
let decision = 0
if cmp >= 0.9
let code = trial
let decision = 1
end
echo 122 5 $&trial $&cmp $&top 0.56015625 $&decision >> decisions.csv
let trial = code + 16
let drive = (floor(trial / 1) - 2*floor(trial / 2))*1.8
alter VB0 = $&drive
let drive = (floor(trial / 2) - 2*floor(trial / 4))*1.8
alter VB1 = $&drive
let drive = (floor(trial / 4) - 2*floor(trial / 8))*1.8
alter VB2 = $&drive
let drive = (floor(trial / 8) - 2*floor(trial / 16))*1.8
alter VB3 = $&drive
let drive = (floor(trial / 16) - 2*floor(trial / 32))*1.8
alter VB4 = $&drive
let drive = (floor(trial / 32) - 2*floor(trial / 64))*1.8
alter VB5 = $&drive
let drive = (floor(trial / 64) - 2*floor(trial / 128))*1.8
alter VB6 = $&drive
let drive = (floor(trial / 128) - 2*floor(trial / 256))*1.8
alter VB7 = $&drive
stop when time = 0.002206
resume
delete all
let endpoint = length(time)-1
let cmp = v(COMP)[endpoint]
let top = v(TOP)[endpoint]
let decision = 0
if cmp >= 0.9
let code = trial
let decision = 1
end
echo 122 4 $&trial $&cmp $&top 0.56015625 $&decision >> decisions.csv
let trial = code + 8
let drive = (floor(trial / 1) - 2*floor(trial / 2))*1.8
alter VB0 = $&drive
let drive = (floor(trial / 2) - 2*floor(trial / 4))*1.8
alter VB1 = $&drive
let drive = (floor(trial / 4) - 2*floor(trial / 8))*1.8
alter VB2 = $&drive
let drive = (floor(trial / 8) - 2*floor(trial / 16))*1.8
alter VB3 = $&drive
let drive = (floor(trial / 16) - 2*floor(trial / 32))*1.8
alter VB4 = $&drive
let drive = (floor(trial / 32) - 2*floor(trial / 64))*1.8
alter VB5 = $&drive
let drive = (floor(trial / 64) - 2*floor(trial / 128))*1.8
alter VB6 = $&drive
let drive = (floor(trial / 128) - 2*floor(trial / 256))*1.8
alter VB7 = $&drive
stop when time = 0.002208
resume
delete all
let endpoint = length(time)-1
let cmp = v(COMP)[endpoint]
let top = v(TOP)[endpoint]
let decision = 0
if cmp >= 0.9
let code = trial
let decision = 1
end
echo 122 3 $&trial $&cmp $&top 0.56015625 $&decision >> decisions.csv
let trial = code + 4
let drive = (floor(trial / 1) - 2*floor(trial / 2))*1.8
alter VB0 = $&drive
let drive = (floor(trial / 2) - 2*floor(trial / 4))*1.8
alter VB1 = $&drive
let drive = (floor(trial / 4) - 2*floor(trial / 8))*1.8
alter VB2 = $&drive
let drive = (floor(trial / 8) - 2*floor(trial / 16))*1.8
alter VB3 = $&drive
let drive = (floor(trial / 16) - 2*floor(trial / 32))*1.8
alter VB4 = $&drive
let drive = (floor(trial / 32) - 2*floor(trial / 64))*1.8
alter VB5 = $&drive
let drive = (floor(trial / 64) - 2*floor(trial / 128))*1.8
alter VB6 = $&drive
let drive = (floor(trial / 128) - 2*floor(trial / 256))*1.8
alter VB7 = $&drive
stop when time = 0.00221
resume
delete all
let endpoint = length(time)-1
let cmp = v(COMP)[endpoint]
let top = v(TOP)[endpoint]
let decision = 0
if cmp >= 0.9
let code = trial
let decision = 1
end
echo 122 2 $&trial $&cmp $&top 0.56015625 $&decision >> decisions.csv
let trial = code + 2
let drive = (floor(trial / 1) - 2*floor(trial / 2))*1.8
alter VB0 = $&drive
let drive = (floor(trial / 2) - 2*floor(trial / 4))*1.8
alter VB1 = $&drive
let drive = (floor(trial / 4) - 2*floor(trial / 8))*1.8
alter VB2 = $&drive
let drive = (floor(trial / 8) - 2*floor(trial / 16))*1.8
alter VB3 = $&drive
let drive = (floor(trial / 16) - 2*floor(trial / 32))*1.8
alter VB4 = $&drive
let drive = (floor(trial / 32) - 2*floor(trial / 64))*1.8
alter VB5 = $&drive
let drive = (floor(trial / 64) - 2*floor(trial / 128))*1.8
alter VB6 = $&drive
let drive = (floor(trial / 128) - 2*floor(trial / 256))*1.8
alter VB7 = $&drive
stop when time = 0.002212
resume
delete all
let endpoint = length(time)-1
let cmp = v(COMP)[endpoint]
let top = v(TOP)[endpoint]
let decision = 0
if cmp >= 0.9
let code = trial
let decision = 1
end
echo 122 1 $&trial $&cmp $&top 0.56015625 $&decision >> decisions.csv
let trial = code + 1
let drive = (floor(trial / 1) - 2*floor(trial / 2))*1.8
alter VB0 = $&drive
let drive = (floor(trial / 2) - 2*floor(trial / 4))*1.8
alter VB1 = $&drive
let drive = (floor(trial / 4) - 2*floor(trial / 8))*1.8
alter VB2 = $&drive
let drive = (floor(trial / 8) - 2*floor(trial / 16))*1.8
alter VB3 = $&drive
let drive = (floor(trial / 16) - 2*floor(trial / 32))*1.8
alter VB4 = $&drive
let drive = (floor(trial / 32) - 2*floor(trial / 64))*1.8
alter VB5 = $&drive
let drive = (floor(trial / 64) - 2*floor(trial / 128))*1.8
alter VB6 = $&drive
let drive = (floor(trial / 128) - 2*floor(trial / 256))*1.8
alter VB7 = $&drive
stop when time = 0.002214
resume
delete all
let endpoint = length(time)-1
let cmp = v(COMP)[endpoint]
let top = v(TOP)[endpoint]
let decision = 0
if cmp >= 0.9
let code = trial
let decision = 1
end
echo 122 0 $&trial $&cmp $&top 0.56015625 $&decision >> decisions.csv
alter VIN = 0.56484375
alter VSAMPLE = 1.8
alter VB0 = 0
alter VB1 = 0
alter VB2 = 0
alter VB3 = 0
alter VB4 = 0
alter VB5 = 0
alter VB6 = 0
alter VB7 = 0
let code = 0
stop when time = 0.002216
resume
delete all
alter VSAMPLE = 0
let trial = code + 128
let drive = (floor(trial / 1) - 2*floor(trial / 2))*1.8
alter VB0 = $&drive
let drive = (floor(trial / 2) - 2*floor(trial / 4))*1.8
alter VB1 = $&drive
let drive = (floor(trial / 4) - 2*floor(trial / 8))*1.8
alter VB2 = $&drive
let drive = (floor(trial / 8) - 2*floor(trial / 16))*1.8
alter VB3 = $&drive
let drive = (floor(trial / 16) - 2*floor(trial / 32))*1.8
alter VB4 = $&drive
let drive = (floor(trial / 32) - 2*floor(trial / 64))*1.8
alter VB5 = $&drive
let drive = (floor(trial / 64) - 2*floor(trial / 128))*1.8
alter VB6 = $&drive
let drive = (floor(trial / 128) - 2*floor(trial / 256))*1.8
alter VB7 = $&drive
stop when time = 0.002218
resume
delete all
let endpoint = length(time)-1
let cmp = v(COMP)[endpoint]
let top = v(TOP)[endpoint]
let decision = 0
if cmp >= 0.9
let code = trial
let decision = 1
end
echo 123 7 $&trial $&cmp $&top 0.56484375 $&decision >> decisions.csv
let trial = code + 64
let drive = (floor(trial / 1) - 2*floor(trial / 2))*1.8
alter VB0 = $&drive
let drive = (floor(trial / 2) - 2*floor(trial / 4))*1.8
alter VB1 = $&drive
let drive = (floor(trial / 4) - 2*floor(trial / 8))*1.8
alter VB2 = $&drive
let drive = (floor(trial / 8) - 2*floor(trial / 16))*1.8
alter VB3 = $&drive
let drive = (floor(trial / 16) - 2*floor(trial / 32))*1.8
alter VB4 = $&drive
let drive = (floor(trial / 32) - 2*floor(trial / 64))*1.8
alter VB5 = $&drive
let drive = (floor(trial / 64) - 2*floor(trial / 128))*1.8
alter VB6 = $&drive
let drive = (floor(trial / 128) - 2*floor(trial / 256))*1.8
alter VB7 = $&drive
stop when time = 0.00222
resume
delete all
let endpoint = length(time)-1
let cmp = v(COMP)[endpoint]
let top = v(TOP)[endpoint]
let decision = 0
if cmp >= 0.9
let code = trial
let decision = 1
end
echo 123 6 $&trial $&cmp $&top 0.56484375 $&decision >> decisions.csv
let trial = code + 32
let drive = (floor(trial / 1) - 2*floor(trial / 2))*1.8
alter VB0 = $&drive
let drive = (floor(trial / 2) - 2*floor(trial / 4))*1.8
alter VB1 = $&drive
let drive = (floor(trial / 4) - 2*floor(trial / 8))*1.8
alter VB2 = $&drive
let drive = (floor(trial / 8) - 2*floor(trial / 16))*1.8
alter VB3 = $&drive
let drive = (floor(trial / 16) - 2*floor(trial / 32))*1.8
alter VB4 = $&drive
let drive = (floor(trial / 32) - 2*floor(trial / 64))*1.8
alter VB5 = $&drive
let drive = (floor(trial / 64) - 2*floor(trial / 128))*1.8
alter VB6 = $&drive
let drive = (floor(trial / 128) - 2*floor(trial / 256))*1.8
alter VB7 = $&drive
stop when time = 0.002222
resume
delete all
let endpoint = length(time)-1
let cmp = v(COMP)[endpoint]
let top = v(TOP)[endpoint]
let decision = 0
if cmp >= 0.9
let code = trial
let decision = 1
end
echo 123 5 $&trial $&cmp $&top 0.56484375 $&decision >> decisions.csv
let trial = code + 16
let drive = (floor(trial / 1) - 2*floor(trial / 2))*1.8
alter VB0 = $&drive
let drive = (floor(trial / 2) - 2*floor(trial / 4))*1.8
alter VB1 = $&drive
let drive = (floor(trial / 4) - 2*floor(trial / 8))*1.8
alter VB2 = $&drive
let drive = (floor(trial / 8) - 2*floor(trial / 16))*1.8
alter VB3 = $&drive
let drive = (floor(trial / 16) - 2*floor(trial / 32))*1.8
alter VB4 = $&drive
let drive = (floor(trial / 32) - 2*floor(trial / 64))*1.8
alter VB5 = $&drive
let drive = (floor(trial / 64) - 2*floor(trial / 128))*1.8
alter VB6 = $&drive
let drive = (floor(trial / 128) - 2*floor(trial / 256))*1.8
alter VB7 = $&drive
stop when time = 0.002224
resume
delete all
let endpoint = length(time)-1
let cmp = v(COMP)[endpoint]
let top = v(TOP)[endpoint]
let decision = 0
if cmp >= 0.9
let code = trial
let decision = 1
end
echo 123 4 $&trial $&cmp $&top 0.56484375 $&decision >> decisions.csv
let trial = code + 8
let drive = (floor(trial / 1) - 2*floor(trial / 2))*1.8
alter VB0 = $&drive
let drive = (floor(trial / 2) - 2*floor(trial / 4))*1.8
alter VB1 = $&drive
let drive = (floor(trial / 4) - 2*floor(trial / 8))*1.8
alter VB2 = $&drive
let drive = (floor(trial / 8) - 2*floor(trial / 16))*1.8
alter VB3 = $&drive
let drive = (floor(trial / 16) - 2*floor(trial / 32))*1.8
alter VB4 = $&drive
let drive = (floor(trial / 32) - 2*floor(trial / 64))*1.8
alter VB5 = $&drive
let drive = (floor(trial / 64) - 2*floor(trial / 128))*1.8
alter VB6 = $&drive
let drive = (floor(trial / 128) - 2*floor(trial / 256))*1.8
alter VB7 = $&drive
stop when time = 0.002226
resume
delete all
let endpoint = length(time)-1
let cmp = v(COMP)[endpoint]
let top = v(TOP)[endpoint]
let decision = 0
if cmp >= 0.9
let code = trial
let decision = 1
end
echo 123 3 $&trial $&cmp $&top 0.56484375 $&decision >> decisions.csv
let trial = code + 4
let drive = (floor(trial / 1) - 2*floor(trial / 2))*1.8
alter VB0 = $&drive
let drive = (floor(trial / 2) - 2*floor(trial / 4))*1.8
alter VB1 = $&drive
let drive = (floor(trial / 4) - 2*floor(trial / 8))*1.8
alter VB2 = $&drive
let drive = (floor(trial / 8) - 2*floor(trial / 16))*1.8
alter VB3 = $&drive
let drive = (floor(trial / 16) - 2*floor(trial / 32))*1.8
alter VB4 = $&drive
let drive = (floor(trial / 32) - 2*floor(trial / 64))*1.8
alter VB5 = $&drive
let drive = (floor(trial / 64) - 2*floor(trial / 128))*1.8
alter VB6 = $&drive
let drive = (floor(trial / 128) - 2*floor(trial / 256))*1.8
alter VB7 = $&drive
stop when time = 0.002228
resume
delete all
let endpoint = length(time)-1
let cmp = v(COMP)[endpoint]
let top = v(TOP)[endpoint]
let decision = 0
if cmp >= 0.9
let code = trial
let decision = 1
end
echo 123 2 $&trial $&cmp $&top 0.56484375 $&decision >> decisions.csv
let trial = code + 2
let drive = (floor(trial / 1) - 2*floor(trial / 2))*1.8
alter VB0 = $&drive
let drive = (floor(trial / 2) - 2*floor(trial / 4))*1.8
alter VB1 = $&drive
let drive = (floor(trial / 4) - 2*floor(trial / 8))*1.8
alter VB2 = $&drive
let drive = (floor(trial / 8) - 2*floor(trial / 16))*1.8
alter VB3 = $&drive
let drive = (floor(trial / 16) - 2*floor(trial / 32))*1.8
alter VB4 = $&drive
let drive = (floor(trial / 32) - 2*floor(trial / 64))*1.8
alter VB5 = $&drive
let drive = (floor(trial / 64) - 2*floor(trial / 128))*1.8
alter VB6 = $&drive
let drive = (floor(trial / 128) - 2*floor(trial / 256))*1.8
alter VB7 = $&drive
stop when time = 0.00223
resume
delete all
let endpoint = length(time)-1
let cmp = v(COMP)[endpoint]
let top = v(TOP)[endpoint]
let decision = 0
if cmp >= 0.9
let code = trial
let decision = 1
end
echo 123 1 $&trial $&cmp $&top 0.56484375 $&decision >> decisions.csv
let trial = code + 1
let drive = (floor(trial / 1) - 2*floor(trial / 2))*1.8
alter VB0 = $&drive
let drive = (floor(trial / 2) - 2*floor(trial / 4))*1.8
alter VB1 = $&drive
let drive = (floor(trial / 4) - 2*floor(trial / 8))*1.8
alter VB2 = $&drive
let drive = (floor(trial / 8) - 2*floor(trial / 16))*1.8
alter VB3 = $&drive
let drive = (floor(trial / 16) - 2*floor(trial / 32))*1.8
alter VB4 = $&drive
let drive = (floor(trial / 32) - 2*floor(trial / 64))*1.8
alter VB5 = $&drive
let drive = (floor(trial / 64) - 2*floor(trial / 128))*1.8
alter VB6 = $&drive
let drive = (floor(trial / 128) - 2*floor(trial / 256))*1.8
alter VB7 = $&drive
stop when time = 0.002232
resume
delete all
let endpoint = length(time)-1
let cmp = v(COMP)[endpoint]
let top = v(TOP)[endpoint]
let decision = 0
if cmp >= 0.9
let code = trial
let decision = 1
end
echo 123 0 $&trial $&cmp $&top 0.56484375 $&decision >> decisions.csv
alter VIN = 0.56953125
alter VSAMPLE = 1.8
alter VB0 = 0
alter VB1 = 0
alter VB2 = 0
alter VB3 = 0
alter VB4 = 0
alter VB5 = 0
alter VB6 = 0
alter VB7 = 0
let code = 0
stop when time = 0.002234
resume
delete all
alter VSAMPLE = 0
let trial = code + 128
let drive = (floor(trial / 1) - 2*floor(trial / 2))*1.8
alter VB0 = $&drive
let drive = (floor(trial / 2) - 2*floor(trial / 4))*1.8
alter VB1 = $&drive
let drive = (floor(trial / 4) - 2*floor(trial / 8))*1.8
alter VB2 = $&drive
let drive = (floor(trial / 8) - 2*floor(trial / 16))*1.8
alter VB3 = $&drive
let drive = (floor(trial / 16) - 2*floor(trial / 32))*1.8
alter VB4 = $&drive
let drive = (floor(trial / 32) - 2*floor(trial / 64))*1.8
alter VB5 = $&drive
let drive = (floor(trial / 64) - 2*floor(trial / 128))*1.8
alter VB6 = $&drive
let drive = (floor(trial / 128) - 2*floor(trial / 256))*1.8
alter VB7 = $&drive
stop when time = 0.002236
resume
delete all
let endpoint = length(time)-1
let cmp = v(COMP)[endpoint]
let top = v(TOP)[endpoint]
let decision = 0
if cmp >= 0.9
let code = trial
let decision = 1
end
echo 124 7 $&trial $&cmp $&top 0.56953125 $&decision >> decisions.csv
let trial = code + 64
let drive = (floor(trial / 1) - 2*floor(trial / 2))*1.8
alter VB0 = $&drive
let drive = (floor(trial / 2) - 2*floor(trial / 4))*1.8
alter VB1 = $&drive
let drive = (floor(trial / 4) - 2*floor(trial / 8))*1.8
alter VB2 = $&drive
let drive = (floor(trial / 8) - 2*floor(trial / 16))*1.8
alter VB3 = $&drive
let drive = (floor(trial / 16) - 2*floor(trial / 32))*1.8
alter VB4 = $&drive
let drive = (floor(trial / 32) - 2*floor(trial / 64))*1.8
alter VB5 = $&drive
let drive = (floor(trial / 64) - 2*floor(trial / 128))*1.8
alter VB6 = $&drive
let drive = (floor(trial / 128) - 2*floor(trial / 256))*1.8
alter VB7 = $&drive
stop when time = 0.002238
resume
delete all
let endpoint = length(time)-1
let cmp = v(COMP)[endpoint]
let top = v(TOP)[endpoint]
let decision = 0
if cmp >= 0.9
let code = trial
let decision = 1
end
echo 124 6 $&trial $&cmp $&top 0.56953125 $&decision >> decisions.csv
let trial = code + 32
let drive = (floor(trial / 1) - 2*floor(trial / 2))*1.8
alter VB0 = $&drive
let drive = (floor(trial / 2) - 2*floor(trial / 4))*1.8
alter VB1 = $&drive
let drive = (floor(trial / 4) - 2*floor(trial / 8))*1.8
alter VB2 = $&drive
let drive = (floor(trial / 8) - 2*floor(trial / 16))*1.8
alter VB3 = $&drive
let drive = (floor(trial / 16) - 2*floor(trial / 32))*1.8
alter VB4 = $&drive
let drive = (floor(trial / 32) - 2*floor(trial / 64))*1.8
alter VB5 = $&drive
let drive = (floor(trial / 64) - 2*floor(trial / 128))*1.8
alter VB6 = $&drive
let drive = (floor(trial / 128) - 2*floor(trial / 256))*1.8
alter VB7 = $&drive
stop when time = 0.00224
resume
delete all
let endpoint = length(time)-1
let cmp = v(COMP)[endpoint]
let top = v(TOP)[endpoint]
let decision = 0
if cmp >= 0.9
let code = trial
let decision = 1
end
echo 124 5 $&trial $&cmp $&top 0.56953125 $&decision >> decisions.csv
let trial = code + 16
let drive = (floor(trial / 1) - 2*floor(trial / 2))*1.8
alter VB0 = $&drive
let drive = (floor(trial / 2) - 2*floor(trial / 4))*1.8
alter VB1 = $&drive
let drive = (floor(trial / 4) - 2*floor(trial / 8))*1.8
alter VB2 = $&drive
let drive = (floor(trial / 8) - 2*floor(trial / 16))*1.8
alter VB3 = $&drive
let drive = (floor(trial / 16) - 2*floor(trial / 32))*1.8
alter VB4 = $&drive
let drive = (floor(trial / 32) - 2*floor(trial / 64))*1.8
alter VB5 = $&drive
let drive = (floor(trial / 64) - 2*floor(trial / 128))*1.8
alter VB6 = $&drive
let drive = (floor(trial / 128) - 2*floor(trial / 256))*1.8
alter VB7 = $&drive
stop when time = 0.002242
resume
delete all
let endpoint = length(time)-1
let cmp = v(COMP)[endpoint]
let top = v(TOP)[endpoint]
let decision = 0
if cmp >= 0.9
let code = trial
let decision = 1
end
echo 124 4 $&trial $&cmp $&top 0.56953125 $&decision >> decisions.csv
let trial = code + 8
let drive = (floor(trial / 1) - 2*floor(trial / 2))*1.8
alter VB0 = $&drive
let drive = (floor(trial / 2) - 2*floor(trial / 4))*1.8
alter VB1 = $&drive
let drive = (floor(trial / 4) - 2*floor(trial / 8))*1.8
alter VB2 = $&drive
let drive = (floor(trial / 8) - 2*floor(trial / 16))*1.8
alter VB3 = $&drive
let drive = (floor(trial / 16) - 2*floor(trial / 32))*1.8
alter VB4 = $&drive
let drive = (floor(trial / 32) - 2*floor(trial / 64))*1.8
alter VB5 = $&drive
let drive = (floor(trial / 64) - 2*floor(trial / 128))*1.8
alter VB6 = $&drive
let drive = (floor(trial / 128) - 2*floor(trial / 256))*1.8
alter VB7 = $&drive
stop when time = 0.002244
resume
delete all
let endpoint = length(time)-1
let cmp = v(COMP)[endpoint]
let top = v(TOP)[endpoint]
let decision = 0
if cmp >= 0.9
let code = trial
let decision = 1
end
echo 124 3 $&trial $&cmp $&top 0.56953125 $&decision >> decisions.csv
let trial = code + 4
let drive = (floor(trial / 1) - 2*floor(trial / 2))*1.8
alter VB0 = $&drive
let drive = (floor(trial / 2) - 2*floor(trial / 4))*1.8
alter VB1 = $&drive
let drive = (floor(trial / 4) - 2*floor(trial / 8))*1.8
alter VB2 = $&drive
let drive = (floor(trial / 8) - 2*floor(trial / 16))*1.8
alter VB3 = $&drive
let drive = (floor(trial / 16) - 2*floor(trial / 32))*1.8
alter VB4 = $&drive
let drive = (floor(trial / 32) - 2*floor(trial / 64))*1.8
alter VB5 = $&drive
let drive = (floor(trial / 64) - 2*floor(trial / 128))*1.8
alter VB6 = $&drive
let drive = (floor(trial / 128) - 2*floor(trial / 256))*1.8
alter VB7 = $&drive
stop when time = 0.002246
resume
delete all
let endpoint = length(time)-1
let cmp = v(COMP)[endpoint]
let top = v(TOP)[endpoint]
let decision = 0
if cmp >= 0.9
let code = trial
let decision = 1
end
echo 124 2 $&trial $&cmp $&top 0.56953125 $&decision >> decisions.csv
let trial = code + 2
let drive = (floor(trial / 1) - 2*floor(trial / 2))*1.8
alter VB0 = $&drive
let drive = (floor(trial / 2) - 2*floor(trial / 4))*1.8
alter VB1 = $&drive
let drive = (floor(trial / 4) - 2*floor(trial / 8))*1.8
alter VB2 = $&drive
let drive = (floor(trial / 8) - 2*floor(trial / 16))*1.8
alter VB3 = $&drive
let drive = (floor(trial / 16) - 2*floor(trial / 32))*1.8
alter VB4 = $&drive
let drive = (floor(trial / 32) - 2*floor(trial / 64))*1.8
alter VB5 = $&drive
let drive = (floor(trial / 64) - 2*floor(trial / 128))*1.8
alter VB6 = $&drive
let drive = (floor(trial / 128) - 2*floor(trial / 256))*1.8
alter VB7 = $&drive
stop when time = 0.002248
resume
delete all
let endpoint = length(time)-1
let cmp = v(COMP)[endpoint]
let top = v(TOP)[endpoint]
let decision = 0
if cmp >= 0.9
let code = trial
let decision = 1
end
echo 124 1 $&trial $&cmp $&top 0.56953125 $&decision >> decisions.csv
let trial = code + 1
let drive = (floor(trial / 1) - 2*floor(trial / 2))*1.8
alter VB0 = $&drive
let drive = (floor(trial / 2) - 2*floor(trial / 4))*1.8
alter VB1 = $&drive
let drive = (floor(trial / 4) - 2*floor(trial / 8))*1.8
alter VB2 = $&drive
let drive = (floor(trial / 8) - 2*floor(trial / 16))*1.8
alter VB3 = $&drive
let drive = (floor(trial / 16) - 2*floor(trial / 32))*1.8
alter VB4 = $&drive
let drive = (floor(trial / 32) - 2*floor(trial / 64))*1.8
alter VB5 = $&drive
let drive = (floor(trial / 64) - 2*floor(trial / 128))*1.8
alter VB6 = $&drive
let drive = (floor(trial / 128) - 2*floor(trial / 256))*1.8
alter VB7 = $&drive
stop when time = 0.00225
resume
delete all
let endpoint = length(time)-1
let cmp = v(COMP)[endpoint]
let top = v(TOP)[endpoint]
let decision = 0
if cmp >= 0.9
let code = trial
let decision = 1
end
echo 124 0 $&trial $&cmp $&top 0.56953125 $&decision >> decisions.csv
alter VIN = 0.57421875
alter VSAMPLE = 1.8
alter VB0 = 0
alter VB1 = 0
alter VB2 = 0
alter VB3 = 0
alter VB4 = 0
alter VB5 = 0
alter VB6 = 0
alter VB7 = 0
let code = 0
stop when time = 0.002252
resume
delete all
alter VSAMPLE = 0
let trial = code + 128
let drive = (floor(trial / 1) - 2*floor(trial / 2))*1.8
alter VB0 = $&drive
let drive = (floor(trial / 2) - 2*floor(trial / 4))*1.8
alter VB1 = $&drive
let drive = (floor(trial / 4) - 2*floor(trial / 8))*1.8
alter VB2 = $&drive
let drive = (floor(trial / 8) - 2*floor(trial / 16))*1.8
alter VB3 = $&drive
let drive = (floor(trial / 16) - 2*floor(trial / 32))*1.8
alter VB4 = $&drive
let drive = (floor(trial / 32) - 2*floor(trial / 64))*1.8
alter VB5 = $&drive
let drive = (floor(trial / 64) - 2*floor(trial / 128))*1.8
alter VB6 = $&drive
let drive = (floor(trial / 128) - 2*floor(trial / 256))*1.8
alter VB7 = $&drive
stop when time = 0.002254
resume
delete all
let endpoint = length(time)-1
let cmp = v(COMP)[endpoint]
let top = v(TOP)[endpoint]
let decision = 0
if cmp >= 0.9
let code = trial
let decision = 1
end
echo 125 7 $&trial $&cmp $&top 0.57421875 $&decision >> decisions.csv
let trial = code + 64
let drive = (floor(trial / 1) - 2*floor(trial / 2))*1.8
alter VB0 = $&drive
let drive = (floor(trial / 2) - 2*floor(trial / 4))*1.8
alter VB1 = $&drive
let drive = (floor(trial / 4) - 2*floor(trial / 8))*1.8
alter VB2 = $&drive
let drive = (floor(trial / 8) - 2*floor(trial / 16))*1.8
alter VB3 = $&drive
let drive = (floor(trial / 16) - 2*floor(trial / 32))*1.8
alter VB4 = $&drive
let drive = (floor(trial / 32) - 2*floor(trial / 64))*1.8
alter VB5 = $&drive
let drive = (floor(trial / 64) - 2*floor(trial / 128))*1.8
alter VB6 = $&drive
let drive = (floor(trial / 128) - 2*floor(trial / 256))*1.8
alter VB7 = $&drive
stop when time = 0.002256
resume
delete all
let endpoint = length(time)-1
let cmp = v(COMP)[endpoint]
let top = v(TOP)[endpoint]
let decision = 0
if cmp >= 0.9
let code = trial
let decision = 1
end
echo 125 6 $&trial $&cmp $&top 0.57421875 $&decision >> decisions.csv
let trial = code + 32
let drive = (floor(trial / 1) - 2*floor(trial / 2))*1.8
alter VB0 = $&drive
let drive = (floor(trial / 2) - 2*floor(trial / 4))*1.8
alter VB1 = $&drive
let drive = (floor(trial / 4) - 2*floor(trial / 8))*1.8
alter VB2 = $&drive
let drive = (floor(trial / 8) - 2*floor(trial / 16))*1.8
alter VB3 = $&drive
let drive = (floor(trial / 16) - 2*floor(trial / 32))*1.8
alter VB4 = $&drive
let drive = (floor(trial / 32) - 2*floor(trial / 64))*1.8
alter VB5 = $&drive
let drive = (floor(trial / 64) - 2*floor(trial / 128))*1.8
alter VB6 = $&drive
let drive = (floor(trial / 128) - 2*floor(trial / 256))*1.8
alter VB7 = $&drive
stop when time = 0.002258
resume
delete all
let endpoint = length(time)-1
let cmp = v(COMP)[endpoint]
let top = v(TOP)[endpoint]
let decision = 0
if cmp >= 0.9
let code = trial
let decision = 1
end
echo 125 5 $&trial $&cmp $&top 0.57421875 $&decision >> decisions.csv
let trial = code + 16
let drive = (floor(trial / 1) - 2*floor(trial / 2))*1.8
alter VB0 = $&drive
let drive = (floor(trial / 2) - 2*floor(trial / 4))*1.8
alter VB1 = $&drive
let drive = (floor(trial / 4) - 2*floor(trial / 8))*1.8
alter VB2 = $&drive
let drive = (floor(trial / 8) - 2*floor(trial / 16))*1.8
alter VB3 = $&drive
let drive = (floor(trial / 16) - 2*floor(trial / 32))*1.8
alter VB4 = $&drive
let drive = (floor(trial / 32) - 2*floor(trial / 64))*1.8
alter VB5 = $&drive
let drive = (floor(trial / 64) - 2*floor(trial / 128))*1.8
alter VB6 = $&drive
let drive = (floor(trial / 128) - 2*floor(trial / 256))*1.8
alter VB7 = $&drive
stop when time = 0.00226
resume
delete all
let endpoint = length(time)-1
let cmp = v(COMP)[endpoint]
let top = v(TOP)[endpoint]
let decision = 0
if cmp >= 0.9
let code = trial
let decision = 1
end
echo 125 4 $&trial $&cmp $&top 0.57421875 $&decision >> decisions.csv
let trial = code + 8
let drive = (floor(trial / 1) - 2*floor(trial / 2))*1.8
alter VB0 = $&drive
let drive = (floor(trial / 2) - 2*floor(trial / 4))*1.8
alter VB1 = $&drive
let drive = (floor(trial / 4) - 2*floor(trial / 8))*1.8
alter VB2 = $&drive
let drive = (floor(trial / 8) - 2*floor(trial / 16))*1.8
alter VB3 = $&drive
let drive = (floor(trial / 16) - 2*floor(trial / 32))*1.8
alter VB4 = $&drive
let drive = (floor(trial / 32) - 2*floor(trial / 64))*1.8
alter VB5 = $&drive
let drive = (floor(trial / 64) - 2*floor(trial / 128))*1.8
alter VB6 = $&drive
let drive = (floor(trial / 128) - 2*floor(trial / 256))*1.8
alter VB7 = $&drive
stop when time = 0.002262
resume
delete all
let endpoint = length(time)-1
let cmp = v(COMP)[endpoint]
let top = v(TOP)[endpoint]
let decision = 0
if cmp >= 0.9
let code = trial
let decision = 1
end
echo 125 3 $&trial $&cmp $&top 0.57421875 $&decision >> decisions.csv
let trial = code + 4
let drive = (floor(trial / 1) - 2*floor(trial / 2))*1.8
alter VB0 = $&drive
let drive = (floor(trial / 2) - 2*floor(trial / 4))*1.8
alter VB1 = $&drive
let drive = (floor(trial / 4) - 2*floor(trial / 8))*1.8
alter VB2 = $&drive
let drive = (floor(trial / 8) - 2*floor(trial / 16))*1.8
alter VB3 = $&drive
let drive = (floor(trial / 16) - 2*floor(trial / 32))*1.8
alter VB4 = $&drive
let drive = (floor(trial / 32) - 2*floor(trial / 64))*1.8
alter VB5 = $&drive
let drive = (floor(trial / 64) - 2*floor(trial / 128))*1.8
alter VB6 = $&drive
let drive = (floor(trial / 128) - 2*floor(trial / 256))*1.8
alter VB7 = $&drive
stop when time = 0.002264
resume
delete all
let endpoint = length(time)-1
let cmp = v(COMP)[endpoint]
let top = v(TOP)[endpoint]
let decision = 0
if cmp >= 0.9
let code = trial
let decision = 1
end
echo 125 2 $&trial $&cmp $&top 0.57421875 $&decision >> decisions.csv
let trial = code + 2
let drive = (floor(trial / 1) - 2*floor(trial / 2))*1.8
alter VB0 = $&drive
let drive = (floor(trial / 2) - 2*floor(trial / 4))*1.8
alter VB1 = $&drive
let drive = (floor(trial / 4) - 2*floor(trial / 8))*1.8
alter VB2 = $&drive
let drive = (floor(trial / 8) - 2*floor(trial / 16))*1.8
alter VB3 = $&drive
let drive = (floor(trial / 16) - 2*floor(trial / 32))*1.8
alter VB4 = $&drive
let drive = (floor(trial / 32) - 2*floor(trial / 64))*1.8
alter VB5 = $&drive
let drive = (floor(trial / 64) - 2*floor(trial / 128))*1.8
alter VB6 = $&drive
let drive = (floor(trial / 128) - 2*floor(trial / 256))*1.8
alter VB7 = $&drive
stop when time = 0.002266
resume
delete all
let endpoint = length(time)-1
let cmp = v(COMP)[endpoint]
let top = v(TOP)[endpoint]
let decision = 0
if cmp >= 0.9
let code = trial
let decision = 1
end
echo 125 1 $&trial $&cmp $&top 0.57421875 $&decision >> decisions.csv
let trial = code + 1
let drive = (floor(trial / 1) - 2*floor(trial / 2))*1.8
alter VB0 = $&drive
let drive = (floor(trial / 2) - 2*floor(trial / 4))*1.8
alter VB1 = $&drive
let drive = (floor(trial / 4) - 2*floor(trial / 8))*1.8
alter VB2 = $&drive
let drive = (floor(trial / 8) - 2*floor(trial / 16))*1.8
alter VB3 = $&drive
let drive = (floor(trial / 16) - 2*floor(trial / 32))*1.8
alter VB4 = $&drive
let drive = (floor(trial / 32) - 2*floor(trial / 64))*1.8
alter VB5 = $&drive
let drive = (floor(trial / 64) - 2*floor(trial / 128))*1.8
alter VB6 = $&drive
let drive = (floor(trial / 128) - 2*floor(trial / 256))*1.8
alter VB7 = $&drive
stop when time = 0.002268
resume
delete all
let endpoint = length(time)-1
let cmp = v(COMP)[endpoint]
let top = v(TOP)[endpoint]
let decision = 0
if cmp >= 0.9
let code = trial
let decision = 1
end
echo 125 0 $&trial $&cmp $&top 0.57421875 $&decision >> decisions.csv
alter VIN = 0.57890625
alter VSAMPLE = 1.8
alter VB0 = 0
alter VB1 = 0
alter VB2 = 0
alter VB3 = 0
alter VB4 = 0
alter VB5 = 0
alter VB6 = 0
alter VB7 = 0
let code = 0
stop when time = 0.00227
resume
delete all
alter VSAMPLE = 0
let trial = code + 128
let drive = (floor(trial / 1) - 2*floor(trial / 2))*1.8
alter VB0 = $&drive
let drive = (floor(trial / 2) - 2*floor(trial / 4))*1.8
alter VB1 = $&drive
let drive = (floor(trial / 4) - 2*floor(trial / 8))*1.8
alter VB2 = $&drive
let drive = (floor(trial / 8) - 2*floor(trial / 16))*1.8
alter VB3 = $&drive
let drive = (floor(trial / 16) - 2*floor(trial / 32))*1.8
alter VB4 = $&drive
let drive = (floor(trial / 32) - 2*floor(trial / 64))*1.8
alter VB5 = $&drive
let drive = (floor(trial / 64) - 2*floor(trial / 128))*1.8
alter VB6 = $&drive
let drive = (floor(trial / 128) - 2*floor(trial / 256))*1.8
alter VB7 = $&drive
stop when time = 0.002272
resume
delete all
let endpoint = length(time)-1
let cmp = v(COMP)[endpoint]
let top = v(TOP)[endpoint]
let decision = 0
if cmp >= 0.9
let code = trial
let decision = 1
end
echo 126 7 $&trial $&cmp $&top 0.57890625 $&decision >> decisions.csv
let trial = code + 64
let drive = (floor(trial / 1) - 2*floor(trial / 2))*1.8
alter VB0 = $&drive
let drive = (floor(trial / 2) - 2*floor(trial / 4))*1.8
alter VB1 = $&drive
let drive = (floor(trial / 4) - 2*floor(trial / 8))*1.8
alter VB2 = $&drive
let drive = (floor(trial / 8) - 2*floor(trial / 16))*1.8
alter VB3 = $&drive
let drive = (floor(trial / 16) - 2*floor(trial / 32))*1.8
alter VB4 = $&drive
let drive = (floor(trial / 32) - 2*floor(trial / 64))*1.8
alter VB5 = $&drive
let drive = (floor(trial / 64) - 2*floor(trial / 128))*1.8
alter VB6 = $&drive
let drive = (floor(trial / 128) - 2*floor(trial / 256))*1.8
alter VB7 = $&drive
stop when time = 0.002274
resume
delete all
let endpoint = length(time)-1
let cmp = v(COMP)[endpoint]
let top = v(TOP)[endpoint]
let decision = 0
if cmp >= 0.9
let code = trial
let decision = 1
end
echo 126 6 $&trial $&cmp $&top 0.57890625 $&decision >> decisions.csv
let trial = code + 32
let drive = (floor(trial / 1) - 2*floor(trial / 2))*1.8
alter VB0 = $&drive
let drive = (floor(trial / 2) - 2*floor(trial / 4))*1.8
alter VB1 = $&drive
let drive = (floor(trial / 4) - 2*floor(trial / 8))*1.8
alter VB2 = $&drive
let drive = (floor(trial / 8) - 2*floor(trial / 16))*1.8
alter VB3 = $&drive
let drive = (floor(trial / 16) - 2*floor(trial / 32))*1.8
alter VB4 = $&drive
let drive = (floor(trial / 32) - 2*floor(trial / 64))*1.8
alter VB5 = $&drive
let drive = (floor(trial / 64) - 2*floor(trial / 128))*1.8
alter VB6 = $&drive
let drive = (floor(trial / 128) - 2*floor(trial / 256))*1.8
alter VB7 = $&drive
stop when time = 0.002276
resume
delete all
let endpoint = length(time)-1
let cmp = v(COMP)[endpoint]
let top = v(TOP)[endpoint]
let decision = 0
if cmp >= 0.9
let code = trial
let decision = 1
end
echo 126 5 $&trial $&cmp $&top 0.57890625 $&decision >> decisions.csv
let trial = code + 16
let drive = (floor(trial / 1) - 2*floor(trial / 2))*1.8
alter VB0 = $&drive
let drive = (floor(trial / 2) - 2*floor(trial / 4))*1.8
alter VB1 = $&drive
let drive = (floor(trial / 4) - 2*floor(trial / 8))*1.8
alter VB2 = $&drive
let drive = (floor(trial / 8) - 2*floor(trial / 16))*1.8
alter VB3 = $&drive
let drive = (floor(trial / 16) - 2*floor(trial / 32))*1.8
alter VB4 = $&drive
let drive = (floor(trial / 32) - 2*floor(trial / 64))*1.8
alter VB5 = $&drive
let drive = (floor(trial / 64) - 2*floor(trial / 128))*1.8
alter VB6 = $&drive
let drive = (floor(trial / 128) - 2*floor(trial / 256))*1.8
alter VB7 = $&drive
stop when time = 0.002278
resume
delete all
let endpoint = length(time)-1
let cmp = v(COMP)[endpoint]
let top = v(TOP)[endpoint]
let decision = 0
if cmp >= 0.9
let code = trial
let decision = 1
end
echo 126 4 $&trial $&cmp $&top 0.57890625 $&decision >> decisions.csv
let trial = code + 8
let drive = (floor(trial / 1) - 2*floor(trial / 2))*1.8
alter VB0 = $&drive
let drive = (floor(trial / 2) - 2*floor(trial / 4))*1.8
alter VB1 = $&drive
let drive = (floor(trial / 4) - 2*floor(trial / 8))*1.8
alter VB2 = $&drive
let drive = (floor(trial / 8) - 2*floor(trial / 16))*1.8
alter VB3 = $&drive
let drive = (floor(trial / 16) - 2*floor(trial / 32))*1.8
alter VB4 = $&drive
let drive = (floor(trial / 32) - 2*floor(trial / 64))*1.8
alter VB5 = $&drive
let drive = (floor(trial / 64) - 2*floor(trial / 128))*1.8
alter VB6 = $&drive
let drive = (floor(trial / 128) - 2*floor(trial / 256))*1.8
alter VB7 = $&drive
stop when time = 0.00228
resume
delete all
let endpoint = length(time)-1
let cmp = v(COMP)[endpoint]
let top = v(TOP)[endpoint]
let decision = 0
if cmp >= 0.9
let code = trial
let decision = 1
end
echo 126 3 $&trial $&cmp $&top 0.57890625 $&decision >> decisions.csv
let trial = code + 4
let drive = (floor(trial / 1) - 2*floor(trial / 2))*1.8
alter VB0 = $&drive
let drive = (floor(trial / 2) - 2*floor(trial / 4))*1.8
alter VB1 = $&drive
let drive = (floor(trial / 4) - 2*floor(trial / 8))*1.8
alter VB2 = $&drive
let drive = (floor(trial / 8) - 2*floor(trial / 16))*1.8
alter VB3 = $&drive
let drive = (floor(trial / 16) - 2*floor(trial / 32))*1.8
alter VB4 = $&drive
let drive = (floor(trial / 32) - 2*floor(trial / 64))*1.8
alter VB5 = $&drive
let drive = (floor(trial / 64) - 2*floor(trial / 128))*1.8
alter VB6 = $&drive
let drive = (floor(trial / 128) - 2*floor(trial / 256))*1.8
alter VB7 = $&drive
stop when time = 0.002282
resume
delete all
let endpoint = length(time)-1
let cmp = v(COMP)[endpoint]
let top = v(TOP)[endpoint]
let decision = 0
if cmp >= 0.9
let code = trial
let decision = 1
end
echo 126 2 $&trial $&cmp $&top 0.57890625 $&decision >> decisions.csv
let trial = code + 2
let drive = (floor(trial / 1) - 2*floor(trial / 2))*1.8
alter VB0 = $&drive
let drive = (floor(trial / 2) - 2*floor(trial / 4))*1.8
alter VB1 = $&drive
let drive = (floor(trial / 4) - 2*floor(trial / 8))*1.8
alter VB2 = $&drive
let drive = (floor(trial / 8) - 2*floor(trial / 16))*1.8
alter VB3 = $&drive
let drive = (floor(trial / 16) - 2*floor(trial / 32))*1.8
alter VB4 = $&drive
let drive = (floor(trial / 32) - 2*floor(trial / 64))*1.8
alter VB5 = $&drive
let drive = (floor(trial / 64) - 2*floor(trial / 128))*1.8
alter VB6 = $&drive
let drive = (floor(trial / 128) - 2*floor(trial / 256))*1.8
alter VB7 = $&drive
stop when time = 0.002284
resume
delete all
let endpoint = length(time)-1
let cmp = v(COMP)[endpoint]
let top = v(TOP)[endpoint]
let decision = 0
if cmp >= 0.9
let code = trial
let decision = 1
end
echo 126 1 $&trial $&cmp $&top 0.57890625 $&decision >> decisions.csv
let trial = code + 1
let drive = (floor(trial / 1) - 2*floor(trial / 2))*1.8
alter VB0 = $&drive
let drive = (floor(trial / 2) - 2*floor(trial / 4))*1.8
alter VB1 = $&drive
let drive = (floor(trial / 4) - 2*floor(trial / 8))*1.8
alter VB2 = $&drive
let drive = (floor(trial / 8) - 2*floor(trial / 16))*1.8
alter VB3 = $&drive
let drive = (floor(trial / 16) - 2*floor(trial / 32))*1.8
alter VB4 = $&drive
let drive = (floor(trial / 32) - 2*floor(trial / 64))*1.8
alter VB5 = $&drive
let drive = (floor(trial / 64) - 2*floor(trial / 128))*1.8
alter VB6 = $&drive
let drive = (floor(trial / 128) - 2*floor(trial / 256))*1.8
alter VB7 = $&drive
stop when time = 0.002286
resume
delete all
let endpoint = length(time)-1
let cmp = v(COMP)[endpoint]
let top = v(TOP)[endpoint]
let decision = 0
if cmp >= 0.9
let code = trial
let decision = 1
end
echo 126 0 $&trial $&cmp $&top 0.57890625 $&decision >> decisions.csv
alter VIN = 0.58359375
alter VSAMPLE = 1.8
alter VB0 = 0
alter VB1 = 0
alter VB2 = 0
alter VB3 = 0
alter VB4 = 0
alter VB5 = 0
alter VB6 = 0
alter VB7 = 0
let code = 0
stop when time = 0.002288
resume
delete all
alter VSAMPLE = 0
let trial = code + 128
let drive = (floor(trial / 1) - 2*floor(trial / 2))*1.8
alter VB0 = $&drive
let drive = (floor(trial / 2) - 2*floor(trial / 4))*1.8
alter VB1 = $&drive
let drive = (floor(trial / 4) - 2*floor(trial / 8))*1.8
alter VB2 = $&drive
let drive = (floor(trial / 8) - 2*floor(trial / 16))*1.8
alter VB3 = $&drive
let drive = (floor(trial / 16) - 2*floor(trial / 32))*1.8
alter VB4 = $&drive
let drive = (floor(trial / 32) - 2*floor(trial / 64))*1.8
alter VB5 = $&drive
let drive = (floor(trial / 64) - 2*floor(trial / 128))*1.8
alter VB6 = $&drive
let drive = (floor(trial / 128) - 2*floor(trial / 256))*1.8
alter VB7 = $&drive
stop when time = 0.00229
resume
delete all
let endpoint = length(time)-1
let cmp = v(COMP)[endpoint]
let top = v(TOP)[endpoint]
let decision = 0
if cmp >= 0.9
let code = trial
let decision = 1
end
echo 127 7 $&trial $&cmp $&top 0.58359375 $&decision >> decisions.csv
let trial = code + 64
let drive = (floor(trial / 1) - 2*floor(trial / 2))*1.8
alter VB0 = $&drive
let drive = (floor(trial / 2) - 2*floor(trial / 4))*1.8
alter VB1 = $&drive
let drive = (floor(trial / 4) - 2*floor(trial / 8))*1.8
alter VB2 = $&drive
let drive = (floor(trial / 8) - 2*floor(trial / 16))*1.8
alter VB3 = $&drive
let drive = (floor(trial / 16) - 2*floor(trial / 32))*1.8
alter VB4 = $&drive
let drive = (floor(trial / 32) - 2*floor(trial / 64))*1.8
alter VB5 = $&drive
let drive = (floor(trial / 64) - 2*floor(trial / 128))*1.8
alter VB6 = $&drive
let drive = (floor(trial / 128) - 2*floor(trial / 256))*1.8
alter VB7 = $&drive
stop when time = 0.002292
resume
delete all
let endpoint = length(time)-1
let cmp = v(COMP)[endpoint]
let top = v(TOP)[endpoint]
let decision = 0
if cmp >= 0.9
let code = trial
let decision = 1
end
echo 127 6 $&trial $&cmp $&top 0.58359375 $&decision >> decisions.csv
let trial = code + 32
let drive = (floor(trial / 1) - 2*floor(trial / 2))*1.8
alter VB0 = $&drive
let drive = (floor(trial / 2) - 2*floor(trial / 4))*1.8
alter VB1 = $&drive
let drive = (floor(trial / 4) - 2*floor(trial / 8))*1.8
alter VB2 = $&drive
let drive = (floor(trial / 8) - 2*floor(trial / 16))*1.8
alter VB3 = $&drive
let drive = (floor(trial / 16) - 2*floor(trial / 32))*1.8
alter VB4 = $&drive
let drive = (floor(trial / 32) - 2*floor(trial / 64))*1.8
alter VB5 = $&drive
let drive = (floor(trial / 64) - 2*floor(trial / 128))*1.8
alter VB6 = $&drive
let drive = (floor(trial / 128) - 2*floor(trial / 256))*1.8
alter VB7 = $&drive
stop when time = 0.002294
resume
delete all
let endpoint = length(time)-1
let cmp = v(COMP)[endpoint]
let top = v(TOP)[endpoint]
let decision = 0
if cmp >= 0.9
let code = trial
let decision = 1
end
echo 127 5 $&trial $&cmp $&top 0.58359375 $&decision >> decisions.csv
let trial = code + 16
let drive = (floor(trial / 1) - 2*floor(trial / 2))*1.8
alter VB0 = $&drive
let drive = (floor(trial / 2) - 2*floor(trial / 4))*1.8
alter VB1 = $&drive
let drive = (floor(trial / 4) - 2*floor(trial / 8))*1.8
alter VB2 = $&drive
let drive = (floor(trial / 8) - 2*floor(trial / 16))*1.8
alter VB3 = $&drive
let drive = (floor(trial / 16) - 2*floor(trial / 32))*1.8
alter VB4 = $&drive
let drive = (floor(trial / 32) - 2*floor(trial / 64))*1.8
alter VB5 = $&drive
let drive = (floor(trial / 64) - 2*floor(trial / 128))*1.8
alter VB6 = $&drive
let drive = (floor(trial / 128) - 2*floor(trial / 256))*1.8
alter VB7 = $&drive
stop when time = 0.002296
resume
delete all
let endpoint = length(time)-1
let cmp = v(COMP)[endpoint]
let top = v(TOP)[endpoint]
let decision = 0
if cmp >= 0.9
let code = trial
let decision = 1
end
echo 127 4 $&trial $&cmp $&top 0.58359375 $&decision >> decisions.csv
let trial = code + 8
let drive = (floor(trial / 1) - 2*floor(trial / 2))*1.8
alter VB0 = $&drive
let drive = (floor(trial / 2) - 2*floor(trial / 4))*1.8
alter VB1 = $&drive
let drive = (floor(trial / 4) - 2*floor(trial / 8))*1.8
alter VB2 = $&drive
let drive = (floor(trial / 8) - 2*floor(trial / 16))*1.8
alter VB3 = $&drive
let drive = (floor(trial / 16) - 2*floor(trial / 32))*1.8
alter VB4 = $&drive
let drive = (floor(trial / 32) - 2*floor(trial / 64))*1.8
alter VB5 = $&drive
let drive = (floor(trial / 64) - 2*floor(trial / 128))*1.8
alter VB6 = $&drive
let drive = (floor(trial / 128) - 2*floor(trial / 256))*1.8
alter VB7 = $&drive
stop when time = 0.002298
resume
delete all
let endpoint = length(time)-1
let cmp = v(COMP)[endpoint]
let top = v(TOP)[endpoint]
let decision = 0
if cmp >= 0.9
let code = trial
let decision = 1
end
echo 127 3 $&trial $&cmp $&top 0.58359375 $&decision >> decisions.csv
let trial = code + 4
let drive = (floor(trial / 1) - 2*floor(trial / 2))*1.8
alter VB0 = $&drive
let drive = (floor(trial / 2) - 2*floor(trial / 4))*1.8
alter VB1 = $&drive
let drive = (floor(trial / 4) - 2*floor(trial / 8))*1.8
alter VB2 = $&drive
let drive = (floor(trial / 8) - 2*floor(trial / 16))*1.8
alter VB3 = $&drive
let drive = (floor(trial / 16) - 2*floor(trial / 32))*1.8
alter VB4 = $&drive
let drive = (floor(trial / 32) - 2*floor(trial / 64))*1.8
alter VB5 = $&drive
let drive = (floor(trial / 64) - 2*floor(trial / 128))*1.8
alter VB6 = $&drive
let drive = (floor(trial / 128) - 2*floor(trial / 256))*1.8
alter VB7 = $&drive
stop when time = 0.0023
resume
delete all
let endpoint = length(time)-1
let cmp = v(COMP)[endpoint]
let top = v(TOP)[endpoint]
let decision = 0
if cmp >= 0.9
let code = trial
let decision = 1
end
echo 127 2 $&trial $&cmp $&top 0.58359375 $&decision >> decisions.csv
let trial = code + 2
let drive = (floor(trial / 1) - 2*floor(trial / 2))*1.8
alter VB0 = $&drive
let drive = (floor(trial / 2) - 2*floor(trial / 4))*1.8
alter VB1 = $&drive
let drive = (floor(trial / 4) - 2*floor(trial / 8))*1.8
alter VB2 = $&drive
let drive = (floor(trial / 8) - 2*floor(trial / 16))*1.8
alter VB3 = $&drive
let drive = (floor(trial / 16) - 2*floor(trial / 32))*1.8
alter VB4 = $&drive
let drive = (floor(trial / 32) - 2*floor(trial / 64))*1.8
alter VB5 = $&drive
let drive = (floor(trial / 64) - 2*floor(trial / 128))*1.8
alter VB6 = $&drive
let drive = (floor(trial / 128) - 2*floor(trial / 256))*1.8
alter VB7 = $&drive
stop when time = 0.002302
resume
delete all
let endpoint = length(time)-1
let cmp = v(COMP)[endpoint]
let top = v(TOP)[endpoint]
let decision = 0
if cmp >= 0.9
let code = trial
let decision = 1
end
echo 127 1 $&trial $&cmp $&top 0.58359375 $&decision >> decisions.csv
let trial = code + 1
let drive = (floor(trial / 1) - 2*floor(trial / 2))*1.8
alter VB0 = $&drive
let drive = (floor(trial / 2) - 2*floor(trial / 4))*1.8
alter VB1 = $&drive
let drive = (floor(trial / 4) - 2*floor(trial / 8))*1.8
alter VB2 = $&drive
let drive = (floor(trial / 8) - 2*floor(trial / 16))*1.8
alter VB3 = $&drive
let drive = (floor(trial / 16) - 2*floor(trial / 32))*1.8
alter VB4 = $&drive
let drive = (floor(trial / 32) - 2*floor(trial / 64))*1.8
alter VB5 = $&drive
let drive = (floor(trial / 64) - 2*floor(trial / 128))*1.8
alter VB6 = $&drive
let drive = (floor(trial / 128) - 2*floor(trial / 256))*1.8
alter VB7 = $&drive
stop when time = 0.002304
resume
delete all
let endpoint = length(time)-1
let cmp = v(COMP)[endpoint]
let top = v(TOP)[endpoint]
let decision = 0
if cmp >= 0.9
let code = trial
let decision = 1
end
echo 127 0 $&trial $&cmp $&top 0.58359375 $&decision >> decisions.csv
alter VIN = 0.58828125
alter VSAMPLE = 1.8
alter VB0 = 0
alter VB1 = 0
alter VB2 = 0
alter VB3 = 0
alter VB4 = 0
alter VB5 = 0
alter VB6 = 0
alter VB7 = 0
let code = 0
stop when time = 0.002306
resume
delete all
alter VSAMPLE = 0
let trial = code + 128
let drive = (floor(trial / 1) - 2*floor(trial / 2))*1.8
alter VB0 = $&drive
let drive = (floor(trial / 2) - 2*floor(trial / 4))*1.8
alter VB1 = $&drive
let drive = (floor(trial / 4) - 2*floor(trial / 8))*1.8
alter VB2 = $&drive
let drive = (floor(trial / 8) - 2*floor(trial / 16))*1.8
alter VB3 = $&drive
let drive = (floor(trial / 16) - 2*floor(trial / 32))*1.8
alter VB4 = $&drive
let drive = (floor(trial / 32) - 2*floor(trial / 64))*1.8
alter VB5 = $&drive
let drive = (floor(trial / 64) - 2*floor(trial / 128))*1.8
alter VB6 = $&drive
let drive = (floor(trial / 128) - 2*floor(trial / 256))*1.8
alter VB7 = $&drive
stop when time = 0.002308
resume
delete all
let endpoint = length(time)-1
let cmp = v(COMP)[endpoint]
let top = v(TOP)[endpoint]
let decision = 0
if cmp >= 0.9
let code = trial
let decision = 1
end
echo 128 7 $&trial $&cmp $&top 0.58828125 $&decision >> decisions.csv
let trial = code + 64
let drive = (floor(trial / 1) - 2*floor(trial / 2))*1.8
alter VB0 = $&drive
let drive = (floor(trial / 2) - 2*floor(trial / 4))*1.8
alter VB1 = $&drive
let drive = (floor(trial / 4) - 2*floor(trial / 8))*1.8
alter VB2 = $&drive
let drive = (floor(trial / 8) - 2*floor(trial / 16))*1.8
alter VB3 = $&drive
let drive = (floor(trial / 16) - 2*floor(trial / 32))*1.8
alter VB4 = $&drive
let drive = (floor(trial / 32) - 2*floor(trial / 64))*1.8
alter VB5 = $&drive
let drive = (floor(trial / 64) - 2*floor(trial / 128))*1.8
alter VB6 = $&drive
let drive = (floor(trial / 128) - 2*floor(trial / 256))*1.8
alter VB7 = $&drive
stop when time = 0.00231
resume
delete all
let endpoint = length(time)-1
let cmp = v(COMP)[endpoint]
let top = v(TOP)[endpoint]
let decision = 0
if cmp >= 0.9
let code = trial
let decision = 1
end
echo 128 6 $&trial $&cmp $&top 0.58828125 $&decision >> decisions.csv
let trial = code + 32
let drive = (floor(trial / 1) - 2*floor(trial / 2))*1.8
alter VB0 = $&drive
let drive = (floor(trial / 2) - 2*floor(trial / 4))*1.8
alter VB1 = $&drive
let drive = (floor(trial / 4) - 2*floor(trial / 8))*1.8
alter VB2 = $&drive
let drive = (floor(trial / 8) - 2*floor(trial / 16))*1.8
alter VB3 = $&drive
let drive = (floor(trial / 16) - 2*floor(trial / 32))*1.8
alter VB4 = $&drive
let drive = (floor(trial / 32) - 2*floor(trial / 64))*1.8
alter VB5 = $&drive
let drive = (floor(trial / 64) - 2*floor(trial / 128))*1.8
alter VB6 = $&drive
let drive = (floor(trial / 128) - 2*floor(trial / 256))*1.8
alter VB7 = $&drive
stop when time = 0.002312
resume
delete all
let endpoint = length(time)-1
let cmp = v(COMP)[endpoint]
let top = v(TOP)[endpoint]
let decision = 0
if cmp >= 0.9
let code = trial
let decision = 1
end
echo 128 5 $&trial $&cmp $&top 0.58828125 $&decision >> decisions.csv
let trial = code + 16
let drive = (floor(trial / 1) - 2*floor(trial / 2))*1.8
alter VB0 = $&drive
let drive = (floor(trial / 2) - 2*floor(trial / 4))*1.8
alter VB1 = $&drive
let drive = (floor(trial / 4) - 2*floor(trial / 8))*1.8
alter VB2 = $&drive
let drive = (floor(trial / 8) - 2*floor(trial / 16))*1.8
alter VB3 = $&drive
let drive = (floor(trial / 16) - 2*floor(trial / 32))*1.8
alter VB4 = $&drive
let drive = (floor(trial / 32) - 2*floor(trial / 64))*1.8
alter VB5 = $&drive
let drive = (floor(trial / 64) - 2*floor(trial / 128))*1.8
alter VB6 = $&drive
let drive = (floor(trial / 128) - 2*floor(trial / 256))*1.8
alter VB7 = $&drive
stop when time = 0.002314
resume
delete all
let endpoint = length(time)-1
let cmp = v(COMP)[endpoint]
let top = v(TOP)[endpoint]
let decision = 0
if cmp >= 0.9
let code = trial
let decision = 1
end
echo 128 4 $&trial $&cmp $&top 0.58828125 $&decision >> decisions.csv
let trial = code + 8
let drive = (floor(trial / 1) - 2*floor(trial / 2))*1.8
alter VB0 = $&drive
let drive = (floor(trial / 2) - 2*floor(trial / 4))*1.8
alter VB1 = $&drive
let drive = (floor(trial / 4) - 2*floor(trial / 8))*1.8
alter VB2 = $&drive
let drive = (floor(trial / 8) - 2*floor(trial / 16))*1.8
alter VB3 = $&drive
let drive = (floor(trial / 16) - 2*floor(trial / 32))*1.8
alter VB4 = $&drive
let drive = (floor(trial / 32) - 2*floor(trial / 64))*1.8
alter VB5 = $&drive
let drive = (floor(trial / 64) - 2*floor(trial / 128))*1.8
alter VB6 = $&drive
let drive = (floor(trial / 128) - 2*floor(trial / 256))*1.8
alter VB7 = $&drive
stop when time = 0.002316
resume
delete all
let endpoint = length(time)-1
let cmp = v(COMP)[endpoint]
let top = v(TOP)[endpoint]
let decision = 0
if cmp >= 0.9
let code = trial
let decision = 1
end
echo 128 3 $&trial $&cmp $&top 0.58828125 $&decision >> decisions.csv
let trial = code + 4
let drive = (floor(trial / 1) - 2*floor(trial / 2))*1.8
alter VB0 = $&drive
let drive = (floor(trial / 2) - 2*floor(trial / 4))*1.8
alter VB1 = $&drive
let drive = (floor(trial / 4) - 2*floor(trial / 8))*1.8
alter VB2 = $&drive
let drive = (floor(trial / 8) - 2*floor(trial / 16))*1.8
alter VB3 = $&drive
let drive = (floor(trial / 16) - 2*floor(trial / 32))*1.8
alter VB4 = $&drive
let drive = (floor(trial / 32) - 2*floor(trial / 64))*1.8
alter VB5 = $&drive
let drive = (floor(trial / 64) - 2*floor(trial / 128))*1.8
alter VB6 = $&drive
let drive = (floor(trial / 128) - 2*floor(trial / 256))*1.8
alter VB7 = $&drive
stop when time = 0.002318
resume
delete all
let endpoint = length(time)-1
let cmp = v(COMP)[endpoint]
let top = v(TOP)[endpoint]
let decision = 0
if cmp >= 0.9
let code = trial
let decision = 1
end
echo 128 2 $&trial $&cmp $&top 0.58828125 $&decision >> decisions.csv
let trial = code + 2
let drive = (floor(trial / 1) - 2*floor(trial / 2))*1.8
alter VB0 = $&drive
let drive = (floor(trial / 2) - 2*floor(trial / 4))*1.8
alter VB1 = $&drive
let drive = (floor(trial / 4) - 2*floor(trial / 8))*1.8
alter VB2 = $&drive
let drive = (floor(trial / 8) - 2*floor(trial / 16))*1.8
alter VB3 = $&drive
let drive = (floor(trial / 16) - 2*floor(trial / 32))*1.8
alter VB4 = $&drive
let drive = (floor(trial / 32) - 2*floor(trial / 64))*1.8
alter VB5 = $&drive
let drive = (floor(trial / 64) - 2*floor(trial / 128))*1.8
alter VB6 = $&drive
let drive = (floor(trial / 128) - 2*floor(trial / 256))*1.8
alter VB7 = $&drive
stop when time = 0.00232
resume
delete all
let endpoint = length(time)-1
let cmp = v(COMP)[endpoint]
let top = v(TOP)[endpoint]
let decision = 0
if cmp >= 0.9
let code = trial
let decision = 1
end
echo 128 1 $&trial $&cmp $&top 0.58828125 $&decision >> decisions.csv
let trial = code + 1
let drive = (floor(trial / 1) - 2*floor(trial / 2))*1.8
alter VB0 = $&drive
let drive = (floor(trial / 2) - 2*floor(trial / 4))*1.8
alter VB1 = $&drive
let drive = (floor(trial / 4) - 2*floor(trial / 8))*1.8
alter VB2 = $&drive
let drive = (floor(trial / 8) - 2*floor(trial / 16))*1.8
alter VB3 = $&drive
let drive = (floor(trial / 16) - 2*floor(trial / 32))*1.8
alter VB4 = $&drive
let drive = (floor(trial / 32) - 2*floor(trial / 64))*1.8
alter VB5 = $&drive
let drive = (floor(trial / 64) - 2*floor(trial / 128))*1.8
alter VB6 = $&drive
let drive = (floor(trial / 128) - 2*floor(trial / 256))*1.8
alter VB7 = $&drive
stop when time = 0.002322
resume
delete all
let endpoint = length(time)-1
let cmp = v(COMP)[endpoint]
let top = v(TOP)[endpoint]
let decision = 0
if cmp >= 0.9
let code = trial
let decision = 1
end
echo 128 0 $&trial $&cmp $&top 0.58828125 $&decision >> decisions.csv
alter VIN = 0.59296875
alter VSAMPLE = 1.8
alter VB0 = 0
alter VB1 = 0
alter VB2 = 0
alter VB3 = 0
alter VB4 = 0
alter VB5 = 0
alter VB6 = 0
alter VB7 = 0
let code = 0
stop when time = 0.002324
resume
delete all
alter VSAMPLE = 0
let trial = code + 128
let drive = (floor(trial / 1) - 2*floor(trial / 2))*1.8
alter VB0 = $&drive
let drive = (floor(trial / 2) - 2*floor(trial / 4))*1.8
alter VB1 = $&drive
let drive = (floor(trial / 4) - 2*floor(trial / 8))*1.8
alter VB2 = $&drive
let drive = (floor(trial / 8) - 2*floor(trial / 16))*1.8
alter VB3 = $&drive
let drive = (floor(trial / 16) - 2*floor(trial / 32))*1.8
alter VB4 = $&drive
let drive = (floor(trial / 32) - 2*floor(trial / 64))*1.8
alter VB5 = $&drive
let drive = (floor(trial / 64) - 2*floor(trial / 128))*1.8
alter VB6 = $&drive
let drive = (floor(trial / 128) - 2*floor(trial / 256))*1.8
alter VB7 = $&drive
stop when time = 0.002326
resume
delete all
let endpoint = length(time)-1
let cmp = v(COMP)[endpoint]
let top = v(TOP)[endpoint]
let decision = 0
if cmp >= 0.9
let code = trial
let decision = 1
end
echo 129 7 $&trial $&cmp $&top 0.59296875 $&decision >> decisions.csv
let trial = code + 64
let drive = (floor(trial / 1) - 2*floor(trial / 2))*1.8
alter VB0 = $&drive
let drive = (floor(trial / 2) - 2*floor(trial / 4))*1.8
alter VB1 = $&drive
let drive = (floor(trial / 4) - 2*floor(trial / 8))*1.8
alter VB2 = $&drive
let drive = (floor(trial / 8) - 2*floor(trial / 16))*1.8
alter VB3 = $&drive
let drive = (floor(trial / 16) - 2*floor(trial / 32))*1.8
alter VB4 = $&drive
let drive = (floor(trial / 32) - 2*floor(trial / 64))*1.8
alter VB5 = $&drive
let drive = (floor(trial / 64) - 2*floor(trial / 128))*1.8
alter VB6 = $&drive
let drive = (floor(trial / 128) - 2*floor(trial / 256))*1.8
alter VB7 = $&drive
stop when time = 0.002328
resume
delete all
let endpoint = length(time)-1
let cmp = v(COMP)[endpoint]
let top = v(TOP)[endpoint]
let decision = 0
if cmp >= 0.9
let code = trial
let decision = 1
end
echo 129 6 $&trial $&cmp $&top 0.59296875 $&decision >> decisions.csv
let trial = code + 32
let drive = (floor(trial / 1) - 2*floor(trial / 2))*1.8
alter VB0 = $&drive
let drive = (floor(trial / 2) - 2*floor(trial / 4))*1.8
alter VB1 = $&drive
let drive = (floor(trial / 4) - 2*floor(trial / 8))*1.8
alter VB2 = $&drive
let drive = (floor(trial / 8) - 2*floor(trial / 16))*1.8
alter VB3 = $&drive
let drive = (floor(trial / 16) - 2*floor(trial / 32))*1.8
alter VB4 = $&drive
let drive = (floor(trial / 32) - 2*floor(trial / 64))*1.8
alter VB5 = $&drive
let drive = (floor(trial / 64) - 2*floor(trial / 128))*1.8
alter VB6 = $&drive
let drive = (floor(trial / 128) - 2*floor(trial / 256))*1.8
alter VB7 = $&drive
stop when time = 0.00233
resume
delete all
let endpoint = length(time)-1
let cmp = v(COMP)[endpoint]
let top = v(TOP)[endpoint]
let decision = 0
if cmp >= 0.9
let code = trial
let decision = 1
end
echo 129 5 $&trial $&cmp $&top 0.59296875 $&decision >> decisions.csv
let trial = code + 16
let drive = (floor(trial / 1) - 2*floor(trial / 2))*1.8
alter VB0 = $&drive
let drive = (floor(trial / 2) - 2*floor(trial / 4))*1.8
alter VB1 = $&drive
let drive = (floor(trial / 4) - 2*floor(trial / 8))*1.8
alter VB2 = $&drive
let drive = (floor(trial / 8) - 2*floor(trial / 16))*1.8
alter VB3 = $&drive
let drive = (floor(trial / 16) - 2*floor(trial / 32))*1.8
alter VB4 = $&drive
let drive = (floor(trial / 32) - 2*floor(trial / 64))*1.8
alter VB5 = $&drive
let drive = (floor(trial / 64) - 2*floor(trial / 128))*1.8
alter VB6 = $&drive
let drive = (floor(trial / 128) - 2*floor(trial / 256))*1.8
alter VB7 = $&drive
stop when time = 0.002332
resume
delete all
let endpoint = length(time)-1
let cmp = v(COMP)[endpoint]
let top = v(TOP)[endpoint]
let decision = 0
if cmp >= 0.9
let code = trial
let decision = 1
end
echo 129 4 $&trial $&cmp $&top 0.59296875 $&decision >> decisions.csv
let trial = code + 8
let drive = (floor(trial / 1) - 2*floor(trial / 2))*1.8
alter VB0 = $&drive
let drive = (floor(trial / 2) - 2*floor(trial / 4))*1.8
alter VB1 = $&drive
let drive = (floor(trial / 4) - 2*floor(trial / 8))*1.8
alter VB2 = $&drive
let drive = (floor(trial / 8) - 2*floor(trial / 16))*1.8
alter VB3 = $&drive
let drive = (floor(trial / 16) - 2*floor(trial / 32))*1.8
alter VB4 = $&drive
let drive = (floor(trial / 32) - 2*floor(trial / 64))*1.8
alter VB5 = $&drive
let drive = (floor(trial / 64) - 2*floor(trial / 128))*1.8
alter VB6 = $&drive
let drive = (floor(trial / 128) - 2*floor(trial / 256))*1.8
alter VB7 = $&drive
stop when time = 0.002334
resume
delete all
let endpoint = length(time)-1
let cmp = v(COMP)[endpoint]
let top = v(TOP)[endpoint]
let decision = 0
if cmp >= 0.9
let code = trial
let decision = 1
end
echo 129 3 $&trial $&cmp $&top 0.59296875 $&decision >> decisions.csv
let trial = code + 4
let drive = (floor(trial / 1) - 2*floor(trial / 2))*1.8
alter VB0 = $&drive
let drive = (floor(trial / 2) - 2*floor(trial / 4))*1.8
alter VB1 = $&drive
let drive = (floor(trial / 4) - 2*floor(trial / 8))*1.8
alter VB2 = $&drive
let drive = (floor(trial / 8) - 2*floor(trial / 16))*1.8
alter VB3 = $&drive
let drive = (floor(trial / 16) - 2*floor(trial / 32))*1.8
alter VB4 = $&drive
let drive = (floor(trial / 32) - 2*floor(trial / 64))*1.8
alter VB5 = $&drive
let drive = (floor(trial / 64) - 2*floor(trial / 128))*1.8
alter VB6 = $&drive
let drive = (floor(trial / 128) - 2*floor(trial / 256))*1.8
alter VB7 = $&drive
stop when time = 0.002336
resume
delete all
let endpoint = length(time)-1
let cmp = v(COMP)[endpoint]
let top = v(TOP)[endpoint]
let decision = 0
if cmp >= 0.9
let code = trial
let decision = 1
end
echo 129 2 $&trial $&cmp $&top 0.59296875 $&decision >> decisions.csv
let trial = code + 2
let drive = (floor(trial / 1) - 2*floor(trial / 2))*1.8
alter VB0 = $&drive
let drive = (floor(trial / 2) - 2*floor(trial / 4))*1.8
alter VB1 = $&drive
let drive = (floor(trial / 4) - 2*floor(trial / 8))*1.8
alter VB2 = $&drive
let drive = (floor(trial / 8) - 2*floor(trial / 16))*1.8
alter VB3 = $&drive
let drive = (floor(trial / 16) - 2*floor(trial / 32))*1.8
alter VB4 = $&drive
let drive = (floor(trial / 32) - 2*floor(trial / 64))*1.8
alter VB5 = $&drive
let drive = (floor(trial / 64) - 2*floor(trial / 128))*1.8
alter VB6 = $&drive
let drive = (floor(trial / 128) - 2*floor(trial / 256))*1.8
alter VB7 = $&drive
stop when time = 0.002338
resume
delete all
let endpoint = length(time)-1
let cmp = v(COMP)[endpoint]
let top = v(TOP)[endpoint]
let decision = 0
if cmp >= 0.9
let code = trial
let decision = 1
end
echo 129 1 $&trial $&cmp $&top 0.59296875 $&decision >> decisions.csv
let trial = code + 1
let drive = (floor(trial / 1) - 2*floor(trial / 2))*1.8
alter VB0 = $&drive
let drive = (floor(trial / 2) - 2*floor(trial / 4))*1.8
alter VB1 = $&drive
let drive = (floor(trial / 4) - 2*floor(trial / 8))*1.8
alter VB2 = $&drive
let drive = (floor(trial / 8) - 2*floor(trial / 16))*1.8
alter VB3 = $&drive
let drive = (floor(trial / 16) - 2*floor(trial / 32))*1.8
alter VB4 = $&drive
let drive = (floor(trial / 32) - 2*floor(trial / 64))*1.8
alter VB5 = $&drive
let drive = (floor(trial / 64) - 2*floor(trial / 128))*1.8
alter VB6 = $&drive
let drive = (floor(trial / 128) - 2*floor(trial / 256))*1.8
alter VB7 = $&drive
stop when time = 0.00234
resume
delete all
let endpoint = length(time)-1
let cmp = v(COMP)[endpoint]
let top = v(TOP)[endpoint]
let decision = 0
if cmp >= 0.9
let code = trial
let decision = 1
end
echo 129 0 $&trial $&cmp $&top 0.59296875 $&decision >> decisions.csv
alter VIN = 0.59765625
alter VSAMPLE = 1.8
alter VB0 = 0
alter VB1 = 0
alter VB2 = 0
alter VB3 = 0
alter VB4 = 0
alter VB5 = 0
alter VB6 = 0
alter VB7 = 0
let code = 0
stop when time = 0.002342
resume
delete all
alter VSAMPLE = 0
let trial = code + 128
let drive = (floor(trial / 1) - 2*floor(trial / 2))*1.8
alter VB0 = $&drive
let drive = (floor(trial / 2) - 2*floor(trial / 4))*1.8
alter VB1 = $&drive
let drive = (floor(trial / 4) - 2*floor(trial / 8))*1.8
alter VB2 = $&drive
let drive = (floor(trial / 8) - 2*floor(trial / 16))*1.8
alter VB3 = $&drive
let drive = (floor(trial / 16) - 2*floor(trial / 32))*1.8
alter VB4 = $&drive
let drive = (floor(trial / 32) - 2*floor(trial / 64))*1.8
alter VB5 = $&drive
let drive = (floor(trial / 64) - 2*floor(trial / 128))*1.8
alter VB6 = $&drive
let drive = (floor(trial / 128) - 2*floor(trial / 256))*1.8
alter VB7 = $&drive
stop when time = 0.002344
resume
delete all
let endpoint = length(time)-1
let cmp = v(COMP)[endpoint]
let top = v(TOP)[endpoint]
let decision = 0
if cmp >= 0.9
let code = trial
let decision = 1
end
echo 130 7 $&trial $&cmp $&top 0.59765625 $&decision >> decisions.csv
let trial = code + 64
let drive = (floor(trial / 1) - 2*floor(trial / 2))*1.8
alter VB0 = $&drive
let drive = (floor(trial / 2) - 2*floor(trial / 4))*1.8
alter VB1 = $&drive
let drive = (floor(trial / 4) - 2*floor(trial / 8))*1.8
alter VB2 = $&drive
let drive = (floor(trial / 8) - 2*floor(trial / 16))*1.8
alter VB3 = $&drive
let drive = (floor(trial / 16) - 2*floor(trial / 32))*1.8
alter VB4 = $&drive
let drive = (floor(trial / 32) - 2*floor(trial / 64))*1.8
alter VB5 = $&drive
let drive = (floor(trial / 64) - 2*floor(trial / 128))*1.8
alter VB6 = $&drive
let drive = (floor(trial / 128) - 2*floor(trial / 256))*1.8
alter VB7 = $&drive
stop when time = 0.002346
resume
delete all
let endpoint = length(time)-1
let cmp = v(COMP)[endpoint]
let top = v(TOP)[endpoint]
let decision = 0
if cmp >= 0.9
let code = trial
let decision = 1
end
echo 130 6 $&trial $&cmp $&top 0.59765625 $&decision >> decisions.csv
let trial = code + 32
let drive = (floor(trial / 1) - 2*floor(trial / 2))*1.8
alter VB0 = $&drive
let drive = (floor(trial / 2) - 2*floor(trial / 4))*1.8
alter VB1 = $&drive
let drive = (floor(trial / 4) - 2*floor(trial / 8))*1.8
alter VB2 = $&drive
let drive = (floor(trial / 8) - 2*floor(trial / 16))*1.8
alter VB3 = $&drive
let drive = (floor(trial / 16) - 2*floor(trial / 32))*1.8
alter VB4 = $&drive
let drive = (floor(trial / 32) - 2*floor(trial / 64))*1.8
alter VB5 = $&drive
let drive = (floor(trial / 64) - 2*floor(trial / 128))*1.8
alter VB6 = $&drive
let drive = (floor(trial / 128) - 2*floor(trial / 256))*1.8
alter VB7 = $&drive
stop when time = 0.002348
resume
delete all
let endpoint = length(time)-1
let cmp = v(COMP)[endpoint]
let top = v(TOP)[endpoint]
let decision = 0
if cmp >= 0.9
let code = trial
let decision = 1
end
echo 130 5 $&trial $&cmp $&top 0.59765625 $&decision >> decisions.csv
let trial = code + 16
let drive = (floor(trial / 1) - 2*floor(trial / 2))*1.8
alter VB0 = $&drive
let drive = (floor(trial / 2) - 2*floor(trial / 4))*1.8
alter VB1 = $&drive
let drive = (floor(trial / 4) - 2*floor(trial / 8))*1.8
alter VB2 = $&drive
let drive = (floor(trial / 8) - 2*floor(trial / 16))*1.8
alter VB3 = $&drive
let drive = (floor(trial / 16) - 2*floor(trial / 32))*1.8
alter VB4 = $&drive
let drive = (floor(trial / 32) - 2*floor(trial / 64))*1.8
alter VB5 = $&drive
let drive = (floor(trial / 64) - 2*floor(trial / 128))*1.8
alter VB6 = $&drive
let drive = (floor(trial / 128) - 2*floor(trial / 256))*1.8
alter VB7 = $&drive
stop when time = 0.00235
resume
delete all
let endpoint = length(time)-1
let cmp = v(COMP)[endpoint]
let top = v(TOP)[endpoint]
let decision = 0
if cmp >= 0.9
let code = trial
let decision = 1
end
echo 130 4 $&trial $&cmp $&top 0.59765625 $&decision >> decisions.csv
let trial = code + 8
let drive = (floor(trial / 1) - 2*floor(trial / 2))*1.8
alter VB0 = $&drive
let drive = (floor(trial / 2) - 2*floor(trial / 4))*1.8
alter VB1 = $&drive
let drive = (floor(trial / 4) - 2*floor(trial / 8))*1.8
alter VB2 = $&drive
let drive = (floor(trial / 8) - 2*floor(trial / 16))*1.8
alter VB3 = $&drive
let drive = (floor(trial / 16) - 2*floor(trial / 32))*1.8
alter VB4 = $&drive
let drive = (floor(trial / 32) - 2*floor(trial / 64))*1.8
alter VB5 = $&drive
let drive = (floor(trial / 64) - 2*floor(trial / 128))*1.8
alter VB6 = $&drive
let drive = (floor(trial / 128) - 2*floor(trial / 256))*1.8
alter VB7 = $&drive
stop when time = 0.002352
resume
delete all
let endpoint = length(time)-1
let cmp = v(COMP)[endpoint]
let top = v(TOP)[endpoint]
let decision = 0
if cmp >= 0.9
let code = trial
let decision = 1
end
echo 130 3 $&trial $&cmp $&top 0.59765625 $&decision >> decisions.csv
let trial = code + 4
let drive = (floor(trial / 1) - 2*floor(trial / 2))*1.8
alter VB0 = $&drive
let drive = (floor(trial / 2) - 2*floor(trial / 4))*1.8
alter VB1 = $&drive
let drive = (floor(trial / 4) - 2*floor(trial / 8))*1.8
alter VB2 = $&drive
let drive = (floor(trial / 8) - 2*floor(trial / 16))*1.8
alter VB3 = $&drive
let drive = (floor(trial / 16) - 2*floor(trial / 32))*1.8
alter VB4 = $&drive
let drive = (floor(trial / 32) - 2*floor(trial / 64))*1.8
alter VB5 = $&drive
let drive = (floor(trial / 64) - 2*floor(trial / 128))*1.8
alter VB6 = $&drive
let drive = (floor(trial / 128) - 2*floor(trial / 256))*1.8
alter VB7 = $&drive
stop when time = 0.002354
resume
delete all
let endpoint = length(time)-1
let cmp = v(COMP)[endpoint]
let top = v(TOP)[endpoint]
let decision = 0
if cmp >= 0.9
let code = trial
let decision = 1
end
echo 130 2 $&trial $&cmp $&top 0.59765625 $&decision >> decisions.csv
let trial = code + 2
let drive = (floor(trial / 1) - 2*floor(trial / 2))*1.8
alter VB0 = $&drive
let drive = (floor(trial / 2) - 2*floor(trial / 4))*1.8
alter VB1 = $&drive
let drive = (floor(trial / 4) - 2*floor(trial / 8))*1.8
alter VB2 = $&drive
let drive = (floor(trial / 8) - 2*floor(trial / 16))*1.8
alter VB3 = $&drive
let drive = (floor(trial / 16) - 2*floor(trial / 32))*1.8
alter VB4 = $&drive
let drive = (floor(trial / 32) - 2*floor(trial / 64))*1.8
alter VB5 = $&drive
let drive = (floor(trial / 64) - 2*floor(trial / 128))*1.8
alter VB6 = $&drive
let drive = (floor(trial / 128) - 2*floor(trial / 256))*1.8
alter VB7 = $&drive
stop when time = 0.002356
resume
delete all
let endpoint = length(time)-1
let cmp = v(COMP)[endpoint]
let top = v(TOP)[endpoint]
let decision = 0
if cmp >= 0.9
let code = trial
let decision = 1
end
echo 130 1 $&trial $&cmp $&top 0.59765625 $&decision >> decisions.csv
let trial = code + 1
let drive = (floor(trial / 1) - 2*floor(trial / 2))*1.8
alter VB0 = $&drive
let drive = (floor(trial / 2) - 2*floor(trial / 4))*1.8
alter VB1 = $&drive
let drive = (floor(trial / 4) - 2*floor(trial / 8))*1.8
alter VB2 = $&drive
let drive = (floor(trial / 8) - 2*floor(trial / 16))*1.8
alter VB3 = $&drive
let drive = (floor(trial / 16) - 2*floor(trial / 32))*1.8
alter VB4 = $&drive
let drive = (floor(trial / 32) - 2*floor(trial / 64))*1.8
alter VB5 = $&drive
let drive = (floor(trial / 64) - 2*floor(trial / 128))*1.8
alter VB6 = $&drive
let drive = (floor(trial / 128) - 2*floor(trial / 256))*1.8
alter VB7 = $&drive
stop when time = 0.002358
resume
delete all
let endpoint = length(time)-1
let cmp = v(COMP)[endpoint]
let top = v(TOP)[endpoint]
let decision = 0
if cmp >= 0.9
let code = trial
let decision = 1
end
echo 130 0 $&trial $&cmp $&top 0.59765625 $&decision >> decisions.csv
alter VIN = 0.60234375
alter VSAMPLE = 1.8
alter VB0 = 0
alter VB1 = 0
alter VB2 = 0
alter VB3 = 0
alter VB4 = 0
alter VB5 = 0
alter VB6 = 0
alter VB7 = 0
let code = 0
stop when time = 0.00236
resume
delete all
alter VSAMPLE = 0
let trial = code + 128
let drive = (floor(trial / 1) - 2*floor(trial / 2))*1.8
alter VB0 = $&drive
let drive = (floor(trial / 2) - 2*floor(trial / 4))*1.8
alter VB1 = $&drive
let drive = (floor(trial / 4) - 2*floor(trial / 8))*1.8
alter VB2 = $&drive
let drive = (floor(trial / 8) - 2*floor(trial / 16))*1.8
alter VB3 = $&drive
let drive = (floor(trial / 16) - 2*floor(trial / 32))*1.8
alter VB4 = $&drive
let drive = (floor(trial / 32) - 2*floor(trial / 64))*1.8
alter VB5 = $&drive
let drive = (floor(trial / 64) - 2*floor(trial / 128))*1.8
alter VB6 = $&drive
let drive = (floor(trial / 128) - 2*floor(trial / 256))*1.8
alter VB7 = $&drive
stop when time = 0.002362
resume
delete all
let endpoint = length(time)-1
let cmp = v(COMP)[endpoint]
let top = v(TOP)[endpoint]
let decision = 0
if cmp >= 0.9
let code = trial
let decision = 1
end
echo 131 7 $&trial $&cmp $&top 0.60234375 $&decision >> decisions.csv
let trial = code + 64
let drive = (floor(trial / 1) - 2*floor(trial / 2))*1.8
alter VB0 = $&drive
let drive = (floor(trial / 2) - 2*floor(trial / 4))*1.8
alter VB1 = $&drive
let drive = (floor(trial / 4) - 2*floor(trial / 8))*1.8
alter VB2 = $&drive
let drive = (floor(trial / 8) - 2*floor(trial / 16))*1.8
alter VB3 = $&drive
let drive = (floor(trial / 16) - 2*floor(trial / 32))*1.8
alter VB4 = $&drive
let drive = (floor(trial / 32) - 2*floor(trial / 64))*1.8
alter VB5 = $&drive
let drive = (floor(trial / 64) - 2*floor(trial / 128))*1.8
alter VB6 = $&drive
let drive = (floor(trial / 128) - 2*floor(trial / 256))*1.8
alter VB7 = $&drive
stop when time = 0.002364
resume
delete all
let endpoint = length(time)-1
let cmp = v(COMP)[endpoint]
let top = v(TOP)[endpoint]
let decision = 0
if cmp >= 0.9
let code = trial
let decision = 1
end
echo 131 6 $&trial $&cmp $&top 0.60234375 $&decision >> decisions.csv
let trial = code + 32
let drive = (floor(trial / 1) - 2*floor(trial / 2))*1.8
alter VB0 = $&drive
let drive = (floor(trial / 2) - 2*floor(trial / 4))*1.8
alter VB1 = $&drive
let drive = (floor(trial / 4) - 2*floor(trial / 8))*1.8
alter VB2 = $&drive
let drive = (floor(trial / 8) - 2*floor(trial / 16))*1.8
alter VB3 = $&drive
let drive = (floor(trial / 16) - 2*floor(trial / 32))*1.8
alter VB4 = $&drive
let drive = (floor(trial / 32) - 2*floor(trial / 64))*1.8
alter VB5 = $&drive
let drive = (floor(trial / 64) - 2*floor(trial / 128))*1.8
alter VB6 = $&drive
let drive = (floor(trial / 128) - 2*floor(trial / 256))*1.8
alter VB7 = $&drive
stop when time = 0.002366
resume
delete all
let endpoint = length(time)-1
let cmp = v(COMP)[endpoint]
let top = v(TOP)[endpoint]
let decision = 0
if cmp >= 0.9
let code = trial
let decision = 1
end
echo 131 5 $&trial $&cmp $&top 0.60234375 $&decision >> decisions.csv
let trial = code + 16
let drive = (floor(trial / 1) - 2*floor(trial / 2))*1.8
alter VB0 = $&drive
let drive = (floor(trial / 2) - 2*floor(trial / 4))*1.8
alter VB1 = $&drive
let drive = (floor(trial / 4) - 2*floor(trial / 8))*1.8
alter VB2 = $&drive
let drive = (floor(trial / 8) - 2*floor(trial / 16))*1.8
alter VB3 = $&drive
let drive = (floor(trial / 16) - 2*floor(trial / 32))*1.8
alter VB4 = $&drive
let drive = (floor(trial / 32) - 2*floor(trial / 64))*1.8
alter VB5 = $&drive
let drive = (floor(trial / 64) - 2*floor(trial / 128))*1.8
alter VB6 = $&drive
let drive = (floor(trial / 128) - 2*floor(trial / 256))*1.8
alter VB7 = $&drive
stop when time = 0.002368
resume
delete all
let endpoint = length(time)-1
let cmp = v(COMP)[endpoint]
let top = v(TOP)[endpoint]
let decision = 0
if cmp >= 0.9
let code = trial
let decision = 1
end
echo 131 4 $&trial $&cmp $&top 0.60234375 $&decision >> decisions.csv
let trial = code + 8
let drive = (floor(trial / 1) - 2*floor(trial / 2))*1.8
alter VB0 = $&drive
let drive = (floor(trial / 2) - 2*floor(trial / 4))*1.8
alter VB1 = $&drive
let drive = (floor(trial / 4) - 2*floor(trial / 8))*1.8
alter VB2 = $&drive
let drive = (floor(trial / 8) - 2*floor(trial / 16))*1.8
alter VB3 = $&drive
let drive = (floor(trial / 16) - 2*floor(trial / 32))*1.8
alter VB4 = $&drive
let drive = (floor(trial / 32) - 2*floor(trial / 64))*1.8
alter VB5 = $&drive
let drive = (floor(trial / 64) - 2*floor(trial / 128))*1.8
alter VB6 = $&drive
let drive = (floor(trial / 128) - 2*floor(trial / 256))*1.8
alter VB7 = $&drive
stop when time = 0.00237
resume
delete all
let endpoint = length(time)-1
let cmp = v(COMP)[endpoint]
let top = v(TOP)[endpoint]
let decision = 0
if cmp >= 0.9
let code = trial
let decision = 1
end
echo 131 3 $&trial $&cmp $&top 0.60234375 $&decision >> decisions.csv
let trial = code + 4
let drive = (floor(trial / 1) - 2*floor(trial / 2))*1.8
alter VB0 = $&drive
let drive = (floor(trial / 2) - 2*floor(trial / 4))*1.8
alter VB1 = $&drive
let drive = (floor(trial / 4) - 2*floor(trial / 8))*1.8
alter VB2 = $&drive
let drive = (floor(trial / 8) - 2*floor(trial / 16))*1.8
alter VB3 = $&drive
let drive = (floor(trial / 16) - 2*floor(trial / 32))*1.8
alter VB4 = $&drive
let drive = (floor(trial / 32) - 2*floor(trial / 64))*1.8
alter VB5 = $&drive
let drive = (floor(trial / 64) - 2*floor(trial / 128))*1.8
alter VB6 = $&drive
let drive = (floor(trial / 128) - 2*floor(trial / 256))*1.8
alter VB7 = $&drive
stop when time = 0.002372
resume
delete all
let endpoint = length(time)-1
let cmp = v(COMP)[endpoint]
let top = v(TOP)[endpoint]
let decision = 0
if cmp >= 0.9
let code = trial
let decision = 1
end
echo 131 2 $&trial $&cmp $&top 0.60234375 $&decision >> decisions.csv
let trial = code + 2
let drive = (floor(trial / 1) - 2*floor(trial / 2))*1.8
alter VB0 = $&drive
let drive = (floor(trial / 2) - 2*floor(trial / 4))*1.8
alter VB1 = $&drive
let drive = (floor(trial / 4) - 2*floor(trial / 8))*1.8
alter VB2 = $&drive
let drive = (floor(trial / 8) - 2*floor(trial / 16))*1.8
alter VB3 = $&drive
let drive = (floor(trial / 16) - 2*floor(trial / 32))*1.8
alter VB4 = $&drive
let drive = (floor(trial / 32) - 2*floor(trial / 64))*1.8
alter VB5 = $&drive
let drive = (floor(trial / 64) - 2*floor(trial / 128))*1.8
alter VB6 = $&drive
let drive = (floor(trial / 128) - 2*floor(trial / 256))*1.8
alter VB7 = $&drive
stop when time = 0.002374
resume
delete all
let endpoint = length(time)-1
let cmp = v(COMP)[endpoint]
let top = v(TOP)[endpoint]
let decision = 0
if cmp >= 0.9
let code = trial
let decision = 1
end
echo 131 1 $&trial $&cmp $&top 0.60234375 $&decision >> decisions.csv
let trial = code + 1
let drive = (floor(trial / 1) - 2*floor(trial / 2))*1.8
alter VB0 = $&drive
let drive = (floor(trial / 2) - 2*floor(trial / 4))*1.8
alter VB1 = $&drive
let drive = (floor(trial / 4) - 2*floor(trial / 8))*1.8
alter VB2 = $&drive
let drive = (floor(trial / 8) - 2*floor(trial / 16))*1.8
alter VB3 = $&drive
let drive = (floor(trial / 16) - 2*floor(trial / 32))*1.8
alter VB4 = $&drive
let drive = (floor(trial / 32) - 2*floor(trial / 64))*1.8
alter VB5 = $&drive
let drive = (floor(trial / 64) - 2*floor(trial / 128))*1.8
alter VB6 = $&drive
let drive = (floor(trial / 128) - 2*floor(trial / 256))*1.8
alter VB7 = $&drive
stop when time = 0.002376
resume
delete all
let endpoint = length(time)-1
let cmp = v(COMP)[endpoint]
let top = v(TOP)[endpoint]
let decision = 0
if cmp >= 0.9
let code = trial
let decision = 1
end
echo 131 0 $&trial $&cmp $&top 0.60234375 $&decision >> decisions.csv
alter VIN = 0.60703125
alter VSAMPLE = 1.8
alter VB0 = 0
alter VB1 = 0
alter VB2 = 0
alter VB3 = 0
alter VB4 = 0
alter VB5 = 0
alter VB6 = 0
alter VB7 = 0
let code = 0
stop when time = 0.002378
resume
delete all
alter VSAMPLE = 0
let trial = code + 128
let drive = (floor(trial / 1) - 2*floor(trial / 2))*1.8
alter VB0 = $&drive
let drive = (floor(trial / 2) - 2*floor(trial / 4))*1.8
alter VB1 = $&drive
let drive = (floor(trial / 4) - 2*floor(trial / 8))*1.8
alter VB2 = $&drive
let drive = (floor(trial / 8) - 2*floor(trial / 16))*1.8
alter VB3 = $&drive
let drive = (floor(trial / 16) - 2*floor(trial / 32))*1.8
alter VB4 = $&drive
let drive = (floor(trial / 32) - 2*floor(trial / 64))*1.8
alter VB5 = $&drive
let drive = (floor(trial / 64) - 2*floor(trial / 128))*1.8
alter VB6 = $&drive
let drive = (floor(trial / 128) - 2*floor(trial / 256))*1.8
alter VB7 = $&drive
stop when time = 0.00238
resume
delete all
let endpoint = length(time)-1
let cmp = v(COMP)[endpoint]
let top = v(TOP)[endpoint]
let decision = 0
if cmp >= 0.9
let code = trial
let decision = 1
end
echo 132 7 $&trial $&cmp $&top 0.60703125 $&decision >> decisions.csv
let trial = code + 64
let drive = (floor(trial / 1) - 2*floor(trial / 2))*1.8
alter VB0 = $&drive
let drive = (floor(trial / 2) - 2*floor(trial / 4))*1.8
alter VB1 = $&drive
let drive = (floor(trial / 4) - 2*floor(trial / 8))*1.8
alter VB2 = $&drive
let drive = (floor(trial / 8) - 2*floor(trial / 16))*1.8
alter VB3 = $&drive
let drive = (floor(trial / 16) - 2*floor(trial / 32))*1.8
alter VB4 = $&drive
let drive = (floor(trial / 32) - 2*floor(trial / 64))*1.8
alter VB5 = $&drive
let drive = (floor(trial / 64) - 2*floor(trial / 128))*1.8
alter VB6 = $&drive
let drive = (floor(trial / 128) - 2*floor(trial / 256))*1.8
alter VB7 = $&drive
stop when time = 0.002382
resume
delete all
let endpoint = length(time)-1
let cmp = v(COMP)[endpoint]
let top = v(TOP)[endpoint]
let decision = 0
if cmp >= 0.9
let code = trial
let decision = 1
end
echo 132 6 $&trial $&cmp $&top 0.60703125 $&decision >> decisions.csv
let trial = code + 32
let drive = (floor(trial / 1) - 2*floor(trial / 2))*1.8
alter VB0 = $&drive
let drive = (floor(trial / 2) - 2*floor(trial / 4))*1.8
alter VB1 = $&drive
let drive = (floor(trial / 4) - 2*floor(trial / 8))*1.8
alter VB2 = $&drive
let drive = (floor(trial / 8) - 2*floor(trial / 16))*1.8
alter VB3 = $&drive
let drive = (floor(trial / 16) - 2*floor(trial / 32))*1.8
alter VB4 = $&drive
let drive = (floor(trial / 32) - 2*floor(trial / 64))*1.8
alter VB5 = $&drive
let drive = (floor(trial / 64) - 2*floor(trial / 128))*1.8
alter VB6 = $&drive
let drive = (floor(trial / 128) - 2*floor(trial / 256))*1.8
alter VB7 = $&drive
stop when time = 0.002384
resume
delete all
let endpoint = length(time)-1
let cmp = v(COMP)[endpoint]
let top = v(TOP)[endpoint]
let decision = 0
if cmp >= 0.9
let code = trial
let decision = 1
end
echo 132 5 $&trial $&cmp $&top 0.60703125 $&decision >> decisions.csv
let trial = code + 16
let drive = (floor(trial / 1) - 2*floor(trial / 2))*1.8
alter VB0 = $&drive
let drive = (floor(trial / 2) - 2*floor(trial / 4))*1.8
alter VB1 = $&drive
let drive = (floor(trial / 4) - 2*floor(trial / 8))*1.8
alter VB2 = $&drive
let drive = (floor(trial / 8) - 2*floor(trial / 16))*1.8
alter VB3 = $&drive
let drive = (floor(trial / 16) - 2*floor(trial / 32))*1.8
alter VB4 = $&drive
let drive = (floor(trial / 32) - 2*floor(trial / 64))*1.8
alter VB5 = $&drive
let drive = (floor(trial / 64) - 2*floor(trial / 128))*1.8
alter VB6 = $&drive
let drive = (floor(trial / 128) - 2*floor(trial / 256))*1.8
alter VB7 = $&drive
stop when time = 0.002386
resume
delete all
let endpoint = length(time)-1
let cmp = v(COMP)[endpoint]
let top = v(TOP)[endpoint]
let decision = 0
if cmp >= 0.9
let code = trial
let decision = 1
end
echo 132 4 $&trial $&cmp $&top 0.60703125 $&decision >> decisions.csv
let trial = code + 8
let drive = (floor(trial / 1) - 2*floor(trial / 2))*1.8
alter VB0 = $&drive
let drive = (floor(trial / 2) - 2*floor(trial / 4))*1.8
alter VB1 = $&drive
let drive = (floor(trial / 4) - 2*floor(trial / 8))*1.8
alter VB2 = $&drive
let drive = (floor(trial / 8) - 2*floor(trial / 16))*1.8
alter VB3 = $&drive
let drive = (floor(trial / 16) - 2*floor(trial / 32))*1.8
alter VB4 = $&drive
let drive = (floor(trial / 32) - 2*floor(trial / 64))*1.8
alter VB5 = $&drive
let drive = (floor(trial / 64) - 2*floor(trial / 128))*1.8
alter VB6 = $&drive
let drive = (floor(trial / 128) - 2*floor(trial / 256))*1.8
alter VB7 = $&drive
stop when time = 0.002388
resume
delete all
let endpoint = length(time)-1
let cmp = v(COMP)[endpoint]
let top = v(TOP)[endpoint]
let decision = 0
if cmp >= 0.9
let code = trial
let decision = 1
end
echo 132 3 $&trial $&cmp $&top 0.60703125 $&decision >> decisions.csv
let trial = code + 4
let drive = (floor(trial / 1) - 2*floor(trial / 2))*1.8
alter VB0 = $&drive
let drive = (floor(trial / 2) - 2*floor(trial / 4))*1.8
alter VB1 = $&drive
let drive = (floor(trial / 4) - 2*floor(trial / 8))*1.8
alter VB2 = $&drive
let drive = (floor(trial / 8) - 2*floor(trial / 16))*1.8
alter VB3 = $&drive
let drive = (floor(trial / 16) - 2*floor(trial / 32))*1.8
alter VB4 = $&drive
let drive = (floor(trial / 32) - 2*floor(trial / 64))*1.8
alter VB5 = $&drive
let drive = (floor(trial / 64) - 2*floor(trial / 128))*1.8
alter VB6 = $&drive
let drive = (floor(trial / 128) - 2*floor(trial / 256))*1.8
alter VB7 = $&drive
stop when time = 0.00239
resume
delete all
let endpoint = length(time)-1
let cmp = v(COMP)[endpoint]
let top = v(TOP)[endpoint]
let decision = 0
if cmp >= 0.9
let code = trial
let decision = 1
end
echo 132 2 $&trial $&cmp $&top 0.60703125 $&decision >> decisions.csv
let trial = code + 2
let drive = (floor(trial / 1) - 2*floor(trial / 2))*1.8
alter VB0 = $&drive
let drive = (floor(trial / 2) - 2*floor(trial / 4))*1.8
alter VB1 = $&drive
let drive = (floor(trial / 4) - 2*floor(trial / 8))*1.8
alter VB2 = $&drive
let drive = (floor(trial / 8) - 2*floor(trial / 16))*1.8
alter VB3 = $&drive
let drive = (floor(trial / 16) - 2*floor(trial / 32))*1.8
alter VB4 = $&drive
let drive = (floor(trial / 32) - 2*floor(trial / 64))*1.8
alter VB5 = $&drive
let drive = (floor(trial / 64) - 2*floor(trial / 128))*1.8
alter VB6 = $&drive
let drive = (floor(trial / 128) - 2*floor(trial / 256))*1.8
alter VB7 = $&drive
stop when time = 0.002392
resume
delete all
let endpoint = length(time)-1
let cmp = v(COMP)[endpoint]
let top = v(TOP)[endpoint]
let decision = 0
if cmp >= 0.9
let code = trial
let decision = 1
end
echo 132 1 $&trial $&cmp $&top 0.60703125 $&decision >> decisions.csv
let trial = code + 1
let drive = (floor(trial / 1) - 2*floor(trial / 2))*1.8
alter VB0 = $&drive
let drive = (floor(trial / 2) - 2*floor(trial / 4))*1.8
alter VB1 = $&drive
let drive = (floor(trial / 4) - 2*floor(trial / 8))*1.8
alter VB2 = $&drive
let drive = (floor(trial / 8) - 2*floor(trial / 16))*1.8
alter VB3 = $&drive
let drive = (floor(trial / 16) - 2*floor(trial / 32))*1.8
alter VB4 = $&drive
let drive = (floor(trial / 32) - 2*floor(trial / 64))*1.8
alter VB5 = $&drive
let drive = (floor(trial / 64) - 2*floor(trial / 128))*1.8
alter VB6 = $&drive
let drive = (floor(trial / 128) - 2*floor(trial / 256))*1.8
alter VB7 = $&drive
stop when time = 0.002394
resume
delete all
let endpoint = length(time)-1
let cmp = v(COMP)[endpoint]
let top = v(TOP)[endpoint]
let decision = 0
if cmp >= 0.9
let code = trial
let decision = 1
end
echo 132 0 $&trial $&cmp $&top 0.60703125 $&decision >> decisions.csv
alter VIN = 0.61171875
alter VSAMPLE = 1.8
alter VB0 = 0
alter VB1 = 0
alter VB2 = 0
alter VB3 = 0
alter VB4 = 0
alter VB5 = 0
alter VB6 = 0
alter VB7 = 0
let code = 0
stop when time = 0.002396
resume
delete all
alter VSAMPLE = 0
let trial = code + 128
let drive = (floor(trial / 1) - 2*floor(trial / 2))*1.8
alter VB0 = $&drive
let drive = (floor(trial / 2) - 2*floor(trial / 4))*1.8
alter VB1 = $&drive
let drive = (floor(trial / 4) - 2*floor(trial / 8))*1.8
alter VB2 = $&drive
let drive = (floor(trial / 8) - 2*floor(trial / 16))*1.8
alter VB3 = $&drive
let drive = (floor(trial / 16) - 2*floor(trial / 32))*1.8
alter VB4 = $&drive
let drive = (floor(trial / 32) - 2*floor(trial / 64))*1.8
alter VB5 = $&drive
let drive = (floor(trial / 64) - 2*floor(trial / 128))*1.8
alter VB6 = $&drive
let drive = (floor(trial / 128) - 2*floor(trial / 256))*1.8
alter VB7 = $&drive
stop when time = 0.002398
resume
delete all
let endpoint = length(time)-1
let cmp = v(COMP)[endpoint]
let top = v(TOP)[endpoint]
let decision = 0
if cmp >= 0.9
let code = trial
let decision = 1
end
echo 133 7 $&trial $&cmp $&top 0.61171875 $&decision >> decisions.csv
let trial = code + 64
let drive = (floor(trial / 1) - 2*floor(trial / 2))*1.8
alter VB0 = $&drive
let drive = (floor(trial / 2) - 2*floor(trial / 4))*1.8
alter VB1 = $&drive
let drive = (floor(trial / 4) - 2*floor(trial / 8))*1.8
alter VB2 = $&drive
let drive = (floor(trial / 8) - 2*floor(trial / 16))*1.8
alter VB3 = $&drive
let drive = (floor(trial / 16) - 2*floor(trial / 32))*1.8
alter VB4 = $&drive
let drive = (floor(trial / 32) - 2*floor(trial / 64))*1.8
alter VB5 = $&drive
let drive = (floor(trial / 64) - 2*floor(trial / 128))*1.8
alter VB6 = $&drive
let drive = (floor(trial / 128) - 2*floor(trial / 256))*1.8
alter VB7 = $&drive
stop when time = 0.0024
resume
delete all
let endpoint = length(time)-1
let cmp = v(COMP)[endpoint]
let top = v(TOP)[endpoint]
let decision = 0
if cmp >= 0.9
let code = trial
let decision = 1
end
echo 133 6 $&trial $&cmp $&top 0.61171875 $&decision >> decisions.csv
let trial = code + 32
let drive = (floor(trial / 1) - 2*floor(trial / 2))*1.8
alter VB0 = $&drive
let drive = (floor(trial / 2) - 2*floor(trial / 4))*1.8
alter VB1 = $&drive
let drive = (floor(trial / 4) - 2*floor(trial / 8))*1.8
alter VB2 = $&drive
let drive = (floor(trial / 8) - 2*floor(trial / 16))*1.8
alter VB3 = $&drive
let drive = (floor(trial / 16) - 2*floor(trial / 32))*1.8
alter VB4 = $&drive
let drive = (floor(trial / 32) - 2*floor(trial / 64))*1.8
alter VB5 = $&drive
let drive = (floor(trial / 64) - 2*floor(trial / 128))*1.8
alter VB6 = $&drive
let drive = (floor(trial / 128) - 2*floor(trial / 256))*1.8
alter VB7 = $&drive
stop when time = 0.002402
resume
delete all
let endpoint = length(time)-1
let cmp = v(COMP)[endpoint]
let top = v(TOP)[endpoint]
let decision = 0
if cmp >= 0.9
let code = trial
let decision = 1
end
echo 133 5 $&trial $&cmp $&top 0.61171875 $&decision >> decisions.csv
let trial = code + 16
let drive = (floor(trial / 1) - 2*floor(trial / 2))*1.8
alter VB0 = $&drive
let drive = (floor(trial / 2) - 2*floor(trial / 4))*1.8
alter VB1 = $&drive
let drive = (floor(trial / 4) - 2*floor(trial / 8))*1.8
alter VB2 = $&drive
let drive = (floor(trial / 8) - 2*floor(trial / 16))*1.8
alter VB3 = $&drive
let drive = (floor(trial / 16) - 2*floor(trial / 32))*1.8
alter VB4 = $&drive
let drive = (floor(trial / 32) - 2*floor(trial / 64))*1.8
alter VB5 = $&drive
let drive = (floor(trial / 64) - 2*floor(trial / 128))*1.8
alter VB6 = $&drive
let drive = (floor(trial / 128) - 2*floor(trial / 256))*1.8
alter VB7 = $&drive
stop when time = 0.002404
resume
delete all
let endpoint = length(time)-1
let cmp = v(COMP)[endpoint]
let top = v(TOP)[endpoint]
let decision = 0
if cmp >= 0.9
let code = trial
let decision = 1
end
echo 133 4 $&trial $&cmp $&top 0.61171875 $&decision >> decisions.csv
let trial = code + 8
let drive = (floor(trial / 1) - 2*floor(trial / 2))*1.8
alter VB0 = $&drive
let drive = (floor(trial / 2) - 2*floor(trial / 4))*1.8
alter VB1 = $&drive
let drive = (floor(trial / 4) - 2*floor(trial / 8))*1.8
alter VB2 = $&drive
let drive = (floor(trial / 8) - 2*floor(trial / 16))*1.8
alter VB3 = $&drive
let drive = (floor(trial / 16) - 2*floor(trial / 32))*1.8
alter VB4 = $&drive
let drive = (floor(trial / 32) - 2*floor(trial / 64))*1.8
alter VB5 = $&drive
let drive = (floor(trial / 64) - 2*floor(trial / 128))*1.8
alter VB6 = $&drive
let drive = (floor(trial / 128) - 2*floor(trial / 256))*1.8
alter VB7 = $&drive
stop when time = 0.002406
resume
delete all
let endpoint = length(time)-1
let cmp = v(COMP)[endpoint]
let top = v(TOP)[endpoint]
let decision = 0
if cmp >= 0.9
let code = trial
let decision = 1
end
echo 133 3 $&trial $&cmp $&top 0.61171875 $&decision >> decisions.csv
let trial = code + 4
let drive = (floor(trial / 1) - 2*floor(trial / 2))*1.8
alter VB0 = $&drive
let drive = (floor(trial / 2) - 2*floor(trial / 4))*1.8
alter VB1 = $&drive
let drive = (floor(trial / 4) - 2*floor(trial / 8))*1.8
alter VB2 = $&drive
let drive = (floor(trial / 8) - 2*floor(trial / 16))*1.8
alter VB3 = $&drive
let drive = (floor(trial / 16) - 2*floor(trial / 32))*1.8
alter VB4 = $&drive
let drive = (floor(trial / 32) - 2*floor(trial / 64))*1.8
alter VB5 = $&drive
let drive = (floor(trial / 64) - 2*floor(trial / 128))*1.8
alter VB6 = $&drive
let drive = (floor(trial / 128) - 2*floor(trial / 256))*1.8
alter VB7 = $&drive
stop when time = 0.002408
resume
delete all
let endpoint = length(time)-1
let cmp = v(COMP)[endpoint]
let top = v(TOP)[endpoint]
let decision = 0
if cmp >= 0.9
let code = trial
let decision = 1
end
echo 133 2 $&trial $&cmp $&top 0.61171875 $&decision >> decisions.csv
let trial = code + 2
let drive = (floor(trial / 1) - 2*floor(trial / 2))*1.8
alter VB0 = $&drive
let drive = (floor(trial / 2) - 2*floor(trial / 4))*1.8
alter VB1 = $&drive
let drive = (floor(trial / 4) - 2*floor(trial / 8))*1.8
alter VB2 = $&drive
let drive = (floor(trial / 8) - 2*floor(trial / 16))*1.8
alter VB3 = $&drive
let drive = (floor(trial / 16) - 2*floor(trial / 32))*1.8
alter VB4 = $&drive
let drive = (floor(trial / 32) - 2*floor(trial / 64))*1.8
alter VB5 = $&drive
let drive = (floor(trial / 64) - 2*floor(trial / 128))*1.8
alter VB6 = $&drive
let drive = (floor(trial / 128) - 2*floor(trial / 256))*1.8
alter VB7 = $&drive
stop when time = 0.00241
resume
delete all
let endpoint = length(time)-1
let cmp = v(COMP)[endpoint]
let top = v(TOP)[endpoint]
let decision = 0
if cmp >= 0.9
let code = trial
let decision = 1
end
echo 133 1 $&trial $&cmp $&top 0.61171875 $&decision >> decisions.csv
let trial = code + 1
let drive = (floor(trial / 1) - 2*floor(trial / 2))*1.8
alter VB0 = $&drive
let drive = (floor(trial / 2) - 2*floor(trial / 4))*1.8
alter VB1 = $&drive
let drive = (floor(trial / 4) - 2*floor(trial / 8))*1.8
alter VB2 = $&drive
let drive = (floor(trial / 8) - 2*floor(trial / 16))*1.8
alter VB3 = $&drive
let drive = (floor(trial / 16) - 2*floor(trial / 32))*1.8
alter VB4 = $&drive
let drive = (floor(trial / 32) - 2*floor(trial / 64))*1.8
alter VB5 = $&drive
let drive = (floor(trial / 64) - 2*floor(trial / 128))*1.8
alter VB6 = $&drive
let drive = (floor(trial / 128) - 2*floor(trial / 256))*1.8
alter VB7 = $&drive
stop when time = 0.002412
resume
delete all
let endpoint = length(time)-1
let cmp = v(COMP)[endpoint]
let top = v(TOP)[endpoint]
let decision = 0
if cmp >= 0.9
let code = trial
let decision = 1
end
echo 133 0 $&trial $&cmp $&top 0.61171875 $&decision >> decisions.csv
alter VIN = 0.61640625
alter VSAMPLE = 1.8
alter VB0 = 0
alter VB1 = 0
alter VB2 = 0
alter VB3 = 0
alter VB4 = 0
alter VB5 = 0
alter VB6 = 0
alter VB7 = 0
let code = 0
stop when time = 0.002414
resume
delete all
alter VSAMPLE = 0
let trial = code + 128
let drive = (floor(trial / 1) - 2*floor(trial / 2))*1.8
alter VB0 = $&drive
let drive = (floor(trial / 2) - 2*floor(trial / 4))*1.8
alter VB1 = $&drive
let drive = (floor(trial / 4) - 2*floor(trial / 8))*1.8
alter VB2 = $&drive
let drive = (floor(trial / 8) - 2*floor(trial / 16))*1.8
alter VB3 = $&drive
let drive = (floor(trial / 16) - 2*floor(trial / 32))*1.8
alter VB4 = $&drive
let drive = (floor(trial / 32) - 2*floor(trial / 64))*1.8
alter VB5 = $&drive
let drive = (floor(trial / 64) - 2*floor(trial / 128))*1.8
alter VB6 = $&drive
let drive = (floor(trial / 128) - 2*floor(trial / 256))*1.8
alter VB7 = $&drive
stop when time = 0.002416
resume
delete all
let endpoint = length(time)-1
let cmp = v(COMP)[endpoint]
let top = v(TOP)[endpoint]
let decision = 0
if cmp >= 0.9
let code = trial
let decision = 1
end
echo 134 7 $&trial $&cmp $&top 0.61640625 $&decision >> decisions.csv
let trial = code + 64
let drive = (floor(trial / 1) - 2*floor(trial / 2))*1.8
alter VB0 = $&drive
let drive = (floor(trial / 2) - 2*floor(trial / 4))*1.8
alter VB1 = $&drive
let drive = (floor(trial / 4) - 2*floor(trial / 8))*1.8
alter VB2 = $&drive
let drive = (floor(trial / 8) - 2*floor(trial / 16))*1.8
alter VB3 = $&drive
let drive = (floor(trial / 16) - 2*floor(trial / 32))*1.8
alter VB4 = $&drive
let drive = (floor(trial / 32) - 2*floor(trial / 64))*1.8
alter VB5 = $&drive
let drive = (floor(trial / 64) - 2*floor(trial / 128))*1.8
alter VB6 = $&drive
let drive = (floor(trial / 128) - 2*floor(trial / 256))*1.8
alter VB7 = $&drive
stop when time = 0.002418
resume
delete all
let endpoint = length(time)-1
let cmp = v(COMP)[endpoint]
let top = v(TOP)[endpoint]
let decision = 0
if cmp >= 0.9
let code = trial
let decision = 1
end
echo 134 6 $&trial $&cmp $&top 0.61640625 $&decision >> decisions.csv
let trial = code + 32
let drive = (floor(trial / 1) - 2*floor(trial / 2))*1.8
alter VB0 = $&drive
let drive = (floor(trial / 2) - 2*floor(trial / 4))*1.8
alter VB1 = $&drive
let drive = (floor(trial / 4) - 2*floor(trial / 8))*1.8
alter VB2 = $&drive
let drive = (floor(trial / 8) - 2*floor(trial / 16))*1.8
alter VB3 = $&drive
let drive = (floor(trial / 16) - 2*floor(trial / 32))*1.8
alter VB4 = $&drive
let drive = (floor(trial / 32) - 2*floor(trial / 64))*1.8
alter VB5 = $&drive
let drive = (floor(trial / 64) - 2*floor(trial / 128))*1.8
alter VB6 = $&drive
let drive = (floor(trial / 128) - 2*floor(trial / 256))*1.8
alter VB7 = $&drive
stop when time = 0.00242
resume
delete all
let endpoint = length(time)-1
let cmp = v(COMP)[endpoint]
let top = v(TOP)[endpoint]
let decision = 0
if cmp >= 0.9
let code = trial
let decision = 1
end
echo 134 5 $&trial $&cmp $&top 0.61640625 $&decision >> decisions.csv
let trial = code + 16
let drive = (floor(trial / 1) - 2*floor(trial / 2))*1.8
alter VB0 = $&drive
let drive = (floor(trial / 2) - 2*floor(trial / 4))*1.8
alter VB1 = $&drive
let drive = (floor(trial / 4) - 2*floor(trial / 8))*1.8
alter VB2 = $&drive
let drive = (floor(trial / 8) - 2*floor(trial / 16))*1.8
alter VB3 = $&drive
let drive = (floor(trial / 16) - 2*floor(trial / 32))*1.8
alter VB4 = $&drive
let drive = (floor(trial / 32) - 2*floor(trial / 64))*1.8
alter VB5 = $&drive
let drive = (floor(trial / 64) - 2*floor(trial / 128))*1.8
alter VB6 = $&drive
let drive = (floor(trial / 128) - 2*floor(trial / 256))*1.8
alter VB7 = $&drive
stop when time = 0.002422
resume
delete all
let endpoint = length(time)-1
let cmp = v(COMP)[endpoint]
let top = v(TOP)[endpoint]
let decision = 0
if cmp >= 0.9
let code = trial
let decision = 1
end
echo 134 4 $&trial $&cmp $&top 0.61640625 $&decision >> decisions.csv
let trial = code + 8
let drive = (floor(trial / 1) - 2*floor(trial / 2))*1.8
alter VB0 = $&drive
let drive = (floor(trial / 2) - 2*floor(trial / 4))*1.8
alter VB1 = $&drive
let drive = (floor(trial / 4) - 2*floor(trial / 8))*1.8
alter VB2 = $&drive
let drive = (floor(trial / 8) - 2*floor(trial / 16))*1.8
alter VB3 = $&drive
let drive = (floor(trial / 16) - 2*floor(trial / 32))*1.8
alter VB4 = $&drive
let drive = (floor(trial / 32) - 2*floor(trial / 64))*1.8
alter VB5 = $&drive
let drive = (floor(trial / 64) - 2*floor(trial / 128))*1.8
alter VB6 = $&drive
let drive = (floor(trial / 128) - 2*floor(trial / 256))*1.8
alter VB7 = $&drive
stop when time = 0.002424
resume
delete all
let endpoint = length(time)-1
let cmp = v(COMP)[endpoint]
let top = v(TOP)[endpoint]
let decision = 0
if cmp >= 0.9
let code = trial
let decision = 1
end
echo 134 3 $&trial $&cmp $&top 0.61640625 $&decision >> decisions.csv
let trial = code + 4
let drive = (floor(trial / 1) - 2*floor(trial / 2))*1.8
alter VB0 = $&drive
let drive = (floor(trial / 2) - 2*floor(trial / 4))*1.8
alter VB1 = $&drive
let drive = (floor(trial / 4) - 2*floor(trial / 8))*1.8
alter VB2 = $&drive
let drive = (floor(trial / 8) - 2*floor(trial / 16))*1.8
alter VB3 = $&drive
let drive = (floor(trial / 16) - 2*floor(trial / 32))*1.8
alter VB4 = $&drive
let drive = (floor(trial / 32) - 2*floor(trial / 64))*1.8
alter VB5 = $&drive
let drive = (floor(trial / 64) - 2*floor(trial / 128))*1.8
alter VB6 = $&drive
let drive = (floor(trial / 128) - 2*floor(trial / 256))*1.8
alter VB7 = $&drive
stop when time = 0.002426
resume
delete all
let endpoint = length(time)-1
let cmp = v(COMP)[endpoint]
let top = v(TOP)[endpoint]
let decision = 0
if cmp >= 0.9
let code = trial
let decision = 1
end
echo 134 2 $&trial $&cmp $&top 0.61640625 $&decision >> decisions.csv
let trial = code + 2
let drive = (floor(trial / 1) - 2*floor(trial / 2))*1.8
alter VB0 = $&drive
let drive = (floor(trial / 2) - 2*floor(trial / 4))*1.8
alter VB1 = $&drive
let drive = (floor(trial / 4) - 2*floor(trial / 8))*1.8
alter VB2 = $&drive
let drive = (floor(trial / 8) - 2*floor(trial / 16))*1.8
alter VB3 = $&drive
let drive = (floor(trial / 16) - 2*floor(trial / 32))*1.8
alter VB4 = $&drive
let drive = (floor(trial / 32) - 2*floor(trial / 64))*1.8
alter VB5 = $&drive
let drive = (floor(trial / 64) - 2*floor(trial / 128))*1.8
alter VB6 = $&drive
let drive = (floor(trial / 128) - 2*floor(trial / 256))*1.8
alter VB7 = $&drive
stop when time = 0.002428
resume
delete all
let endpoint = length(time)-1
let cmp = v(COMP)[endpoint]
let top = v(TOP)[endpoint]
let decision = 0
if cmp >= 0.9
let code = trial
let decision = 1
end
echo 134 1 $&trial $&cmp $&top 0.61640625 $&decision >> decisions.csv
let trial = code + 1
let drive = (floor(trial / 1) - 2*floor(trial / 2))*1.8
alter VB0 = $&drive
let drive = (floor(trial / 2) - 2*floor(trial / 4))*1.8
alter VB1 = $&drive
let drive = (floor(trial / 4) - 2*floor(trial / 8))*1.8
alter VB2 = $&drive
let drive = (floor(trial / 8) - 2*floor(trial / 16))*1.8
alter VB3 = $&drive
let drive = (floor(trial / 16) - 2*floor(trial / 32))*1.8
alter VB4 = $&drive
let drive = (floor(trial / 32) - 2*floor(trial / 64))*1.8
alter VB5 = $&drive
let drive = (floor(trial / 64) - 2*floor(trial / 128))*1.8
alter VB6 = $&drive
let drive = (floor(trial / 128) - 2*floor(trial / 256))*1.8
alter VB7 = $&drive
stop when time = 0.00243
resume
delete all
let endpoint = length(time)-1
let cmp = v(COMP)[endpoint]
let top = v(TOP)[endpoint]
let decision = 0
if cmp >= 0.9
let code = trial
let decision = 1
end
echo 134 0 $&trial $&cmp $&top 0.61640625 $&decision >> decisions.csv
alter VIN = 0.62109375
alter VSAMPLE = 1.8
alter VB0 = 0
alter VB1 = 0
alter VB2 = 0
alter VB3 = 0
alter VB4 = 0
alter VB5 = 0
alter VB6 = 0
alter VB7 = 0
let code = 0
stop when time = 0.002432
resume
delete all
alter VSAMPLE = 0
let trial = code + 128
let drive = (floor(trial / 1) - 2*floor(trial / 2))*1.8
alter VB0 = $&drive
let drive = (floor(trial / 2) - 2*floor(trial / 4))*1.8
alter VB1 = $&drive
let drive = (floor(trial / 4) - 2*floor(trial / 8))*1.8
alter VB2 = $&drive
let drive = (floor(trial / 8) - 2*floor(trial / 16))*1.8
alter VB3 = $&drive
let drive = (floor(trial / 16) - 2*floor(trial / 32))*1.8
alter VB4 = $&drive
let drive = (floor(trial / 32) - 2*floor(trial / 64))*1.8
alter VB5 = $&drive
let drive = (floor(trial / 64) - 2*floor(trial / 128))*1.8
alter VB6 = $&drive
let drive = (floor(trial / 128) - 2*floor(trial / 256))*1.8
alter VB7 = $&drive
stop when time = 0.002434
resume
delete all
let endpoint = length(time)-1
let cmp = v(COMP)[endpoint]
let top = v(TOP)[endpoint]
let decision = 0
if cmp >= 0.9
let code = trial
let decision = 1
end
echo 135 7 $&trial $&cmp $&top 0.62109375 $&decision >> decisions.csv
let trial = code + 64
let drive = (floor(trial / 1) - 2*floor(trial / 2))*1.8
alter VB0 = $&drive
let drive = (floor(trial / 2) - 2*floor(trial / 4))*1.8
alter VB1 = $&drive
let drive = (floor(trial / 4) - 2*floor(trial / 8))*1.8
alter VB2 = $&drive
let drive = (floor(trial / 8) - 2*floor(trial / 16))*1.8
alter VB3 = $&drive
let drive = (floor(trial / 16) - 2*floor(trial / 32))*1.8
alter VB4 = $&drive
let drive = (floor(trial / 32) - 2*floor(trial / 64))*1.8
alter VB5 = $&drive
let drive = (floor(trial / 64) - 2*floor(trial / 128))*1.8
alter VB6 = $&drive
let drive = (floor(trial / 128) - 2*floor(trial / 256))*1.8
alter VB7 = $&drive
stop when time = 0.002436
resume
delete all
let endpoint = length(time)-1
let cmp = v(COMP)[endpoint]
let top = v(TOP)[endpoint]
let decision = 0
if cmp >= 0.9
let code = trial
let decision = 1
end
echo 135 6 $&trial $&cmp $&top 0.62109375 $&decision >> decisions.csv
let trial = code + 32
let drive = (floor(trial / 1) - 2*floor(trial / 2))*1.8
alter VB0 = $&drive
let drive = (floor(trial / 2) - 2*floor(trial / 4))*1.8
alter VB1 = $&drive
let drive = (floor(trial / 4) - 2*floor(trial / 8))*1.8
alter VB2 = $&drive
let drive = (floor(trial / 8) - 2*floor(trial / 16))*1.8
alter VB3 = $&drive
let drive = (floor(trial / 16) - 2*floor(trial / 32))*1.8
alter VB4 = $&drive
let drive = (floor(trial / 32) - 2*floor(trial / 64))*1.8
alter VB5 = $&drive
let drive = (floor(trial / 64) - 2*floor(trial / 128))*1.8
alter VB6 = $&drive
let drive = (floor(trial / 128) - 2*floor(trial / 256))*1.8
alter VB7 = $&drive
stop when time = 0.002438
resume
delete all
let endpoint = length(time)-1
let cmp = v(COMP)[endpoint]
let top = v(TOP)[endpoint]
let decision = 0
if cmp >= 0.9
let code = trial
let decision = 1
end
echo 135 5 $&trial $&cmp $&top 0.62109375 $&decision >> decisions.csv
let trial = code + 16
let drive = (floor(trial / 1) - 2*floor(trial / 2))*1.8
alter VB0 = $&drive
let drive = (floor(trial / 2) - 2*floor(trial / 4))*1.8
alter VB1 = $&drive
let drive = (floor(trial / 4) - 2*floor(trial / 8))*1.8
alter VB2 = $&drive
let drive = (floor(trial / 8) - 2*floor(trial / 16))*1.8
alter VB3 = $&drive
let drive = (floor(trial / 16) - 2*floor(trial / 32))*1.8
alter VB4 = $&drive
let drive = (floor(trial / 32) - 2*floor(trial / 64))*1.8
alter VB5 = $&drive
let drive = (floor(trial / 64) - 2*floor(trial / 128))*1.8
alter VB6 = $&drive
let drive = (floor(trial / 128) - 2*floor(trial / 256))*1.8
alter VB7 = $&drive
stop when time = 0.00244
resume
delete all
let endpoint = length(time)-1
let cmp = v(COMP)[endpoint]
let top = v(TOP)[endpoint]
let decision = 0
if cmp >= 0.9
let code = trial
let decision = 1
end
echo 135 4 $&trial $&cmp $&top 0.62109375 $&decision >> decisions.csv
let trial = code + 8
let drive = (floor(trial / 1) - 2*floor(trial / 2))*1.8
alter VB0 = $&drive
let drive = (floor(trial / 2) - 2*floor(trial / 4))*1.8
alter VB1 = $&drive
let drive = (floor(trial / 4) - 2*floor(trial / 8))*1.8
alter VB2 = $&drive
let drive = (floor(trial / 8) - 2*floor(trial / 16))*1.8
alter VB3 = $&drive
let drive = (floor(trial / 16) - 2*floor(trial / 32))*1.8
alter VB4 = $&drive
let drive = (floor(trial / 32) - 2*floor(trial / 64))*1.8
alter VB5 = $&drive
let drive = (floor(trial / 64) - 2*floor(trial / 128))*1.8
alter VB6 = $&drive
let drive = (floor(trial / 128) - 2*floor(trial / 256))*1.8
alter VB7 = $&drive
stop when time = 0.002442
resume
delete all
let endpoint = length(time)-1
let cmp = v(COMP)[endpoint]
let top = v(TOP)[endpoint]
let decision = 0
if cmp >= 0.9
let code = trial
let decision = 1
end
echo 135 3 $&trial $&cmp $&top 0.62109375 $&decision >> decisions.csv
let trial = code + 4
let drive = (floor(trial / 1) - 2*floor(trial / 2))*1.8
alter VB0 = $&drive
let drive = (floor(trial / 2) - 2*floor(trial / 4))*1.8
alter VB1 = $&drive
let drive = (floor(trial / 4) - 2*floor(trial / 8))*1.8
alter VB2 = $&drive
let drive = (floor(trial / 8) - 2*floor(trial / 16))*1.8
alter VB3 = $&drive
let drive = (floor(trial / 16) - 2*floor(trial / 32))*1.8
alter VB4 = $&drive
let drive = (floor(trial / 32) - 2*floor(trial / 64))*1.8
alter VB5 = $&drive
let drive = (floor(trial / 64) - 2*floor(trial / 128))*1.8
alter VB6 = $&drive
let drive = (floor(trial / 128) - 2*floor(trial / 256))*1.8
alter VB7 = $&drive
stop when time = 0.002444
resume
delete all
let endpoint = length(time)-1
let cmp = v(COMP)[endpoint]
let top = v(TOP)[endpoint]
let decision = 0
if cmp >= 0.9
let code = trial
let decision = 1
end
echo 135 2 $&trial $&cmp $&top 0.62109375 $&decision >> decisions.csv
let trial = code + 2
let drive = (floor(trial / 1) - 2*floor(trial / 2))*1.8
alter VB0 = $&drive
let drive = (floor(trial / 2) - 2*floor(trial / 4))*1.8
alter VB1 = $&drive
let drive = (floor(trial / 4) - 2*floor(trial / 8))*1.8
alter VB2 = $&drive
let drive = (floor(trial / 8) - 2*floor(trial / 16))*1.8
alter VB3 = $&drive
let drive = (floor(trial / 16) - 2*floor(trial / 32))*1.8
alter VB4 = $&drive
let drive = (floor(trial / 32) - 2*floor(trial / 64))*1.8
alter VB5 = $&drive
let drive = (floor(trial / 64) - 2*floor(trial / 128))*1.8
alter VB6 = $&drive
let drive = (floor(trial / 128) - 2*floor(trial / 256))*1.8
alter VB7 = $&drive
stop when time = 0.002446
resume
delete all
let endpoint = length(time)-1
let cmp = v(COMP)[endpoint]
let top = v(TOP)[endpoint]
let decision = 0
if cmp >= 0.9
let code = trial
let decision = 1
end
echo 135 1 $&trial $&cmp $&top 0.62109375 $&decision >> decisions.csv
let trial = code + 1
let drive = (floor(trial / 1) - 2*floor(trial / 2))*1.8
alter VB0 = $&drive
let drive = (floor(trial / 2) - 2*floor(trial / 4))*1.8
alter VB1 = $&drive
let drive = (floor(trial / 4) - 2*floor(trial / 8))*1.8
alter VB2 = $&drive
let drive = (floor(trial / 8) - 2*floor(trial / 16))*1.8
alter VB3 = $&drive
let drive = (floor(trial / 16) - 2*floor(trial / 32))*1.8
alter VB4 = $&drive
let drive = (floor(trial / 32) - 2*floor(trial / 64))*1.8
alter VB5 = $&drive
let drive = (floor(trial / 64) - 2*floor(trial / 128))*1.8
alter VB6 = $&drive
let drive = (floor(trial / 128) - 2*floor(trial / 256))*1.8
alter VB7 = $&drive
stop when time = 0.002448
resume
delete all
let endpoint = length(time)-1
let cmp = v(COMP)[endpoint]
let top = v(TOP)[endpoint]
let decision = 0
if cmp >= 0.9
let code = trial
let decision = 1
end
echo 135 0 $&trial $&cmp $&top 0.62109375 $&decision >> decisions.csv
alter VIN = 0.62578125
alter VSAMPLE = 1.8
alter VB0 = 0
alter VB1 = 0
alter VB2 = 0
alter VB3 = 0
alter VB4 = 0
alter VB5 = 0
alter VB6 = 0
alter VB7 = 0
let code = 0
stop when time = 0.00245
resume
delete all
alter VSAMPLE = 0
let trial = code + 128
let drive = (floor(trial / 1) - 2*floor(trial / 2))*1.8
alter VB0 = $&drive
let drive = (floor(trial / 2) - 2*floor(trial / 4))*1.8
alter VB1 = $&drive
let drive = (floor(trial / 4) - 2*floor(trial / 8))*1.8
alter VB2 = $&drive
let drive = (floor(trial / 8) - 2*floor(trial / 16))*1.8
alter VB3 = $&drive
let drive = (floor(trial / 16) - 2*floor(trial / 32))*1.8
alter VB4 = $&drive
let drive = (floor(trial / 32) - 2*floor(trial / 64))*1.8
alter VB5 = $&drive
let drive = (floor(trial / 64) - 2*floor(trial / 128))*1.8
alter VB6 = $&drive
let drive = (floor(trial / 128) - 2*floor(trial / 256))*1.8
alter VB7 = $&drive
stop when time = 0.002452
resume
delete all
let endpoint = length(time)-1
let cmp = v(COMP)[endpoint]
let top = v(TOP)[endpoint]
let decision = 0
if cmp >= 0.9
let code = trial
let decision = 1
end
echo 136 7 $&trial $&cmp $&top 0.62578125 $&decision >> decisions.csv
let trial = code + 64
let drive = (floor(trial / 1) - 2*floor(trial / 2))*1.8
alter VB0 = $&drive
let drive = (floor(trial / 2) - 2*floor(trial / 4))*1.8
alter VB1 = $&drive
let drive = (floor(trial / 4) - 2*floor(trial / 8))*1.8
alter VB2 = $&drive
let drive = (floor(trial / 8) - 2*floor(trial / 16))*1.8
alter VB3 = $&drive
let drive = (floor(trial / 16) - 2*floor(trial / 32))*1.8
alter VB4 = $&drive
let drive = (floor(trial / 32) - 2*floor(trial / 64))*1.8
alter VB5 = $&drive
let drive = (floor(trial / 64) - 2*floor(trial / 128))*1.8
alter VB6 = $&drive
let drive = (floor(trial / 128) - 2*floor(trial / 256))*1.8
alter VB7 = $&drive
stop when time = 0.002454
resume
delete all
let endpoint = length(time)-1
let cmp = v(COMP)[endpoint]
let top = v(TOP)[endpoint]
let decision = 0
if cmp >= 0.9
let code = trial
let decision = 1
end
echo 136 6 $&trial $&cmp $&top 0.62578125 $&decision >> decisions.csv
let trial = code + 32
let drive = (floor(trial / 1) - 2*floor(trial / 2))*1.8
alter VB0 = $&drive
let drive = (floor(trial / 2) - 2*floor(trial / 4))*1.8
alter VB1 = $&drive
let drive = (floor(trial / 4) - 2*floor(trial / 8))*1.8
alter VB2 = $&drive
let drive = (floor(trial / 8) - 2*floor(trial / 16))*1.8
alter VB3 = $&drive
let drive = (floor(trial / 16) - 2*floor(trial / 32))*1.8
alter VB4 = $&drive
let drive = (floor(trial / 32) - 2*floor(trial / 64))*1.8
alter VB5 = $&drive
let drive = (floor(trial / 64) - 2*floor(trial / 128))*1.8
alter VB6 = $&drive
let drive = (floor(trial / 128) - 2*floor(trial / 256))*1.8
alter VB7 = $&drive
stop when time = 0.002456
resume
delete all
let endpoint = length(time)-1
let cmp = v(COMP)[endpoint]
let top = v(TOP)[endpoint]
let decision = 0
if cmp >= 0.9
let code = trial
let decision = 1
end
echo 136 5 $&trial $&cmp $&top 0.62578125 $&decision >> decisions.csv
let trial = code + 16
let drive = (floor(trial / 1) - 2*floor(trial / 2))*1.8
alter VB0 = $&drive
let drive = (floor(trial / 2) - 2*floor(trial / 4))*1.8
alter VB1 = $&drive
let drive = (floor(trial / 4) - 2*floor(trial / 8))*1.8
alter VB2 = $&drive
let drive = (floor(trial / 8) - 2*floor(trial / 16))*1.8
alter VB3 = $&drive
let drive = (floor(trial / 16) - 2*floor(trial / 32))*1.8
alter VB4 = $&drive
let drive = (floor(trial / 32) - 2*floor(trial / 64))*1.8
alter VB5 = $&drive
let drive = (floor(trial / 64) - 2*floor(trial / 128))*1.8
alter VB6 = $&drive
let drive = (floor(trial / 128) - 2*floor(trial / 256))*1.8
alter VB7 = $&drive
stop when time = 0.002458
resume
delete all
let endpoint = length(time)-1
let cmp = v(COMP)[endpoint]
let top = v(TOP)[endpoint]
let decision = 0
if cmp >= 0.9
let code = trial
let decision = 1
end
echo 136 4 $&trial $&cmp $&top 0.62578125 $&decision >> decisions.csv
let trial = code + 8
let drive = (floor(trial / 1) - 2*floor(trial / 2))*1.8
alter VB0 = $&drive
let drive = (floor(trial / 2) - 2*floor(trial / 4))*1.8
alter VB1 = $&drive
let drive = (floor(trial / 4) - 2*floor(trial / 8))*1.8
alter VB2 = $&drive
let drive = (floor(trial / 8) - 2*floor(trial / 16))*1.8
alter VB3 = $&drive
let drive = (floor(trial / 16) - 2*floor(trial / 32))*1.8
alter VB4 = $&drive
let drive = (floor(trial / 32) - 2*floor(trial / 64))*1.8
alter VB5 = $&drive
let drive = (floor(trial / 64) - 2*floor(trial / 128))*1.8
alter VB6 = $&drive
let drive = (floor(trial / 128) - 2*floor(trial / 256))*1.8
alter VB7 = $&drive
stop when time = 0.00246
resume
delete all
let endpoint = length(time)-1
let cmp = v(COMP)[endpoint]
let top = v(TOP)[endpoint]
let decision = 0
if cmp >= 0.9
let code = trial
let decision = 1
end
echo 136 3 $&trial $&cmp $&top 0.62578125 $&decision >> decisions.csv
let trial = code + 4
let drive = (floor(trial / 1) - 2*floor(trial / 2))*1.8
alter VB0 = $&drive
let drive = (floor(trial / 2) - 2*floor(trial / 4))*1.8
alter VB1 = $&drive
let drive = (floor(trial / 4) - 2*floor(trial / 8))*1.8
alter VB2 = $&drive
let drive = (floor(trial / 8) - 2*floor(trial / 16))*1.8
alter VB3 = $&drive
let drive = (floor(trial / 16) - 2*floor(trial / 32))*1.8
alter VB4 = $&drive
let drive = (floor(trial / 32) - 2*floor(trial / 64))*1.8
alter VB5 = $&drive
let drive = (floor(trial / 64) - 2*floor(trial / 128))*1.8
alter VB6 = $&drive
let drive = (floor(trial / 128) - 2*floor(trial / 256))*1.8
alter VB7 = $&drive
stop when time = 0.002462
resume
delete all
let endpoint = length(time)-1
let cmp = v(COMP)[endpoint]
let top = v(TOP)[endpoint]
let decision = 0
if cmp >= 0.9
let code = trial
let decision = 1
end
echo 136 2 $&trial $&cmp $&top 0.62578125 $&decision >> decisions.csv
let trial = code + 2
let drive = (floor(trial / 1) - 2*floor(trial / 2))*1.8
alter VB0 = $&drive
let drive = (floor(trial / 2) - 2*floor(trial / 4))*1.8
alter VB1 = $&drive
let drive = (floor(trial / 4) - 2*floor(trial / 8))*1.8
alter VB2 = $&drive
let drive = (floor(trial / 8) - 2*floor(trial / 16))*1.8
alter VB3 = $&drive
let drive = (floor(trial / 16) - 2*floor(trial / 32))*1.8
alter VB4 = $&drive
let drive = (floor(trial / 32) - 2*floor(trial / 64))*1.8
alter VB5 = $&drive
let drive = (floor(trial / 64) - 2*floor(trial / 128))*1.8
alter VB6 = $&drive
let drive = (floor(trial / 128) - 2*floor(trial / 256))*1.8
alter VB7 = $&drive
stop when time = 0.002464
resume
delete all
let endpoint = length(time)-1
let cmp = v(COMP)[endpoint]
let top = v(TOP)[endpoint]
let decision = 0
if cmp >= 0.9
let code = trial
let decision = 1
end
echo 136 1 $&trial $&cmp $&top 0.62578125 $&decision >> decisions.csv
let trial = code + 1
let drive = (floor(trial / 1) - 2*floor(trial / 2))*1.8
alter VB0 = $&drive
let drive = (floor(trial / 2) - 2*floor(trial / 4))*1.8
alter VB1 = $&drive
let drive = (floor(trial / 4) - 2*floor(trial / 8))*1.8
alter VB2 = $&drive
let drive = (floor(trial / 8) - 2*floor(trial / 16))*1.8
alter VB3 = $&drive
let drive = (floor(trial / 16) - 2*floor(trial / 32))*1.8
alter VB4 = $&drive
let drive = (floor(trial / 32) - 2*floor(trial / 64))*1.8
alter VB5 = $&drive
let drive = (floor(trial / 64) - 2*floor(trial / 128))*1.8
alter VB6 = $&drive
let drive = (floor(trial / 128) - 2*floor(trial / 256))*1.8
alter VB7 = $&drive
stop when time = 0.002466
resume
delete all
let endpoint = length(time)-1
let cmp = v(COMP)[endpoint]
let top = v(TOP)[endpoint]
let decision = 0
if cmp >= 0.9
let code = trial
let decision = 1
end
echo 136 0 $&trial $&cmp $&top 0.62578125 $&decision >> decisions.csv
alter VIN = 0.63046875
alter VSAMPLE = 1.8
alter VB0 = 0
alter VB1 = 0
alter VB2 = 0
alter VB3 = 0
alter VB4 = 0
alter VB5 = 0
alter VB6 = 0
alter VB7 = 0
let code = 0
stop when time = 0.002468
resume
delete all
alter VSAMPLE = 0
let trial = code + 128
let drive = (floor(trial / 1) - 2*floor(trial / 2))*1.8
alter VB0 = $&drive
let drive = (floor(trial / 2) - 2*floor(trial / 4))*1.8
alter VB1 = $&drive
let drive = (floor(trial / 4) - 2*floor(trial / 8))*1.8
alter VB2 = $&drive
let drive = (floor(trial / 8) - 2*floor(trial / 16))*1.8
alter VB3 = $&drive
let drive = (floor(trial / 16) - 2*floor(trial / 32))*1.8
alter VB4 = $&drive
let drive = (floor(trial / 32) - 2*floor(trial / 64))*1.8
alter VB5 = $&drive
let drive = (floor(trial / 64) - 2*floor(trial / 128))*1.8
alter VB6 = $&drive
let drive = (floor(trial / 128) - 2*floor(trial / 256))*1.8
alter VB7 = $&drive
stop when time = 0.00247
resume
delete all
let endpoint = length(time)-1
let cmp = v(COMP)[endpoint]
let top = v(TOP)[endpoint]
let decision = 0
if cmp >= 0.9
let code = trial
let decision = 1
end
echo 137 7 $&trial $&cmp $&top 0.63046875 $&decision >> decisions.csv
let trial = code + 64
let drive = (floor(trial / 1) - 2*floor(trial / 2))*1.8
alter VB0 = $&drive
let drive = (floor(trial / 2) - 2*floor(trial / 4))*1.8
alter VB1 = $&drive
let drive = (floor(trial / 4) - 2*floor(trial / 8))*1.8
alter VB2 = $&drive
let drive = (floor(trial / 8) - 2*floor(trial / 16))*1.8
alter VB3 = $&drive
let drive = (floor(trial / 16) - 2*floor(trial / 32))*1.8
alter VB4 = $&drive
let drive = (floor(trial / 32) - 2*floor(trial / 64))*1.8
alter VB5 = $&drive
let drive = (floor(trial / 64) - 2*floor(trial / 128))*1.8
alter VB6 = $&drive
let drive = (floor(trial / 128) - 2*floor(trial / 256))*1.8
alter VB7 = $&drive
stop when time = 0.002472
resume
delete all
let endpoint = length(time)-1
let cmp = v(COMP)[endpoint]
let top = v(TOP)[endpoint]
let decision = 0
if cmp >= 0.9
let code = trial
let decision = 1
end
echo 137 6 $&trial $&cmp $&top 0.63046875 $&decision >> decisions.csv
let trial = code + 32
let drive = (floor(trial / 1) - 2*floor(trial / 2))*1.8
alter VB0 = $&drive
let drive = (floor(trial / 2) - 2*floor(trial / 4))*1.8
alter VB1 = $&drive
let drive = (floor(trial / 4) - 2*floor(trial / 8))*1.8
alter VB2 = $&drive
let drive = (floor(trial / 8) - 2*floor(trial / 16))*1.8
alter VB3 = $&drive
let drive = (floor(trial / 16) - 2*floor(trial / 32))*1.8
alter VB4 = $&drive
let drive = (floor(trial / 32) - 2*floor(trial / 64))*1.8
alter VB5 = $&drive
let drive = (floor(trial / 64) - 2*floor(trial / 128))*1.8
alter VB6 = $&drive
let drive = (floor(trial / 128) - 2*floor(trial / 256))*1.8
alter VB7 = $&drive
stop when time = 0.002474
resume
delete all
let endpoint = length(time)-1
let cmp = v(COMP)[endpoint]
let top = v(TOP)[endpoint]
let decision = 0
if cmp >= 0.9
let code = trial
let decision = 1
end
echo 137 5 $&trial $&cmp $&top 0.63046875 $&decision >> decisions.csv
let trial = code + 16
let drive = (floor(trial / 1) - 2*floor(trial / 2))*1.8
alter VB0 = $&drive
let drive = (floor(trial / 2) - 2*floor(trial / 4))*1.8
alter VB1 = $&drive
let drive = (floor(trial / 4) - 2*floor(trial / 8))*1.8
alter VB2 = $&drive
let drive = (floor(trial / 8) - 2*floor(trial / 16))*1.8
alter VB3 = $&drive
let drive = (floor(trial / 16) - 2*floor(trial / 32))*1.8
alter VB4 = $&drive
let drive = (floor(trial / 32) - 2*floor(trial / 64))*1.8
alter VB5 = $&drive
let drive = (floor(trial / 64) - 2*floor(trial / 128))*1.8
alter VB6 = $&drive
let drive = (floor(trial / 128) - 2*floor(trial / 256))*1.8
alter VB7 = $&drive
stop when time = 0.002476
resume
delete all
let endpoint = length(time)-1
let cmp = v(COMP)[endpoint]
let top = v(TOP)[endpoint]
let decision = 0
if cmp >= 0.9
let code = trial
let decision = 1
end
echo 137 4 $&trial $&cmp $&top 0.63046875 $&decision >> decisions.csv
let trial = code + 8
let drive = (floor(trial / 1) - 2*floor(trial / 2))*1.8
alter VB0 = $&drive
let drive = (floor(trial / 2) - 2*floor(trial / 4))*1.8
alter VB1 = $&drive
let drive = (floor(trial / 4) - 2*floor(trial / 8))*1.8
alter VB2 = $&drive
let drive = (floor(trial / 8) - 2*floor(trial / 16))*1.8
alter VB3 = $&drive
let drive = (floor(trial / 16) - 2*floor(trial / 32))*1.8
alter VB4 = $&drive
let drive = (floor(trial / 32) - 2*floor(trial / 64))*1.8
alter VB5 = $&drive
let drive = (floor(trial / 64) - 2*floor(trial / 128))*1.8
alter VB6 = $&drive
let drive = (floor(trial / 128) - 2*floor(trial / 256))*1.8
alter VB7 = $&drive
stop when time = 0.002478
resume
delete all
let endpoint = length(time)-1
let cmp = v(COMP)[endpoint]
let top = v(TOP)[endpoint]
let decision = 0
if cmp >= 0.9
let code = trial
let decision = 1
end
echo 137 3 $&trial $&cmp $&top 0.63046875 $&decision >> decisions.csv
let trial = code + 4
let drive = (floor(trial / 1) - 2*floor(trial / 2))*1.8
alter VB0 = $&drive
let drive = (floor(trial / 2) - 2*floor(trial / 4))*1.8
alter VB1 = $&drive
let drive = (floor(trial / 4) - 2*floor(trial / 8))*1.8
alter VB2 = $&drive
let drive = (floor(trial / 8) - 2*floor(trial / 16))*1.8
alter VB3 = $&drive
let drive = (floor(trial / 16) - 2*floor(trial / 32))*1.8
alter VB4 = $&drive
let drive = (floor(trial / 32) - 2*floor(trial / 64))*1.8
alter VB5 = $&drive
let drive = (floor(trial / 64) - 2*floor(trial / 128))*1.8
alter VB6 = $&drive
let drive = (floor(trial / 128) - 2*floor(trial / 256))*1.8
alter VB7 = $&drive
stop when time = 0.00248
resume
delete all
let endpoint = length(time)-1
let cmp = v(COMP)[endpoint]
let top = v(TOP)[endpoint]
let decision = 0
if cmp >= 0.9
let code = trial
let decision = 1
end
echo 137 2 $&trial $&cmp $&top 0.63046875 $&decision >> decisions.csv
let trial = code + 2
let drive = (floor(trial / 1) - 2*floor(trial / 2))*1.8
alter VB0 = $&drive
let drive = (floor(trial / 2) - 2*floor(trial / 4))*1.8
alter VB1 = $&drive
let drive = (floor(trial / 4) - 2*floor(trial / 8))*1.8
alter VB2 = $&drive
let drive = (floor(trial / 8) - 2*floor(trial / 16))*1.8
alter VB3 = $&drive
let drive = (floor(trial / 16) - 2*floor(trial / 32))*1.8
alter VB4 = $&drive
let drive = (floor(trial / 32) - 2*floor(trial / 64))*1.8
alter VB5 = $&drive
let drive = (floor(trial / 64) - 2*floor(trial / 128))*1.8
alter VB6 = $&drive
let drive = (floor(trial / 128) - 2*floor(trial / 256))*1.8
alter VB7 = $&drive
stop when time = 0.002482
resume
delete all
let endpoint = length(time)-1
let cmp = v(COMP)[endpoint]
let top = v(TOP)[endpoint]
let decision = 0
if cmp >= 0.9
let code = trial
let decision = 1
end
echo 137 1 $&trial $&cmp $&top 0.63046875 $&decision >> decisions.csv
let trial = code + 1
let drive = (floor(trial / 1) - 2*floor(trial / 2))*1.8
alter VB0 = $&drive
let drive = (floor(trial / 2) - 2*floor(trial / 4))*1.8
alter VB1 = $&drive
let drive = (floor(trial / 4) - 2*floor(trial / 8))*1.8
alter VB2 = $&drive
let drive = (floor(trial / 8) - 2*floor(trial / 16))*1.8
alter VB3 = $&drive
let drive = (floor(trial / 16) - 2*floor(trial / 32))*1.8
alter VB4 = $&drive
let drive = (floor(trial / 32) - 2*floor(trial / 64))*1.8
alter VB5 = $&drive
let drive = (floor(trial / 64) - 2*floor(trial / 128))*1.8
alter VB6 = $&drive
let drive = (floor(trial / 128) - 2*floor(trial / 256))*1.8
alter VB7 = $&drive
stop when time = 0.002484
resume
delete all
let endpoint = length(time)-1
let cmp = v(COMP)[endpoint]
let top = v(TOP)[endpoint]
let decision = 0
if cmp >= 0.9
let code = trial
let decision = 1
end
echo 137 0 $&trial $&cmp $&top 0.63046875 $&decision >> decisions.csv
alter VIN = 0.63515625
alter VSAMPLE = 1.8
alter VB0 = 0
alter VB1 = 0
alter VB2 = 0
alter VB3 = 0
alter VB4 = 0
alter VB5 = 0
alter VB6 = 0
alter VB7 = 0
let code = 0
stop when time = 0.002486
resume
delete all
alter VSAMPLE = 0
let trial = code + 128
let drive = (floor(trial / 1) - 2*floor(trial / 2))*1.8
alter VB0 = $&drive
let drive = (floor(trial / 2) - 2*floor(trial / 4))*1.8
alter VB1 = $&drive
let drive = (floor(trial / 4) - 2*floor(trial / 8))*1.8
alter VB2 = $&drive
let drive = (floor(trial / 8) - 2*floor(trial / 16))*1.8
alter VB3 = $&drive
let drive = (floor(trial / 16) - 2*floor(trial / 32))*1.8
alter VB4 = $&drive
let drive = (floor(trial / 32) - 2*floor(trial / 64))*1.8
alter VB5 = $&drive
let drive = (floor(trial / 64) - 2*floor(trial / 128))*1.8
alter VB6 = $&drive
let drive = (floor(trial / 128) - 2*floor(trial / 256))*1.8
alter VB7 = $&drive
stop when time = 0.002488
resume
delete all
let endpoint = length(time)-1
let cmp = v(COMP)[endpoint]
let top = v(TOP)[endpoint]
let decision = 0
if cmp >= 0.9
let code = trial
let decision = 1
end
echo 138 7 $&trial $&cmp $&top 0.63515625 $&decision >> decisions.csv
let trial = code + 64
let drive = (floor(trial / 1) - 2*floor(trial / 2))*1.8
alter VB0 = $&drive
let drive = (floor(trial / 2) - 2*floor(trial / 4))*1.8
alter VB1 = $&drive
let drive = (floor(trial / 4) - 2*floor(trial / 8))*1.8
alter VB2 = $&drive
let drive = (floor(trial / 8) - 2*floor(trial / 16))*1.8
alter VB3 = $&drive
let drive = (floor(trial / 16) - 2*floor(trial / 32))*1.8
alter VB4 = $&drive
let drive = (floor(trial / 32) - 2*floor(trial / 64))*1.8
alter VB5 = $&drive
let drive = (floor(trial / 64) - 2*floor(trial / 128))*1.8
alter VB6 = $&drive
let drive = (floor(trial / 128) - 2*floor(trial / 256))*1.8
alter VB7 = $&drive
stop when time = 0.00249
resume
delete all
let endpoint = length(time)-1
let cmp = v(COMP)[endpoint]
let top = v(TOP)[endpoint]
let decision = 0
if cmp >= 0.9
let code = trial
let decision = 1
end
echo 138 6 $&trial $&cmp $&top 0.63515625 $&decision >> decisions.csv
let trial = code + 32
let drive = (floor(trial / 1) - 2*floor(trial / 2))*1.8
alter VB0 = $&drive
let drive = (floor(trial / 2) - 2*floor(trial / 4))*1.8
alter VB1 = $&drive
let drive = (floor(trial / 4) - 2*floor(trial / 8))*1.8
alter VB2 = $&drive
let drive = (floor(trial / 8) - 2*floor(trial / 16))*1.8
alter VB3 = $&drive
let drive = (floor(trial / 16) - 2*floor(trial / 32))*1.8
alter VB4 = $&drive
let drive = (floor(trial / 32) - 2*floor(trial / 64))*1.8
alter VB5 = $&drive
let drive = (floor(trial / 64) - 2*floor(trial / 128))*1.8
alter VB6 = $&drive
let drive = (floor(trial / 128) - 2*floor(trial / 256))*1.8
alter VB7 = $&drive
stop when time = 0.002492
resume
delete all
let endpoint = length(time)-1
let cmp = v(COMP)[endpoint]
let top = v(TOP)[endpoint]
let decision = 0
if cmp >= 0.9
let code = trial
let decision = 1
end
echo 138 5 $&trial $&cmp $&top 0.63515625 $&decision >> decisions.csv
let trial = code + 16
let drive = (floor(trial / 1) - 2*floor(trial / 2))*1.8
alter VB0 = $&drive
let drive = (floor(trial / 2) - 2*floor(trial / 4))*1.8
alter VB1 = $&drive
let drive = (floor(trial / 4) - 2*floor(trial / 8))*1.8
alter VB2 = $&drive
let drive = (floor(trial / 8) - 2*floor(trial / 16))*1.8
alter VB3 = $&drive
let drive = (floor(trial / 16) - 2*floor(trial / 32))*1.8
alter VB4 = $&drive
let drive = (floor(trial / 32) - 2*floor(trial / 64))*1.8
alter VB5 = $&drive
let drive = (floor(trial / 64) - 2*floor(trial / 128))*1.8
alter VB6 = $&drive
let drive = (floor(trial / 128) - 2*floor(trial / 256))*1.8
alter VB7 = $&drive
stop when time = 0.002494
resume
delete all
let endpoint = length(time)-1
let cmp = v(COMP)[endpoint]
let top = v(TOP)[endpoint]
let decision = 0
if cmp >= 0.9
let code = trial
let decision = 1
end
echo 138 4 $&trial $&cmp $&top 0.63515625 $&decision >> decisions.csv
let trial = code + 8
let drive = (floor(trial / 1) - 2*floor(trial / 2))*1.8
alter VB0 = $&drive
let drive = (floor(trial / 2) - 2*floor(trial / 4))*1.8
alter VB1 = $&drive
let drive = (floor(trial / 4) - 2*floor(trial / 8))*1.8
alter VB2 = $&drive
let drive = (floor(trial / 8) - 2*floor(trial / 16))*1.8
alter VB3 = $&drive
let drive = (floor(trial / 16) - 2*floor(trial / 32))*1.8
alter VB4 = $&drive
let drive = (floor(trial / 32) - 2*floor(trial / 64))*1.8
alter VB5 = $&drive
let drive = (floor(trial / 64) - 2*floor(trial / 128))*1.8
alter VB6 = $&drive
let drive = (floor(trial / 128) - 2*floor(trial / 256))*1.8
alter VB7 = $&drive
stop when time = 0.002496
resume
delete all
let endpoint = length(time)-1
let cmp = v(COMP)[endpoint]
let top = v(TOP)[endpoint]
let decision = 0
if cmp >= 0.9
let code = trial
let decision = 1
end
echo 138 3 $&trial $&cmp $&top 0.63515625 $&decision >> decisions.csv
let trial = code + 4
let drive = (floor(trial / 1) - 2*floor(trial / 2))*1.8
alter VB0 = $&drive
let drive = (floor(trial / 2) - 2*floor(trial / 4))*1.8
alter VB1 = $&drive
let drive = (floor(trial / 4) - 2*floor(trial / 8))*1.8
alter VB2 = $&drive
let drive = (floor(trial / 8) - 2*floor(trial / 16))*1.8
alter VB3 = $&drive
let drive = (floor(trial / 16) - 2*floor(trial / 32))*1.8
alter VB4 = $&drive
let drive = (floor(trial / 32) - 2*floor(trial / 64))*1.8
alter VB5 = $&drive
let drive = (floor(trial / 64) - 2*floor(trial / 128))*1.8
alter VB6 = $&drive
let drive = (floor(trial / 128) - 2*floor(trial / 256))*1.8
alter VB7 = $&drive
stop when time = 0.002498
resume
delete all
let endpoint = length(time)-1
let cmp = v(COMP)[endpoint]
let top = v(TOP)[endpoint]
let decision = 0
if cmp >= 0.9
let code = trial
let decision = 1
end
echo 138 2 $&trial $&cmp $&top 0.63515625 $&decision >> decisions.csv
let trial = code + 2
let drive = (floor(trial / 1) - 2*floor(trial / 2))*1.8
alter VB0 = $&drive
let drive = (floor(trial / 2) - 2*floor(trial / 4))*1.8
alter VB1 = $&drive
let drive = (floor(trial / 4) - 2*floor(trial / 8))*1.8
alter VB2 = $&drive
let drive = (floor(trial / 8) - 2*floor(trial / 16))*1.8
alter VB3 = $&drive
let drive = (floor(trial / 16) - 2*floor(trial / 32))*1.8
alter VB4 = $&drive
let drive = (floor(trial / 32) - 2*floor(trial / 64))*1.8
alter VB5 = $&drive
let drive = (floor(trial / 64) - 2*floor(trial / 128))*1.8
alter VB6 = $&drive
let drive = (floor(trial / 128) - 2*floor(trial / 256))*1.8
alter VB7 = $&drive
stop when time = 0.0025
resume
delete all
let endpoint = length(time)-1
let cmp = v(COMP)[endpoint]
let top = v(TOP)[endpoint]
let decision = 0
if cmp >= 0.9
let code = trial
let decision = 1
end
echo 138 1 $&trial $&cmp $&top 0.63515625 $&decision >> decisions.csv
let trial = code + 1
let drive = (floor(trial / 1) - 2*floor(trial / 2))*1.8
alter VB0 = $&drive
let drive = (floor(trial / 2) - 2*floor(trial / 4))*1.8
alter VB1 = $&drive
let drive = (floor(trial / 4) - 2*floor(trial / 8))*1.8
alter VB2 = $&drive
let drive = (floor(trial / 8) - 2*floor(trial / 16))*1.8
alter VB3 = $&drive
let drive = (floor(trial / 16) - 2*floor(trial / 32))*1.8
alter VB4 = $&drive
let drive = (floor(trial / 32) - 2*floor(trial / 64))*1.8
alter VB5 = $&drive
let drive = (floor(trial / 64) - 2*floor(trial / 128))*1.8
alter VB6 = $&drive
let drive = (floor(trial / 128) - 2*floor(trial / 256))*1.8
alter VB7 = $&drive
stop when time = 0.002502
resume
delete all
let endpoint = length(time)-1
let cmp = v(COMP)[endpoint]
let top = v(TOP)[endpoint]
let decision = 0
if cmp >= 0.9
let code = trial
let decision = 1
end
echo 138 0 $&trial $&cmp $&top 0.63515625 $&decision >> decisions.csv
alter VIN = 0.63984375
alter VSAMPLE = 1.8
alter VB0 = 0
alter VB1 = 0
alter VB2 = 0
alter VB3 = 0
alter VB4 = 0
alter VB5 = 0
alter VB6 = 0
alter VB7 = 0
let code = 0
stop when time = 0.002504
resume
delete all
alter VSAMPLE = 0
let trial = code + 128
let drive = (floor(trial / 1) - 2*floor(trial / 2))*1.8
alter VB0 = $&drive
let drive = (floor(trial / 2) - 2*floor(trial / 4))*1.8
alter VB1 = $&drive
let drive = (floor(trial / 4) - 2*floor(trial / 8))*1.8
alter VB2 = $&drive
let drive = (floor(trial / 8) - 2*floor(trial / 16))*1.8
alter VB3 = $&drive
let drive = (floor(trial / 16) - 2*floor(trial / 32))*1.8
alter VB4 = $&drive
let drive = (floor(trial / 32) - 2*floor(trial / 64))*1.8
alter VB5 = $&drive
let drive = (floor(trial / 64) - 2*floor(trial / 128))*1.8
alter VB6 = $&drive
let drive = (floor(trial / 128) - 2*floor(trial / 256))*1.8
alter VB7 = $&drive
stop when time = 0.002506
resume
delete all
let endpoint = length(time)-1
let cmp = v(COMP)[endpoint]
let top = v(TOP)[endpoint]
let decision = 0
if cmp >= 0.9
let code = trial
let decision = 1
end
echo 139 7 $&trial $&cmp $&top 0.63984375 $&decision >> decisions.csv
let trial = code + 64
let drive = (floor(trial / 1) - 2*floor(trial / 2))*1.8
alter VB0 = $&drive
let drive = (floor(trial / 2) - 2*floor(trial / 4))*1.8
alter VB1 = $&drive
let drive = (floor(trial / 4) - 2*floor(trial / 8))*1.8
alter VB2 = $&drive
let drive = (floor(trial / 8) - 2*floor(trial / 16))*1.8
alter VB3 = $&drive
let drive = (floor(trial / 16) - 2*floor(trial / 32))*1.8
alter VB4 = $&drive
let drive = (floor(trial / 32) - 2*floor(trial / 64))*1.8
alter VB5 = $&drive
let drive = (floor(trial / 64) - 2*floor(trial / 128))*1.8
alter VB6 = $&drive
let drive = (floor(trial / 128) - 2*floor(trial / 256))*1.8
alter VB7 = $&drive
stop when time = 0.002508
resume
delete all
let endpoint = length(time)-1
let cmp = v(COMP)[endpoint]
let top = v(TOP)[endpoint]
let decision = 0
if cmp >= 0.9
let code = trial
let decision = 1
end
echo 139 6 $&trial $&cmp $&top 0.63984375 $&decision >> decisions.csv
let trial = code + 32
let drive = (floor(trial / 1) - 2*floor(trial / 2))*1.8
alter VB0 = $&drive
let drive = (floor(trial / 2) - 2*floor(trial / 4))*1.8
alter VB1 = $&drive
let drive = (floor(trial / 4) - 2*floor(trial / 8))*1.8
alter VB2 = $&drive
let drive = (floor(trial / 8) - 2*floor(trial / 16))*1.8
alter VB3 = $&drive
let drive = (floor(trial / 16) - 2*floor(trial / 32))*1.8
alter VB4 = $&drive
let drive = (floor(trial / 32) - 2*floor(trial / 64))*1.8
alter VB5 = $&drive
let drive = (floor(trial / 64) - 2*floor(trial / 128))*1.8
alter VB6 = $&drive
let drive = (floor(trial / 128) - 2*floor(trial / 256))*1.8
alter VB7 = $&drive
stop when time = 0.00251
resume
delete all
let endpoint = length(time)-1
let cmp = v(COMP)[endpoint]
let top = v(TOP)[endpoint]
let decision = 0
if cmp >= 0.9
let code = trial
let decision = 1
end
echo 139 5 $&trial $&cmp $&top 0.63984375 $&decision >> decisions.csv
let trial = code + 16
let drive = (floor(trial / 1) - 2*floor(trial / 2))*1.8
alter VB0 = $&drive
let drive = (floor(trial / 2) - 2*floor(trial / 4))*1.8
alter VB1 = $&drive
let drive = (floor(trial / 4) - 2*floor(trial / 8))*1.8
alter VB2 = $&drive
let drive = (floor(trial / 8) - 2*floor(trial / 16))*1.8
alter VB3 = $&drive
let drive = (floor(trial / 16) - 2*floor(trial / 32))*1.8
alter VB4 = $&drive
let drive = (floor(trial / 32) - 2*floor(trial / 64))*1.8
alter VB5 = $&drive
let drive = (floor(trial / 64) - 2*floor(trial / 128))*1.8
alter VB6 = $&drive
let drive = (floor(trial / 128) - 2*floor(trial / 256))*1.8
alter VB7 = $&drive
stop when time = 0.002512
resume
delete all
let endpoint = length(time)-1
let cmp = v(COMP)[endpoint]
let top = v(TOP)[endpoint]
let decision = 0
if cmp >= 0.9
let code = trial
let decision = 1
end
echo 139 4 $&trial $&cmp $&top 0.63984375 $&decision >> decisions.csv
let trial = code + 8
let drive = (floor(trial / 1) - 2*floor(trial / 2))*1.8
alter VB0 = $&drive
let drive = (floor(trial / 2) - 2*floor(trial / 4))*1.8
alter VB1 = $&drive
let drive = (floor(trial / 4) - 2*floor(trial / 8))*1.8
alter VB2 = $&drive
let drive = (floor(trial / 8) - 2*floor(trial / 16))*1.8
alter VB3 = $&drive
let drive = (floor(trial / 16) - 2*floor(trial / 32))*1.8
alter VB4 = $&drive
let drive = (floor(trial / 32) - 2*floor(trial / 64))*1.8
alter VB5 = $&drive
let drive = (floor(trial / 64) - 2*floor(trial / 128))*1.8
alter VB6 = $&drive
let drive = (floor(trial / 128) - 2*floor(trial / 256))*1.8
alter VB7 = $&drive
stop when time = 0.002514
resume
delete all
let endpoint = length(time)-1
let cmp = v(COMP)[endpoint]
let top = v(TOP)[endpoint]
let decision = 0
if cmp >= 0.9
let code = trial
let decision = 1
end
echo 139 3 $&trial $&cmp $&top 0.63984375 $&decision >> decisions.csv
let trial = code + 4
let drive = (floor(trial / 1) - 2*floor(trial / 2))*1.8
alter VB0 = $&drive
let drive = (floor(trial / 2) - 2*floor(trial / 4))*1.8
alter VB1 = $&drive
let drive = (floor(trial / 4) - 2*floor(trial / 8))*1.8
alter VB2 = $&drive
let drive = (floor(trial / 8) - 2*floor(trial / 16))*1.8
alter VB3 = $&drive
let drive = (floor(trial / 16) - 2*floor(trial / 32))*1.8
alter VB4 = $&drive
let drive = (floor(trial / 32) - 2*floor(trial / 64))*1.8
alter VB5 = $&drive
let drive = (floor(trial / 64) - 2*floor(trial / 128))*1.8
alter VB6 = $&drive
let drive = (floor(trial / 128) - 2*floor(trial / 256))*1.8
alter VB7 = $&drive
stop when time = 0.002516
resume
delete all
let endpoint = length(time)-1
let cmp = v(COMP)[endpoint]
let top = v(TOP)[endpoint]
let decision = 0
if cmp >= 0.9
let code = trial
let decision = 1
end
echo 139 2 $&trial $&cmp $&top 0.63984375 $&decision >> decisions.csv
let trial = code + 2
let drive = (floor(trial / 1) - 2*floor(trial / 2))*1.8
alter VB0 = $&drive
let drive = (floor(trial / 2) - 2*floor(trial / 4))*1.8
alter VB1 = $&drive
let drive = (floor(trial / 4) - 2*floor(trial / 8))*1.8
alter VB2 = $&drive
let drive = (floor(trial / 8) - 2*floor(trial / 16))*1.8
alter VB3 = $&drive
let drive = (floor(trial / 16) - 2*floor(trial / 32))*1.8
alter VB4 = $&drive
let drive = (floor(trial / 32) - 2*floor(trial / 64))*1.8
alter VB5 = $&drive
let drive = (floor(trial / 64) - 2*floor(trial / 128))*1.8
alter VB6 = $&drive
let drive = (floor(trial / 128) - 2*floor(trial / 256))*1.8
alter VB7 = $&drive
stop when time = 0.002518
resume
delete all
let endpoint = length(time)-1
let cmp = v(COMP)[endpoint]
let top = v(TOP)[endpoint]
let decision = 0
if cmp >= 0.9
let code = trial
let decision = 1
end
echo 139 1 $&trial $&cmp $&top 0.63984375 $&decision >> decisions.csv
let trial = code + 1
let drive = (floor(trial / 1) - 2*floor(trial / 2))*1.8
alter VB0 = $&drive
let drive = (floor(trial / 2) - 2*floor(trial / 4))*1.8
alter VB1 = $&drive
let drive = (floor(trial / 4) - 2*floor(trial / 8))*1.8
alter VB2 = $&drive
let drive = (floor(trial / 8) - 2*floor(trial / 16))*1.8
alter VB3 = $&drive
let drive = (floor(trial / 16) - 2*floor(trial / 32))*1.8
alter VB4 = $&drive
let drive = (floor(trial / 32) - 2*floor(trial / 64))*1.8
alter VB5 = $&drive
let drive = (floor(trial / 64) - 2*floor(trial / 128))*1.8
alter VB6 = $&drive
let drive = (floor(trial / 128) - 2*floor(trial / 256))*1.8
alter VB7 = $&drive
stop when time = 0.00252
resume
delete all
let endpoint = length(time)-1
let cmp = v(COMP)[endpoint]
let top = v(TOP)[endpoint]
let decision = 0
if cmp >= 0.9
let code = trial
let decision = 1
end
echo 139 0 $&trial $&cmp $&top 0.63984375 $&decision >> decisions.csv
alter VIN = 0.64453125
alter VSAMPLE = 1.8
alter VB0 = 0
alter VB1 = 0
alter VB2 = 0
alter VB3 = 0
alter VB4 = 0
alter VB5 = 0
alter VB6 = 0
alter VB7 = 0
let code = 0
stop when time = 0.002522
resume
delete all
alter VSAMPLE = 0
let trial = code + 128
let drive = (floor(trial / 1) - 2*floor(trial / 2))*1.8
alter VB0 = $&drive
let drive = (floor(trial / 2) - 2*floor(trial / 4))*1.8
alter VB1 = $&drive
let drive = (floor(trial / 4) - 2*floor(trial / 8))*1.8
alter VB2 = $&drive
let drive = (floor(trial / 8) - 2*floor(trial / 16))*1.8
alter VB3 = $&drive
let drive = (floor(trial / 16) - 2*floor(trial / 32))*1.8
alter VB4 = $&drive
let drive = (floor(trial / 32) - 2*floor(trial / 64))*1.8
alter VB5 = $&drive
let drive = (floor(trial / 64) - 2*floor(trial / 128))*1.8
alter VB6 = $&drive
let drive = (floor(trial / 128) - 2*floor(trial / 256))*1.8
alter VB7 = $&drive
stop when time = 0.002524
resume
delete all
let endpoint = length(time)-1
let cmp = v(COMP)[endpoint]
let top = v(TOP)[endpoint]
let decision = 0
if cmp >= 0.9
let code = trial
let decision = 1
end
echo 140 7 $&trial $&cmp $&top 0.64453125 $&decision >> decisions.csv
let trial = code + 64
let drive = (floor(trial / 1) - 2*floor(trial / 2))*1.8
alter VB0 = $&drive
let drive = (floor(trial / 2) - 2*floor(trial / 4))*1.8
alter VB1 = $&drive
let drive = (floor(trial / 4) - 2*floor(trial / 8))*1.8
alter VB2 = $&drive
let drive = (floor(trial / 8) - 2*floor(trial / 16))*1.8
alter VB3 = $&drive
let drive = (floor(trial / 16) - 2*floor(trial / 32))*1.8
alter VB4 = $&drive
let drive = (floor(trial / 32) - 2*floor(trial / 64))*1.8
alter VB5 = $&drive
let drive = (floor(trial / 64) - 2*floor(trial / 128))*1.8
alter VB6 = $&drive
let drive = (floor(trial / 128) - 2*floor(trial / 256))*1.8
alter VB7 = $&drive
stop when time = 0.002526
resume
delete all
let endpoint = length(time)-1
let cmp = v(COMP)[endpoint]
let top = v(TOP)[endpoint]
let decision = 0
if cmp >= 0.9
let code = trial
let decision = 1
end
echo 140 6 $&trial $&cmp $&top 0.64453125 $&decision >> decisions.csv
let trial = code + 32
let drive = (floor(trial / 1) - 2*floor(trial / 2))*1.8
alter VB0 = $&drive
let drive = (floor(trial / 2) - 2*floor(trial / 4))*1.8
alter VB1 = $&drive
let drive = (floor(trial / 4) - 2*floor(trial / 8))*1.8
alter VB2 = $&drive
let drive = (floor(trial / 8) - 2*floor(trial / 16))*1.8
alter VB3 = $&drive
let drive = (floor(trial / 16) - 2*floor(trial / 32))*1.8
alter VB4 = $&drive
let drive = (floor(trial / 32) - 2*floor(trial / 64))*1.8
alter VB5 = $&drive
let drive = (floor(trial / 64) - 2*floor(trial / 128))*1.8
alter VB6 = $&drive
let drive = (floor(trial / 128) - 2*floor(trial / 256))*1.8
alter VB7 = $&drive
stop when time = 0.002528
resume
delete all
let endpoint = length(time)-1
let cmp = v(COMP)[endpoint]
let top = v(TOP)[endpoint]
let decision = 0
if cmp >= 0.9
let code = trial
let decision = 1
end
echo 140 5 $&trial $&cmp $&top 0.64453125 $&decision >> decisions.csv
let trial = code + 16
let drive = (floor(trial / 1) - 2*floor(trial / 2))*1.8
alter VB0 = $&drive
let drive = (floor(trial / 2) - 2*floor(trial / 4))*1.8
alter VB1 = $&drive
let drive = (floor(trial / 4) - 2*floor(trial / 8))*1.8
alter VB2 = $&drive
let drive = (floor(trial / 8) - 2*floor(trial / 16))*1.8
alter VB3 = $&drive
let drive = (floor(trial / 16) - 2*floor(trial / 32))*1.8
alter VB4 = $&drive
let drive = (floor(trial / 32) - 2*floor(trial / 64))*1.8
alter VB5 = $&drive
let drive = (floor(trial / 64) - 2*floor(trial / 128))*1.8
alter VB6 = $&drive
let drive = (floor(trial / 128) - 2*floor(trial / 256))*1.8
alter VB7 = $&drive
stop when time = 0.00253
resume
delete all
let endpoint = length(time)-1
let cmp = v(COMP)[endpoint]
let top = v(TOP)[endpoint]
let decision = 0
if cmp >= 0.9
let code = trial
let decision = 1
end
echo 140 4 $&trial $&cmp $&top 0.64453125 $&decision >> decisions.csv
let trial = code + 8
let drive = (floor(trial / 1) - 2*floor(trial / 2))*1.8
alter VB0 = $&drive
let drive = (floor(trial / 2) - 2*floor(trial / 4))*1.8
alter VB1 = $&drive
let drive = (floor(trial / 4) - 2*floor(trial / 8))*1.8
alter VB2 = $&drive
let drive = (floor(trial / 8) - 2*floor(trial / 16))*1.8
alter VB3 = $&drive
let drive = (floor(trial / 16) - 2*floor(trial / 32))*1.8
alter VB4 = $&drive
let drive = (floor(trial / 32) - 2*floor(trial / 64))*1.8
alter VB5 = $&drive
let drive = (floor(trial / 64) - 2*floor(trial / 128))*1.8
alter VB6 = $&drive
let drive = (floor(trial / 128) - 2*floor(trial / 256))*1.8
alter VB7 = $&drive
stop when time = 0.002532
resume
delete all
let endpoint = length(time)-1
let cmp = v(COMP)[endpoint]
let top = v(TOP)[endpoint]
let decision = 0
if cmp >= 0.9
let code = trial
let decision = 1
end
echo 140 3 $&trial $&cmp $&top 0.64453125 $&decision >> decisions.csv
let trial = code + 4
let drive = (floor(trial / 1) - 2*floor(trial / 2))*1.8
alter VB0 = $&drive
let drive = (floor(trial / 2) - 2*floor(trial / 4))*1.8
alter VB1 = $&drive
let drive = (floor(trial / 4) - 2*floor(trial / 8))*1.8
alter VB2 = $&drive
let drive = (floor(trial / 8) - 2*floor(trial / 16))*1.8
alter VB3 = $&drive
let drive = (floor(trial / 16) - 2*floor(trial / 32))*1.8
alter VB4 = $&drive
let drive = (floor(trial / 32) - 2*floor(trial / 64))*1.8
alter VB5 = $&drive
let drive = (floor(trial / 64) - 2*floor(trial / 128))*1.8
alter VB6 = $&drive
let drive = (floor(trial / 128) - 2*floor(trial / 256))*1.8
alter VB7 = $&drive
stop when time = 0.002534
resume
delete all
let endpoint = length(time)-1
let cmp = v(COMP)[endpoint]
let top = v(TOP)[endpoint]
let decision = 0
if cmp >= 0.9
let code = trial
let decision = 1
end
echo 140 2 $&trial $&cmp $&top 0.64453125 $&decision >> decisions.csv
let trial = code + 2
let drive = (floor(trial / 1) - 2*floor(trial / 2))*1.8
alter VB0 = $&drive
let drive = (floor(trial / 2) - 2*floor(trial / 4))*1.8
alter VB1 = $&drive
let drive = (floor(trial / 4) - 2*floor(trial / 8))*1.8
alter VB2 = $&drive
let drive = (floor(trial / 8) - 2*floor(trial / 16))*1.8
alter VB3 = $&drive
let drive = (floor(trial / 16) - 2*floor(trial / 32))*1.8
alter VB4 = $&drive
let drive = (floor(trial / 32) - 2*floor(trial / 64))*1.8
alter VB5 = $&drive
let drive = (floor(trial / 64) - 2*floor(trial / 128))*1.8
alter VB6 = $&drive
let drive = (floor(trial / 128) - 2*floor(trial / 256))*1.8
alter VB7 = $&drive
stop when time = 0.002536
resume
delete all
let endpoint = length(time)-1
let cmp = v(COMP)[endpoint]
let top = v(TOP)[endpoint]
let decision = 0
if cmp >= 0.9
let code = trial
let decision = 1
end
echo 140 1 $&trial $&cmp $&top 0.64453125 $&decision >> decisions.csv
let trial = code + 1
let drive = (floor(trial / 1) - 2*floor(trial / 2))*1.8
alter VB0 = $&drive
let drive = (floor(trial / 2) - 2*floor(trial / 4))*1.8
alter VB1 = $&drive
let drive = (floor(trial / 4) - 2*floor(trial / 8))*1.8
alter VB2 = $&drive
let drive = (floor(trial / 8) - 2*floor(trial / 16))*1.8
alter VB3 = $&drive
let drive = (floor(trial / 16) - 2*floor(trial / 32))*1.8
alter VB4 = $&drive
let drive = (floor(trial / 32) - 2*floor(trial / 64))*1.8
alter VB5 = $&drive
let drive = (floor(trial / 64) - 2*floor(trial / 128))*1.8
alter VB6 = $&drive
let drive = (floor(trial / 128) - 2*floor(trial / 256))*1.8
alter VB7 = $&drive
stop when time = 0.002538
resume
delete all
let endpoint = length(time)-1
let cmp = v(COMP)[endpoint]
let top = v(TOP)[endpoint]
let decision = 0
if cmp >= 0.9
let code = trial
let decision = 1
end
echo 140 0 $&trial $&cmp $&top 0.64453125 $&decision >> decisions.csv
alter VIN = 0.64921875
alter VSAMPLE = 1.8
alter VB0 = 0
alter VB1 = 0
alter VB2 = 0
alter VB3 = 0
alter VB4 = 0
alter VB5 = 0
alter VB6 = 0
alter VB7 = 0
let code = 0
stop when time = 0.00254
resume
delete all
alter VSAMPLE = 0
let trial = code + 128
let drive = (floor(trial / 1) - 2*floor(trial / 2))*1.8
alter VB0 = $&drive
let drive = (floor(trial / 2) - 2*floor(trial / 4))*1.8
alter VB1 = $&drive
let drive = (floor(trial / 4) - 2*floor(trial / 8))*1.8
alter VB2 = $&drive
let drive = (floor(trial / 8) - 2*floor(trial / 16))*1.8
alter VB3 = $&drive
let drive = (floor(trial / 16) - 2*floor(trial / 32))*1.8
alter VB4 = $&drive
let drive = (floor(trial / 32) - 2*floor(trial / 64))*1.8
alter VB5 = $&drive
let drive = (floor(trial / 64) - 2*floor(trial / 128))*1.8
alter VB6 = $&drive
let drive = (floor(trial / 128) - 2*floor(trial / 256))*1.8
alter VB7 = $&drive
stop when time = 0.002542
resume
delete all
let endpoint = length(time)-1
let cmp = v(COMP)[endpoint]
let top = v(TOP)[endpoint]
let decision = 0
if cmp >= 0.9
let code = trial
let decision = 1
end
echo 141 7 $&trial $&cmp $&top 0.64921875 $&decision >> decisions.csv
let trial = code + 64
let drive = (floor(trial / 1) - 2*floor(trial / 2))*1.8
alter VB0 = $&drive
let drive = (floor(trial / 2) - 2*floor(trial / 4))*1.8
alter VB1 = $&drive
let drive = (floor(trial / 4) - 2*floor(trial / 8))*1.8
alter VB2 = $&drive
let drive = (floor(trial / 8) - 2*floor(trial / 16))*1.8
alter VB3 = $&drive
let drive = (floor(trial / 16) - 2*floor(trial / 32))*1.8
alter VB4 = $&drive
let drive = (floor(trial / 32) - 2*floor(trial / 64))*1.8
alter VB5 = $&drive
let drive = (floor(trial / 64) - 2*floor(trial / 128))*1.8
alter VB6 = $&drive
let drive = (floor(trial / 128) - 2*floor(trial / 256))*1.8
alter VB7 = $&drive
stop when time = 0.002544
resume
delete all
let endpoint = length(time)-1
let cmp = v(COMP)[endpoint]
let top = v(TOP)[endpoint]
let decision = 0
if cmp >= 0.9
let code = trial
let decision = 1
end
echo 141 6 $&trial $&cmp $&top 0.64921875 $&decision >> decisions.csv
let trial = code + 32
let drive = (floor(trial / 1) - 2*floor(trial / 2))*1.8
alter VB0 = $&drive
let drive = (floor(trial / 2) - 2*floor(trial / 4))*1.8
alter VB1 = $&drive
let drive = (floor(trial / 4) - 2*floor(trial / 8))*1.8
alter VB2 = $&drive
let drive = (floor(trial / 8) - 2*floor(trial / 16))*1.8
alter VB3 = $&drive
let drive = (floor(trial / 16) - 2*floor(trial / 32))*1.8
alter VB4 = $&drive
let drive = (floor(trial / 32) - 2*floor(trial / 64))*1.8
alter VB5 = $&drive
let drive = (floor(trial / 64) - 2*floor(trial / 128))*1.8
alter VB6 = $&drive
let drive = (floor(trial / 128) - 2*floor(trial / 256))*1.8
alter VB7 = $&drive
stop when time = 0.002546
resume
delete all
let endpoint = length(time)-1
let cmp = v(COMP)[endpoint]
let top = v(TOP)[endpoint]
let decision = 0
if cmp >= 0.9
let code = trial
let decision = 1
end
echo 141 5 $&trial $&cmp $&top 0.64921875 $&decision >> decisions.csv
let trial = code + 16
let drive = (floor(trial / 1) - 2*floor(trial / 2))*1.8
alter VB0 = $&drive
let drive = (floor(trial / 2) - 2*floor(trial / 4))*1.8
alter VB1 = $&drive
let drive = (floor(trial / 4) - 2*floor(trial / 8))*1.8
alter VB2 = $&drive
let drive = (floor(trial / 8) - 2*floor(trial / 16))*1.8
alter VB3 = $&drive
let drive = (floor(trial / 16) - 2*floor(trial / 32))*1.8
alter VB4 = $&drive
let drive = (floor(trial / 32) - 2*floor(trial / 64))*1.8
alter VB5 = $&drive
let drive = (floor(trial / 64) - 2*floor(trial / 128))*1.8
alter VB6 = $&drive
let drive = (floor(trial / 128) - 2*floor(trial / 256))*1.8
alter VB7 = $&drive
stop when time = 0.002548
resume
delete all
let endpoint = length(time)-1
let cmp = v(COMP)[endpoint]
let top = v(TOP)[endpoint]
let decision = 0
if cmp >= 0.9
let code = trial
let decision = 1
end
echo 141 4 $&trial $&cmp $&top 0.64921875 $&decision >> decisions.csv
let trial = code + 8
let drive = (floor(trial / 1) - 2*floor(trial / 2))*1.8
alter VB0 = $&drive
let drive = (floor(trial / 2) - 2*floor(trial / 4))*1.8
alter VB1 = $&drive
let drive = (floor(trial / 4) - 2*floor(trial / 8))*1.8
alter VB2 = $&drive
let drive = (floor(trial / 8) - 2*floor(trial / 16))*1.8
alter VB3 = $&drive
let drive = (floor(trial / 16) - 2*floor(trial / 32))*1.8
alter VB4 = $&drive
let drive = (floor(trial / 32) - 2*floor(trial / 64))*1.8
alter VB5 = $&drive
let drive = (floor(trial / 64) - 2*floor(trial / 128))*1.8
alter VB6 = $&drive
let drive = (floor(trial / 128) - 2*floor(trial / 256))*1.8
alter VB7 = $&drive
stop when time = 0.00255
resume
delete all
let endpoint = length(time)-1
let cmp = v(COMP)[endpoint]
let top = v(TOP)[endpoint]
let decision = 0
if cmp >= 0.9
let code = trial
let decision = 1
end
echo 141 3 $&trial $&cmp $&top 0.64921875 $&decision >> decisions.csv
let trial = code + 4
let drive = (floor(trial / 1) - 2*floor(trial / 2))*1.8
alter VB0 = $&drive
let drive = (floor(trial / 2) - 2*floor(trial / 4))*1.8
alter VB1 = $&drive
let drive = (floor(trial / 4) - 2*floor(trial / 8))*1.8
alter VB2 = $&drive
let drive = (floor(trial / 8) - 2*floor(trial / 16))*1.8
alter VB3 = $&drive
let drive = (floor(trial / 16) - 2*floor(trial / 32))*1.8
alter VB4 = $&drive
let drive = (floor(trial / 32) - 2*floor(trial / 64))*1.8
alter VB5 = $&drive
let drive = (floor(trial / 64) - 2*floor(trial / 128))*1.8
alter VB6 = $&drive
let drive = (floor(trial / 128) - 2*floor(trial / 256))*1.8
alter VB7 = $&drive
stop when time = 0.002552
resume
delete all
let endpoint = length(time)-1
let cmp = v(COMP)[endpoint]
let top = v(TOP)[endpoint]
let decision = 0
if cmp >= 0.9
let code = trial
let decision = 1
end
echo 141 2 $&trial $&cmp $&top 0.64921875 $&decision >> decisions.csv
let trial = code + 2
let drive = (floor(trial / 1) - 2*floor(trial / 2))*1.8
alter VB0 = $&drive
let drive = (floor(trial / 2) - 2*floor(trial / 4))*1.8
alter VB1 = $&drive
let drive = (floor(trial / 4) - 2*floor(trial / 8))*1.8
alter VB2 = $&drive
let drive = (floor(trial / 8) - 2*floor(trial / 16))*1.8
alter VB3 = $&drive
let drive = (floor(trial / 16) - 2*floor(trial / 32))*1.8
alter VB4 = $&drive
let drive = (floor(trial / 32) - 2*floor(trial / 64))*1.8
alter VB5 = $&drive
let drive = (floor(trial / 64) - 2*floor(trial / 128))*1.8
alter VB6 = $&drive
let drive = (floor(trial / 128) - 2*floor(trial / 256))*1.8
alter VB7 = $&drive
stop when time = 0.002554
resume
delete all
let endpoint = length(time)-1
let cmp = v(COMP)[endpoint]
let top = v(TOP)[endpoint]
let decision = 0
if cmp >= 0.9
let code = trial
let decision = 1
end
echo 141 1 $&trial $&cmp $&top 0.64921875 $&decision >> decisions.csv
let trial = code + 1
let drive = (floor(trial / 1) - 2*floor(trial / 2))*1.8
alter VB0 = $&drive
let drive = (floor(trial / 2) - 2*floor(trial / 4))*1.8
alter VB1 = $&drive
let drive = (floor(trial / 4) - 2*floor(trial / 8))*1.8
alter VB2 = $&drive
let drive = (floor(trial / 8) - 2*floor(trial / 16))*1.8
alter VB3 = $&drive
let drive = (floor(trial / 16) - 2*floor(trial / 32))*1.8
alter VB4 = $&drive
let drive = (floor(trial / 32) - 2*floor(trial / 64))*1.8
alter VB5 = $&drive
let drive = (floor(trial / 64) - 2*floor(trial / 128))*1.8
alter VB6 = $&drive
let drive = (floor(trial / 128) - 2*floor(trial / 256))*1.8
alter VB7 = $&drive
stop when time = 0.002556
resume
delete all
let endpoint = length(time)-1
let cmp = v(COMP)[endpoint]
let top = v(TOP)[endpoint]
let decision = 0
if cmp >= 0.9
let code = trial
let decision = 1
end
echo 141 0 $&trial $&cmp $&top 0.64921875 $&decision >> decisions.csv
alter VIN = 0.65390625
alter VSAMPLE = 1.8
alter VB0 = 0
alter VB1 = 0
alter VB2 = 0
alter VB3 = 0
alter VB4 = 0
alter VB5 = 0
alter VB6 = 0
alter VB7 = 0
let code = 0
stop when time = 0.002558
resume
delete all
alter VSAMPLE = 0
let trial = code + 128
let drive = (floor(trial / 1) - 2*floor(trial / 2))*1.8
alter VB0 = $&drive
let drive = (floor(trial / 2) - 2*floor(trial / 4))*1.8
alter VB1 = $&drive
let drive = (floor(trial / 4) - 2*floor(trial / 8))*1.8
alter VB2 = $&drive
let drive = (floor(trial / 8) - 2*floor(trial / 16))*1.8
alter VB3 = $&drive
let drive = (floor(trial / 16) - 2*floor(trial / 32))*1.8
alter VB4 = $&drive
let drive = (floor(trial / 32) - 2*floor(trial / 64))*1.8
alter VB5 = $&drive
let drive = (floor(trial / 64) - 2*floor(trial / 128))*1.8
alter VB6 = $&drive
let drive = (floor(trial / 128) - 2*floor(trial / 256))*1.8
alter VB7 = $&drive
stop when time = 0.00256
resume
delete all
let endpoint = length(time)-1
let cmp = v(COMP)[endpoint]
let top = v(TOP)[endpoint]
let decision = 0
if cmp >= 0.9
let code = trial
let decision = 1
end
echo 142 7 $&trial $&cmp $&top 0.65390625 $&decision >> decisions.csv
let trial = code + 64
let drive = (floor(trial / 1) - 2*floor(trial / 2))*1.8
alter VB0 = $&drive
let drive = (floor(trial / 2) - 2*floor(trial / 4))*1.8
alter VB1 = $&drive
let drive = (floor(trial / 4) - 2*floor(trial / 8))*1.8
alter VB2 = $&drive
let drive = (floor(trial / 8) - 2*floor(trial / 16))*1.8
alter VB3 = $&drive
let drive = (floor(trial / 16) - 2*floor(trial / 32))*1.8
alter VB4 = $&drive
let drive = (floor(trial / 32) - 2*floor(trial / 64))*1.8
alter VB5 = $&drive
let drive = (floor(trial / 64) - 2*floor(trial / 128))*1.8
alter VB6 = $&drive
let drive = (floor(trial / 128) - 2*floor(trial / 256))*1.8
alter VB7 = $&drive
stop when time = 0.002562
resume
delete all
let endpoint = length(time)-1
let cmp = v(COMP)[endpoint]
let top = v(TOP)[endpoint]
let decision = 0
if cmp >= 0.9
let code = trial
let decision = 1
end
echo 142 6 $&trial $&cmp $&top 0.65390625 $&decision >> decisions.csv
let trial = code + 32
let drive = (floor(trial / 1) - 2*floor(trial / 2))*1.8
alter VB0 = $&drive
let drive = (floor(trial / 2) - 2*floor(trial / 4))*1.8
alter VB1 = $&drive
let drive = (floor(trial / 4) - 2*floor(trial / 8))*1.8
alter VB2 = $&drive
let drive = (floor(trial / 8) - 2*floor(trial / 16))*1.8
alter VB3 = $&drive
let drive = (floor(trial / 16) - 2*floor(trial / 32))*1.8
alter VB4 = $&drive
let drive = (floor(trial / 32) - 2*floor(trial / 64))*1.8
alter VB5 = $&drive
let drive = (floor(trial / 64) - 2*floor(trial / 128))*1.8
alter VB6 = $&drive
let drive = (floor(trial / 128) - 2*floor(trial / 256))*1.8
alter VB7 = $&drive
stop when time = 0.002564
resume
delete all
let endpoint = length(time)-1
let cmp = v(COMP)[endpoint]
let top = v(TOP)[endpoint]
let decision = 0
if cmp >= 0.9
let code = trial
let decision = 1
end
echo 142 5 $&trial $&cmp $&top 0.65390625 $&decision >> decisions.csv
let trial = code + 16
let drive = (floor(trial / 1) - 2*floor(trial / 2))*1.8
alter VB0 = $&drive
let drive = (floor(trial / 2) - 2*floor(trial / 4))*1.8
alter VB1 = $&drive
let drive = (floor(trial / 4) - 2*floor(trial / 8))*1.8
alter VB2 = $&drive
let drive = (floor(trial / 8) - 2*floor(trial / 16))*1.8
alter VB3 = $&drive
let drive = (floor(trial / 16) - 2*floor(trial / 32))*1.8
alter VB4 = $&drive
let drive = (floor(trial / 32) - 2*floor(trial / 64))*1.8
alter VB5 = $&drive
let drive = (floor(trial / 64) - 2*floor(trial / 128))*1.8
alter VB6 = $&drive
let drive = (floor(trial / 128) - 2*floor(trial / 256))*1.8
alter VB7 = $&drive
stop when time = 0.002566
resume
delete all
let endpoint = length(time)-1
let cmp = v(COMP)[endpoint]
let top = v(TOP)[endpoint]
let decision = 0
if cmp >= 0.9
let code = trial
let decision = 1
end
echo 142 4 $&trial $&cmp $&top 0.65390625 $&decision >> decisions.csv
let trial = code + 8
let drive = (floor(trial / 1) - 2*floor(trial / 2))*1.8
alter VB0 = $&drive
let drive = (floor(trial / 2) - 2*floor(trial / 4))*1.8
alter VB1 = $&drive
let drive = (floor(trial / 4) - 2*floor(trial / 8))*1.8
alter VB2 = $&drive
let drive = (floor(trial / 8) - 2*floor(trial / 16))*1.8
alter VB3 = $&drive
let drive = (floor(trial / 16) - 2*floor(trial / 32))*1.8
alter VB4 = $&drive
let drive = (floor(trial / 32) - 2*floor(trial / 64))*1.8
alter VB5 = $&drive
let drive = (floor(trial / 64) - 2*floor(trial / 128))*1.8
alter VB6 = $&drive
let drive = (floor(trial / 128) - 2*floor(trial / 256))*1.8
alter VB7 = $&drive
stop when time = 0.002568
resume
delete all
let endpoint = length(time)-1
let cmp = v(COMP)[endpoint]
let top = v(TOP)[endpoint]
let decision = 0
if cmp >= 0.9
let code = trial
let decision = 1
end
echo 142 3 $&trial $&cmp $&top 0.65390625 $&decision >> decisions.csv
let trial = code + 4
let drive = (floor(trial / 1) - 2*floor(trial / 2))*1.8
alter VB0 = $&drive
let drive = (floor(trial / 2) - 2*floor(trial / 4))*1.8
alter VB1 = $&drive
let drive = (floor(trial / 4) - 2*floor(trial / 8))*1.8
alter VB2 = $&drive
let drive = (floor(trial / 8) - 2*floor(trial / 16))*1.8
alter VB3 = $&drive
let drive = (floor(trial / 16) - 2*floor(trial / 32))*1.8
alter VB4 = $&drive
let drive = (floor(trial / 32) - 2*floor(trial / 64))*1.8
alter VB5 = $&drive
let drive = (floor(trial / 64) - 2*floor(trial / 128))*1.8
alter VB6 = $&drive
let drive = (floor(trial / 128) - 2*floor(trial / 256))*1.8
alter VB7 = $&drive
stop when time = 0.00257
resume
delete all
let endpoint = length(time)-1
let cmp = v(COMP)[endpoint]
let top = v(TOP)[endpoint]
let decision = 0
if cmp >= 0.9
let code = trial
let decision = 1
end
echo 142 2 $&trial $&cmp $&top 0.65390625 $&decision >> decisions.csv
let trial = code + 2
let drive = (floor(trial / 1) - 2*floor(trial / 2))*1.8
alter VB0 = $&drive
let drive = (floor(trial / 2) - 2*floor(trial / 4))*1.8
alter VB1 = $&drive
let drive = (floor(trial / 4) - 2*floor(trial / 8))*1.8
alter VB2 = $&drive
let drive = (floor(trial / 8) - 2*floor(trial / 16))*1.8
alter VB3 = $&drive
let drive = (floor(trial / 16) - 2*floor(trial / 32))*1.8
alter VB4 = $&drive
let drive = (floor(trial / 32) - 2*floor(trial / 64))*1.8
alter VB5 = $&drive
let drive = (floor(trial / 64) - 2*floor(trial / 128))*1.8
alter VB6 = $&drive
let drive = (floor(trial / 128) - 2*floor(trial / 256))*1.8
alter VB7 = $&drive
stop when time = 0.002572
resume
delete all
let endpoint = length(time)-1
let cmp = v(COMP)[endpoint]
let top = v(TOP)[endpoint]
let decision = 0
if cmp >= 0.9
let code = trial
let decision = 1
end
echo 142 1 $&trial $&cmp $&top 0.65390625 $&decision >> decisions.csv
let trial = code + 1
let drive = (floor(trial / 1) - 2*floor(trial / 2))*1.8
alter VB0 = $&drive
let drive = (floor(trial / 2) - 2*floor(trial / 4))*1.8
alter VB1 = $&drive
let drive = (floor(trial / 4) - 2*floor(trial / 8))*1.8
alter VB2 = $&drive
let drive = (floor(trial / 8) - 2*floor(trial / 16))*1.8
alter VB3 = $&drive
let drive = (floor(trial / 16) - 2*floor(trial / 32))*1.8
alter VB4 = $&drive
let drive = (floor(trial / 32) - 2*floor(trial / 64))*1.8
alter VB5 = $&drive
let drive = (floor(trial / 64) - 2*floor(trial / 128))*1.8
alter VB6 = $&drive
let drive = (floor(trial / 128) - 2*floor(trial / 256))*1.8
alter VB7 = $&drive
stop when time = 0.002574
resume
delete all
let endpoint = length(time)-1
let cmp = v(COMP)[endpoint]
let top = v(TOP)[endpoint]
let decision = 0
if cmp >= 0.9
let code = trial
let decision = 1
end
echo 142 0 $&trial $&cmp $&top 0.65390625 $&decision >> decisions.csv
alter VIN = 0.65859375
alter VSAMPLE = 1.8
alter VB0 = 0
alter VB1 = 0
alter VB2 = 0
alter VB3 = 0
alter VB4 = 0
alter VB5 = 0
alter VB6 = 0
alter VB7 = 0
let code = 0
stop when time = 0.002576
resume
delete all
alter VSAMPLE = 0
let trial = code + 128
let drive = (floor(trial / 1) - 2*floor(trial / 2))*1.8
alter VB0 = $&drive
let drive = (floor(trial / 2) - 2*floor(trial / 4))*1.8
alter VB1 = $&drive
let drive = (floor(trial / 4) - 2*floor(trial / 8))*1.8
alter VB2 = $&drive
let drive = (floor(trial / 8) - 2*floor(trial / 16))*1.8
alter VB3 = $&drive
let drive = (floor(trial / 16) - 2*floor(trial / 32))*1.8
alter VB4 = $&drive
let drive = (floor(trial / 32) - 2*floor(trial / 64))*1.8
alter VB5 = $&drive
let drive = (floor(trial / 64) - 2*floor(trial / 128))*1.8
alter VB6 = $&drive
let drive = (floor(trial / 128) - 2*floor(trial / 256))*1.8
alter VB7 = $&drive
stop when time = 0.002578
resume
delete all
let endpoint = length(time)-1
let cmp = v(COMP)[endpoint]
let top = v(TOP)[endpoint]
let decision = 0
if cmp >= 0.9
let code = trial
let decision = 1
end
echo 143 7 $&trial $&cmp $&top 0.65859375 $&decision >> decisions.csv
let trial = code + 64
let drive = (floor(trial / 1) - 2*floor(trial / 2))*1.8
alter VB0 = $&drive
let drive = (floor(trial / 2) - 2*floor(trial / 4))*1.8
alter VB1 = $&drive
let drive = (floor(trial / 4) - 2*floor(trial / 8))*1.8
alter VB2 = $&drive
let drive = (floor(trial / 8) - 2*floor(trial / 16))*1.8
alter VB3 = $&drive
let drive = (floor(trial / 16) - 2*floor(trial / 32))*1.8
alter VB4 = $&drive
let drive = (floor(trial / 32) - 2*floor(trial / 64))*1.8
alter VB5 = $&drive
let drive = (floor(trial / 64) - 2*floor(trial / 128))*1.8
alter VB6 = $&drive
let drive = (floor(trial / 128) - 2*floor(trial / 256))*1.8
alter VB7 = $&drive
stop when time = 0.00258
resume
delete all
let endpoint = length(time)-1
let cmp = v(COMP)[endpoint]
let top = v(TOP)[endpoint]
let decision = 0
if cmp >= 0.9
let code = trial
let decision = 1
end
echo 143 6 $&trial $&cmp $&top 0.65859375 $&decision >> decisions.csv
let trial = code + 32
let drive = (floor(trial / 1) - 2*floor(trial / 2))*1.8
alter VB0 = $&drive
let drive = (floor(trial / 2) - 2*floor(trial / 4))*1.8
alter VB1 = $&drive
let drive = (floor(trial / 4) - 2*floor(trial / 8))*1.8
alter VB2 = $&drive
let drive = (floor(trial / 8) - 2*floor(trial / 16))*1.8
alter VB3 = $&drive
let drive = (floor(trial / 16) - 2*floor(trial / 32))*1.8
alter VB4 = $&drive
let drive = (floor(trial / 32) - 2*floor(trial / 64))*1.8
alter VB5 = $&drive
let drive = (floor(trial / 64) - 2*floor(trial / 128))*1.8
alter VB6 = $&drive
let drive = (floor(trial / 128) - 2*floor(trial / 256))*1.8
alter VB7 = $&drive
stop when time = 0.002582
resume
delete all
let endpoint = length(time)-1
let cmp = v(COMP)[endpoint]
let top = v(TOP)[endpoint]
let decision = 0
if cmp >= 0.9
let code = trial
let decision = 1
end
echo 143 5 $&trial $&cmp $&top 0.65859375 $&decision >> decisions.csv
let trial = code + 16
let drive = (floor(trial / 1) - 2*floor(trial / 2))*1.8
alter VB0 = $&drive
let drive = (floor(trial / 2) - 2*floor(trial / 4))*1.8
alter VB1 = $&drive
let drive = (floor(trial / 4) - 2*floor(trial / 8))*1.8
alter VB2 = $&drive
let drive = (floor(trial / 8) - 2*floor(trial / 16))*1.8
alter VB3 = $&drive
let drive = (floor(trial / 16) - 2*floor(trial / 32))*1.8
alter VB4 = $&drive
let drive = (floor(trial / 32) - 2*floor(trial / 64))*1.8
alter VB5 = $&drive
let drive = (floor(trial / 64) - 2*floor(trial / 128))*1.8
alter VB6 = $&drive
let drive = (floor(trial / 128) - 2*floor(trial / 256))*1.8
alter VB7 = $&drive
stop when time = 0.002584
resume
delete all
let endpoint = length(time)-1
let cmp = v(COMP)[endpoint]
let top = v(TOP)[endpoint]
let decision = 0
if cmp >= 0.9
let code = trial
let decision = 1
end
echo 143 4 $&trial $&cmp $&top 0.65859375 $&decision >> decisions.csv
let trial = code + 8
let drive = (floor(trial / 1) - 2*floor(trial / 2))*1.8
alter VB0 = $&drive
let drive = (floor(trial / 2) - 2*floor(trial / 4))*1.8
alter VB1 = $&drive
let drive = (floor(trial / 4) - 2*floor(trial / 8))*1.8
alter VB2 = $&drive
let drive = (floor(trial / 8) - 2*floor(trial / 16))*1.8
alter VB3 = $&drive
let drive = (floor(trial / 16) - 2*floor(trial / 32))*1.8
alter VB4 = $&drive
let drive = (floor(trial / 32) - 2*floor(trial / 64))*1.8
alter VB5 = $&drive
let drive = (floor(trial / 64) - 2*floor(trial / 128))*1.8
alter VB6 = $&drive
let drive = (floor(trial / 128) - 2*floor(trial / 256))*1.8
alter VB7 = $&drive
stop when time = 0.002586
resume
delete all
let endpoint = length(time)-1
let cmp = v(COMP)[endpoint]
let top = v(TOP)[endpoint]
let decision = 0
if cmp >= 0.9
let code = trial
let decision = 1
end
echo 143 3 $&trial $&cmp $&top 0.65859375 $&decision >> decisions.csv
let trial = code + 4
let drive = (floor(trial / 1) - 2*floor(trial / 2))*1.8
alter VB0 = $&drive
let drive = (floor(trial / 2) - 2*floor(trial / 4))*1.8
alter VB1 = $&drive
let drive = (floor(trial / 4) - 2*floor(trial / 8))*1.8
alter VB2 = $&drive
let drive = (floor(trial / 8) - 2*floor(trial / 16))*1.8
alter VB3 = $&drive
let drive = (floor(trial / 16) - 2*floor(trial / 32))*1.8
alter VB4 = $&drive
let drive = (floor(trial / 32) - 2*floor(trial / 64))*1.8
alter VB5 = $&drive
let drive = (floor(trial / 64) - 2*floor(trial / 128))*1.8
alter VB6 = $&drive
let drive = (floor(trial / 128) - 2*floor(trial / 256))*1.8
alter VB7 = $&drive
stop when time = 0.002588
resume
delete all
let endpoint = length(time)-1
let cmp = v(COMP)[endpoint]
let top = v(TOP)[endpoint]
let decision = 0
if cmp >= 0.9
let code = trial
let decision = 1
end
echo 143 2 $&trial $&cmp $&top 0.65859375 $&decision >> decisions.csv
let trial = code + 2
let drive = (floor(trial / 1) - 2*floor(trial / 2))*1.8
alter VB0 = $&drive
let drive = (floor(trial / 2) - 2*floor(trial / 4))*1.8
alter VB1 = $&drive
let drive = (floor(trial / 4) - 2*floor(trial / 8))*1.8
alter VB2 = $&drive
let drive = (floor(trial / 8) - 2*floor(trial / 16))*1.8
alter VB3 = $&drive
let drive = (floor(trial / 16) - 2*floor(trial / 32))*1.8
alter VB4 = $&drive
let drive = (floor(trial / 32) - 2*floor(trial / 64))*1.8
alter VB5 = $&drive
let drive = (floor(trial / 64) - 2*floor(trial / 128))*1.8
alter VB6 = $&drive
let drive = (floor(trial / 128) - 2*floor(trial / 256))*1.8
alter VB7 = $&drive
stop when time = 0.00259
resume
delete all
let endpoint = length(time)-1
let cmp = v(COMP)[endpoint]
let top = v(TOP)[endpoint]
let decision = 0
if cmp >= 0.9
let code = trial
let decision = 1
end
echo 143 1 $&trial $&cmp $&top 0.65859375 $&decision >> decisions.csv
let trial = code + 1
let drive = (floor(trial / 1) - 2*floor(trial / 2))*1.8
alter VB0 = $&drive
let drive = (floor(trial / 2) - 2*floor(trial / 4))*1.8
alter VB1 = $&drive
let drive = (floor(trial / 4) - 2*floor(trial / 8))*1.8
alter VB2 = $&drive
let drive = (floor(trial / 8) - 2*floor(trial / 16))*1.8
alter VB3 = $&drive
let drive = (floor(trial / 16) - 2*floor(trial / 32))*1.8
alter VB4 = $&drive
let drive = (floor(trial / 32) - 2*floor(trial / 64))*1.8
alter VB5 = $&drive
let drive = (floor(trial / 64) - 2*floor(trial / 128))*1.8
alter VB6 = $&drive
let drive = (floor(trial / 128) - 2*floor(trial / 256))*1.8
alter VB7 = $&drive
stop when time = 0.002592
resume
delete all
let endpoint = length(time)-1
let cmp = v(COMP)[endpoint]
let top = v(TOP)[endpoint]
let decision = 0
if cmp >= 0.9
let code = trial
let decision = 1
end
echo 143 0 $&trial $&cmp $&top 0.65859375 $&decision >> decisions.csv
alter VIN = 0.66328125
alter VSAMPLE = 1.8
alter VB0 = 0
alter VB1 = 0
alter VB2 = 0
alter VB3 = 0
alter VB4 = 0
alter VB5 = 0
alter VB6 = 0
alter VB7 = 0
let code = 0
stop when time = 0.002594
resume
delete all
alter VSAMPLE = 0
let trial = code + 128
let drive = (floor(trial / 1) - 2*floor(trial / 2))*1.8
alter VB0 = $&drive
let drive = (floor(trial / 2) - 2*floor(trial / 4))*1.8
alter VB1 = $&drive
let drive = (floor(trial / 4) - 2*floor(trial / 8))*1.8
alter VB2 = $&drive
let drive = (floor(trial / 8) - 2*floor(trial / 16))*1.8
alter VB3 = $&drive
let drive = (floor(trial / 16) - 2*floor(trial / 32))*1.8
alter VB4 = $&drive
let drive = (floor(trial / 32) - 2*floor(trial / 64))*1.8
alter VB5 = $&drive
let drive = (floor(trial / 64) - 2*floor(trial / 128))*1.8
alter VB6 = $&drive
let drive = (floor(trial / 128) - 2*floor(trial / 256))*1.8
alter VB7 = $&drive
stop when time = 0.002596
resume
delete all
let endpoint = length(time)-1
let cmp = v(COMP)[endpoint]
let top = v(TOP)[endpoint]
let decision = 0
if cmp >= 0.9
let code = trial
let decision = 1
end
echo 144 7 $&trial $&cmp $&top 0.66328125 $&decision >> decisions.csv
let trial = code + 64
let drive = (floor(trial / 1) - 2*floor(trial / 2))*1.8
alter VB0 = $&drive
let drive = (floor(trial / 2) - 2*floor(trial / 4))*1.8
alter VB1 = $&drive
let drive = (floor(trial / 4) - 2*floor(trial / 8))*1.8
alter VB2 = $&drive
let drive = (floor(trial / 8) - 2*floor(trial / 16))*1.8
alter VB3 = $&drive
let drive = (floor(trial / 16) - 2*floor(trial / 32))*1.8
alter VB4 = $&drive
let drive = (floor(trial / 32) - 2*floor(trial / 64))*1.8
alter VB5 = $&drive
let drive = (floor(trial / 64) - 2*floor(trial / 128))*1.8
alter VB6 = $&drive
let drive = (floor(trial / 128) - 2*floor(trial / 256))*1.8
alter VB7 = $&drive
stop when time = 0.002598
resume
delete all
let endpoint = length(time)-1
let cmp = v(COMP)[endpoint]
let top = v(TOP)[endpoint]
let decision = 0
if cmp >= 0.9
let code = trial
let decision = 1
end
echo 144 6 $&trial $&cmp $&top 0.66328125 $&decision >> decisions.csv
let trial = code + 32
let drive = (floor(trial / 1) - 2*floor(trial / 2))*1.8
alter VB0 = $&drive
let drive = (floor(trial / 2) - 2*floor(trial / 4))*1.8
alter VB1 = $&drive
let drive = (floor(trial / 4) - 2*floor(trial / 8))*1.8
alter VB2 = $&drive
let drive = (floor(trial / 8) - 2*floor(trial / 16))*1.8
alter VB3 = $&drive
let drive = (floor(trial / 16) - 2*floor(trial / 32))*1.8
alter VB4 = $&drive
let drive = (floor(trial / 32) - 2*floor(trial / 64))*1.8
alter VB5 = $&drive
let drive = (floor(trial / 64) - 2*floor(trial / 128))*1.8
alter VB6 = $&drive
let drive = (floor(trial / 128) - 2*floor(trial / 256))*1.8
alter VB7 = $&drive
stop when time = 0.0026
resume
delete all
let endpoint = length(time)-1
let cmp = v(COMP)[endpoint]
let top = v(TOP)[endpoint]
let decision = 0
if cmp >= 0.9
let code = trial
let decision = 1
end
echo 144 5 $&trial $&cmp $&top 0.66328125 $&decision >> decisions.csv
let trial = code + 16
let drive = (floor(trial / 1) - 2*floor(trial / 2))*1.8
alter VB0 = $&drive
let drive = (floor(trial / 2) - 2*floor(trial / 4))*1.8
alter VB1 = $&drive
let drive = (floor(trial / 4) - 2*floor(trial / 8))*1.8
alter VB2 = $&drive
let drive = (floor(trial / 8) - 2*floor(trial / 16))*1.8
alter VB3 = $&drive
let drive = (floor(trial / 16) - 2*floor(trial / 32))*1.8
alter VB4 = $&drive
let drive = (floor(trial / 32) - 2*floor(trial / 64))*1.8
alter VB5 = $&drive
let drive = (floor(trial / 64) - 2*floor(trial / 128))*1.8
alter VB6 = $&drive
let drive = (floor(trial / 128) - 2*floor(trial / 256))*1.8
alter VB7 = $&drive
stop when time = 0.002602
resume
delete all
let endpoint = length(time)-1
let cmp = v(COMP)[endpoint]
let top = v(TOP)[endpoint]
let decision = 0
if cmp >= 0.9
let code = trial
let decision = 1
end
echo 144 4 $&trial $&cmp $&top 0.66328125 $&decision >> decisions.csv
let trial = code + 8
let drive = (floor(trial / 1) - 2*floor(trial / 2))*1.8
alter VB0 = $&drive
let drive = (floor(trial / 2) - 2*floor(trial / 4))*1.8
alter VB1 = $&drive
let drive = (floor(trial / 4) - 2*floor(trial / 8))*1.8
alter VB2 = $&drive
let drive = (floor(trial / 8) - 2*floor(trial / 16))*1.8
alter VB3 = $&drive
let drive = (floor(trial / 16) - 2*floor(trial / 32))*1.8
alter VB4 = $&drive
let drive = (floor(trial / 32) - 2*floor(trial / 64))*1.8
alter VB5 = $&drive
let drive = (floor(trial / 64) - 2*floor(trial / 128))*1.8
alter VB6 = $&drive
let drive = (floor(trial / 128) - 2*floor(trial / 256))*1.8
alter VB7 = $&drive
stop when time = 0.002604
resume
delete all
let endpoint = length(time)-1
let cmp = v(COMP)[endpoint]
let top = v(TOP)[endpoint]
let decision = 0
if cmp >= 0.9
let code = trial
let decision = 1
end
echo 144 3 $&trial $&cmp $&top 0.66328125 $&decision >> decisions.csv
let trial = code + 4
let drive = (floor(trial / 1) - 2*floor(trial / 2))*1.8
alter VB0 = $&drive
let drive = (floor(trial / 2) - 2*floor(trial / 4))*1.8
alter VB1 = $&drive
let drive = (floor(trial / 4) - 2*floor(trial / 8))*1.8
alter VB2 = $&drive
let drive = (floor(trial / 8) - 2*floor(trial / 16))*1.8
alter VB3 = $&drive
let drive = (floor(trial / 16) - 2*floor(trial / 32))*1.8
alter VB4 = $&drive
let drive = (floor(trial / 32) - 2*floor(trial / 64))*1.8
alter VB5 = $&drive
let drive = (floor(trial / 64) - 2*floor(trial / 128))*1.8
alter VB6 = $&drive
let drive = (floor(trial / 128) - 2*floor(trial / 256))*1.8
alter VB7 = $&drive
stop when time = 0.002606
resume
delete all
let endpoint = length(time)-1
let cmp = v(COMP)[endpoint]
let top = v(TOP)[endpoint]
let decision = 0
if cmp >= 0.9
let code = trial
let decision = 1
end
echo 144 2 $&trial $&cmp $&top 0.66328125 $&decision >> decisions.csv
let trial = code + 2
let drive = (floor(trial / 1) - 2*floor(trial / 2))*1.8
alter VB0 = $&drive
let drive = (floor(trial / 2) - 2*floor(trial / 4))*1.8
alter VB1 = $&drive
let drive = (floor(trial / 4) - 2*floor(trial / 8))*1.8
alter VB2 = $&drive
let drive = (floor(trial / 8) - 2*floor(trial / 16))*1.8
alter VB3 = $&drive
let drive = (floor(trial / 16) - 2*floor(trial / 32))*1.8
alter VB4 = $&drive
let drive = (floor(trial / 32) - 2*floor(trial / 64))*1.8
alter VB5 = $&drive
let drive = (floor(trial / 64) - 2*floor(trial / 128))*1.8
alter VB6 = $&drive
let drive = (floor(trial / 128) - 2*floor(trial / 256))*1.8
alter VB7 = $&drive
stop when time = 0.002608
resume
delete all
let endpoint = length(time)-1
let cmp = v(COMP)[endpoint]
let top = v(TOP)[endpoint]
let decision = 0
if cmp >= 0.9
let code = trial
let decision = 1
end
echo 144 1 $&trial $&cmp $&top 0.66328125 $&decision >> decisions.csv
let trial = code + 1
let drive = (floor(trial / 1) - 2*floor(trial / 2))*1.8
alter VB0 = $&drive
let drive = (floor(trial / 2) - 2*floor(trial / 4))*1.8
alter VB1 = $&drive
let drive = (floor(trial / 4) - 2*floor(trial / 8))*1.8
alter VB2 = $&drive
let drive = (floor(trial / 8) - 2*floor(trial / 16))*1.8
alter VB3 = $&drive
let drive = (floor(trial / 16) - 2*floor(trial / 32))*1.8
alter VB4 = $&drive
let drive = (floor(trial / 32) - 2*floor(trial / 64))*1.8
alter VB5 = $&drive
let drive = (floor(trial / 64) - 2*floor(trial / 128))*1.8
alter VB6 = $&drive
let drive = (floor(trial / 128) - 2*floor(trial / 256))*1.8
alter VB7 = $&drive
stop when time = 0.00261
resume
delete all
let endpoint = length(time)-1
let cmp = v(COMP)[endpoint]
let top = v(TOP)[endpoint]
let decision = 0
if cmp >= 0.9
let code = trial
let decision = 1
end
echo 144 0 $&trial $&cmp $&top 0.66328125 $&decision >> decisions.csv
alter VIN = 0.66796875
alter VSAMPLE = 1.8
alter VB0 = 0
alter VB1 = 0
alter VB2 = 0
alter VB3 = 0
alter VB4 = 0
alter VB5 = 0
alter VB6 = 0
alter VB7 = 0
let code = 0
stop when time = 0.002612
resume
delete all
alter VSAMPLE = 0
let trial = code + 128
let drive = (floor(trial / 1) - 2*floor(trial / 2))*1.8
alter VB0 = $&drive
let drive = (floor(trial / 2) - 2*floor(trial / 4))*1.8
alter VB1 = $&drive
let drive = (floor(trial / 4) - 2*floor(trial / 8))*1.8
alter VB2 = $&drive
let drive = (floor(trial / 8) - 2*floor(trial / 16))*1.8
alter VB3 = $&drive
let drive = (floor(trial / 16) - 2*floor(trial / 32))*1.8
alter VB4 = $&drive
let drive = (floor(trial / 32) - 2*floor(trial / 64))*1.8
alter VB5 = $&drive
let drive = (floor(trial / 64) - 2*floor(trial / 128))*1.8
alter VB6 = $&drive
let drive = (floor(trial / 128) - 2*floor(trial / 256))*1.8
alter VB7 = $&drive
stop when time = 0.002614
resume
delete all
let endpoint = length(time)-1
let cmp = v(COMP)[endpoint]
let top = v(TOP)[endpoint]
let decision = 0
if cmp >= 0.9
let code = trial
let decision = 1
end
echo 145 7 $&trial $&cmp $&top 0.66796875 $&decision >> decisions.csv
let trial = code + 64
let drive = (floor(trial / 1) - 2*floor(trial / 2))*1.8
alter VB0 = $&drive
let drive = (floor(trial / 2) - 2*floor(trial / 4))*1.8
alter VB1 = $&drive
let drive = (floor(trial / 4) - 2*floor(trial / 8))*1.8
alter VB2 = $&drive
let drive = (floor(trial / 8) - 2*floor(trial / 16))*1.8
alter VB3 = $&drive
let drive = (floor(trial / 16) - 2*floor(trial / 32))*1.8
alter VB4 = $&drive
let drive = (floor(trial / 32) - 2*floor(trial / 64))*1.8
alter VB5 = $&drive
let drive = (floor(trial / 64) - 2*floor(trial / 128))*1.8
alter VB6 = $&drive
let drive = (floor(trial / 128) - 2*floor(trial / 256))*1.8
alter VB7 = $&drive
stop when time = 0.002616
resume
delete all
let endpoint = length(time)-1
let cmp = v(COMP)[endpoint]
let top = v(TOP)[endpoint]
let decision = 0
if cmp >= 0.9
let code = trial
let decision = 1
end
echo 145 6 $&trial $&cmp $&top 0.66796875 $&decision >> decisions.csv
let trial = code + 32
let drive = (floor(trial / 1) - 2*floor(trial / 2))*1.8
alter VB0 = $&drive
let drive = (floor(trial / 2) - 2*floor(trial / 4))*1.8
alter VB1 = $&drive
let drive = (floor(trial / 4) - 2*floor(trial / 8))*1.8
alter VB2 = $&drive
let drive = (floor(trial / 8) - 2*floor(trial / 16))*1.8
alter VB3 = $&drive
let drive = (floor(trial / 16) - 2*floor(trial / 32))*1.8
alter VB4 = $&drive
let drive = (floor(trial / 32) - 2*floor(trial / 64))*1.8
alter VB5 = $&drive
let drive = (floor(trial / 64) - 2*floor(trial / 128))*1.8
alter VB6 = $&drive
let drive = (floor(trial / 128) - 2*floor(trial / 256))*1.8
alter VB7 = $&drive
stop when time = 0.002618
resume
delete all
let endpoint = length(time)-1
let cmp = v(COMP)[endpoint]
let top = v(TOP)[endpoint]
let decision = 0
if cmp >= 0.9
let code = trial
let decision = 1
end
echo 145 5 $&trial $&cmp $&top 0.66796875 $&decision >> decisions.csv
let trial = code + 16
let drive = (floor(trial / 1) - 2*floor(trial / 2))*1.8
alter VB0 = $&drive
let drive = (floor(trial / 2) - 2*floor(trial / 4))*1.8
alter VB1 = $&drive
let drive = (floor(trial / 4) - 2*floor(trial / 8))*1.8
alter VB2 = $&drive
let drive = (floor(trial / 8) - 2*floor(trial / 16))*1.8
alter VB3 = $&drive
let drive = (floor(trial / 16) - 2*floor(trial / 32))*1.8
alter VB4 = $&drive
let drive = (floor(trial / 32) - 2*floor(trial / 64))*1.8
alter VB5 = $&drive
let drive = (floor(trial / 64) - 2*floor(trial / 128))*1.8
alter VB6 = $&drive
let drive = (floor(trial / 128) - 2*floor(trial / 256))*1.8
alter VB7 = $&drive
stop when time = 0.00262
resume
delete all
let endpoint = length(time)-1
let cmp = v(COMP)[endpoint]
let top = v(TOP)[endpoint]
let decision = 0
if cmp >= 0.9
let code = trial
let decision = 1
end
echo 145 4 $&trial $&cmp $&top 0.66796875 $&decision >> decisions.csv
let trial = code + 8
let drive = (floor(trial / 1) - 2*floor(trial / 2))*1.8
alter VB0 = $&drive
let drive = (floor(trial / 2) - 2*floor(trial / 4))*1.8
alter VB1 = $&drive
let drive = (floor(trial / 4) - 2*floor(trial / 8))*1.8
alter VB2 = $&drive
let drive = (floor(trial / 8) - 2*floor(trial / 16))*1.8
alter VB3 = $&drive
let drive = (floor(trial / 16) - 2*floor(trial / 32))*1.8
alter VB4 = $&drive
let drive = (floor(trial / 32) - 2*floor(trial / 64))*1.8
alter VB5 = $&drive
let drive = (floor(trial / 64) - 2*floor(trial / 128))*1.8
alter VB6 = $&drive
let drive = (floor(trial / 128) - 2*floor(trial / 256))*1.8
alter VB7 = $&drive
stop when time = 0.002622
resume
delete all
let endpoint = length(time)-1
let cmp = v(COMP)[endpoint]
let top = v(TOP)[endpoint]
let decision = 0
if cmp >= 0.9
let code = trial
let decision = 1
end
echo 145 3 $&trial $&cmp $&top 0.66796875 $&decision >> decisions.csv
let trial = code + 4
let drive = (floor(trial / 1) - 2*floor(trial / 2))*1.8
alter VB0 = $&drive
let drive = (floor(trial / 2) - 2*floor(trial / 4))*1.8
alter VB1 = $&drive
let drive = (floor(trial / 4) - 2*floor(trial / 8))*1.8
alter VB2 = $&drive
let drive = (floor(trial / 8) - 2*floor(trial / 16))*1.8
alter VB3 = $&drive
let drive = (floor(trial / 16) - 2*floor(trial / 32))*1.8
alter VB4 = $&drive
let drive = (floor(trial / 32) - 2*floor(trial / 64))*1.8
alter VB5 = $&drive
let drive = (floor(trial / 64) - 2*floor(trial / 128))*1.8
alter VB6 = $&drive
let drive = (floor(trial / 128) - 2*floor(trial / 256))*1.8
alter VB7 = $&drive
stop when time = 0.002624
resume
delete all
let endpoint = length(time)-1
let cmp = v(COMP)[endpoint]
let top = v(TOP)[endpoint]
let decision = 0
if cmp >= 0.9
let code = trial
let decision = 1
end
echo 145 2 $&trial $&cmp $&top 0.66796875 $&decision >> decisions.csv
let trial = code + 2
let drive = (floor(trial / 1) - 2*floor(trial / 2))*1.8
alter VB0 = $&drive
let drive = (floor(trial / 2) - 2*floor(trial / 4))*1.8
alter VB1 = $&drive
let drive = (floor(trial / 4) - 2*floor(trial / 8))*1.8
alter VB2 = $&drive
let drive = (floor(trial / 8) - 2*floor(trial / 16))*1.8
alter VB3 = $&drive
let drive = (floor(trial / 16) - 2*floor(trial / 32))*1.8
alter VB4 = $&drive
let drive = (floor(trial / 32) - 2*floor(trial / 64))*1.8
alter VB5 = $&drive
let drive = (floor(trial / 64) - 2*floor(trial / 128))*1.8
alter VB6 = $&drive
let drive = (floor(trial / 128) - 2*floor(trial / 256))*1.8
alter VB7 = $&drive
stop when time = 0.002626
resume
delete all
let endpoint = length(time)-1
let cmp = v(COMP)[endpoint]
let top = v(TOP)[endpoint]
let decision = 0
if cmp >= 0.9
let code = trial
let decision = 1
end
echo 145 1 $&trial $&cmp $&top 0.66796875 $&decision >> decisions.csv
let trial = code + 1
let drive = (floor(trial / 1) - 2*floor(trial / 2))*1.8
alter VB0 = $&drive
let drive = (floor(trial / 2) - 2*floor(trial / 4))*1.8
alter VB1 = $&drive
let drive = (floor(trial / 4) - 2*floor(trial / 8))*1.8
alter VB2 = $&drive
let drive = (floor(trial / 8) - 2*floor(trial / 16))*1.8
alter VB3 = $&drive
let drive = (floor(trial / 16) - 2*floor(trial / 32))*1.8
alter VB4 = $&drive
let drive = (floor(trial / 32) - 2*floor(trial / 64))*1.8
alter VB5 = $&drive
let drive = (floor(trial / 64) - 2*floor(trial / 128))*1.8
alter VB6 = $&drive
let drive = (floor(trial / 128) - 2*floor(trial / 256))*1.8
alter VB7 = $&drive
stop when time = 0.002628
resume
delete all
let endpoint = length(time)-1
let cmp = v(COMP)[endpoint]
let top = v(TOP)[endpoint]
let decision = 0
if cmp >= 0.9
let code = trial
let decision = 1
end
echo 145 0 $&trial $&cmp $&top 0.66796875 $&decision >> decisions.csv
alter VIN = 0.67265625
alter VSAMPLE = 1.8
alter VB0 = 0
alter VB1 = 0
alter VB2 = 0
alter VB3 = 0
alter VB4 = 0
alter VB5 = 0
alter VB6 = 0
alter VB7 = 0
let code = 0
stop when time = 0.00263
resume
delete all
alter VSAMPLE = 0
let trial = code + 128
let drive = (floor(trial / 1) - 2*floor(trial / 2))*1.8
alter VB0 = $&drive
let drive = (floor(trial / 2) - 2*floor(trial / 4))*1.8
alter VB1 = $&drive
let drive = (floor(trial / 4) - 2*floor(trial / 8))*1.8
alter VB2 = $&drive
let drive = (floor(trial / 8) - 2*floor(trial / 16))*1.8
alter VB3 = $&drive
let drive = (floor(trial / 16) - 2*floor(trial / 32))*1.8
alter VB4 = $&drive
let drive = (floor(trial / 32) - 2*floor(trial / 64))*1.8
alter VB5 = $&drive
let drive = (floor(trial / 64) - 2*floor(trial / 128))*1.8
alter VB6 = $&drive
let drive = (floor(trial / 128) - 2*floor(trial / 256))*1.8
alter VB7 = $&drive
stop when time = 0.002632
resume
delete all
let endpoint = length(time)-1
let cmp = v(COMP)[endpoint]
let top = v(TOP)[endpoint]
let decision = 0
if cmp >= 0.9
let code = trial
let decision = 1
end
echo 146 7 $&trial $&cmp $&top 0.67265625 $&decision >> decisions.csv
let trial = code + 64
let drive = (floor(trial / 1) - 2*floor(trial / 2))*1.8
alter VB0 = $&drive
let drive = (floor(trial / 2) - 2*floor(trial / 4))*1.8
alter VB1 = $&drive
let drive = (floor(trial / 4) - 2*floor(trial / 8))*1.8
alter VB2 = $&drive
let drive = (floor(trial / 8) - 2*floor(trial / 16))*1.8
alter VB3 = $&drive
let drive = (floor(trial / 16) - 2*floor(trial / 32))*1.8
alter VB4 = $&drive
let drive = (floor(trial / 32) - 2*floor(trial / 64))*1.8
alter VB5 = $&drive
let drive = (floor(trial / 64) - 2*floor(trial / 128))*1.8
alter VB6 = $&drive
let drive = (floor(trial / 128) - 2*floor(trial / 256))*1.8
alter VB7 = $&drive
stop when time = 0.002634
resume
delete all
let endpoint = length(time)-1
let cmp = v(COMP)[endpoint]
let top = v(TOP)[endpoint]
let decision = 0
if cmp >= 0.9
let code = trial
let decision = 1
end
echo 146 6 $&trial $&cmp $&top 0.67265625 $&decision >> decisions.csv
let trial = code + 32
let drive = (floor(trial / 1) - 2*floor(trial / 2))*1.8
alter VB0 = $&drive
let drive = (floor(trial / 2) - 2*floor(trial / 4))*1.8
alter VB1 = $&drive
let drive = (floor(trial / 4) - 2*floor(trial / 8))*1.8
alter VB2 = $&drive
let drive = (floor(trial / 8) - 2*floor(trial / 16))*1.8
alter VB3 = $&drive
let drive = (floor(trial / 16) - 2*floor(trial / 32))*1.8
alter VB4 = $&drive
let drive = (floor(trial / 32) - 2*floor(trial / 64))*1.8
alter VB5 = $&drive
let drive = (floor(trial / 64) - 2*floor(trial / 128))*1.8
alter VB6 = $&drive
let drive = (floor(trial / 128) - 2*floor(trial / 256))*1.8
alter VB7 = $&drive
stop when time = 0.002636
resume
delete all
let endpoint = length(time)-1
let cmp = v(COMP)[endpoint]
let top = v(TOP)[endpoint]
let decision = 0
if cmp >= 0.9
let code = trial
let decision = 1
end
echo 146 5 $&trial $&cmp $&top 0.67265625 $&decision >> decisions.csv
let trial = code + 16
let drive = (floor(trial / 1) - 2*floor(trial / 2))*1.8
alter VB0 = $&drive
let drive = (floor(trial / 2) - 2*floor(trial / 4))*1.8
alter VB1 = $&drive
let drive = (floor(trial / 4) - 2*floor(trial / 8))*1.8
alter VB2 = $&drive
let drive = (floor(trial / 8) - 2*floor(trial / 16))*1.8
alter VB3 = $&drive
let drive = (floor(trial / 16) - 2*floor(trial / 32))*1.8
alter VB4 = $&drive
let drive = (floor(trial / 32) - 2*floor(trial / 64))*1.8
alter VB5 = $&drive
let drive = (floor(trial / 64) - 2*floor(trial / 128))*1.8
alter VB6 = $&drive
let drive = (floor(trial / 128) - 2*floor(trial / 256))*1.8
alter VB7 = $&drive
stop when time = 0.002638
resume
delete all
let endpoint = length(time)-1
let cmp = v(COMP)[endpoint]
let top = v(TOP)[endpoint]
let decision = 0
if cmp >= 0.9
let code = trial
let decision = 1
end
echo 146 4 $&trial $&cmp $&top 0.67265625 $&decision >> decisions.csv
let trial = code + 8
let drive = (floor(trial / 1) - 2*floor(trial / 2))*1.8
alter VB0 = $&drive
let drive = (floor(trial / 2) - 2*floor(trial / 4))*1.8
alter VB1 = $&drive
let drive = (floor(trial / 4) - 2*floor(trial / 8))*1.8
alter VB2 = $&drive
let drive = (floor(trial / 8) - 2*floor(trial / 16))*1.8
alter VB3 = $&drive
let drive = (floor(trial / 16) - 2*floor(trial / 32))*1.8
alter VB4 = $&drive
let drive = (floor(trial / 32) - 2*floor(trial / 64))*1.8
alter VB5 = $&drive
let drive = (floor(trial / 64) - 2*floor(trial / 128))*1.8
alter VB6 = $&drive
let drive = (floor(trial / 128) - 2*floor(trial / 256))*1.8
alter VB7 = $&drive
stop when time = 0.00264
resume
delete all
let endpoint = length(time)-1
let cmp = v(COMP)[endpoint]
let top = v(TOP)[endpoint]
let decision = 0
if cmp >= 0.9
let code = trial
let decision = 1
end
echo 146 3 $&trial $&cmp $&top 0.67265625 $&decision >> decisions.csv
let trial = code + 4
let drive = (floor(trial / 1) - 2*floor(trial / 2))*1.8
alter VB0 = $&drive
let drive = (floor(trial / 2) - 2*floor(trial / 4))*1.8
alter VB1 = $&drive
let drive = (floor(trial / 4) - 2*floor(trial / 8))*1.8
alter VB2 = $&drive
let drive = (floor(trial / 8) - 2*floor(trial / 16))*1.8
alter VB3 = $&drive
let drive = (floor(trial / 16) - 2*floor(trial / 32))*1.8
alter VB4 = $&drive
let drive = (floor(trial / 32) - 2*floor(trial / 64))*1.8
alter VB5 = $&drive
let drive = (floor(trial / 64) - 2*floor(trial / 128))*1.8
alter VB6 = $&drive
let drive = (floor(trial / 128) - 2*floor(trial / 256))*1.8
alter VB7 = $&drive
stop when time = 0.002642
resume
delete all
let endpoint = length(time)-1
let cmp = v(COMP)[endpoint]
let top = v(TOP)[endpoint]
let decision = 0
if cmp >= 0.9
let code = trial
let decision = 1
end
echo 146 2 $&trial $&cmp $&top 0.67265625 $&decision >> decisions.csv
let trial = code + 2
let drive = (floor(trial / 1) - 2*floor(trial / 2))*1.8
alter VB0 = $&drive
let drive = (floor(trial / 2) - 2*floor(trial / 4))*1.8
alter VB1 = $&drive
let drive = (floor(trial / 4) - 2*floor(trial / 8))*1.8
alter VB2 = $&drive
let drive = (floor(trial / 8) - 2*floor(trial / 16))*1.8
alter VB3 = $&drive
let drive = (floor(trial / 16) - 2*floor(trial / 32))*1.8
alter VB4 = $&drive
let drive = (floor(trial / 32) - 2*floor(trial / 64))*1.8
alter VB5 = $&drive
let drive = (floor(trial / 64) - 2*floor(trial / 128))*1.8
alter VB6 = $&drive
let drive = (floor(trial / 128) - 2*floor(trial / 256))*1.8
alter VB7 = $&drive
stop when time = 0.002644
resume
delete all
let endpoint = length(time)-1
let cmp = v(COMP)[endpoint]
let top = v(TOP)[endpoint]
let decision = 0
if cmp >= 0.9
let code = trial
let decision = 1
end
echo 146 1 $&trial $&cmp $&top 0.67265625 $&decision >> decisions.csv
let trial = code + 1
let drive = (floor(trial / 1) - 2*floor(trial / 2))*1.8
alter VB0 = $&drive
let drive = (floor(trial / 2) - 2*floor(trial / 4))*1.8
alter VB1 = $&drive
let drive = (floor(trial / 4) - 2*floor(trial / 8))*1.8
alter VB2 = $&drive
let drive = (floor(trial / 8) - 2*floor(trial / 16))*1.8
alter VB3 = $&drive
let drive = (floor(trial / 16) - 2*floor(trial / 32))*1.8
alter VB4 = $&drive
let drive = (floor(trial / 32) - 2*floor(trial / 64))*1.8
alter VB5 = $&drive
let drive = (floor(trial / 64) - 2*floor(trial / 128))*1.8
alter VB6 = $&drive
let drive = (floor(trial / 128) - 2*floor(trial / 256))*1.8
alter VB7 = $&drive
stop when time = 0.002646
resume
delete all
let endpoint = length(time)-1
let cmp = v(COMP)[endpoint]
let top = v(TOP)[endpoint]
let decision = 0
if cmp >= 0.9
let code = trial
let decision = 1
end
echo 146 0 $&trial $&cmp $&top 0.67265625 $&decision >> decisions.csv
alter VIN = 0.67734375
alter VSAMPLE = 1.8
alter VB0 = 0
alter VB1 = 0
alter VB2 = 0
alter VB3 = 0
alter VB4 = 0
alter VB5 = 0
alter VB6 = 0
alter VB7 = 0
let code = 0
stop when time = 0.002648
resume
delete all
alter VSAMPLE = 0
let trial = code + 128
let drive = (floor(trial / 1) - 2*floor(trial / 2))*1.8
alter VB0 = $&drive
let drive = (floor(trial / 2) - 2*floor(trial / 4))*1.8
alter VB1 = $&drive
let drive = (floor(trial / 4) - 2*floor(trial / 8))*1.8
alter VB2 = $&drive
let drive = (floor(trial / 8) - 2*floor(trial / 16))*1.8
alter VB3 = $&drive
let drive = (floor(trial / 16) - 2*floor(trial / 32))*1.8
alter VB4 = $&drive
let drive = (floor(trial / 32) - 2*floor(trial / 64))*1.8
alter VB5 = $&drive
let drive = (floor(trial / 64) - 2*floor(trial / 128))*1.8
alter VB6 = $&drive
let drive = (floor(trial / 128) - 2*floor(trial / 256))*1.8
alter VB7 = $&drive
stop when time = 0.00265
resume
delete all
let endpoint = length(time)-1
let cmp = v(COMP)[endpoint]
let top = v(TOP)[endpoint]
let decision = 0
if cmp >= 0.9
let code = trial
let decision = 1
end
echo 147 7 $&trial $&cmp $&top 0.67734375 $&decision >> decisions.csv
let trial = code + 64
let drive = (floor(trial / 1) - 2*floor(trial / 2))*1.8
alter VB0 = $&drive
let drive = (floor(trial / 2) - 2*floor(trial / 4))*1.8
alter VB1 = $&drive
let drive = (floor(trial / 4) - 2*floor(trial / 8))*1.8
alter VB2 = $&drive
let drive = (floor(trial / 8) - 2*floor(trial / 16))*1.8
alter VB3 = $&drive
let drive = (floor(trial / 16) - 2*floor(trial / 32))*1.8
alter VB4 = $&drive
let drive = (floor(trial / 32) - 2*floor(trial / 64))*1.8
alter VB5 = $&drive
let drive = (floor(trial / 64) - 2*floor(trial / 128))*1.8
alter VB6 = $&drive
let drive = (floor(trial / 128) - 2*floor(trial / 256))*1.8
alter VB7 = $&drive
stop when time = 0.002652
resume
delete all
let endpoint = length(time)-1
let cmp = v(COMP)[endpoint]
let top = v(TOP)[endpoint]
let decision = 0
if cmp >= 0.9
let code = trial
let decision = 1
end
echo 147 6 $&trial $&cmp $&top 0.67734375 $&decision >> decisions.csv
let trial = code + 32
let drive = (floor(trial / 1) - 2*floor(trial / 2))*1.8
alter VB0 = $&drive
let drive = (floor(trial / 2) - 2*floor(trial / 4))*1.8
alter VB1 = $&drive
let drive = (floor(trial / 4) - 2*floor(trial / 8))*1.8
alter VB2 = $&drive
let drive = (floor(trial / 8) - 2*floor(trial / 16))*1.8
alter VB3 = $&drive
let drive = (floor(trial / 16) - 2*floor(trial / 32))*1.8
alter VB4 = $&drive
let drive = (floor(trial / 32) - 2*floor(trial / 64))*1.8
alter VB5 = $&drive
let drive = (floor(trial / 64) - 2*floor(trial / 128))*1.8
alter VB6 = $&drive
let drive = (floor(trial / 128) - 2*floor(trial / 256))*1.8
alter VB7 = $&drive
stop when time = 0.002654
resume
delete all
let endpoint = length(time)-1
let cmp = v(COMP)[endpoint]
let top = v(TOP)[endpoint]
let decision = 0
if cmp >= 0.9
let code = trial
let decision = 1
end
echo 147 5 $&trial $&cmp $&top 0.67734375 $&decision >> decisions.csv
let trial = code + 16
let drive = (floor(trial / 1) - 2*floor(trial / 2))*1.8
alter VB0 = $&drive
let drive = (floor(trial / 2) - 2*floor(trial / 4))*1.8
alter VB1 = $&drive
let drive = (floor(trial / 4) - 2*floor(trial / 8))*1.8
alter VB2 = $&drive
let drive = (floor(trial / 8) - 2*floor(trial / 16))*1.8
alter VB3 = $&drive
let drive = (floor(trial / 16) - 2*floor(trial / 32))*1.8
alter VB4 = $&drive
let drive = (floor(trial / 32) - 2*floor(trial / 64))*1.8
alter VB5 = $&drive
let drive = (floor(trial / 64) - 2*floor(trial / 128))*1.8
alter VB6 = $&drive
let drive = (floor(trial / 128) - 2*floor(trial / 256))*1.8
alter VB7 = $&drive
stop when time = 0.002656
resume
delete all
let endpoint = length(time)-1
let cmp = v(COMP)[endpoint]
let top = v(TOP)[endpoint]
let decision = 0
if cmp >= 0.9
let code = trial
let decision = 1
end
echo 147 4 $&trial $&cmp $&top 0.67734375 $&decision >> decisions.csv
let trial = code + 8
let drive = (floor(trial / 1) - 2*floor(trial / 2))*1.8
alter VB0 = $&drive
let drive = (floor(trial / 2) - 2*floor(trial / 4))*1.8
alter VB1 = $&drive
let drive = (floor(trial / 4) - 2*floor(trial / 8))*1.8
alter VB2 = $&drive
let drive = (floor(trial / 8) - 2*floor(trial / 16))*1.8
alter VB3 = $&drive
let drive = (floor(trial / 16) - 2*floor(trial / 32))*1.8
alter VB4 = $&drive
let drive = (floor(trial / 32) - 2*floor(trial / 64))*1.8
alter VB5 = $&drive
let drive = (floor(trial / 64) - 2*floor(trial / 128))*1.8
alter VB6 = $&drive
let drive = (floor(trial / 128) - 2*floor(trial / 256))*1.8
alter VB7 = $&drive
stop when time = 0.002658
resume
delete all
let endpoint = length(time)-1
let cmp = v(COMP)[endpoint]
let top = v(TOP)[endpoint]
let decision = 0
if cmp >= 0.9
let code = trial
let decision = 1
end
echo 147 3 $&trial $&cmp $&top 0.67734375 $&decision >> decisions.csv
let trial = code + 4
let drive = (floor(trial / 1) - 2*floor(trial / 2))*1.8
alter VB0 = $&drive
let drive = (floor(trial / 2) - 2*floor(trial / 4))*1.8
alter VB1 = $&drive
let drive = (floor(trial / 4) - 2*floor(trial / 8))*1.8
alter VB2 = $&drive
let drive = (floor(trial / 8) - 2*floor(trial / 16))*1.8
alter VB3 = $&drive
let drive = (floor(trial / 16) - 2*floor(trial / 32))*1.8
alter VB4 = $&drive
let drive = (floor(trial / 32) - 2*floor(trial / 64))*1.8
alter VB5 = $&drive
let drive = (floor(trial / 64) - 2*floor(trial / 128))*1.8
alter VB6 = $&drive
let drive = (floor(trial / 128) - 2*floor(trial / 256))*1.8
alter VB7 = $&drive
stop when time = 0.00266
resume
delete all
let endpoint = length(time)-1
let cmp = v(COMP)[endpoint]
let top = v(TOP)[endpoint]
let decision = 0
if cmp >= 0.9
let code = trial
let decision = 1
end
echo 147 2 $&trial $&cmp $&top 0.67734375 $&decision >> decisions.csv
let trial = code + 2
let drive = (floor(trial / 1) - 2*floor(trial / 2))*1.8
alter VB0 = $&drive
let drive = (floor(trial / 2) - 2*floor(trial / 4))*1.8
alter VB1 = $&drive
let drive = (floor(trial / 4) - 2*floor(trial / 8))*1.8
alter VB2 = $&drive
let drive = (floor(trial / 8) - 2*floor(trial / 16))*1.8
alter VB3 = $&drive
let drive = (floor(trial / 16) - 2*floor(trial / 32))*1.8
alter VB4 = $&drive
let drive = (floor(trial / 32) - 2*floor(trial / 64))*1.8
alter VB5 = $&drive
let drive = (floor(trial / 64) - 2*floor(trial / 128))*1.8
alter VB6 = $&drive
let drive = (floor(trial / 128) - 2*floor(trial / 256))*1.8
alter VB7 = $&drive
stop when time = 0.002662
resume
delete all
let endpoint = length(time)-1
let cmp = v(COMP)[endpoint]
let top = v(TOP)[endpoint]
let decision = 0
if cmp >= 0.9
let code = trial
let decision = 1
end
echo 147 1 $&trial $&cmp $&top 0.67734375 $&decision >> decisions.csv
let trial = code + 1
let drive = (floor(trial / 1) - 2*floor(trial / 2))*1.8
alter VB0 = $&drive
let drive = (floor(trial / 2) - 2*floor(trial / 4))*1.8
alter VB1 = $&drive
let drive = (floor(trial / 4) - 2*floor(trial / 8))*1.8
alter VB2 = $&drive
let drive = (floor(trial / 8) - 2*floor(trial / 16))*1.8
alter VB3 = $&drive
let drive = (floor(trial / 16) - 2*floor(trial / 32))*1.8
alter VB4 = $&drive
let drive = (floor(trial / 32) - 2*floor(trial / 64))*1.8
alter VB5 = $&drive
let drive = (floor(trial / 64) - 2*floor(trial / 128))*1.8
alter VB6 = $&drive
let drive = (floor(trial / 128) - 2*floor(trial / 256))*1.8
alter VB7 = $&drive
stop when time = 0.002664
resume
delete all
let endpoint = length(time)-1
let cmp = v(COMP)[endpoint]
let top = v(TOP)[endpoint]
let decision = 0
if cmp >= 0.9
let code = trial
let decision = 1
end
echo 147 0 $&trial $&cmp $&top 0.67734375 $&decision >> decisions.csv
alter VIN = 0.68203125
alter VSAMPLE = 1.8
alter VB0 = 0
alter VB1 = 0
alter VB2 = 0
alter VB3 = 0
alter VB4 = 0
alter VB5 = 0
alter VB6 = 0
alter VB7 = 0
let code = 0
stop when time = 0.002666
resume
delete all
alter VSAMPLE = 0
let trial = code + 128
let drive = (floor(trial / 1) - 2*floor(trial / 2))*1.8
alter VB0 = $&drive
let drive = (floor(trial / 2) - 2*floor(trial / 4))*1.8
alter VB1 = $&drive
let drive = (floor(trial / 4) - 2*floor(trial / 8))*1.8
alter VB2 = $&drive
let drive = (floor(trial / 8) - 2*floor(trial / 16))*1.8
alter VB3 = $&drive
let drive = (floor(trial / 16) - 2*floor(trial / 32))*1.8
alter VB4 = $&drive
let drive = (floor(trial / 32) - 2*floor(trial / 64))*1.8
alter VB5 = $&drive
let drive = (floor(trial / 64) - 2*floor(trial / 128))*1.8
alter VB6 = $&drive
let drive = (floor(trial / 128) - 2*floor(trial / 256))*1.8
alter VB7 = $&drive
stop when time = 0.002668
resume
delete all
let endpoint = length(time)-1
let cmp = v(COMP)[endpoint]
let top = v(TOP)[endpoint]
let decision = 0
if cmp >= 0.9
let code = trial
let decision = 1
end
echo 148 7 $&trial $&cmp $&top 0.68203125 $&decision >> decisions.csv
let trial = code + 64
let drive = (floor(trial / 1) - 2*floor(trial / 2))*1.8
alter VB0 = $&drive
let drive = (floor(trial / 2) - 2*floor(trial / 4))*1.8
alter VB1 = $&drive
let drive = (floor(trial / 4) - 2*floor(trial / 8))*1.8
alter VB2 = $&drive
let drive = (floor(trial / 8) - 2*floor(trial / 16))*1.8
alter VB3 = $&drive
let drive = (floor(trial / 16) - 2*floor(trial / 32))*1.8
alter VB4 = $&drive
let drive = (floor(trial / 32) - 2*floor(trial / 64))*1.8
alter VB5 = $&drive
let drive = (floor(trial / 64) - 2*floor(trial / 128))*1.8
alter VB6 = $&drive
let drive = (floor(trial / 128) - 2*floor(trial / 256))*1.8
alter VB7 = $&drive
stop when time = 0.00267
resume
delete all
let endpoint = length(time)-1
let cmp = v(COMP)[endpoint]
let top = v(TOP)[endpoint]
let decision = 0
if cmp >= 0.9
let code = trial
let decision = 1
end
echo 148 6 $&trial $&cmp $&top 0.68203125 $&decision >> decisions.csv
let trial = code + 32
let drive = (floor(trial / 1) - 2*floor(trial / 2))*1.8
alter VB0 = $&drive
let drive = (floor(trial / 2) - 2*floor(trial / 4))*1.8
alter VB1 = $&drive
let drive = (floor(trial / 4) - 2*floor(trial / 8))*1.8
alter VB2 = $&drive
let drive = (floor(trial / 8) - 2*floor(trial / 16))*1.8
alter VB3 = $&drive
let drive = (floor(trial / 16) - 2*floor(trial / 32))*1.8
alter VB4 = $&drive
let drive = (floor(trial / 32) - 2*floor(trial / 64))*1.8
alter VB5 = $&drive
let drive = (floor(trial / 64) - 2*floor(trial / 128))*1.8
alter VB6 = $&drive
let drive = (floor(trial / 128) - 2*floor(trial / 256))*1.8
alter VB7 = $&drive
stop when time = 0.002672
resume
delete all
let endpoint = length(time)-1
let cmp = v(COMP)[endpoint]
let top = v(TOP)[endpoint]
let decision = 0
if cmp >= 0.9
let code = trial
let decision = 1
end
echo 148 5 $&trial $&cmp $&top 0.68203125 $&decision >> decisions.csv
let trial = code + 16
let drive = (floor(trial / 1) - 2*floor(trial / 2))*1.8
alter VB0 = $&drive
let drive = (floor(trial / 2) - 2*floor(trial / 4))*1.8
alter VB1 = $&drive
let drive = (floor(trial / 4) - 2*floor(trial / 8))*1.8
alter VB2 = $&drive
let drive = (floor(trial / 8) - 2*floor(trial / 16))*1.8
alter VB3 = $&drive
let drive = (floor(trial / 16) - 2*floor(trial / 32))*1.8
alter VB4 = $&drive
let drive = (floor(trial / 32) - 2*floor(trial / 64))*1.8
alter VB5 = $&drive
let drive = (floor(trial / 64) - 2*floor(trial / 128))*1.8
alter VB6 = $&drive
let drive = (floor(trial / 128) - 2*floor(trial / 256))*1.8
alter VB7 = $&drive
stop when time = 0.002674
resume
delete all
let endpoint = length(time)-1
let cmp = v(COMP)[endpoint]
let top = v(TOP)[endpoint]
let decision = 0
if cmp >= 0.9
let code = trial
let decision = 1
end
echo 148 4 $&trial $&cmp $&top 0.68203125 $&decision >> decisions.csv
let trial = code + 8
let drive = (floor(trial / 1) - 2*floor(trial / 2))*1.8
alter VB0 = $&drive
let drive = (floor(trial / 2) - 2*floor(trial / 4))*1.8
alter VB1 = $&drive
let drive = (floor(trial / 4) - 2*floor(trial / 8))*1.8
alter VB2 = $&drive
let drive = (floor(trial / 8) - 2*floor(trial / 16))*1.8
alter VB3 = $&drive
let drive = (floor(trial / 16) - 2*floor(trial / 32))*1.8
alter VB4 = $&drive
let drive = (floor(trial / 32) - 2*floor(trial / 64))*1.8
alter VB5 = $&drive
let drive = (floor(trial / 64) - 2*floor(trial / 128))*1.8
alter VB6 = $&drive
let drive = (floor(trial / 128) - 2*floor(trial / 256))*1.8
alter VB7 = $&drive
stop when time = 0.002676
resume
delete all
let endpoint = length(time)-1
let cmp = v(COMP)[endpoint]
let top = v(TOP)[endpoint]
let decision = 0
if cmp >= 0.9
let code = trial
let decision = 1
end
echo 148 3 $&trial $&cmp $&top 0.68203125 $&decision >> decisions.csv
let trial = code + 4
let drive = (floor(trial / 1) - 2*floor(trial / 2))*1.8
alter VB0 = $&drive
let drive = (floor(trial / 2) - 2*floor(trial / 4))*1.8
alter VB1 = $&drive
let drive = (floor(trial / 4) - 2*floor(trial / 8))*1.8
alter VB2 = $&drive
let drive = (floor(trial / 8) - 2*floor(trial / 16))*1.8
alter VB3 = $&drive
let drive = (floor(trial / 16) - 2*floor(trial / 32))*1.8
alter VB4 = $&drive
let drive = (floor(trial / 32) - 2*floor(trial / 64))*1.8
alter VB5 = $&drive
let drive = (floor(trial / 64) - 2*floor(trial / 128))*1.8
alter VB6 = $&drive
let drive = (floor(trial / 128) - 2*floor(trial / 256))*1.8
alter VB7 = $&drive
stop when time = 0.002678
resume
delete all
let endpoint = length(time)-1
let cmp = v(COMP)[endpoint]
let top = v(TOP)[endpoint]
let decision = 0
if cmp >= 0.9
let code = trial
let decision = 1
end
echo 148 2 $&trial $&cmp $&top 0.68203125 $&decision >> decisions.csv
let trial = code + 2
let drive = (floor(trial / 1) - 2*floor(trial / 2))*1.8
alter VB0 = $&drive
let drive = (floor(trial / 2) - 2*floor(trial / 4))*1.8
alter VB1 = $&drive
let drive = (floor(trial / 4) - 2*floor(trial / 8))*1.8
alter VB2 = $&drive
let drive = (floor(trial / 8) - 2*floor(trial / 16))*1.8
alter VB3 = $&drive
let drive = (floor(trial / 16) - 2*floor(trial / 32))*1.8
alter VB4 = $&drive
let drive = (floor(trial / 32) - 2*floor(trial / 64))*1.8
alter VB5 = $&drive
let drive = (floor(trial / 64) - 2*floor(trial / 128))*1.8
alter VB6 = $&drive
let drive = (floor(trial / 128) - 2*floor(trial / 256))*1.8
alter VB7 = $&drive
stop when time = 0.00268
resume
delete all
let endpoint = length(time)-1
let cmp = v(COMP)[endpoint]
let top = v(TOP)[endpoint]
let decision = 0
if cmp >= 0.9
let code = trial
let decision = 1
end
echo 148 1 $&trial $&cmp $&top 0.68203125 $&decision >> decisions.csv
let trial = code + 1
let drive = (floor(trial / 1) - 2*floor(trial / 2))*1.8
alter VB0 = $&drive
let drive = (floor(trial / 2) - 2*floor(trial / 4))*1.8
alter VB1 = $&drive
let drive = (floor(trial / 4) - 2*floor(trial / 8))*1.8
alter VB2 = $&drive
let drive = (floor(trial / 8) - 2*floor(trial / 16))*1.8
alter VB3 = $&drive
let drive = (floor(trial / 16) - 2*floor(trial / 32))*1.8
alter VB4 = $&drive
let drive = (floor(trial / 32) - 2*floor(trial / 64))*1.8
alter VB5 = $&drive
let drive = (floor(trial / 64) - 2*floor(trial / 128))*1.8
alter VB6 = $&drive
let drive = (floor(trial / 128) - 2*floor(trial / 256))*1.8
alter VB7 = $&drive
stop when time = 0.002682
resume
delete all
let endpoint = length(time)-1
let cmp = v(COMP)[endpoint]
let top = v(TOP)[endpoint]
let decision = 0
if cmp >= 0.9
let code = trial
let decision = 1
end
echo 148 0 $&trial $&cmp $&top 0.68203125 $&decision >> decisions.csv
alter VIN = 0.68671875
alter VSAMPLE = 1.8
alter VB0 = 0
alter VB1 = 0
alter VB2 = 0
alter VB3 = 0
alter VB4 = 0
alter VB5 = 0
alter VB6 = 0
alter VB7 = 0
let code = 0
stop when time = 0.002684
resume
delete all
alter VSAMPLE = 0
let trial = code + 128
let drive = (floor(trial / 1) - 2*floor(trial / 2))*1.8
alter VB0 = $&drive
let drive = (floor(trial / 2) - 2*floor(trial / 4))*1.8
alter VB1 = $&drive
let drive = (floor(trial / 4) - 2*floor(trial / 8))*1.8
alter VB2 = $&drive
let drive = (floor(trial / 8) - 2*floor(trial / 16))*1.8
alter VB3 = $&drive
let drive = (floor(trial / 16) - 2*floor(trial / 32))*1.8
alter VB4 = $&drive
let drive = (floor(trial / 32) - 2*floor(trial / 64))*1.8
alter VB5 = $&drive
let drive = (floor(trial / 64) - 2*floor(trial / 128))*1.8
alter VB6 = $&drive
let drive = (floor(trial / 128) - 2*floor(trial / 256))*1.8
alter VB7 = $&drive
stop when time = 0.002686
resume
delete all
let endpoint = length(time)-1
let cmp = v(COMP)[endpoint]
let top = v(TOP)[endpoint]
let decision = 0
if cmp >= 0.9
let code = trial
let decision = 1
end
echo 149 7 $&trial $&cmp $&top 0.68671875 $&decision >> decisions.csv
let trial = code + 64
let drive = (floor(trial / 1) - 2*floor(trial / 2))*1.8
alter VB0 = $&drive
let drive = (floor(trial / 2) - 2*floor(trial / 4))*1.8
alter VB1 = $&drive
let drive = (floor(trial / 4) - 2*floor(trial / 8))*1.8
alter VB2 = $&drive
let drive = (floor(trial / 8) - 2*floor(trial / 16))*1.8
alter VB3 = $&drive
let drive = (floor(trial / 16) - 2*floor(trial / 32))*1.8
alter VB4 = $&drive
let drive = (floor(trial / 32) - 2*floor(trial / 64))*1.8
alter VB5 = $&drive
let drive = (floor(trial / 64) - 2*floor(trial / 128))*1.8
alter VB6 = $&drive
let drive = (floor(trial / 128) - 2*floor(trial / 256))*1.8
alter VB7 = $&drive
stop when time = 0.002688
resume
delete all
let endpoint = length(time)-1
let cmp = v(COMP)[endpoint]
let top = v(TOP)[endpoint]
let decision = 0
if cmp >= 0.9
let code = trial
let decision = 1
end
echo 149 6 $&trial $&cmp $&top 0.68671875 $&decision >> decisions.csv
let trial = code + 32
let drive = (floor(trial / 1) - 2*floor(trial / 2))*1.8
alter VB0 = $&drive
let drive = (floor(trial / 2) - 2*floor(trial / 4))*1.8
alter VB1 = $&drive
let drive = (floor(trial / 4) - 2*floor(trial / 8))*1.8
alter VB2 = $&drive
let drive = (floor(trial / 8) - 2*floor(trial / 16))*1.8
alter VB3 = $&drive
let drive = (floor(trial / 16) - 2*floor(trial / 32))*1.8
alter VB4 = $&drive
let drive = (floor(trial / 32) - 2*floor(trial / 64))*1.8
alter VB5 = $&drive
let drive = (floor(trial / 64) - 2*floor(trial / 128))*1.8
alter VB6 = $&drive
let drive = (floor(trial / 128) - 2*floor(trial / 256))*1.8
alter VB7 = $&drive
stop when time = 0.00269
resume
delete all
let endpoint = length(time)-1
let cmp = v(COMP)[endpoint]
let top = v(TOP)[endpoint]
let decision = 0
if cmp >= 0.9
let code = trial
let decision = 1
end
echo 149 5 $&trial $&cmp $&top 0.68671875 $&decision >> decisions.csv
let trial = code + 16
let drive = (floor(trial / 1) - 2*floor(trial / 2))*1.8
alter VB0 = $&drive
let drive = (floor(trial / 2) - 2*floor(trial / 4))*1.8
alter VB1 = $&drive
let drive = (floor(trial / 4) - 2*floor(trial / 8))*1.8
alter VB2 = $&drive
let drive = (floor(trial / 8) - 2*floor(trial / 16))*1.8
alter VB3 = $&drive
let drive = (floor(trial / 16) - 2*floor(trial / 32))*1.8
alter VB4 = $&drive
let drive = (floor(trial / 32) - 2*floor(trial / 64))*1.8
alter VB5 = $&drive
let drive = (floor(trial / 64) - 2*floor(trial / 128))*1.8
alter VB6 = $&drive
let drive = (floor(trial / 128) - 2*floor(trial / 256))*1.8
alter VB7 = $&drive
stop when time = 0.002692
resume
delete all
let endpoint = length(time)-1
let cmp = v(COMP)[endpoint]
let top = v(TOP)[endpoint]
let decision = 0
if cmp >= 0.9
let code = trial
let decision = 1
end
echo 149 4 $&trial $&cmp $&top 0.68671875 $&decision >> decisions.csv
let trial = code + 8
let drive = (floor(trial / 1) - 2*floor(trial / 2))*1.8
alter VB0 = $&drive
let drive = (floor(trial / 2) - 2*floor(trial / 4))*1.8
alter VB1 = $&drive
let drive = (floor(trial / 4) - 2*floor(trial / 8))*1.8
alter VB2 = $&drive
let drive = (floor(trial / 8) - 2*floor(trial / 16))*1.8
alter VB3 = $&drive
let drive = (floor(trial / 16) - 2*floor(trial / 32))*1.8
alter VB4 = $&drive
let drive = (floor(trial / 32) - 2*floor(trial / 64))*1.8
alter VB5 = $&drive
let drive = (floor(trial / 64) - 2*floor(trial / 128))*1.8
alter VB6 = $&drive
let drive = (floor(trial / 128) - 2*floor(trial / 256))*1.8
alter VB7 = $&drive
stop when time = 0.002694
resume
delete all
let endpoint = length(time)-1
let cmp = v(COMP)[endpoint]
let top = v(TOP)[endpoint]
let decision = 0
if cmp >= 0.9
let code = trial
let decision = 1
end
echo 149 3 $&trial $&cmp $&top 0.68671875 $&decision >> decisions.csv
let trial = code + 4
let drive = (floor(trial / 1) - 2*floor(trial / 2))*1.8
alter VB0 = $&drive
let drive = (floor(trial / 2) - 2*floor(trial / 4))*1.8
alter VB1 = $&drive
let drive = (floor(trial / 4) - 2*floor(trial / 8))*1.8
alter VB2 = $&drive
let drive = (floor(trial / 8) - 2*floor(trial / 16))*1.8
alter VB3 = $&drive
let drive = (floor(trial / 16) - 2*floor(trial / 32))*1.8
alter VB4 = $&drive
let drive = (floor(trial / 32) - 2*floor(trial / 64))*1.8
alter VB5 = $&drive
let drive = (floor(trial / 64) - 2*floor(trial / 128))*1.8
alter VB6 = $&drive
let drive = (floor(trial / 128) - 2*floor(trial / 256))*1.8
alter VB7 = $&drive
stop when time = 0.002696
resume
delete all
let endpoint = length(time)-1
let cmp = v(COMP)[endpoint]
let top = v(TOP)[endpoint]
let decision = 0
if cmp >= 0.9
let code = trial
let decision = 1
end
echo 149 2 $&trial $&cmp $&top 0.68671875 $&decision >> decisions.csv
let trial = code + 2
let drive = (floor(trial / 1) - 2*floor(trial / 2))*1.8
alter VB0 = $&drive
let drive = (floor(trial / 2) - 2*floor(trial / 4))*1.8
alter VB1 = $&drive
let drive = (floor(trial / 4) - 2*floor(trial / 8))*1.8
alter VB2 = $&drive
let drive = (floor(trial / 8) - 2*floor(trial / 16))*1.8
alter VB3 = $&drive
let drive = (floor(trial / 16) - 2*floor(trial / 32))*1.8
alter VB4 = $&drive
let drive = (floor(trial / 32) - 2*floor(trial / 64))*1.8
alter VB5 = $&drive
let drive = (floor(trial / 64) - 2*floor(trial / 128))*1.8
alter VB6 = $&drive
let drive = (floor(trial / 128) - 2*floor(trial / 256))*1.8
alter VB7 = $&drive
stop when time = 0.002698
resume
delete all
let endpoint = length(time)-1
let cmp = v(COMP)[endpoint]
let top = v(TOP)[endpoint]
let decision = 0
if cmp >= 0.9
let code = trial
let decision = 1
end
echo 149 1 $&trial $&cmp $&top 0.68671875 $&decision >> decisions.csv
let trial = code + 1
let drive = (floor(trial / 1) - 2*floor(trial / 2))*1.8
alter VB0 = $&drive
let drive = (floor(trial / 2) - 2*floor(trial / 4))*1.8
alter VB1 = $&drive
let drive = (floor(trial / 4) - 2*floor(trial / 8))*1.8
alter VB2 = $&drive
let drive = (floor(trial / 8) - 2*floor(trial / 16))*1.8
alter VB3 = $&drive
let drive = (floor(trial / 16) - 2*floor(trial / 32))*1.8
alter VB4 = $&drive
let drive = (floor(trial / 32) - 2*floor(trial / 64))*1.8
alter VB5 = $&drive
let drive = (floor(trial / 64) - 2*floor(trial / 128))*1.8
alter VB6 = $&drive
let drive = (floor(trial / 128) - 2*floor(trial / 256))*1.8
alter VB7 = $&drive
stop when time = 0.0027
resume
delete all
let endpoint = length(time)-1
let cmp = v(COMP)[endpoint]
let top = v(TOP)[endpoint]
let decision = 0
if cmp >= 0.9
let code = trial
let decision = 1
end
echo 149 0 $&trial $&cmp $&top 0.68671875 $&decision >> decisions.csv
alter VIN = 0.69140625
alter VSAMPLE = 1.8
alter VB0 = 0
alter VB1 = 0
alter VB2 = 0
alter VB3 = 0
alter VB4 = 0
alter VB5 = 0
alter VB6 = 0
alter VB7 = 0
let code = 0
stop when time = 0.002702
resume
delete all
alter VSAMPLE = 0
let trial = code + 128
let drive = (floor(trial / 1) - 2*floor(trial / 2))*1.8
alter VB0 = $&drive
let drive = (floor(trial / 2) - 2*floor(trial / 4))*1.8
alter VB1 = $&drive
let drive = (floor(trial / 4) - 2*floor(trial / 8))*1.8
alter VB2 = $&drive
let drive = (floor(trial / 8) - 2*floor(trial / 16))*1.8
alter VB3 = $&drive
let drive = (floor(trial / 16) - 2*floor(trial / 32))*1.8
alter VB4 = $&drive
let drive = (floor(trial / 32) - 2*floor(trial / 64))*1.8
alter VB5 = $&drive
let drive = (floor(trial / 64) - 2*floor(trial / 128))*1.8
alter VB6 = $&drive
let drive = (floor(trial / 128) - 2*floor(trial / 256))*1.8
alter VB7 = $&drive
stop when time = 0.002704
resume
delete all
let endpoint = length(time)-1
let cmp = v(COMP)[endpoint]
let top = v(TOP)[endpoint]
let decision = 0
if cmp >= 0.9
let code = trial
let decision = 1
end
echo 150 7 $&trial $&cmp $&top 0.69140625 $&decision >> decisions.csv
let trial = code + 64
let drive = (floor(trial / 1) - 2*floor(trial / 2))*1.8
alter VB0 = $&drive
let drive = (floor(trial / 2) - 2*floor(trial / 4))*1.8
alter VB1 = $&drive
let drive = (floor(trial / 4) - 2*floor(trial / 8))*1.8
alter VB2 = $&drive
let drive = (floor(trial / 8) - 2*floor(trial / 16))*1.8
alter VB3 = $&drive
let drive = (floor(trial / 16) - 2*floor(trial / 32))*1.8
alter VB4 = $&drive
let drive = (floor(trial / 32) - 2*floor(trial / 64))*1.8
alter VB5 = $&drive
let drive = (floor(trial / 64) - 2*floor(trial / 128))*1.8
alter VB6 = $&drive
let drive = (floor(trial / 128) - 2*floor(trial / 256))*1.8
alter VB7 = $&drive
stop when time = 0.002706
resume
delete all
let endpoint = length(time)-1
let cmp = v(COMP)[endpoint]
let top = v(TOP)[endpoint]
let decision = 0
if cmp >= 0.9
let code = trial
let decision = 1
end
echo 150 6 $&trial $&cmp $&top 0.69140625 $&decision >> decisions.csv
let trial = code + 32
let drive = (floor(trial / 1) - 2*floor(trial / 2))*1.8
alter VB0 = $&drive
let drive = (floor(trial / 2) - 2*floor(trial / 4))*1.8
alter VB1 = $&drive
let drive = (floor(trial / 4) - 2*floor(trial / 8))*1.8
alter VB2 = $&drive
let drive = (floor(trial / 8) - 2*floor(trial / 16))*1.8
alter VB3 = $&drive
let drive = (floor(trial / 16) - 2*floor(trial / 32))*1.8
alter VB4 = $&drive
let drive = (floor(trial / 32) - 2*floor(trial / 64))*1.8
alter VB5 = $&drive
let drive = (floor(trial / 64) - 2*floor(trial / 128))*1.8
alter VB6 = $&drive
let drive = (floor(trial / 128) - 2*floor(trial / 256))*1.8
alter VB7 = $&drive
stop when time = 0.002708
resume
delete all
let endpoint = length(time)-1
let cmp = v(COMP)[endpoint]
let top = v(TOP)[endpoint]
let decision = 0
if cmp >= 0.9
let code = trial
let decision = 1
end
echo 150 5 $&trial $&cmp $&top 0.69140625 $&decision >> decisions.csv
let trial = code + 16
let drive = (floor(trial / 1) - 2*floor(trial / 2))*1.8
alter VB0 = $&drive
let drive = (floor(trial / 2) - 2*floor(trial / 4))*1.8
alter VB1 = $&drive
let drive = (floor(trial / 4) - 2*floor(trial / 8))*1.8
alter VB2 = $&drive
let drive = (floor(trial / 8) - 2*floor(trial / 16))*1.8
alter VB3 = $&drive
let drive = (floor(trial / 16) - 2*floor(trial / 32))*1.8
alter VB4 = $&drive
let drive = (floor(trial / 32) - 2*floor(trial / 64))*1.8
alter VB5 = $&drive
let drive = (floor(trial / 64) - 2*floor(trial / 128))*1.8
alter VB6 = $&drive
let drive = (floor(trial / 128) - 2*floor(trial / 256))*1.8
alter VB7 = $&drive
stop when time = 0.00271
resume
delete all
let endpoint = length(time)-1
let cmp = v(COMP)[endpoint]
let top = v(TOP)[endpoint]
let decision = 0
if cmp >= 0.9
let code = trial
let decision = 1
end
echo 150 4 $&trial $&cmp $&top 0.69140625 $&decision >> decisions.csv
let trial = code + 8
let drive = (floor(trial / 1) - 2*floor(trial / 2))*1.8
alter VB0 = $&drive
let drive = (floor(trial / 2) - 2*floor(trial / 4))*1.8
alter VB1 = $&drive
let drive = (floor(trial / 4) - 2*floor(trial / 8))*1.8
alter VB2 = $&drive
let drive = (floor(trial / 8) - 2*floor(trial / 16))*1.8
alter VB3 = $&drive
let drive = (floor(trial / 16) - 2*floor(trial / 32))*1.8
alter VB4 = $&drive
let drive = (floor(trial / 32) - 2*floor(trial / 64))*1.8
alter VB5 = $&drive
let drive = (floor(trial / 64) - 2*floor(trial / 128))*1.8
alter VB6 = $&drive
let drive = (floor(trial / 128) - 2*floor(trial / 256))*1.8
alter VB7 = $&drive
stop when time = 0.002712
resume
delete all
let endpoint = length(time)-1
let cmp = v(COMP)[endpoint]
let top = v(TOP)[endpoint]
let decision = 0
if cmp >= 0.9
let code = trial
let decision = 1
end
echo 150 3 $&trial $&cmp $&top 0.69140625 $&decision >> decisions.csv
let trial = code + 4
let drive = (floor(trial / 1) - 2*floor(trial / 2))*1.8
alter VB0 = $&drive
let drive = (floor(trial / 2) - 2*floor(trial / 4))*1.8
alter VB1 = $&drive
let drive = (floor(trial / 4) - 2*floor(trial / 8))*1.8
alter VB2 = $&drive
let drive = (floor(trial / 8) - 2*floor(trial / 16))*1.8
alter VB3 = $&drive
let drive = (floor(trial / 16) - 2*floor(trial / 32))*1.8
alter VB4 = $&drive
let drive = (floor(trial / 32) - 2*floor(trial / 64))*1.8
alter VB5 = $&drive
let drive = (floor(trial / 64) - 2*floor(trial / 128))*1.8
alter VB6 = $&drive
let drive = (floor(trial / 128) - 2*floor(trial / 256))*1.8
alter VB7 = $&drive
stop when time = 0.002714
resume
delete all
let endpoint = length(time)-1
let cmp = v(COMP)[endpoint]
let top = v(TOP)[endpoint]
let decision = 0
if cmp >= 0.9
let code = trial
let decision = 1
end
echo 150 2 $&trial $&cmp $&top 0.69140625 $&decision >> decisions.csv
let trial = code + 2
let drive = (floor(trial / 1) - 2*floor(trial / 2))*1.8
alter VB0 = $&drive
let drive = (floor(trial / 2) - 2*floor(trial / 4))*1.8
alter VB1 = $&drive
let drive = (floor(trial / 4) - 2*floor(trial / 8))*1.8
alter VB2 = $&drive
let drive = (floor(trial / 8) - 2*floor(trial / 16))*1.8
alter VB3 = $&drive
let drive = (floor(trial / 16) - 2*floor(trial / 32))*1.8
alter VB4 = $&drive
let drive = (floor(trial / 32) - 2*floor(trial / 64))*1.8
alter VB5 = $&drive
let drive = (floor(trial / 64) - 2*floor(trial / 128))*1.8
alter VB6 = $&drive
let drive = (floor(trial / 128) - 2*floor(trial / 256))*1.8
alter VB7 = $&drive
stop when time = 0.002716
resume
delete all
let endpoint = length(time)-1
let cmp = v(COMP)[endpoint]
let top = v(TOP)[endpoint]
let decision = 0
if cmp >= 0.9
let code = trial
let decision = 1
end
echo 150 1 $&trial $&cmp $&top 0.69140625 $&decision >> decisions.csv
let trial = code + 1
let drive = (floor(trial / 1) - 2*floor(trial / 2))*1.8
alter VB0 = $&drive
let drive = (floor(trial / 2) - 2*floor(trial / 4))*1.8
alter VB1 = $&drive
let drive = (floor(trial / 4) - 2*floor(trial / 8))*1.8
alter VB2 = $&drive
let drive = (floor(trial / 8) - 2*floor(trial / 16))*1.8
alter VB3 = $&drive
let drive = (floor(trial / 16) - 2*floor(trial / 32))*1.8
alter VB4 = $&drive
let drive = (floor(trial / 32) - 2*floor(trial / 64))*1.8
alter VB5 = $&drive
let drive = (floor(trial / 64) - 2*floor(trial / 128))*1.8
alter VB6 = $&drive
let drive = (floor(trial / 128) - 2*floor(trial / 256))*1.8
alter VB7 = $&drive
stop when time = 0.002718
resume
delete all
let endpoint = length(time)-1
let cmp = v(COMP)[endpoint]
let top = v(TOP)[endpoint]
let decision = 0
if cmp >= 0.9
let code = trial
let decision = 1
end
echo 150 0 $&trial $&cmp $&top 0.69140625 $&decision >> decisions.csv
alter VIN = 0.69609375
alter VSAMPLE = 1.8
alter VB0 = 0
alter VB1 = 0
alter VB2 = 0
alter VB3 = 0
alter VB4 = 0
alter VB5 = 0
alter VB6 = 0
alter VB7 = 0
let code = 0
stop when time = 0.00272
resume
delete all
alter VSAMPLE = 0
let trial = code + 128
let drive = (floor(trial / 1) - 2*floor(trial / 2))*1.8
alter VB0 = $&drive
let drive = (floor(trial / 2) - 2*floor(trial / 4))*1.8
alter VB1 = $&drive
let drive = (floor(trial / 4) - 2*floor(trial / 8))*1.8
alter VB2 = $&drive
let drive = (floor(trial / 8) - 2*floor(trial / 16))*1.8
alter VB3 = $&drive
let drive = (floor(trial / 16) - 2*floor(trial / 32))*1.8
alter VB4 = $&drive
let drive = (floor(trial / 32) - 2*floor(trial / 64))*1.8
alter VB5 = $&drive
let drive = (floor(trial / 64) - 2*floor(trial / 128))*1.8
alter VB6 = $&drive
let drive = (floor(trial / 128) - 2*floor(trial / 256))*1.8
alter VB7 = $&drive
stop when time = 0.002722
resume
delete all
let endpoint = length(time)-1
let cmp = v(COMP)[endpoint]
let top = v(TOP)[endpoint]
let decision = 0
if cmp >= 0.9
let code = trial
let decision = 1
end
echo 151 7 $&trial $&cmp $&top 0.69609375 $&decision >> decisions.csv
let trial = code + 64
let drive = (floor(trial / 1) - 2*floor(trial / 2))*1.8
alter VB0 = $&drive
let drive = (floor(trial / 2) - 2*floor(trial / 4))*1.8
alter VB1 = $&drive
let drive = (floor(trial / 4) - 2*floor(trial / 8))*1.8
alter VB2 = $&drive
let drive = (floor(trial / 8) - 2*floor(trial / 16))*1.8
alter VB3 = $&drive
let drive = (floor(trial / 16) - 2*floor(trial / 32))*1.8
alter VB4 = $&drive
let drive = (floor(trial / 32) - 2*floor(trial / 64))*1.8
alter VB5 = $&drive
let drive = (floor(trial / 64) - 2*floor(trial / 128))*1.8
alter VB6 = $&drive
let drive = (floor(trial / 128) - 2*floor(trial / 256))*1.8
alter VB7 = $&drive
stop when time = 0.002724
resume
delete all
let endpoint = length(time)-1
let cmp = v(COMP)[endpoint]
let top = v(TOP)[endpoint]
let decision = 0
if cmp >= 0.9
let code = trial
let decision = 1
end
echo 151 6 $&trial $&cmp $&top 0.69609375 $&decision >> decisions.csv
let trial = code + 32
let drive = (floor(trial / 1) - 2*floor(trial / 2))*1.8
alter VB0 = $&drive
let drive = (floor(trial / 2) - 2*floor(trial / 4))*1.8
alter VB1 = $&drive
let drive = (floor(trial / 4) - 2*floor(trial / 8))*1.8
alter VB2 = $&drive
let drive = (floor(trial / 8) - 2*floor(trial / 16))*1.8
alter VB3 = $&drive
let drive = (floor(trial / 16) - 2*floor(trial / 32))*1.8
alter VB4 = $&drive
let drive = (floor(trial / 32) - 2*floor(trial / 64))*1.8
alter VB5 = $&drive
let drive = (floor(trial / 64) - 2*floor(trial / 128))*1.8
alter VB6 = $&drive
let drive = (floor(trial / 128) - 2*floor(trial / 256))*1.8
alter VB7 = $&drive
stop when time = 0.002726
resume
delete all
let endpoint = length(time)-1
let cmp = v(COMP)[endpoint]
let top = v(TOP)[endpoint]
let decision = 0
if cmp >= 0.9
let code = trial
let decision = 1
end
echo 151 5 $&trial $&cmp $&top 0.69609375 $&decision >> decisions.csv
let trial = code + 16
let drive = (floor(trial / 1) - 2*floor(trial / 2))*1.8
alter VB0 = $&drive
let drive = (floor(trial / 2) - 2*floor(trial / 4))*1.8
alter VB1 = $&drive
let drive = (floor(trial / 4) - 2*floor(trial / 8))*1.8
alter VB2 = $&drive
let drive = (floor(trial / 8) - 2*floor(trial / 16))*1.8
alter VB3 = $&drive
let drive = (floor(trial / 16) - 2*floor(trial / 32))*1.8
alter VB4 = $&drive
let drive = (floor(trial / 32) - 2*floor(trial / 64))*1.8
alter VB5 = $&drive
let drive = (floor(trial / 64) - 2*floor(trial / 128))*1.8
alter VB6 = $&drive
let drive = (floor(trial / 128) - 2*floor(trial / 256))*1.8
alter VB7 = $&drive
stop when time = 0.002728
resume
delete all
let endpoint = length(time)-1
let cmp = v(COMP)[endpoint]
let top = v(TOP)[endpoint]
let decision = 0
if cmp >= 0.9
let code = trial
let decision = 1
end
echo 151 4 $&trial $&cmp $&top 0.69609375 $&decision >> decisions.csv
let trial = code + 8
let drive = (floor(trial / 1) - 2*floor(trial / 2))*1.8
alter VB0 = $&drive
let drive = (floor(trial / 2) - 2*floor(trial / 4))*1.8
alter VB1 = $&drive
let drive = (floor(trial / 4) - 2*floor(trial / 8))*1.8
alter VB2 = $&drive
let drive = (floor(trial / 8) - 2*floor(trial / 16))*1.8
alter VB3 = $&drive
let drive = (floor(trial / 16) - 2*floor(trial / 32))*1.8
alter VB4 = $&drive
let drive = (floor(trial / 32) - 2*floor(trial / 64))*1.8
alter VB5 = $&drive
let drive = (floor(trial / 64) - 2*floor(trial / 128))*1.8
alter VB6 = $&drive
let drive = (floor(trial / 128) - 2*floor(trial / 256))*1.8
alter VB7 = $&drive
stop when time = 0.00273
resume
delete all
let endpoint = length(time)-1
let cmp = v(COMP)[endpoint]
let top = v(TOP)[endpoint]
let decision = 0
if cmp >= 0.9
let code = trial
let decision = 1
end
echo 151 3 $&trial $&cmp $&top 0.69609375 $&decision >> decisions.csv
let trial = code + 4
let drive = (floor(trial / 1) - 2*floor(trial / 2))*1.8
alter VB0 = $&drive
let drive = (floor(trial / 2) - 2*floor(trial / 4))*1.8
alter VB1 = $&drive
let drive = (floor(trial / 4) - 2*floor(trial / 8))*1.8
alter VB2 = $&drive
let drive = (floor(trial / 8) - 2*floor(trial / 16))*1.8
alter VB3 = $&drive
let drive = (floor(trial / 16) - 2*floor(trial / 32))*1.8
alter VB4 = $&drive
let drive = (floor(trial / 32) - 2*floor(trial / 64))*1.8
alter VB5 = $&drive
let drive = (floor(trial / 64) - 2*floor(trial / 128))*1.8
alter VB6 = $&drive
let drive = (floor(trial / 128) - 2*floor(trial / 256))*1.8
alter VB7 = $&drive
stop when time = 0.002732
resume
delete all
let endpoint = length(time)-1
let cmp = v(COMP)[endpoint]
let top = v(TOP)[endpoint]
let decision = 0
if cmp >= 0.9
let code = trial
let decision = 1
end
echo 151 2 $&trial $&cmp $&top 0.69609375 $&decision >> decisions.csv
let trial = code + 2
let drive = (floor(trial / 1) - 2*floor(trial / 2))*1.8
alter VB0 = $&drive
let drive = (floor(trial / 2) - 2*floor(trial / 4))*1.8
alter VB1 = $&drive
let drive = (floor(trial / 4) - 2*floor(trial / 8))*1.8
alter VB2 = $&drive
let drive = (floor(trial / 8) - 2*floor(trial / 16))*1.8
alter VB3 = $&drive
let drive = (floor(trial / 16) - 2*floor(trial / 32))*1.8
alter VB4 = $&drive
let drive = (floor(trial / 32) - 2*floor(trial / 64))*1.8
alter VB5 = $&drive
let drive = (floor(trial / 64) - 2*floor(trial / 128))*1.8
alter VB6 = $&drive
let drive = (floor(trial / 128) - 2*floor(trial / 256))*1.8
alter VB7 = $&drive
stop when time = 0.002734
resume
delete all
let endpoint = length(time)-1
let cmp = v(COMP)[endpoint]
let top = v(TOP)[endpoint]
let decision = 0
if cmp >= 0.9
let code = trial
let decision = 1
end
echo 151 1 $&trial $&cmp $&top 0.69609375 $&decision >> decisions.csv
let trial = code + 1
let drive = (floor(trial / 1) - 2*floor(trial / 2))*1.8
alter VB0 = $&drive
let drive = (floor(trial / 2) - 2*floor(trial / 4))*1.8
alter VB1 = $&drive
let drive = (floor(trial / 4) - 2*floor(trial / 8))*1.8
alter VB2 = $&drive
let drive = (floor(trial / 8) - 2*floor(trial / 16))*1.8
alter VB3 = $&drive
let drive = (floor(trial / 16) - 2*floor(trial / 32))*1.8
alter VB4 = $&drive
let drive = (floor(trial / 32) - 2*floor(trial / 64))*1.8
alter VB5 = $&drive
let drive = (floor(trial / 64) - 2*floor(trial / 128))*1.8
alter VB6 = $&drive
let drive = (floor(trial / 128) - 2*floor(trial / 256))*1.8
alter VB7 = $&drive
stop when time = 0.002736
resume
delete all
let endpoint = length(time)-1
let cmp = v(COMP)[endpoint]
let top = v(TOP)[endpoint]
let decision = 0
if cmp >= 0.9
let code = trial
let decision = 1
end
echo 151 0 $&trial $&cmp $&top 0.69609375 $&decision >> decisions.csv
alter VIN = 0.70078125
alter VSAMPLE = 1.8
alter VB0 = 0
alter VB1 = 0
alter VB2 = 0
alter VB3 = 0
alter VB4 = 0
alter VB5 = 0
alter VB6 = 0
alter VB7 = 0
let code = 0
stop when time = 0.002738
resume
delete all
alter VSAMPLE = 0
let trial = code + 128
let drive = (floor(trial / 1) - 2*floor(trial / 2))*1.8
alter VB0 = $&drive
let drive = (floor(trial / 2) - 2*floor(trial / 4))*1.8
alter VB1 = $&drive
let drive = (floor(trial / 4) - 2*floor(trial / 8))*1.8
alter VB2 = $&drive
let drive = (floor(trial / 8) - 2*floor(trial / 16))*1.8
alter VB3 = $&drive
let drive = (floor(trial / 16) - 2*floor(trial / 32))*1.8
alter VB4 = $&drive
let drive = (floor(trial / 32) - 2*floor(trial / 64))*1.8
alter VB5 = $&drive
let drive = (floor(trial / 64) - 2*floor(trial / 128))*1.8
alter VB6 = $&drive
let drive = (floor(trial / 128) - 2*floor(trial / 256))*1.8
alter VB7 = $&drive
stop when time = 0.00274
resume
delete all
let endpoint = length(time)-1
let cmp = v(COMP)[endpoint]
let top = v(TOP)[endpoint]
let decision = 0
if cmp >= 0.9
let code = trial
let decision = 1
end
echo 152 7 $&trial $&cmp $&top 0.70078125 $&decision >> decisions.csv
let trial = code + 64
let drive = (floor(trial / 1) - 2*floor(trial / 2))*1.8
alter VB0 = $&drive
let drive = (floor(trial / 2) - 2*floor(trial / 4))*1.8
alter VB1 = $&drive
let drive = (floor(trial / 4) - 2*floor(trial / 8))*1.8
alter VB2 = $&drive
let drive = (floor(trial / 8) - 2*floor(trial / 16))*1.8
alter VB3 = $&drive
let drive = (floor(trial / 16) - 2*floor(trial / 32))*1.8
alter VB4 = $&drive
let drive = (floor(trial / 32) - 2*floor(trial / 64))*1.8
alter VB5 = $&drive
let drive = (floor(trial / 64) - 2*floor(trial / 128))*1.8
alter VB6 = $&drive
let drive = (floor(trial / 128) - 2*floor(trial / 256))*1.8
alter VB7 = $&drive
stop when time = 0.002742
resume
delete all
let endpoint = length(time)-1
let cmp = v(COMP)[endpoint]
let top = v(TOP)[endpoint]
let decision = 0
if cmp >= 0.9
let code = trial
let decision = 1
end
echo 152 6 $&trial $&cmp $&top 0.70078125 $&decision >> decisions.csv
let trial = code + 32
let drive = (floor(trial / 1) - 2*floor(trial / 2))*1.8
alter VB0 = $&drive
let drive = (floor(trial / 2) - 2*floor(trial / 4))*1.8
alter VB1 = $&drive
let drive = (floor(trial / 4) - 2*floor(trial / 8))*1.8
alter VB2 = $&drive
let drive = (floor(trial / 8) - 2*floor(trial / 16))*1.8
alter VB3 = $&drive
let drive = (floor(trial / 16) - 2*floor(trial / 32))*1.8
alter VB4 = $&drive
let drive = (floor(trial / 32) - 2*floor(trial / 64))*1.8
alter VB5 = $&drive
let drive = (floor(trial / 64) - 2*floor(trial / 128))*1.8
alter VB6 = $&drive
let drive = (floor(trial / 128) - 2*floor(trial / 256))*1.8
alter VB7 = $&drive
stop when time = 0.002744
resume
delete all
let endpoint = length(time)-1
let cmp = v(COMP)[endpoint]
let top = v(TOP)[endpoint]
let decision = 0
if cmp >= 0.9
let code = trial
let decision = 1
end
echo 152 5 $&trial $&cmp $&top 0.70078125 $&decision >> decisions.csv
let trial = code + 16
let drive = (floor(trial / 1) - 2*floor(trial / 2))*1.8
alter VB0 = $&drive
let drive = (floor(trial / 2) - 2*floor(trial / 4))*1.8
alter VB1 = $&drive
let drive = (floor(trial / 4) - 2*floor(trial / 8))*1.8
alter VB2 = $&drive
let drive = (floor(trial / 8) - 2*floor(trial / 16))*1.8
alter VB3 = $&drive
let drive = (floor(trial / 16) - 2*floor(trial / 32))*1.8
alter VB4 = $&drive
let drive = (floor(trial / 32) - 2*floor(trial / 64))*1.8
alter VB5 = $&drive
let drive = (floor(trial / 64) - 2*floor(trial / 128))*1.8
alter VB6 = $&drive
let drive = (floor(trial / 128) - 2*floor(trial / 256))*1.8
alter VB7 = $&drive
stop when time = 0.002746
resume
delete all
let endpoint = length(time)-1
let cmp = v(COMP)[endpoint]
let top = v(TOP)[endpoint]
let decision = 0
if cmp >= 0.9
let code = trial
let decision = 1
end
echo 152 4 $&trial $&cmp $&top 0.70078125 $&decision >> decisions.csv
let trial = code + 8
let drive = (floor(trial / 1) - 2*floor(trial / 2))*1.8
alter VB0 = $&drive
let drive = (floor(trial / 2) - 2*floor(trial / 4))*1.8
alter VB1 = $&drive
let drive = (floor(trial / 4) - 2*floor(trial / 8))*1.8
alter VB2 = $&drive
let drive = (floor(trial / 8) - 2*floor(trial / 16))*1.8
alter VB3 = $&drive
let drive = (floor(trial / 16) - 2*floor(trial / 32))*1.8
alter VB4 = $&drive
let drive = (floor(trial / 32) - 2*floor(trial / 64))*1.8
alter VB5 = $&drive
let drive = (floor(trial / 64) - 2*floor(trial / 128))*1.8
alter VB6 = $&drive
let drive = (floor(trial / 128) - 2*floor(trial / 256))*1.8
alter VB7 = $&drive
stop when time = 0.002748
resume
delete all
let endpoint = length(time)-1
let cmp = v(COMP)[endpoint]
let top = v(TOP)[endpoint]
let decision = 0
if cmp >= 0.9
let code = trial
let decision = 1
end
echo 152 3 $&trial $&cmp $&top 0.70078125 $&decision >> decisions.csv
let trial = code + 4
let drive = (floor(trial / 1) - 2*floor(trial / 2))*1.8
alter VB0 = $&drive
let drive = (floor(trial / 2) - 2*floor(trial / 4))*1.8
alter VB1 = $&drive
let drive = (floor(trial / 4) - 2*floor(trial / 8))*1.8
alter VB2 = $&drive
let drive = (floor(trial / 8) - 2*floor(trial / 16))*1.8
alter VB3 = $&drive
let drive = (floor(trial / 16) - 2*floor(trial / 32))*1.8
alter VB4 = $&drive
let drive = (floor(trial / 32) - 2*floor(trial / 64))*1.8
alter VB5 = $&drive
let drive = (floor(trial / 64) - 2*floor(trial / 128))*1.8
alter VB6 = $&drive
let drive = (floor(trial / 128) - 2*floor(trial / 256))*1.8
alter VB7 = $&drive
stop when time = 0.00275
resume
delete all
let endpoint = length(time)-1
let cmp = v(COMP)[endpoint]
let top = v(TOP)[endpoint]
let decision = 0
if cmp >= 0.9
let code = trial
let decision = 1
end
echo 152 2 $&trial $&cmp $&top 0.70078125 $&decision >> decisions.csv
let trial = code + 2
let drive = (floor(trial / 1) - 2*floor(trial / 2))*1.8
alter VB0 = $&drive
let drive = (floor(trial / 2) - 2*floor(trial / 4))*1.8
alter VB1 = $&drive
let drive = (floor(trial / 4) - 2*floor(trial / 8))*1.8
alter VB2 = $&drive
let drive = (floor(trial / 8) - 2*floor(trial / 16))*1.8
alter VB3 = $&drive
let drive = (floor(trial / 16) - 2*floor(trial / 32))*1.8
alter VB4 = $&drive
let drive = (floor(trial / 32) - 2*floor(trial / 64))*1.8
alter VB5 = $&drive
let drive = (floor(trial / 64) - 2*floor(trial / 128))*1.8
alter VB6 = $&drive
let drive = (floor(trial / 128) - 2*floor(trial / 256))*1.8
alter VB7 = $&drive
stop when time = 0.002752
resume
delete all
let endpoint = length(time)-1
let cmp = v(COMP)[endpoint]
let top = v(TOP)[endpoint]
let decision = 0
if cmp >= 0.9
let code = trial
let decision = 1
end
echo 152 1 $&trial $&cmp $&top 0.70078125 $&decision >> decisions.csv
let trial = code + 1
let drive = (floor(trial / 1) - 2*floor(trial / 2))*1.8
alter VB0 = $&drive
let drive = (floor(trial / 2) - 2*floor(trial / 4))*1.8
alter VB1 = $&drive
let drive = (floor(trial / 4) - 2*floor(trial / 8))*1.8
alter VB2 = $&drive
let drive = (floor(trial / 8) - 2*floor(trial / 16))*1.8
alter VB3 = $&drive
let drive = (floor(trial / 16) - 2*floor(trial / 32))*1.8
alter VB4 = $&drive
let drive = (floor(trial / 32) - 2*floor(trial / 64))*1.8
alter VB5 = $&drive
let drive = (floor(trial / 64) - 2*floor(trial / 128))*1.8
alter VB6 = $&drive
let drive = (floor(trial / 128) - 2*floor(trial / 256))*1.8
alter VB7 = $&drive
stop when time = 0.002754
resume
delete all
let endpoint = length(time)-1
let cmp = v(COMP)[endpoint]
let top = v(TOP)[endpoint]
let decision = 0
if cmp >= 0.9
let code = trial
let decision = 1
end
echo 152 0 $&trial $&cmp $&top 0.70078125 $&decision >> decisions.csv
alter VIN = 0.70546875
alter VSAMPLE = 1.8
alter VB0 = 0
alter VB1 = 0
alter VB2 = 0
alter VB3 = 0
alter VB4 = 0
alter VB5 = 0
alter VB6 = 0
alter VB7 = 0
let code = 0
stop when time = 0.002756
resume
delete all
alter VSAMPLE = 0
let trial = code + 128
let drive = (floor(trial / 1) - 2*floor(trial / 2))*1.8
alter VB0 = $&drive
let drive = (floor(trial / 2) - 2*floor(trial / 4))*1.8
alter VB1 = $&drive
let drive = (floor(trial / 4) - 2*floor(trial / 8))*1.8
alter VB2 = $&drive
let drive = (floor(trial / 8) - 2*floor(trial / 16))*1.8
alter VB3 = $&drive
let drive = (floor(trial / 16) - 2*floor(trial / 32))*1.8
alter VB4 = $&drive
let drive = (floor(trial / 32) - 2*floor(trial / 64))*1.8
alter VB5 = $&drive
let drive = (floor(trial / 64) - 2*floor(trial / 128))*1.8
alter VB6 = $&drive
let drive = (floor(trial / 128) - 2*floor(trial / 256))*1.8
alter VB7 = $&drive
stop when time = 0.002758
resume
delete all
let endpoint = length(time)-1
let cmp = v(COMP)[endpoint]
let top = v(TOP)[endpoint]
let decision = 0
if cmp >= 0.9
let code = trial
let decision = 1
end
echo 153 7 $&trial $&cmp $&top 0.70546875 $&decision >> decisions.csv
let trial = code + 64
let drive = (floor(trial / 1) - 2*floor(trial / 2))*1.8
alter VB0 = $&drive
let drive = (floor(trial / 2) - 2*floor(trial / 4))*1.8
alter VB1 = $&drive
let drive = (floor(trial / 4) - 2*floor(trial / 8))*1.8
alter VB2 = $&drive
let drive = (floor(trial / 8) - 2*floor(trial / 16))*1.8
alter VB3 = $&drive
let drive = (floor(trial / 16) - 2*floor(trial / 32))*1.8
alter VB4 = $&drive
let drive = (floor(trial / 32) - 2*floor(trial / 64))*1.8
alter VB5 = $&drive
let drive = (floor(trial / 64) - 2*floor(trial / 128))*1.8
alter VB6 = $&drive
let drive = (floor(trial / 128) - 2*floor(trial / 256))*1.8
alter VB7 = $&drive
stop when time = 0.00276
resume
delete all
let endpoint = length(time)-1
let cmp = v(COMP)[endpoint]
let top = v(TOP)[endpoint]
let decision = 0
if cmp >= 0.9
let code = trial
let decision = 1
end
echo 153 6 $&trial $&cmp $&top 0.70546875 $&decision >> decisions.csv
let trial = code + 32
let drive = (floor(trial / 1) - 2*floor(trial / 2))*1.8
alter VB0 = $&drive
let drive = (floor(trial / 2) - 2*floor(trial / 4))*1.8
alter VB1 = $&drive
let drive = (floor(trial / 4) - 2*floor(trial / 8))*1.8
alter VB2 = $&drive
let drive = (floor(trial / 8) - 2*floor(trial / 16))*1.8
alter VB3 = $&drive
let drive = (floor(trial / 16) - 2*floor(trial / 32))*1.8
alter VB4 = $&drive
let drive = (floor(trial / 32) - 2*floor(trial / 64))*1.8
alter VB5 = $&drive
let drive = (floor(trial / 64) - 2*floor(trial / 128))*1.8
alter VB6 = $&drive
let drive = (floor(trial / 128) - 2*floor(trial / 256))*1.8
alter VB7 = $&drive
stop when time = 0.002762
resume
delete all
let endpoint = length(time)-1
let cmp = v(COMP)[endpoint]
let top = v(TOP)[endpoint]
let decision = 0
if cmp >= 0.9
let code = trial
let decision = 1
end
echo 153 5 $&trial $&cmp $&top 0.70546875 $&decision >> decisions.csv
let trial = code + 16
let drive = (floor(trial / 1) - 2*floor(trial / 2))*1.8
alter VB0 = $&drive
let drive = (floor(trial / 2) - 2*floor(trial / 4))*1.8
alter VB1 = $&drive
let drive = (floor(trial / 4) - 2*floor(trial / 8))*1.8
alter VB2 = $&drive
let drive = (floor(trial / 8) - 2*floor(trial / 16))*1.8
alter VB3 = $&drive
let drive = (floor(trial / 16) - 2*floor(trial / 32))*1.8
alter VB4 = $&drive
let drive = (floor(trial / 32) - 2*floor(trial / 64))*1.8
alter VB5 = $&drive
let drive = (floor(trial / 64) - 2*floor(trial / 128))*1.8
alter VB6 = $&drive
let drive = (floor(trial / 128) - 2*floor(trial / 256))*1.8
alter VB7 = $&drive
stop when time = 0.002764
resume
delete all
let endpoint = length(time)-1
let cmp = v(COMP)[endpoint]
let top = v(TOP)[endpoint]
let decision = 0
if cmp >= 0.9
let code = trial
let decision = 1
end
echo 153 4 $&trial $&cmp $&top 0.70546875 $&decision >> decisions.csv
let trial = code + 8
let drive = (floor(trial / 1) - 2*floor(trial / 2))*1.8
alter VB0 = $&drive
let drive = (floor(trial / 2) - 2*floor(trial / 4))*1.8
alter VB1 = $&drive
let drive = (floor(trial / 4) - 2*floor(trial / 8))*1.8
alter VB2 = $&drive
let drive = (floor(trial / 8) - 2*floor(trial / 16))*1.8
alter VB3 = $&drive
let drive = (floor(trial / 16) - 2*floor(trial / 32))*1.8
alter VB4 = $&drive
let drive = (floor(trial / 32) - 2*floor(trial / 64))*1.8
alter VB5 = $&drive
let drive = (floor(trial / 64) - 2*floor(trial / 128))*1.8
alter VB6 = $&drive
let drive = (floor(trial / 128) - 2*floor(trial / 256))*1.8
alter VB7 = $&drive
stop when time = 0.002766
resume
delete all
let endpoint = length(time)-1
let cmp = v(COMP)[endpoint]
let top = v(TOP)[endpoint]
let decision = 0
if cmp >= 0.9
let code = trial
let decision = 1
end
echo 153 3 $&trial $&cmp $&top 0.70546875 $&decision >> decisions.csv
let trial = code + 4
let drive = (floor(trial / 1) - 2*floor(trial / 2))*1.8
alter VB0 = $&drive
let drive = (floor(trial / 2) - 2*floor(trial / 4))*1.8
alter VB1 = $&drive
let drive = (floor(trial / 4) - 2*floor(trial / 8))*1.8
alter VB2 = $&drive
let drive = (floor(trial / 8) - 2*floor(trial / 16))*1.8
alter VB3 = $&drive
let drive = (floor(trial / 16) - 2*floor(trial / 32))*1.8
alter VB4 = $&drive
let drive = (floor(trial / 32) - 2*floor(trial / 64))*1.8
alter VB5 = $&drive
let drive = (floor(trial / 64) - 2*floor(trial / 128))*1.8
alter VB6 = $&drive
let drive = (floor(trial / 128) - 2*floor(trial / 256))*1.8
alter VB7 = $&drive
stop when time = 0.002768
resume
delete all
let endpoint = length(time)-1
let cmp = v(COMP)[endpoint]
let top = v(TOP)[endpoint]
let decision = 0
if cmp >= 0.9
let code = trial
let decision = 1
end
echo 153 2 $&trial $&cmp $&top 0.70546875 $&decision >> decisions.csv
let trial = code + 2
let drive = (floor(trial / 1) - 2*floor(trial / 2))*1.8
alter VB0 = $&drive
let drive = (floor(trial / 2) - 2*floor(trial / 4))*1.8
alter VB1 = $&drive
let drive = (floor(trial / 4) - 2*floor(trial / 8))*1.8
alter VB2 = $&drive
let drive = (floor(trial / 8) - 2*floor(trial / 16))*1.8
alter VB3 = $&drive
let drive = (floor(trial / 16) - 2*floor(trial / 32))*1.8
alter VB4 = $&drive
let drive = (floor(trial / 32) - 2*floor(trial / 64))*1.8
alter VB5 = $&drive
let drive = (floor(trial / 64) - 2*floor(trial / 128))*1.8
alter VB6 = $&drive
let drive = (floor(trial / 128) - 2*floor(trial / 256))*1.8
alter VB7 = $&drive
stop when time = 0.00277
resume
delete all
let endpoint = length(time)-1
let cmp = v(COMP)[endpoint]
let top = v(TOP)[endpoint]
let decision = 0
if cmp >= 0.9
let code = trial
let decision = 1
end
echo 153 1 $&trial $&cmp $&top 0.70546875 $&decision >> decisions.csv
let trial = code + 1
let drive = (floor(trial / 1) - 2*floor(trial / 2))*1.8
alter VB0 = $&drive
let drive = (floor(trial / 2) - 2*floor(trial / 4))*1.8
alter VB1 = $&drive
let drive = (floor(trial / 4) - 2*floor(trial / 8))*1.8
alter VB2 = $&drive
let drive = (floor(trial / 8) - 2*floor(trial / 16))*1.8
alter VB3 = $&drive
let drive = (floor(trial / 16) - 2*floor(trial / 32))*1.8
alter VB4 = $&drive
let drive = (floor(trial / 32) - 2*floor(trial / 64))*1.8
alter VB5 = $&drive
let drive = (floor(trial / 64) - 2*floor(trial / 128))*1.8
alter VB6 = $&drive
let drive = (floor(trial / 128) - 2*floor(trial / 256))*1.8
alter VB7 = $&drive
stop when time = 0.002772
resume
delete all
let endpoint = length(time)-1
let cmp = v(COMP)[endpoint]
let top = v(TOP)[endpoint]
let decision = 0
if cmp >= 0.9
let code = trial
let decision = 1
end
echo 153 0 $&trial $&cmp $&top 0.70546875 $&decision >> decisions.csv
alter VIN = 0.71015625
alter VSAMPLE = 1.8
alter VB0 = 0
alter VB1 = 0
alter VB2 = 0
alter VB3 = 0
alter VB4 = 0
alter VB5 = 0
alter VB6 = 0
alter VB7 = 0
let code = 0
stop when time = 0.002774
resume
delete all
alter VSAMPLE = 0
let trial = code + 128
let drive = (floor(trial / 1) - 2*floor(trial / 2))*1.8
alter VB0 = $&drive
let drive = (floor(trial / 2) - 2*floor(trial / 4))*1.8
alter VB1 = $&drive
let drive = (floor(trial / 4) - 2*floor(trial / 8))*1.8
alter VB2 = $&drive
let drive = (floor(trial / 8) - 2*floor(trial / 16))*1.8
alter VB3 = $&drive
let drive = (floor(trial / 16) - 2*floor(trial / 32))*1.8
alter VB4 = $&drive
let drive = (floor(trial / 32) - 2*floor(trial / 64))*1.8
alter VB5 = $&drive
let drive = (floor(trial / 64) - 2*floor(trial / 128))*1.8
alter VB6 = $&drive
let drive = (floor(trial / 128) - 2*floor(trial / 256))*1.8
alter VB7 = $&drive
stop when time = 0.002776
resume
delete all
let endpoint = length(time)-1
let cmp = v(COMP)[endpoint]
let top = v(TOP)[endpoint]
let decision = 0
if cmp >= 0.9
let code = trial
let decision = 1
end
echo 154 7 $&trial $&cmp $&top 0.71015625 $&decision >> decisions.csv
let trial = code + 64
let drive = (floor(trial / 1) - 2*floor(trial / 2))*1.8
alter VB0 = $&drive
let drive = (floor(trial / 2) - 2*floor(trial / 4))*1.8
alter VB1 = $&drive
let drive = (floor(trial / 4) - 2*floor(trial / 8))*1.8
alter VB2 = $&drive
let drive = (floor(trial / 8) - 2*floor(trial / 16))*1.8
alter VB3 = $&drive
let drive = (floor(trial / 16) - 2*floor(trial / 32))*1.8
alter VB4 = $&drive
let drive = (floor(trial / 32) - 2*floor(trial / 64))*1.8
alter VB5 = $&drive
let drive = (floor(trial / 64) - 2*floor(trial / 128))*1.8
alter VB6 = $&drive
let drive = (floor(trial / 128) - 2*floor(trial / 256))*1.8
alter VB7 = $&drive
stop when time = 0.002778
resume
delete all
let endpoint = length(time)-1
let cmp = v(COMP)[endpoint]
let top = v(TOP)[endpoint]
let decision = 0
if cmp >= 0.9
let code = trial
let decision = 1
end
echo 154 6 $&trial $&cmp $&top 0.71015625 $&decision >> decisions.csv
let trial = code + 32
let drive = (floor(trial / 1) - 2*floor(trial / 2))*1.8
alter VB0 = $&drive
let drive = (floor(trial / 2) - 2*floor(trial / 4))*1.8
alter VB1 = $&drive
let drive = (floor(trial / 4) - 2*floor(trial / 8))*1.8
alter VB2 = $&drive
let drive = (floor(trial / 8) - 2*floor(trial / 16))*1.8
alter VB3 = $&drive
let drive = (floor(trial / 16) - 2*floor(trial / 32))*1.8
alter VB4 = $&drive
let drive = (floor(trial / 32) - 2*floor(trial / 64))*1.8
alter VB5 = $&drive
let drive = (floor(trial / 64) - 2*floor(trial / 128))*1.8
alter VB6 = $&drive
let drive = (floor(trial / 128) - 2*floor(trial / 256))*1.8
alter VB7 = $&drive
stop when time = 0.00278
resume
delete all
let endpoint = length(time)-1
let cmp = v(COMP)[endpoint]
let top = v(TOP)[endpoint]
let decision = 0
if cmp >= 0.9
let code = trial
let decision = 1
end
echo 154 5 $&trial $&cmp $&top 0.71015625 $&decision >> decisions.csv
let trial = code + 16
let drive = (floor(trial / 1) - 2*floor(trial / 2))*1.8
alter VB0 = $&drive
let drive = (floor(trial / 2) - 2*floor(trial / 4))*1.8
alter VB1 = $&drive
let drive = (floor(trial / 4) - 2*floor(trial / 8))*1.8
alter VB2 = $&drive
let drive = (floor(trial / 8) - 2*floor(trial / 16))*1.8
alter VB3 = $&drive
let drive = (floor(trial / 16) - 2*floor(trial / 32))*1.8
alter VB4 = $&drive
let drive = (floor(trial / 32) - 2*floor(trial / 64))*1.8
alter VB5 = $&drive
let drive = (floor(trial / 64) - 2*floor(trial / 128))*1.8
alter VB6 = $&drive
let drive = (floor(trial / 128) - 2*floor(trial / 256))*1.8
alter VB7 = $&drive
stop when time = 0.002782
resume
delete all
let endpoint = length(time)-1
let cmp = v(COMP)[endpoint]
let top = v(TOP)[endpoint]
let decision = 0
if cmp >= 0.9
let code = trial
let decision = 1
end
echo 154 4 $&trial $&cmp $&top 0.71015625 $&decision >> decisions.csv
let trial = code + 8
let drive = (floor(trial / 1) - 2*floor(trial / 2))*1.8
alter VB0 = $&drive
let drive = (floor(trial / 2) - 2*floor(trial / 4))*1.8
alter VB1 = $&drive
let drive = (floor(trial / 4) - 2*floor(trial / 8))*1.8
alter VB2 = $&drive
let drive = (floor(trial / 8) - 2*floor(trial / 16))*1.8
alter VB3 = $&drive
let drive = (floor(trial / 16) - 2*floor(trial / 32))*1.8
alter VB4 = $&drive
let drive = (floor(trial / 32) - 2*floor(trial / 64))*1.8
alter VB5 = $&drive
let drive = (floor(trial / 64) - 2*floor(trial / 128))*1.8
alter VB6 = $&drive
let drive = (floor(trial / 128) - 2*floor(trial / 256))*1.8
alter VB7 = $&drive
stop when time = 0.002784
resume
delete all
let endpoint = length(time)-1
let cmp = v(COMP)[endpoint]
let top = v(TOP)[endpoint]
let decision = 0
if cmp >= 0.9
let code = trial
let decision = 1
end
echo 154 3 $&trial $&cmp $&top 0.71015625 $&decision >> decisions.csv
let trial = code + 4
let drive = (floor(trial / 1) - 2*floor(trial / 2))*1.8
alter VB0 = $&drive
let drive = (floor(trial / 2) - 2*floor(trial / 4))*1.8
alter VB1 = $&drive
let drive = (floor(trial / 4) - 2*floor(trial / 8))*1.8
alter VB2 = $&drive
let drive = (floor(trial / 8) - 2*floor(trial / 16))*1.8
alter VB3 = $&drive
let drive = (floor(trial / 16) - 2*floor(trial / 32))*1.8
alter VB4 = $&drive
let drive = (floor(trial / 32) - 2*floor(trial / 64))*1.8
alter VB5 = $&drive
let drive = (floor(trial / 64) - 2*floor(trial / 128))*1.8
alter VB6 = $&drive
let drive = (floor(trial / 128) - 2*floor(trial / 256))*1.8
alter VB7 = $&drive
stop when time = 0.002786
resume
delete all
let endpoint = length(time)-1
let cmp = v(COMP)[endpoint]
let top = v(TOP)[endpoint]
let decision = 0
if cmp >= 0.9
let code = trial
let decision = 1
end
echo 154 2 $&trial $&cmp $&top 0.71015625 $&decision >> decisions.csv
let trial = code + 2
let drive = (floor(trial / 1) - 2*floor(trial / 2))*1.8
alter VB0 = $&drive
let drive = (floor(trial / 2) - 2*floor(trial / 4))*1.8
alter VB1 = $&drive
let drive = (floor(trial / 4) - 2*floor(trial / 8))*1.8
alter VB2 = $&drive
let drive = (floor(trial / 8) - 2*floor(trial / 16))*1.8
alter VB3 = $&drive
let drive = (floor(trial / 16) - 2*floor(trial / 32))*1.8
alter VB4 = $&drive
let drive = (floor(trial / 32) - 2*floor(trial / 64))*1.8
alter VB5 = $&drive
let drive = (floor(trial / 64) - 2*floor(trial / 128))*1.8
alter VB6 = $&drive
let drive = (floor(trial / 128) - 2*floor(trial / 256))*1.8
alter VB7 = $&drive
stop when time = 0.002788
resume
delete all
let endpoint = length(time)-1
let cmp = v(COMP)[endpoint]
let top = v(TOP)[endpoint]
let decision = 0
if cmp >= 0.9
let code = trial
let decision = 1
end
echo 154 1 $&trial $&cmp $&top 0.71015625 $&decision >> decisions.csv
let trial = code + 1
let drive = (floor(trial / 1) - 2*floor(trial / 2))*1.8
alter VB0 = $&drive
let drive = (floor(trial / 2) - 2*floor(trial / 4))*1.8
alter VB1 = $&drive
let drive = (floor(trial / 4) - 2*floor(trial / 8))*1.8
alter VB2 = $&drive
let drive = (floor(trial / 8) - 2*floor(trial / 16))*1.8
alter VB3 = $&drive
let drive = (floor(trial / 16) - 2*floor(trial / 32))*1.8
alter VB4 = $&drive
let drive = (floor(trial / 32) - 2*floor(trial / 64))*1.8
alter VB5 = $&drive
let drive = (floor(trial / 64) - 2*floor(trial / 128))*1.8
alter VB6 = $&drive
let drive = (floor(trial / 128) - 2*floor(trial / 256))*1.8
alter VB7 = $&drive
stop when time = 0.00279
resume
delete all
let endpoint = length(time)-1
let cmp = v(COMP)[endpoint]
let top = v(TOP)[endpoint]
let decision = 0
if cmp >= 0.9
let code = trial
let decision = 1
end
echo 154 0 $&trial $&cmp $&top 0.71015625 $&decision >> decisions.csv
alter VIN = 0.71484375
alter VSAMPLE = 1.8
alter VB0 = 0
alter VB1 = 0
alter VB2 = 0
alter VB3 = 0
alter VB4 = 0
alter VB5 = 0
alter VB6 = 0
alter VB7 = 0
let code = 0
stop when time = 0.002792
resume
delete all
alter VSAMPLE = 0
let trial = code + 128
let drive = (floor(trial / 1) - 2*floor(trial / 2))*1.8
alter VB0 = $&drive
let drive = (floor(trial / 2) - 2*floor(trial / 4))*1.8
alter VB1 = $&drive
let drive = (floor(trial / 4) - 2*floor(trial / 8))*1.8
alter VB2 = $&drive
let drive = (floor(trial / 8) - 2*floor(trial / 16))*1.8
alter VB3 = $&drive
let drive = (floor(trial / 16) - 2*floor(trial / 32))*1.8
alter VB4 = $&drive
let drive = (floor(trial / 32) - 2*floor(trial / 64))*1.8
alter VB5 = $&drive
let drive = (floor(trial / 64) - 2*floor(trial / 128))*1.8
alter VB6 = $&drive
let drive = (floor(trial / 128) - 2*floor(trial / 256))*1.8
alter VB7 = $&drive
stop when time = 0.002794
resume
delete all
let endpoint = length(time)-1
let cmp = v(COMP)[endpoint]
let top = v(TOP)[endpoint]
let decision = 0
if cmp >= 0.9
let code = trial
let decision = 1
end
echo 155 7 $&trial $&cmp $&top 0.71484375 $&decision >> decisions.csv
let trial = code + 64
let drive = (floor(trial / 1) - 2*floor(trial / 2))*1.8
alter VB0 = $&drive
let drive = (floor(trial / 2) - 2*floor(trial / 4))*1.8
alter VB1 = $&drive
let drive = (floor(trial / 4) - 2*floor(trial / 8))*1.8
alter VB2 = $&drive
let drive = (floor(trial / 8) - 2*floor(trial / 16))*1.8
alter VB3 = $&drive
let drive = (floor(trial / 16) - 2*floor(trial / 32))*1.8
alter VB4 = $&drive
let drive = (floor(trial / 32) - 2*floor(trial / 64))*1.8
alter VB5 = $&drive
let drive = (floor(trial / 64) - 2*floor(trial / 128))*1.8
alter VB6 = $&drive
let drive = (floor(trial / 128) - 2*floor(trial / 256))*1.8
alter VB7 = $&drive
stop when time = 0.002796
resume
delete all
let endpoint = length(time)-1
let cmp = v(COMP)[endpoint]
let top = v(TOP)[endpoint]
let decision = 0
if cmp >= 0.9
let code = trial
let decision = 1
end
echo 155 6 $&trial $&cmp $&top 0.71484375 $&decision >> decisions.csv
let trial = code + 32
let drive = (floor(trial / 1) - 2*floor(trial / 2))*1.8
alter VB0 = $&drive
let drive = (floor(trial / 2) - 2*floor(trial / 4))*1.8
alter VB1 = $&drive
let drive = (floor(trial / 4) - 2*floor(trial / 8))*1.8
alter VB2 = $&drive
let drive = (floor(trial / 8) - 2*floor(trial / 16))*1.8
alter VB3 = $&drive
let drive = (floor(trial / 16) - 2*floor(trial / 32))*1.8
alter VB4 = $&drive
let drive = (floor(trial / 32) - 2*floor(trial / 64))*1.8
alter VB5 = $&drive
let drive = (floor(trial / 64) - 2*floor(trial / 128))*1.8
alter VB6 = $&drive
let drive = (floor(trial / 128) - 2*floor(trial / 256))*1.8
alter VB7 = $&drive
stop when time = 0.002798
resume
delete all
let endpoint = length(time)-1
let cmp = v(COMP)[endpoint]
let top = v(TOP)[endpoint]
let decision = 0
if cmp >= 0.9
let code = trial
let decision = 1
end
echo 155 5 $&trial $&cmp $&top 0.71484375 $&decision >> decisions.csv
let trial = code + 16
let drive = (floor(trial / 1) - 2*floor(trial / 2))*1.8
alter VB0 = $&drive
let drive = (floor(trial / 2) - 2*floor(trial / 4))*1.8
alter VB1 = $&drive
let drive = (floor(trial / 4) - 2*floor(trial / 8))*1.8
alter VB2 = $&drive
let drive = (floor(trial / 8) - 2*floor(trial / 16))*1.8
alter VB3 = $&drive
let drive = (floor(trial / 16) - 2*floor(trial / 32))*1.8
alter VB4 = $&drive
let drive = (floor(trial / 32) - 2*floor(trial / 64))*1.8
alter VB5 = $&drive
let drive = (floor(trial / 64) - 2*floor(trial / 128))*1.8
alter VB6 = $&drive
let drive = (floor(trial / 128) - 2*floor(trial / 256))*1.8
alter VB7 = $&drive
stop when time = 0.0028
resume
delete all
let endpoint = length(time)-1
let cmp = v(COMP)[endpoint]
let top = v(TOP)[endpoint]
let decision = 0
if cmp >= 0.9
let code = trial
let decision = 1
end
echo 155 4 $&trial $&cmp $&top 0.71484375 $&decision >> decisions.csv
let trial = code + 8
let drive = (floor(trial / 1) - 2*floor(trial / 2))*1.8
alter VB0 = $&drive
let drive = (floor(trial / 2) - 2*floor(trial / 4))*1.8
alter VB1 = $&drive
let drive = (floor(trial / 4) - 2*floor(trial / 8))*1.8
alter VB2 = $&drive
let drive = (floor(trial / 8) - 2*floor(trial / 16))*1.8
alter VB3 = $&drive
let drive = (floor(trial / 16) - 2*floor(trial / 32))*1.8
alter VB4 = $&drive
let drive = (floor(trial / 32) - 2*floor(trial / 64))*1.8
alter VB5 = $&drive
let drive = (floor(trial / 64) - 2*floor(trial / 128))*1.8
alter VB6 = $&drive
let drive = (floor(trial / 128) - 2*floor(trial / 256))*1.8
alter VB7 = $&drive
stop when time = 0.002802
resume
delete all
let endpoint = length(time)-1
let cmp = v(COMP)[endpoint]
let top = v(TOP)[endpoint]
let decision = 0
if cmp >= 0.9
let code = trial
let decision = 1
end
echo 155 3 $&trial $&cmp $&top 0.71484375 $&decision >> decisions.csv
let trial = code + 4
let drive = (floor(trial / 1) - 2*floor(trial / 2))*1.8
alter VB0 = $&drive
let drive = (floor(trial / 2) - 2*floor(trial / 4))*1.8
alter VB1 = $&drive
let drive = (floor(trial / 4) - 2*floor(trial / 8))*1.8
alter VB2 = $&drive
let drive = (floor(trial / 8) - 2*floor(trial / 16))*1.8
alter VB3 = $&drive
let drive = (floor(trial / 16) - 2*floor(trial / 32))*1.8
alter VB4 = $&drive
let drive = (floor(trial / 32) - 2*floor(trial / 64))*1.8
alter VB5 = $&drive
let drive = (floor(trial / 64) - 2*floor(trial / 128))*1.8
alter VB6 = $&drive
let drive = (floor(trial / 128) - 2*floor(trial / 256))*1.8
alter VB7 = $&drive
stop when time = 0.002804
resume
delete all
let endpoint = length(time)-1
let cmp = v(COMP)[endpoint]
let top = v(TOP)[endpoint]
let decision = 0
if cmp >= 0.9
let code = trial
let decision = 1
end
echo 155 2 $&trial $&cmp $&top 0.71484375 $&decision >> decisions.csv
let trial = code + 2
let drive = (floor(trial / 1) - 2*floor(trial / 2))*1.8
alter VB0 = $&drive
let drive = (floor(trial / 2) - 2*floor(trial / 4))*1.8
alter VB1 = $&drive
let drive = (floor(trial / 4) - 2*floor(trial / 8))*1.8
alter VB2 = $&drive
let drive = (floor(trial / 8) - 2*floor(trial / 16))*1.8
alter VB3 = $&drive
let drive = (floor(trial / 16) - 2*floor(trial / 32))*1.8
alter VB4 = $&drive
let drive = (floor(trial / 32) - 2*floor(trial / 64))*1.8
alter VB5 = $&drive
let drive = (floor(trial / 64) - 2*floor(trial / 128))*1.8
alter VB6 = $&drive
let drive = (floor(trial / 128) - 2*floor(trial / 256))*1.8
alter VB7 = $&drive
stop when time = 0.002806
resume
delete all
let endpoint = length(time)-1
let cmp = v(COMP)[endpoint]
let top = v(TOP)[endpoint]
let decision = 0
if cmp >= 0.9
let code = trial
let decision = 1
end
echo 155 1 $&trial $&cmp $&top 0.71484375 $&decision >> decisions.csv
let trial = code + 1
let drive = (floor(trial / 1) - 2*floor(trial / 2))*1.8
alter VB0 = $&drive
let drive = (floor(trial / 2) - 2*floor(trial / 4))*1.8
alter VB1 = $&drive
let drive = (floor(trial / 4) - 2*floor(trial / 8))*1.8
alter VB2 = $&drive
let drive = (floor(trial / 8) - 2*floor(trial / 16))*1.8
alter VB3 = $&drive
let drive = (floor(trial / 16) - 2*floor(trial / 32))*1.8
alter VB4 = $&drive
let drive = (floor(trial / 32) - 2*floor(trial / 64))*1.8
alter VB5 = $&drive
let drive = (floor(trial / 64) - 2*floor(trial / 128))*1.8
alter VB6 = $&drive
let drive = (floor(trial / 128) - 2*floor(trial / 256))*1.8
alter VB7 = $&drive
stop when time = 0.002808
resume
delete all
let endpoint = length(time)-1
let cmp = v(COMP)[endpoint]
let top = v(TOP)[endpoint]
let decision = 0
if cmp >= 0.9
let code = trial
let decision = 1
end
echo 155 0 $&trial $&cmp $&top 0.71484375 $&decision >> decisions.csv
alter VIN = 0.71953125
alter VSAMPLE = 1.8
alter VB0 = 0
alter VB1 = 0
alter VB2 = 0
alter VB3 = 0
alter VB4 = 0
alter VB5 = 0
alter VB6 = 0
alter VB7 = 0
let code = 0
stop when time = 0.00281
resume
delete all
alter VSAMPLE = 0
let trial = code + 128
let drive = (floor(trial / 1) - 2*floor(trial / 2))*1.8
alter VB0 = $&drive
let drive = (floor(trial / 2) - 2*floor(trial / 4))*1.8
alter VB1 = $&drive
let drive = (floor(trial / 4) - 2*floor(trial / 8))*1.8
alter VB2 = $&drive
let drive = (floor(trial / 8) - 2*floor(trial / 16))*1.8
alter VB3 = $&drive
let drive = (floor(trial / 16) - 2*floor(trial / 32))*1.8
alter VB4 = $&drive
let drive = (floor(trial / 32) - 2*floor(trial / 64))*1.8
alter VB5 = $&drive
let drive = (floor(trial / 64) - 2*floor(trial / 128))*1.8
alter VB6 = $&drive
let drive = (floor(trial / 128) - 2*floor(trial / 256))*1.8
alter VB7 = $&drive
stop when time = 0.002812
resume
delete all
let endpoint = length(time)-1
let cmp = v(COMP)[endpoint]
let top = v(TOP)[endpoint]
let decision = 0
if cmp >= 0.9
let code = trial
let decision = 1
end
echo 156 7 $&trial $&cmp $&top 0.71953125 $&decision >> decisions.csv
let trial = code + 64
let drive = (floor(trial / 1) - 2*floor(trial / 2))*1.8
alter VB0 = $&drive
let drive = (floor(trial / 2) - 2*floor(trial / 4))*1.8
alter VB1 = $&drive
let drive = (floor(trial / 4) - 2*floor(trial / 8))*1.8
alter VB2 = $&drive
let drive = (floor(trial / 8) - 2*floor(trial / 16))*1.8
alter VB3 = $&drive
let drive = (floor(trial / 16) - 2*floor(trial / 32))*1.8
alter VB4 = $&drive
let drive = (floor(trial / 32) - 2*floor(trial / 64))*1.8
alter VB5 = $&drive
let drive = (floor(trial / 64) - 2*floor(trial / 128))*1.8
alter VB6 = $&drive
let drive = (floor(trial / 128) - 2*floor(trial / 256))*1.8
alter VB7 = $&drive
stop when time = 0.002814
resume
delete all
let endpoint = length(time)-1
let cmp = v(COMP)[endpoint]
let top = v(TOP)[endpoint]
let decision = 0
if cmp >= 0.9
let code = trial
let decision = 1
end
echo 156 6 $&trial $&cmp $&top 0.71953125 $&decision >> decisions.csv
let trial = code + 32
let drive = (floor(trial / 1) - 2*floor(trial / 2))*1.8
alter VB0 = $&drive
let drive = (floor(trial / 2) - 2*floor(trial / 4))*1.8
alter VB1 = $&drive
let drive = (floor(trial / 4) - 2*floor(trial / 8))*1.8
alter VB2 = $&drive
let drive = (floor(trial / 8) - 2*floor(trial / 16))*1.8
alter VB3 = $&drive
let drive = (floor(trial / 16) - 2*floor(trial / 32))*1.8
alter VB4 = $&drive
let drive = (floor(trial / 32) - 2*floor(trial / 64))*1.8
alter VB5 = $&drive
let drive = (floor(trial / 64) - 2*floor(trial / 128))*1.8
alter VB6 = $&drive
let drive = (floor(trial / 128) - 2*floor(trial / 256))*1.8
alter VB7 = $&drive
stop when time = 0.002816
resume
delete all
let endpoint = length(time)-1
let cmp = v(COMP)[endpoint]
let top = v(TOP)[endpoint]
let decision = 0
if cmp >= 0.9
let code = trial
let decision = 1
end
echo 156 5 $&trial $&cmp $&top 0.71953125 $&decision >> decisions.csv
let trial = code + 16
let drive = (floor(trial / 1) - 2*floor(trial / 2))*1.8
alter VB0 = $&drive
let drive = (floor(trial / 2) - 2*floor(trial / 4))*1.8
alter VB1 = $&drive
let drive = (floor(trial / 4) - 2*floor(trial / 8))*1.8
alter VB2 = $&drive
let drive = (floor(trial / 8) - 2*floor(trial / 16))*1.8
alter VB3 = $&drive
let drive = (floor(trial / 16) - 2*floor(trial / 32))*1.8
alter VB4 = $&drive
let drive = (floor(trial / 32) - 2*floor(trial / 64))*1.8
alter VB5 = $&drive
let drive = (floor(trial / 64) - 2*floor(trial / 128))*1.8
alter VB6 = $&drive
let drive = (floor(trial / 128) - 2*floor(trial / 256))*1.8
alter VB7 = $&drive
stop when time = 0.002818
resume
delete all
let endpoint = length(time)-1
let cmp = v(COMP)[endpoint]
let top = v(TOP)[endpoint]
let decision = 0
if cmp >= 0.9
let code = trial
let decision = 1
end
echo 156 4 $&trial $&cmp $&top 0.71953125 $&decision >> decisions.csv
let trial = code + 8
let drive = (floor(trial / 1) - 2*floor(trial / 2))*1.8
alter VB0 = $&drive
let drive = (floor(trial / 2) - 2*floor(trial / 4))*1.8
alter VB1 = $&drive
let drive = (floor(trial / 4) - 2*floor(trial / 8))*1.8
alter VB2 = $&drive
let drive = (floor(trial / 8) - 2*floor(trial / 16))*1.8
alter VB3 = $&drive
let drive = (floor(trial / 16) - 2*floor(trial / 32))*1.8
alter VB4 = $&drive
let drive = (floor(trial / 32) - 2*floor(trial / 64))*1.8
alter VB5 = $&drive
let drive = (floor(trial / 64) - 2*floor(trial / 128))*1.8
alter VB6 = $&drive
let drive = (floor(trial / 128) - 2*floor(trial / 256))*1.8
alter VB7 = $&drive
stop when time = 0.00282
resume
delete all
let endpoint = length(time)-1
let cmp = v(COMP)[endpoint]
let top = v(TOP)[endpoint]
let decision = 0
if cmp >= 0.9
let code = trial
let decision = 1
end
echo 156 3 $&trial $&cmp $&top 0.71953125 $&decision >> decisions.csv
let trial = code + 4
let drive = (floor(trial / 1) - 2*floor(trial / 2))*1.8
alter VB0 = $&drive
let drive = (floor(trial / 2) - 2*floor(trial / 4))*1.8
alter VB1 = $&drive
let drive = (floor(trial / 4) - 2*floor(trial / 8))*1.8
alter VB2 = $&drive
let drive = (floor(trial / 8) - 2*floor(trial / 16))*1.8
alter VB3 = $&drive
let drive = (floor(trial / 16) - 2*floor(trial / 32))*1.8
alter VB4 = $&drive
let drive = (floor(trial / 32) - 2*floor(trial / 64))*1.8
alter VB5 = $&drive
let drive = (floor(trial / 64) - 2*floor(trial / 128))*1.8
alter VB6 = $&drive
let drive = (floor(trial / 128) - 2*floor(trial / 256))*1.8
alter VB7 = $&drive
stop when time = 0.002822
resume
delete all
let endpoint = length(time)-1
let cmp = v(COMP)[endpoint]
let top = v(TOP)[endpoint]
let decision = 0
if cmp >= 0.9
let code = trial
let decision = 1
end
echo 156 2 $&trial $&cmp $&top 0.71953125 $&decision >> decisions.csv
let trial = code + 2
let drive = (floor(trial / 1) - 2*floor(trial / 2))*1.8
alter VB0 = $&drive
let drive = (floor(trial / 2) - 2*floor(trial / 4))*1.8
alter VB1 = $&drive
let drive = (floor(trial / 4) - 2*floor(trial / 8))*1.8
alter VB2 = $&drive
let drive = (floor(trial / 8) - 2*floor(trial / 16))*1.8
alter VB3 = $&drive
let drive = (floor(trial / 16) - 2*floor(trial / 32))*1.8
alter VB4 = $&drive
let drive = (floor(trial / 32) - 2*floor(trial / 64))*1.8
alter VB5 = $&drive
let drive = (floor(trial / 64) - 2*floor(trial / 128))*1.8
alter VB6 = $&drive
let drive = (floor(trial / 128) - 2*floor(trial / 256))*1.8
alter VB7 = $&drive
stop when time = 0.002824
resume
delete all
let endpoint = length(time)-1
let cmp = v(COMP)[endpoint]
let top = v(TOP)[endpoint]
let decision = 0
if cmp >= 0.9
let code = trial
let decision = 1
end
echo 156 1 $&trial $&cmp $&top 0.71953125 $&decision >> decisions.csv
let trial = code + 1
let drive = (floor(trial / 1) - 2*floor(trial / 2))*1.8
alter VB0 = $&drive
let drive = (floor(trial / 2) - 2*floor(trial / 4))*1.8
alter VB1 = $&drive
let drive = (floor(trial / 4) - 2*floor(trial / 8))*1.8
alter VB2 = $&drive
let drive = (floor(trial / 8) - 2*floor(trial / 16))*1.8
alter VB3 = $&drive
let drive = (floor(trial / 16) - 2*floor(trial / 32))*1.8
alter VB4 = $&drive
let drive = (floor(trial / 32) - 2*floor(trial / 64))*1.8
alter VB5 = $&drive
let drive = (floor(trial / 64) - 2*floor(trial / 128))*1.8
alter VB6 = $&drive
let drive = (floor(trial / 128) - 2*floor(trial / 256))*1.8
alter VB7 = $&drive
stop when time = 0.002826
resume
delete all
let endpoint = length(time)-1
let cmp = v(COMP)[endpoint]
let top = v(TOP)[endpoint]
let decision = 0
if cmp >= 0.9
let code = trial
let decision = 1
end
echo 156 0 $&trial $&cmp $&top 0.71953125 $&decision >> decisions.csv
alter VIN = 0.72421875
alter VSAMPLE = 1.8
alter VB0 = 0
alter VB1 = 0
alter VB2 = 0
alter VB3 = 0
alter VB4 = 0
alter VB5 = 0
alter VB6 = 0
alter VB7 = 0
let code = 0
stop when time = 0.002828
resume
delete all
alter VSAMPLE = 0
let trial = code + 128
let drive = (floor(trial / 1) - 2*floor(trial / 2))*1.8
alter VB0 = $&drive
let drive = (floor(trial / 2) - 2*floor(trial / 4))*1.8
alter VB1 = $&drive
let drive = (floor(trial / 4) - 2*floor(trial / 8))*1.8
alter VB2 = $&drive
let drive = (floor(trial / 8) - 2*floor(trial / 16))*1.8
alter VB3 = $&drive
let drive = (floor(trial / 16) - 2*floor(trial / 32))*1.8
alter VB4 = $&drive
let drive = (floor(trial / 32) - 2*floor(trial / 64))*1.8
alter VB5 = $&drive
let drive = (floor(trial / 64) - 2*floor(trial / 128))*1.8
alter VB6 = $&drive
let drive = (floor(trial / 128) - 2*floor(trial / 256))*1.8
alter VB7 = $&drive
stop when time = 0.00283
resume
delete all
let endpoint = length(time)-1
let cmp = v(COMP)[endpoint]
let top = v(TOP)[endpoint]
let decision = 0
if cmp >= 0.9
let code = trial
let decision = 1
end
echo 157 7 $&trial $&cmp $&top 0.72421875 $&decision >> decisions.csv
let trial = code + 64
let drive = (floor(trial / 1) - 2*floor(trial / 2))*1.8
alter VB0 = $&drive
let drive = (floor(trial / 2) - 2*floor(trial / 4))*1.8
alter VB1 = $&drive
let drive = (floor(trial / 4) - 2*floor(trial / 8))*1.8
alter VB2 = $&drive
let drive = (floor(trial / 8) - 2*floor(trial / 16))*1.8
alter VB3 = $&drive
let drive = (floor(trial / 16) - 2*floor(trial / 32))*1.8
alter VB4 = $&drive
let drive = (floor(trial / 32) - 2*floor(trial / 64))*1.8
alter VB5 = $&drive
let drive = (floor(trial / 64) - 2*floor(trial / 128))*1.8
alter VB6 = $&drive
let drive = (floor(trial / 128) - 2*floor(trial / 256))*1.8
alter VB7 = $&drive
stop when time = 0.002832
resume
delete all
let endpoint = length(time)-1
let cmp = v(COMP)[endpoint]
let top = v(TOP)[endpoint]
let decision = 0
if cmp >= 0.9
let code = trial
let decision = 1
end
echo 157 6 $&trial $&cmp $&top 0.72421875 $&decision >> decisions.csv
let trial = code + 32
let drive = (floor(trial / 1) - 2*floor(trial / 2))*1.8
alter VB0 = $&drive
let drive = (floor(trial / 2) - 2*floor(trial / 4))*1.8
alter VB1 = $&drive
let drive = (floor(trial / 4) - 2*floor(trial / 8))*1.8
alter VB2 = $&drive
let drive = (floor(trial / 8) - 2*floor(trial / 16))*1.8
alter VB3 = $&drive
let drive = (floor(trial / 16) - 2*floor(trial / 32))*1.8
alter VB4 = $&drive
let drive = (floor(trial / 32) - 2*floor(trial / 64))*1.8
alter VB5 = $&drive
let drive = (floor(trial / 64) - 2*floor(trial / 128))*1.8
alter VB6 = $&drive
let drive = (floor(trial / 128) - 2*floor(trial / 256))*1.8
alter VB7 = $&drive
stop when time = 0.002834
resume
delete all
let endpoint = length(time)-1
let cmp = v(COMP)[endpoint]
let top = v(TOP)[endpoint]
let decision = 0
if cmp >= 0.9
let code = trial
let decision = 1
end
echo 157 5 $&trial $&cmp $&top 0.72421875 $&decision >> decisions.csv
let trial = code + 16
let drive = (floor(trial / 1) - 2*floor(trial / 2))*1.8
alter VB0 = $&drive
let drive = (floor(trial / 2) - 2*floor(trial / 4))*1.8
alter VB1 = $&drive
let drive = (floor(trial / 4) - 2*floor(trial / 8))*1.8
alter VB2 = $&drive
let drive = (floor(trial / 8) - 2*floor(trial / 16))*1.8
alter VB3 = $&drive
let drive = (floor(trial / 16) - 2*floor(trial / 32))*1.8
alter VB4 = $&drive
let drive = (floor(trial / 32) - 2*floor(trial / 64))*1.8
alter VB5 = $&drive
let drive = (floor(trial / 64) - 2*floor(trial / 128))*1.8
alter VB6 = $&drive
let drive = (floor(trial / 128) - 2*floor(trial / 256))*1.8
alter VB7 = $&drive
stop when time = 0.002836
resume
delete all
let endpoint = length(time)-1
let cmp = v(COMP)[endpoint]
let top = v(TOP)[endpoint]
let decision = 0
if cmp >= 0.9
let code = trial
let decision = 1
end
echo 157 4 $&trial $&cmp $&top 0.72421875 $&decision >> decisions.csv
let trial = code + 8
let drive = (floor(trial / 1) - 2*floor(trial / 2))*1.8
alter VB0 = $&drive
let drive = (floor(trial / 2) - 2*floor(trial / 4))*1.8
alter VB1 = $&drive
let drive = (floor(trial / 4) - 2*floor(trial / 8))*1.8
alter VB2 = $&drive
let drive = (floor(trial / 8) - 2*floor(trial / 16))*1.8
alter VB3 = $&drive
let drive = (floor(trial / 16) - 2*floor(trial / 32))*1.8
alter VB4 = $&drive
let drive = (floor(trial / 32) - 2*floor(trial / 64))*1.8
alter VB5 = $&drive
let drive = (floor(trial / 64) - 2*floor(trial / 128))*1.8
alter VB6 = $&drive
let drive = (floor(trial / 128) - 2*floor(trial / 256))*1.8
alter VB7 = $&drive
stop when time = 0.002838
resume
delete all
let endpoint = length(time)-1
let cmp = v(COMP)[endpoint]
let top = v(TOP)[endpoint]
let decision = 0
if cmp >= 0.9
let code = trial
let decision = 1
end
echo 157 3 $&trial $&cmp $&top 0.72421875 $&decision >> decisions.csv
let trial = code + 4
let drive = (floor(trial / 1) - 2*floor(trial / 2))*1.8
alter VB0 = $&drive
let drive = (floor(trial / 2) - 2*floor(trial / 4))*1.8
alter VB1 = $&drive
let drive = (floor(trial / 4) - 2*floor(trial / 8))*1.8
alter VB2 = $&drive
let drive = (floor(trial / 8) - 2*floor(trial / 16))*1.8
alter VB3 = $&drive
let drive = (floor(trial / 16) - 2*floor(trial / 32))*1.8
alter VB4 = $&drive
let drive = (floor(trial / 32) - 2*floor(trial / 64))*1.8
alter VB5 = $&drive
let drive = (floor(trial / 64) - 2*floor(trial / 128))*1.8
alter VB6 = $&drive
let drive = (floor(trial / 128) - 2*floor(trial / 256))*1.8
alter VB7 = $&drive
stop when time = 0.00284
resume
delete all
let endpoint = length(time)-1
let cmp = v(COMP)[endpoint]
let top = v(TOP)[endpoint]
let decision = 0
if cmp >= 0.9
let code = trial
let decision = 1
end
echo 157 2 $&trial $&cmp $&top 0.72421875 $&decision >> decisions.csv
let trial = code + 2
let drive = (floor(trial / 1) - 2*floor(trial / 2))*1.8
alter VB0 = $&drive
let drive = (floor(trial / 2) - 2*floor(trial / 4))*1.8
alter VB1 = $&drive
let drive = (floor(trial / 4) - 2*floor(trial / 8))*1.8
alter VB2 = $&drive
let drive = (floor(trial / 8) - 2*floor(trial / 16))*1.8
alter VB3 = $&drive
let drive = (floor(trial / 16) - 2*floor(trial / 32))*1.8
alter VB4 = $&drive
let drive = (floor(trial / 32) - 2*floor(trial / 64))*1.8
alter VB5 = $&drive
let drive = (floor(trial / 64) - 2*floor(trial / 128))*1.8
alter VB6 = $&drive
let drive = (floor(trial / 128) - 2*floor(trial / 256))*1.8
alter VB7 = $&drive
stop when time = 0.002842
resume
delete all
let endpoint = length(time)-1
let cmp = v(COMP)[endpoint]
let top = v(TOP)[endpoint]
let decision = 0
if cmp >= 0.9
let code = trial
let decision = 1
end
echo 157 1 $&trial $&cmp $&top 0.72421875 $&decision >> decisions.csv
let trial = code + 1
let drive = (floor(trial / 1) - 2*floor(trial / 2))*1.8
alter VB0 = $&drive
let drive = (floor(trial / 2) - 2*floor(trial / 4))*1.8
alter VB1 = $&drive
let drive = (floor(trial / 4) - 2*floor(trial / 8))*1.8
alter VB2 = $&drive
let drive = (floor(trial / 8) - 2*floor(trial / 16))*1.8
alter VB3 = $&drive
let drive = (floor(trial / 16) - 2*floor(trial / 32))*1.8
alter VB4 = $&drive
let drive = (floor(trial / 32) - 2*floor(trial / 64))*1.8
alter VB5 = $&drive
let drive = (floor(trial / 64) - 2*floor(trial / 128))*1.8
alter VB6 = $&drive
let drive = (floor(trial / 128) - 2*floor(trial / 256))*1.8
alter VB7 = $&drive
stop when time = 0.002844
resume
delete all
let endpoint = length(time)-1
let cmp = v(COMP)[endpoint]
let top = v(TOP)[endpoint]
let decision = 0
if cmp >= 0.9
let code = trial
let decision = 1
end
echo 157 0 $&trial $&cmp $&top 0.72421875 $&decision >> decisions.csv
alter VIN = 0.72890625
alter VSAMPLE = 1.8
alter VB0 = 0
alter VB1 = 0
alter VB2 = 0
alter VB3 = 0
alter VB4 = 0
alter VB5 = 0
alter VB6 = 0
alter VB7 = 0
let code = 0
stop when time = 0.002846
resume
delete all
alter VSAMPLE = 0
let trial = code + 128
let drive = (floor(trial / 1) - 2*floor(trial / 2))*1.8
alter VB0 = $&drive
let drive = (floor(trial / 2) - 2*floor(trial / 4))*1.8
alter VB1 = $&drive
let drive = (floor(trial / 4) - 2*floor(trial / 8))*1.8
alter VB2 = $&drive
let drive = (floor(trial / 8) - 2*floor(trial / 16))*1.8
alter VB3 = $&drive
let drive = (floor(trial / 16) - 2*floor(trial / 32))*1.8
alter VB4 = $&drive
let drive = (floor(trial / 32) - 2*floor(trial / 64))*1.8
alter VB5 = $&drive
let drive = (floor(trial / 64) - 2*floor(trial / 128))*1.8
alter VB6 = $&drive
let drive = (floor(trial / 128) - 2*floor(trial / 256))*1.8
alter VB7 = $&drive
stop when time = 0.002848
resume
delete all
let endpoint = length(time)-1
let cmp = v(COMP)[endpoint]
let top = v(TOP)[endpoint]
let decision = 0
if cmp >= 0.9
let code = trial
let decision = 1
end
echo 158 7 $&trial $&cmp $&top 0.72890625 $&decision >> decisions.csv
let trial = code + 64
let drive = (floor(trial / 1) - 2*floor(trial / 2))*1.8
alter VB0 = $&drive
let drive = (floor(trial / 2) - 2*floor(trial / 4))*1.8
alter VB1 = $&drive
let drive = (floor(trial / 4) - 2*floor(trial / 8))*1.8
alter VB2 = $&drive
let drive = (floor(trial / 8) - 2*floor(trial / 16))*1.8
alter VB3 = $&drive
let drive = (floor(trial / 16) - 2*floor(trial / 32))*1.8
alter VB4 = $&drive
let drive = (floor(trial / 32) - 2*floor(trial / 64))*1.8
alter VB5 = $&drive
let drive = (floor(trial / 64) - 2*floor(trial / 128))*1.8
alter VB6 = $&drive
let drive = (floor(trial / 128) - 2*floor(trial / 256))*1.8
alter VB7 = $&drive
stop when time = 0.00285
resume
delete all
let endpoint = length(time)-1
let cmp = v(COMP)[endpoint]
let top = v(TOP)[endpoint]
let decision = 0
if cmp >= 0.9
let code = trial
let decision = 1
end
echo 158 6 $&trial $&cmp $&top 0.72890625 $&decision >> decisions.csv
let trial = code + 32
let drive = (floor(trial / 1) - 2*floor(trial / 2))*1.8
alter VB0 = $&drive
let drive = (floor(trial / 2) - 2*floor(trial / 4))*1.8
alter VB1 = $&drive
let drive = (floor(trial / 4) - 2*floor(trial / 8))*1.8
alter VB2 = $&drive
let drive = (floor(trial / 8) - 2*floor(trial / 16))*1.8
alter VB3 = $&drive
let drive = (floor(trial / 16) - 2*floor(trial / 32))*1.8
alter VB4 = $&drive
let drive = (floor(trial / 32) - 2*floor(trial / 64))*1.8
alter VB5 = $&drive
let drive = (floor(trial / 64) - 2*floor(trial / 128))*1.8
alter VB6 = $&drive
let drive = (floor(trial / 128) - 2*floor(trial / 256))*1.8
alter VB7 = $&drive
stop when time = 0.002852
resume
delete all
let endpoint = length(time)-1
let cmp = v(COMP)[endpoint]
let top = v(TOP)[endpoint]
let decision = 0
if cmp >= 0.9
let code = trial
let decision = 1
end
echo 158 5 $&trial $&cmp $&top 0.72890625 $&decision >> decisions.csv
let trial = code + 16
let drive = (floor(trial / 1) - 2*floor(trial / 2))*1.8
alter VB0 = $&drive
let drive = (floor(trial / 2) - 2*floor(trial / 4))*1.8
alter VB1 = $&drive
let drive = (floor(trial / 4) - 2*floor(trial / 8))*1.8
alter VB2 = $&drive
let drive = (floor(trial / 8) - 2*floor(trial / 16))*1.8
alter VB3 = $&drive
let drive = (floor(trial / 16) - 2*floor(trial / 32))*1.8
alter VB4 = $&drive
let drive = (floor(trial / 32) - 2*floor(trial / 64))*1.8
alter VB5 = $&drive
let drive = (floor(trial / 64) - 2*floor(trial / 128))*1.8
alter VB6 = $&drive
let drive = (floor(trial / 128) - 2*floor(trial / 256))*1.8
alter VB7 = $&drive
stop when time = 0.002854
resume
delete all
let endpoint = length(time)-1
let cmp = v(COMP)[endpoint]
let top = v(TOP)[endpoint]
let decision = 0
if cmp >= 0.9
let code = trial
let decision = 1
end
echo 158 4 $&trial $&cmp $&top 0.72890625 $&decision >> decisions.csv
let trial = code + 8
let drive = (floor(trial / 1) - 2*floor(trial / 2))*1.8
alter VB0 = $&drive
let drive = (floor(trial / 2) - 2*floor(trial / 4))*1.8
alter VB1 = $&drive
let drive = (floor(trial / 4) - 2*floor(trial / 8))*1.8
alter VB2 = $&drive
let drive = (floor(trial / 8) - 2*floor(trial / 16))*1.8
alter VB3 = $&drive
let drive = (floor(trial / 16) - 2*floor(trial / 32))*1.8
alter VB4 = $&drive
let drive = (floor(trial / 32) - 2*floor(trial / 64))*1.8
alter VB5 = $&drive
let drive = (floor(trial / 64) - 2*floor(trial / 128))*1.8
alter VB6 = $&drive
let drive = (floor(trial / 128) - 2*floor(trial / 256))*1.8
alter VB7 = $&drive
stop when time = 0.002856
resume
delete all
let endpoint = length(time)-1
let cmp = v(COMP)[endpoint]
let top = v(TOP)[endpoint]
let decision = 0
if cmp >= 0.9
let code = trial
let decision = 1
end
echo 158 3 $&trial $&cmp $&top 0.72890625 $&decision >> decisions.csv
let trial = code + 4
let drive = (floor(trial / 1) - 2*floor(trial / 2))*1.8
alter VB0 = $&drive
let drive = (floor(trial / 2) - 2*floor(trial / 4))*1.8
alter VB1 = $&drive
let drive = (floor(trial / 4) - 2*floor(trial / 8))*1.8
alter VB2 = $&drive
let drive = (floor(trial / 8) - 2*floor(trial / 16))*1.8
alter VB3 = $&drive
let drive = (floor(trial / 16) - 2*floor(trial / 32))*1.8
alter VB4 = $&drive
let drive = (floor(trial / 32) - 2*floor(trial / 64))*1.8
alter VB5 = $&drive
let drive = (floor(trial / 64) - 2*floor(trial / 128))*1.8
alter VB6 = $&drive
let drive = (floor(trial / 128) - 2*floor(trial / 256))*1.8
alter VB7 = $&drive
stop when time = 0.002858
resume
delete all
let endpoint = length(time)-1
let cmp = v(COMP)[endpoint]
let top = v(TOP)[endpoint]
let decision = 0
if cmp >= 0.9
let code = trial
let decision = 1
end
echo 158 2 $&trial $&cmp $&top 0.72890625 $&decision >> decisions.csv
let trial = code + 2
let drive = (floor(trial / 1) - 2*floor(trial / 2))*1.8
alter VB0 = $&drive
let drive = (floor(trial / 2) - 2*floor(trial / 4))*1.8
alter VB1 = $&drive
let drive = (floor(trial / 4) - 2*floor(trial / 8))*1.8
alter VB2 = $&drive
let drive = (floor(trial / 8) - 2*floor(trial / 16))*1.8
alter VB3 = $&drive
let drive = (floor(trial / 16) - 2*floor(trial / 32))*1.8
alter VB4 = $&drive
let drive = (floor(trial / 32) - 2*floor(trial / 64))*1.8
alter VB5 = $&drive
let drive = (floor(trial / 64) - 2*floor(trial / 128))*1.8
alter VB6 = $&drive
let drive = (floor(trial / 128) - 2*floor(trial / 256))*1.8
alter VB7 = $&drive
stop when time = 0.00286
resume
delete all
let endpoint = length(time)-1
let cmp = v(COMP)[endpoint]
let top = v(TOP)[endpoint]
let decision = 0
if cmp >= 0.9
let code = trial
let decision = 1
end
echo 158 1 $&trial $&cmp $&top 0.72890625 $&decision >> decisions.csv
let trial = code + 1
let drive = (floor(trial / 1) - 2*floor(trial / 2))*1.8
alter VB0 = $&drive
let drive = (floor(trial / 2) - 2*floor(trial / 4))*1.8
alter VB1 = $&drive
let drive = (floor(trial / 4) - 2*floor(trial / 8))*1.8
alter VB2 = $&drive
let drive = (floor(trial / 8) - 2*floor(trial / 16))*1.8
alter VB3 = $&drive
let drive = (floor(trial / 16) - 2*floor(trial / 32))*1.8
alter VB4 = $&drive
let drive = (floor(trial / 32) - 2*floor(trial / 64))*1.8
alter VB5 = $&drive
let drive = (floor(trial / 64) - 2*floor(trial / 128))*1.8
alter VB6 = $&drive
let drive = (floor(trial / 128) - 2*floor(trial / 256))*1.8
alter VB7 = $&drive
stop when time = 0.002862
resume
delete all
let endpoint = length(time)-1
let cmp = v(COMP)[endpoint]
let top = v(TOP)[endpoint]
let decision = 0
if cmp >= 0.9
let code = trial
let decision = 1
end
echo 158 0 $&trial $&cmp $&top 0.72890625 $&decision >> decisions.csv
alter VIN = 0.73359375
alter VSAMPLE = 1.8
alter VB0 = 0
alter VB1 = 0
alter VB2 = 0
alter VB3 = 0
alter VB4 = 0
alter VB5 = 0
alter VB6 = 0
alter VB7 = 0
let code = 0
stop when time = 0.002864
resume
delete all
alter VSAMPLE = 0
let trial = code + 128
let drive = (floor(trial / 1) - 2*floor(trial / 2))*1.8
alter VB0 = $&drive
let drive = (floor(trial / 2) - 2*floor(trial / 4))*1.8
alter VB1 = $&drive
let drive = (floor(trial / 4) - 2*floor(trial / 8))*1.8
alter VB2 = $&drive
let drive = (floor(trial / 8) - 2*floor(trial / 16))*1.8
alter VB3 = $&drive
let drive = (floor(trial / 16) - 2*floor(trial / 32))*1.8
alter VB4 = $&drive
let drive = (floor(trial / 32) - 2*floor(trial / 64))*1.8
alter VB5 = $&drive
let drive = (floor(trial / 64) - 2*floor(trial / 128))*1.8
alter VB6 = $&drive
let drive = (floor(trial / 128) - 2*floor(trial / 256))*1.8
alter VB7 = $&drive
stop when time = 0.002866
resume
delete all
let endpoint = length(time)-1
let cmp = v(COMP)[endpoint]
let top = v(TOP)[endpoint]
let decision = 0
if cmp >= 0.9
let code = trial
let decision = 1
end
echo 159 7 $&trial $&cmp $&top 0.73359375 $&decision >> decisions.csv
let trial = code + 64
let drive = (floor(trial / 1) - 2*floor(trial / 2))*1.8
alter VB0 = $&drive
let drive = (floor(trial / 2) - 2*floor(trial / 4))*1.8
alter VB1 = $&drive
let drive = (floor(trial / 4) - 2*floor(trial / 8))*1.8
alter VB2 = $&drive
let drive = (floor(trial / 8) - 2*floor(trial / 16))*1.8
alter VB3 = $&drive
let drive = (floor(trial / 16) - 2*floor(trial / 32))*1.8
alter VB4 = $&drive
let drive = (floor(trial / 32) - 2*floor(trial / 64))*1.8
alter VB5 = $&drive
let drive = (floor(trial / 64) - 2*floor(trial / 128))*1.8
alter VB6 = $&drive
let drive = (floor(trial / 128) - 2*floor(trial / 256))*1.8
alter VB7 = $&drive
stop when time = 0.002868
resume
delete all
let endpoint = length(time)-1
let cmp = v(COMP)[endpoint]
let top = v(TOP)[endpoint]
let decision = 0
if cmp >= 0.9
let code = trial
let decision = 1
end
echo 159 6 $&trial $&cmp $&top 0.73359375 $&decision >> decisions.csv
let trial = code + 32
let drive = (floor(trial / 1) - 2*floor(trial / 2))*1.8
alter VB0 = $&drive
let drive = (floor(trial / 2) - 2*floor(trial / 4))*1.8
alter VB1 = $&drive
let drive = (floor(trial / 4) - 2*floor(trial / 8))*1.8
alter VB2 = $&drive
let drive = (floor(trial / 8) - 2*floor(trial / 16))*1.8
alter VB3 = $&drive
let drive = (floor(trial / 16) - 2*floor(trial / 32))*1.8
alter VB4 = $&drive
let drive = (floor(trial / 32) - 2*floor(trial / 64))*1.8
alter VB5 = $&drive
let drive = (floor(trial / 64) - 2*floor(trial / 128))*1.8
alter VB6 = $&drive
let drive = (floor(trial / 128) - 2*floor(trial / 256))*1.8
alter VB7 = $&drive
stop when time = 0.00287
resume
delete all
let endpoint = length(time)-1
let cmp = v(COMP)[endpoint]
let top = v(TOP)[endpoint]
let decision = 0
if cmp >= 0.9
let code = trial
let decision = 1
end
echo 159 5 $&trial $&cmp $&top 0.73359375 $&decision >> decisions.csv
let trial = code + 16
let drive = (floor(trial / 1) - 2*floor(trial / 2))*1.8
alter VB0 = $&drive
let drive = (floor(trial / 2) - 2*floor(trial / 4))*1.8
alter VB1 = $&drive
let drive = (floor(trial / 4) - 2*floor(trial / 8))*1.8
alter VB2 = $&drive
let drive = (floor(trial / 8) - 2*floor(trial / 16))*1.8
alter VB3 = $&drive
let drive = (floor(trial / 16) - 2*floor(trial / 32))*1.8
alter VB4 = $&drive
let drive = (floor(trial / 32) - 2*floor(trial / 64))*1.8
alter VB5 = $&drive
let drive = (floor(trial / 64) - 2*floor(trial / 128))*1.8
alter VB6 = $&drive
let drive = (floor(trial / 128) - 2*floor(trial / 256))*1.8
alter VB7 = $&drive
stop when time = 0.002872
resume
delete all
let endpoint = length(time)-1
let cmp = v(COMP)[endpoint]
let top = v(TOP)[endpoint]
let decision = 0
if cmp >= 0.9
let code = trial
let decision = 1
end
echo 159 4 $&trial $&cmp $&top 0.73359375 $&decision >> decisions.csv
let trial = code + 8
let drive = (floor(trial / 1) - 2*floor(trial / 2))*1.8
alter VB0 = $&drive
let drive = (floor(trial / 2) - 2*floor(trial / 4))*1.8
alter VB1 = $&drive
let drive = (floor(trial / 4) - 2*floor(trial / 8))*1.8
alter VB2 = $&drive
let drive = (floor(trial / 8) - 2*floor(trial / 16))*1.8
alter VB3 = $&drive
let drive = (floor(trial / 16) - 2*floor(trial / 32))*1.8
alter VB4 = $&drive
let drive = (floor(trial / 32) - 2*floor(trial / 64))*1.8
alter VB5 = $&drive
let drive = (floor(trial / 64) - 2*floor(trial / 128))*1.8
alter VB6 = $&drive
let drive = (floor(trial / 128) - 2*floor(trial / 256))*1.8
alter VB7 = $&drive
stop when time = 0.002874
resume
delete all
let endpoint = length(time)-1
let cmp = v(COMP)[endpoint]
let top = v(TOP)[endpoint]
let decision = 0
if cmp >= 0.9
let code = trial
let decision = 1
end
echo 159 3 $&trial $&cmp $&top 0.73359375 $&decision >> decisions.csv
let trial = code + 4
let drive = (floor(trial / 1) - 2*floor(trial / 2))*1.8
alter VB0 = $&drive
let drive = (floor(trial / 2) - 2*floor(trial / 4))*1.8
alter VB1 = $&drive
let drive = (floor(trial / 4) - 2*floor(trial / 8))*1.8
alter VB2 = $&drive
let drive = (floor(trial / 8) - 2*floor(trial / 16))*1.8
alter VB3 = $&drive
let drive = (floor(trial / 16) - 2*floor(trial / 32))*1.8
alter VB4 = $&drive
let drive = (floor(trial / 32) - 2*floor(trial / 64))*1.8
alter VB5 = $&drive
let drive = (floor(trial / 64) - 2*floor(trial / 128))*1.8
alter VB6 = $&drive
let drive = (floor(trial / 128) - 2*floor(trial / 256))*1.8
alter VB7 = $&drive
stop when time = 0.002876
resume
delete all
let endpoint = length(time)-1
let cmp = v(COMP)[endpoint]
let top = v(TOP)[endpoint]
let decision = 0
if cmp >= 0.9
let code = trial
let decision = 1
end
echo 159 2 $&trial $&cmp $&top 0.73359375 $&decision >> decisions.csv
let trial = code + 2
let drive = (floor(trial / 1) - 2*floor(trial / 2))*1.8
alter VB0 = $&drive
let drive = (floor(trial / 2) - 2*floor(trial / 4))*1.8
alter VB1 = $&drive
let drive = (floor(trial / 4) - 2*floor(trial / 8))*1.8
alter VB2 = $&drive
let drive = (floor(trial / 8) - 2*floor(trial / 16))*1.8
alter VB3 = $&drive
let drive = (floor(trial / 16) - 2*floor(trial / 32))*1.8
alter VB4 = $&drive
let drive = (floor(trial / 32) - 2*floor(trial / 64))*1.8
alter VB5 = $&drive
let drive = (floor(trial / 64) - 2*floor(trial / 128))*1.8
alter VB6 = $&drive
let drive = (floor(trial / 128) - 2*floor(trial / 256))*1.8
alter VB7 = $&drive
stop when time = 0.002878
resume
delete all
let endpoint = length(time)-1
let cmp = v(COMP)[endpoint]
let top = v(TOP)[endpoint]
let decision = 0
if cmp >= 0.9
let code = trial
let decision = 1
end
echo 159 1 $&trial $&cmp $&top 0.73359375 $&decision >> decisions.csv
let trial = code + 1
let drive = (floor(trial / 1) - 2*floor(trial / 2))*1.8
alter VB0 = $&drive
let drive = (floor(trial / 2) - 2*floor(trial / 4))*1.8
alter VB1 = $&drive
let drive = (floor(trial / 4) - 2*floor(trial / 8))*1.8
alter VB2 = $&drive
let drive = (floor(trial / 8) - 2*floor(trial / 16))*1.8
alter VB3 = $&drive
let drive = (floor(trial / 16) - 2*floor(trial / 32))*1.8
alter VB4 = $&drive
let drive = (floor(trial / 32) - 2*floor(trial / 64))*1.8
alter VB5 = $&drive
let drive = (floor(trial / 64) - 2*floor(trial / 128))*1.8
alter VB6 = $&drive
let drive = (floor(trial / 128) - 2*floor(trial / 256))*1.8
alter VB7 = $&drive
stop when time = 0.00288
resume
delete all
let endpoint = length(time)-1
let cmp = v(COMP)[endpoint]
let top = v(TOP)[endpoint]
let decision = 0
if cmp >= 0.9
let code = trial
let decision = 1
end
echo 159 0 $&trial $&cmp $&top 0.73359375 $&decision >> decisions.csv
alter VIN = 0.73828125
alter VSAMPLE = 1.8
alter VB0 = 0
alter VB1 = 0
alter VB2 = 0
alter VB3 = 0
alter VB4 = 0
alter VB5 = 0
alter VB6 = 0
alter VB7 = 0
let code = 0
stop when time = 0.002882
resume
delete all
alter VSAMPLE = 0
let trial = code + 128
let drive = (floor(trial / 1) - 2*floor(trial / 2))*1.8
alter VB0 = $&drive
let drive = (floor(trial / 2) - 2*floor(trial / 4))*1.8
alter VB1 = $&drive
let drive = (floor(trial / 4) - 2*floor(trial / 8))*1.8
alter VB2 = $&drive
let drive = (floor(trial / 8) - 2*floor(trial / 16))*1.8
alter VB3 = $&drive
let drive = (floor(trial / 16) - 2*floor(trial / 32))*1.8
alter VB4 = $&drive
let drive = (floor(trial / 32) - 2*floor(trial / 64))*1.8
alter VB5 = $&drive
let drive = (floor(trial / 64) - 2*floor(trial / 128))*1.8
alter VB6 = $&drive
let drive = (floor(trial / 128) - 2*floor(trial / 256))*1.8
alter VB7 = $&drive
stop when time = 0.002884
resume
delete all
let endpoint = length(time)-1
let cmp = v(COMP)[endpoint]
let top = v(TOP)[endpoint]
let decision = 0
if cmp >= 0.9
let code = trial
let decision = 1
end
echo 160 7 $&trial $&cmp $&top 0.73828125 $&decision >> decisions.csv
let trial = code + 64
let drive = (floor(trial / 1) - 2*floor(trial / 2))*1.8
alter VB0 = $&drive
let drive = (floor(trial / 2) - 2*floor(trial / 4))*1.8
alter VB1 = $&drive
let drive = (floor(trial / 4) - 2*floor(trial / 8))*1.8
alter VB2 = $&drive
let drive = (floor(trial / 8) - 2*floor(trial / 16))*1.8
alter VB3 = $&drive
let drive = (floor(trial / 16) - 2*floor(trial / 32))*1.8
alter VB4 = $&drive
let drive = (floor(trial / 32) - 2*floor(trial / 64))*1.8
alter VB5 = $&drive
let drive = (floor(trial / 64) - 2*floor(trial / 128))*1.8
alter VB6 = $&drive
let drive = (floor(trial / 128) - 2*floor(trial / 256))*1.8
alter VB7 = $&drive
stop when time = 0.002886
resume
delete all
let endpoint = length(time)-1
let cmp = v(COMP)[endpoint]
let top = v(TOP)[endpoint]
let decision = 0
if cmp >= 0.9
let code = trial
let decision = 1
end
echo 160 6 $&trial $&cmp $&top 0.73828125 $&decision >> decisions.csv
let trial = code + 32
let drive = (floor(trial / 1) - 2*floor(trial / 2))*1.8
alter VB0 = $&drive
let drive = (floor(trial / 2) - 2*floor(trial / 4))*1.8
alter VB1 = $&drive
let drive = (floor(trial / 4) - 2*floor(trial / 8))*1.8
alter VB2 = $&drive
let drive = (floor(trial / 8) - 2*floor(trial / 16))*1.8
alter VB3 = $&drive
let drive = (floor(trial / 16) - 2*floor(trial / 32))*1.8
alter VB4 = $&drive
let drive = (floor(trial / 32) - 2*floor(trial / 64))*1.8
alter VB5 = $&drive
let drive = (floor(trial / 64) - 2*floor(trial / 128))*1.8
alter VB6 = $&drive
let drive = (floor(trial / 128) - 2*floor(trial / 256))*1.8
alter VB7 = $&drive
stop when time = 0.002888
resume
delete all
let endpoint = length(time)-1
let cmp = v(COMP)[endpoint]
let top = v(TOP)[endpoint]
let decision = 0
if cmp >= 0.9
let code = trial
let decision = 1
end
echo 160 5 $&trial $&cmp $&top 0.73828125 $&decision >> decisions.csv
let trial = code + 16
let drive = (floor(trial / 1) - 2*floor(trial / 2))*1.8
alter VB0 = $&drive
let drive = (floor(trial / 2) - 2*floor(trial / 4))*1.8
alter VB1 = $&drive
let drive = (floor(trial / 4) - 2*floor(trial / 8))*1.8
alter VB2 = $&drive
let drive = (floor(trial / 8) - 2*floor(trial / 16))*1.8
alter VB3 = $&drive
let drive = (floor(trial / 16) - 2*floor(trial / 32))*1.8
alter VB4 = $&drive
let drive = (floor(trial / 32) - 2*floor(trial / 64))*1.8
alter VB5 = $&drive
let drive = (floor(trial / 64) - 2*floor(trial / 128))*1.8
alter VB6 = $&drive
let drive = (floor(trial / 128) - 2*floor(trial / 256))*1.8
alter VB7 = $&drive
stop when time = 0.00289
resume
delete all
let endpoint = length(time)-1
let cmp = v(COMP)[endpoint]
let top = v(TOP)[endpoint]
let decision = 0
if cmp >= 0.9
let code = trial
let decision = 1
end
echo 160 4 $&trial $&cmp $&top 0.73828125 $&decision >> decisions.csv
let trial = code + 8
let drive = (floor(trial / 1) - 2*floor(trial / 2))*1.8
alter VB0 = $&drive
let drive = (floor(trial / 2) - 2*floor(trial / 4))*1.8
alter VB1 = $&drive
let drive = (floor(trial / 4) - 2*floor(trial / 8))*1.8
alter VB2 = $&drive
let drive = (floor(trial / 8) - 2*floor(trial / 16))*1.8
alter VB3 = $&drive
let drive = (floor(trial / 16) - 2*floor(trial / 32))*1.8
alter VB4 = $&drive
let drive = (floor(trial / 32) - 2*floor(trial / 64))*1.8
alter VB5 = $&drive
let drive = (floor(trial / 64) - 2*floor(trial / 128))*1.8
alter VB6 = $&drive
let drive = (floor(trial / 128) - 2*floor(trial / 256))*1.8
alter VB7 = $&drive
stop when time = 0.002892
resume
delete all
let endpoint = length(time)-1
let cmp = v(COMP)[endpoint]
let top = v(TOP)[endpoint]
let decision = 0
if cmp >= 0.9
let code = trial
let decision = 1
end
echo 160 3 $&trial $&cmp $&top 0.73828125 $&decision >> decisions.csv
let trial = code + 4
let drive = (floor(trial / 1) - 2*floor(trial / 2))*1.8
alter VB0 = $&drive
let drive = (floor(trial / 2) - 2*floor(trial / 4))*1.8
alter VB1 = $&drive
let drive = (floor(trial / 4) - 2*floor(trial / 8))*1.8
alter VB2 = $&drive
let drive = (floor(trial / 8) - 2*floor(trial / 16))*1.8
alter VB3 = $&drive
let drive = (floor(trial / 16) - 2*floor(trial / 32))*1.8
alter VB4 = $&drive
let drive = (floor(trial / 32) - 2*floor(trial / 64))*1.8
alter VB5 = $&drive
let drive = (floor(trial / 64) - 2*floor(trial / 128))*1.8
alter VB6 = $&drive
let drive = (floor(trial / 128) - 2*floor(trial / 256))*1.8
alter VB7 = $&drive
stop when time = 0.002894
resume
delete all
let endpoint = length(time)-1
let cmp = v(COMP)[endpoint]
let top = v(TOP)[endpoint]
let decision = 0
if cmp >= 0.9
let code = trial
let decision = 1
end
echo 160 2 $&trial $&cmp $&top 0.73828125 $&decision >> decisions.csv
let trial = code + 2
let drive = (floor(trial / 1) - 2*floor(trial / 2))*1.8
alter VB0 = $&drive
let drive = (floor(trial / 2) - 2*floor(trial / 4))*1.8
alter VB1 = $&drive
let drive = (floor(trial / 4) - 2*floor(trial / 8))*1.8
alter VB2 = $&drive
let drive = (floor(trial / 8) - 2*floor(trial / 16))*1.8
alter VB3 = $&drive
let drive = (floor(trial / 16) - 2*floor(trial / 32))*1.8
alter VB4 = $&drive
let drive = (floor(trial / 32) - 2*floor(trial / 64))*1.8
alter VB5 = $&drive
let drive = (floor(trial / 64) - 2*floor(trial / 128))*1.8
alter VB6 = $&drive
let drive = (floor(trial / 128) - 2*floor(trial / 256))*1.8
alter VB7 = $&drive
stop when time = 0.002896
resume
delete all
let endpoint = length(time)-1
let cmp = v(COMP)[endpoint]
let top = v(TOP)[endpoint]
let decision = 0
if cmp >= 0.9
let code = trial
let decision = 1
end
echo 160 1 $&trial $&cmp $&top 0.73828125 $&decision >> decisions.csv
let trial = code + 1
let drive = (floor(trial / 1) - 2*floor(trial / 2))*1.8
alter VB0 = $&drive
let drive = (floor(trial / 2) - 2*floor(trial / 4))*1.8
alter VB1 = $&drive
let drive = (floor(trial / 4) - 2*floor(trial / 8))*1.8
alter VB2 = $&drive
let drive = (floor(trial / 8) - 2*floor(trial / 16))*1.8
alter VB3 = $&drive
let drive = (floor(trial / 16) - 2*floor(trial / 32))*1.8
alter VB4 = $&drive
let drive = (floor(trial / 32) - 2*floor(trial / 64))*1.8
alter VB5 = $&drive
let drive = (floor(trial / 64) - 2*floor(trial / 128))*1.8
alter VB6 = $&drive
let drive = (floor(trial / 128) - 2*floor(trial / 256))*1.8
alter VB7 = $&drive
stop when time = 0.002898
resume
delete all
let endpoint = length(time)-1
let cmp = v(COMP)[endpoint]
let top = v(TOP)[endpoint]
let decision = 0
if cmp >= 0.9
let code = trial
let decision = 1
end
echo 160 0 $&trial $&cmp $&top 0.73828125 $&decision >> decisions.csv
alter VIN = 0.74296875
alter VSAMPLE = 1.8
alter VB0 = 0
alter VB1 = 0
alter VB2 = 0
alter VB3 = 0
alter VB4 = 0
alter VB5 = 0
alter VB6 = 0
alter VB7 = 0
let code = 0
stop when time = 0.0029
resume
delete all
alter VSAMPLE = 0
let trial = code + 128
let drive = (floor(trial / 1) - 2*floor(trial / 2))*1.8
alter VB0 = $&drive
let drive = (floor(trial / 2) - 2*floor(trial / 4))*1.8
alter VB1 = $&drive
let drive = (floor(trial / 4) - 2*floor(trial / 8))*1.8
alter VB2 = $&drive
let drive = (floor(trial / 8) - 2*floor(trial / 16))*1.8
alter VB3 = $&drive
let drive = (floor(trial / 16) - 2*floor(trial / 32))*1.8
alter VB4 = $&drive
let drive = (floor(trial / 32) - 2*floor(trial / 64))*1.8
alter VB5 = $&drive
let drive = (floor(trial / 64) - 2*floor(trial / 128))*1.8
alter VB6 = $&drive
let drive = (floor(trial / 128) - 2*floor(trial / 256))*1.8
alter VB7 = $&drive
stop when time = 0.002902
resume
delete all
let endpoint = length(time)-1
let cmp = v(COMP)[endpoint]
let top = v(TOP)[endpoint]
let decision = 0
if cmp >= 0.9
let code = trial
let decision = 1
end
echo 161 7 $&trial $&cmp $&top 0.74296875 $&decision >> decisions.csv
let trial = code + 64
let drive = (floor(trial / 1) - 2*floor(trial / 2))*1.8
alter VB0 = $&drive
let drive = (floor(trial / 2) - 2*floor(trial / 4))*1.8
alter VB1 = $&drive
let drive = (floor(trial / 4) - 2*floor(trial / 8))*1.8
alter VB2 = $&drive
let drive = (floor(trial / 8) - 2*floor(trial / 16))*1.8
alter VB3 = $&drive
let drive = (floor(trial / 16) - 2*floor(trial / 32))*1.8
alter VB4 = $&drive
let drive = (floor(trial / 32) - 2*floor(trial / 64))*1.8
alter VB5 = $&drive
let drive = (floor(trial / 64) - 2*floor(trial / 128))*1.8
alter VB6 = $&drive
let drive = (floor(trial / 128) - 2*floor(trial / 256))*1.8
alter VB7 = $&drive
stop when time = 0.002904
resume
delete all
let endpoint = length(time)-1
let cmp = v(COMP)[endpoint]
let top = v(TOP)[endpoint]
let decision = 0
if cmp >= 0.9
let code = trial
let decision = 1
end
echo 161 6 $&trial $&cmp $&top 0.74296875 $&decision >> decisions.csv
let trial = code + 32
let drive = (floor(trial / 1) - 2*floor(trial / 2))*1.8
alter VB0 = $&drive
let drive = (floor(trial / 2) - 2*floor(trial / 4))*1.8
alter VB1 = $&drive
let drive = (floor(trial / 4) - 2*floor(trial / 8))*1.8
alter VB2 = $&drive
let drive = (floor(trial / 8) - 2*floor(trial / 16))*1.8
alter VB3 = $&drive
let drive = (floor(trial / 16) - 2*floor(trial / 32))*1.8
alter VB4 = $&drive
let drive = (floor(trial / 32) - 2*floor(trial / 64))*1.8
alter VB5 = $&drive
let drive = (floor(trial / 64) - 2*floor(trial / 128))*1.8
alter VB6 = $&drive
let drive = (floor(trial / 128) - 2*floor(trial / 256))*1.8
alter VB7 = $&drive
stop when time = 0.002906
resume
delete all
let endpoint = length(time)-1
let cmp = v(COMP)[endpoint]
let top = v(TOP)[endpoint]
let decision = 0
if cmp >= 0.9
let code = trial
let decision = 1
end
echo 161 5 $&trial $&cmp $&top 0.74296875 $&decision >> decisions.csv
let trial = code + 16
let drive = (floor(trial / 1) - 2*floor(trial / 2))*1.8
alter VB0 = $&drive
let drive = (floor(trial / 2) - 2*floor(trial / 4))*1.8
alter VB1 = $&drive
let drive = (floor(trial / 4) - 2*floor(trial / 8))*1.8
alter VB2 = $&drive
let drive = (floor(trial / 8) - 2*floor(trial / 16))*1.8
alter VB3 = $&drive
let drive = (floor(trial / 16) - 2*floor(trial / 32))*1.8
alter VB4 = $&drive
let drive = (floor(trial / 32) - 2*floor(trial / 64))*1.8
alter VB5 = $&drive
let drive = (floor(trial / 64) - 2*floor(trial / 128))*1.8
alter VB6 = $&drive
let drive = (floor(trial / 128) - 2*floor(trial / 256))*1.8
alter VB7 = $&drive
stop when time = 0.002908
resume
delete all
let endpoint = length(time)-1
let cmp = v(COMP)[endpoint]
let top = v(TOP)[endpoint]
let decision = 0
if cmp >= 0.9
let code = trial
let decision = 1
end
echo 161 4 $&trial $&cmp $&top 0.74296875 $&decision >> decisions.csv
let trial = code + 8
let drive = (floor(trial / 1) - 2*floor(trial / 2))*1.8
alter VB0 = $&drive
let drive = (floor(trial / 2) - 2*floor(trial / 4))*1.8
alter VB1 = $&drive
let drive = (floor(trial / 4) - 2*floor(trial / 8))*1.8
alter VB2 = $&drive
let drive = (floor(trial / 8) - 2*floor(trial / 16))*1.8
alter VB3 = $&drive
let drive = (floor(trial / 16) - 2*floor(trial / 32))*1.8
alter VB4 = $&drive
let drive = (floor(trial / 32) - 2*floor(trial / 64))*1.8
alter VB5 = $&drive
let drive = (floor(trial / 64) - 2*floor(trial / 128))*1.8
alter VB6 = $&drive
let drive = (floor(trial / 128) - 2*floor(trial / 256))*1.8
alter VB7 = $&drive
stop when time = 0.00291
resume
delete all
let endpoint = length(time)-1
let cmp = v(COMP)[endpoint]
let top = v(TOP)[endpoint]
let decision = 0
if cmp >= 0.9
let code = trial
let decision = 1
end
echo 161 3 $&trial $&cmp $&top 0.74296875 $&decision >> decisions.csv
let trial = code + 4
let drive = (floor(trial / 1) - 2*floor(trial / 2))*1.8
alter VB0 = $&drive
let drive = (floor(trial / 2) - 2*floor(trial / 4))*1.8
alter VB1 = $&drive
let drive = (floor(trial / 4) - 2*floor(trial / 8))*1.8
alter VB2 = $&drive
let drive = (floor(trial / 8) - 2*floor(trial / 16))*1.8
alter VB3 = $&drive
let drive = (floor(trial / 16) - 2*floor(trial / 32))*1.8
alter VB4 = $&drive
let drive = (floor(trial / 32) - 2*floor(trial / 64))*1.8
alter VB5 = $&drive
let drive = (floor(trial / 64) - 2*floor(trial / 128))*1.8
alter VB6 = $&drive
let drive = (floor(trial / 128) - 2*floor(trial / 256))*1.8
alter VB7 = $&drive
stop when time = 0.002912
resume
delete all
let endpoint = length(time)-1
let cmp = v(COMP)[endpoint]
let top = v(TOP)[endpoint]
let decision = 0
if cmp >= 0.9
let code = trial
let decision = 1
end
echo 161 2 $&trial $&cmp $&top 0.74296875 $&decision >> decisions.csv
let trial = code + 2
let drive = (floor(trial / 1) - 2*floor(trial / 2))*1.8
alter VB0 = $&drive
let drive = (floor(trial / 2) - 2*floor(trial / 4))*1.8
alter VB1 = $&drive
let drive = (floor(trial / 4) - 2*floor(trial / 8))*1.8
alter VB2 = $&drive
let drive = (floor(trial / 8) - 2*floor(trial / 16))*1.8
alter VB3 = $&drive
let drive = (floor(trial / 16) - 2*floor(trial / 32))*1.8
alter VB4 = $&drive
let drive = (floor(trial / 32) - 2*floor(trial / 64))*1.8
alter VB5 = $&drive
let drive = (floor(trial / 64) - 2*floor(trial / 128))*1.8
alter VB6 = $&drive
let drive = (floor(trial / 128) - 2*floor(trial / 256))*1.8
alter VB7 = $&drive
stop when time = 0.002914
resume
delete all
let endpoint = length(time)-1
let cmp = v(COMP)[endpoint]
let top = v(TOP)[endpoint]
let decision = 0
if cmp >= 0.9
let code = trial
let decision = 1
end
echo 161 1 $&trial $&cmp $&top 0.74296875 $&decision >> decisions.csv
let trial = code + 1
let drive = (floor(trial / 1) - 2*floor(trial / 2))*1.8
alter VB0 = $&drive
let drive = (floor(trial / 2) - 2*floor(trial / 4))*1.8
alter VB1 = $&drive
let drive = (floor(trial / 4) - 2*floor(trial / 8))*1.8
alter VB2 = $&drive
let drive = (floor(trial / 8) - 2*floor(trial / 16))*1.8
alter VB3 = $&drive
let drive = (floor(trial / 16) - 2*floor(trial / 32))*1.8
alter VB4 = $&drive
let drive = (floor(trial / 32) - 2*floor(trial / 64))*1.8
alter VB5 = $&drive
let drive = (floor(trial / 64) - 2*floor(trial / 128))*1.8
alter VB6 = $&drive
let drive = (floor(trial / 128) - 2*floor(trial / 256))*1.8
alter VB7 = $&drive
stop when time = 0.002916
resume
delete all
let endpoint = length(time)-1
let cmp = v(COMP)[endpoint]
let top = v(TOP)[endpoint]
let decision = 0
if cmp >= 0.9
let code = trial
let decision = 1
end
echo 161 0 $&trial $&cmp $&top 0.74296875 $&decision >> decisions.csv
alter VIN = 0.74765625
alter VSAMPLE = 1.8
alter VB0 = 0
alter VB1 = 0
alter VB2 = 0
alter VB3 = 0
alter VB4 = 0
alter VB5 = 0
alter VB6 = 0
alter VB7 = 0
let code = 0
stop when time = 0.002918
resume
delete all
alter VSAMPLE = 0
let trial = code + 128
let drive = (floor(trial / 1) - 2*floor(trial / 2))*1.8
alter VB0 = $&drive
let drive = (floor(trial / 2) - 2*floor(trial / 4))*1.8
alter VB1 = $&drive
let drive = (floor(trial / 4) - 2*floor(trial / 8))*1.8
alter VB2 = $&drive
let drive = (floor(trial / 8) - 2*floor(trial / 16))*1.8
alter VB3 = $&drive
let drive = (floor(trial / 16) - 2*floor(trial / 32))*1.8
alter VB4 = $&drive
let drive = (floor(trial / 32) - 2*floor(trial / 64))*1.8
alter VB5 = $&drive
let drive = (floor(trial / 64) - 2*floor(trial / 128))*1.8
alter VB6 = $&drive
let drive = (floor(trial / 128) - 2*floor(trial / 256))*1.8
alter VB7 = $&drive
stop when time = 0.00292
resume
delete all
let endpoint = length(time)-1
let cmp = v(COMP)[endpoint]
let top = v(TOP)[endpoint]
let decision = 0
if cmp >= 0.9
let code = trial
let decision = 1
end
echo 162 7 $&trial $&cmp $&top 0.74765625 $&decision >> decisions.csv
let trial = code + 64
let drive = (floor(trial / 1) - 2*floor(trial / 2))*1.8
alter VB0 = $&drive
let drive = (floor(trial / 2) - 2*floor(trial / 4))*1.8
alter VB1 = $&drive
let drive = (floor(trial / 4) - 2*floor(trial / 8))*1.8
alter VB2 = $&drive
let drive = (floor(trial / 8) - 2*floor(trial / 16))*1.8
alter VB3 = $&drive
let drive = (floor(trial / 16) - 2*floor(trial / 32))*1.8
alter VB4 = $&drive
let drive = (floor(trial / 32) - 2*floor(trial / 64))*1.8
alter VB5 = $&drive
let drive = (floor(trial / 64) - 2*floor(trial / 128))*1.8
alter VB6 = $&drive
let drive = (floor(trial / 128) - 2*floor(trial / 256))*1.8
alter VB7 = $&drive
stop when time = 0.002922
resume
delete all
let endpoint = length(time)-1
let cmp = v(COMP)[endpoint]
let top = v(TOP)[endpoint]
let decision = 0
if cmp >= 0.9
let code = trial
let decision = 1
end
echo 162 6 $&trial $&cmp $&top 0.74765625 $&decision >> decisions.csv
let trial = code + 32
let drive = (floor(trial / 1) - 2*floor(trial / 2))*1.8
alter VB0 = $&drive
let drive = (floor(trial / 2) - 2*floor(trial / 4))*1.8
alter VB1 = $&drive
let drive = (floor(trial / 4) - 2*floor(trial / 8))*1.8
alter VB2 = $&drive
let drive = (floor(trial / 8) - 2*floor(trial / 16))*1.8
alter VB3 = $&drive
let drive = (floor(trial / 16) - 2*floor(trial / 32))*1.8
alter VB4 = $&drive
let drive = (floor(trial / 32) - 2*floor(trial / 64))*1.8
alter VB5 = $&drive
let drive = (floor(trial / 64) - 2*floor(trial / 128))*1.8
alter VB6 = $&drive
let drive = (floor(trial / 128) - 2*floor(trial / 256))*1.8
alter VB7 = $&drive
stop when time = 0.002924
resume
delete all
let endpoint = length(time)-1
let cmp = v(COMP)[endpoint]
let top = v(TOP)[endpoint]
let decision = 0
if cmp >= 0.9
let code = trial
let decision = 1
end
echo 162 5 $&trial $&cmp $&top 0.74765625 $&decision >> decisions.csv
let trial = code + 16
let drive = (floor(trial / 1) - 2*floor(trial / 2))*1.8
alter VB0 = $&drive
let drive = (floor(trial / 2) - 2*floor(trial / 4))*1.8
alter VB1 = $&drive
let drive = (floor(trial / 4) - 2*floor(trial / 8))*1.8
alter VB2 = $&drive
let drive = (floor(trial / 8) - 2*floor(trial / 16))*1.8
alter VB3 = $&drive
let drive = (floor(trial / 16) - 2*floor(trial / 32))*1.8
alter VB4 = $&drive
let drive = (floor(trial / 32) - 2*floor(trial / 64))*1.8
alter VB5 = $&drive
let drive = (floor(trial / 64) - 2*floor(trial / 128))*1.8
alter VB6 = $&drive
let drive = (floor(trial / 128) - 2*floor(trial / 256))*1.8
alter VB7 = $&drive
stop when time = 0.002926
resume
delete all
let endpoint = length(time)-1
let cmp = v(COMP)[endpoint]
let top = v(TOP)[endpoint]
let decision = 0
if cmp >= 0.9
let code = trial
let decision = 1
end
echo 162 4 $&trial $&cmp $&top 0.74765625 $&decision >> decisions.csv
let trial = code + 8
let drive = (floor(trial / 1) - 2*floor(trial / 2))*1.8
alter VB0 = $&drive
let drive = (floor(trial / 2) - 2*floor(trial / 4))*1.8
alter VB1 = $&drive
let drive = (floor(trial / 4) - 2*floor(trial / 8))*1.8
alter VB2 = $&drive
let drive = (floor(trial / 8) - 2*floor(trial / 16))*1.8
alter VB3 = $&drive
let drive = (floor(trial / 16) - 2*floor(trial / 32))*1.8
alter VB4 = $&drive
let drive = (floor(trial / 32) - 2*floor(trial / 64))*1.8
alter VB5 = $&drive
let drive = (floor(trial / 64) - 2*floor(trial / 128))*1.8
alter VB6 = $&drive
let drive = (floor(trial / 128) - 2*floor(trial / 256))*1.8
alter VB7 = $&drive
stop when time = 0.002928
resume
delete all
let endpoint = length(time)-1
let cmp = v(COMP)[endpoint]
let top = v(TOP)[endpoint]
let decision = 0
if cmp >= 0.9
let code = trial
let decision = 1
end
echo 162 3 $&trial $&cmp $&top 0.74765625 $&decision >> decisions.csv
let trial = code + 4
let drive = (floor(trial / 1) - 2*floor(trial / 2))*1.8
alter VB0 = $&drive
let drive = (floor(trial / 2) - 2*floor(trial / 4))*1.8
alter VB1 = $&drive
let drive = (floor(trial / 4) - 2*floor(trial / 8))*1.8
alter VB2 = $&drive
let drive = (floor(trial / 8) - 2*floor(trial / 16))*1.8
alter VB3 = $&drive
let drive = (floor(trial / 16) - 2*floor(trial / 32))*1.8
alter VB4 = $&drive
let drive = (floor(trial / 32) - 2*floor(trial / 64))*1.8
alter VB5 = $&drive
let drive = (floor(trial / 64) - 2*floor(trial / 128))*1.8
alter VB6 = $&drive
let drive = (floor(trial / 128) - 2*floor(trial / 256))*1.8
alter VB7 = $&drive
stop when time = 0.00293
resume
delete all
let endpoint = length(time)-1
let cmp = v(COMP)[endpoint]
let top = v(TOP)[endpoint]
let decision = 0
if cmp >= 0.9
let code = trial
let decision = 1
end
echo 162 2 $&trial $&cmp $&top 0.74765625 $&decision >> decisions.csv
let trial = code + 2
let drive = (floor(trial / 1) - 2*floor(trial / 2))*1.8
alter VB0 = $&drive
let drive = (floor(trial / 2) - 2*floor(trial / 4))*1.8
alter VB1 = $&drive
let drive = (floor(trial / 4) - 2*floor(trial / 8))*1.8
alter VB2 = $&drive
let drive = (floor(trial / 8) - 2*floor(trial / 16))*1.8
alter VB3 = $&drive
let drive = (floor(trial / 16) - 2*floor(trial / 32))*1.8
alter VB4 = $&drive
let drive = (floor(trial / 32) - 2*floor(trial / 64))*1.8
alter VB5 = $&drive
let drive = (floor(trial / 64) - 2*floor(trial / 128))*1.8
alter VB6 = $&drive
let drive = (floor(trial / 128) - 2*floor(trial / 256))*1.8
alter VB7 = $&drive
stop when time = 0.002932
resume
delete all
let endpoint = length(time)-1
let cmp = v(COMP)[endpoint]
let top = v(TOP)[endpoint]
let decision = 0
if cmp >= 0.9
let code = trial
let decision = 1
end
echo 162 1 $&trial $&cmp $&top 0.74765625 $&decision >> decisions.csv
let trial = code + 1
let drive = (floor(trial / 1) - 2*floor(trial / 2))*1.8
alter VB0 = $&drive
let drive = (floor(trial / 2) - 2*floor(trial / 4))*1.8
alter VB1 = $&drive
let drive = (floor(trial / 4) - 2*floor(trial / 8))*1.8
alter VB2 = $&drive
let drive = (floor(trial / 8) - 2*floor(trial / 16))*1.8
alter VB3 = $&drive
let drive = (floor(trial / 16) - 2*floor(trial / 32))*1.8
alter VB4 = $&drive
let drive = (floor(trial / 32) - 2*floor(trial / 64))*1.8
alter VB5 = $&drive
let drive = (floor(trial / 64) - 2*floor(trial / 128))*1.8
alter VB6 = $&drive
let drive = (floor(trial / 128) - 2*floor(trial / 256))*1.8
alter VB7 = $&drive
stop when time = 0.002934
resume
delete all
let endpoint = length(time)-1
let cmp = v(COMP)[endpoint]
let top = v(TOP)[endpoint]
let decision = 0
if cmp >= 0.9
let code = trial
let decision = 1
end
echo 162 0 $&trial $&cmp $&top 0.74765625 $&decision >> decisions.csv
alter VIN = 0.75234375
alter VSAMPLE = 1.8
alter VB0 = 0
alter VB1 = 0
alter VB2 = 0
alter VB3 = 0
alter VB4 = 0
alter VB5 = 0
alter VB6 = 0
alter VB7 = 0
let code = 0
stop when time = 0.002936
resume
delete all
alter VSAMPLE = 0
let trial = code + 128
let drive = (floor(trial / 1) - 2*floor(trial / 2))*1.8
alter VB0 = $&drive
let drive = (floor(trial / 2) - 2*floor(trial / 4))*1.8
alter VB1 = $&drive
let drive = (floor(trial / 4) - 2*floor(trial / 8))*1.8
alter VB2 = $&drive
let drive = (floor(trial / 8) - 2*floor(trial / 16))*1.8
alter VB3 = $&drive
let drive = (floor(trial / 16) - 2*floor(trial / 32))*1.8
alter VB4 = $&drive
let drive = (floor(trial / 32) - 2*floor(trial / 64))*1.8
alter VB5 = $&drive
let drive = (floor(trial / 64) - 2*floor(trial / 128))*1.8
alter VB6 = $&drive
let drive = (floor(trial / 128) - 2*floor(trial / 256))*1.8
alter VB7 = $&drive
stop when time = 0.002938
resume
delete all
let endpoint = length(time)-1
let cmp = v(COMP)[endpoint]
let top = v(TOP)[endpoint]
let decision = 0
if cmp >= 0.9
let code = trial
let decision = 1
end
echo 163 7 $&trial $&cmp $&top 0.75234375 $&decision >> decisions.csv
let trial = code + 64
let drive = (floor(trial / 1) - 2*floor(trial / 2))*1.8
alter VB0 = $&drive
let drive = (floor(trial / 2) - 2*floor(trial / 4))*1.8
alter VB1 = $&drive
let drive = (floor(trial / 4) - 2*floor(trial / 8))*1.8
alter VB2 = $&drive
let drive = (floor(trial / 8) - 2*floor(trial / 16))*1.8
alter VB3 = $&drive
let drive = (floor(trial / 16) - 2*floor(trial / 32))*1.8
alter VB4 = $&drive
let drive = (floor(trial / 32) - 2*floor(trial / 64))*1.8
alter VB5 = $&drive
let drive = (floor(trial / 64) - 2*floor(trial / 128))*1.8
alter VB6 = $&drive
let drive = (floor(trial / 128) - 2*floor(trial / 256))*1.8
alter VB7 = $&drive
stop when time = 0.00294
resume
delete all
let endpoint = length(time)-1
let cmp = v(COMP)[endpoint]
let top = v(TOP)[endpoint]
let decision = 0
if cmp >= 0.9
let code = trial
let decision = 1
end
echo 163 6 $&trial $&cmp $&top 0.75234375 $&decision >> decisions.csv
let trial = code + 32
let drive = (floor(trial / 1) - 2*floor(trial / 2))*1.8
alter VB0 = $&drive
let drive = (floor(trial / 2) - 2*floor(trial / 4))*1.8
alter VB1 = $&drive
let drive = (floor(trial / 4) - 2*floor(trial / 8))*1.8
alter VB2 = $&drive
let drive = (floor(trial / 8) - 2*floor(trial / 16))*1.8
alter VB3 = $&drive
let drive = (floor(trial / 16) - 2*floor(trial / 32))*1.8
alter VB4 = $&drive
let drive = (floor(trial / 32) - 2*floor(trial / 64))*1.8
alter VB5 = $&drive
let drive = (floor(trial / 64) - 2*floor(trial / 128))*1.8
alter VB6 = $&drive
let drive = (floor(trial / 128) - 2*floor(trial / 256))*1.8
alter VB7 = $&drive
stop when time = 0.002942
resume
delete all
let endpoint = length(time)-1
let cmp = v(COMP)[endpoint]
let top = v(TOP)[endpoint]
let decision = 0
if cmp >= 0.9
let code = trial
let decision = 1
end
echo 163 5 $&trial $&cmp $&top 0.75234375 $&decision >> decisions.csv
let trial = code + 16
let drive = (floor(trial / 1) - 2*floor(trial / 2))*1.8
alter VB0 = $&drive
let drive = (floor(trial / 2) - 2*floor(trial / 4))*1.8
alter VB1 = $&drive
let drive = (floor(trial / 4) - 2*floor(trial / 8))*1.8
alter VB2 = $&drive
let drive = (floor(trial / 8) - 2*floor(trial / 16))*1.8
alter VB3 = $&drive
let drive = (floor(trial / 16) - 2*floor(trial / 32))*1.8
alter VB4 = $&drive
let drive = (floor(trial / 32) - 2*floor(trial / 64))*1.8
alter VB5 = $&drive
let drive = (floor(trial / 64) - 2*floor(trial / 128))*1.8
alter VB6 = $&drive
let drive = (floor(trial / 128) - 2*floor(trial / 256))*1.8
alter VB7 = $&drive
stop when time = 0.002944
resume
delete all
let endpoint = length(time)-1
let cmp = v(COMP)[endpoint]
let top = v(TOP)[endpoint]
let decision = 0
if cmp >= 0.9
let code = trial
let decision = 1
end
echo 163 4 $&trial $&cmp $&top 0.75234375 $&decision >> decisions.csv
let trial = code + 8
let drive = (floor(trial / 1) - 2*floor(trial / 2))*1.8
alter VB0 = $&drive
let drive = (floor(trial / 2) - 2*floor(trial / 4))*1.8
alter VB1 = $&drive
let drive = (floor(trial / 4) - 2*floor(trial / 8))*1.8
alter VB2 = $&drive
let drive = (floor(trial / 8) - 2*floor(trial / 16))*1.8
alter VB3 = $&drive
let drive = (floor(trial / 16) - 2*floor(trial / 32))*1.8
alter VB4 = $&drive
let drive = (floor(trial / 32) - 2*floor(trial / 64))*1.8
alter VB5 = $&drive
let drive = (floor(trial / 64) - 2*floor(trial / 128))*1.8
alter VB6 = $&drive
let drive = (floor(trial / 128) - 2*floor(trial / 256))*1.8
alter VB7 = $&drive
stop when time = 0.002946
resume
delete all
let endpoint = length(time)-1
let cmp = v(COMP)[endpoint]
let top = v(TOP)[endpoint]
let decision = 0
if cmp >= 0.9
let code = trial
let decision = 1
end
echo 163 3 $&trial $&cmp $&top 0.75234375 $&decision >> decisions.csv
let trial = code + 4
let drive = (floor(trial / 1) - 2*floor(trial / 2))*1.8
alter VB0 = $&drive
let drive = (floor(trial / 2) - 2*floor(trial / 4))*1.8
alter VB1 = $&drive
let drive = (floor(trial / 4) - 2*floor(trial / 8))*1.8
alter VB2 = $&drive
let drive = (floor(trial / 8) - 2*floor(trial / 16))*1.8
alter VB3 = $&drive
let drive = (floor(trial / 16) - 2*floor(trial / 32))*1.8
alter VB4 = $&drive
let drive = (floor(trial / 32) - 2*floor(trial / 64))*1.8
alter VB5 = $&drive
let drive = (floor(trial / 64) - 2*floor(trial / 128))*1.8
alter VB6 = $&drive
let drive = (floor(trial / 128) - 2*floor(trial / 256))*1.8
alter VB7 = $&drive
stop when time = 0.002948
resume
delete all
let endpoint = length(time)-1
let cmp = v(COMP)[endpoint]
let top = v(TOP)[endpoint]
let decision = 0
if cmp >= 0.9
let code = trial
let decision = 1
end
echo 163 2 $&trial $&cmp $&top 0.75234375 $&decision >> decisions.csv
let trial = code + 2
let drive = (floor(trial / 1) - 2*floor(trial / 2))*1.8
alter VB0 = $&drive
let drive = (floor(trial / 2) - 2*floor(trial / 4))*1.8
alter VB1 = $&drive
let drive = (floor(trial / 4) - 2*floor(trial / 8))*1.8
alter VB2 = $&drive
let drive = (floor(trial / 8) - 2*floor(trial / 16))*1.8
alter VB3 = $&drive
let drive = (floor(trial / 16) - 2*floor(trial / 32))*1.8
alter VB4 = $&drive
let drive = (floor(trial / 32) - 2*floor(trial / 64))*1.8
alter VB5 = $&drive
let drive = (floor(trial / 64) - 2*floor(trial / 128))*1.8
alter VB6 = $&drive
let drive = (floor(trial / 128) - 2*floor(trial / 256))*1.8
alter VB7 = $&drive
stop when time = 0.00295
resume
delete all
let endpoint = length(time)-1
let cmp = v(COMP)[endpoint]
let top = v(TOP)[endpoint]
let decision = 0
if cmp >= 0.9
let code = trial
let decision = 1
end
echo 163 1 $&trial $&cmp $&top 0.75234375 $&decision >> decisions.csv
let trial = code + 1
let drive = (floor(trial / 1) - 2*floor(trial / 2))*1.8
alter VB0 = $&drive
let drive = (floor(trial / 2) - 2*floor(trial / 4))*1.8
alter VB1 = $&drive
let drive = (floor(trial / 4) - 2*floor(trial / 8))*1.8
alter VB2 = $&drive
let drive = (floor(trial / 8) - 2*floor(trial / 16))*1.8
alter VB3 = $&drive
let drive = (floor(trial / 16) - 2*floor(trial / 32))*1.8
alter VB4 = $&drive
let drive = (floor(trial / 32) - 2*floor(trial / 64))*1.8
alter VB5 = $&drive
let drive = (floor(trial / 64) - 2*floor(trial / 128))*1.8
alter VB6 = $&drive
let drive = (floor(trial / 128) - 2*floor(trial / 256))*1.8
alter VB7 = $&drive
stop when time = 0.002952
resume
delete all
let endpoint = length(time)-1
let cmp = v(COMP)[endpoint]
let top = v(TOP)[endpoint]
let decision = 0
if cmp >= 0.9
let code = trial
let decision = 1
end
echo 163 0 $&trial $&cmp $&top 0.75234375 $&decision >> decisions.csv
alter VIN = 0.75703125
alter VSAMPLE = 1.8
alter VB0 = 0
alter VB1 = 0
alter VB2 = 0
alter VB3 = 0
alter VB4 = 0
alter VB5 = 0
alter VB6 = 0
alter VB7 = 0
let code = 0
stop when time = 0.002954
resume
delete all
alter VSAMPLE = 0
let trial = code + 128
let drive = (floor(trial / 1) - 2*floor(trial / 2))*1.8
alter VB0 = $&drive
let drive = (floor(trial / 2) - 2*floor(trial / 4))*1.8
alter VB1 = $&drive
let drive = (floor(trial / 4) - 2*floor(trial / 8))*1.8
alter VB2 = $&drive
let drive = (floor(trial / 8) - 2*floor(trial / 16))*1.8
alter VB3 = $&drive
let drive = (floor(trial / 16) - 2*floor(trial / 32))*1.8
alter VB4 = $&drive
let drive = (floor(trial / 32) - 2*floor(trial / 64))*1.8
alter VB5 = $&drive
let drive = (floor(trial / 64) - 2*floor(trial / 128))*1.8
alter VB6 = $&drive
let drive = (floor(trial / 128) - 2*floor(trial / 256))*1.8
alter VB7 = $&drive
stop when time = 0.002956
resume
delete all
let endpoint = length(time)-1
let cmp = v(COMP)[endpoint]
let top = v(TOP)[endpoint]
let decision = 0
if cmp >= 0.9
let code = trial
let decision = 1
end
echo 164 7 $&trial $&cmp $&top 0.75703125 $&decision >> decisions.csv
let trial = code + 64
let drive = (floor(trial / 1) - 2*floor(trial / 2))*1.8
alter VB0 = $&drive
let drive = (floor(trial / 2) - 2*floor(trial / 4))*1.8
alter VB1 = $&drive
let drive = (floor(trial / 4) - 2*floor(trial / 8))*1.8
alter VB2 = $&drive
let drive = (floor(trial / 8) - 2*floor(trial / 16))*1.8
alter VB3 = $&drive
let drive = (floor(trial / 16) - 2*floor(trial / 32))*1.8
alter VB4 = $&drive
let drive = (floor(trial / 32) - 2*floor(trial / 64))*1.8
alter VB5 = $&drive
let drive = (floor(trial / 64) - 2*floor(trial / 128))*1.8
alter VB6 = $&drive
let drive = (floor(trial / 128) - 2*floor(trial / 256))*1.8
alter VB7 = $&drive
stop when time = 0.002958
resume
delete all
let endpoint = length(time)-1
let cmp = v(COMP)[endpoint]
let top = v(TOP)[endpoint]
let decision = 0
if cmp >= 0.9
let code = trial
let decision = 1
end
echo 164 6 $&trial $&cmp $&top 0.75703125 $&decision >> decisions.csv
let trial = code + 32
let drive = (floor(trial / 1) - 2*floor(trial / 2))*1.8
alter VB0 = $&drive
let drive = (floor(trial / 2) - 2*floor(trial / 4))*1.8
alter VB1 = $&drive
let drive = (floor(trial / 4) - 2*floor(trial / 8))*1.8
alter VB2 = $&drive
let drive = (floor(trial / 8) - 2*floor(trial / 16))*1.8
alter VB3 = $&drive
let drive = (floor(trial / 16) - 2*floor(trial / 32))*1.8
alter VB4 = $&drive
let drive = (floor(trial / 32) - 2*floor(trial / 64))*1.8
alter VB5 = $&drive
let drive = (floor(trial / 64) - 2*floor(trial / 128))*1.8
alter VB6 = $&drive
let drive = (floor(trial / 128) - 2*floor(trial / 256))*1.8
alter VB7 = $&drive
stop when time = 0.00296
resume
delete all
let endpoint = length(time)-1
let cmp = v(COMP)[endpoint]
let top = v(TOP)[endpoint]
let decision = 0
if cmp >= 0.9
let code = trial
let decision = 1
end
echo 164 5 $&trial $&cmp $&top 0.75703125 $&decision >> decisions.csv
let trial = code + 16
let drive = (floor(trial / 1) - 2*floor(trial / 2))*1.8
alter VB0 = $&drive
let drive = (floor(trial / 2) - 2*floor(trial / 4))*1.8
alter VB1 = $&drive
let drive = (floor(trial / 4) - 2*floor(trial / 8))*1.8
alter VB2 = $&drive
let drive = (floor(trial / 8) - 2*floor(trial / 16))*1.8
alter VB3 = $&drive
let drive = (floor(trial / 16) - 2*floor(trial / 32))*1.8
alter VB4 = $&drive
let drive = (floor(trial / 32) - 2*floor(trial / 64))*1.8
alter VB5 = $&drive
let drive = (floor(trial / 64) - 2*floor(trial / 128))*1.8
alter VB6 = $&drive
let drive = (floor(trial / 128) - 2*floor(trial / 256))*1.8
alter VB7 = $&drive
stop when time = 0.002962
resume
delete all
let endpoint = length(time)-1
let cmp = v(COMP)[endpoint]
let top = v(TOP)[endpoint]
let decision = 0
if cmp >= 0.9
let code = trial
let decision = 1
end
echo 164 4 $&trial $&cmp $&top 0.75703125 $&decision >> decisions.csv
let trial = code + 8
let drive = (floor(trial / 1) - 2*floor(trial / 2))*1.8
alter VB0 = $&drive
let drive = (floor(trial / 2) - 2*floor(trial / 4))*1.8
alter VB1 = $&drive
let drive = (floor(trial / 4) - 2*floor(trial / 8))*1.8
alter VB2 = $&drive
let drive = (floor(trial / 8) - 2*floor(trial / 16))*1.8
alter VB3 = $&drive
let drive = (floor(trial / 16) - 2*floor(trial / 32))*1.8
alter VB4 = $&drive
let drive = (floor(trial / 32) - 2*floor(trial / 64))*1.8
alter VB5 = $&drive
let drive = (floor(trial / 64) - 2*floor(trial / 128))*1.8
alter VB6 = $&drive
let drive = (floor(trial / 128) - 2*floor(trial / 256))*1.8
alter VB7 = $&drive
stop when time = 0.002964
resume
delete all
let endpoint = length(time)-1
let cmp = v(COMP)[endpoint]
let top = v(TOP)[endpoint]
let decision = 0
if cmp >= 0.9
let code = trial
let decision = 1
end
echo 164 3 $&trial $&cmp $&top 0.75703125 $&decision >> decisions.csv
let trial = code + 4
let drive = (floor(trial / 1) - 2*floor(trial / 2))*1.8
alter VB0 = $&drive
let drive = (floor(trial / 2) - 2*floor(trial / 4))*1.8
alter VB1 = $&drive
let drive = (floor(trial / 4) - 2*floor(trial / 8))*1.8
alter VB2 = $&drive
let drive = (floor(trial / 8) - 2*floor(trial / 16))*1.8
alter VB3 = $&drive
let drive = (floor(trial / 16) - 2*floor(trial / 32))*1.8
alter VB4 = $&drive
let drive = (floor(trial / 32) - 2*floor(trial / 64))*1.8
alter VB5 = $&drive
let drive = (floor(trial / 64) - 2*floor(trial / 128))*1.8
alter VB6 = $&drive
let drive = (floor(trial / 128) - 2*floor(trial / 256))*1.8
alter VB7 = $&drive
stop when time = 0.002966
resume
delete all
let endpoint = length(time)-1
let cmp = v(COMP)[endpoint]
let top = v(TOP)[endpoint]
let decision = 0
if cmp >= 0.9
let code = trial
let decision = 1
end
echo 164 2 $&trial $&cmp $&top 0.75703125 $&decision >> decisions.csv
let trial = code + 2
let drive = (floor(trial / 1) - 2*floor(trial / 2))*1.8
alter VB0 = $&drive
let drive = (floor(trial / 2) - 2*floor(trial / 4))*1.8
alter VB1 = $&drive
let drive = (floor(trial / 4) - 2*floor(trial / 8))*1.8
alter VB2 = $&drive
let drive = (floor(trial / 8) - 2*floor(trial / 16))*1.8
alter VB3 = $&drive
let drive = (floor(trial / 16) - 2*floor(trial / 32))*1.8
alter VB4 = $&drive
let drive = (floor(trial / 32) - 2*floor(trial / 64))*1.8
alter VB5 = $&drive
let drive = (floor(trial / 64) - 2*floor(trial / 128))*1.8
alter VB6 = $&drive
let drive = (floor(trial / 128) - 2*floor(trial / 256))*1.8
alter VB7 = $&drive
stop when time = 0.002968
resume
delete all
let endpoint = length(time)-1
let cmp = v(COMP)[endpoint]
let top = v(TOP)[endpoint]
let decision = 0
if cmp >= 0.9
let code = trial
let decision = 1
end
echo 164 1 $&trial $&cmp $&top 0.75703125 $&decision >> decisions.csv
let trial = code + 1
let drive = (floor(trial / 1) - 2*floor(trial / 2))*1.8
alter VB0 = $&drive
let drive = (floor(trial / 2) - 2*floor(trial / 4))*1.8
alter VB1 = $&drive
let drive = (floor(trial / 4) - 2*floor(trial / 8))*1.8
alter VB2 = $&drive
let drive = (floor(trial / 8) - 2*floor(trial / 16))*1.8
alter VB3 = $&drive
let drive = (floor(trial / 16) - 2*floor(trial / 32))*1.8
alter VB4 = $&drive
let drive = (floor(trial / 32) - 2*floor(trial / 64))*1.8
alter VB5 = $&drive
let drive = (floor(trial / 64) - 2*floor(trial / 128))*1.8
alter VB6 = $&drive
let drive = (floor(trial / 128) - 2*floor(trial / 256))*1.8
alter VB7 = $&drive
stop when time = 0.00297
resume
delete all
let endpoint = length(time)-1
let cmp = v(COMP)[endpoint]
let top = v(TOP)[endpoint]
let decision = 0
if cmp >= 0.9
let code = trial
let decision = 1
end
echo 164 0 $&trial $&cmp $&top 0.75703125 $&decision >> decisions.csv
alter VIN = 0.76171875
alter VSAMPLE = 1.8
alter VB0 = 0
alter VB1 = 0
alter VB2 = 0
alter VB3 = 0
alter VB4 = 0
alter VB5 = 0
alter VB6 = 0
alter VB7 = 0
let code = 0
stop when time = 0.002972
resume
delete all
alter VSAMPLE = 0
let trial = code + 128
let drive = (floor(trial / 1) - 2*floor(trial / 2))*1.8
alter VB0 = $&drive
let drive = (floor(trial / 2) - 2*floor(trial / 4))*1.8
alter VB1 = $&drive
let drive = (floor(trial / 4) - 2*floor(trial / 8))*1.8
alter VB2 = $&drive
let drive = (floor(trial / 8) - 2*floor(trial / 16))*1.8
alter VB3 = $&drive
let drive = (floor(trial / 16) - 2*floor(trial / 32))*1.8
alter VB4 = $&drive
let drive = (floor(trial / 32) - 2*floor(trial / 64))*1.8
alter VB5 = $&drive
let drive = (floor(trial / 64) - 2*floor(trial / 128))*1.8
alter VB6 = $&drive
let drive = (floor(trial / 128) - 2*floor(trial / 256))*1.8
alter VB7 = $&drive
stop when time = 0.002974
resume
delete all
let endpoint = length(time)-1
let cmp = v(COMP)[endpoint]
let top = v(TOP)[endpoint]
let decision = 0
if cmp >= 0.9
let code = trial
let decision = 1
end
echo 165 7 $&trial $&cmp $&top 0.76171875 $&decision >> decisions.csv
let trial = code + 64
let drive = (floor(trial / 1) - 2*floor(trial / 2))*1.8
alter VB0 = $&drive
let drive = (floor(trial / 2) - 2*floor(trial / 4))*1.8
alter VB1 = $&drive
let drive = (floor(trial / 4) - 2*floor(trial / 8))*1.8
alter VB2 = $&drive
let drive = (floor(trial / 8) - 2*floor(trial / 16))*1.8
alter VB3 = $&drive
let drive = (floor(trial / 16) - 2*floor(trial / 32))*1.8
alter VB4 = $&drive
let drive = (floor(trial / 32) - 2*floor(trial / 64))*1.8
alter VB5 = $&drive
let drive = (floor(trial / 64) - 2*floor(trial / 128))*1.8
alter VB6 = $&drive
let drive = (floor(trial / 128) - 2*floor(trial / 256))*1.8
alter VB7 = $&drive
stop when time = 0.002976
resume
delete all
let endpoint = length(time)-1
let cmp = v(COMP)[endpoint]
let top = v(TOP)[endpoint]
let decision = 0
if cmp >= 0.9
let code = trial
let decision = 1
end
echo 165 6 $&trial $&cmp $&top 0.76171875 $&decision >> decisions.csv
let trial = code + 32
let drive = (floor(trial / 1) - 2*floor(trial / 2))*1.8
alter VB0 = $&drive
let drive = (floor(trial / 2) - 2*floor(trial / 4))*1.8
alter VB1 = $&drive
let drive = (floor(trial / 4) - 2*floor(trial / 8))*1.8
alter VB2 = $&drive
let drive = (floor(trial / 8) - 2*floor(trial / 16))*1.8
alter VB3 = $&drive
let drive = (floor(trial / 16) - 2*floor(trial / 32))*1.8
alter VB4 = $&drive
let drive = (floor(trial / 32) - 2*floor(trial / 64))*1.8
alter VB5 = $&drive
let drive = (floor(trial / 64) - 2*floor(trial / 128))*1.8
alter VB6 = $&drive
let drive = (floor(trial / 128) - 2*floor(trial / 256))*1.8
alter VB7 = $&drive
stop when time = 0.002978
resume
delete all
let endpoint = length(time)-1
let cmp = v(COMP)[endpoint]
let top = v(TOP)[endpoint]
let decision = 0
if cmp >= 0.9
let code = trial
let decision = 1
end
echo 165 5 $&trial $&cmp $&top 0.76171875 $&decision >> decisions.csv
let trial = code + 16
let drive = (floor(trial / 1) - 2*floor(trial / 2))*1.8
alter VB0 = $&drive
let drive = (floor(trial / 2) - 2*floor(trial / 4))*1.8
alter VB1 = $&drive
let drive = (floor(trial / 4) - 2*floor(trial / 8))*1.8
alter VB2 = $&drive
let drive = (floor(trial / 8) - 2*floor(trial / 16))*1.8
alter VB3 = $&drive
let drive = (floor(trial / 16) - 2*floor(trial / 32))*1.8
alter VB4 = $&drive
let drive = (floor(trial / 32) - 2*floor(trial / 64))*1.8
alter VB5 = $&drive
let drive = (floor(trial / 64) - 2*floor(trial / 128))*1.8
alter VB6 = $&drive
let drive = (floor(trial / 128) - 2*floor(trial / 256))*1.8
alter VB7 = $&drive
stop when time = 0.00298
resume
delete all
let endpoint = length(time)-1
let cmp = v(COMP)[endpoint]
let top = v(TOP)[endpoint]
let decision = 0
if cmp >= 0.9
let code = trial
let decision = 1
end
echo 165 4 $&trial $&cmp $&top 0.76171875 $&decision >> decisions.csv
let trial = code + 8
let drive = (floor(trial / 1) - 2*floor(trial / 2))*1.8
alter VB0 = $&drive
let drive = (floor(trial / 2) - 2*floor(trial / 4))*1.8
alter VB1 = $&drive
let drive = (floor(trial / 4) - 2*floor(trial / 8))*1.8
alter VB2 = $&drive
let drive = (floor(trial / 8) - 2*floor(trial / 16))*1.8
alter VB3 = $&drive
let drive = (floor(trial / 16) - 2*floor(trial / 32))*1.8
alter VB4 = $&drive
let drive = (floor(trial / 32) - 2*floor(trial / 64))*1.8
alter VB5 = $&drive
let drive = (floor(trial / 64) - 2*floor(trial / 128))*1.8
alter VB6 = $&drive
let drive = (floor(trial / 128) - 2*floor(trial / 256))*1.8
alter VB7 = $&drive
stop when time = 0.002982
resume
delete all
let endpoint = length(time)-1
let cmp = v(COMP)[endpoint]
let top = v(TOP)[endpoint]
let decision = 0
if cmp >= 0.9
let code = trial
let decision = 1
end
echo 165 3 $&trial $&cmp $&top 0.76171875 $&decision >> decisions.csv
let trial = code + 4
let drive = (floor(trial / 1) - 2*floor(trial / 2))*1.8
alter VB0 = $&drive
let drive = (floor(trial / 2) - 2*floor(trial / 4))*1.8
alter VB1 = $&drive
let drive = (floor(trial / 4) - 2*floor(trial / 8))*1.8
alter VB2 = $&drive
let drive = (floor(trial / 8) - 2*floor(trial / 16))*1.8
alter VB3 = $&drive
let drive = (floor(trial / 16) - 2*floor(trial / 32))*1.8
alter VB4 = $&drive
let drive = (floor(trial / 32) - 2*floor(trial / 64))*1.8
alter VB5 = $&drive
let drive = (floor(trial / 64) - 2*floor(trial / 128))*1.8
alter VB6 = $&drive
let drive = (floor(trial / 128) - 2*floor(trial / 256))*1.8
alter VB7 = $&drive
stop when time = 0.002984
resume
delete all
let endpoint = length(time)-1
let cmp = v(COMP)[endpoint]
let top = v(TOP)[endpoint]
let decision = 0
if cmp >= 0.9
let code = trial
let decision = 1
end
echo 165 2 $&trial $&cmp $&top 0.76171875 $&decision >> decisions.csv
let trial = code + 2
let drive = (floor(trial / 1) - 2*floor(trial / 2))*1.8
alter VB0 = $&drive
let drive = (floor(trial / 2) - 2*floor(trial / 4))*1.8
alter VB1 = $&drive
let drive = (floor(trial / 4) - 2*floor(trial / 8))*1.8
alter VB2 = $&drive
let drive = (floor(trial / 8) - 2*floor(trial / 16))*1.8
alter VB3 = $&drive
let drive = (floor(trial / 16) - 2*floor(trial / 32))*1.8
alter VB4 = $&drive
let drive = (floor(trial / 32) - 2*floor(trial / 64))*1.8
alter VB5 = $&drive
let drive = (floor(trial / 64) - 2*floor(trial / 128))*1.8
alter VB6 = $&drive
let drive = (floor(trial / 128) - 2*floor(trial / 256))*1.8
alter VB7 = $&drive
stop when time = 0.002986
resume
delete all
let endpoint = length(time)-1
let cmp = v(COMP)[endpoint]
let top = v(TOP)[endpoint]
let decision = 0
if cmp >= 0.9
let code = trial
let decision = 1
end
echo 165 1 $&trial $&cmp $&top 0.76171875 $&decision >> decisions.csv
let trial = code + 1
let drive = (floor(trial / 1) - 2*floor(trial / 2))*1.8
alter VB0 = $&drive
let drive = (floor(trial / 2) - 2*floor(trial / 4))*1.8
alter VB1 = $&drive
let drive = (floor(trial / 4) - 2*floor(trial / 8))*1.8
alter VB2 = $&drive
let drive = (floor(trial / 8) - 2*floor(trial / 16))*1.8
alter VB3 = $&drive
let drive = (floor(trial / 16) - 2*floor(trial / 32))*1.8
alter VB4 = $&drive
let drive = (floor(trial / 32) - 2*floor(trial / 64))*1.8
alter VB5 = $&drive
let drive = (floor(trial / 64) - 2*floor(trial / 128))*1.8
alter VB6 = $&drive
let drive = (floor(trial / 128) - 2*floor(trial / 256))*1.8
alter VB7 = $&drive
stop when time = 0.002988
resume
delete all
let endpoint = length(time)-1
let cmp = v(COMP)[endpoint]
let top = v(TOP)[endpoint]
let decision = 0
if cmp >= 0.9
let code = trial
let decision = 1
end
echo 165 0 $&trial $&cmp $&top 0.76171875 $&decision >> decisions.csv
alter VIN = 0.76640625
alter VSAMPLE = 1.8
alter VB0 = 0
alter VB1 = 0
alter VB2 = 0
alter VB3 = 0
alter VB4 = 0
alter VB5 = 0
alter VB6 = 0
alter VB7 = 0
let code = 0
stop when time = 0.00299
resume
delete all
alter VSAMPLE = 0
let trial = code + 128
let drive = (floor(trial / 1) - 2*floor(trial / 2))*1.8
alter VB0 = $&drive
let drive = (floor(trial / 2) - 2*floor(trial / 4))*1.8
alter VB1 = $&drive
let drive = (floor(trial / 4) - 2*floor(trial / 8))*1.8
alter VB2 = $&drive
let drive = (floor(trial / 8) - 2*floor(trial / 16))*1.8
alter VB3 = $&drive
let drive = (floor(trial / 16) - 2*floor(trial / 32))*1.8
alter VB4 = $&drive
let drive = (floor(trial / 32) - 2*floor(trial / 64))*1.8
alter VB5 = $&drive
let drive = (floor(trial / 64) - 2*floor(trial / 128))*1.8
alter VB6 = $&drive
let drive = (floor(trial / 128) - 2*floor(trial / 256))*1.8
alter VB7 = $&drive
stop when time = 0.002992
resume
delete all
let endpoint = length(time)-1
let cmp = v(COMP)[endpoint]
let top = v(TOP)[endpoint]
let decision = 0
if cmp >= 0.9
let code = trial
let decision = 1
end
echo 166 7 $&trial $&cmp $&top 0.76640625 $&decision >> decisions.csv
let trial = code + 64
let drive = (floor(trial / 1) - 2*floor(trial / 2))*1.8
alter VB0 = $&drive
let drive = (floor(trial / 2) - 2*floor(trial / 4))*1.8
alter VB1 = $&drive
let drive = (floor(trial / 4) - 2*floor(trial / 8))*1.8
alter VB2 = $&drive
let drive = (floor(trial / 8) - 2*floor(trial / 16))*1.8
alter VB3 = $&drive
let drive = (floor(trial / 16) - 2*floor(trial / 32))*1.8
alter VB4 = $&drive
let drive = (floor(trial / 32) - 2*floor(trial / 64))*1.8
alter VB5 = $&drive
let drive = (floor(trial / 64) - 2*floor(trial / 128))*1.8
alter VB6 = $&drive
let drive = (floor(trial / 128) - 2*floor(trial / 256))*1.8
alter VB7 = $&drive
stop when time = 0.002994
resume
delete all
let endpoint = length(time)-1
let cmp = v(COMP)[endpoint]
let top = v(TOP)[endpoint]
let decision = 0
if cmp >= 0.9
let code = trial
let decision = 1
end
echo 166 6 $&trial $&cmp $&top 0.76640625 $&decision >> decisions.csv
let trial = code + 32
let drive = (floor(trial / 1) - 2*floor(trial / 2))*1.8
alter VB0 = $&drive
let drive = (floor(trial / 2) - 2*floor(trial / 4))*1.8
alter VB1 = $&drive
let drive = (floor(trial / 4) - 2*floor(trial / 8))*1.8
alter VB2 = $&drive
let drive = (floor(trial / 8) - 2*floor(trial / 16))*1.8
alter VB3 = $&drive
let drive = (floor(trial / 16) - 2*floor(trial / 32))*1.8
alter VB4 = $&drive
let drive = (floor(trial / 32) - 2*floor(trial / 64))*1.8
alter VB5 = $&drive
let drive = (floor(trial / 64) - 2*floor(trial / 128))*1.8
alter VB6 = $&drive
let drive = (floor(trial / 128) - 2*floor(trial / 256))*1.8
alter VB7 = $&drive
stop when time = 0.002996
resume
delete all
let endpoint = length(time)-1
let cmp = v(COMP)[endpoint]
let top = v(TOP)[endpoint]
let decision = 0
if cmp >= 0.9
let code = trial
let decision = 1
end
echo 166 5 $&trial $&cmp $&top 0.76640625 $&decision >> decisions.csv
let trial = code + 16
let drive = (floor(trial / 1) - 2*floor(trial / 2))*1.8
alter VB0 = $&drive
let drive = (floor(trial / 2) - 2*floor(trial / 4))*1.8
alter VB1 = $&drive
let drive = (floor(trial / 4) - 2*floor(trial / 8))*1.8
alter VB2 = $&drive
let drive = (floor(trial / 8) - 2*floor(trial / 16))*1.8
alter VB3 = $&drive
let drive = (floor(trial / 16) - 2*floor(trial / 32))*1.8
alter VB4 = $&drive
let drive = (floor(trial / 32) - 2*floor(trial / 64))*1.8
alter VB5 = $&drive
let drive = (floor(trial / 64) - 2*floor(trial / 128))*1.8
alter VB6 = $&drive
let drive = (floor(trial / 128) - 2*floor(trial / 256))*1.8
alter VB7 = $&drive
stop when time = 0.002998
resume
delete all
let endpoint = length(time)-1
let cmp = v(COMP)[endpoint]
let top = v(TOP)[endpoint]
let decision = 0
if cmp >= 0.9
let code = trial
let decision = 1
end
echo 166 4 $&trial $&cmp $&top 0.76640625 $&decision >> decisions.csv
let trial = code + 8
let drive = (floor(trial / 1) - 2*floor(trial / 2))*1.8
alter VB0 = $&drive
let drive = (floor(trial / 2) - 2*floor(trial / 4))*1.8
alter VB1 = $&drive
let drive = (floor(trial / 4) - 2*floor(trial / 8))*1.8
alter VB2 = $&drive
let drive = (floor(trial / 8) - 2*floor(trial / 16))*1.8
alter VB3 = $&drive
let drive = (floor(trial / 16) - 2*floor(trial / 32))*1.8
alter VB4 = $&drive
let drive = (floor(trial / 32) - 2*floor(trial / 64))*1.8
alter VB5 = $&drive
let drive = (floor(trial / 64) - 2*floor(trial / 128))*1.8
alter VB6 = $&drive
let drive = (floor(trial / 128) - 2*floor(trial / 256))*1.8
alter VB7 = $&drive
stop when time = 0.003
resume
delete all
let endpoint = length(time)-1
let cmp = v(COMP)[endpoint]
let top = v(TOP)[endpoint]
let decision = 0
if cmp >= 0.9
let code = trial
let decision = 1
end
echo 166 3 $&trial $&cmp $&top 0.76640625 $&decision >> decisions.csv
let trial = code + 4
let drive = (floor(trial / 1) - 2*floor(trial / 2))*1.8
alter VB0 = $&drive
let drive = (floor(trial / 2) - 2*floor(trial / 4))*1.8
alter VB1 = $&drive
let drive = (floor(trial / 4) - 2*floor(trial / 8))*1.8
alter VB2 = $&drive
let drive = (floor(trial / 8) - 2*floor(trial / 16))*1.8
alter VB3 = $&drive
let drive = (floor(trial / 16) - 2*floor(trial / 32))*1.8
alter VB4 = $&drive
let drive = (floor(trial / 32) - 2*floor(trial / 64))*1.8
alter VB5 = $&drive
let drive = (floor(trial / 64) - 2*floor(trial / 128))*1.8
alter VB6 = $&drive
let drive = (floor(trial / 128) - 2*floor(trial / 256))*1.8
alter VB7 = $&drive
stop when time = 0.003002
resume
delete all
let endpoint = length(time)-1
let cmp = v(COMP)[endpoint]
let top = v(TOP)[endpoint]
let decision = 0
if cmp >= 0.9
let code = trial
let decision = 1
end
echo 166 2 $&trial $&cmp $&top 0.76640625 $&decision >> decisions.csv
let trial = code + 2
let drive = (floor(trial / 1) - 2*floor(trial / 2))*1.8
alter VB0 = $&drive
let drive = (floor(trial / 2) - 2*floor(trial / 4))*1.8
alter VB1 = $&drive
let drive = (floor(trial / 4) - 2*floor(trial / 8))*1.8
alter VB2 = $&drive
let drive = (floor(trial / 8) - 2*floor(trial / 16))*1.8
alter VB3 = $&drive
let drive = (floor(trial / 16) - 2*floor(trial / 32))*1.8
alter VB4 = $&drive
let drive = (floor(trial / 32) - 2*floor(trial / 64))*1.8
alter VB5 = $&drive
let drive = (floor(trial / 64) - 2*floor(trial / 128))*1.8
alter VB6 = $&drive
let drive = (floor(trial / 128) - 2*floor(trial / 256))*1.8
alter VB7 = $&drive
stop when time = 0.003004
resume
delete all
let endpoint = length(time)-1
let cmp = v(COMP)[endpoint]
let top = v(TOP)[endpoint]
let decision = 0
if cmp >= 0.9
let code = trial
let decision = 1
end
echo 166 1 $&trial $&cmp $&top 0.76640625 $&decision >> decisions.csv
let trial = code + 1
let drive = (floor(trial / 1) - 2*floor(trial / 2))*1.8
alter VB0 = $&drive
let drive = (floor(trial / 2) - 2*floor(trial / 4))*1.8
alter VB1 = $&drive
let drive = (floor(trial / 4) - 2*floor(trial / 8))*1.8
alter VB2 = $&drive
let drive = (floor(trial / 8) - 2*floor(trial / 16))*1.8
alter VB3 = $&drive
let drive = (floor(trial / 16) - 2*floor(trial / 32))*1.8
alter VB4 = $&drive
let drive = (floor(trial / 32) - 2*floor(trial / 64))*1.8
alter VB5 = $&drive
let drive = (floor(trial / 64) - 2*floor(trial / 128))*1.8
alter VB6 = $&drive
let drive = (floor(trial / 128) - 2*floor(trial / 256))*1.8
alter VB7 = $&drive
stop when time = 0.003006
resume
delete all
let endpoint = length(time)-1
let cmp = v(COMP)[endpoint]
let top = v(TOP)[endpoint]
let decision = 0
if cmp >= 0.9
let code = trial
let decision = 1
end
echo 166 0 $&trial $&cmp $&top 0.76640625 $&decision >> decisions.csv
alter VIN = 0.77109375
alter VSAMPLE = 1.8
alter VB0 = 0
alter VB1 = 0
alter VB2 = 0
alter VB3 = 0
alter VB4 = 0
alter VB5 = 0
alter VB6 = 0
alter VB7 = 0
let code = 0
stop when time = 0.003008
resume
delete all
alter VSAMPLE = 0
let trial = code + 128
let drive = (floor(trial / 1) - 2*floor(trial / 2))*1.8
alter VB0 = $&drive
let drive = (floor(trial / 2) - 2*floor(trial / 4))*1.8
alter VB1 = $&drive
let drive = (floor(trial / 4) - 2*floor(trial / 8))*1.8
alter VB2 = $&drive
let drive = (floor(trial / 8) - 2*floor(trial / 16))*1.8
alter VB3 = $&drive
let drive = (floor(trial / 16) - 2*floor(trial / 32))*1.8
alter VB4 = $&drive
let drive = (floor(trial / 32) - 2*floor(trial / 64))*1.8
alter VB5 = $&drive
let drive = (floor(trial / 64) - 2*floor(trial / 128))*1.8
alter VB6 = $&drive
let drive = (floor(trial / 128) - 2*floor(trial / 256))*1.8
alter VB7 = $&drive
stop when time = 0.00301
resume
delete all
let endpoint = length(time)-1
let cmp = v(COMP)[endpoint]
let top = v(TOP)[endpoint]
let decision = 0
if cmp >= 0.9
let code = trial
let decision = 1
end
echo 167 7 $&trial $&cmp $&top 0.77109375 $&decision >> decisions.csv
let trial = code + 64
let drive = (floor(trial / 1) - 2*floor(trial / 2))*1.8
alter VB0 = $&drive
let drive = (floor(trial / 2) - 2*floor(trial / 4))*1.8
alter VB1 = $&drive
let drive = (floor(trial / 4) - 2*floor(trial / 8))*1.8
alter VB2 = $&drive
let drive = (floor(trial / 8) - 2*floor(trial / 16))*1.8
alter VB3 = $&drive
let drive = (floor(trial / 16) - 2*floor(trial / 32))*1.8
alter VB4 = $&drive
let drive = (floor(trial / 32) - 2*floor(trial / 64))*1.8
alter VB5 = $&drive
let drive = (floor(trial / 64) - 2*floor(trial / 128))*1.8
alter VB6 = $&drive
let drive = (floor(trial / 128) - 2*floor(trial / 256))*1.8
alter VB7 = $&drive
stop when time = 0.003012
resume
delete all
let endpoint = length(time)-1
let cmp = v(COMP)[endpoint]
let top = v(TOP)[endpoint]
let decision = 0
if cmp >= 0.9
let code = trial
let decision = 1
end
echo 167 6 $&trial $&cmp $&top 0.77109375 $&decision >> decisions.csv
let trial = code + 32
let drive = (floor(trial / 1) - 2*floor(trial / 2))*1.8
alter VB0 = $&drive
let drive = (floor(trial / 2) - 2*floor(trial / 4))*1.8
alter VB1 = $&drive
let drive = (floor(trial / 4) - 2*floor(trial / 8))*1.8
alter VB2 = $&drive
let drive = (floor(trial / 8) - 2*floor(trial / 16))*1.8
alter VB3 = $&drive
let drive = (floor(trial / 16) - 2*floor(trial / 32))*1.8
alter VB4 = $&drive
let drive = (floor(trial / 32) - 2*floor(trial / 64))*1.8
alter VB5 = $&drive
let drive = (floor(trial / 64) - 2*floor(trial / 128))*1.8
alter VB6 = $&drive
let drive = (floor(trial / 128) - 2*floor(trial / 256))*1.8
alter VB7 = $&drive
stop when time = 0.003014
resume
delete all
let endpoint = length(time)-1
let cmp = v(COMP)[endpoint]
let top = v(TOP)[endpoint]
let decision = 0
if cmp >= 0.9
let code = trial
let decision = 1
end
echo 167 5 $&trial $&cmp $&top 0.77109375 $&decision >> decisions.csv
let trial = code + 16
let drive = (floor(trial / 1) - 2*floor(trial / 2))*1.8
alter VB0 = $&drive
let drive = (floor(trial / 2) - 2*floor(trial / 4))*1.8
alter VB1 = $&drive
let drive = (floor(trial / 4) - 2*floor(trial / 8))*1.8
alter VB2 = $&drive
let drive = (floor(trial / 8) - 2*floor(trial / 16))*1.8
alter VB3 = $&drive
let drive = (floor(trial / 16) - 2*floor(trial / 32))*1.8
alter VB4 = $&drive
let drive = (floor(trial / 32) - 2*floor(trial / 64))*1.8
alter VB5 = $&drive
let drive = (floor(trial / 64) - 2*floor(trial / 128))*1.8
alter VB6 = $&drive
let drive = (floor(trial / 128) - 2*floor(trial / 256))*1.8
alter VB7 = $&drive
stop when time = 0.003016
resume
delete all
let endpoint = length(time)-1
let cmp = v(COMP)[endpoint]
let top = v(TOP)[endpoint]
let decision = 0
if cmp >= 0.9
let code = trial
let decision = 1
end
echo 167 4 $&trial $&cmp $&top 0.77109375 $&decision >> decisions.csv
let trial = code + 8
let drive = (floor(trial / 1) - 2*floor(trial / 2))*1.8
alter VB0 = $&drive
let drive = (floor(trial / 2) - 2*floor(trial / 4))*1.8
alter VB1 = $&drive
let drive = (floor(trial / 4) - 2*floor(trial / 8))*1.8
alter VB2 = $&drive
let drive = (floor(trial / 8) - 2*floor(trial / 16))*1.8
alter VB3 = $&drive
let drive = (floor(trial / 16) - 2*floor(trial / 32))*1.8
alter VB4 = $&drive
let drive = (floor(trial / 32) - 2*floor(trial / 64))*1.8
alter VB5 = $&drive
let drive = (floor(trial / 64) - 2*floor(trial / 128))*1.8
alter VB6 = $&drive
let drive = (floor(trial / 128) - 2*floor(trial / 256))*1.8
alter VB7 = $&drive
stop when time = 0.003018
resume
delete all
let endpoint = length(time)-1
let cmp = v(COMP)[endpoint]
let top = v(TOP)[endpoint]
let decision = 0
if cmp >= 0.9
let code = trial
let decision = 1
end
echo 167 3 $&trial $&cmp $&top 0.77109375 $&decision >> decisions.csv
let trial = code + 4
let drive = (floor(trial / 1) - 2*floor(trial / 2))*1.8
alter VB0 = $&drive
let drive = (floor(trial / 2) - 2*floor(trial / 4))*1.8
alter VB1 = $&drive
let drive = (floor(trial / 4) - 2*floor(trial / 8))*1.8
alter VB2 = $&drive
let drive = (floor(trial / 8) - 2*floor(trial / 16))*1.8
alter VB3 = $&drive
let drive = (floor(trial / 16) - 2*floor(trial / 32))*1.8
alter VB4 = $&drive
let drive = (floor(trial / 32) - 2*floor(trial / 64))*1.8
alter VB5 = $&drive
let drive = (floor(trial / 64) - 2*floor(trial / 128))*1.8
alter VB6 = $&drive
let drive = (floor(trial / 128) - 2*floor(trial / 256))*1.8
alter VB7 = $&drive
stop when time = 0.00302
resume
delete all
let endpoint = length(time)-1
let cmp = v(COMP)[endpoint]
let top = v(TOP)[endpoint]
let decision = 0
if cmp >= 0.9
let code = trial
let decision = 1
end
echo 167 2 $&trial $&cmp $&top 0.77109375 $&decision >> decisions.csv
let trial = code + 2
let drive = (floor(trial / 1) - 2*floor(trial / 2))*1.8
alter VB0 = $&drive
let drive = (floor(trial / 2) - 2*floor(trial / 4))*1.8
alter VB1 = $&drive
let drive = (floor(trial / 4) - 2*floor(trial / 8))*1.8
alter VB2 = $&drive
let drive = (floor(trial / 8) - 2*floor(trial / 16))*1.8
alter VB3 = $&drive
let drive = (floor(trial / 16) - 2*floor(trial / 32))*1.8
alter VB4 = $&drive
let drive = (floor(trial / 32) - 2*floor(trial / 64))*1.8
alter VB5 = $&drive
let drive = (floor(trial / 64) - 2*floor(trial / 128))*1.8
alter VB6 = $&drive
let drive = (floor(trial / 128) - 2*floor(trial / 256))*1.8
alter VB7 = $&drive
stop when time = 0.003022
resume
delete all
let endpoint = length(time)-1
let cmp = v(COMP)[endpoint]
let top = v(TOP)[endpoint]
let decision = 0
if cmp >= 0.9
let code = trial
let decision = 1
end
echo 167 1 $&trial $&cmp $&top 0.77109375 $&decision >> decisions.csv
let trial = code + 1
let drive = (floor(trial / 1) - 2*floor(trial / 2))*1.8
alter VB0 = $&drive
let drive = (floor(trial / 2) - 2*floor(trial / 4))*1.8
alter VB1 = $&drive
let drive = (floor(trial / 4) - 2*floor(trial / 8))*1.8
alter VB2 = $&drive
let drive = (floor(trial / 8) - 2*floor(trial / 16))*1.8
alter VB3 = $&drive
let drive = (floor(trial / 16) - 2*floor(trial / 32))*1.8
alter VB4 = $&drive
let drive = (floor(trial / 32) - 2*floor(trial / 64))*1.8
alter VB5 = $&drive
let drive = (floor(trial / 64) - 2*floor(trial / 128))*1.8
alter VB6 = $&drive
let drive = (floor(trial / 128) - 2*floor(trial / 256))*1.8
alter VB7 = $&drive
stop when time = 0.003024
resume
delete all
let endpoint = length(time)-1
let cmp = v(COMP)[endpoint]
let top = v(TOP)[endpoint]
let decision = 0
if cmp >= 0.9
let code = trial
let decision = 1
end
echo 167 0 $&trial $&cmp $&top 0.77109375 $&decision >> decisions.csv
alter VIN = 0.77578125
alter VSAMPLE = 1.8
alter VB0 = 0
alter VB1 = 0
alter VB2 = 0
alter VB3 = 0
alter VB4 = 0
alter VB5 = 0
alter VB6 = 0
alter VB7 = 0
let code = 0
stop when time = 0.003026
resume
delete all
alter VSAMPLE = 0
let trial = code + 128
let drive = (floor(trial / 1) - 2*floor(trial / 2))*1.8
alter VB0 = $&drive
let drive = (floor(trial / 2) - 2*floor(trial / 4))*1.8
alter VB1 = $&drive
let drive = (floor(trial / 4) - 2*floor(trial / 8))*1.8
alter VB2 = $&drive
let drive = (floor(trial / 8) - 2*floor(trial / 16))*1.8
alter VB3 = $&drive
let drive = (floor(trial / 16) - 2*floor(trial / 32))*1.8
alter VB4 = $&drive
let drive = (floor(trial / 32) - 2*floor(trial / 64))*1.8
alter VB5 = $&drive
let drive = (floor(trial / 64) - 2*floor(trial / 128))*1.8
alter VB6 = $&drive
let drive = (floor(trial / 128) - 2*floor(trial / 256))*1.8
alter VB7 = $&drive
stop when time = 0.003028
resume
delete all
let endpoint = length(time)-1
let cmp = v(COMP)[endpoint]
let top = v(TOP)[endpoint]
let decision = 0
if cmp >= 0.9
let code = trial
let decision = 1
end
echo 168 7 $&trial $&cmp $&top 0.77578125 $&decision >> decisions.csv
let trial = code + 64
let drive = (floor(trial / 1) - 2*floor(trial / 2))*1.8
alter VB0 = $&drive
let drive = (floor(trial / 2) - 2*floor(trial / 4))*1.8
alter VB1 = $&drive
let drive = (floor(trial / 4) - 2*floor(trial / 8))*1.8
alter VB2 = $&drive
let drive = (floor(trial / 8) - 2*floor(trial / 16))*1.8
alter VB3 = $&drive
let drive = (floor(trial / 16) - 2*floor(trial / 32))*1.8
alter VB4 = $&drive
let drive = (floor(trial / 32) - 2*floor(trial / 64))*1.8
alter VB5 = $&drive
let drive = (floor(trial / 64) - 2*floor(trial / 128))*1.8
alter VB6 = $&drive
let drive = (floor(trial / 128) - 2*floor(trial / 256))*1.8
alter VB7 = $&drive
stop when time = 0.00303
resume
delete all
let endpoint = length(time)-1
let cmp = v(COMP)[endpoint]
let top = v(TOP)[endpoint]
let decision = 0
if cmp >= 0.9
let code = trial
let decision = 1
end
echo 168 6 $&trial $&cmp $&top 0.77578125 $&decision >> decisions.csv
let trial = code + 32
let drive = (floor(trial / 1) - 2*floor(trial / 2))*1.8
alter VB0 = $&drive
let drive = (floor(trial / 2) - 2*floor(trial / 4))*1.8
alter VB1 = $&drive
let drive = (floor(trial / 4) - 2*floor(trial / 8))*1.8
alter VB2 = $&drive
let drive = (floor(trial / 8) - 2*floor(trial / 16))*1.8
alter VB3 = $&drive
let drive = (floor(trial / 16) - 2*floor(trial / 32))*1.8
alter VB4 = $&drive
let drive = (floor(trial / 32) - 2*floor(trial / 64))*1.8
alter VB5 = $&drive
let drive = (floor(trial / 64) - 2*floor(trial / 128))*1.8
alter VB6 = $&drive
let drive = (floor(trial / 128) - 2*floor(trial / 256))*1.8
alter VB7 = $&drive
stop when time = 0.003032
resume
delete all
let endpoint = length(time)-1
let cmp = v(COMP)[endpoint]
let top = v(TOP)[endpoint]
let decision = 0
if cmp >= 0.9
let code = trial
let decision = 1
end
echo 168 5 $&trial $&cmp $&top 0.77578125 $&decision >> decisions.csv
let trial = code + 16
let drive = (floor(trial / 1) - 2*floor(trial / 2))*1.8
alter VB0 = $&drive
let drive = (floor(trial / 2) - 2*floor(trial / 4))*1.8
alter VB1 = $&drive
let drive = (floor(trial / 4) - 2*floor(trial / 8))*1.8
alter VB2 = $&drive
let drive = (floor(trial / 8) - 2*floor(trial / 16))*1.8
alter VB3 = $&drive
let drive = (floor(trial / 16) - 2*floor(trial / 32))*1.8
alter VB4 = $&drive
let drive = (floor(trial / 32) - 2*floor(trial / 64))*1.8
alter VB5 = $&drive
let drive = (floor(trial / 64) - 2*floor(trial / 128))*1.8
alter VB6 = $&drive
let drive = (floor(trial / 128) - 2*floor(trial / 256))*1.8
alter VB7 = $&drive
stop when time = 0.003034
resume
delete all
let endpoint = length(time)-1
let cmp = v(COMP)[endpoint]
let top = v(TOP)[endpoint]
let decision = 0
if cmp >= 0.9
let code = trial
let decision = 1
end
echo 168 4 $&trial $&cmp $&top 0.77578125 $&decision >> decisions.csv
let trial = code + 8
let drive = (floor(trial / 1) - 2*floor(trial / 2))*1.8
alter VB0 = $&drive
let drive = (floor(trial / 2) - 2*floor(trial / 4))*1.8
alter VB1 = $&drive
let drive = (floor(trial / 4) - 2*floor(trial / 8))*1.8
alter VB2 = $&drive
let drive = (floor(trial / 8) - 2*floor(trial / 16))*1.8
alter VB3 = $&drive
let drive = (floor(trial / 16) - 2*floor(trial / 32))*1.8
alter VB4 = $&drive
let drive = (floor(trial / 32) - 2*floor(trial / 64))*1.8
alter VB5 = $&drive
let drive = (floor(trial / 64) - 2*floor(trial / 128))*1.8
alter VB6 = $&drive
let drive = (floor(trial / 128) - 2*floor(trial / 256))*1.8
alter VB7 = $&drive
stop when time = 0.003036
resume
delete all
let endpoint = length(time)-1
let cmp = v(COMP)[endpoint]
let top = v(TOP)[endpoint]
let decision = 0
if cmp >= 0.9
let code = trial
let decision = 1
end
echo 168 3 $&trial $&cmp $&top 0.77578125 $&decision >> decisions.csv
let trial = code + 4
let drive = (floor(trial / 1) - 2*floor(trial / 2))*1.8
alter VB0 = $&drive
let drive = (floor(trial / 2) - 2*floor(trial / 4))*1.8
alter VB1 = $&drive
let drive = (floor(trial / 4) - 2*floor(trial / 8))*1.8
alter VB2 = $&drive
let drive = (floor(trial / 8) - 2*floor(trial / 16))*1.8
alter VB3 = $&drive
let drive = (floor(trial / 16) - 2*floor(trial / 32))*1.8
alter VB4 = $&drive
let drive = (floor(trial / 32) - 2*floor(trial / 64))*1.8
alter VB5 = $&drive
let drive = (floor(trial / 64) - 2*floor(trial / 128))*1.8
alter VB6 = $&drive
let drive = (floor(trial / 128) - 2*floor(trial / 256))*1.8
alter VB7 = $&drive
stop when time = 0.003038
resume
delete all
let endpoint = length(time)-1
let cmp = v(COMP)[endpoint]
let top = v(TOP)[endpoint]
let decision = 0
if cmp >= 0.9
let code = trial
let decision = 1
end
echo 168 2 $&trial $&cmp $&top 0.77578125 $&decision >> decisions.csv
let trial = code + 2
let drive = (floor(trial / 1) - 2*floor(trial / 2))*1.8
alter VB0 = $&drive
let drive = (floor(trial / 2) - 2*floor(trial / 4))*1.8
alter VB1 = $&drive
let drive = (floor(trial / 4) - 2*floor(trial / 8))*1.8
alter VB2 = $&drive
let drive = (floor(trial / 8) - 2*floor(trial / 16))*1.8
alter VB3 = $&drive
let drive = (floor(trial / 16) - 2*floor(trial / 32))*1.8
alter VB4 = $&drive
let drive = (floor(trial / 32) - 2*floor(trial / 64))*1.8
alter VB5 = $&drive
let drive = (floor(trial / 64) - 2*floor(trial / 128))*1.8
alter VB6 = $&drive
let drive = (floor(trial / 128) - 2*floor(trial / 256))*1.8
alter VB7 = $&drive
stop when time = 0.00304
resume
delete all
let endpoint = length(time)-1
let cmp = v(COMP)[endpoint]
let top = v(TOP)[endpoint]
let decision = 0
if cmp >= 0.9
let code = trial
let decision = 1
end
echo 168 1 $&trial $&cmp $&top 0.77578125 $&decision >> decisions.csv
let trial = code + 1
let drive = (floor(trial / 1) - 2*floor(trial / 2))*1.8
alter VB0 = $&drive
let drive = (floor(trial / 2) - 2*floor(trial / 4))*1.8
alter VB1 = $&drive
let drive = (floor(trial / 4) - 2*floor(trial / 8))*1.8
alter VB2 = $&drive
let drive = (floor(trial / 8) - 2*floor(trial / 16))*1.8
alter VB3 = $&drive
let drive = (floor(trial / 16) - 2*floor(trial / 32))*1.8
alter VB4 = $&drive
let drive = (floor(trial / 32) - 2*floor(trial / 64))*1.8
alter VB5 = $&drive
let drive = (floor(trial / 64) - 2*floor(trial / 128))*1.8
alter VB6 = $&drive
let drive = (floor(trial / 128) - 2*floor(trial / 256))*1.8
alter VB7 = $&drive
stop when time = 0.003042
resume
delete all
let endpoint = length(time)-1
let cmp = v(COMP)[endpoint]
let top = v(TOP)[endpoint]
let decision = 0
if cmp >= 0.9
let code = trial
let decision = 1
end
echo 168 0 $&trial $&cmp $&top 0.77578125 $&decision >> decisions.csv
alter VIN = 0.78046875
alter VSAMPLE = 1.8
alter VB0 = 0
alter VB1 = 0
alter VB2 = 0
alter VB3 = 0
alter VB4 = 0
alter VB5 = 0
alter VB6 = 0
alter VB7 = 0
let code = 0
stop when time = 0.003044
resume
delete all
alter VSAMPLE = 0
let trial = code + 128
let drive = (floor(trial / 1) - 2*floor(trial / 2))*1.8
alter VB0 = $&drive
let drive = (floor(trial / 2) - 2*floor(trial / 4))*1.8
alter VB1 = $&drive
let drive = (floor(trial / 4) - 2*floor(trial / 8))*1.8
alter VB2 = $&drive
let drive = (floor(trial / 8) - 2*floor(trial / 16))*1.8
alter VB3 = $&drive
let drive = (floor(trial / 16) - 2*floor(trial / 32))*1.8
alter VB4 = $&drive
let drive = (floor(trial / 32) - 2*floor(trial / 64))*1.8
alter VB5 = $&drive
let drive = (floor(trial / 64) - 2*floor(trial / 128))*1.8
alter VB6 = $&drive
let drive = (floor(trial / 128) - 2*floor(trial / 256))*1.8
alter VB7 = $&drive
stop when time = 0.003046
resume
delete all
let endpoint = length(time)-1
let cmp = v(COMP)[endpoint]
let top = v(TOP)[endpoint]
let decision = 0
if cmp >= 0.9
let code = trial
let decision = 1
end
echo 169 7 $&trial $&cmp $&top 0.78046875 $&decision >> decisions.csv
let trial = code + 64
let drive = (floor(trial / 1) - 2*floor(trial / 2))*1.8
alter VB0 = $&drive
let drive = (floor(trial / 2) - 2*floor(trial / 4))*1.8
alter VB1 = $&drive
let drive = (floor(trial / 4) - 2*floor(trial / 8))*1.8
alter VB2 = $&drive
let drive = (floor(trial / 8) - 2*floor(trial / 16))*1.8
alter VB3 = $&drive
let drive = (floor(trial / 16) - 2*floor(trial / 32))*1.8
alter VB4 = $&drive
let drive = (floor(trial / 32) - 2*floor(trial / 64))*1.8
alter VB5 = $&drive
let drive = (floor(trial / 64) - 2*floor(trial / 128))*1.8
alter VB6 = $&drive
let drive = (floor(trial / 128) - 2*floor(trial / 256))*1.8
alter VB7 = $&drive
stop when time = 0.003048
resume
delete all
let endpoint = length(time)-1
let cmp = v(COMP)[endpoint]
let top = v(TOP)[endpoint]
let decision = 0
if cmp >= 0.9
let code = trial
let decision = 1
end
echo 169 6 $&trial $&cmp $&top 0.78046875 $&decision >> decisions.csv
let trial = code + 32
let drive = (floor(trial / 1) - 2*floor(trial / 2))*1.8
alter VB0 = $&drive
let drive = (floor(trial / 2) - 2*floor(trial / 4))*1.8
alter VB1 = $&drive
let drive = (floor(trial / 4) - 2*floor(trial / 8))*1.8
alter VB2 = $&drive
let drive = (floor(trial / 8) - 2*floor(trial / 16))*1.8
alter VB3 = $&drive
let drive = (floor(trial / 16) - 2*floor(trial / 32))*1.8
alter VB4 = $&drive
let drive = (floor(trial / 32) - 2*floor(trial / 64))*1.8
alter VB5 = $&drive
let drive = (floor(trial / 64) - 2*floor(trial / 128))*1.8
alter VB6 = $&drive
let drive = (floor(trial / 128) - 2*floor(trial / 256))*1.8
alter VB7 = $&drive
stop when time = 0.00305
resume
delete all
let endpoint = length(time)-1
let cmp = v(COMP)[endpoint]
let top = v(TOP)[endpoint]
let decision = 0
if cmp >= 0.9
let code = trial
let decision = 1
end
echo 169 5 $&trial $&cmp $&top 0.78046875 $&decision >> decisions.csv
let trial = code + 16
let drive = (floor(trial / 1) - 2*floor(trial / 2))*1.8
alter VB0 = $&drive
let drive = (floor(trial / 2) - 2*floor(trial / 4))*1.8
alter VB1 = $&drive
let drive = (floor(trial / 4) - 2*floor(trial / 8))*1.8
alter VB2 = $&drive
let drive = (floor(trial / 8) - 2*floor(trial / 16))*1.8
alter VB3 = $&drive
let drive = (floor(trial / 16) - 2*floor(trial / 32))*1.8
alter VB4 = $&drive
let drive = (floor(trial / 32) - 2*floor(trial / 64))*1.8
alter VB5 = $&drive
let drive = (floor(trial / 64) - 2*floor(trial / 128))*1.8
alter VB6 = $&drive
let drive = (floor(trial / 128) - 2*floor(trial / 256))*1.8
alter VB7 = $&drive
stop when time = 0.003052
resume
delete all
let endpoint = length(time)-1
let cmp = v(COMP)[endpoint]
let top = v(TOP)[endpoint]
let decision = 0
if cmp >= 0.9
let code = trial
let decision = 1
end
echo 169 4 $&trial $&cmp $&top 0.78046875 $&decision >> decisions.csv
let trial = code + 8
let drive = (floor(trial / 1) - 2*floor(trial / 2))*1.8
alter VB0 = $&drive
let drive = (floor(trial / 2) - 2*floor(trial / 4))*1.8
alter VB1 = $&drive
let drive = (floor(trial / 4) - 2*floor(trial / 8))*1.8
alter VB2 = $&drive
let drive = (floor(trial / 8) - 2*floor(trial / 16))*1.8
alter VB3 = $&drive
let drive = (floor(trial / 16) - 2*floor(trial / 32))*1.8
alter VB4 = $&drive
let drive = (floor(trial / 32) - 2*floor(trial / 64))*1.8
alter VB5 = $&drive
let drive = (floor(trial / 64) - 2*floor(trial / 128))*1.8
alter VB6 = $&drive
let drive = (floor(trial / 128) - 2*floor(trial / 256))*1.8
alter VB7 = $&drive
stop when time = 0.003054
resume
delete all
let endpoint = length(time)-1
let cmp = v(COMP)[endpoint]
let top = v(TOP)[endpoint]
let decision = 0
if cmp >= 0.9
let code = trial
let decision = 1
end
echo 169 3 $&trial $&cmp $&top 0.78046875 $&decision >> decisions.csv
let trial = code + 4
let drive = (floor(trial / 1) - 2*floor(trial / 2))*1.8
alter VB0 = $&drive
let drive = (floor(trial / 2) - 2*floor(trial / 4))*1.8
alter VB1 = $&drive
let drive = (floor(trial / 4) - 2*floor(trial / 8))*1.8
alter VB2 = $&drive
let drive = (floor(trial / 8) - 2*floor(trial / 16))*1.8
alter VB3 = $&drive
let drive = (floor(trial / 16) - 2*floor(trial / 32))*1.8
alter VB4 = $&drive
let drive = (floor(trial / 32) - 2*floor(trial / 64))*1.8
alter VB5 = $&drive
let drive = (floor(trial / 64) - 2*floor(trial / 128))*1.8
alter VB6 = $&drive
let drive = (floor(trial / 128) - 2*floor(trial / 256))*1.8
alter VB7 = $&drive
stop when time = 0.003056
resume
delete all
let endpoint = length(time)-1
let cmp = v(COMP)[endpoint]
let top = v(TOP)[endpoint]
let decision = 0
if cmp >= 0.9
let code = trial
let decision = 1
end
echo 169 2 $&trial $&cmp $&top 0.78046875 $&decision >> decisions.csv
let trial = code + 2
let drive = (floor(trial / 1) - 2*floor(trial / 2))*1.8
alter VB0 = $&drive
let drive = (floor(trial / 2) - 2*floor(trial / 4))*1.8
alter VB1 = $&drive
let drive = (floor(trial / 4) - 2*floor(trial / 8))*1.8
alter VB2 = $&drive
let drive = (floor(trial / 8) - 2*floor(trial / 16))*1.8
alter VB3 = $&drive
let drive = (floor(trial / 16) - 2*floor(trial / 32))*1.8
alter VB4 = $&drive
let drive = (floor(trial / 32) - 2*floor(trial / 64))*1.8
alter VB5 = $&drive
let drive = (floor(trial / 64) - 2*floor(trial / 128))*1.8
alter VB6 = $&drive
let drive = (floor(trial / 128) - 2*floor(trial / 256))*1.8
alter VB7 = $&drive
stop when time = 0.003058
resume
delete all
let endpoint = length(time)-1
let cmp = v(COMP)[endpoint]
let top = v(TOP)[endpoint]
let decision = 0
if cmp >= 0.9
let code = trial
let decision = 1
end
echo 169 1 $&trial $&cmp $&top 0.78046875 $&decision >> decisions.csv
let trial = code + 1
let drive = (floor(trial / 1) - 2*floor(trial / 2))*1.8
alter VB0 = $&drive
let drive = (floor(trial / 2) - 2*floor(trial / 4))*1.8
alter VB1 = $&drive
let drive = (floor(trial / 4) - 2*floor(trial / 8))*1.8
alter VB2 = $&drive
let drive = (floor(trial / 8) - 2*floor(trial / 16))*1.8
alter VB3 = $&drive
let drive = (floor(trial / 16) - 2*floor(trial / 32))*1.8
alter VB4 = $&drive
let drive = (floor(trial / 32) - 2*floor(trial / 64))*1.8
alter VB5 = $&drive
let drive = (floor(trial / 64) - 2*floor(trial / 128))*1.8
alter VB6 = $&drive
let drive = (floor(trial / 128) - 2*floor(trial / 256))*1.8
alter VB7 = $&drive
stop when time = 0.00306
resume
delete all
let endpoint = length(time)-1
let cmp = v(COMP)[endpoint]
let top = v(TOP)[endpoint]
let decision = 0
if cmp >= 0.9
let code = trial
let decision = 1
end
echo 169 0 $&trial $&cmp $&top 0.78046875 $&decision >> decisions.csv
alter VIN = 0.78515625
alter VSAMPLE = 1.8
alter VB0 = 0
alter VB1 = 0
alter VB2 = 0
alter VB3 = 0
alter VB4 = 0
alter VB5 = 0
alter VB6 = 0
alter VB7 = 0
let code = 0
stop when time = 0.003062
resume
delete all
alter VSAMPLE = 0
let trial = code + 128
let drive = (floor(trial / 1) - 2*floor(trial / 2))*1.8
alter VB0 = $&drive
let drive = (floor(trial / 2) - 2*floor(trial / 4))*1.8
alter VB1 = $&drive
let drive = (floor(trial / 4) - 2*floor(trial / 8))*1.8
alter VB2 = $&drive
let drive = (floor(trial / 8) - 2*floor(trial / 16))*1.8
alter VB3 = $&drive
let drive = (floor(trial / 16) - 2*floor(trial / 32))*1.8
alter VB4 = $&drive
let drive = (floor(trial / 32) - 2*floor(trial / 64))*1.8
alter VB5 = $&drive
let drive = (floor(trial / 64) - 2*floor(trial / 128))*1.8
alter VB6 = $&drive
let drive = (floor(trial / 128) - 2*floor(trial / 256))*1.8
alter VB7 = $&drive
stop when time = 0.003064
resume
delete all
let endpoint = length(time)-1
let cmp = v(COMP)[endpoint]
let top = v(TOP)[endpoint]
let decision = 0
if cmp >= 0.9
let code = trial
let decision = 1
end
echo 170 7 $&trial $&cmp $&top 0.78515625 $&decision >> decisions.csv
let trial = code + 64
let drive = (floor(trial / 1) - 2*floor(trial / 2))*1.8
alter VB0 = $&drive
let drive = (floor(trial / 2) - 2*floor(trial / 4))*1.8
alter VB1 = $&drive
let drive = (floor(trial / 4) - 2*floor(trial / 8))*1.8
alter VB2 = $&drive
let drive = (floor(trial / 8) - 2*floor(trial / 16))*1.8
alter VB3 = $&drive
let drive = (floor(trial / 16) - 2*floor(trial / 32))*1.8
alter VB4 = $&drive
let drive = (floor(trial / 32) - 2*floor(trial / 64))*1.8
alter VB5 = $&drive
let drive = (floor(trial / 64) - 2*floor(trial / 128))*1.8
alter VB6 = $&drive
let drive = (floor(trial / 128) - 2*floor(trial / 256))*1.8
alter VB7 = $&drive
stop when time = 0.003066
resume
delete all
let endpoint = length(time)-1
let cmp = v(COMP)[endpoint]
let top = v(TOP)[endpoint]
let decision = 0
if cmp >= 0.9
let code = trial
let decision = 1
end
echo 170 6 $&trial $&cmp $&top 0.78515625 $&decision >> decisions.csv
let trial = code + 32
let drive = (floor(trial / 1) - 2*floor(trial / 2))*1.8
alter VB0 = $&drive
let drive = (floor(trial / 2) - 2*floor(trial / 4))*1.8
alter VB1 = $&drive
let drive = (floor(trial / 4) - 2*floor(trial / 8))*1.8
alter VB2 = $&drive
let drive = (floor(trial / 8) - 2*floor(trial / 16))*1.8
alter VB3 = $&drive
let drive = (floor(trial / 16) - 2*floor(trial / 32))*1.8
alter VB4 = $&drive
let drive = (floor(trial / 32) - 2*floor(trial / 64))*1.8
alter VB5 = $&drive
let drive = (floor(trial / 64) - 2*floor(trial / 128))*1.8
alter VB6 = $&drive
let drive = (floor(trial / 128) - 2*floor(trial / 256))*1.8
alter VB7 = $&drive
stop when time = 0.003068
resume
delete all
let endpoint = length(time)-1
let cmp = v(COMP)[endpoint]
let top = v(TOP)[endpoint]
let decision = 0
if cmp >= 0.9
let code = trial
let decision = 1
end
echo 170 5 $&trial $&cmp $&top 0.78515625 $&decision >> decisions.csv
let trial = code + 16
let drive = (floor(trial / 1) - 2*floor(trial / 2))*1.8
alter VB0 = $&drive
let drive = (floor(trial / 2) - 2*floor(trial / 4))*1.8
alter VB1 = $&drive
let drive = (floor(trial / 4) - 2*floor(trial / 8))*1.8
alter VB2 = $&drive
let drive = (floor(trial / 8) - 2*floor(trial / 16))*1.8
alter VB3 = $&drive
let drive = (floor(trial / 16) - 2*floor(trial / 32))*1.8
alter VB4 = $&drive
let drive = (floor(trial / 32) - 2*floor(trial / 64))*1.8
alter VB5 = $&drive
let drive = (floor(trial / 64) - 2*floor(trial / 128))*1.8
alter VB6 = $&drive
let drive = (floor(trial / 128) - 2*floor(trial / 256))*1.8
alter VB7 = $&drive
stop when time = 0.00307
resume
delete all
let endpoint = length(time)-1
let cmp = v(COMP)[endpoint]
let top = v(TOP)[endpoint]
let decision = 0
if cmp >= 0.9
let code = trial
let decision = 1
end
echo 170 4 $&trial $&cmp $&top 0.78515625 $&decision >> decisions.csv
let trial = code + 8
let drive = (floor(trial / 1) - 2*floor(trial / 2))*1.8
alter VB0 = $&drive
let drive = (floor(trial / 2) - 2*floor(trial / 4))*1.8
alter VB1 = $&drive
let drive = (floor(trial / 4) - 2*floor(trial / 8))*1.8
alter VB2 = $&drive
let drive = (floor(trial / 8) - 2*floor(trial / 16))*1.8
alter VB3 = $&drive
let drive = (floor(trial / 16) - 2*floor(trial / 32))*1.8
alter VB4 = $&drive
let drive = (floor(trial / 32) - 2*floor(trial / 64))*1.8
alter VB5 = $&drive
let drive = (floor(trial / 64) - 2*floor(trial / 128))*1.8
alter VB6 = $&drive
let drive = (floor(trial / 128) - 2*floor(trial / 256))*1.8
alter VB7 = $&drive
stop when time = 0.003072
resume
delete all
let endpoint = length(time)-1
let cmp = v(COMP)[endpoint]
let top = v(TOP)[endpoint]
let decision = 0
if cmp >= 0.9
let code = trial
let decision = 1
end
echo 170 3 $&trial $&cmp $&top 0.78515625 $&decision >> decisions.csv
let trial = code + 4
let drive = (floor(trial / 1) - 2*floor(trial / 2))*1.8
alter VB0 = $&drive
let drive = (floor(trial / 2) - 2*floor(trial / 4))*1.8
alter VB1 = $&drive
let drive = (floor(trial / 4) - 2*floor(trial / 8))*1.8
alter VB2 = $&drive
let drive = (floor(trial / 8) - 2*floor(trial / 16))*1.8
alter VB3 = $&drive
let drive = (floor(trial / 16) - 2*floor(trial / 32))*1.8
alter VB4 = $&drive
let drive = (floor(trial / 32) - 2*floor(trial / 64))*1.8
alter VB5 = $&drive
let drive = (floor(trial / 64) - 2*floor(trial / 128))*1.8
alter VB6 = $&drive
let drive = (floor(trial / 128) - 2*floor(trial / 256))*1.8
alter VB7 = $&drive
stop when time = 0.003074
resume
delete all
let endpoint = length(time)-1
let cmp = v(COMP)[endpoint]
let top = v(TOP)[endpoint]
let decision = 0
if cmp >= 0.9
let code = trial
let decision = 1
end
echo 170 2 $&trial $&cmp $&top 0.78515625 $&decision >> decisions.csv
let trial = code + 2
let drive = (floor(trial / 1) - 2*floor(trial / 2))*1.8
alter VB0 = $&drive
let drive = (floor(trial / 2) - 2*floor(trial / 4))*1.8
alter VB1 = $&drive
let drive = (floor(trial / 4) - 2*floor(trial / 8))*1.8
alter VB2 = $&drive
let drive = (floor(trial / 8) - 2*floor(trial / 16))*1.8
alter VB3 = $&drive
let drive = (floor(trial / 16) - 2*floor(trial / 32))*1.8
alter VB4 = $&drive
let drive = (floor(trial / 32) - 2*floor(trial / 64))*1.8
alter VB5 = $&drive
let drive = (floor(trial / 64) - 2*floor(trial / 128))*1.8
alter VB6 = $&drive
let drive = (floor(trial / 128) - 2*floor(trial / 256))*1.8
alter VB7 = $&drive
stop when time = 0.003076
resume
delete all
let endpoint = length(time)-1
let cmp = v(COMP)[endpoint]
let top = v(TOP)[endpoint]
let decision = 0
if cmp >= 0.9
let code = trial
let decision = 1
end
echo 170 1 $&trial $&cmp $&top 0.78515625 $&decision >> decisions.csv
let trial = code + 1
let drive = (floor(trial / 1) - 2*floor(trial / 2))*1.8
alter VB0 = $&drive
let drive = (floor(trial / 2) - 2*floor(trial / 4))*1.8
alter VB1 = $&drive
let drive = (floor(trial / 4) - 2*floor(trial / 8))*1.8
alter VB2 = $&drive
let drive = (floor(trial / 8) - 2*floor(trial / 16))*1.8
alter VB3 = $&drive
let drive = (floor(trial / 16) - 2*floor(trial / 32))*1.8
alter VB4 = $&drive
let drive = (floor(trial / 32) - 2*floor(trial / 64))*1.8
alter VB5 = $&drive
let drive = (floor(trial / 64) - 2*floor(trial / 128))*1.8
alter VB6 = $&drive
let drive = (floor(trial / 128) - 2*floor(trial / 256))*1.8
alter VB7 = $&drive
stop when time = 0.003078
resume
delete all
let endpoint = length(time)-1
let cmp = v(COMP)[endpoint]
let top = v(TOP)[endpoint]
let decision = 0
if cmp >= 0.9
let code = trial
let decision = 1
end
echo 170 0 $&trial $&cmp $&top 0.78515625 $&decision >> decisions.csv
alter VIN = 0.78984375
alter VSAMPLE = 1.8
alter VB0 = 0
alter VB1 = 0
alter VB2 = 0
alter VB3 = 0
alter VB4 = 0
alter VB5 = 0
alter VB6 = 0
alter VB7 = 0
let code = 0
stop when time = 0.00308
resume
delete all
alter VSAMPLE = 0
let trial = code + 128
let drive = (floor(trial / 1) - 2*floor(trial / 2))*1.8
alter VB0 = $&drive
let drive = (floor(trial / 2) - 2*floor(trial / 4))*1.8
alter VB1 = $&drive
let drive = (floor(trial / 4) - 2*floor(trial / 8))*1.8
alter VB2 = $&drive
let drive = (floor(trial / 8) - 2*floor(trial / 16))*1.8
alter VB3 = $&drive
let drive = (floor(trial / 16) - 2*floor(trial / 32))*1.8
alter VB4 = $&drive
let drive = (floor(trial / 32) - 2*floor(trial / 64))*1.8
alter VB5 = $&drive
let drive = (floor(trial / 64) - 2*floor(trial / 128))*1.8
alter VB6 = $&drive
let drive = (floor(trial / 128) - 2*floor(trial / 256))*1.8
alter VB7 = $&drive
stop when time = 0.003082
resume
delete all
let endpoint = length(time)-1
let cmp = v(COMP)[endpoint]
let top = v(TOP)[endpoint]
let decision = 0
if cmp >= 0.9
let code = trial
let decision = 1
end
echo 171 7 $&trial $&cmp $&top 0.78984375 $&decision >> decisions.csv
let trial = code + 64
let drive = (floor(trial / 1) - 2*floor(trial / 2))*1.8
alter VB0 = $&drive
let drive = (floor(trial / 2) - 2*floor(trial / 4))*1.8
alter VB1 = $&drive
let drive = (floor(trial / 4) - 2*floor(trial / 8))*1.8
alter VB2 = $&drive
let drive = (floor(trial / 8) - 2*floor(trial / 16))*1.8
alter VB3 = $&drive
let drive = (floor(trial / 16) - 2*floor(trial / 32))*1.8
alter VB4 = $&drive
let drive = (floor(trial / 32) - 2*floor(trial / 64))*1.8
alter VB5 = $&drive
let drive = (floor(trial / 64) - 2*floor(trial / 128))*1.8
alter VB6 = $&drive
let drive = (floor(trial / 128) - 2*floor(trial / 256))*1.8
alter VB7 = $&drive
stop when time = 0.003084
resume
delete all
let endpoint = length(time)-1
let cmp = v(COMP)[endpoint]
let top = v(TOP)[endpoint]
let decision = 0
if cmp >= 0.9
let code = trial
let decision = 1
end
echo 171 6 $&trial $&cmp $&top 0.78984375 $&decision >> decisions.csv
let trial = code + 32
let drive = (floor(trial / 1) - 2*floor(trial / 2))*1.8
alter VB0 = $&drive
let drive = (floor(trial / 2) - 2*floor(trial / 4))*1.8
alter VB1 = $&drive
let drive = (floor(trial / 4) - 2*floor(trial / 8))*1.8
alter VB2 = $&drive
let drive = (floor(trial / 8) - 2*floor(trial / 16))*1.8
alter VB3 = $&drive
let drive = (floor(trial / 16) - 2*floor(trial / 32))*1.8
alter VB4 = $&drive
let drive = (floor(trial / 32) - 2*floor(trial / 64))*1.8
alter VB5 = $&drive
let drive = (floor(trial / 64) - 2*floor(trial / 128))*1.8
alter VB6 = $&drive
let drive = (floor(trial / 128) - 2*floor(trial / 256))*1.8
alter VB7 = $&drive
stop when time = 0.003086
resume
delete all
let endpoint = length(time)-1
let cmp = v(COMP)[endpoint]
let top = v(TOP)[endpoint]
let decision = 0
if cmp >= 0.9
let code = trial
let decision = 1
end
echo 171 5 $&trial $&cmp $&top 0.78984375 $&decision >> decisions.csv
let trial = code + 16
let drive = (floor(trial / 1) - 2*floor(trial / 2))*1.8
alter VB0 = $&drive
let drive = (floor(trial / 2) - 2*floor(trial / 4))*1.8
alter VB1 = $&drive
let drive = (floor(trial / 4) - 2*floor(trial / 8))*1.8
alter VB2 = $&drive
let drive = (floor(trial / 8) - 2*floor(trial / 16))*1.8
alter VB3 = $&drive
let drive = (floor(trial / 16) - 2*floor(trial / 32))*1.8
alter VB4 = $&drive
let drive = (floor(trial / 32) - 2*floor(trial / 64))*1.8
alter VB5 = $&drive
let drive = (floor(trial / 64) - 2*floor(trial / 128))*1.8
alter VB6 = $&drive
let drive = (floor(trial / 128) - 2*floor(trial / 256))*1.8
alter VB7 = $&drive
stop when time = 0.003088
resume
delete all
let endpoint = length(time)-1
let cmp = v(COMP)[endpoint]
let top = v(TOP)[endpoint]
let decision = 0
if cmp >= 0.9
let code = trial
let decision = 1
end
echo 171 4 $&trial $&cmp $&top 0.78984375 $&decision >> decisions.csv
let trial = code + 8
let drive = (floor(trial / 1) - 2*floor(trial / 2))*1.8
alter VB0 = $&drive
let drive = (floor(trial / 2) - 2*floor(trial / 4))*1.8
alter VB1 = $&drive
let drive = (floor(trial / 4) - 2*floor(trial / 8))*1.8
alter VB2 = $&drive
let drive = (floor(trial / 8) - 2*floor(trial / 16))*1.8
alter VB3 = $&drive
let drive = (floor(trial / 16) - 2*floor(trial / 32))*1.8
alter VB4 = $&drive
let drive = (floor(trial / 32) - 2*floor(trial / 64))*1.8
alter VB5 = $&drive
let drive = (floor(trial / 64) - 2*floor(trial / 128))*1.8
alter VB6 = $&drive
let drive = (floor(trial / 128) - 2*floor(trial / 256))*1.8
alter VB7 = $&drive
stop when time = 0.00309
resume
delete all
let endpoint = length(time)-1
let cmp = v(COMP)[endpoint]
let top = v(TOP)[endpoint]
let decision = 0
if cmp >= 0.9
let code = trial
let decision = 1
end
echo 171 3 $&trial $&cmp $&top 0.78984375 $&decision >> decisions.csv
let trial = code + 4
let drive = (floor(trial / 1) - 2*floor(trial / 2))*1.8
alter VB0 = $&drive
let drive = (floor(trial / 2) - 2*floor(trial / 4))*1.8
alter VB1 = $&drive
let drive = (floor(trial / 4) - 2*floor(trial / 8))*1.8
alter VB2 = $&drive
let drive = (floor(trial / 8) - 2*floor(trial / 16))*1.8
alter VB3 = $&drive
let drive = (floor(trial / 16) - 2*floor(trial / 32))*1.8
alter VB4 = $&drive
let drive = (floor(trial / 32) - 2*floor(trial / 64))*1.8
alter VB5 = $&drive
let drive = (floor(trial / 64) - 2*floor(trial / 128))*1.8
alter VB6 = $&drive
let drive = (floor(trial / 128) - 2*floor(trial / 256))*1.8
alter VB7 = $&drive
stop when time = 0.003092
resume
delete all
let endpoint = length(time)-1
let cmp = v(COMP)[endpoint]
let top = v(TOP)[endpoint]
let decision = 0
if cmp >= 0.9
let code = trial
let decision = 1
end
echo 171 2 $&trial $&cmp $&top 0.78984375 $&decision >> decisions.csv
let trial = code + 2
let drive = (floor(trial / 1) - 2*floor(trial / 2))*1.8
alter VB0 = $&drive
let drive = (floor(trial / 2) - 2*floor(trial / 4))*1.8
alter VB1 = $&drive
let drive = (floor(trial / 4) - 2*floor(trial / 8))*1.8
alter VB2 = $&drive
let drive = (floor(trial / 8) - 2*floor(trial / 16))*1.8
alter VB3 = $&drive
let drive = (floor(trial / 16) - 2*floor(trial / 32))*1.8
alter VB4 = $&drive
let drive = (floor(trial / 32) - 2*floor(trial / 64))*1.8
alter VB5 = $&drive
let drive = (floor(trial / 64) - 2*floor(trial / 128))*1.8
alter VB6 = $&drive
let drive = (floor(trial / 128) - 2*floor(trial / 256))*1.8
alter VB7 = $&drive
stop when time = 0.003094
resume
delete all
let endpoint = length(time)-1
let cmp = v(COMP)[endpoint]
let top = v(TOP)[endpoint]
let decision = 0
if cmp >= 0.9
let code = trial
let decision = 1
end
echo 171 1 $&trial $&cmp $&top 0.78984375 $&decision >> decisions.csv
let trial = code + 1
let drive = (floor(trial / 1) - 2*floor(trial / 2))*1.8
alter VB0 = $&drive
let drive = (floor(trial / 2) - 2*floor(trial / 4))*1.8
alter VB1 = $&drive
let drive = (floor(trial / 4) - 2*floor(trial / 8))*1.8
alter VB2 = $&drive
let drive = (floor(trial / 8) - 2*floor(trial / 16))*1.8
alter VB3 = $&drive
let drive = (floor(trial / 16) - 2*floor(trial / 32))*1.8
alter VB4 = $&drive
let drive = (floor(trial / 32) - 2*floor(trial / 64))*1.8
alter VB5 = $&drive
let drive = (floor(trial / 64) - 2*floor(trial / 128))*1.8
alter VB6 = $&drive
let drive = (floor(trial / 128) - 2*floor(trial / 256))*1.8
alter VB7 = $&drive
stop when time = 0.003096
resume
delete all
let endpoint = length(time)-1
let cmp = v(COMP)[endpoint]
let top = v(TOP)[endpoint]
let decision = 0
if cmp >= 0.9
let code = trial
let decision = 1
end
echo 171 0 $&trial $&cmp $&top 0.78984375 $&decision >> decisions.csv
alter VIN = 0.79453125
alter VSAMPLE = 1.8
alter VB0 = 0
alter VB1 = 0
alter VB2 = 0
alter VB3 = 0
alter VB4 = 0
alter VB5 = 0
alter VB6 = 0
alter VB7 = 0
let code = 0
stop when time = 0.003098
resume
delete all
alter VSAMPLE = 0
let trial = code + 128
let drive = (floor(trial / 1) - 2*floor(trial / 2))*1.8
alter VB0 = $&drive
let drive = (floor(trial / 2) - 2*floor(trial / 4))*1.8
alter VB1 = $&drive
let drive = (floor(trial / 4) - 2*floor(trial / 8))*1.8
alter VB2 = $&drive
let drive = (floor(trial / 8) - 2*floor(trial / 16))*1.8
alter VB3 = $&drive
let drive = (floor(trial / 16) - 2*floor(trial / 32))*1.8
alter VB4 = $&drive
let drive = (floor(trial / 32) - 2*floor(trial / 64))*1.8
alter VB5 = $&drive
let drive = (floor(trial / 64) - 2*floor(trial / 128))*1.8
alter VB6 = $&drive
let drive = (floor(trial / 128) - 2*floor(trial / 256))*1.8
alter VB7 = $&drive
stop when time = 0.0031
resume
delete all
let endpoint = length(time)-1
let cmp = v(COMP)[endpoint]
let top = v(TOP)[endpoint]
let decision = 0
if cmp >= 0.9
let code = trial
let decision = 1
end
echo 172 7 $&trial $&cmp $&top 0.79453125 $&decision >> decisions.csv
let trial = code + 64
let drive = (floor(trial / 1) - 2*floor(trial / 2))*1.8
alter VB0 = $&drive
let drive = (floor(trial / 2) - 2*floor(trial / 4))*1.8
alter VB1 = $&drive
let drive = (floor(trial / 4) - 2*floor(trial / 8))*1.8
alter VB2 = $&drive
let drive = (floor(trial / 8) - 2*floor(trial / 16))*1.8
alter VB3 = $&drive
let drive = (floor(trial / 16) - 2*floor(trial / 32))*1.8
alter VB4 = $&drive
let drive = (floor(trial / 32) - 2*floor(trial / 64))*1.8
alter VB5 = $&drive
let drive = (floor(trial / 64) - 2*floor(trial / 128))*1.8
alter VB6 = $&drive
let drive = (floor(trial / 128) - 2*floor(trial / 256))*1.8
alter VB7 = $&drive
stop when time = 0.003102
resume
delete all
let endpoint = length(time)-1
let cmp = v(COMP)[endpoint]
let top = v(TOP)[endpoint]
let decision = 0
if cmp >= 0.9
let code = trial
let decision = 1
end
echo 172 6 $&trial $&cmp $&top 0.79453125 $&decision >> decisions.csv
let trial = code + 32
let drive = (floor(trial / 1) - 2*floor(trial / 2))*1.8
alter VB0 = $&drive
let drive = (floor(trial / 2) - 2*floor(trial / 4))*1.8
alter VB1 = $&drive
let drive = (floor(trial / 4) - 2*floor(trial / 8))*1.8
alter VB2 = $&drive
let drive = (floor(trial / 8) - 2*floor(trial / 16))*1.8
alter VB3 = $&drive
let drive = (floor(trial / 16) - 2*floor(trial / 32))*1.8
alter VB4 = $&drive
let drive = (floor(trial / 32) - 2*floor(trial / 64))*1.8
alter VB5 = $&drive
let drive = (floor(trial / 64) - 2*floor(trial / 128))*1.8
alter VB6 = $&drive
let drive = (floor(trial / 128) - 2*floor(trial / 256))*1.8
alter VB7 = $&drive
stop when time = 0.003104
resume
delete all
let endpoint = length(time)-1
let cmp = v(COMP)[endpoint]
let top = v(TOP)[endpoint]
let decision = 0
if cmp >= 0.9
let code = trial
let decision = 1
end
echo 172 5 $&trial $&cmp $&top 0.79453125 $&decision >> decisions.csv
let trial = code + 16
let drive = (floor(trial / 1) - 2*floor(trial / 2))*1.8
alter VB0 = $&drive
let drive = (floor(trial / 2) - 2*floor(trial / 4))*1.8
alter VB1 = $&drive
let drive = (floor(trial / 4) - 2*floor(trial / 8))*1.8
alter VB2 = $&drive
let drive = (floor(trial / 8) - 2*floor(trial / 16))*1.8
alter VB3 = $&drive
let drive = (floor(trial / 16) - 2*floor(trial / 32))*1.8
alter VB4 = $&drive
let drive = (floor(trial / 32) - 2*floor(trial / 64))*1.8
alter VB5 = $&drive
let drive = (floor(trial / 64) - 2*floor(trial / 128))*1.8
alter VB6 = $&drive
let drive = (floor(trial / 128) - 2*floor(trial / 256))*1.8
alter VB7 = $&drive
stop when time = 0.003106
resume
delete all
let endpoint = length(time)-1
let cmp = v(COMP)[endpoint]
let top = v(TOP)[endpoint]
let decision = 0
if cmp >= 0.9
let code = trial
let decision = 1
end
echo 172 4 $&trial $&cmp $&top 0.79453125 $&decision >> decisions.csv
let trial = code + 8
let drive = (floor(trial / 1) - 2*floor(trial / 2))*1.8
alter VB0 = $&drive
let drive = (floor(trial / 2) - 2*floor(trial / 4))*1.8
alter VB1 = $&drive
let drive = (floor(trial / 4) - 2*floor(trial / 8))*1.8
alter VB2 = $&drive
let drive = (floor(trial / 8) - 2*floor(trial / 16))*1.8
alter VB3 = $&drive
let drive = (floor(trial / 16) - 2*floor(trial / 32))*1.8
alter VB4 = $&drive
let drive = (floor(trial / 32) - 2*floor(trial / 64))*1.8
alter VB5 = $&drive
let drive = (floor(trial / 64) - 2*floor(trial / 128))*1.8
alter VB6 = $&drive
let drive = (floor(trial / 128) - 2*floor(trial / 256))*1.8
alter VB7 = $&drive
stop when time = 0.003108
resume
delete all
let endpoint = length(time)-1
let cmp = v(COMP)[endpoint]
let top = v(TOP)[endpoint]
let decision = 0
if cmp >= 0.9
let code = trial
let decision = 1
end
echo 172 3 $&trial $&cmp $&top 0.79453125 $&decision >> decisions.csv
let trial = code + 4
let drive = (floor(trial / 1) - 2*floor(trial / 2))*1.8
alter VB0 = $&drive
let drive = (floor(trial / 2) - 2*floor(trial / 4))*1.8
alter VB1 = $&drive
let drive = (floor(trial / 4) - 2*floor(trial / 8))*1.8
alter VB2 = $&drive
let drive = (floor(trial / 8) - 2*floor(trial / 16))*1.8
alter VB3 = $&drive
let drive = (floor(trial / 16) - 2*floor(trial / 32))*1.8
alter VB4 = $&drive
let drive = (floor(trial / 32) - 2*floor(trial / 64))*1.8
alter VB5 = $&drive
let drive = (floor(trial / 64) - 2*floor(trial / 128))*1.8
alter VB6 = $&drive
let drive = (floor(trial / 128) - 2*floor(trial / 256))*1.8
alter VB7 = $&drive
stop when time = 0.00311
resume
delete all
let endpoint = length(time)-1
let cmp = v(COMP)[endpoint]
let top = v(TOP)[endpoint]
let decision = 0
if cmp >= 0.9
let code = trial
let decision = 1
end
echo 172 2 $&trial $&cmp $&top 0.79453125 $&decision >> decisions.csv
let trial = code + 2
let drive = (floor(trial / 1) - 2*floor(trial / 2))*1.8
alter VB0 = $&drive
let drive = (floor(trial / 2) - 2*floor(trial / 4))*1.8
alter VB1 = $&drive
let drive = (floor(trial / 4) - 2*floor(trial / 8))*1.8
alter VB2 = $&drive
let drive = (floor(trial / 8) - 2*floor(trial / 16))*1.8
alter VB3 = $&drive
let drive = (floor(trial / 16) - 2*floor(trial / 32))*1.8
alter VB4 = $&drive
let drive = (floor(trial / 32) - 2*floor(trial / 64))*1.8
alter VB5 = $&drive
let drive = (floor(trial / 64) - 2*floor(trial / 128))*1.8
alter VB6 = $&drive
let drive = (floor(trial / 128) - 2*floor(trial / 256))*1.8
alter VB7 = $&drive
stop when time = 0.003112
resume
delete all
let endpoint = length(time)-1
let cmp = v(COMP)[endpoint]
let top = v(TOP)[endpoint]
let decision = 0
if cmp >= 0.9
let code = trial
let decision = 1
end
echo 172 1 $&trial $&cmp $&top 0.79453125 $&decision >> decisions.csv
let trial = code + 1
let drive = (floor(trial / 1) - 2*floor(trial / 2))*1.8
alter VB0 = $&drive
let drive = (floor(trial / 2) - 2*floor(trial / 4))*1.8
alter VB1 = $&drive
let drive = (floor(trial / 4) - 2*floor(trial / 8))*1.8
alter VB2 = $&drive
let drive = (floor(trial / 8) - 2*floor(trial / 16))*1.8
alter VB3 = $&drive
let drive = (floor(trial / 16) - 2*floor(trial / 32))*1.8
alter VB4 = $&drive
let drive = (floor(trial / 32) - 2*floor(trial / 64))*1.8
alter VB5 = $&drive
let drive = (floor(trial / 64) - 2*floor(trial / 128))*1.8
alter VB6 = $&drive
let drive = (floor(trial / 128) - 2*floor(trial / 256))*1.8
alter VB7 = $&drive
stop when time = 0.003114
resume
delete all
let endpoint = length(time)-1
let cmp = v(COMP)[endpoint]
let top = v(TOP)[endpoint]
let decision = 0
if cmp >= 0.9
let code = trial
let decision = 1
end
echo 172 0 $&trial $&cmp $&top 0.79453125 $&decision >> decisions.csv
alter VIN = 0.79921875
alter VSAMPLE = 1.8
alter VB0 = 0
alter VB1 = 0
alter VB2 = 0
alter VB3 = 0
alter VB4 = 0
alter VB5 = 0
alter VB6 = 0
alter VB7 = 0
let code = 0
stop when time = 0.003116
resume
delete all
alter VSAMPLE = 0
let trial = code + 128
let drive = (floor(trial / 1) - 2*floor(trial / 2))*1.8
alter VB0 = $&drive
let drive = (floor(trial / 2) - 2*floor(trial / 4))*1.8
alter VB1 = $&drive
let drive = (floor(trial / 4) - 2*floor(trial / 8))*1.8
alter VB2 = $&drive
let drive = (floor(trial / 8) - 2*floor(trial / 16))*1.8
alter VB3 = $&drive
let drive = (floor(trial / 16) - 2*floor(trial / 32))*1.8
alter VB4 = $&drive
let drive = (floor(trial / 32) - 2*floor(trial / 64))*1.8
alter VB5 = $&drive
let drive = (floor(trial / 64) - 2*floor(trial / 128))*1.8
alter VB6 = $&drive
let drive = (floor(trial / 128) - 2*floor(trial / 256))*1.8
alter VB7 = $&drive
stop when time = 0.003118
resume
delete all
let endpoint = length(time)-1
let cmp = v(COMP)[endpoint]
let top = v(TOP)[endpoint]
let decision = 0
if cmp >= 0.9
let code = trial
let decision = 1
end
echo 173 7 $&trial $&cmp $&top 0.79921875 $&decision >> decisions.csv
let trial = code + 64
let drive = (floor(trial / 1) - 2*floor(trial / 2))*1.8
alter VB0 = $&drive
let drive = (floor(trial / 2) - 2*floor(trial / 4))*1.8
alter VB1 = $&drive
let drive = (floor(trial / 4) - 2*floor(trial / 8))*1.8
alter VB2 = $&drive
let drive = (floor(trial / 8) - 2*floor(trial / 16))*1.8
alter VB3 = $&drive
let drive = (floor(trial / 16) - 2*floor(trial / 32))*1.8
alter VB4 = $&drive
let drive = (floor(trial / 32) - 2*floor(trial / 64))*1.8
alter VB5 = $&drive
let drive = (floor(trial / 64) - 2*floor(trial / 128))*1.8
alter VB6 = $&drive
let drive = (floor(trial / 128) - 2*floor(trial / 256))*1.8
alter VB7 = $&drive
stop when time = 0.00312
resume
delete all
let endpoint = length(time)-1
let cmp = v(COMP)[endpoint]
let top = v(TOP)[endpoint]
let decision = 0
if cmp >= 0.9
let code = trial
let decision = 1
end
echo 173 6 $&trial $&cmp $&top 0.79921875 $&decision >> decisions.csv
let trial = code + 32
let drive = (floor(trial / 1) - 2*floor(trial / 2))*1.8
alter VB0 = $&drive
let drive = (floor(trial / 2) - 2*floor(trial / 4))*1.8
alter VB1 = $&drive
let drive = (floor(trial / 4) - 2*floor(trial / 8))*1.8
alter VB2 = $&drive
let drive = (floor(trial / 8) - 2*floor(trial / 16))*1.8
alter VB3 = $&drive
let drive = (floor(trial / 16) - 2*floor(trial / 32))*1.8
alter VB4 = $&drive
let drive = (floor(trial / 32) - 2*floor(trial / 64))*1.8
alter VB5 = $&drive
let drive = (floor(trial / 64) - 2*floor(trial / 128))*1.8
alter VB6 = $&drive
let drive = (floor(trial / 128) - 2*floor(trial / 256))*1.8
alter VB7 = $&drive
stop when time = 0.003122
resume
delete all
let endpoint = length(time)-1
let cmp = v(COMP)[endpoint]
let top = v(TOP)[endpoint]
let decision = 0
if cmp >= 0.9
let code = trial
let decision = 1
end
echo 173 5 $&trial $&cmp $&top 0.79921875 $&decision >> decisions.csv
let trial = code + 16
let drive = (floor(trial / 1) - 2*floor(trial / 2))*1.8
alter VB0 = $&drive
let drive = (floor(trial / 2) - 2*floor(trial / 4))*1.8
alter VB1 = $&drive
let drive = (floor(trial / 4) - 2*floor(trial / 8))*1.8
alter VB2 = $&drive
let drive = (floor(trial / 8) - 2*floor(trial / 16))*1.8
alter VB3 = $&drive
let drive = (floor(trial / 16) - 2*floor(trial / 32))*1.8
alter VB4 = $&drive
let drive = (floor(trial / 32) - 2*floor(trial / 64))*1.8
alter VB5 = $&drive
let drive = (floor(trial / 64) - 2*floor(trial / 128))*1.8
alter VB6 = $&drive
let drive = (floor(trial / 128) - 2*floor(trial / 256))*1.8
alter VB7 = $&drive
stop when time = 0.003124
resume
delete all
let endpoint = length(time)-1
let cmp = v(COMP)[endpoint]
let top = v(TOP)[endpoint]
let decision = 0
if cmp >= 0.9
let code = trial
let decision = 1
end
echo 173 4 $&trial $&cmp $&top 0.79921875 $&decision >> decisions.csv
let trial = code + 8
let drive = (floor(trial / 1) - 2*floor(trial / 2))*1.8
alter VB0 = $&drive
let drive = (floor(trial / 2) - 2*floor(trial / 4))*1.8
alter VB1 = $&drive
let drive = (floor(trial / 4) - 2*floor(trial / 8))*1.8
alter VB2 = $&drive
let drive = (floor(trial / 8) - 2*floor(trial / 16))*1.8
alter VB3 = $&drive
let drive = (floor(trial / 16) - 2*floor(trial / 32))*1.8
alter VB4 = $&drive
let drive = (floor(trial / 32) - 2*floor(trial / 64))*1.8
alter VB5 = $&drive
let drive = (floor(trial / 64) - 2*floor(trial / 128))*1.8
alter VB6 = $&drive
let drive = (floor(trial / 128) - 2*floor(trial / 256))*1.8
alter VB7 = $&drive
stop when time = 0.003126
resume
delete all
let endpoint = length(time)-1
let cmp = v(COMP)[endpoint]
let top = v(TOP)[endpoint]
let decision = 0
if cmp >= 0.9
let code = trial
let decision = 1
end
echo 173 3 $&trial $&cmp $&top 0.79921875 $&decision >> decisions.csv
let trial = code + 4
let drive = (floor(trial / 1) - 2*floor(trial / 2))*1.8
alter VB0 = $&drive
let drive = (floor(trial / 2) - 2*floor(trial / 4))*1.8
alter VB1 = $&drive
let drive = (floor(trial / 4) - 2*floor(trial / 8))*1.8
alter VB2 = $&drive
let drive = (floor(trial / 8) - 2*floor(trial / 16))*1.8
alter VB3 = $&drive
let drive = (floor(trial / 16) - 2*floor(trial / 32))*1.8
alter VB4 = $&drive
let drive = (floor(trial / 32) - 2*floor(trial / 64))*1.8
alter VB5 = $&drive
let drive = (floor(trial / 64) - 2*floor(trial / 128))*1.8
alter VB6 = $&drive
let drive = (floor(trial / 128) - 2*floor(trial / 256))*1.8
alter VB7 = $&drive
stop when time = 0.003128
resume
delete all
let endpoint = length(time)-1
let cmp = v(COMP)[endpoint]
let top = v(TOP)[endpoint]
let decision = 0
if cmp >= 0.9
let code = trial
let decision = 1
end
echo 173 2 $&trial $&cmp $&top 0.79921875 $&decision >> decisions.csv
let trial = code + 2
let drive = (floor(trial / 1) - 2*floor(trial / 2))*1.8
alter VB0 = $&drive
let drive = (floor(trial / 2) - 2*floor(trial / 4))*1.8
alter VB1 = $&drive
let drive = (floor(trial / 4) - 2*floor(trial / 8))*1.8
alter VB2 = $&drive
let drive = (floor(trial / 8) - 2*floor(trial / 16))*1.8
alter VB3 = $&drive
let drive = (floor(trial / 16) - 2*floor(trial / 32))*1.8
alter VB4 = $&drive
let drive = (floor(trial / 32) - 2*floor(trial / 64))*1.8
alter VB5 = $&drive
let drive = (floor(trial / 64) - 2*floor(trial / 128))*1.8
alter VB6 = $&drive
let drive = (floor(trial / 128) - 2*floor(trial / 256))*1.8
alter VB7 = $&drive
stop when time = 0.00313
resume
delete all
let endpoint = length(time)-1
let cmp = v(COMP)[endpoint]
let top = v(TOP)[endpoint]
let decision = 0
if cmp >= 0.9
let code = trial
let decision = 1
end
echo 173 1 $&trial $&cmp $&top 0.79921875 $&decision >> decisions.csv
let trial = code + 1
let drive = (floor(trial / 1) - 2*floor(trial / 2))*1.8
alter VB0 = $&drive
let drive = (floor(trial / 2) - 2*floor(trial / 4))*1.8
alter VB1 = $&drive
let drive = (floor(trial / 4) - 2*floor(trial / 8))*1.8
alter VB2 = $&drive
let drive = (floor(trial / 8) - 2*floor(trial / 16))*1.8
alter VB3 = $&drive
let drive = (floor(trial / 16) - 2*floor(trial / 32))*1.8
alter VB4 = $&drive
let drive = (floor(trial / 32) - 2*floor(trial / 64))*1.8
alter VB5 = $&drive
let drive = (floor(trial / 64) - 2*floor(trial / 128))*1.8
alter VB6 = $&drive
let drive = (floor(trial / 128) - 2*floor(trial / 256))*1.8
alter VB7 = $&drive
stop when time = 0.003132
resume
delete all
let endpoint = length(time)-1
let cmp = v(COMP)[endpoint]
let top = v(TOP)[endpoint]
let decision = 0
if cmp >= 0.9
let code = trial
let decision = 1
end
echo 173 0 $&trial $&cmp $&top 0.79921875 $&decision >> decisions.csv
alter VIN = 0.80390625
alter VSAMPLE = 1.8
alter VB0 = 0
alter VB1 = 0
alter VB2 = 0
alter VB3 = 0
alter VB4 = 0
alter VB5 = 0
alter VB6 = 0
alter VB7 = 0
let code = 0
stop when time = 0.003134
resume
delete all
alter VSAMPLE = 0
let trial = code + 128
let drive = (floor(trial / 1) - 2*floor(trial / 2))*1.8
alter VB0 = $&drive
let drive = (floor(trial / 2) - 2*floor(trial / 4))*1.8
alter VB1 = $&drive
let drive = (floor(trial / 4) - 2*floor(trial / 8))*1.8
alter VB2 = $&drive
let drive = (floor(trial / 8) - 2*floor(trial / 16))*1.8
alter VB3 = $&drive
let drive = (floor(trial / 16) - 2*floor(trial / 32))*1.8
alter VB4 = $&drive
let drive = (floor(trial / 32) - 2*floor(trial / 64))*1.8
alter VB5 = $&drive
let drive = (floor(trial / 64) - 2*floor(trial / 128))*1.8
alter VB6 = $&drive
let drive = (floor(trial / 128) - 2*floor(trial / 256))*1.8
alter VB7 = $&drive
stop when time = 0.003136
resume
delete all
let endpoint = length(time)-1
let cmp = v(COMP)[endpoint]
let top = v(TOP)[endpoint]
let decision = 0
if cmp >= 0.9
let code = trial
let decision = 1
end
echo 174 7 $&trial $&cmp $&top 0.80390625 $&decision >> decisions.csv
let trial = code + 64
let drive = (floor(trial / 1) - 2*floor(trial / 2))*1.8
alter VB0 = $&drive
let drive = (floor(trial / 2) - 2*floor(trial / 4))*1.8
alter VB1 = $&drive
let drive = (floor(trial / 4) - 2*floor(trial / 8))*1.8
alter VB2 = $&drive
let drive = (floor(trial / 8) - 2*floor(trial / 16))*1.8
alter VB3 = $&drive
let drive = (floor(trial / 16) - 2*floor(trial / 32))*1.8
alter VB4 = $&drive
let drive = (floor(trial / 32) - 2*floor(trial / 64))*1.8
alter VB5 = $&drive
let drive = (floor(trial / 64) - 2*floor(trial / 128))*1.8
alter VB6 = $&drive
let drive = (floor(trial / 128) - 2*floor(trial / 256))*1.8
alter VB7 = $&drive
stop when time = 0.003138
resume
delete all
let endpoint = length(time)-1
let cmp = v(COMP)[endpoint]
let top = v(TOP)[endpoint]
let decision = 0
if cmp >= 0.9
let code = trial
let decision = 1
end
echo 174 6 $&trial $&cmp $&top 0.80390625 $&decision >> decisions.csv
let trial = code + 32
let drive = (floor(trial / 1) - 2*floor(trial / 2))*1.8
alter VB0 = $&drive
let drive = (floor(trial / 2) - 2*floor(trial / 4))*1.8
alter VB1 = $&drive
let drive = (floor(trial / 4) - 2*floor(trial / 8))*1.8
alter VB2 = $&drive
let drive = (floor(trial / 8) - 2*floor(trial / 16))*1.8
alter VB3 = $&drive
let drive = (floor(trial / 16) - 2*floor(trial / 32))*1.8
alter VB4 = $&drive
let drive = (floor(trial / 32) - 2*floor(trial / 64))*1.8
alter VB5 = $&drive
let drive = (floor(trial / 64) - 2*floor(trial / 128))*1.8
alter VB6 = $&drive
let drive = (floor(trial / 128) - 2*floor(trial / 256))*1.8
alter VB7 = $&drive
stop when time = 0.00314
resume
delete all
let endpoint = length(time)-1
let cmp = v(COMP)[endpoint]
let top = v(TOP)[endpoint]
let decision = 0
if cmp >= 0.9
let code = trial
let decision = 1
end
echo 174 5 $&trial $&cmp $&top 0.80390625 $&decision >> decisions.csv
let trial = code + 16
let drive = (floor(trial / 1) - 2*floor(trial / 2))*1.8
alter VB0 = $&drive
let drive = (floor(trial / 2) - 2*floor(trial / 4))*1.8
alter VB1 = $&drive
let drive = (floor(trial / 4) - 2*floor(trial / 8))*1.8
alter VB2 = $&drive
let drive = (floor(trial / 8) - 2*floor(trial / 16))*1.8
alter VB3 = $&drive
let drive = (floor(trial / 16) - 2*floor(trial / 32))*1.8
alter VB4 = $&drive
let drive = (floor(trial / 32) - 2*floor(trial / 64))*1.8
alter VB5 = $&drive
let drive = (floor(trial / 64) - 2*floor(trial / 128))*1.8
alter VB6 = $&drive
let drive = (floor(trial / 128) - 2*floor(trial / 256))*1.8
alter VB7 = $&drive
stop when time = 0.003142
resume
delete all
let endpoint = length(time)-1
let cmp = v(COMP)[endpoint]
let top = v(TOP)[endpoint]
let decision = 0
if cmp >= 0.9
let code = trial
let decision = 1
end
echo 174 4 $&trial $&cmp $&top 0.80390625 $&decision >> decisions.csv
let trial = code + 8
let drive = (floor(trial / 1) - 2*floor(trial / 2))*1.8
alter VB0 = $&drive
let drive = (floor(trial / 2) - 2*floor(trial / 4))*1.8
alter VB1 = $&drive
let drive = (floor(trial / 4) - 2*floor(trial / 8))*1.8
alter VB2 = $&drive
let drive = (floor(trial / 8) - 2*floor(trial / 16))*1.8
alter VB3 = $&drive
let drive = (floor(trial / 16) - 2*floor(trial / 32))*1.8
alter VB4 = $&drive
let drive = (floor(trial / 32) - 2*floor(trial / 64))*1.8
alter VB5 = $&drive
let drive = (floor(trial / 64) - 2*floor(trial / 128))*1.8
alter VB6 = $&drive
let drive = (floor(trial / 128) - 2*floor(trial / 256))*1.8
alter VB7 = $&drive
stop when time = 0.003144
resume
delete all
let endpoint = length(time)-1
let cmp = v(COMP)[endpoint]
let top = v(TOP)[endpoint]
let decision = 0
if cmp >= 0.9
let code = trial
let decision = 1
end
echo 174 3 $&trial $&cmp $&top 0.80390625 $&decision >> decisions.csv
let trial = code + 4
let drive = (floor(trial / 1) - 2*floor(trial / 2))*1.8
alter VB0 = $&drive
let drive = (floor(trial / 2) - 2*floor(trial / 4))*1.8
alter VB1 = $&drive
let drive = (floor(trial / 4) - 2*floor(trial / 8))*1.8
alter VB2 = $&drive
let drive = (floor(trial / 8) - 2*floor(trial / 16))*1.8
alter VB3 = $&drive
let drive = (floor(trial / 16) - 2*floor(trial / 32))*1.8
alter VB4 = $&drive
let drive = (floor(trial / 32) - 2*floor(trial / 64))*1.8
alter VB5 = $&drive
let drive = (floor(trial / 64) - 2*floor(trial / 128))*1.8
alter VB6 = $&drive
let drive = (floor(trial / 128) - 2*floor(trial / 256))*1.8
alter VB7 = $&drive
stop when time = 0.003146
resume
delete all
let endpoint = length(time)-1
let cmp = v(COMP)[endpoint]
let top = v(TOP)[endpoint]
let decision = 0
if cmp >= 0.9
let code = trial
let decision = 1
end
echo 174 2 $&trial $&cmp $&top 0.80390625 $&decision >> decisions.csv
let trial = code + 2
let drive = (floor(trial / 1) - 2*floor(trial / 2))*1.8
alter VB0 = $&drive
let drive = (floor(trial / 2) - 2*floor(trial / 4))*1.8
alter VB1 = $&drive
let drive = (floor(trial / 4) - 2*floor(trial / 8))*1.8
alter VB2 = $&drive
let drive = (floor(trial / 8) - 2*floor(trial / 16))*1.8
alter VB3 = $&drive
let drive = (floor(trial / 16) - 2*floor(trial / 32))*1.8
alter VB4 = $&drive
let drive = (floor(trial / 32) - 2*floor(trial / 64))*1.8
alter VB5 = $&drive
let drive = (floor(trial / 64) - 2*floor(trial / 128))*1.8
alter VB6 = $&drive
let drive = (floor(trial / 128) - 2*floor(trial / 256))*1.8
alter VB7 = $&drive
stop when time = 0.003148
resume
delete all
let endpoint = length(time)-1
let cmp = v(COMP)[endpoint]
let top = v(TOP)[endpoint]
let decision = 0
if cmp >= 0.9
let code = trial
let decision = 1
end
echo 174 1 $&trial $&cmp $&top 0.80390625 $&decision >> decisions.csv
let trial = code + 1
let drive = (floor(trial / 1) - 2*floor(trial / 2))*1.8
alter VB0 = $&drive
let drive = (floor(trial / 2) - 2*floor(trial / 4))*1.8
alter VB1 = $&drive
let drive = (floor(trial / 4) - 2*floor(trial / 8))*1.8
alter VB2 = $&drive
let drive = (floor(trial / 8) - 2*floor(trial / 16))*1.8
alter VB3 = $&drive
let drive = (floor(trial / 16) - 2*floor(trial / 32))*1.8
alter VB4 = $&drive
let drive = (floor(trial / 32) - 2*floor(trial / 64))*1.8
alter VB5 = $&drive
let drive = (floor(trial / 64) - 2*floor(trial / 128))*1.8
alter VB6 = $&drive
let drive = (floor(trial / 128) - 2*floor(trial / 256))*1.8
alter VB7 = $&drive
stop when time = 0.00315
resume
delete all
let endpoint = length(time)-1
let cmp = v(COMP)[endpoint]
let top = v(TOP)[endpoint]
let decision = 0
if cmp >= 0.9
let code = trial
let decision = 1
end
echo 174 0 $&trial $&cmp $&top 0.80390625 $&decision >> decisions.csv
alter VIN = 0.80859375
alter VSAMPLE = 1.8
alter VB0 = 0
alter VB1 = 0
alter VB2 = 0
alter VB3 = 0
alter VB4 = 0
alter VB5 = 0
alter VB6 = 0
alter VB7 = 0
let code = 0
stop when time = 0.003152
resume
delete all
alter VSAMPLE = 0
let trial = code + 128
let drive = (floor(trial / 1) - 2*floor(trial / 2))*1.8
alter VB0 = $&drive
let drive = (floor(trial / 2) - 2*floor(trial / 4))*1.8
alter VB1 = $&drive
let drive = (floor(trial / 4) - 2*floor(trial / 8))*1.8
alter VB2 = $&drive
let drive = (floor(trial / 8) - 2*floor(trial / 16))*1.8
alter VB3 = $&drive
let drive = (floor(trial / 16) - 2*floor(trial / 32))*1.8
alter VB4 = $&drive
let drive = (floor(trial / 32) - 2*floor(trial / 64))*1.8
alter VB5 = $&drive
let drive = (floor(trial / 64) - 2*floor(trial / 128))*1.8
alter VB6 = $&drive
let drive = (floor(trial / 128) - 2*floor(trial / 256))*1.8
alter VB7 = $&drive
stop when time = 0.003154
resume
delete all
let endpoint = length(time)-1
let cmp = v(COMP)[endpoint]
let top = v(TOP)[endpoint]
let decision = 0
if cmp >= 0.9
let code = trial
let decision = 1
end
echo 175 7 $&trial $&cmp $&top 0.80859375 $&decision >> decisions.csv
let trial = code + 64
let drive = (floor(trial / 1) - 2*floor(trial / 2))*1.8
alter VB0 = $&drive
let drive = (floor(trial / 2) - 2*floor(trial / 4))*1.8
alter VB1 = $&drive
let drive = (floor(trial / 4) - 2*floor(trial / 8))*1.8
alter VB2 = $&drive
let drive = (floor(trial / 8) - 2*floor(trial / 16))*1.8
alter VB3 = $&drive
let drive = (floor(trial / 16) - 2*floor(trial / 32))*1.8
alter VB4 = $&drive
let drive = (floor(trial / 32) - 2*floor(trial / 64))*1.8
alter VB5 = $&drive
let drive = (floor(trial / 64) - 2*floor(trial / 128))*1.8
alter VB6 = $&drive
let drive = (floor(trial / 128) - 2*floor(trial / 256))*1.8
alter VB7 = $&drive
stop when time = 0.003156
resume
delete all
let endpoint = length(time)-1
let cmp = v(COMP)[endpoint]
let top = v(TOP)[endpoint]
let decision = 0
if cmp >= 0.9
let code = trial
let decision = 1
end
echo 175 6 $&trial $&cmp $&top 0.80859375 $&decision >> decisions.csv
let trial = code + 32
let drive = (floor(trial / 1) - 2*floor(trial / 2))*1.8
alter VB0 = $&drive
let drive = (floor(trial / 2) - 2*floor(trial / 4))*1.8
alter VB1 = $&drive
let drive = (floor(trial / 4) - 2*floor(trial / 8))*1.8
alter VB2 = $&drive
let drive = (floor(trial / 8) - 2*floor(trial / 16))*1.8
alter VB3 = $&drive
let drive = (floor(trial / 16) - 2*floor(trial / 32))*1.8
alter VB4 = $&drive
let drive = (floor(trial / 32) - 2*floor(trial / 64))*1.8
alter VB5 = $&drive
let drive = (floor(trial / 64) - 2*floor(trial / 128))*1.8
alter VB6 = $&drive
let drive = (floor(trial / 128) - 2*floor(trial / 256))*1.8
alter VB7 = $&drive
stop when time = 0.003158
resume
delete all
let endpoint = length(time)-1
let cmp = v(COMP)[endpoint]
let top = v(TOP)[endpoint]
let decision = 0
if cmp >= 0.9
let code = trial
let decision = 1
end
echo 175 5 $&trial $&cmp $&top 0.80859375 $&decision >> decisions.csv
let trial = code + 16
let drive = (floor(trial / 1) - 2*floor(trial / 2))*1.8
alter VB0 = $&drive
let drive = (floor(trial / 2) - 2*floor(trial / 4))*1.8
alter VB1 = $&drive
let drive = (floor(trial / 4) - 2*floor(trial / 8))*1.8
alter VB2 = $&drive
let drive = (floor(trial / 8) - 2*floor(trial / 16))*1.8
alter VB3 = $&drive
let drive = (floor(trial / 16) - 2*floor(trial / 32))*1.8
alter VB4 = $&drive
let drive = (floor(trial / 32) - 2*floor(trial / 64))*1.8
alter VB5 = $&drive
let drive = (floor(trial / 64) - 2*floor(trial / 128))*1.8
alter VB6 = $&drive
let drive = (floor(trial / 128) - 2*floor(trial / 256))*1.8
alter VB7 = $&drive
stop when time = 0.00316
resume
delete all
let endpoint = length(time)-1
let cmp = v(COMP)[endpoint]
let top = v(TOP)[endpoint]
let decision = 0
if cmp >= 0.9
let code = trial
let decision = 1
end
echo 175 4 $&trial $&cmp $&top 0.80859375 $&decision >> decisions.csv
let trial = code + 8
let drive = (floor(trial / 1) - 2*floor(trial / 2))*1.8
alter VB0 = $&drive
let drive = (floor(trial / 2) - 2*floor(trial / 4))*1.8
alter VB1 = $&drive
let drive = (floor(trial / 4) - 2*floor(trial / 8))*1.8
alter VB2 = $&drive
let drive = (floor(trial / 8) - 2*floor(trial / 16))*1.8
alter VB3 = $&drive
let drive = (floor(trial / 16) - 2*floor(trial / 32))*1.8
alter VB4 = $&drive
let drive = (floor(trial / 32) - 2*floor(trial / 64))*1.8
alter VB5 = $&drive
let drive = (floor(trial / 64) - 2*floor(trial / 128))*1.8
alter VB6 = $&drive
let drive = (floor(trial / 128) - 2*floor(trial / 256))*1.8
alter VB7 = $&drive
stop when time = 0.003162
resume
delete all
let endpoint = length(time)-1
let cmp = v(COMP)[endpoint]
let top = v(TOP)[endpoint]
let decision = 0
if cmp >= 0.9
let code = trial
let decision = 1
end
echo 175 3 $&trial $&cmp $&top 0.80859375 $&decision >> decisions.csv
let trial = code + 4
let drive = (floor(trial / 1) - 2*floor(trial / 2))*1.8
alter VB0 = $&drive
let drive = (floor(trial / 2) - 2*floor(trial / 4))*1.8
alter VB1 = $&drive
let drive = (floor(trial / 4) - 2*floor(trial / 8))*1.8
alter VB2 = $&drive
let drive = (floor(trial / 8) - 2*floor(trial / 16))*1.8
alter VB3 = $&drive
let drive = (floor(trial / 16) - 2*floor(trial / 32))*1.8
alter VB4 = $&drive
let drive = (floor(trial / 32) - 2*floor(trial / 64))*1.8
alter VB5 = $&drive
let drive = (floor(trial / 64) - 2*floor(trial / 128))*1.8
alter VB6 = $&drive
let drive = (floor(trial / 128) - 2*floor(trial / 256))*1.8
alter VB7 = $&drive
stop when time = 0.003164
resume
delete all
let endpoint = length(time)-1
let cmp = v(COMP)[endpoint]
let top = v(TOP)[endpoint]
let decision = 0
if cmp >= 0.9
let code = trial
let decision = 1
end
echo 175 2 $&trial $&cmp $&top 0.80859375 $&decision >> decisions.csv
let trial = code + 2
let drive = (floor(trial / 1) - 2*floor(trial / 2))*1.8
alter VB0 = $&drive
let drive = (floor(trial / 2) - 2*floor(trial / 4))*1.8
alter VB1 = $&drive
let drive = (floor(trial / 4) - 2*floor(trial / 8))*1.8
alter VB2 = $&drive
let drive = (floor(trial / 8) - 2*floor(trial / 16))*1.8
alter VB3 = $&drive
let drive = (floor(trial / 16) - 2*floor(trial / 32))*1.8
alter VB4 = $&drive
let drive = (floor(trial / 32) - 2*floor(trial / 64))*1.8
alter VB5 = $&drive
let drive = (floor(trial / 64) - 2*floor(trial / 128))*1.8
alter VB6 = $&drive
let drive = (floor(trial / 128) - 2*floor(trial / 256))*1.8
alter VB7 = $&drive
stop when time = 0.003166
resume
delete all
let endpoint = length(time)-1
let cmp = v(COMP)[endpoint]
let top = v(TOP)[endpoint]
let decision = 0
if cmp >= 0.9
let code = trial
let decision = 1
end
echo 175 1 $&trial $&cmp $&top 0.80859375 $&decision >> decisions.csv
let trial = code + 1
let drive = (floor(trial / 1) - 2*floor(trial / 2))*1.8
alter VB0 = $&drive
let drive = (floor(trial / 2) - 2*floor(trial / 4))*1.8
alter VB1 = $&drive
let drive = (floor(trial / 4) - 2*floor(trial / 8))*1.8
alter VB2 = $&drive
let drive = (floor(trial / 8) - 2*floor(trial / 16))*1.8
alter VB3 = $&drive
let drive = (floor(trial / 16) - 2*floor(trial / 32))*1.8
alter VB4 = $&drive
let drive = (floor(trial / 32) - 2*floor(trial / 64))*1.8
alter VB5 = $&drive
let drive = (floor(trial / 64) - 2*floor(trial / 128))*1.8
alter VB6 = $&drive
let drive = (floor(trial / 128) - 2*floor(trial / 256))*1.8
alter VB7 = $&drive
stop when time = 0.003168
resume
delete all
let endpoint = length(time)-1
let cmp = v(COMP)[endpoint]
let top = v(TOP)[endpoint]
let decision = 0
if cmp >= 0.9
let code = trial
let decision = 1
end
echo 175 0 $&trial $&cmp $&top 0.80859375 $&decision >> decisions.csv
alter VIN = 0.81328125
alter VSAMPLE = 1.8
alter VB0 = 0
alter VB1 = 0
alter VB2 = 0
alter VB3 = 0
alter VB4 = 0
alter VB5 = 0
alter VB6 = 0
alter VB7 = 0
let code = 0
stop when time = 0.00317
resume
delete all
alter VSAMPLE = 0
let trial = code + 128
let drive = (floor(trial / 1) - 2*floor(trial / 2))*1.8
alter VB0 = $&drive
let drive = (floor(trial / 2) - 2*floor(trial / 4))*1.8
alter VB1 = $&drive
let drive = (floor(trial / 4) - 2*floor(trial / 8))*1.8
alter VB2 = $&drive
let drive = (floor(trial / 8) - 2*floor(trial / 16))*1.8
alter VB3 = $&drive
let drive = (floor(trial / 16) - 2*floor(trial / 32))*1.8
alter VB4 = $&drive
let drive = (floor(trial / 32) - 2*floor(trial / 64))*1.8
alter VB5 = $&drive
let drive = (floor(trial / 64) - 2*floor(trial / 128))*1.8
alter VB6 = $&drive
let drive = (floor(trial / 128) - 2*floor(trial / 256))*1.8
alter VB7 = $&drive
stop when time = 0.003172
resume
delete all
let endpoint = length(time)-1
let cmp = v(COMP)[endpoint]
let top = v(TOP)[endpoint]
let decision = 0
if cmp >= 0.9
let code = trial
let decision = 1
end
echo 176 7 $&trial $&cmp $&top 0.81328125 $&decision >> decisions.csv
let trial = code + 64
let drive = (floor(trial / 1) - 2*floor(trial / 2))*1.8
alter VB0 = $&drive
let drive = (floor(trial / 2) - 2*floor(trial / 4))*1.8
alter VB1 = $&drive
let drive = (floor(trial / 4) - 2*floor(trial / 8))*1.8
alter VB2 = $&drive
let drive = (floor(trial / 8) - 2*floor(trial / 16))*1.8
alter VB3 = $&drive
let drive = (floor(trial / 16) - 2*floor(trial / 32))*1.8
alter VB4 = $&drive
let drive = (floor(trial / 32) - 2*floor(trial / 64))*1.8
alter VB5 = $&drive
let drive = (floor(trial / 64) - 2*floor(trial / 128))*1.8
alter VB6 = $&drive
let drive = (floor(trial / 128) - 2*floor(trial / 256))*1.8
alter VB7 = $&drive
stop when time = 0.003174
resume
delete all
let endpoint = length(time)-1
let cmp = v(COMP)[endpoint]
let top = v(TOP)[endpoint]
let decision = 0
if cmp >= 0.9
let code = trial
let decision = 1
end
echo 176 6 $&trial $&cmp $&top 0.81328125 $&decision >> decisions.csv
let trial = code + 32
let drive = (floor(trial / 1) - 2*floor(trial / 2))*1.8
alter VB0 = $&drive
let drive = (floor(trial / 2) - 2*floor(trial / 4))*1.8
alter VB1 = $&drive
let drive = (floor(trial / 4) - 2*floor(trial / 8))*1.8
alter VB2 = $&drive
let drive = (floor(trial / 8) - 2*floor(trial / 16))*1.8
alter VB3 = $&drive
let drive = (floor(trial / 16) - 2*floor(trial / 32))*1.8
alter VB4 = $&drive
let drive = (floor(trial / 32) - 2*floor(trial / 64))*1.8
alter VB5 = $&drive
let drive = (floor(trial / 64) - 2*floor(trial / 128))*1.8
alter VB6 = $&drive
let drive = (floor(trial / 128) - 2*floor(trial / 256))*1.8
alter VB7 = $&drive
stop when time = 0.003176
resume
delete all
let endpoint = length(time)-1
let cmp = v(COMP)[endpoint]
let top = v(TOP)[endpoint]
let decision = 0
if cmp >= 0.9
let code = trial
let decision = 1
end
echo 176 5 $&trial $&cmp $&top 0.81328125 $&decision >> decisions.csv
let trial = code + 16
let drive = (floor(trial / 1) - 2*floor(trial / 2))*1.8
alter VB0 = $&drive
let drive = (floor(trial / 2) - 2*floor(trial / 4))*1.8
alter VB1 = $&drive
let drive = (floor(trial / 4) - 2*floor(trial / 8))*1.8
alter VB2 = $&drive
let drive = (floor(trial / 8) - 2*floor(trial / 16))*1.8
alter VB3 = $&drive
let drive = (floor(trial / 16) - 2*floor(trial / 32))*1.8
alter VB4 = $&drive
let drive = (floor(trial / 32) - 2*floor(trial / 64))*1.8
alter VB5 = $&drive
let drive = (floor(trial / 64) - 2*floor(trial / 128))*1.8
alter VB6 = $&drive
let drive = (floor(trial / 128) - 2*floor(trial / 256))*1.8
alter VB7 = $&drive
stop when time = 0.003178
resume
delete all
let endpoint = length(time)-1
let cmp = v(COMP)[endpoint]
let top = v(TOP)[endpoint]
let decision = 0
if cmp >= 0.9
let code = trial
let decision = 1
end
echo 176 4 $&trial $&cmp $&top 0.81328125 $&decision >> decisions.csv
let trial = code + 8
let drive = (floor(trial / 1) - 2*floor(trial / 2))*1.8
alter VB0 = $&drive
let drive = (floor(trial / 2) - 2*floor(trial / 4))*1.8
alter VB1 = $&drive
let drive = (floor(trial / 4) - 2*floor(trial / 8))*1.8
alter VB2 = $&drive
let drive = (floor(trial / 8) - 2*floor(trial / 16))*1.8
alter VB3 = $&drive
let drive = (floor(trial / 16) - 2*floor(trial / 32))*1.8
alter VB4 = $&drive
let drive = (floor(trial / 32) - 2*floor(trial / 64))*1.8
alter VB5 = $&drive
let drive = (floor(trial / 64) - 2*floor(trial / 128))*1.8
alter VB6 = $&drive
let drive = (floor(trial / 128) - 2*floor(trial / 256))*1.8
alter VB7 = $&drive
stop when time = 0.00318
resume
delete all
let endpoint = length(time)-1
let cmp = v(COMP)[endpoint]
let top = v(TOP)[endpoint]
let decision = 0
if cmp >= 0.9
let code = trial
let decision = 1
end
echo 176 3 $&trial $&cmp $&top 0.81328125 $&decision >> decisions.csv
let trial = code + 4
let drive = (floor(trial / 1) - 2*floor(trial / 2))*1.8
alter VB0 = $&drive
let drive = (floor(trial / 2) - 2*floor(trial / 4))*1.8
alter VB1 = $&drive
let drive = (floor(trial / 4) - 2*floor(trial / 8))*1.8
alter VB2 = $&drive
let drive = (floor(trial / 8) - 2*floor(trial / 16))*1.8
alter VB3 = $&drive
let drive = (floor(trial / 16) - 2*floor(trial / 32))*1.8
alter VB4 = $&drive
let drive = (floor(trial / 32) - 2*floor(trial / 64))*1.8
alter VB5 = $&drive
let drive = (floor(trial / 64) - 2*floor(trial / 128))*1.8
alter VB6 = $&drive
let drive = (floor(trial / 128) - 2*floor(trial / 256))*1.8
alter VB7 = $&drive
stop when time = 0.003182
resume
delete all
let endpoint = length(time)-1
let cmp = v(COMP)[endpoint]
let top = v(TOP)[endpoint]
let decision = 0
if cmp >= 0.9
let code = trial
let decision = 1
end
echo 176 2 $&trial $&cmp $&top 0.81328125 $&decision >> decisions.csv
let trial = code + 2
let drive = (floor(trial / 1) - 2*floor(trial / 2))*1.8
alter VB0 = $&drive
let drive = (floor(trial / 2) - 2*floor(trial / 4))*1.8
alter VB1 = $&drive
let drive = (floor(trial / 4) - 2*floor(trial / 8))*1.8
alter VB2 = $&drive
let drive = (floor(trial / 8) - 2*floor(trial / 16))*1.8
alter VB3 = $&drive
let drive = (floor(trial / 16) - 2*floor(trial / 32))*1.8
alter VB4 = $&drive
let drive = (floor(trial / 32) - 2*floor(trial / 64))*1.8
alter VB5 = $&drive
let drive = (floor(trial / 64) - 2*floor(trial / 128))*1.8
alter VB6 = $&drive
let drive = (floor(trial / 128) - 2*floor(trial / 256))*1.8
alter VB7 = $&drive
stop when time = 0.003184
resume
delete all
let endpoint = length(time)-1
let cmp = v(COMP)[endpoint]
let top = v(TOP)[endpoint]
let decision = 0
if cmp >= 0.9
let code = trial
let decision = 1
end
echo 176 1 $&trial $&cmp $&top 0.81328125 $&decision >> decisions.csv
let trial = code + 1
let drive = (floor(trial / 1) - 2*floor(trial / 2))*1.8
alter VB0 = $&drive
let drive = (floor(trial / 2) - 2*floor(trial / 4))*1.8
alter VB1 = $&drive
let drive = (floor(trial / 4) - 2*floor(trial / 8))*1.8
alter VB2 = $&drive
let drive = (floor(trial / 8) - 2*floor(trial / 16))*1.8
alter VB3 = $&drive
let drive = (floor(trial / 16) - 2*floor(trial / 32))*1.8
alter VB4 = $&drive
let drive = (floor(trial / 32) - 2*floor(trial / 64))*1.8
alter VB5 = $&drive
let drive = (floor(trial / 64) - 2*floor(trial / 128))*1.8
alter VB6 = $&drive
let drive = (floor(trial / 128) - 2*floor(trial / 256))*1.8
alter VB7 = $&drive
stop when time = 0.003186
resume
delete all
let endpoint = length(time)-1
let cmp = v(COMP)[endpoint]
let top = v(TOP)[endpoint]
let decision = 0
if cmp >= 0.9
let code = trial
let decision = 1
end
echo 176 0 $&trial $&cmp $&top 0.81328125 $&decision >> decisions.csv
alter VIN = 0.81796875
alter VSAMPLE = 1.8
alter VB0 = 0
alter VB1 = 0
alter VB2 = 0
alter VB3 = 0
alter VB4 = 0
alter VB5 = 0
alter VB6 = 0
alter VB7 = 0
let code = 0
stop when time = 0.003188
resume
delete all
alter VSAMPLE = 0
let trial = code + 128
let drive = (floor(trial / 1) - 2*floor(trial / 2))*1.8
alter VB0 = $&drive
let drive = (floor(trial / 2) - 2*floor(trial / 4))*1.8
alter VB1 = $&drive
let drive = (floor(trial / 4) - 2*floor(trial / 8))*1.8
alter VB2 = $&drive
let drive = (floor(trial / 8) - 2*floor(trial / 16))*1.8
alter VB3 = $&drive
let drive = (floor(trial / 16) - 2*floor(trial / 32))*1.8
alter VB4 = $&drive
let drive = (floor(trial / 32) - 2*floor(trial / 64))*1.8
alter VB5 = $&drive
let drive = (floor(trial / 64) - 2*floor(trial / 128))*1.8
alter VB6 = $&drive
let drive = (floor(trial / 128) - 2*floor(trial / 256))*1.8
alter VB7 = $&drive
stop when time = 0.00319
resume
delete all
let endpoint = length(time)-1
let cmp = v(COMP)[endpoint]
let top = v(TOP)[endpoint]
let decision = 0
if cmp >= 0.9
let code = trial
let decision = 1
end
echo 177 7 $&trial $&cmp $&top 0.81796875 $&decision >> decisions.csv
let trial = code + 64
let drive = (floor(trial / 1) - 2*floor(trial / 2))*1.8
alter VB0 = $&drive
let drive = (floor(trial / 2) - 2*floor(trial / 4))*1.8
alter VB1 = $&drive
let drive = (floor(trial / 4) - 2*floor(trial / 8))*1.8
alter VB2 = $&drive
let drive = (floor(trial / 8) - 2*floor(trial / 16))*1.8
alter VB3 = $&drive
let drive = (floor(trial / 16) - 2*floor(trial / 32))*1.8
alter VB4 = $&drive
let drive = (floor(trial / 32) - 2*floor(trial / 64))*1.8
alter VB5 = $&drive
let drive = (floor(trial / 64) - 2*floor(trial / 128))*1.8
alter VB6 = $&drive
let drive = (floor(trial / 128) - 2*floor(trial / 256))*1.8
alter VB7 = $&drive
stop when time = 0.003192
resume
delete all
let endpoint = length(time)-1
let cmp = v(COMP)[endpoint]
let top = v(TOP)[endpoint]
let decision = 0
if cmp >= 0.9
let code = trial
let decision = 1
end
echo 177 6 $&trial $&cmp $&top 0.81796875 $&decision >> decisions.csv
let trial = code + 32
let drive = (floor(trial / 1) - 2*floor(trial / 2))*1.8
alter VB0 = $&drive
let drive = (floor(trial / 2) - 2*floor(trial / 4))*1.8
alter VB1 = $&drive
let drive = (floor(trial / 4) - 2*floor(trial / 8))*1.8
alter VB2 = $&drive
let drive = (floor(trial / 8) - 2*floor(trial / 16))*1.8
alter VB3 = $&drive
let drive = (floor(trial / 16) - 2*floor(trial / 32))*1.8
alter VB4 = $&drive
let drive = (floor(trial / 32) - 2*floor(trial / 64))*1.8
alter VB5 = $&drive
let drive = (floor(trial / 64) - 2*floor(trial / 128))*1.8
alter VB6 = $&drive
let drive = (floor(trial / 128) - 2*floor(trial / 256))*1.8
alter VB7 = $&drive
stop when time = 0.003194
resume
delete all
let endpoint = length(time)-1
let cmp = v(COMP)[endpoint]
let top = v(TOP)[endpoint]
let decision = 0
if cmp >= 0.9
let code = trial
let decision = 1
end
echo 177 5 $&trial $&cmp $&top 0.81796875 $&decision >> decisions.csv
let trial = code + 16
let drive = (floor(trial / 1) - 2*floor(trial / 2))*1.8
alter VB0 = $&drive
let drive = (floor(trial / 2) - 2*floor(trial / 4))*1.8
alter VB1 = $&drive
let drive = (floor(trial / 4) - 2*floor(trial / 8))*1.8
alter VB2 = $&drive
let drive = (floor(trial / 8) - 2*floor(trial / 16))*1.8
alter VB3 = $&drive
let drive = (floor(trial / 16) - 2*floor(trial / 32))*1.8
alter VB4 = $&drive
let drive = (floor(trial / 32) - 2*floor(trial / 64))*1.8
alter VB5 = $&drive
let drive = (floor(trial / 64) - 2*floor(trial / 128))*1.8
alter VB6 = $&drive
let drive = (floor(trial / 128) - 2*floor(trial / 256))*1.8
alter VB7 = $&drive
stop when time = 0.003196
resume
delete all
let endpoint = length(time)-1
let cmp = v(COMP)[endpoint]
let top = v(TOP)[endpoint]
let decision = 0
if cmp >= 0.9
let code = trial
let decision = 1
end
echo 177 4 $&trial $&cmp $&top 0.81796875 $&decision >> decisions.csv
let trial = code + 8
let drive = (floor(trial / 1) - 2*floor(trial / 2))*1.8
alter VB0 = $&drive
let drive = (floor(trial / 2) - 2*floor(trial / 4))*1.8
alter VB1 = $&drive
let drive = (floor(trial / 4) - 2*floor(trial / 8))*1.8
alter VB2 = $&drive
let drive = (floor(trial / 8) - 2*floor(trial / 16))*1.8
alter VB3 = $&drive
let drive = (floor(trial / 16) - 2*floor(trial / 32))*1.8
alter VB4 = $&drive
let drive = (floor(trial / 32) - 2*floor(trial / 64))*1.8
alter VB5 = $&drive
let drive = (floor(trial / 64) - 2*floor(trial / 128))*1.8
alter VB6 = $&drive
let drive = (floor(trial / 128) - 2*floor(trial / 256))*1.8
alter VB7 = $&drive
stop when time = 0.003198
resume
delete all
let endpoint = length(time)-1
let cmp = v(COMP)[endpoint]
let top = v(TOP)[endpoint]
let decision = 0
if cmp >= 0.9
let code = trial
let decision = 1
end
echo 177 3 $&trial $&cmp $&top 0.81796875 $&decision >> decisions.csv
let trial = code + 4
let drive = (floor(trial / 1) - 2*floor(trial / 2))*1.8
alter VB0 = $&drive
let drive = (floor(trial / 2) - 2*floor(trial / 4))*1.8
alter VB1 = $&drive
let drive = (floor(trial / 4) - 2*floor(trial / 8))*1.8
alter VB2 = $&drive
let drive = (floor(trial / 8) - 2*floor(trial / 16))*1.8
alter VB3 = $&drive
let drive = (floor(trial / 16) - 2*floor(trial / 32))*1.8
alter VB4 = $&drive
let drive = (floor(trial / 32) - 2*floor(trial / 64))*1.8
alter VB5 = $&drive
let drive = (floor(trial / 64) - 2*floor(trial / 128))*1.8
alter VB6 = $&drive
let drive = (floor(trial / 128) - 2*floor(trial / 256))*1.8
alter VB7 = $&drive
stop when time = 0.0032
resume
delete all
let endpoint = length(time)-1
let cmp = v(COMP)[endpoint]
let top = v(TOP)[endpoint]
let decision = 0
if cmp >= 0.9
let code = trial
let decision = 1
end
echo 177 2 $&trial $&cmp $&top 0.81796875 $&decision >> decisions.csv
let trial = code + 2
let drive = (floor(trial / 1) - 2*floor(trial / 2))*1.8
alter VB0 = $&drive
let drive = (floor(trial / 2) - 2*floor(trial / 4))*1.8
alter VB1 = $&drive
let drive = (floor(trial / 4) - 2*floor(trial / 8))*1.8
alter VB2 = $&drive
let drive = (floor(trial / 8) - 2*floor(trial / 16))*1.8
alter VB3 = $&drive
let drive = (floor(trial / 16) - 2*floor(trial / 32))*1.8
alter VB4 = $&drive
let drive = (floor(trial / 32) - 2*floor(trial / 64))*1.8
alter VB5 = $&drive
let drive = (floor(trial / 64) - 2*floor(trial / 128))*1.8
alter VB6 = $&drive
let drive = (floor(trial / 128) - 2*floor(trial / 256))*1.8
alter VB7 = $&drive
stop when time = 0.003202
resume
delete all
let endpoint = length(time)-1
let cmp = v(COMP)[endpoint]
let top = v(TOP)[endpoint]
let decision = 0
if cmp >= 0.9
let code = trial
let decision = 1
end
echo 177 1 $&trial $&cmp $&top 0.81796875 $&decision >> decisions.csv
let trial = code + 1
let drive = (floor(trial / 1) - 2*floor(trial / 2))*1.8
alter VB0 = $&drive
let drive = (floor(trial / 2) - 2*floor(trial / 4))*1.8
alter VB1 = $&drive
let drive = (floor(trial / 4) - 2*floor(trial / 8))*1.8
alter VB2 = $&drive
let drive = (floor(trial / 8) - 2*floor(trial / 16))*1.8
alter VB3 = $&drive
let drive = (floor(trial / 16) - 2*floor(trial / 32))*1.8
alter VB4 = $&drive
let drive = (floor(trial / 32) - 2*floor(trial / 64))*1.8
alter VB5 = $&drive
let drive = (floor(trial / 64) - 2*floor(trial / 128))*1.8
alter VB6 = $&drive
let drive = (floor(trial / 128) - 2*floor(trial / 256))*1.8
alter VB7 = $&drive
stop when time = 0.003204
resume
delete all
let endpoint = length(time)-1
let cmp = v(COMP)[endpoint]
let top = v(TOP)[endpoint]
let decision = 0
if cmp >= 0.9
let code = trial
let decision = 1
end
echo 177 0 $&trial $&cmp $&top 0.81796875 $&decision >> decisions.csv
alter VIN = 0.82265625
alter VSAMPLE = 1.8
alter VB0 = 0
alter VB1 = 0
alter VB2 = 0
alter VB3 = 0
alter VB4 = 0
alter VB5 = 0
alter VB6 = 0
alter VB7 = 0
let code = 0
stop when time = 0.003206
resume
delete all
alter VSAMPLE = 0
let trial = code + 128
let drive = (floor(trial / 1) - 2*floor(trial / 2))*1.8
alter VB0 = $&drive
let drive = (floor(trial / 2) - 2*floor(trial / 4))*1.8
alter VB1 = $&drive
let drive = (floor(trial / 4) - 2*floor(trial / 8))*1.8
alter VB2 = $&drive
let drive = (floor(trial / 8) - 2*floor(trial / 16))*1.8
alter VB3 = $&drive
let drive = (floor(trial / 16) - 2*floor(trial / 32))*1.8
alter VB4 = $&drive
let drive = (floor(trial / 32) - 2*floor(trial / 64))*1.8
alter VB5 = $&drive
let drive = (floor(trial / 64) - 2*floor(trial / 128))*1.8
alter VB6 = $&drive
let drive = (floor(trial / 128) - 2*floor(trial / 256))*1.8
alter VB7 = $&drive
stop when time = 0.003208
resume
delete all
let endpoint = length(time)-1
let cmp = v(COMP)[endpoint]
let top = v(TOP)[endpoint]
let decision = 0
if cmp >= 0.9
let code = trial
let decision = 1
end
echo 178 7 $&trial $&cmp $&top 0.82265625 $&decision >> decisions.csv
let trial = code + 64
let drive = (floor(trial / 1) - 2*floor(trial / 2))*1.8
alter VB0 = $&drive
let drive = (floor(trial / 2) - 2*floor(trial / 4))*1.8
alter VB1 = $&drive
let drive = (floor(trial / 4) - 2*floor(trial / 8))*1.8
alter VB2 = $&drive
let drive = (floor(trial / 8) - 2*floor(trial / 16))*1.8
alter VB3 = $&drive
let drive = (floor(trial / 16) - 2*floor(trial / 32))*1.8
alter VB4 = $&drive
let drive = (floor(trial / 32) - 2*floor(trial / 64))*1.8
alter VB5 = $&drive
let drive = (floor(trial / 64) - 2*floor(trial / 128))*1.8
alter VB6 = $&drive
let drive = (floor(trial / 128) - 2*floor(trial / 256))*1.8
alter VB7 = $&drive
stop when time = 0.00321
resume
delete all
let endpoint = length(time)-1
let cmp = v(COMP)[endpoint]
let top = v(TOP)[endpoint]
let decision = 0
if cmp >= 0.9
let code = trial
let decision = 1
end
echo 178 6 $&trial $&cmp $&top 0.82265625 $&decision >> decisions.csv
let trial = code + 32
let drive = (floor(trial / 1) - 2*floor(trial / 2))*1.8
alter VB0 = $&drive
let drive = (floor(trial / 2) - 2*floor(trial / 4))*1.8
alter VB1 = $&drive
let drive = (floor(trial / 4) - 2*floor(trial / 8))*1.8
alter VB2 = $&drive
let drive = (floor(trial / 8) - 2*floor(trial / 16))*1.8
alter VB3 = $&drive
let drive = (floor(trial / 16) - 2*floor(trial / 32))*1.8
alter VB4 = $&drive
let drive = (floor(trial / 32) - 2*floor(trial / 64))*1.8
alter VB5 = $&drive
let drive = (floor(trial / 64) - 2*floor(trial / 128))*1.8
alter VB6 = $&drive
let drive = (floor(trial / 128) - 2*floor(trial / 256))*1.8
alter VB7 = $&drive
stop when time = 0.003212
resume
delete all
let endpoint = length(time)-1
let cmp = v(COMP)[endpoint]
let top = v(TOP)[endpoint]
let decision = 0
if cmp >= 0.9
let code = trial
let decision = 1
end
echo 178 5 $&trial $&cmp $&top 0.82265625 $&decision >> decisions.csv
let trial = code + 16
let drive = (floor(trial / 1) - 2*floor(trial / 2))*1.8
alter VB0 = $&drive
let drive = (floor(trial / 2) - 2*floor(trial / 4))*1.8
alter VB1 = $&drive
let drive = (floor(trial / 4) - 2*floor(trial / 8))*1.8
alter VB2 = $&drive
let drive = (floor(trial / 8) - 2*floor(trial / 16))*1.8
alter VB3 = $&drive
let drive = (floor(trial / 16) - 2*floor(trial / 32))*1.8
alter VB4 = $&drive
let drive = (floor(trial / 32) - 2*floor(trial / 64))*1.8
alter VB5 = $&drive
let drive = (floor(trial / 64) - 2*floor(trial / 128))*1.8
alter VB6 = $&drive
let drive = (floor(trial / 128) - 2*floor(trial / 256))*1.8
alter VB7 = $&drive
stop when time = 0.003214
resume
delete all
let endpoint = length(time)-1
let cmp = v(COMP)[endpoint]
let top = v(TOP)[endpoint]
let decision = 0
if cmp >= 0.9
let code = trial
let decision = 1
end
echo 178 4 $&trial $&cmp $&top 0.82265625 $&decision >> decisions.csv
let trial = code + 8
let drive = (floor(trial / 1) - 2*floor(trial / 2))*1.8
alter VB0 = $&drive
let drive = (floor(trial / 2) - 2*floor(trial / 4))*1.8
alter VB1 = $&drive
let drive = (floor(trial / 4) - 2*floor(trial / 8))*1.8
alter VB2 = $&drive
let drive = (floor(trial / 8) - 2*floor(trial / 16))*1.8
alter VB3 = $&drive
let drive = (floor(trial / 16) - 2*floor(trial / 32))*1.8
alter VB4 = $&drive
let drive = (floor(trial / 32) - 2*floor(trial / 64))*1.8
alter VB5 = $&drive
let drive = (floor(trial / 64) - 2*floor(trial / 128))*1.8
alter VB6 = $&drive
let drive = (floor(trial / 128) - 2*floor(trial / 256))*1.8
alter VB7 = $&drive
stop when time = 0.003216
resume
delete all
let endpoint = length(time)-1
let cmp = v(COMP)[endpoint]
let top = v(TOP)[endpoint]
let decision = 0
if cmp >= 0.9
let code = trial
let decision = 1
end
echo 178 3 $&trial $&cmp $&top 0.82265625 $&decision >> decisions.csv
let trial = code + 4
let drive = (floor(trial / 1) - 2*floor(trial / 2))*1.8
alter VB0 = $&drive
let drive = (floor(trial / 2) - 2*floor(trial / 4))*1.8
alter VB1 = $&drive
let drive = (floor(trial / 4) - 2*floor(trial / 8))*1.8
alter VB2 = $&drive
let drive = (floor(trial / 8) - 2*floor(trial / 16))*1.8
alter VB3 = $&drive
let drive = (floor(trial / 16) - 2*floor(trial / 32))*1.8
alter VB4 = $&drive
let drive = (floor(trial / 32) - 2*floor(trial / 64))*1.8
alter VB5 = $&drive
let drive = (floor(trial / 64) - 2*floor(trial / 128))*1.8
alter VB6 = $&drive
let drive = (floor(trial / 128) - 2*floor(trial / 256))*1.8
alter VB7 = $&drive
stop when time = 0.003218
resume
delete all
let endpoint = length(time)-1
let cmp = v(COMP)[endpoint]
let top = v(TOP)[endpoint]
let decision = 0
if cmp >= 0.9
let code = trial
let decision = 1
end
echo 178 2 $&trial $&cmp $&top 0.82265625 $&decision >> decisions.csv
let trial = code + 2
let drive = (floor(trial / 1) - 2*floor(trial / 2))*1.8
alter VB0 = $&drive
let drive = (floor(trial / 2) - 2*floor(trial / 4))*1.8
alter VB1 = $&drive
let drive = (floor(trial / 4) - 2*floor(trial / 8))*1.8
alter VB2 = $&drive
let drive = (floor(trial / 8) - 2*floor(trial / 16))*1.8
alter VB3 = $&drive
let drive = (floor(trial / 16) - 2*floor(trial / 32))*1.8
alter VB4 = $&drive
let drive = (floor(trial / 32) - 2*floor(trial / 64))*1.8
alter VB5 = $&drive
let drive = (floor(trial / 64) - 2*floor(trial / 128))*1.8
alter VB6 = $&drive
let drive = (floor(trial / 128) - 2*floor(trial / 256))*1.8
alter VB7 = $&drive
stop when time = 0.00322
resume
delete all
let endpoint = length(time)-1
let cmp = v(COMP)[endpoint]
let top = v(TOP)[endpoint]
let decision = 0
if cmp >= 0.9
let code = trial
let decision = 1
end
echo 178 1 $&trial $&cmp $&top 0.82265625 $&decision >> decisions.csv
let trial = code + 1
let drive = (floor(trial / 1) - 2*floor(trial / 2))*1.8
alter VB0 = $&drive
let drive = (floor(trial / 2) - 2*floor(trial / 4))*1.8
alter VB1 = $&drive
let drive = (floor(trial / 4) - 2*floor(trial / 8))*1.8
alter VB2 = $&drive
let drive = (floor(trial / 8) - 2*floor(trial / 16))*1.8
alter VB3 = $&drive
let drive = (floor(trial / 16) - 2*floor(trial / 32))*1.8
alter VB4 = $&drive
let drive = (floor(trial / 32) - 2*floor(trial / 64))*1.8
alter VB5 = $&drive
let drive = (floor(trial / 64) - 2*floor(trial / 128))*1.8
alter VB6 = $&drive
let drive = (floor(trial / 128) - 2*floor(trial / 256))*1.8
alter VB7 = $&drive
stop when time = 0.003222
resume
delete all
let endpoint = length(time)-1
let cmp = v(COMP)[endpoint]
let top = v(TOP)[endpoint]
let decision = 0
if cmp >= 0.9
let code = trial
let decision = 1
end
echo 178 0 $&trial $&cmp $&top 0.82265625 $&decision >> decisions.csv
alter VIN = 0.82734375
alter VSAMPLE = 1.8
alter VB0 = 0
alter VB1 = 0
alter VB2 = 0
alter VB3 = 0
alter VB4 = 0
alter VB5 = 0
alter VB6 = 0
alter VB7 = 0
let code = 0
stop when time = 0.003224
resume
delete all
alter VSAMPLE = 0
let trial = code + 128
let drive = (floor(trial / 1) - 2*floor(trial / 2))*1.8
alter VB0 = $&drive
let drive = (floor(trial / 2) - 2*floor(trial / 4))*1.8
alter VB1 = $&drive
let drive = (floor(trial / 4) - 2*floor(trial / 8))*1.8
alter VB2 = $&drive
let drive = (floor(trial / 8) - 2*floor(trial / 16))*1.8
alter VB3 = $&drive
let drive = (floor(trial / 16) - 2*floor(trial / 32))*1.8
alter VB4 = $&drive
let drive = (floor(trial / 32) - 2*floor(trial / 64))*1.8
alter VB5 = $&drive
let drive = (floor(trial / 64) - 2*floor(trial / 128))*1.8
alter VB6 = $&drive
let drive = (floor(trial / 128) - 2*floor(trial / 256))*1.8
alter VB7 = $&drive
stop when time = 0.003226
resume
delete all
let endpoint = length(time)-1
let cmp = v(COMP)[endpoint]
let top = v(TOP)[endpoint]
let decision = 0
if cmp >= 0.9
let code = trial
let decision = 1
end
echo 179 7 $&trial $&cmp $&top 0.82734375 $&decision >> decisions.csv
let trial = code + 64
let drive = (floor(trial / 1) - 2*floor(trial / 2))*1.8
alter VB0 = $&drive
let drive = (floor(trial / 2) - 2*floor(trial / 4))*1.8
alter VB1 = $&drive
let drive = (floor(trial / 4) - 2*floor(trial / 8))*1.8
alter VB2 = $&drive
let drive = (floor(trial / 8) - 2*floor(trial / 16))*1.8
alter VB3 = $&drive
let drive = (floor(trial / 16) - 2*floor(trial / 32))*1.8
alter VB4 = $&drive
let drive = (floor(trial / 32) - 2*floor(trial / 64))*1.8
alter VB5 = $&drive
let drive = (floor(trial / 64) - 2*floor(trial / 128))*1.8
alter VB6 = $&drive
let drive = (floor(trial / 128) - 2*floor(trial / 256))*1.8
alter VB7 = $&drive
stop when time = 0.003228
resume
delete all
let endpoint = length(time)-1
let cmp = v(COMP)[endpoint]
let top = v(TOP)[endpoint]
let decision = 0
if cmp >= 0.9
let code = trial
let decision = 1
end
echo 179 6 $&trial $&cmp $&top 0.82734375 $&decision >> decisions.csv
let trial = code + 32
let drive = (floor(trial / 1) - 2*floor(trial / 2))*1.8
alter VB0 = $&drive
let drive = (floor(trial / 2) - 2*floor(trial / 4))*1.8
alter VB1 = $&drive
let drive = (floor(trial / 4) - 2*floor(trial / 8))*1.8
alter VB2 = $&drive
let drive = (floor(trial / 8) - 2*floor(trial / 16))*1.8
alter VB3 = $&drive
let drive = (floor(trial / 16) - 2*floor(trial / 32))*1.8
alter VB4 = $&drive
let drive = (floor(trial / 32) - 2*floor(trial / 64))*1.8
alter VB5 = $&drive
let drive = (floor(trial / 64) - 2*floor(trial / 128))*1.8
alter VB6 = $&drive
let drive = (floor(trial / 128) - 2*floor(trial / 256))*1.8
alter VB7 = $&drive
stop when time = 0.00323
resume
delete all
let endpoint = length(time)-1
let cmp = v(COMP)[endpoint]
let top = v(TOP)[endpoint]
let decision = 0
if cmp >= 0.9
let code = trial
let decision = 1
end
echo 179 5 $&trial $&cmp $&top 0.82734375 $&decision >> decisions.csv
let trial = code + 16
let drive = (floor(trial / 1) - 2*floor(trial / 2))*1.8
alter VB0 = $&drive
let drive = (floor(trial / 2) - 2*floor(trial / 4))*1.8
alter VB1 = $&drive
let drive = (floor(trial / 4) - 2*floor(trial / 8))*1.8
alter VB2 = $&drive
let drive = (floor(trial / 8) - 2*floor(trial / 16))*1.8
alter VB3 = $&drive
let drive = (floor(trial / 16) - 2*floor(trial / 32))*1.8
alter VB4 = $&drive
let drive = (floor(trial / 32) - 2*floor(trial / 64))*1.8
alter VB5 = $&drive
let drive = (floor(trial / 64) - 2*floor(trial / 128))*1.8
alter VB6 = $&drive
let drive = (floor(trial / 128) - 2*floor(trial / 256))*1.8
alter VB7 = $&drive
stop when time = 0.003232
resume
delete all
let endpoint = length(time)-1
let cmp = v(COMP)[endpoint]
let top = v(TOP)[endpoint]
let decision = 0
if cmp >= 0.9
let code = trial
let decision = 1
end
echo 179 4 $&trial $&cmp $&top 0.82734375 $&decision >> decisions.csv
let trial = code + 8
let drive = (floor(trial / 1) - 2*floor(trial / 2))*1.8
alter VB0 = $&drive
let drive = (floor(trial / 2) - 2*floor(trial / 4))*1.8
alter VB1 = $&drive
let drive = (floor(trial / 4) - 2*floor(trial / 8))*1.8
alter VB2 = $&drive
let drive = (floor(trial / 8) - 2*floor(trial / 16))*1.8
alter VB3 = $&drive
let drive = (floor(trial / 16) - 2*floor(trial / 32))*1.8
alter VB4 = $&drive
let drive = (floor(trial / 32) - 2*floor(trial / 64))*1.8
alter VB5 = $&drive
let drive = (floor(trial / 64) - 2*floor(trial / 128))*1.8
alter VB6 = $&drive
let drive = (floor(trial / 128) - 2*floor(trial / 256))*1.8
alter VB7 = $&drive
stop when time = 0.003234
resume
delete all
let endpoint = length(time)-1
let cmp = v(COMP)[endpoint]
let top = v(TOP)[endpoint]
let decision = 0
if cmp >= 0.9
let code = trial
let decision = 1
end
echo 179 3 $&trial $&cmp $&top 0.82734375 $&decision >> decisions.csv
let trial = code + 4
let drive = (floor(trial / 1) - 2*floor(trial / 2))*1.8
alter VB0 = $&drive
let drive = (floor(trial / 2) - 2*floor(trial / 4))*1.8
alter VB1 = $&drive
let drive = (floor(trial / 4) - 2*floor(trial / 8))*1.8
alter VB2 = $&drive
let drive = (floor(trial / 8) - 2*floor(trial / 16))*1.8
alter VB3 = $&drive
let drive = (floor(trial / 16) - 2*floor(trial / 32))*1.8
alter VB4 = $&drive
let drive = (floor(trial / 32) - 2*floor(trial / 64))*1.8
alter VB5 = $&drive
let drive = (floor(trial / 64) - 2*floor(trial / 128))*1.8
alter VB6 = $&drive
let drive = (floor(trial / 128) - 2*floor(trial / 256))*1.8
alter VB7 = $&drive
stop when time = 0.003236
resume
delete all
let endpoint = length(time)-1
let cmp = v(COMP)[endpoint]
let top = v(TOP)[endpoint]
let decision = 0
if cmp >= 0.9
let code = trial
let decision = 1
end
echo 179 2 $&trial $&cmp $&top 0.82734375 $&decision >> decisions.csv
let trial = code + 2
let drive = (floor(trial / 1) - 2*floor(trial / 2))*1.8
alter VB0 = $&drive
let drive = (floor(trial / 2) - 2*floor(trial / 4))*1.8
alter VB1 = $&drive
let drive = (floor(trial / 4) - 2*floor(trial / 8))*1.8
alter VB2 = $&drive
let drive = (floor(trial / 8) - 2*floor(trial / 16))*1.8
alter VB3 = $&drive
let drive = (floor(trial / 16) - 2*floor(trial / 32))*1.8
alter VB4 = $&drive
let drive = (floor(trial / 32) - 2*floor(trial / 64))*1.8
alter VB5 = $&drive
let drive = (floor(trial / 64) - 2*floor(trial / 128))*1.8
alter VB6 = $&drive
let drive = (floor(trial / 128) - 2*floor(trial / 256))*1.8
alter VB7 = $&drive
stop when time = 0.003238
resume
delete all
let endpoint = length(time)-1
let cmp = v(COMP)[endpoint]
let top = v(TOP)[endpoint]
let decision = 0
if cmp >= 0.9
let code = trial
let decision = 1
end
echo 179 1 $&trial $&cmp $&top 0.82734375 $&decision >> decisions.csv
let trial = code + 1
let drive = (floor(trial / 1) - 2*floor(trial / 2))*1.8
alter VB0 = $&drive
let drive = (floor(trial / 2) - 2*floor(trial / 4))*1.8
alter VB1 = $&drive
let drive = (floor(trial / 4) - 2*floor(trial / 8))*1.8
alter VB2 = $&drive
let drive = (floor(trial / 8) - 2*floor(trial / 16))*1.8
alter VB3 = $&drive
let drive = (floor(trial / 16) - 2*floor(trial / 32))*1.8
alter VB4 = $&drive
let drive = (floor(trial / 32) - 2*floor(trial / 64))*1.8
alter VB5 = $&drive
let drive = (floor(trial / 64) - 2*floor(trial / 128))*1.8
alter VB6 = $&drive
let drive = (floor(trial / 128) - 2*floor(trial / 256))*1.8
alter VB7 = $&drive
stop when time = 0.00324
resume
delete all
let endpoint = length(time)-1
let cmp = v(COMP)[endpoint]
let top = v(TOP)[endpoint]
let decision = 0
if cmp >= 0.9
let code = trial
let decision = 1
end
echo 179 0 $&trial $&cmp $&top 0.82734375 $&decision >> decisions.csv
alter VIN = 0.83203125
alter VSAMPLE = 1.8
alter VB0 = 0
alter VB1 = 0
alter VB2 = 0
alter VB3 = 0
alter VB4 = 0
alter VB5 = 0
alter VB6 = 0
alter VB7 = 0
let code = 0
stop when time = 0.003242
resume
delete all
alter VSAMPLE = 0
let trial = code + 128
let drive = (floor(trial / 1) - 2*floor(trial / 2))*1.8
alter VB0 = $&drive
let drive = (floor(trial / 2) - 2*floor(trial / 4))*1.8
alter VB1 = $&drive
let drive = (floor(trial / 4) - 2*floor(trial / 8))*1.8
alter VB2 = $&drive
let drive = (floor(trial / 8) - 2*floor(trial / 16))*1.8
alter VB3 = $&drive
let drive = (floor(trial / 16) - 2*floor(trial / 32))*1.8
alter VB4 = $&drive
let drive = (floor(trial / 32) - 2*floor(trial / 64))*1.8
alter VB5 = $&drive
let drive = (floor(trial / 64) - 2*floor(trial / 128))*1.8
alter VB6 = $&drive
let drive = (floor(trial / 128) - 2*floor(trial / 256))*1.8
alter VB7 = $&drive
stop when time = 0.003244
resume
delete all
let endpoint = length(time)-1
let cmp = v(COMP)[endpoint]
let top = v(TOP)[endpoint]
let decision = 0
if cmp >= 0.9
let code = trial
let decision = 1
end
echo 180 7 $&trial $&cmp $&top 0.83203125 $&decision >> decisions.csv
let trial = code + 64
let drive = (floor(trial / 1) - 2*floor(trial / 2))*1.8
alter VB0 = $&drive
let drive = (floor(trial / 2) - 2*floor(trial / 4))*1.8
alter VB1 = $&drive
let drive = (floor(trial / 4) - 2*floor(trial / 8))*1.8
alter VB2 = $&drive
let drive = (floor(trial / 8) - 2*floor(trial / 16))*1.8
alter VB3 = $&drive
let drive = (floor(trial / 16) - 2*floor(trial / 32))*1.8
alter VB4 = $&drive
let drive = (floor(trial / 32) - 2*floor(trial / 64))*1.8
alter VB5 = $&drive
let drive = (floor(trial / 64) - 2*floor(trial / 128))*1.8
alter VB6 = $&drive
let drive = (floor(trial / 128) - 2*floor(trial / 256))*1.8
alter VB7 = $&drive
stop when time = 0.003246
resume
delete all
let endpoint = length(time)-1
let cmp = v(COMP)[endpoint]
let top = v(TOP)[endpoint]
let decision = 0
if cmp >= 0.9
let code = trial
let decision = 1
end
echo 180 6 $&trial $&cmp $&top 0.83203125 $&decision >> decisions.csv
let trial = code + 32
let drive = (floor(trial / 1) - 2*floor(trial / 2))*1.8
alter VB0 = $&drive
let drive = (floor(trial / 2) - 2*floor(trial / 4))*1.8
alter VB1 = $&drive
let drive = (floor(trial / 4) - 2*floor(trial / 8))*1.8
alter VB2 = $&drive
let drive = (floor(trial / 8) - 2*floor(trial / 16))*1.8
alter VB3 = $&drive
let drive = (floor(trial / 16) - 2*floor(trial / 32))*1.8
alter VB4 = $&drive
let drive = (floor(trial / 32) - 2*floor(trial / 64))*1.8
alter VB5 = $&drive
let drive = (floor(trial / 64) - 2*floor(trial / 128))*1.8
alter VB6 = $&drive
let drive = (floor(trial / 128) - 2*floor(trial / 256))*1.8
alter VB7 = $&drive
stop when time = 0.003248
resume
delete all
let endpoint = length(time)-1
let cmp = v(COMP)[endpoint]
let top = v(TOP)[endpoint]
let decision = 0
if cmp >= 0.9
let code = trial
let decision = 1
end
echo 180 5 $&trial $&cmp $&top 0.83203125 $&decision >> decisions.csv
let trial = code + 16
let drive = (floor(trial / 1) - 2*floor(trial / 2))*1.8
alter VB0 = $&drive
let drive = (floor(trial / 2) - 2*floor(trial / 4))*1.8
alter VB1 = $&drive
let drive = (floor(trial / 4) - 2*floor(trial / 8))*1.8
alter VB2 = $&drive
let drive = (floor(trial / 8) - 2*floor(trial / 16))*1.8
alter VB3 = $&drive
let drive = (floor(trial / 16) - 2*floor(trial / 32))*1.8
alter VB4 = $&drive
let drive = (floor(trial / 32) - 2*floor(trial / 64))*1.8
alter VB5 = $&drive
let drive = (floor(trial / 64) - 2*floor(trial / 128))*1.8
alter VB6 = $&drive
let drive = (floor(trial / 128) - 2*floor(trial / 256))*1.8
alter VB7 = $&drive
stop when time = 0.00325
resume
delete all
let endpoint = length(time)-1
let cmp = v(COMP)[endpoint]
let top = v(TOP)[endpoint]
let decision = 0
if cmp >= 0.9
let code = trial
let decision = 1
end
echo 180 4 $&trial $&cmp $&top 0.83203125 $&decision >> decisions.csv
let trial = code + 8
let drive = (floor(trial / 1) - 2*floor(trial / 2))*1.8
alter VB0 = $&drive
let drive = (floor(trial / 2) - 2*floor(trial / 4))*1.8
alter VB1 = $&drive
let drive = (floor(trial / 4) - 2*floor(trial / 8))*1.8
alter VB2 = $&drive
let drive = (floor(trial / 8) - 2*floor(trial / 16))*1.8
alter VB3 = $&drive
let drive = (floor(trial / 16) - 2*floor(trial / 32))*1.8
alter VB4 = $&drive
let drive = (floor(trial / 32) - 2*floor(trial / 64))*1.8
alter VB5 = $&drive
let drive = (floor(trial / 64) - 2*floor(trial / 128))*1.8
alter VB6 = $&drive
let drive = (floor(trial / 128) - 2*floor(trial / 256))*1.8
alter VB7 = $&drive
stop when time = 0.003252
resume
delete all
let endpoint = length(time)-1
let cmp = v(COMP)[endpoint]
let top = v(TOP)[endpoint]
let decision = 0
if cmp >= 0.9
let code = trial
let decision = 1
end
echo 180 3 $&trial $&cmp $&top 0.83203125 $&decision >> decisions.csv
let trial = code + 4
let drive = (floor(trial / 1) - 2*floor(trial / 2))*1.8
alter VB0 = $&drive
let drive = (floor(trial / 2) - 2*floor(trial / 4))*1.8
alter VB1 = $&drive
let drive = (floor(trial / 4) - 2*floor(trial / 8))*1.8
alter VB2 = $&drive
let drive = (floor(trial / 8) - 2*floor(trial / 16))*1.8
alter VB3 = $&drive
let drive = (floor(trial / 16) - 2*floor(trial / 32))*1.8
alter VB4 = $&drive
let drive = (floor(trial / 32) - 2*floor(trial / 64))*1.8
alter VB5 = $&drive
let drive = (floor(trial / 64) - 2*floor(trial / 128))*1.8
alter VB6 = $&drive
let drive = (floor(trial / 128) - 2*floor(trial / 256))*1.8
alter VB7 = $&drive
stop when time = 0.003254
resume
delete all
let endpoint = length(time)-1
let cmp = v(COMP)[endpoint]
let top = v(TOP)[endpoint]
let decision = 0
if cmp >= 0.9
let code = trial
let decision = 1
end
echo 180 2 $&trial $&cmp $&top 0.83203125 $&decision >> decisions.csv
let trial = code + 2
let drive = (floor(trial / 1) - 2*floor(trial / 2))*1.8
alter VB0 = $&drive
let drive = (floor(trial / 2) - 2*floor(trial / 4))*1.8
alter VB1 = $&drive
let drive = (floor(trial / 4) - 2*floor(trial / 8))*1.8
alter VB2 = $&drive
let drive = (floor(trial / 8) - 2*floor(trial / 16))*1.8
alter VB3 = $&drive
let drive = (floor(trial / 16) - 2*floor(trial / 32))*1.8
alter VB4 = $&drive
let drive = (floor(trial / 32) - 2*floor(trial / 64))*1.8
alter VB5 = $&drive
let drive = (floor(trial / 64) - 2*floor(trial / 128))*1.8
alter VB6 = $&drive
let drive = (floor(trial / 128) - 2*floor(trial / 256))*1.8
alter VB7 = $&drive
stop when time = 0.003256
resume
delete all
let endpoint = length(time)-1
let cmp = v(COMP)[endpoint]
let top = v(TOP)[endpoint]
let decision = 0
if cmp >= 0.9
let code = trial
let decision = 1
end
echo 180 1 $&trial $&cmp $&top 0.83203125 $&decision >> decisions.csv
let trial = code + 1
let drive = (floor(trial / 1) - 2*floor(trial / 2))*1.8
alter VB0 = $&drive
let drive = (floor(trial / 2) - 2*floor(trial / 4))*1.8
alter VB1 = $&drive
let drive = (floor(trial / 4) - 2*floor(trial / 8))*1.8
alter VB2 = $&drive
let drive = (floor(trial / 8) - 2*floor(trial / 16))*1.8
alter VB3 = $&drive
let drive = (floor(trial / 16) - 2*floor(trial / 32))*1.8
alter VB4 = $&drive
let drive = (floor(trial / 32) - 2*floor(trial / 64))*1.8
alter VB5 = $&drive
let drive = (floor(trial / 64) - 2*floor(trial / 128))*1.8
alter VB6 = $&drive
let drive = (floor(trial / 128) - 2*floor(trial / 256))*1.8
alter VB7 = $&drive
stop when time = 0.003258
resume
delete all
let endpoint = length(time)-1
let cmp = v(COMP)[endpoint]
let top = v(TOP)[endpoint]
let decision = 0
if cmp >= 0.9
let code = trial
let decision = 1
end
echo 180 0 $&trial $&cmp $&top 0.83203125 $&decision >> decisions.csv
alter VIN = 0.83671875
alter VSAMPLE = 1.8
alter VB0 = 0
alter VB1 = 0
alter VB2 = 0
alter VB3 = 0
alter VB4 = 0
alter VB5 = 0
alter VB6 = 0
alter VB7 = 0
let code = 0
stop when time = 0.00326
resume
delete all
alter VSAMPLE = 0
let trial = code + 128
let drive = (floor(trial / 1) - 2*floor(trial / 2))*1.8
alter VB0 = $&drive
let drive = (floor(trial / 2) - 2*floor(trial / 4))*1.8
alter VB1 = $&drive
let drive = (floor(trial / 4) - 2*floor(trial / 8))*1.8
alter VB2 = $&drive
let drive = (floor(trial / 8) - 2*floor(trial / 16))*1.8
alter VB3 = $&drive
let drive = (floor(trial / 16) - 2*floor(trial / 32))*1.8
alter VB4 = $&drive
let drive = (floor(trial / 32) - 2*floor(trial / 64))*1.8
alter VB5 = $&drive
let drive = (floor(trial / 64) - 2*floor(trial / 128))*1.8
alter VB6 = $&drive
let drive = (floor(trial / 128) - 2*floor(trial / 256))*1.8
alter VB7 = $&drive
stop when time = 0.003262
resume
delete all
let endpoint = length(time)-1
let cmp = v(COMP)[endpoint]
let top = v(TOP)[endpoint]
let decision = 0
if cmp >= 0.9
let code = trial
let decision = 1
end
echo 181 7 $&trial $&cmp $&top 0.83671875 $&decision >> decisions.csv
let trial = code + 64
let drive = (floor(trial / 1) - 2*floor(trial / 2))*1.8
alter VB0 = $&drive
let drive = (floor(trial / 2) - 2*floor(trial / 4))*1.8
alter VB1 = $&drive
let drive = (floor(trial / 4) - 2*floor(trial / 8))*1.8
alter VB2 = $&drive
let drive = (floor(trial / 8) - 2*floor(trial / 16))*1.8
alter VB3 = $&drive
let drive = (floor(trial / 16) - 2*floor(trial / 32))*1.8
alter VB4 = $&drive
let drive = (floor(trial / 32) - 2*floor(trial / 64))*1.8
alter VB5 = $&drive
let drive = (floor(trial / 64) - 2*floor(trial / 128))*1.8
alter VB6 = $&drive
let drive = (floor(trial / 128) - 2*floor(trial / 256))*1.8
alter VB7 = $&drive
stop when time = 0.003264
resume
delete all
let endpoint = length(time)-1
let cmp = v(COMP)[endpoint]
let top = v(TOP)[endpoint]
let decision = 0
if cmp >= 0.9
let code = trial
let decision = 1
end
echo 181 6 $&trial $&cmp $&top 0.83671875 $&decision >> decisions.csv
let trial = code + 32
let drive = (floor(trial / 1) - 2*floor(trial / 2))*1.8
alter VB0 = $&drive
let drive = (floor(trial / 2) - 2*floor(trial / 4))*1.8
alter VB1 = $&drive
let drive = (floor(trial / 4) - 2*floor(trial / 8))*1.8
alter VB2 = $&drive
let drive = (floor(trial / 8) - 2*floor(trial / 16))*1.8
alter VB3 = $&drive
let drive = (floor(trial / 16) - 2*floor(trial / 32))*1.8
alter VB4 = $&drive
let drive = (floor(trial / 32) - 2*floor(trial / 64))*1.8
alter VB5 = $&drive
let drive = (floor(trial / 64) - 2*floor(trial / 128))*1.8
alter VB6 = $&drive
let drive = (floor(trial / 128) - 2*floor(trial / 256))*1.8
alter VB7 = $&drive
stop when time = 0.003266
resume
delete all
let endpoint = length(time)-1
let cmp = v(COMP)[endpoint]
let top = v(TOP)[endpoint]
let decision = 0
if cmp >= 0.9
let code = trial
let decision = 1
end
echo 181 5 $&trial $&cmp $&top 0.83671875 $&decision >> decisions.csv
let trial = code + 16
let drive = (floor(trial / 1) - 2*floor(trial / 2))*1.8
alter VB0 = $&drive
let drive = (floor(trial / 2) - 2*floor(trial / 4))*1.8
alter VB1 = $&drive
let drive = (floor(trial / 4) - 2*floor(trial / 8))*1.8
alter VB2 = $&drive
let drive = (floor(trial / 8) - 2*floor(trial / 16))*1.8
alter VB3 = $&drive
let drive = (floor(trial / 16) - 2*floor(trial / 32))*1.8
alter VB4 = $&drive
let drive = (floor(trial / 32) - 2*floor(trial / 64))*1.8
alter VB5 = $&drive
let drive = (floor(trial / 64) - 2*floor(trial / 128))*1.8
alter VB6 = $&drive
let drive = (floor(trial / 128) - 2*floor(trial / 256))*1.8
alter VB7 = $&drive
stop when time = 0.003268
resume
delete all
let endpoint = length(time)-1
let cmp = v(COMP)[endpoint]
let top = v(TOP)[endpoint]
let decision = 0
if cmp >= 0.9
let code = trial
let decision = 1
end
echo 181 4 $&trial $&cmp $&top 0.83671875 $&decision >> decisions.csv
let trial = code + 8
let drive = (floor(trial / 1) - 2*floor(trial / 2))*1.8
alter VB0 = $&drive
let drive = (floor(trial / 2) - 2*floor(trial / 4))*1.8
alter VB1 = $&drive
let drive = (floor(trial / 4) - 2*floor(trial / 8))*1.8
alter VB2 = $&drive
let drive = (floor(trial / 8) - 2*floor(trial / 16))*1.8
alter VB3 = $&drive
let drive = (floor(trial / 16) - 2*floor(trial / 32))*1.8
alter VB4 = $&drive
let drive = (floor(trial / 32) - 2*floor(trial / 64))*1.8
alter VB5 = $&drive
let drive = (floor(trial / 64) - 2*floor(trial / 128))*1.8
alter VB6 = $&drive
let drive = (floor(trial / 128) - 2*floor(trial / 256))*1.8
alter VB7 = $&drive
stop when time = 0.00327
resume
delete all
let endpoint = length(time)-1
let cmp = v(COMP)[endpoint]
let top = v(TOP)[endpoint]
let decision = 0
if cmp >= 0.9
let code = trial
let decision = 1
end
echo 181 3 $&trial $&cmp $&top 0.83671875 $&decision >> decisions.csv
let trial = code + 4
let drive = (floor(trial / 1) - 2*floor(trial / 2))*1.8
alter VB0 = $&drive
let drive = (floor(trial / 2) - 2*floor(trial / 4))*1.8
alter VB1 = $&drive
let drive = (floor(trial / 4) - 2*floor(trial / 8))*1.8
alter VB2 = $&drive
let drive = (floor(trial / 8) - 2*floor(trial / 16))*1.8
alter VB3 = $&drive
let drive = (floor(trial / 16) - 2*floor(trial / 32))*1.8
alter VB4 = $&drive
let drive = (floor(trial / 32) - 2*floor(trial / 64))*1.8
alter VB5 = $&drive
let drive = (floor(trial / 64) - 2*floor(trial / 128))*1.8
alter VB6 = $&drive
let drive = (floor(trial / 128) - 2*floor(trial / 256))*1.8
alter VB7 = $&drive
stop when time = 0.003272
resume
delete all
let endpoint = length(time)-1
let cmp = v(COMP)[endpoint]
let top = v(TOP)[endpoint]
let decision = 0
if cmp >= 0.9
let code = trial
let decision = 1
end
echo 181 2 $&trial $&cmp $&top 0.83671875 $&decision >> decisions.csv
let trial = code + 2
let drive = (floor(trial / 1) - 2*floor(trial / 2))*1.8
alter VB0 = $&drive
let drive = (floor(trial / 2) - 2*floor(trial / 4))*1.8
alter VB1 = $&drive
let drive = (floor(trial / 4) - 2*floor(trial / 8))*1.8
alter VB2 = $&drive
let drive = (floor(trial / 8) - 2*floor(trial / 16))*1.8
alter VB3 = $&drive
let drive = (floor(trial / 16) - 2*floor(trial / 32))*1.8
alter VB4 = $&drive
let drive = (floor(trial / 32) - 2*floor(trial / 64))*1.8
alter VB5 = $&drive
let drive = (floor(trial / 64) - 2*floor(trial / 128))*1.8
alter VB6 = $&drive
let drive = (floor(trial / 128) - 2*floor(trial / 256))*1.8
alter VB7 = $&drive
stop when time = 0.003274
resume
delete all
let endpoint = length(time)-1
let cmp = v(COMP)[endpoint]
let top = v(TOP)[endpoint]
let decision = 0
if cmp >= 0.9
let code = trial
let decision = 1
end
echo 181 1 $&trial $&cmp $&top 0.83671875 $&decision >> decisions.csv
let trial = code + 1
let drive = (floor(trial / 1) - 2*floor(trial / 2))*1.8
alter VB0 = $&drive
let drive = (floor(trial / 2) - 2*floor(trial / 4))*1.8
alter VB1 = $&drive
let drive = (floor(trial / 4) - 2*floor(trial / 8))*1.8
alter VB2 = $&drive
let drive = (floor(trial / 8) - 2*floor(trial / 16))*1.8
alter VB3 = $&drive
let drive = (floor(trial / 16) - 2*floor(trial / 32))*1.8
alter VB4 = $&drive
let drive = (floor(trial / 32) - 2*floor(trial / 64))*1.8
alter VB5 = $&drive
let drive = (floor(trial / 64) - 2*floor(trial / 128))*1.8
alter VB6 = $&drive
let drive = (floor(trial / 128) - 2*floor(trial / 256))*1.8
alter VB7 = $&drive
stop when time = 0.003276
resume
delete all
let endpoint = length(time)-1
let cmp = v(COMP)[endpoint]
let top = v(TOP)[endpoint]
let decision = 0
if cmp >= 0.9
let code = trial
let decision = 1
end
echo 181 0 $&trial $&cmp $&top 0.83671875 $&decision >> decisions.csv
alter VIN = 0.84140625
alter VSAMPLE = 1.8
alter VB0 = 0
alter VB1 = 0
alter VB2 = 0
alter VB3 = 0
alter VB4 = 0
alter VB5 = 0
alter VB6 = 0
alter VB7 = 0
let code = 0
stop when time = 0.003278
resume
delete all
alter VSAMPLE = 0
let trial = code + 128
let drive = (floor(trial / 1) - 2*floor(trial / 2))*1.8
alter VB0 = $&drive
let drive = (floor(trial / 2) - 2*floor(trial / 4))*1.8
alter VB1 = $&drive
let drive = (floor(trial / 4) - 2*floor(trial / 8))*1.8
alter VB2 = $&drive
let drive = (floor(trial / 8) - 2*floor(trial / 16))*1.8
alter VB3 = $&drive
let drive = (floor(trial / 16) - 2*floor(trial / 32))*1.8
alter VB4 = $&drive
let drive = (floor(trial / 32) - 2*floor(trial / 64))*1.8
alter VB5 = $&drive
let drive = (floor(trial / 64) - 2*floor(trial / 128))*1.8
alter VB6 = $&drive
let drive = (floor(trial / 128) - 2*floor(trial / 256))*1.8
alter VB7 = $&drive
stop when time = 0.00328
resume
delete all
let endpoint = length(time)-1
let cmp = v(COMP)[endpoint]
let top = v(TOP)[endpoint]
let decision = 0
if cmp >= 0.9
let code = trial
let decision = 1
end
echo 182 7 $&trial $&cmp $&top 0.84140625 $&decision >> decisions.csv
let trial = code + 64
let drive = (floor(trial / 1) - 2*floor(trial / 2))*1.8
alter VB0 = $&drive
let drive = (floor(trial / 2) - 2*floor(trial / 4))*1.8
alter VB1 = $&drive
let drive = (floor(trial / 4) - 2*floor(trial / 8))*1.8
alter VB2 = $&drive
let drive = (floor(trial / 8) - 2*floor(trial / 16))*1.8
alter VB3 = $&drive
let drive = (floor(trial / 16) - 2*floor(trial / 32))*1.8
alter VB4 = $&drive
let drive = (floor(trial / 32) - 2*floor(trial / 64))*1.8
alter VB5 = $&drive
let drive = (floor(trial / 64) - 2*floor(trial / 128))*1.8
alter VB6 = $&drive
let drive = (floor(trial / 128) - 2*floor(trial / 256))*1.8
alter VB7 = $&drive
stop when time = 0.003282
resume
delete all
let endpoint = length(time)-1
let cmp = v(COMP)[endpoint]
let top = v(TOP)[endpoint]
let decision = 0
if cmp >= 0.9
let code = trial
let decision = 1
end
echo 182 6 $&trial $&cmp $&top 0.84140625 $&decision >> decisions.csv
let trial = code + 32
let drive = (floor(trial / 1) - 2*floor(trial / 2))*1.8
alter VB0 = $&drive
let drive = (floor(trial / 2) - 2*floor(trial / 4))*1.8
alter VB1 = $&drive
let drive = (floor(trial / 4) - 2*floor(trial / 8))*1.8
alter VB2 = $&drive
let drive = (floor(trial / 8) - 2*floor(trial / 16))*1.8
alter VB3 = $&drive
let drive = (floor(trial / 16) - 2*floor(trial / 32))*1.8
alter VB4 = $&drive
let drive = (floor(trial / 32) - 2*floor(trial / 64))*1.8
alter VB5 = $&drive
let drive = (floor(trial / 64) - 2*floor(trial / 128))*1.8
alter VB6 = $&drive
let drive = (floor(trial / 128) - 2*floor(trial / 256))*1.8
alter VB7 = $&drive
stop when time = 0.003284
resume
delete all
let endpoint = length(time)-1
let cmp = v(COMP)[endpoint]
let top = v(TOP)[endpoint]
let decision = 0
if cmp >= 0.9
let code = trial
let decision = 1
end
echo 182 5 $&trial $&cmp $&top 0.84140625 $&decision >> decisions.csv
let trial = code + 16
let drive = (floor(trial / 1) - 2*floor(trial / 2))*1.8
alter VB0 = $&drive
let drive = (floor(trial / 2) - 2*floor(trial / 4))*1.8
alter VB1 = $&drive
let drive = (floor(trial / 4) - 2*floor(trial / 8))*1.8
alter VB2 = $&drive
let drive = (floor(trial / 8) - 2*floor(trial / 16))*1.8
alter VB3 = $&drive
let drive = (floor(trial / 16) - 2*floor(trial / 32))*1.8
alter VB4 = $&drive
let drive = (floor(trial / 32) - 2*floor(trial / 64))*1.8
alter VB5 = $&drive
let drive = (floor(trial / 64) - 2*floor(trial / 128))*1.8
alter VB6 = $&drive
let drive = (floor(trial / 128) - 2*floor(trial / 256))*1.8
alter VB7 = $&drive
stop when time = 0.003286
resume
delete all
let endpoint = length(time)-1
let cmp = v(COMP)[endpoint]
let top = v(TOP)[endpoint]
let decision = 0
if cmp >= 0.9
let code = trial
let decision = 1
end
echo 182 4 $&trial $&cmp $&top 0.84140625 $&decision >> decisions.csv
let trial = code + 8
let drive = (floor(trial / 1) - 2*floor(trial / 2))*1.8
alter VB0 = $&drive
let drive = (floor(trial / 2) - 2*floor(trial / 4))*1.8
alter VB1 = $&drive
let drive = (floor(trial / 4) - 2*floor(trial / 8))*1.8
alter VB2 = $&drive
let drive = (floor(trial / 8) - 2*floor(trial / 16))*1.8
alter VB3 = $&drive
let drive = (floor(trial / 16) - 2*floor(trial / 32))*1.8
alter VB4 = $&drive
let drive = (floor(trial / 32) - 2*floor(trial / 64))*1.8
alter VB5 = $&drive
let drive = (floor(trial / 64) - 2*floor(trial / 128))*1.8
alter VB6 = $&drive
let drive = (floor(trial / 128) - 2*floor(trial / 256))*1.8
alter VB7 = $&drive
stop when time = 0.003288
resume
delete all
let endpoint = length(time)-1
let cmp = v(COMP)[endpoint]
let top = v(TOP)[endpoint]
let decision = 0
if cmp >= 0.9
let code = trial
let decision = 1
end
echo 182 3 $&trial $&cmp $&top 0.84140625 $&decision >> decisions.csv
let trial = code + 4
let drive = (floor(trial / 1) - 2*floor(trial / 2))*1.8
alter VB0 = $&drive
let drive = (floor(trial / 2) - 2*floor(trial / 4))*1.8
alter VB1 = $&drive
let drive = (floor(trial / 4) - 2*floor(trial / 8))*1.8
alter VB2 = $&drive
let drive = (floor(trial / 8) - 2*floor(trial / 16))*1.8
alter VB3 = $&drive
let drive = (floor(trial / 16) - 2*floor(trial / 32))*1.8
alter VB4 = $&drive
let drive = (floor(trial / 32) - 2*floor(trial / 64))*1.8
alter VB5 = $&drive
let drive = (floor(trial / 64) - 2*floor(trial / 128))*1.8
alter VB6 = $&drive
let drive = (floor(trial / 128) - 2*floor(trial / 256))*1.8
alter VB7 = $&drive
stop when time = 0.00329
resume
delete all
let endpoint = length(time)-1
let cmp = v(COMP)[endpoint]
let top = v(TOP)[endpoint]
let decision = 0
if cmp >= 0.9
let code = trial
let decision = 1
end
echo 182 2 $&trial $&cmp $&top 0.84140625 $&decision >> decisions.csv
let trial = code + 2
let drive = (floor(trial / 1) - 2*floor(trial / 2))*1.8
alter VB0 = $&drive
let drive = (floor(trial / 2) - 2*floor(trial / 4))*1.8
alter VB1 = $&drive
let drive = (floor(trial / 4) - 2*floor(trial / 8))*1.8
alter VB2 = $&drive
let drive = (floor(trial / 8) - 2*floor(trial / 16))*1.8
alter VB3 = $&drive
let drive = (floor(trial / 16) - 2*floor(trial / 32))*1.8
alter VB4 = $&drive
let drive = (floor(trial / 32) - 2*floor(trial / 64))*1.8
alter VB5 = $&drive
let drive = (floor(trial / 64) - 2*floor(trial / 128))*1.8
alter VB6 = $&drive
let drive = (floor(trial / 128) - 2*floor(trial / 256))*1.8
alter VB7 = $&drive
stop when time = 0.003292
resume
delete all
let endpoint = length(time)-1
let cmp = v(COMP)[endpoint]
let top = v(TOP)[endpoint]
let decision = 0
if cmp >= 0.9
let code = trial
let decision = 1
end
echo 182 1 $&trial $&cmp $&top 0.84140625 $&decision >> decisions.csv
let trial = code + 1
let drive = (floor(trial / 1) - 2*floor(trial / 2))*1.8
alter VB0 = $&drive
let drive = (floor(trial / 2) - 2*floor(trial / 4))*1.8
alter VB1 = $&drive
let drive = (floor(trial / 4) - 2*floor(trial / 8))*1.8
alter VB2 = $&drive
let drive = (floor(trial / 8) - 2*floor(trial / 16))*1.8
alter VB3 = $&drive
let drive = (floor(trial / 16) - 2*floor(trial / 32))*1.8
alter VB4 = $&drive
let drive = (floor(trial / 32) - 2*floor(trial / 64))*1.8
alter VB5 = $&drive
let drive = (floor(trial / 64) - 2*floor(trial / 128))*1.8
alter VB6 = $&drive
let drive = (floor(trial / 128) - 2*floor(trial / 256))*1.8
alter VB7 = $&drive
stop when time = 0.003294
resume
delete all
let endpoint = length(time)-1
let cmp = v(COMP)[endpoint]
let top = v(TOP)[endpoint]
let decision = 0
if cmp >= 0.9
let code = trial
let decision = 1
end
echo 182 0 $&trial $&cmp $&top 0.84140625 $&decision >> decisions.csv
alter VIN = 0.84609375
alter VSAMPLE = 1.8
alter VB0 = 0
alter VB1 = 0
alter VB2 = 0
alter VB3 = 0
alter VB4 = 0
alter VB5 = 0
alter VB6 = 0
alter VB7 = 0
let code = 0
stop when time = 0.003296
resume
delete all
alter VSAMPLE = 0
let trial = code + 128
let drive = (floor(trial / 1) - 2*floor(trial / 2))*1.8
alter VB0 = $&drive
let drive = (floor(trial / 2) - 2*floor(trial / 4))*1.8
alter VB1 = $&drive
let drive = (floor(trial / 4) - 2*floor(trial / 8))*1.8
alter VB2 = $&drive
let drive = (floor(trial / 8) - 2*floor(trial / 16))*1.8
alter VB3 = $&drive
let drive = (floor(trial / 16) - 2*floor(trial / 32))*1.8
alter VB4 = $&drive
let drive = (floor(trial / 32) - 2*floor(trial / 64))*1.8
alter VB5 = $&drive
let drive = (floor(trial / 64) - 2*floor(trial / 128))*1.8
alter VB6 = $&drive
let drive = (floor(trial / 128) - 2*floor(trial / 256))*1.8
alter VB7 = $&drive
stop when time = 0.003298
resume
delete all
let endpoint = length(time)-1
let cmp = v(COMP)[endpoint]
let top = v(TOP)[endpoint]
let decision = 0
if cmp >= 0.9
let code = trial
let decision = 1
end
echo 183 7 $&trial $&cmp $&top 0.84609375 $&decision >> decisions.csv
let trial = code + 64
let drive = (floor(trial / 1) - 2*floor(trial / 2))*1.8
alter VB0 = $&drive
let drive = (floor(trial / 2) - 2*floor(trial / 4))*1.8
alter VB1 = $&drive
let drive = (floor(trial / 4) - 2*floor(trial / 8))*1.8
alter VB2 = $&drive
let drive = (floor(trial / 8) - 2*floor(trial / 16))*1.8
alter VB3 = $&drive
let drive = (floor(trial / 16) - 2*floor(trial / 32))*1.8
alter VB4 = $&drive
let drive = (floor(trial / 32) - 2*floor(trial / 64))*1.8
alter VB5 = $&drive
let drive = (floor(trial / 64) - 2*floor(trial / 128))*1.8
alter VB6 = $&drive
let drive = (floor(trial / 128) - 2*floor(trial / 256))*1.8
alter VB7 = $&drive
stop when time = 0.0033
resume
delete all
let endpoint = length(time)-1
let cmp = v(COMP)[endpoint]
let top = v(TOP)[endpoint]
let decision = 0
if cmp >= 0.9
let code = trial
let decision = 1
end
echo 183 6 $&trial $&cmp $&top 0.84609375 $&decision >> decisions.csv
let trial = code + 32
let drive = (floor(trial / 1) - 2*floor(trial / 2))*1.8
alter VB0 = $&drive
let drive = (floor(trial / 2) - 2*floor(trial / 4))*1.8
alter VB1 = $&drive
let drive = (floor(trial / 4) - 2*floor(trial / 8))*1.8
alter VB2 = $&drive
let drive = (floor(trial / 8) - 2*floor(trial / 16))*1.8
alter VB3 = $&drive
let drive = (floor(trial / 16) - 2*floor(trial / 32))*1.8
alter VB4 = $&drive
let drive = (floor(trial / 32) - 2*floor(trial / 64))*1.8
alter VB5 = $&drive
let drive = (floor(trial / 64) - 2*floor(trial / 128))*1.8
alter VB6 = $&drive
let drive = (floor(trial / 128) - 2*floor(trial / 256))*1.8
alter VB7 = $&drive
stop when time = 0.003302
resume
delete all
let endpoint = length(time)-1
let cmp = v(COMP)[endpoint]
let top = v(TOP)[endpoint]
let decision = 0
if cmp >= 0.9
let code = trial
let decision = 1
end
echo 183 5 $&trial $&cmp $&top 0.84609375 $&decision >> decisions.csv
let trial = code + 16
let drive = (floor(trial / 1) - 2*floor(trial / 2))*1.8
alter VB0 = $&drive
let drive = (floor(trial / 2) - 2*floor(trial / 4))*1.8
alter VB1 = $&drive
let drive = (floor(trial / 4) - 2*floor(trial / 8))*1.8
alter VB2 = $&drive
let drive = (floor(trial / 8) - 2*floor(trial / 16))*1.8
alter VB3 = $&drive
let drive = (floor(trial / 16) - 2*floor(trial / 32))*1.8
alter VB4 = $&drive
let drive = (floor(trial / 32) - 2*floor(trial / 64))*1.8
alter VB5 = $&drive
let drive = (floor(trial / 64) - 2*floor(trial / 128))*1.8
alter VB6 = $&drive
let drive = (floor(trial / 128) - 2*floor(trial / 256))*1.8
alter VB7 = $&drive
stop when time = 0.003304
resume
delete all
let endpoint = length(time)-1
let cmp = v(COMP)[endpoint]
let top = v(TOP)[endpoint]
let decision = 0
if cmp >= 0.9
let code = trial
let decision = 1
end
echo 183 4 $&trial $&cmp $&top 0.84609375 $&decision >> decisions.csv
let trial = code + 8
let drive = (floor(trial / 1) - 2*floor(trial / 2))*1.8
alter VB0 = $&drive
let drive = (floor(trial / 2) - 2*floor(trial / 4))*1.8
alter VB1 = $&drive
let drive = (floor(trial / 4) - 2*floor(trial / 8))*1.8
alter VB2 = $&drive
let drive = (floor(trial / 8) - 2*floor(trial / 16))*1.8
alter VB3 = $&drive
let drive = (floor(trial / 16) - 2*floor(trial / 32))*1.8
alter VB4 = $&drive
let drive = (floor(trial / 32) - 2*floor(trial / 64))*1.8
alter VB5 = $&drive
let drive = (floor(trial / 64) - 2*floor(trial / 128))*1.8
alter VB6 = $&drive
let drive = (floor(trial / 128) - 2*floor(trial / 256))*1.8
alter VB7 = $&drive
stop when time = 0.003306
resume
delete all
let endpoint = length(time)-1
let cmp = v(COMP)[endpoint]
let top = v(TOP)[endpoint]
let decision = 0
if cmp >= 0.9
let code = trial
let decision = 1
end
echo 183 3 $&trial $&cmp $&top 0.84609375 $&decision >> decisions.csv
let trial = code + 4
let drive = (floor(trial / 1) - 2*floor(trial / 2))*1.8
alter VB0 = $&drive
let drive = (floor(trial / 2) - 2*floor(trial / 4))*1.8
alter VB1 = $&drive
let drive = (floor(trial / 4) - 2*floor(trial / 8))*1.8
alter VB2 = $&drive
let drive = (floor(trial / 8) - 2*floor(trial / 16))*1.8
alter VB3 = $&drive
let drive = (floor(trial / 16) - 2*floor(trial / 32))*1.8
alter VB4 = $&drive
let drive = (floor(trial / 32) - 2*floor(trial / 64))*1.8
alter VB5 = $&drive
let drive = (floor(trial / 64) - 2*floor(trial / 128))*1.8
alter VB6 = $&drive
let drive = (floor(trial / 128) - 2*floor(trial / 256))*1.8
alter VB7 = $&drive
stop when time = 0.003308
resume
delete all
let endpoint = length(time)-1
let cmp = v(COMP)[endpoint]
let top = v(TOP)[endpoint]
let decision = 0
if cmp >= 0.9
let code = trial
let decision = 1
end
echo 183 2 $&trial $&cmp $&top 0.84609375 $&decision >> decisions.csv
let trial = code + 2
let drive = (floor(trial / 1) - 2*floor(trial / 2))*1.8
alter VB0 = $&drive
let drive = (floor(trial / 2) - 2*floor(trial / 4))*1.8
alter VB1 = $&drive
let drive = (floor(trial / 4) - 2*floor(trial / 8))*1.8
alter VB2 = $&drive
let drive = (floor(trial / 8) - 2*floor(trial / 16))*1.8
alter VB3 = $&drive
let drive = (floor(trial / 16) - 2*floor(trial / 32))*1.8
alter VB4 = $&drive
let drive = (floor(trial / 32) - 2*floor(trial / 64))*1.8
alter VB5 = $&drive
let drive = (floor(trial / 64) - 2*floor(trial / 128))*1.8
alter VB6 = $&drive
let drive = (floor(trial / 128) - 2*floor(trial / 256))*1.8
alter VB7 = $&drive
stop when time = 0.00331
resume
delete all
let endpoint = length(time)-1
let cmp = v(COMP)[endpoint]
let top = v(TOP)[endpoint]
let decision = 0
if cmp >= 0.9
let code = trial
let decision = 1
end
echo 183 1 $&trial $&cmp $&top 0.84609375 $&decision >> decisions.csv
let trial = code + 1
let drive = (floor(trial / 1) - 2*floor(trial / 2))*1.8
alter VB0 = $&drive
let drive = (floor(trial / 2) - 2*floor(trial / 4))*1.8
alter VB1 = $&drive
let drive = (floor(trial / 4) - 2*floor(trial / 8))*1.8
alter VB2 = $&drive
let drive = (floor(trial / 8) - 2*floor(trial / 16))*1.8
alter VB3 = $&drive
let drive = (floor(trial / 16) - 2*floor(trial / 32))*1.8
alter VB4 = $&drive
let drive = (floor(trial / 32) - 2*floor(trial / 64))*1.8
alter VB5 = $&drive
let drive = (floor(trial / 64) - 2*floor(trial / 128))*1.8
alter VB6 = $&drive
let drive = (floor(trial / 128) - 2*floor(trial / 256))*1.8
alter VB7 = $&drive
stop when time = 0.003312
resume
delete all
let endpoint = length(time)-1
let cmp = v(COMP)[endpoint]
let top = v(TOP)[endpoint]
let decision = 0
if cmp >= 0.9
let code = trial
let decision = 1
end
echo 183 0 $&trial $&cmp $&top 0.84609375 $&decision >> decisions.csv
alter VIN = 0.85078125
alter VSAMPLE = 1.8
alter VB0 = 0
alter VB1 = 0
alter VB2 = 0
alter VB3 = 0
alter VB4 = 0
alter VB5 = 0
alter VB6 = 0
alter VB7 = 0
let code = 0
stop when time = 0.003314
resume
delete all
alter VSAMPLE = 0
let trial = code + 128
let drive = (floor(trial / 1) - 2*floor(trial / 2))*1.8
alter VB0 = $&drive
let drive = (floor(trial / 2) - 2*floor(trial / 4))*1.8
alter VB1 = $&drive
let drive = (floor(trial / 4) - 2*floor(trial / 8))*1.8
alter VB2 = $&drive
let drive = (floor(trial / 8) - 2*floor(trial / 16))*1.8
alter VB3 = $&drive
let drive = (floor(trial / 16) - 2*floor(trial / 32))*1.8
alter VB4 = $&drive
let drive = (floor(trial / 32) - 2*floor(trial / 64))*1.8
alter VB5 = $&drive
let drive = (floor(trial / 64) - 2*floor(trial / 128))*1.8
alter VB6 = $&drive
let drive = (floor(trial / 128) - 2*floor(trial / 256))*1.8
alter VB7 = $&drive
stop when time = 0.003316
resume
delete all
let endpoint = length(time)-1
let cmp = v(COMP)[endpoint]
let top = v(TOP)[endpoint]
let decision = 0
if cmp >= 0.9
let code = trial
let decision = 1
end
echo 184 7 $&trial $&cmp $&top 0.85078125 $&decision >> decisions.csv
let trial = code + 64
let drive = (floor(trial / 1) - 2*floor(trial / 2))*1.8
alter VB0 = $&drive
let drive = (floor(trial / 2) - 2*floor(trial / 4))*1.8
alter VB1 = $&drive
let drive = (floor(trial / 4) - 2*floor(trial / 8))*1.8
alter VB2 = $&drive
let drive = (floor(trial / 8) - 2*floor(trial / 16))*1.8
alter VB3 = $&drive
let drive = (floor(trial / 16) - 2*floor(trial / 32))*1.8
alter VB4 = $&drive
let drive = (floor(trial / 32) - 2*floor(trial / 64))*1.8
alter VB5 = $&drive
let drive = (floor(trial / 64) - 2*floor(trial / 128))*1.8
alter VB6 = $&drive
let drive = (floor(trial / 128) - 2*floor(trial / 256))*1.8
alter VB7 = $&drive
stop when time = 0.003318
resume
delete all
let endpoint = length(time)-1
let cmp = v(COMP)[endpoint]
let top = v(TOP)[endpoint]
let decision = 0
if cmp >= 0.9
let code = trial
let decision = 1
end
echo 184 6 $&trial $&cmp $&top 0.85078125 $&decision >> decisions.csv
let trial = code + 32
let drive = (floor(trial / 1) - 2*floor(trial / 2))*1.8
alter VB0 = $&drive
let drive = (floor(trial / 2) - 2*floor(trial / 4))*1.8
alter VB1 = $&drive
let drive = (floor(trial / 4) - 2*floor(trial / 8))*1.8
alter VB2 = $&drive
let drive = (floor(trial / 8) - 2*floor(trial / 16))*1.8
alter VB3 = $&drive
let drive = (floor(trial / 16) - 2*floor(trial / 32))*1.8
alter VB4 = $&drive
let drive = (floor(trial / 32) - 2*floor(trial / 64))*1.8
alter VB5 = $&drive
let drive = (floor(trial / 64) - 2*floor(trial / 128))*1.8
alter VB6 = $&drive
let drive = (floor(trial / 128) - 2*floor(trial / 256))*1.8
alter VB7 = $&drive
stop when time = 0.00332
resume
delete all
let endpoint = length(time)-1
let cmp = v(COMP)[endpoint]
let top = v(TOP)[endpoint]
let decision = 0
if cmp >= 0.9
let code = trial
let decision = 1
end
echo 184 5 $&trial $&cmp $&top 0.85078125 $&decision >> decisions.csv
let trial = code + 16
let drive = (floor(trial / 1) - 2*floor(trial / 2))*1.8
alter VB0 = $&drive
let drive = (floor(trial / 2) - 2*floor(trial / 4))*1.8
alter VB1 = $&drive
let drive = (floor(trial / 4) - 2*floor(trial / 8))*1.8
alter VB2 = $&drive
let drive = (floor(trial / 8) - 2*floor(trial / 16))*1.8
alter VB3 = $&drive
let drive = (floor(trial / 16) - 2*floor(trial / 32))*1.8
alter VB4 = $&drive
let drive = (floor(trial / 32) - 2*floor(trial / 64))*1.8
alter VB5 = $&drive
let drive = (floor(trial / 64) - 2*floor(trial / 128))*1.8
alter VB6 = $&drive
let drive = (floor(trial / 128) - 2*floor(trial / 256))*1.8
alter VB7 = $&drive
stop when time = 0.003322
resume
delete all
let endpoint = length(time)-1
let cmp = v(COMP)[endpoint]
let top = v(TOP)[endpoint]
let decision = 0
if cmp >= 0.9
let code = trial
let decision = 1
end
echo 184 4 $&trial $&cmp $&top 0.85078125 $&decision >> decisions.csv
let trial = code + 8
let drive = (floor(trial / 1) - 2*floor(trial / 2))*1.8
alter VB0 = $&drive
let drive = (floor(trial / 2) - 2*floor(trial / 4))*1.8
alter VB1 = $&drive
let drive = (floor(trial / 4) - 2*floor(trial / 8))*1.8
alter VB2 = $&drive
let drive = (floor(trial / 8) - 2*floor(trial / 16))*1.8
alter VB3 = $&drive
let drive = (floor(trial / 16) - 2*floor(trial / 32))*1.8
alter VB4 = $&drive
let drive = (floor(trial / 32) - 2*floor(trial / 64))*1.8
alter VB5 = $&drive
let drive = (floor(trial / 64) - 2*floor(trial / 128))*1.8
alter VB6 = $&drive
let drive = (floor(trial / 128) - 2*floor(trial / 256))*1.8
alter VB7 = $&drive
stop when time = 0.003324
resume
delete all
let endpoint = length(time)-1
let cmp = v(COMP)[endpoint]
let top = v(TOP)[endpoint]
let decision = 0
if cmp >= 0.9
let code = trial
let decision = 1
end
echo 184 3 $&trial $&cmp $&top 0.85078125 $&decision >> decisions.csv
let trial = code + 4
let drive = (floor(trial / 1) - 2*floor(trial / 2))*1.8
alter VB0 = $&drive
let drive = (floor(trial / 2) - 2*floor(trial / 4))*1.8
alter VB1 = $&drive
let drive = (floor(trial / 4) - 2*floor(trial / 8))*1.8
alter VB2 = $&drive
let drive = (floor(trial / 8) - 2*floor(trial / 16))*1.8
alter VB3 = $&drive
let drive = (floor(trial / 16) - 2*floor(trial / 32))*1.8
alter VB4 = $&drive
let drive = (floor(trial / 32) - 2*floor(trial / 64))*1.8
alter VB5 = $&drive
let drive = (floor(trial / 64) - 2*floor(trial / 128))*1.8
alter VB6 = $&drive
let drive = (floor(trial / 128) - 2*floor(trial / 256))*1.8
alter VB7 = $&drive
stop when time = 0.003326
resume
delete all
let endpoint = length(time)-1
let cmp = v(COMP)[endpoint]
let top = v(TOP)[endpoint]
let decision = 0
if cmp >= 0.9
let code = trial
let decision = 1
end
echo 184 2 $&trial $&cmp $&top 0.85078125 $&decision >> decisions.csv
let trial = code + 2
let drive = (floor(trial / 1) - 2*floor(trial / 2))*1.8
alter VB0 = $&drive
let drive = (floor(trial / 2) - 2*floor(trial / 4))*1.8
alter VB1 = $&drive
let drive = (floor(trial / 4) - 2*floor(trial / 8))*1.8
alter VB2 = $&drive
let drive = (floor(trial / 8) - 2*floor(trial / 16))*1.8
alter VB3 = $&drive
let drive = (floor(trial / 16) - 2*floor(trial / 32))*1.8
alter VB4 = $&drive
let drive = (floor(trial / 32) - 2*floor(trial / 64))*1.8
alter VB5 = $&drive
let drive = (floor(trial / 64) - 2*floor(trial / 128))*1.8
alter VB6 = $&drive
let drive = (floor(trial / 128) - 2*floor(trial / 256))*1.8
alter VB7 = $&drive
stop when time = 0.003328
resume
delete all
let endpoint = length(time)-1
let cmp = v(COMP)[endpoint]
let top = v(TOP)[endpoint]
let decision = 0
if cmp >= 0.9
let code = trial
let decision = 1
end
echo 184 1 $&trial $&cmp $&top 0.85078125 $&decision >> decisions.csv
let trial = code + 1
let drive = (floor(trial / 1) - 2*floor(trial / 2))*1.8
alter VB0 = $&drive
let drive = (floor(trial / 2) - 2*floor(trial / 4))*1.8
alter VB1 = $&drive
let drive = (floor(trial / 4) - 2*floor(trial / 8))*1.8
alter VB2 = $&drive
let drive = (floor(trial / 8) - 2*floor(trial / 16))*1.8
alter VB3 = $&drive
let drive = (floor(trial / 16) - 2*floor(trial / 32))*1.8
alter VB4 = $&drive
let drive = (floor(trial / 32) - 2*floor(trial / 64))*1.8
alter VB5 = $&drive
let drive = (floor(trial / 64) - 2*floor(trial / 128))*1.8
alter VB6 = $&drive
let drive = (floor(trial / 128) - 2*floor(trial / 256))*1.8
alter VB7 = $&drive
stop when time = 0.00333
resume
delete all
let endpoint = length(time)-1
let cmp = v(COMP)[endpoint]
let top = v(TOP)[endpoint]
let decision = 0
if cmp >= 0.9
let code = trial
let decision = 1
end
echo 184 0 $&trial $&cmp $&top 0.85078125 $&decision >> decisions.csv
alter VIN = 0.85546875
alter VSAMPLE = 1.8
alter VB0 = 0
alter VB1 = 0
alter VB2 = 0
alter VB3 = 0
alter VB4 = 0
alter VB5 = 0
alter VB6 = 0
alter VB7 = 0
let code = 0
stop when time = 0.003332
resume
delete all
alter VSAMPLE = 0
let trial = code + 128
let drive = (floor(trial / 1) - 2*floor(trial / 2))*1.8
alter VB0 = $&drive
let drive = (floor(trial / 2) - 2*floor(trial / 4))*1.8
alter VB1 = $&drive
let drive = (floor(trial / 4) - 2*floor(trial / 8))*1.8
alter VB2 = $&drive
let drive = (floor(trial / 8) - 2*floor(trial / 16))*1.8
alter VB3 = $&drive
let drive = (floor(trial / 16) - 2*floor(trial / 32))*1.8
alter VB4 = $&drive
let drive = (floor(trial / 32) - 2*floor(trial / 64))*1.8
alter VB5 = $&drive
let drive = (floor(trial / 64) - 2*floor(trial / 128))*1.8
alter VB6 = $&drive
let drive = (floor(trial / 128) - 2*floor(trial / 256))*1.8
alter VB7 = $&drive
stop when time = 0.003334
resume
delete all
let endpoint = length(time)-1
let cmp = v(COMP)[endpoint]
let top = v(TOP)[endpoint]
let decision = 0
if cmp >= 0.9
let code = trial
let decision = 1
end
echo 185 7 $&trial $&cmp $&top 0.85546875 $&decision >> decisions.csv
let trial = code + 64
let drive = (floor(trial / 1) - 2*floor(trial / 2))*1.8
alter VB0 = $&drive
let drive = (floor(trial / 2) - 2*floor(trial / 4))*1.8
alter VB1 = $&drive
let drive = (floor(trial / 4) - 2*floor(trial / 8))*1.8
alter VB2 = $&drive
let drive = (floor(trial / 8) - 2*floor(trial / 16))*1.8
alter VB3 = $&drive
let drive = (floor(trial / 16) - 2*floor(trial / 32))*1.8
alter VB4 = $&drive
let drive = (floor(trial / 32) - 2*floor(trial / 64))*1.8
alter VB5 = $&drive
let drive = (floor(trial / 64) - 2*floor(trial / 128))*1.8
alter VB6 = $&drive
let drive = (floor(trial / 128) - 2*floor(trial / 256))*1.8
alter VB7 = $&drive
stop when time = 0.003336
resume
delete all
let endpoint = length(time)-1
let cmp = v(COMP)[endpoint]
let top = v(TOP)[endpoint]
let decision = 0
if cmp >= 0.9
let code = trial
let decision = 1
end
echo 185 6 $&trial $&cmp $&top 0.85546875 $&decision >> decisions.csv
let trial = code + 32
let drive = (floor(trial / 1) - 2*floor(trial / 2))*1.8
alter VB0 = $&drive
let drive = (floor(trial / 2) - 2*floor(trial / 4))*1.8
alter VB1 = $&drive
let drive = (floor(trial / 4) - 2*floor(trial / 8))*1.8
alter VB2 = $&drive
let drive = (floor(trial / 8) - 2*floor(trial / 16))*1.8
alter VB3 = $&drive
let drive = (floor(trial / 16) - 2*floor(trial / 32))*1.8
alter VB4 = $&drive
let drive = (floor(trial / 32) - 2*floor(trial / 64))*1.8
alter VB5 = $&drive
let drive = (floor(trial / 64) - 2*floor(trial / 128))*1.8
alter VB6 = $&drive
let drive = (floor(trial / 128) - 2*floor(trial / 256))*1.8
alter VB7 = $&drive
stop when time = 0.003338
resume
delete all
let endpoint = length(time)-1
let cmp = v(COMP)[endpoint]
let top = v(TOP)[endpoint]
let decision = 0
if cmp >= 0.9
let code = trial
let decision = 1
end
echo 185 5 $&trial $&cmp $&top 0.85546875 $&decision >> decisions.csv
let trial = code + 16
let drive = (floor(trial / 1) - 2*floor(trial / 2))*1.8
alter VB0 = $&drive
let drive = (floor(trial / 2) - 2*floor(trial / 4))*1.8
alter VB1 = $&drive
let drive = (floor(trial / 4) - 2*floor(trial / 8))*1.8
alter VB2 = $&drive
let drive = (floor(trial / 8) - 2*floor(trial / 16))*1.8
alter VB3 = $&drive
let drive = (floor(trial / 16) - 2*floor(trial / 32))*1.8
alter VB4 = $&drive
let drive = (floor(trial / 32) - 2*floor(trial / 64))*1.8
alter VB5 = $&drive
let drive = (floor(trial / 64) - 2*floor(trial / 128))*1.8
alter VB6 = $&drive
let drive = (floor(trial / 128) - 2*floor(trial / 256))*1.8
alter VB7 = $&drive
stop when time = 0.00334
resume
delete all
let endpoint = length(time)-1
let cmp = v(COMP)[endpoint]
let top = v(TOP)[endpoint]
let decision = 0
if cmp >= 0.9
let code = trial
let decision = 1
end
echo 185 4 $&trial $&cmp $&top 0.85546875 $&decision >> decisions.csv
let trial = code + 8
let drive = (floor(trial / 1) - 2*floor(trial / 2))*1.8
alter VB0 = $&drive
let drive = (floor(trial / 2) - 2*floor(trial / 4))*1.8
alter VB1 = $&drive
let drive = (floor(trial / 4) - 2*floor(trial / 8))*1.8
alter VB2 = $&drive
let drive = (floor(trial / 8) - 2*floor(trial / 16))*1.8
alter VB3 = $&drive
let drive = (floor(trial / 16) - 2*floor(trial / 32))*1.8
alter VB4 = $&drive
let drive = (floor(trial / 32) - 2*floor(trial / 64))*1.8
alter VB5 = $&drive
let drive = (floor(trial / 64) - 2*floor(trial / 128))*1.8
alter VB6 = $&drive
let drive = (floor(trial / 128) - 2*floor(trial / 256))*1.8
alter VB7 = $&drive
stop when time = 0.003342
resume
delete all
let endpoint = length(time)-1
let cmp = v(COMP)[endpoint]
let top = v(TOP)[endpoint]
let decision = 0
if cmp >= 0.9
let code = trial
let decision = 1
end
echo 185 3 $&trial $&cmp $&top 0.85546875 $&decision >> decisions.csv
let trial = code + 4
let drive = (floor(trial / 1) - 2*floor(trial / 2))*1.8
alter VB0 = $&drive
let drive = (floor(trial / 2) - 2*floor(trial / 4))*1.8
alter VB1 = $&drive
let drive = (floor(trial / 4) - 2*floor(trial / 8))*1.8
alter VB2 = $&drive
let drive = (floor(trial / 8) - 2*floor(trial / 16))*1.8
alter VB3 = $&drive
let drive = (floor(trial / 16) - 2*floor(trial / 32))*1.8
alter VB4 = $&drive
let drive = (floor(trial / 32) - 2*floor(trial / 64))*1.8
alter VB5 = $&drive
let drive = (floor(trial / 64) - 2*floor(trial / 128))*1.8
alter VB6 = $&drive
let drive = (floor(trial / 128) - 2*floor(trial / 256))*1.8
alter VB7 = $&drive
stop when time = 0.003344
resume
delete all
let endpoint = length(time)-1
let cmp = v(COMP)[endpoint]
let top = v(TOP)[endpoint]
let decision = 0
if cmp >= 0.9
let code = trial
let decision = 1
end
echo 185 2 $&trial $&cmp $&top 0.85546875 $&decision >> decisions.csv
let trial = code + 2
let drive = (floor(trial / 1) - 2*floor(trial / 2))*1.8
alter VB0 = $&drive
let drive = (floor(trial / 2) - 2*floor(trial / 4))*1.8
alter VB1 = $&drive
let drive = (floor(trial / 4) - 2*floor(trial / 8))*1.8
alter VB2 = $&drive
let drive = (floor(trial / 8) - 2*floor(trial / 16))*1.8
alter VB3 = $&drive
let drive = (floor(trial / 16) - 2*floor(trial / 32))*1.8
alter VB4 = $&drive
let drive = (floor(trial / 32) - 2*floor(trial / 64))*1.8
alter VB5 = $&drive
let drive = (floor(trial / 64) - 2*floor(trial / 128))*1.8
alter VB6 = $&drive
let drive = (floor(trial / 128) - 2*floor(trial / 256))*1.8
alter VB7 = $&drive
stop when time = 0.003346
resume
delete all
let endpoint = length(time)-1
let cmp = v(COMP)[endpoint]
let top = v(TOP)[endpoint]
let decision = 0
if cmp >= 0.9
let code = trial
let decision = 1
end
echo 185 1 $&trial $&cmp $&top 0.85546875 $&decision >> decisions.csv
let trial = code + 1
let drive = (floor(trial / 1) - 2*floor(trial / 2))*1.8
alter VB0 = $&drive
let drive = (floor(trial / 2) - 2*floor(trial / 4))*1.8
alter VB1 = $&drive
let drive = (floor(trial / 4) - 2*floor(trial / 8))*1.8
alter VB2 = $&drive
let drive = (floor(trial / 8) - 2*floor(trial / 16))*1.8
alter VB3 = $&drive
let drive = (floor(trial / 16) - 2*floor(trial / 32))*1.8
alter VB4 = $&drive
let drive = (floor(trial / 32) - 2*floor(trial / 64))*1.8
alter VB5 = $&drive
let drive = (floor(trial / 64) - 2*floor(trial / 128))*1.8
alter VB6 = $&drive
let drive = (floor(trial / 128) - 2*floor(trial / 256))*1.8
alter VB7 = $&drive
stop when time = 0.003348
resume
delete all
let endpoint = length(time)-1
let cmp = v(COMP)[endpoint]
let top = v(TOP)[endpoint]
let decision = 0
if cmp >= 0.9
let code = trial
let decision = 1
end
echo 185 0 $&trial $&cmp $&top 0.85546875 $&decision >> decisions.csv
alter VIN = 0.86015625
alter VSAMPLE = 1.8
alter VB0 = 0
alter VB1 = 0
alter VB2 = 0
alter VB3 = 0
alter VB4 = 0
alter VB5 = 0
alter VB6 = 0
alter VB7 = 0
let code = 0
stop when time = 0.00335
resume
delete all
alter VSAMPLE = 0
let trial = code + 128
let drive = (floor(trial / 1) - 2*floor(trial / 2))*1.8
alter VB0 = $&drive
let drive = (floor(trial / 2) - 2*floor(trial / 4))*1.8
alter VB1 = $&drive
let drive = (floor(trial / 4) - 2*floor(trial / 8))*1.8
alter VB2 = $&drive
let drive = (floor(trial / 8) - 2*floor(trial / 16))*1.8
alter VB3 = $&drive
let drive = (floor(trial / 16) - 2*floor(trial / 32))*1.8
alter VB4 = $&drive
let drive = (floor(trial / 32) - 2*floor(trial / 64))*1.8
alter VB5 = $&drive
let drive = (floor(trial / 64) - 2*floor(trial / 128))*1.8
alter VB6 = $&drive
let drive = (floor(trial / 128) - 2*floor(trial / 256))*1.8
alter VB7 = $&drive
stop when time = 0.003352
resume
delete all
let endpoint = length(time)-1
let cmp = v(COMP)[endpoint]
let top = v(TOP)[endpoint]
let decision = 0
if cmp >= 0.9
let code = trial
let decision = 1
end
echo 186 7 $&trial $&cmp $&top 0.86015625 $&decision >> decisions.csv
let trial = code + 64
let drive = (floor(trial / 1) - 2*floor(trial / 2))*1.8
alter VB0 = $&drive
let drive = (floor(trial / 2) - 2*floor(trial / 4))*1.8
alter VB1 = $&drive
let drive = (floor(trial / 4) - 2*floor(trial / 8))*1.8
alter VB2 = $&drive
let drive = (floor(trial / 8) - 2*floor(trial / 16))*1.8
alter VB3 = $&drive
let drive = (floor(trial / 16) - 2*floor(trial / 32))*1.8
alter VB4 = $&drive
let drive = (floor(trial / 32) - 2*floor(trial / 64))*1.8
alter VB5 = $&drive
let drive = (floor(trial / 64) - 2*floor(trial / 128))*1.8
alter VB6 = $&drive
let drive = (floor(trial / 128) - 2*floor(trial / 256))*1.8
alter VB7 = $&drive
stop when time = 0.003354
resume
delete all
let endpoint = length(time)-1
let cmp = v(COMP)[endpoint]
let top = v(TOP)[endpoint]
let decision = 0
if cmp >= 0.9
let code = trial
let decision = 1
end
echo 186 6 $&trial $&cmp $&top 0.86015625 $&decision >> decisions.csv
let trial = code + 32
let drive = (floor(trial / 1) - 2*floor(trial / 2))*1.8
alter VB0 = $&drive
let drive = (floor(trial / 2) - 2*floor(trial / 4))*1.8
alter VB1 = $&drive
let drive = (floor(trial / 4) - 2*floor(trial / 8))*1.8
alter VB2 = $&drive
let drive = (floor(trial / 8) - 2*floor(trial / 16))*1.8
alter VB3 = $&drive
let drive = (floor(trial / 16) - 2*floor(trial / 32))*1.8
alter VB4 = $&drive
let drive = (floor(trial / 32) - 2*floor(trial / 64))*1.8
alter VB5 = $&drive
let drive = (floor(trial / 64) - 2*floor(trial / 128))*1.8
alter VB6 = $&drive
let drive = (floor(trial / 128) - 2*floor(trial / 256))*1.8
alter VB7 = $&drive
stop when time = 0.003356
resume
delete all
let endpoint = length(time)-1
let cmp = v(COMP)[endpoint]
let top = v(TOP)[endpoint]
let decision = 0
if cmp >= 0.9
let code = trial
let decision = 1
end
echo 186 5 $&trial $&cmp $&top 0.86015625 $&decision >> decisions.csv
let trial = code + 16
let drive = (floor(trial / 1) - 2*floor(trial / 2))*1.8
alter VB0 = $&drive
let drive = (floor(trial / 2) - 2*floor(trial / 4))*1.8
alter VB1 = $&drive
let drive = (floor(trial / 4) - 2*floor(trial / 8))*1.8
alter VB2 = $&drive
let drive = (floor(trial / 8) - 2*floor(trial / 16))*1.8
alter VB3 = $&drive
let drive = (floor(trial / 16) - 2*floor(trial / 32))*1.8
alter VB4 = $&drive
let drive = (floor(trial / 32) - 2*floor(trial / 64))*1.8
alter VB5 = $&drive
let drive = (floor(trial / 64) - 2*floor(trial / 128))*1.8
alter VB6 = $&drive
let drive = (floor(trial / 128) - 2*floor(trial / 256))*1.8
alter VB7 = $&drive
stop when time = 0.003358
resume
delete all
let endpoint = length(time)-1
let cmp = v(COMP)[endpoint]
let top = v(TOP)[endpoint]
let decision = 0
if cmp >= 0.9
let code = trial
let decision = 1
end
echo 186 4 $&trial $&cmp $&top 0.86015625 $&decision >> decisions.csv
let trial = code + 8
let drive = (floor(trial / 1) - 2*floor(trial / 2))*1.8
alter VB0 = $&drive
let drive = (floor(trial / 2) - 2*floor(trial / 4))*1.8
alter VB1 = $&drive
let drive = (floor(trial / 4) - 2*floor(trial / 8))*1.8
alter VB2 = $&drive
let drive = (floor(trial / 8) - 2*floor(trial / 16))*1.8
alter VB3 = $&drive
let drive = (floor(trial / 16) - 2*floor(trial / 32))*1.8
alter VB4 = $&drive
let drive = (floor(trial / 32) - 2*floor(trial / 64))*1.8
alter VB5 = $&drive
let drive = (floor(trial / 64) - 2*floor(trial / 128))*1.8
alter VB6 = $&drive
let drive = (floor(trial / 128) - 2*floor(trial / 256))*1.8
alter VB7 = $&drive
stop when time = 0.00336
resume
delete all
let endpoint = length(time)-1
let cmp = v(COMP)[endpoint]
let top = v(TOP)[endpoint]
let decision = 0
if cmp >= 0.9
let code = trial
let decision = 1
end
echo 186 3 $&trial $&cmp $&top 0.86015625 $&decision >> decisions.csv
let trial = code + 4
let drive = (floor(trial / 1) - 2*floor(trial / 2))*1.8
alter VB0 = $&drive
let drive = (floor(trial / 2) - 2*floor(trial / 4))*1.8
alter VB1 = $&drive
let drive = (floor(trial / 4) - 2*floor(trial / 8))*1.8
alter VB2 = $&drive
let drive = (floor(trial / 8) - 2*floor(trial / 16))*1.8
alter VB3 = $&drive
let drive = (floor(trial / 16) - 2*floor(trial / 32))*1.8
alter VB4 = $&drive
let drive = (floor(trial / 32) - 2*floor(trial / 64))*1.8
alter VB5 = $&drive
let drive = (floor(trial / 64) - 2*floor(trial / 128))*1.8
alter VB6 = $&drive
let drive = (floor(trial / 128) - 2*floor(trial / 256))*1.8
alter VB7 = $&drive
stop when time = 0.003362
resume
delete all
let endpoint = length(time)-1
let cmp = v(COMP)[endpoint]
let top = v(TOP)[endpoint]
let decision = 0
if cmp >= 0.9
let code = trial
let decision = 1
end
echo 186 2 $&trial $&cmp $&top 0.86015625 $&decision >> decisions.csv
let trial = code + 2
let drive = (floor(trial / 1) - 2*floor(trial / 2))*1.8
alter VB0 = $&drive
let drive = (floor(trial / 2) - 2*floor(trial / 4))*1.8
alter VB1 = $&drive
let drive = (floor(trial / 4) - 2*floor(trial / 8))*1.8
alter VB2 = $&drive
let drive = (floor(trial / 8) - 2*floor(trial / 16))*1.8
alter VB3 = $&drive
let drive = (floor(trial / 16) - 2*floor(trial / 32))*1.8
alter VB4 = $&drive
let drive = (floor(trial / 32) - 2*floor(trial / 64))*1.8
alter VB5 = $&drive
let drive = (floor(trial / 64) - 2*floor(trial / 128))*1.8
alter VB6 = $&drive
let drive = (floor(trial / 128) - 2*floor(trial / 256))*1.8
alter VB7 = $&drive
stop when time = 0.003364
resume
delete all
let endpoint = length(time)-1
let cmp = v(COMP)[endpoint]
let top = v(TOP)[endpoint]
let decision = 0
if cmp >= 0.9
let code = trial
let decision = 1
end
echo 186 1 $&trial $&cmp $&top 0.86015625 $&decision >> decisions.csv
let trial = code + 1
let drive = (floor(trial / 1) - 2*floor(trial / 2))*1.8
alter VB0 = $&drive
let drive = (floor(trial / 2) - 2*floor(trial / 4))*1.8
alter VB1 = $&drive
let drive = (floor(trial / 4) - 2*floor(trial / 8))*1.8
alter VB2 = $&drive
let drive = (floor(trial / 8) - 2*floor(trial / 16))*1.8
alter VB3 = $&drive
let drive = (floor(trial / 16) - 2*floor(trial / 32))*1.8
alter VB4 = $&drive
let drive = (floor(trial / 32) - 2*floor(trial / 64))*1.8
alter VB5 = $&drive
let drive = (floor(trial / 64) - 2*floor(trial / 128))*1.8
alter VB6 = $&drive
let drive = (floor(trial / 128) - 2*floor(trial / 256))*1.8
alter VB7 = $&drive
stop when time = 0.003366
resume
delete all
let endpoint = length(time)-1
let cmp = v(COMP)[endpoint]
let top = v(TOP)[endpoint]
let decision = 0
if cmp >= 0.9
let code = trial
let decision = 1
end
echo 186 0 $&trial $&cmp $&top 0.86015625 $&decision >> decisions.csv
alter VIN = 0.86484375
alter VSAMPLE = 1.8
alter VB0 = 0
alter VB1 = 0
alter VB2 = 0
alter VB3 = 0
alter VB4 = 0
alter VB5 = 0
alter VB6 = 0
alter VB7 = 0
let code = 0
stop when time = 0.003368
resume
delete all
alter VSAMPLE = 0
let trial = code + 128
let drive = (floor(trial / 1) - 2*floor(trial / 2))*1.8
alter VB0 = $&drive
let drive = (floor(trial / 2) - 2*floor(trial / 4))*1.8
alter VB1 = $&drive
let drive = (floor(trial / 4) - 2*floor(trial / 8))*1.8
alter VB2 = $&drive
let drive = (floor(trial / 8) - 2*floor(trial / 16))*1.8
alter VB3 = $&drive
let drive = (floor(trial / 16) - 2*floor(trial / 32))*1.8
alter VB4 = $&drive
let drive = (floor(trial / 32) - 2*floor(trial / 64))*1.8
alter VB5 = $&drive
let drive = (floor(trial / 64) - 2*floor(trial / 128))*1.8
alter VB6 = $&drive
let drive = (floor(trial / 128) - 2*floor(trial / 256))*1.8
alter VB7 = $&drive
stop when time = 0.00337
resume
delete all
let endpoint = length(time)-1
let cmp = v(COMP)[endpoint]
let top = v(TOP)[endpoint]
let decision = 0
if cmp >= 0.9
let code = trial
let decision = 1
end
echo 187 7 $&trial $&cmp $&top 0.86484375 $&decision >> decisions.csv
let trial = code + 64
let drive = (floor(trial / 1) - 2*floor(trial / 2))*1.8
alter VB0 = $&drive
let drive = (floor(trial / 2) - 2*floor(trial / 4))*1.8
alter VB1 = $&drive
let drive = (floor(trial / 4) - 2*floor(trial / 8))*1.8
alter VB2 = $&drive
let drive = (floor(trial / 8) - 2*floor(trial / 16))*1.8
alter VB3 = $&drive
let drive = (floor(trial / 16) - 2*floor(trial / 32))*1.8
alter VB4 = $&drive
let drive = (floor(trial / 32) - 2*floor(trial / 64))*1.8
alter VB5 = $&drive
let drive = (floor(trial / 64) - 2*floor(trial / 128))*1.8
alter VB6 = $&drive
let drive = (floor(trial / 128) - 2*floor(trial / 256))*1.8
alter VB7 = $&drive
stop when time = 0.003372
resume
delete all
let endpoint = length(time)-1
let cmp = v(COMP)[endpoint]
let top = v(TOP)[endpoint]
let decision = 0
if cmp >= 0.9
let code = trial
let decision = 1
end
echo 187 6 $&trial $&cmp $&top 0.86484375 $&decision >> decisions.csv
let trial = code + 32
let drive = (floor(trial / 1) - 2*floor(trial / 2))*1.8
alter VB0 = $&drive
let drive = (floor(trial / 2) - 2*floor(trial / 4))*1.8
alter VB1 = $&drive
let drive = (floor(trial / 4) - 2*floor(trial / 8))*1.8
alter VB2 = $&drive
let drive = (floor(trial / 8) - 2*floor(trial / 16))*1.8
alter VB3 = $&drive
let drive = (floor(trial / 16) - 2*floor(trial / 32))*1.8
alter VB4 = $&drive
let drive = (floor(trial / 32) - 2*floor(trial / 64))*1.8
alter VB5 = $&drive
let drive = (floor(trial / 64) - 2*floor(trial / 128))*1.8
alter VB6 = $&drive
let drive = (floor(trial / 128) - 2*floor(trial / 256))*1.8
alter VB7 = $&drive
stop when time = 0.003374
resume
delete all
let endpoint = length(time)-1
let cmp = v(COMP)[endpoint]
let top = v(TOP)[endpoint]
let decision = 0
if cmp >= 0.9
let code = trial
let decision = 1
end
echo 187 5 $&trial $&cmp $&top 0.86484375 $&decision >> decisions.csv
let trial = code + 16
let drive = (floor(trial / 1) - 2*floor(trial / 2))*1.8
alter VB0 = $&drive
let drive = (floor(trial / 2) - 2*floor(trial / 4))*1.8
alter VB1 = $&drive
let drive = (floor(trial / 4) - 2*floor(trial / 8))*1.8
alter VB2 = $&drive
let drive = (floor(trial / 8) - 2*floor(trial / 16))*1.8
alter VB3 = $&drive
let drive = (floor(trial / 16) - 2*floor(trial / 32))*1.8
alter VB4 = $&drive
let drive = (floor(trial / 32) - 2*floor(trial / 64))*1.8
alter VB5 = $&drive
let drive = (floor(trial / 64) - 2*floor(trial / 128))*1.8
alter VB6 = $&drive
let drive = (floor(trial / 128) - 2*floor(trial / 256))*1.8
alter VB7 = $&drive
stop when time = 0.003376
resume
delete all
let endpoint = length(time)-1
let cmp = v(COMP)[endpoint]
let top = v(TOP)[endpoint]
let decision = 0
if cmp >= 0.9
let code = trial
let decision = 1
end
echo 187 4 $&trial $&cmp $&top 0.86484375 $&decision >> decisions.csv
let trial = code + 8
let drive = (floor(trial / 1) - 2*floor(trial / 2))*1.8
alter VB0 = $&drive
let drive = (floor(trial / 2) - 2*floor(trial / 4))*1.8
alter VB1 = $&drive
let drive = (floor(trial / 4) - 2*floor(trial / 8))*1.8
alter VB2 = $&drive
let drive = (floor(trial / 8) - 2*floor(trial / 16))*1.8
alter VB3 = $&drive
let drive = (floor(trial / 16) - 2*floor(trial / 32))*1.8
alter VB4 = $&drive
let drive = (floor(trial / 32) - 2*floor(trial / 64))*1.8
alter VB5 = $&drive
let drive = (floor(trial / 64) - 2*floor(trial / 128))*1.8
alter VB6 = $&drive
let drive = (floor(trial / 128) - 2*floor(trial / 256))*1.8
alter VB7 = $&drive
stop when time = 0.003378
resume
delete all
let endpoint = length(time)-1
let cmp = v(COMP)[endpoint]
let top = v(TOP)[endpoint]
let decision = 0
if cmp >= 0.9
let code = trial
let decision = 1
end
echo 187 3 $&trial $&cmp $&top 0.86484375 $&decision >> decisions.csv
let trial = code + 4
let drive = (floor(trial / 1) - 2*floor(trial / 2))*1.8
alter VB0 = $&drive
let drive = (floor(trial / 2) - 2*floor(trial / 4))*1.8
alter VB1 = $&drive
let drive = (floor(trial / 4) - 2*floor(trial / 8))*1.8
alter VB2 = $&drive
let drive = (floor(trial / 8) - 2*floor(trial / 16))*1.8
alter VB3 = $&drive
let drive = (floor(trial / 16) - 2*floor(trial / 32))*1.8
alter VB4 = $&drive
let drive = (floor(trial / 32) - 2*floor(trial / 64))*1.8
alter VB5 = $&drive
let drive = (floor(trial / 64) - 2*floor(trial / 128))*1.8
alter VB6 = $&drive
let drive = (floor(trial / 128) - 2*floor(trial / 256))*1.8
alter VB7 = $&drive
stop when time = 0.00338
resume
delete all
let endpoint = length(time)-1
let cmp = v(COMP)[endpoint]
let top = v(TOP)[endpoint]
let decision = 0
if cmp >= 0.9
let code = trial
let decision = 1
end
echo 187 2 $&trial $&cmp $&top 0.86484375 $&decision >> decisions.csv
let trial = code + 2
let drive = (floor(trial / 1) - 2*floor(trial / 2))*1.8
alter VB0 = $&drive
let drive = (floor(trial / 2) - 2*floor(trial / 4))*1.8
alter VB1 = $&drive
let drive = (floor(trial / 4) - 2*floor(trial / 8))*1.8
alter VB2 = $&drive
let drive = (floor(trial / 8) - 2*floor(trial / 16))*1.8
alter VB3 = $&drive
let drive = (floor(trial / 16) - 2*floor(trial / 32))*1.8
alter VB4 = $&drive
let drive = (floor(trial / 32) - 2*floor(trial / 64))*1.8
alter VB5 = $&drive
let drive = (floor(trial / 64) - 2*floor(trial / 128))*1.8
alter VB6 = $&drive
let drive = (floor(trial / 128) - 2*floor(trial / 256))*1.8
alter VB7 = $&drive
stop when time = 0.003382
resume
delete all
let endpoint = length(time)-1
let cmp = v(COMP)[endpoint]
let top = v(TOP)[endpoint]
let decision = 0
if cmp >= 0.9
let code = trial
let decision = 1
end
echo 187 1 $&trial $&cmp $&top 0.86484375 $&decision >> decisions.csv
let trial = code + 1
let drive = (floor(trial / 1) - 2*floor(trial / 2))*1.8
alter VB0 = $&drive
let drive = (floor(trial / 2) - 2*floor(trial / 4))*1.8
alter VB1 = $&drive
let drive = (floor(trial / 4) - 2*floor(trial / 8))*1.8
alter VB2 = $&drive
let drive = (floor(trial / 8) - 2*floor(trial / 16))*1.8
alter VB3 = $&drive
let drive = (floor(trial / 16) - 2*floor(trial / 32))*1.8
alter VB4 = $&drive
let drive = (floor(trial / 32) - 2*floor(trial / 64))*1.8
alter VB5 = $&drive
let drive = (floor(trial / 64) - 2*floor(trial / 128))*1.8
alter VB6 = $&drive
let drive = (floor(trial / 128) - 2*floor(trial / 256))*1.8
alter VB7 = $&drive
stop when time = 0.003384
resume
delete all
let endpoint = length(time)-1
let cmp = v(COMP)[endpoint]
let top = v(TOP)[endpoint]
let decision = 0
if cmp >= 0.9
let code = trial
let decision = 1
end
echo 187 0 $&trial $&cmp $&top 0.86484375 $&decision >> decisions.csv
alter VIN = 0.86953125
alter VSAMPLE = 1.8
alter VB0 = 0
alter VB1 = 0
alter VB2 = 0
alter VB3 = 0
alter VB4 = 0
alter VB5 = 0
alter VB6 = 0
alter VB7 = 0
let code = 0
stop when time = 0.003386
resume
delete all
alter VSAMPLE = 0
let trial = code + 128
let drive = (floor(trial / 1) - 2*floor(trial / 2))*1.8
alter VB0 = $&drive
let drive = (floor(trial / 2) - 2*floor(trial / 4))*1.8
alter VB1 = $&drive
let drive = (floor(trial / 4) - 2*floor(trial / 8))*1.8
alter VB2 = $&drive
let drive = (floor(trial / 8) - 2*floor(trial / 16))*1.8
alter VB3 = $&drive
let drive = (floor(trial / 16) - 2*floor(trial / 32))*1.8
alter VB4 = $&drive
let drive = (floor(trial / 32) - 2*floor(trial / 64))*1.8
alter VB5 = $&drive
let drive = (floor(trial / 64) - 2*floor(trial / 128))*1.8
alter VB6 = $&drive
let drive = (floor(trial / 128) - 2*floor(trial / 256))*1.8
alter VB7 = $&drive
stop when time = 0.003388
resume
delete all
let endpoint = length(time)-1
let cmp = v(COMP)[endpoint]
let top = v(TOP)[endpoint]
let decision = 0
if cmp >= 0.9
let code = trial
let decision = 1
end
echo 188 7 $&trial $&cmp $&top 0.86953125 $&decision >> decisions.csv
let trial = code + 64
let drive = (floor(trial / 1) - 2*floor(trial / 2))*1.8
alter VB0 = $&drive
let drive = (floor(trial / 2) - 2*floor(trial / 4))*1.8
alter VB1 = $&drive
let drive = (floor(trial / 4) - 2*floor(trial / 8))*1.8
alter VB2 = $&drive
let drive = (floor(trial / 8) - 2*floor(trial / 16))*1.8
alter VB3 = $&drive
let drive = (floor(trial / 16) - 2*floor(trial / 32))*1.8
alter VB4 = $&drive
let drive = (floor(trial / 32) - 2*floor(trial / 64))*1.8
alter VB5 = $&drive
let drive = (floor(trial / 64) - 2*floor(trial / 128))*1.8
alter VB6 = $&drive
let drive = (floor(trial / 128) - 2*floor(trial / 256))*1.8
alter VB7 = $&drive
stop when time = 0.00339
resume
delete all
let endpoint = length(time)-1
let cmp = v(COMP)[endpoint]
let top = v(TOP)[endpoint]
let decision = 0
if cmp >= 0.9
let code = trial
let decision = 1
end
echo 188 6 $&trial $&cmp $&top 0.86953125 $&decision >> decisions.csv
let trial = code + 32
let drive = (floor(trial / 1) - 2*floor(trial / 2))*1.8
alter VB0 = $&drive
let drive = (floor(trial / 2) - 2*floor(trial / 4))*1.8
alter VB1 = $&drive
let drive = (floor(trial / 4) - 2*floor(trial / 8))*1.8
alter VB2 = $&drive
let drive = (floor(trial / 8) - 2*floor(trial / 16))*1.8
alter VB3 = $&drive
let drive = (floor(trial / 16) - 2*floor(trial / 32))*1.8
alter VB4 = $&drive
let drive = (floor(trial / 32) - 2*floor(trial / 64))*1.8
alter VB5 = $&drive
let drive = (floor(trial / 64) - 2*floor(trial / 128))*1.8
alter VB6 = $&drive
let drive = (floor(trial / 128) - 2*floor(trial / 256))*1.8
alter VB7 = $&drive
stop when time = 0.003392
resume
delete all
let endpoint = length(time)-1
let cmp = v(COMP)[endpoint]
let top = v(TOP)[endpoint]
let decision = 0
if cmp >= 0.9
let code = trial
let decision = 1
end
echo 188 5 $&trial $&cmp $&top 0.86953125 $&decision >> decisions.csv
let trial = code + 16
let drive = (floor(trial / 1) - 2*floor(trial / 2))*1.8
alter VB0 = $&drive
let drive = (floor(trial / 2) - 2*floor(trial / 4))*1.8
alter VB1 = $&drive
let drive = (floor(trial / 4) - 2*floor(trial / 8))*1.8
alter VB2 = $&drive
let drive = (floor(trial / 8) - 2*floor(trial / 16))*1.8
alter VB3 = $&drive
let drive = (floor(trial / 16) - 2*floor(trial / 32))*1.8
alter VB4 = $&drive
let drive = (floor(trial / 32) - 2*floor(trial / 64))*1.8
alter VB5 = $&drive
let drive = (floor(trial / 64) - 2*floor(trial / 128))*1.8
alter VB6 = $&drive
let drive = (floor(trial / 128) - 2*floor(trial / 256))*1.8
alter VB7 = $&drive
stop when time = 0.003394
resume
delete all
let endpoint = length(time)-1
let cmp = v(COMP)[endpoint]
let top = v(TOP)[endpoint]
let decision = 0
if cmp >= 0.9
let code = trial
let decision = 1
end
echo 188 4 $&trial $&cmp $&top 0.86953125 $&decision >> decisions.csv
let trial = code + 8
let drive = (floor(trial / 1) - 2*floor(trial / 2))*1.8
alter VB0 = $&drive
let drive = (floor(trial / 2) - 2*floor(trial / 4))*1.8
alter VB1 = $&drive
let drive = (floor(trial / 4) - 2*floor(trial / 8))*1.8
alter VB2 = $&drive
let drive = (floor(trial / 8) - 2*floor(trial / 16))*1.8
alter VB3 = $&drive
let drive = (floor(trial / 16) - 2*floor(trial / 32))*1.8
alter VB4 = $&drive
let drive = (floor(trial / 32) - 2*floor(trial / 64))*1.8
alter VB5 = $&drive
let drive = (floor(trial / 64) - 2*floor(trial / 128))*1.8
alter VB6 = $&drive
let drive = (floor(trial / 128) - 2*floor(trial / 256))*1.8
alter VB7 = $&drive
stop when time = 0.003396
resume
delete all
let endpoint = length(time)-1
let cmp = v(COMP)[endpoint]
let top = v(TOP)[endpoint]
let decision = 0
if cmp >= 0.9
let code = trial
let decision = 1
end
echo 188 3 $&trial $&cmp $&top 0.86953125 $&decision >> decisions.csv
let trial = code + 4
let drive = (floor(trial / 1) - 2*floor(trial / 2))*1.8
alter VB0 = $&drive
let drive = (floor(trial / 2) - 2*floor(trial / 4))*1.8
alter VB1 = $&drive
let drive = (floor(trial / 4) - 2*floor(trial / 8))*1.8
alter VB2 = $&drive
let drive = (floor(trial / 8) - 2*floor(trial / 16))*1.8
alter VB3 = $&drive
let drive = (floor(trial / 16) - 2*floor(trial / 32))*1.8
alter VB4 = $&drive
let drive = (floor(trial / 32) - 2*floor(trial / 64))*1.8
alter VB5 = $&drive
let drive = (floor(trial / 64) - 2*floor(trial / 128))*1.8
alter VB6 = $&drive
let drive = (floor(trial / 128) - 2*floor(trial / 256))*1.8
alter VB7 = $&drive
stop when time = 0.003398
resume
delete all
let endpoint = length(time)-1
let cmp = v(COMP)[endpoint]
let top = v(TOP)[endpoint]
let decision = 0
if cmp >= 0.9
let code = trial
let decision = 1
end
echo 188 2 $&trial $&cmp $&top 0.86953125 $&decision >> decisions.csv
let trial = code + 2
let drive = (floor(trial / 1) - 2*floor(trial / 2))*1.8
alter VB0 = $&drive
let drive = (floor(trial / 2) - 2*floor(trial / 4))*1.8
alter VB1 = $&drive
let drive = (floor(trial / 4) - 2*floor(trial / 8))*1.8
alter VB2 = $&drive
let drive = (floor(trial / 8) - 2*floor(trial / 16))*1.8
alter VB3 = $&drive
let drive = (floor(trial / 16) - 2*floor(trial / 32))*1.8
alter VB4 = $&drive
let drive = (floor(trial / 32) - 2*floor(trial / 64))*1.8
alter VB5 = $&drive
let drive = (floor(trial / 64) - 2*floor(trial / 128))*1.8
alter VB6 = $&drive
let drive = (floor(trial / 128) - 2*floor(trial / 256))*1.8
alter VB7 = $&drive
stop when time = 0.0034
resume
delete all
let endpoint = length(time)-1
let cmp = v(COMP)[endpoint]
let top = v(TOP)[endpoint]
let decision = 0
if cmp >= 0.9
let code = trial
let decision = 1
end
echo 188 1 $&trial $&cmp $&top 0.86953125 $&decision >> decisions.csv
let trial = code + 1
let drive = (floor(trial / 1) - 2*floor(trial / 2))*1.8
alter VB0 = $&drive
let drive = (floor(trial / 2) - 2*floor(trial / 4))*1.8
alter VB1 = $&drive
let drive = (floor(trial / 4) - 2*floor(trial / 8))*1.8
alter VB2 = $&drive
let drive = (floor(trial / 8) - 2*floor(trial / 16))*1.8
alter VB3 = $&drive
let drive = (floor(trial / 16) - 2*floor(trial / 32))*1.8
alter VB4 = $&drive
let drive = (floor(trial / 32) - 2*floor(trial / 64))*1.8
alter VB5 = $&drive
let drive = (floor(trial / 64) - 2*floor(trial / 128))*1.8
alter VB6 = $&drive
let drive = (floor(trial / 128) - 2*floor(trial / 256))*1.8
alter VB7 = $&drive
stop when time = 0.003402
resume
delete all
let endpoint = length(time)-1
let cmp = v(COMP)[endpoint]
let top = v(TOP)[endpoint]
let decision = 0
if cmp >= 0.9
let code = trial
let decision = 1
end
echo 188 0 $&trial $&cmp $&top 0.86953125 $&decision >> decisions.csv
alter VIN = 0.87421875
alter VSAMPLE = 1.8
alter VB0 = 0
alter VB1 = 0
alter VB2 = 0
alter VB3 = 0
alter VB4 = 0
alter VB5 = 0
alter VB6 = 0
alter VB7 = 0
let code = 0
stop when time = 0.003404
resume
delete all
alter VSAMPLE = 0
let trial = code + 128
let drive = (floor(trial / 1) - 2*floor(trial / 2))*1.8
alter VB0 = $&drive
let drive = (floor(trial / 2) - 2*floor(trial / 4))*1.8
alter VB1 = $&drive
let drive = (floor(trial / 4) - 2*floor(trial / 8))*1.8
alter VB2 = $&drive
let drive = (floor(trial / 8) - 2*floor(trial / 16))*1.8
alter VB3 = $&drive
let drive = (floor(trial / 16) - 2*floor(trial / 32))*1.8
alter VB4 = $&drive
let drive = (floor(trial / 32) - 2*floor(trial / 64))*1.8
alter VB5 = $&drive
let drive = (floor(trial / 64) - 2*floor(trial / 128))*1.8
alter VB6 = $&drive
let drive = (floor(trial / 128) - 2*floor(trial / 256))*1.8
alter VB7 = $&drive
stop when time = 0.003406
resume
delete all
let endpoint = length(time)-1
let cmp = v(COMP)[endpoint]
let top = v(TOP)[endpoint]
let decision = 0
if cmp >= 0.9
let code = trial
let decision = 1
end
echo 189 7 $&trial $&cmp $&top 0.87421875 $&decision >> decisions.csv
let trial = code + 64
let drive = (floor(trial / 1) - 2*floor(trial / 2))*1.8
alter VB0 = $&drive
let drive = (floor(trial / 2) - 2*floor(trial / 4))*1.8
alter VB1 = $&drive
let drive = (floor(trial / 4) - 2*floor(trial / 8))*1.8
alter VB2 = $&drive
let drive = (floor(trial / 8) - 2*floor(trial / 16))*1.8
alter VB3 = $&drive
let drive = (floor(trial / 16) - 2*floor(trial / 32))*1.8
alter VB4 = $&drive
let drive = (floor(trial / 32) - 2*floor(trial / 64))*1.8
alter VB5 = $&drive
let drive = (floor(trial / 64) - 2*floor(trial / 128))*1.8
alter VB6 = $&drive
let drive = (floor(trial / 128) - 2*floor(trial / 256))*1.8
alter VB7 = $&drive
stop when time = 0.003408
resume
delete all
let endpoint = length(time)-1
let cmp = v(COMP)[endpoint]
let top = v(TOP)[endpoint]
let decision = 0
if cmp >= 0.9
let code = trial
let decision = 1
end
echo 189 6 $&trial $&cmp $&top 0.87421875 $&decision >> decisions.csv
let trial = code + 32
let drive = (floor(trial / 1) - 2*floor(trial / 2))*1.8
alter VB0 = $&drive
let drive = (floor(trial / 2) - 2*floor(trial / 4))*1.8
alter VB1 = $&drive
let drive = (floor(trial / 4) - 2*floor(trial / 8))*1.8
alter VB2 = $&drive
let drive = (floor(trial / 8) - 2*floor(trial / 16))*1.8
alter VB3 = $&drive
let drive = (floor(trial / 16) - 2*floor(trial / 32))*1.8
alter VB4 = $&drive
let drive = (floor(trial / 32) - 2*floor(trial / 64))*1.8
alter VB5 = $&drive
let drive = (floor(trial / 64) - 2*floor(trial / 128))*1.8
alter VB6 = $&drive
let drive = (floor(trial / 128) - 2*floor(trial / 256))*1.8
alter VB7 = $&drive
stop when time = 0.00341
resume
delete all
let endpoint = length(time)-1
let cmp = v(COMP)[endpoint]
let top = v(TOP)[endpoint]
let decision = 0
if cmp >= 0.9
let code = trial
let decision = 1
end
echo 189 5 $&trial $&cmp $&top 0.87421875 $&decision >> decisions.csv
let trial = code + 16
let drive = (floor(trial / 1) - 2*floor(trial / 2))*1.8
alter VB0 = $&drive
let drive = (floor(trial / 2) - 2*floor(trial / 4))*1.8
alter VB1 = $&drive
let drive = (floor(trial / 4) - 2*floor(trial / 8))*1.8
alter VB2 = $&drive
let drive = (floor(trial / 8) - 2*floor(trial / 16))*1.8
alter VB3 = $&drive
let drive = (floor(trial / 16) - 2*floor(trial / 32))*1.8
alter VB4 = $&drive
let drive = (floor(trial / 32) - 2*floor(trial / 64))*1.8
alter VB5 = $&drive
let drive = (floor(trial / 64) - 2*floor(trial / 128))*1.8
alter VB6 = $&drive
let drive = (floor(trial / 128) - 2*floor(trial / 256))*1.8
alter VB7 = $&drive
stop when time = 0.003412
resume
delete all
let endpoint = length(time)-1
let cmp = v(COMP)[endpoint]
let top = v(TOP)[endpoint]
let decision = 0
if cmp >= 0.9
let code = trial
let decision = 1
end
echo 189 4 $&trial $&cmp $&top 0.87421875 $&decision >> decisions.csv
let trial = code + 8
let drive = (floor(trial / 1) - 2*floor(trial / 2))*1.8
alter VB0 = $&drive
let drive = (floor(trial / 2) - 2*floor(trial / 4))*1.8
alter VB1 = $&drive
let drive = (floor(trial / 4) - 2*floor(trial / 8))*1.8
alter VB2 = $&drive
let drive = (floor(trial / 8) - 2*floor(trial / 16))*1.8
alter VB3 = $&drive
let drive = (floor(trial / 16) - 2*floor(trial / 32))*1.8
alter VB4 = $&drive
let drive = (floor(trial / 32) - 2*floor(trial / 64))*1.8
alter VB5 = $&drive
let drive = (floor(trial / 64) - 2*floor(trial / 128))*1.8
alter VB6 = $&drive
let drive = (floor(trial / 128) - 2*floor(trial / 256))*1.8
alter VB7 = $&drive
stop when time = 0.003414
resume
delete all
let endpoint = length(time)-1
let cmp = v(COMP)[endpoint]
let top = v(TOP)[endpoint]
let decision = 0
if cmp >= 0.9
let code = trial
let decision = 1
end
echo 189 3 $&trial $&cmp $&top 0.87421875 $&decision >> decisions.csv
let trial = code + 4
let drive = (floor(trial / 1) - 2*floor(trial / 2))*1.8
alter VB0 = $&drive
let drive = (floor(trial / 2) - 2*floor(trial / 4))*1.8
alter VB1 = $&drive
let drive = (floor(trial / 4) - 2*floor(trial / 8))*1.8
alter VB2 = $&drive
let drive = (floor(trial / 8) - 2*floor(trial / 16))*1.8
alter VB3 = $&drive
let drive = (floor(trial / 16) - 2*floor(trial / 32))*1.8
alter VB4 = $&drive
let drive = (floor(trial / 32) - 2*floor(trial / 64))*1.8
alter VB5 = $&drive
let drive = (floor(trial / 64) - 2*floor(trial / 128))*1.8
alter VB6 = $&drive
let drive = (floor(trial / 128) - 2*floor(trial / 256))*1.8
alter VB7 = $&drive
stop when time = 0.003416
resume
delete all
let endpoint = length(time)-1
let cmp = v(COMP)[endpoint]
let top = v(TOP)[endpoint]
let decision = 0
if cmp >= 0.9
let code = trial
let decision = 1
end
echo 189 2 $&trial $&cmp $&top 0.87421875 $&decision >> decisions.csv
let trial = code + 2
let drive = (floor(trial / 1) - 2*floor(trial / 2))*1.8
alter VB0 = $&drive
let drive = (floor(trial / 2) - 2*floor(trial / 4))*1.8
alter VB1 = $&drive
let drive = (floor(trial / 4) - 2*floor(trial / 8))*1.8
alter VB2 = $&drive
let drive = (floor(trial / 8) - 2*floor(trial / 16))*1.8
alter VB3 = $&drive
let drive = (floor(trial / 16) - 2*floor(trial / 32))*1.8
alter VB4 = $&drive
let drive = (floor(trial / 32) - 2*floor(trial / 64))*1.8
alter VB5 = $&drive
let drive = (floor(trial / 64) - 2*floor(trial / 128))*1.8
alter VB6 = $&drive
let drive = (floor(trial / 128) - 2*floor(trial / 256))*1.8
alter VB7 = $&drive
stop when time = 0.003418
resume
delete all
let endpoint = length(time)-1
let cmp = v(COMP)[endpoint]
let top = v(TOP)[endpoint]
let decision = 0
if cmp >= 0.9
let code = trial
let decision = 1
end
echo 189 1 $&trial $&cmp $&top 0.87421875 $&decision >> decisions.csv
let trial = code + 1
let drive = (floor(trial / 1) - 2*floor(trial / 2))*1.8
alter VB0 = $&drive
let drive = (floor(trial / 2) - 2*floor(trial / 4))*1.8
alter VB1 = $&drive
let drive = (floor(trial / 4) - 2*floor(trial / 8))*1.8
alter VB2 = $&drive
let drive = (floor(trial / 8) - 2*floor(trial / 16))*1.8
alter VB3 = $&drive
let drive = (floor(trial / 16) - 2*floor(trial / 32))*1.8
alter VB4 = $&drive
let drive = (floor(trial / 32) - 2*floor(trial / 64))*1.8
alter VB5 = $&drive
let drive = (floor(trial / 64) - 2*floor(trial / 128))*1.8
alter VB6 = $&drive
let drive = (floor(trial / 128) - 2*floor(trial / 256))*1.8
alter VB7 = $&drive
stop when time = 0.00342
resume
delete all
let endpoint = length(time)-1
let cmp = v(COMP)[endpoint]
let top = v(TOP)[endpoint]
let decision = 0
if cmp >= 0.9
let code = trial
let decision = 1
end
echo 189 0 $&trial $&cmp $&top 0.87421875 $&decision >> decisions.csv
alter VIN = 0.87890625
alter VSAMPLE = 1.8
alter VB0 = 0
alter VB1 = 0
alter VB2 = 0
alter VB3 = 0
alter VB4 = 0
alter VB5 = 0
alter VB6 = 0
alter VB7 = 0
let code = 0
stop when time = 0.003422
resume
delete all
alter VSAMPLE = 0
let trial = code + 128
let drive = (floor(trial / 1) - 2*floor(trial / 2))*1.8
alter VB0 = $&drive
let drive = (floor(trial / 2) - 2*floor(trial / 4))*1.8
alter VB1 = $&drive
let drive = (floor(trial / 4) - 2*floor(trial / 8))*1.8
alter VB2 = $&drive
let drive = (floor(trial / 8) - 2*floor(trial / 16))*1.8
alter VB3 = $&drive
let drive = (floor(trial / 16) - 2*floor(trial / 32))*1.8
alter VB4 = $&drive
let drive = (floor(trial / 32) - 2*floor(trial / 64))*1.8
alter VB5 = $&drive
let drive = (floor(trial / 64) - 2*floor(trial / 128))*1.8
alter VB6 = $&drive
let drive = (floor(trial / 128) - 2*floor(trial / 256))*1.8
alter VB7 = $&drive
stop when time = 0.003424
resume
delete all
let endpoint = length(time)-1
let cmp = v(COMP)[endpoint]
let top = v(TOP)[endpoint]
let decision = 0
if cmp >= 0.9
let code = trial
let decision = 1
end
echo 190 7 $&trial $&cmp $&top 0.87890625 $&decision >> decisions.csv
let trial = code + 64
let drive = (floor(trial / 1) - 2*floor(trial / 2))*1.8
alter VB0 = $&drive
let drive = (floor(trial / 2) - 2*floor(trial / 4))*1.8
alter VB1 = $&drive
let drive = (floor(trial / 4) - 2*floor(trial / 8))*1.8
alter VB2 = $&drive
let drive = (floor(trial / 8) - 2*floor(trial / 16))*1.8
alter VB3 = $&drive
let drive = (floor(trial / 16) - 2*floor(trial / 32))*1.8
alter VB4 = $&drive
let drive = (floor(trial / 32) - 2*floor(trial / 64))*1.8
alter VB5 = $&drive
let drive = (floor(trial / 64) - 2*floor(trial / 128))*1.8
alter VB6 = $&drive
let drive = (floor(trial / 128) - 2*floor(trial / 256))*1.8
alter VB7 = $&drive
stop when time = 0.003426
resume
delete all
let endpoint = length(time)-1
let cmp = v(COMP)[endpoint]
let top = v(TOP)[endpoint]
let decision = 0
if cmp >= 0.9
let code = trial
let decision = 1
end
echo 190 6 $&trial $&cmp $&top 0.87890625 $&decision >> decisions.csv
let trial = code + 32
let drive = (floor(trial / 1) - 2*floor(trial / 2))*1.8
alter VB0 = $&drive
let drive = (floor(trial / 2) - 2*floor(trial / 4))*1.8
alter VB1 = $&drive
let drive = (floor(trial / 4) - 2*floor(trial / 8))*1.8
alter VB2 = $&drive
let drive = (floor(trial / 8) - 2*floor(trial / 16))*1.8
alter VB3 = $&drive
let drive = (floor(trial / 16) - 2*floor(trial / 32))*1.8
alter VB4 = $&drive
let drive = (floor(trial / 32) - 2*floor(trial / 64))*1.8
alter VB5 = $&drive
let drive = (floor(trial / 64) - 2*floor(trial / 128))*1.8
alter VB6 = $&drive
let drive = (floor(trial / 128) - 2*floor(trial / 256))*1.8
alter VB7 = $&drive
stop when time = 0.003428
resume
delete all
let endpoint = length(time)-1
let cmp = v(COMP)[endpoint]
let top = v(TOP)[endpoint]
let decision = 0
if cmp >= 0.9
let code = trial
let decision = 1
end
echo 190 5 $&trial $&cmp $&top 0.87890625 $&decision >> decisions.csv
let trial = code + 16
let drive = (floor(trial / 1) - 2*floor(trial / 2))*1.8
alter VB0 = $&drive
let drive = (floor(trial / 2) - 2*floor(trial / 4))*1.8
alter VB1 = $&drive
let drive = (floor(trial / 4) - 2*floor(trial / 8))*1.8
alter VB2 = $&drive
let drive = (floor(trial / 8) - 2*floor(trial / 16))*1.8
alter VB3 = $&drive
let drive = (floor(trial / 16) - 2*floor(trial / 32))*1.8
alter VB4 = $&drive
let drive = (floor(trial / 32) - 2*floor(trial / 64))*1.8
alter VB5 = $&drive
let drive = (floor(trial / 64) - 2*floor(trial / 128))*1.8
alter VB6 = $&drive
let drive = (floor(trial / 128) - 2*floor(trial / 256))*1.8
alter VB7 = $&drive
stop when time = 0.00343
resume
delete all
let endpoint = length(time)-1
let cmp = v(COMP)[endpoint]
let top = v(TOP)[endpoint]
let decision = 0
if cmp >= 0.9
let code = trial
let decision = 1
end
echo 190 4 $&trial $&cmp $&top 0.87890625 $&decision >> decisions.csv
let trial = code + 8
let drive = (floor(trial / 1) - 2*floor(trial / 2))*1.8
alter VB0 = $&drive
let drive = (floor(trial / 2) - 2*floor(trial / 4))*1.8
alter VB1 = $&drive
let drive = (floor(trial / 4) - 2*floor(trial / 8))*1.8
alter VB2 = $&drive
let drive = (floor(trial / 8) - 2*floor(trial / 16))*1.8
alter VB3 = $&drive
let drive = (floor(trial / 16) - 2*floor(trial / 32))*1.8
alter VB4 = $&drive
let drive = (floor(trial / 32) - 2*floor(trial / 64))*1.8
alter VB5 = $&drive
let drive = (floor(trial / 64) - 2*floor(trial / 128))*1.8
alter VB6 = $&drive
let drive = (floor(trial / 128) - 2*floor(trial / 256))*1.8
alter VB7 = $&drive
stop when time = 0.003432
resume
delete all
let endpoint = length(time)-1
let cmp = v(COMP)[endpoint]
let top = v(TOP)[endpoint]
let decision = 0
if cmp >= 0.9
let code = trial
let decision = 1
end
echo 190 3 $&trial $&cmp $&top 0.87890625 $&decision >> decisions.csv
let trial = code + 4
let drive = (floor(trial / 1) - 2*floor(trial / 2))*1.8
alter VB0 = $&drive
let drive = (floor(trial / 2) - 2*floor(trial / 4))*1.8
alter VB1 = $&drive
let drive = (floor(trial / 4) - 2*floor(trial / 8))*1.8
alter VB2 = $&drive
let drive = (floor(trial / 8) - 2*floor(trial / 16))*1.8
alter VB3 = $&drive
let drive = (floor(trial / 16) - 2*floor(trial / 32))*1.8
alter VB4 = $&drive
let drive = (floor(trial / 32) - 2*floor(trial / 64))*1.8
alter VB5 = $&drive
let drive = (floor(trial / 64) - 2*floor(trial / 128))*1.8
alter VB6 = $&drive
let drive = (floor(trial / 128) - 2*floor(trial / 256))*1.8
alter VB7 = $&drive
stop when time = 0.003434
resume
delete all
let endpoint = length(time)-1
let cmp = v(COMP)[endpoint]
let top = v(TOP)[endpoint]
let decision = 0
if cmp >= 0.9
let code = trial
let decision = 1
end
echo 190 2 $&trial $&cmp $&top 0.87890625 $&decision >> decisions.csv
let trial = code + 2
let drive = (floor(trial / 1) - 2*floor(trial / 2))*1.8
alter VB0 = $&drive
let drive = (floor(trial / 2) - 2*floor(trial / 4))*1.8
alter VB1 = $&drive
let drive = (floor(trial / 4) - 2*floor(trial / 8))*1.8
alter VB2 = $&drive
let drive = (floor(trial / 8) - 2*floor(trial / 16))*1.8
alter VB3 = $&drive
let drive = (floor(trial / 16) - 2*floor(trial / 32))*1.8
alter VB4 = $&drive
let drive = (floor(trial / 32) - 2*floor(trial / 64))*1.8
alter VB5 = $&drive
let drive = (floor(trial / 64) - 2*floor(trial / 128))*1.8
alter VB6 = $&drive
let drive = (floor(trial / 128) - 2*floor(trial / 256))*1.8
alter VB7 = $&drive
stop when time = 0.003436
resume
delete all
let endpoint = length(time)-1
let cmp = v(COMP)[endpoint]
let top = v(TOP)[endpoint]
let decision = 0
if cmp >= 0.9
let code = trial
let decision = 1
end
echo 190 1 $&trial $&cmp $&top 0.87890625 $&decision >> decisions.csv
let trial = code + 1
let drive = (floor(trial / 1) - 2*floor(trial / 2))*1.8
alter VB0 = $&drive
let drive = (floor(trial / 2) - 2*floor(trial / 4))*1.8
alter VB1 = $&drive
let drive = (floor(trial / 4) - 2*floor(trial / 8))*1.8
alter VB2 = $&drive
let drive = (floor(trial / 8) - 2*floor(trial / 16))*1.8
alter VB3 = $&drive
let drive = (floor(trial / 16) - 2*floor(trial / 32))*1.8
alter VB4 = $&drive
let drive = (floor(trial / 32) - 2*floor(trial / 64))*1.8
alter VB5 = $&drive
let drive = (floor(trial / 64) - 2*floor(trial / 128))*1.8
alter VB6 = $&drive
let drive = (floor(trial / 128) - 2*floor(trial / 256))*1.8
alter VB7 = $&drive
stop when time = 0.003438
resume
delete all
let endpoint = length(time)-1
let cmp = v(COMP)[endpoint]
let top = v(TOP)[endpoint]
let decision = 0
if cmp >= 0.9
let code = trial
let decision = 1
end
echo 190 0 $&trial $&cmp $&top 0.87890625 $&decision >> decisions.csv
alter VIN = 0.88359375
alter VSAMPLE = 1.8
alter VB0 = 0
alter VB1 = 0
alter VB2 = 0
alter VB3 = 0
alter VB4 = 0
alter VB5 = 0
alter VB6 = 0
alter VB7 = 0
let code = 0
stop when time = 0.00344
resume
delete all
alter VSAMPLE = 0
let trial = code + 128
let drive = (floor(trial / 1) - 2*floor(trial / 2))*1.8
alter VB0 = $&drive
let drive = (floor(trial / 2) - 2*floor(trial / 4))*1.8
alter VB1 = $&drive
let drive = (floor(trial / 4) - 2*floor(trial / 8))*1.8
alter VB2 = $&drive
let drive = (floor(trial / 8) - 2*floor(trial / 16))*1.8
alter VB3 = $&drive
let drive = (floor(trial / 16) - 2*floor(trial / 32))*1.8
alter VB4 = $&drive
let drive = (floor(trial / 32) - 2*floor(trial / 64))*1.8
alter VB5 = $&drive
let drive = (floor(trial / 64) - 2*floor(trial / 128))*1.8
alter VB6 = $&drive
let drive = (floor(trial / 128) - 2*floor(trial / 256))*1.8
alter VB7 = $&drive
stop when time = 0.003442
resume
delete all
let endpoint = length(time)-1
let cmp = v(COMP)[endpoint]
let top = v(TOP)[endpoint]
let decision = 0
if cmp >= 0.9
let code = trial
let decision = 1
end
echo 191 7 $&trial $&cmp $&top 0.88359375 $&decision >> decisions.csv
let trial = code + 64
let drive = (floor(trial / 1) - 2*floor(trial / 2))*1.8
alter VB0 = $&drive
let drive = (floor(trial / 2) - 2*floor(trial / 4))*1.8
alter VB1 = $&drive
let drive = (floor(trial / 4) - 2*floor(trial / 8))*1.8
alter VB2 = $&drive
let drive = (floor(trial / 8) - 2*floor(trial / 16))*1.8
alter VB3 = $&drive
let drive = (floor(trial / 16) - 2*floor(trial / 32))*1.8
alter VB4 = $&drive
let drive = (floor(trial / 32) - 2*floor(trial / 64))*1.8
alter VB5 = $&drive
let drive = (floor(trial / 64) - 2*floor(trial / 128))*1.8
alter VB6 = $&drive
let drive = (floor(trial / 128) - 2*floor(trial / 256))*1.8
alter VB7 = $&drive
stop when time = 0.003444
resume
delete all
let endpoint = length(time)-1
let cmp = v(COMP)[endpoint]
let top = v(TOP)[endpoint]
let decision = 0
if cmp >= 0.9
let code = trial
let decision = 1
end
echo 191 6 $&trial $&cmp $&top 0.88359375 $&decision >> decisions.csv
let trial = code + 32
let drive = (floor(trial / 1) - 2*floor(trial / 2))*1.8
alter VB0 = $&drive
let drive = (floor(trial / 2) - 2*floor(trial / 4))*1.8
alter VB1 = $&drive
let drive = (floor(trial / 4) - 2*floor(trial / 8))*1.8
alter VB2 = $&drive
let drive = (floor(trial / 8) - 2*floor(trial / 16))*1.8
alter VB3 = $&drive
let drive = (floor(trial / 16) - 2*floor(trial / 32))*1.8
alter VB4 = $&drive
let drive = (floor(trial / 32) - 2*floor(trial / 64))*1.8
alter VB5 = $&drive
let drive = (floor(trial / 64) - 2*floor(trial / 128))*1.8
alter VB6 = $&drive
let drive = (floor(trial / 128) - 2*floor(trial / 256))*1.8
alter VB7 = $&drive
stop when time = 0.003446
resume
delete all
let endpoint = length(time)-1
let cmp = v(COMP)[endpoint]
let top = v(TOP)[endpoint]
let decision = 0
if cmp >= 0.9
let code = trial
let decision = 1
end
echo 191 5 $&trial $&cmp $&top 0.88359375 $&decision >> decisions.csv
let trial = code + 16
let drive = (floor(trial / 1) - 2*floor(trial / 2))*1.8
alter VB0 = $&drive
let drive = (floor(trial / 2) - 2*floor(trial / 4))*1.8
alter VB1 = $&drive
let drive = (floor(trial / 4) - 2*floor(trial / 8))*1.8
alter VB2 = $&drive
let drive = (floor(trial / 8) - 2*floor(trial / 16))*1.8
alter VB3 = $&drive
let drive = (floor(trial / 16) - 2*floor(trial / 32))*1.8
alter VB4 = $&drive
let drive = (floor(trial / 32) - 2*floor(trial / 64))*1.8
alter VB5 = $&drive
let drive = (floor(trial / 64) - 2*floor(trial / 128))*1.8
alter VB6 = $&drive
let drive = (floor(trial / 128) - 2*floor(trial / 256))*1.8
alter VB7 = $&drive
stop when time = 0.003448
resume
delete all
let endpoint = length(time)-1
let cmp = v(COMP)[endpoint]
let top = v(TOP)[endpoint]
let decision = 0
if cmp >= 0.9
let code = trial
let decision = 1
end
echo 191 4 $&trial $&cmp $&top 0.88359375 $&decision >> decisions.csv
let trial = code + 8
let drive = (floor(trial / 1) - 2*floor(trial / 2))*1.8
alter VB0 = $&drive
let drive = (floor(trial / 2) - 2*floor(trial / 4))*1.8
alter VB1 = $&drive
let drive = (floor(trial / 4) - 2*floor(trial / 8))*1.8
alter VB2 = $&drive
let drive = (floor(trial / 8) - 2*floor(trial / 16))*1.8
alter VB3 = $&drive
let drive = (floor(trial / 16) - 2*floor(trial / 32))*1.8
alter VB4 = $&drive
let drive = (floor(trial / 32) - 2*floor(trial / 64))*1.8
alter VB5 = $&drive
let drive = (floor(trial / 64) - 2*floor(trial / 128))*1.8
alter VB6 = $&drive
let drive = (floor(trial / 128) - 2*floor(trial / 256))*1.8
alter VB7 = $&drive
stop when time = 0.00345
resume
delete all
let endpoint = length(time)-1
let cmp = v(COMP)[endpoint]
let top = v(TOP)[endpoint]
let decision = 0
if cmp >= 0.9
let code = trial
let decision = 1
end
echo 191 3 $&trial $&cmp $&top 0.88359375 $&decision >> decisions.csv
let trial = code + 4
let drive = (floor(trial / 1) - 2*floor(trial / 2))*1.8
alter VB0 = $&drive
let drive = (floor(trial / 2) - 2*floor(trial / 4))*1.8
alter VB1 = $&drive
let drive = (floor(trial / 4) - 2*floor(trial / 8))*1.8
alter VB2 = $&drive
let drive = (floor(trial / 8) - 2*floor(trial / 16))*1.8
alter VB3 = $&drive
let drive = (floor(trial / 16) - 2*floor(trial / 32))*1.8
alter VB4 = $&drive
let drive = (floor(trial / 32) - 2*floor(trial / 64))*1.8
alter VB5 = $&drive
let drive = (floor(trial / 64) - 2*floor(trial / 128))*1.8
alter VB6 = $&drive
let drive = (floor(trial / 128) - 2*floor(trial / 256))*1.8
alter VB7 = $&drive
stop when time = 0.003452
resume
delete all
let endpoint = length(time)-1
let cmp = v(COMP)[endpoint]
let top = v(TOP)[endpoint]
let decision = 0
if cmp >= 0.9
let code = trial
let decision = 1
end
echo 191 2 $&trial $&cmp $&top 0.88359375 $&decision >> decisions.csv
let trial = code + 2
let drive = (floor(trial / 1) - 2*floor(trial / 2))*1.8
alter VB0 = $&drive
let drive = (floor(trial / 2) - 2*floor(trial / 4))*1.8
alter VB1 = $&drive
let drive = (floor(trial / 4) - 2*floor(trial / 8))*1.8
alter VB2 = $&drive
let drive = (floor(trial / 8) - 2*floor(trial / 16))*1.8
alter VB3 = $&drive
let drive = (floor(trial / 16) - 2*floor(trial / 32))*1.8
alter VB4 = $&drive
let drive = (floor(trial / 32) - 2*floor(trial / 64))*1.8
alter VB5 = $&drive
let drive = (floor(trial / 64) - 2*floor(trial / 128))*1.8
alter VB6 = $&drive
let drive = (floor(trial / 128) - 2*floor(trial / 256))*1.8
alter VB7 = $&drive
stop when time = 0.003454
resume
delete all
let endpoint = length(time)-1
let cmp = v(COMP)[endpoint]
let top = v(TOP)[endpoint]
let decision = 0
if cmp >= 0.9
let code = trial
let decision = 1
end
echo 191 1 $&trial $&cmp $&top 0.88359375 $&decision >> decisions.csv
let trial = code + 1
let drive = (floor(trial / 1) - 2*floor(trial / 2))*1.8
alter VB0 = $&drive
let drive = (floor(trial / 2) - 2*floor(trial / 4))*1.8
alter VB1 = $&drive
let drive = (floor(trial / 4) - 2*floor(trial / 8))*1.8
alter VB2 = $&drive
let drive = (floor(trial / 8) - 2*floor(trial / 16))*1.8
alter VB3 = $&drive
let drive = (floor(trial / 16) - 2*floor(trial / 32))*1.8
alter VB4 = $&drive
let drive = (floor(trial / 32) - 2*floor(trial / 64))*1.8
alter VB5 = $&drive
let drive = (floor(trial / 64) - 2*floor(trial / 128))*1.8
alter VB6 = $&drive
let drive = (floor(trial / 128) - 2*floor(trial / 256))*1.8
alter VB7 = $&drive
stop when time = 0.003456
resume
delete all
let endpoint = length(time)-1
let cmp = v(COMP)[endpoint]
let top = v(TOP)[endpoint]
let decision = 0
if cmp >= 0.9
let code = trial
let decision = 1
end
echo 191 0 $&trial $&cmp $&top 0.88359375 $&decision >> decisions.csv
alter VIN = 0.88828125
alter VSAMPLE = 1.8
alter VB0 = 0
alter VB1 = 0
alter VB2 = 0
alter VB3 = 0
alter VB4 = 0
alter VB5 = 0
alter VB6 = 0
alter VB7 = 0
let code = 0
stop when time = 0.003458
resume
delete all
alter VSAMPLE = 0
let trial = code + 128
let drive = (floor(trial / 1) - 2*floor(trial / 2))*1.8
alter VB0 = $&drive
let drive = (floor(trial / 2) - 2*floor(trial / 4))*1.8
alter VB1 = $&drive
let drive = (floor(trial / 4) - 2*floor(trial / 8))*1.8
alter VB2 = $&drive
let drive = (floor(trial / 8) - 2*floor(trial / 16))*1.8
alter VB3 = $&drive
let drive = (floor(trial / 16) - 2*floor(trial / 32))*1.8
alter VB4 = $&drive
let drive = (floor(trial / 32) - 2*floor(trial / 64))*1.8
alter VB5 = $&drive
let drive = (floor(trial / 64) - 2*floor(trial / 128))*1.8
alter VB6 = $&drive
let drive = (floor(trial / 128) - 2*floor(trial / 256))*1.8
alter VB7 = $&drive
stop when time = 0.00346
resume
delete all
let endpoint = length(time)-1
let cmp = v(COMP)[endpoint]
let top = v(TOP)[endpoint]
let decision = 0
if cmp >= 0.9
let code = trial
let decision = 1
end
echo 192 7 $&trial $&cmp $&top 0.88828125 $&decision >> decisions.csv
let trial = code + 64
let drive = (floor(trial / 1) - 2*floor(trial / 2))*1.8
alter VB0 = $&drive
let drive = (floor(trial / 2) - 2*floor(trial / 4))*1.8
alter VB1 = $&drive
let drive = (floor(trial / 4) - 2*floor(trial / 8))*1.8
alter VB2 = $&drive
let drive = (floor(trial / 8) - 2*floor(trial / 16))*1.8
alter VB3 = $&drive
let drive = (floor(trial / 16) - 2*floor(trial / 32))*1.8
alter VB4 = $&drive
let drive = (floor(trial / 32) - 2*floor(trial / 64))*1.8
alter VB5 = $&drive
let drive = (floor(trial / 64) - 2*floor(trial / 128))*1.8
alter VB6 = $&drive
let drive = (floor(trial / 128) - 2*floor(trial / 256))*1.8
alter VB7 = $&drive
stop when time = 0.003462
resume
delete all
let endpoint = length(time)-1
let cmp = v(COMP)[endpoint]
let top = v(TOP)[endpoint]
let decision = 0
if cmp >= 0.9
let code = trial
let decision = 1
end
echo 192 6 $&trial $&cmp $&top 0.88828125 $&decision >> decisions.csv
let trial = code + 32
let drive = (floor(trial / 1) - 2*floor(trial / 2))*1.8
alter VB0 = $&drive
let drive = (floor(trial / 2) - 2*floor(trial / 4))*1.8
alter VB1 = $&drive
let drive = (floor(trial / 4) - 2*floor(trial / 8))*1.8
alter VB2 = $&drive
let drive = (floor(trial / 8) - 2*floor(trial / 16))*1.8
alter VB3 = $&drive
let drive = (floor(trial / 16) - 2*floor(trial / 32))*1.8
alter VB4 = $&drive
let drive = (floor(trial / 32) - 2*floor(trial / 64))*1.8
alter VB5 = $&drive
let drive = (floor(trial / 64) - 2*floor(trial / 128))*1.8
alter VB6 = $&drive
let drive = (floor(trial / 128) - 2*floor(trial / 256))*1.8
alter VB7 = $&drive
stop when time = 0.003464
resume
delete all
let endpoint = length(time)-1
let cmp = v(COMP)[endpoint]
let top = v(TOP)[endpoint]
let decision = 0
if cmp >= 0.9
let code = trial
let decision = 1
end
echo 192 5 $&trial $&cmp $&top 0.88828125 $&decision >> decisions.csv
let trial = code + 16
let drive = (floor(trial / 1) - 2*floor(trial / 2))*1.8
alter VB0 = $&drive
let drive = (floor(trial / 2) - 2*floor(trial / 4))*1.8
alter VB1 = $&drive
let drive = (floor(trial / 4) - 2*floor(trial / 8))*1.8
alter VB2 = $&drive
let drive = (floor(trial / 8) - 2*floor(trial / 16))*1.8
alter VB3 = $&drive
let drive = (floor(trial / 16) - 2*floor(trial / 32))*1.8
alter VB4 = $&drive
let drive = (floor(trial / 32) - 2*floor(trial / 64))*1.8
alter VB5 = $&drive
let drive = (floor(trial / 64) - 2*floor(trial / 128))*1.8
alter VB6 = $&drive
let drive = (floor(trial / 128) - 2*floor(trial / 256))*1.8
alter VB7 = $&drive
stop when time = 0.003466
resume
delete all
let endpoint = length(time)-1
let cmp = v(COMP)[endpoint]
let top = v(TOP)[endpoint]
let decision = 0
if cmp >= 0.9
let code = trial
let decision = 1
end
echo 192 4 $&trial $&cmp $&top 0.88828125 $&decision >> decisions.csv
let trial = code + 8
let drive = (floor(trial / 1) - 2*floor(trial / 2))*1.8
alter VB0 = $&drive
let drive = (floor(trial / 2) - 2*floor(trial / 4))*1.8
alter VB1 = $&drive
let drive = (floor(trial / 4) - 2*floor(trial / 8))*1.8
alter VB2 = $&drive
let drive = (floor(trial / 8) - 2*floor(trial / 16))*1.8
alter VB3 = $&drive
let drive = (floor(trial / 16) - 2*floor(trial / 32))*1.8
alter VB4 = $&drive
let drive = (floor(trial / 32) - 2*floor(trial / 64))*1.8
alter VB5 = $&drive
let drive = (floor(trial / 64) - 2*floor(trial / 128))*1.8
alter VB6 = $&drive
let drive = (floor(trial / 128) - 2*floor(trial / 256))*1.8
alter VB7 = $&drive
stop when time = 0.003468
resume
delete all
let endpoint = length(time)-1
let cmp = v(COMP)[endpoint]
let top = v(TOP)[endpoint]
let decision = 0
if cmp >= 0.9
let code = trial
let decision = 1
end
echo 192 3 $&trial $&cmp $&top 0.88828125 $&decision >> decisions.csv
let trial = code + 4
let drive = (floor(trial / 1) - 2*floor(trial / 2))*1.8
alter VB0 = $&drive
let drive = (floor(trial / 2) - 2*floor(trial / 4))*1.8
alter VB1 = $&drive
let drive = (floor(trial / 4) - 2*floor(trial / 8))*1.8
alter VB2 = $&drive
let drive = (floor(trial / 8) - 2*floor(trial / 16))*1.8
alter VB3 = $&drive
let drive = (floor(trial / 16) - 2*floor(trial / 32))*1.8
alter VB4 = $&drive
let drive = (floor(trial / 32) - 2*floor(trial / 64))*1.8
alter VB5 = $&drive
let drive = (floor(trial / 64) - 2*floor(trial / 128))*1.8
alter VB6 = $&drive
let drive = (floor(trial / 128) - 2*floor(trial / 256))*1.8
alter VB7 = $&drive
stop when time = 0.00347
resume
delete all
let endpoint = length(time)-1
let cmp = v(COMP)[endpoint]
let top = v(TOP)[endpoint]
let decision = 0
if cmp >= 0.9
let code = trial
let decision = 1
end
echo 192 2 $&trial $&cmp $&top 0.88828125 $&decision >> decisions.csv
let trial = code + 2
let drive = (floor(trial / 1) - 2*floor(trial / 2))*1.8
alter VB0 = $&drive
let drive = (floor(trial / 2) - 2*floor(trial / 4))*1.8
alter VB1 = $&drive
let drive = (floor(trial / 4) - 2*floor(trial / 8))*1.8
alter VB2 = $&drive
let drive = (floor(trial / 8) - 2*floor(trial / 16))*1.8
alter VB3 = $&drive
let drive = (floor(trial / 16) - 2*floor(trial / 32))*1.8
alter VB4 = $&drive
let drive = (floor(trial / 32) - 2*floor(trial / 64))*1.8
alter VB5 = $&drive
let drive = (floor(trial / 64) - 2*floor(trial / 128))*1.8
alter VB6 = $&drive
let drive = (floor(trial / 128) - 2*floor(trial / 256))*1.8
alter VB7 = $&drive
stop when time = 0.003472
resume
delete all
let endpoint = length(time)-1
let cmp = v(COMP)[endpoint]
let top = v(TOP)[endpoint]
let decision = 0
if cmp >= 0.9
let code = trial
let decision = 1
end
echo 192 1 $&trial $&cmp $&top 0.88828125 $&decision >> decisions.csv
let trial = code + 1
let drive = (floor(trial / 1) - 2*floor(trial / 2))*1.8
alter VB0 = $&drive
let drive = (floor(trial / 2) - 2*floor(trial / 4))*1.8
alter VB1 = $&drive
let drive = (floor(trial / 4) - 2*floor(trial / 8))*1.8
alter VB2 = $&drive
let drive = (floor(trial / 8) - 2*floor(trial / 16))*1.8
alter VB3 = $&drive
let drive = (floor(trial / 16) - 2*floor(trial / 32))*1.8
alter VB4 = $&drive
let drive = (floor(trial / 32) - 2*floor(trial / 64))*1.8
alter VB5 = $&drive
let drive = (floor(trial / 64) - 2*floor(trial / 128))*1.8
alter VB6 = $&drive
let drive = (floor(trial / 128) - 2*floor(trial / 256))*1.8
alter VB7 = $&drive
stop when time = 0.003474
resume
delete all
let endpoint = length(time)-1
let cmp = v(COMP)[endpoint]
let top = v(TOP)[endpoint]
let decision = 0
if cmp >= 0.9
let code = trial
let decision = 1
end
echo 192 0 $&trial $&cmp $&top 0.88828125 $&decision >> decisions.csv
alter VIN = 0.89296875
alter VSAMPLE = 1.8
alter VB0 = 0
alter VB1 = 0
alter VB2 = 0
alter VB3 = 0
alter VB4 = 0
alter VB5 = 0
alter VB6 = 0
alter VB7 = 0
let code = 0
stop when time = 0.003476
resume
delete all
alter VSAMPLE = 0
let trial = code + 128
let drive = (floor(trial / 1) - 2*floor(trial / 2))*1.8
alter VB0 = $&drive
let drive = (floor(trial / 2) - 2*floor(trial / 4))*1.8
alter VB1 = $&drive
let drive = (floor(trial / 4) - 2*floor(trial / 8))*1.8
alter VB2 = $&drive
let drive = (floor(trial / 8) - 2*floor(trial / 16))*1.8
alter VB3 = $&drive
let drive = (floor(trial / 16) - 2*floor(trial / 32))*1.8
alter VB4 = $&drive
let drive = (floor(trial / 32) - 2*floor(trial / 64))*1.8
alter VB5 = $&drive
let drive = (floor(trial / 64) - 2*floor(trial / 128))*1.8
alter VB6 = $&drive
let drive = (floor(trial / 128) - 2*floor(trial / 256))*1.8
alter VB7 = $&drive
stop when time = 0.003478
resume
delete all
let endpoint = length(time)-1
let cmp = v(COMP)[endpoint]
let top = v(TOP)[endpoint]
let decision = 0
if cmp >= 0.9
let code = trial
let decision = 1
end
echo 193 7 $&trial $&cmp $&top 0.89296875 $&decision >> decisions.csv
let trial = code + 64
let drive = (floor(trial / 1) - 2*floor(trial / 2))*1.8
alter VB0 = $&drive
let drive = (floor(trial / 2) - 2*floor(trial / 4))*1.8
alter VB1 = $&drive
let drive = (floor(trial / 4) - 2*floor(trial / 8))*1.8
alter VB2 = $&drive
let drive = (floor(trial / 8) - 2*floor(trial / 16))*1.8
alter VB3 = $&drive
let drive = (floor(trial / 16) - 2*floor(trial / 32))*1.8
alter VB4 = $&drive
let drive = (floor(trial / 32) - 2*floor(trial / 64))*1.8
alter VB5 = $&drive
let drive = (floor(trial / 64) - 2*floor(trial / 128))*1.8
alter VB6 = $&drive
let drive = (floor(trial / 128) - 2*floor(trial / 256))*1.8
alter VB7 = $&drive
stop when time = 0.00348
resume
delete all
let endpoint = length(time)-1
let cmp = v(COMP)[endpoint]
let top = v(TOP)[endpoint]
let decision = 0
if cmp >= 0.9
let code = trial
let decision = 1
end
echo 193 6 $&trial $&cmp $&top 0.89296875 $&decision >> decisions.csv
let trial = code + 32
let drive = (floor(trial / 1) - 2*floor(trial / 2))*1.8
alter VB0 = $&drive
let drive = (floor(trial / 2) - 2*floor(trial / 4))*1.8
alter VB1 = $&drive
let drive = (floor(trial / 4) - 2*floor(trial / 8))*1.8
alter VB2 = $&drive
let drive = (floor(trial / 8) - 2*floor(trial / 16))*1.8
alter VB3 = $&drive
let drive = (floor(trial / 16) - 2*floor(trial / 32))*1.8
alter VB4 = $&drive
let drive = (floor(trial / 32) - 2*floor(trial / 64))*1.8
alter VB5 = $&drive
let drive = (floor(trial / 64) - 2*floor(trial / 128))*1.8
alter VB6 = $&drive
let drive = (floor(trial / 128) - 2*floor(trial / 256))*1.8
alter VB7 = $&drive
stop when time = 0.003482
resume
delete all
let endpoint = length(time)-1
let cmp = v(COMP)[endpoint]
let top = v(TOP)[endpoint]
let decision = 0
if cmp >= 0.9
let code = trial
let decision = 1
end
echo 193 5 $&trial $&cmp $&top 0.89296875 $&decision >> decisions.csv
let trial = code + 16
let drive = (floor(trial / 1) - 2*floor(trial / 2))*1.8
alter VB0 = $&drive
let drive = (floor(trial / 2) - 2*floor(trial / 4))*1.8
alter VB1 = $&drive
let drive = (floor(trial / 4) - 2*floor(trial / 8))*1.8
alter VB2 = $&drive
let drive = (floor(trial / 8) - 2*floor(trial / 16))*1.8
alter VB3 = $&drive
let drive = (floor(trial / 16) - 2*floor(trial / 32))*1.8
alter VB4 = $&drive
let drive = (floor(trial / 32) - 2*floor(trial / 64))*1.8
alter VB5 = $&drive
let drive = (floor(trial / 64) - 2*floor(trial / 128))*1.8
alter VB6 = $&drive
let drive = (floor(trial / 128) - 2*floor(trial / 256))*1.8
alter VB7 = $&drive
stop when time = 0.003484
resume
delete all
let endpoint = length(time)-1
let cmp = v(COMP)[endpoint]
let top = v(TOP)[endpoint]
let decision = 0
if cmp >= 0.9
let code = trial
let decision = 1
end
echo 193 4 $&trial $&cmp $&top 0.89296875 $&decision >> decisions.csv
let trial = code + 8
let drive = (floor(trial / 1) - 2*floor(trial / 2))*1.8
alter VB0 = $&drive
let drive = (floor(trial / 2) - 2*floor(trial / 4))*1.8
alter VB1 = $&drive
let drive = (floor(trial / 4) - 2*floor(trial / 8))*1.8
alter VB2 = $&drive
let drive = (floor(trial / 8) - 2*floor(trial / 16))*1.8
alter VB3 = $&drive
let drive = (floor(trial / 16) - 2*floor(trial / 32))*1.8
alter VB4 = $&drive
let drive = (floor(trial / 32) - 2*floor(trial / 64))*1.8
alter VB5 = $&drive
let drive = (floor(trial / 64) - 2*floor(trial / 128))*1.8
alter VB6 = $&drive
let drive = (floor(trial / 128) - 2*floor(trial / 256))*1.8
alter VB7 = $&drive
stop when time = 0.003486
resume
delete all
let endpoint = length(time)-1
let cmp = v(COMP)[endpoint]
let top = v(TOP)[endpoint]
let decision = 0
if cmp >= 0.9
let code = trial
let decision = 1
end
echo 193 3 $&trial $&cmp $&top 0.89296875 $&decision >> decisions.csv
let trial = code + 4
let drive = (floor(trial / 1) - 2*floor(trial / 2))*1.8
alter VB0 = $&drive
let drive = (floor(trial / 2) - 2*floor(trial / 4))*1.8
alter VB1 = $&drive
let drive = (floor(trial / 4) - 2*floor(trial / 8))*1.8
alter VB2 = $&drive
let drive = (floor(trial / 8) - 2*floor(trial / 16))*1.8
alter VB3 = $&drive
let drive = (floor(trial / 16) - 2*floor(trial / 32))*1.8
alter VB4 = $&drive
let drive = (floor(trial / 32) - 2*floor(trial / 64))*1.8
alter VB5 = $&drive
let drive = (floor(trial / 64) - 2*floor(trial / 128))*1.8
alter VB6 = $&drive
let drive = (floor(trial / 128) - 2*floor(trial / 256))*1.8
alter VB7 = $&drive
stop when time = 0.003488
resume
delete all
let endpoint = length(time)-1
let cmp = v(COMP)[endpoint]
let top = v(TOP)[endpoint]
let decision = 0
if cmp >= 0.9
let code = trial
let decision = 1
end
echo 193 2 $&trial $&cmp $&top 0.89296875 $&decision >> decisions.csv
let trial = code + 2
let drive = (floor(trial / 1) - 2*floor(trial / 2))*1.8
alter VB0 = $&drive
let drive = (floor(trial / 2) - 2*floor(trial / 4))*1.8
alter VB1 = $&drive
let drive = (floor(trial / 4) - 2*floor(trial / 8))*1.8
alter VB2 = $&drive
let drive = (floor(trial / 8) - 2*floor(trial / 16))*1.8
alter VB3 = $&drive
let drive = (floor(trial / 16) - 2*floor(trial / 32))*1.8
alter VB4 = $&drive
let drive = (floor(trial / 32) - 2*floor(trial / 64))*1.8
alter VB5 = $&drive
let drive = (floor(trial / 64) - 2*floor(trial / 128))*1.8
alter VB6 = $&drive
let drive = (floor(trial / 128) - 2*floor(trial / 256))*1.8
alter VB7 = $&drive
stop when time = 0.00349
resume
delete all
let endpoint = length(time)-1
let cmp = v(COMP)[endpoint]
let top = v(TOP)[endpoint]
let decision = 0
if cmp >= 0.9
let code = trial
let decision = 1
end
echo 193 1 $&trial $&cmp $&top 0.89296875 $&decision >> decisions.csv
let trial = code + 1
let drive = (floor(trial / 1) - 2*floor(trial / 2))*1.8
alter VB0 = $&drive
let drive = (floor(trial / 2) - 2*floor(trial / 4))*1.8
alter VB1 = $&drive
let drive = (floor(trial / 4) - 2*floor(trial / 8))*1.8
alter VB2 = $&drive
let drive = (floor(trial / 8) - 2*floor(trial / 16))*1.8
alter VB3 = $&drive
let drive = (floor(trial / 16) - 2*floor(trial / 32))*1.8
alter VB4 = $&drive
let drive = (floor(trial / 32) - 2*floor(trial / 64))*1.8
alter VB5 = $&drive
let drive = (floor(trial / 64) - 2*floor(trial / 128))*1.8
alter VB6 = $&drive
let drive = (floor(trial / 128) - 2*floor(trial / 256))*1.8
alter VB7 = $&drive
stop when time = 0.003492
resume
delete all
let endpoint = length(time)-1
let cmp = v(COMP)[endpoint]
let top = v(TOP)[endpoint]
let decision = 0
if cmp >= 0.9
let code = trial
let decision = 1
end
echo 193 0 $&trial $&cmp $&top 0.89296875 $&decision >> decisions.csv
alter VIN = 0.89765625
alter VSAMPLE = 1.8
alter VB0 = 0
alter VB1 = 0
alter VB2 = 0
alter VB3 = 0
alter VB4 = 0
alter VB5 = 0
alter VB6 = 0
alter VB7 = 0
let code = 0
stop when time = 0.003494
resume
delete all
alter VSAMPLE = 0
let trial = code + 128
let drive = (floor(trial / 1) - 2*floor(trial / 2))*1.8
alter VB0 = $&drive
let drive = (floor(trial / 2) - 2*floor(trial / 4))*1.8
alter VB1 = $&drive
let drive = (floor(trial / 4) - 2*floor(trial / 8))*1.8
alter VB2 = $&drive
let drive = (floor(trial / 8) - 2*floor(trial / 16))*1.8
alter VB3 = $&drive
let drive = (floor(trial / 16) - 2*floor(trial / 32))*1.8
alter VB4 = $&drive
let drive = (floor(trial / 32) - 2*floor(trial / 64))*1.8
alter VB5 = $&drive
let drive = (floor(trial / 64) - 2*floor(trial / 128))*1.8
alter VB6 = $&drive
let drive = (floor(trial / 128) - 2*floor(trial / 256))*1.8
alter VB7 = $&drive
stop when time = 0.003496
resume
delete all
let endpoint = length(time)-1
let cmp = v(COMP)[endpoint]
let top = v(TOP)[endpoint]
let decision = 0
if cmp >= 0.9
let code = trial
let decision = 1
end
echo 194 7 $&trial $&cmp $&top 0.89765625 $&decision >> decisions.csv
let trial = code + 64
let drive = (floor(trial / 1) - 2*floor(trial / 2))*1.8
alter VB0 = $&drive
let drive = (floor(trial / 2) - 2*floor(trial / 4))*1.8
alter VB1 = $&drive
let drive = (floor(trial / 4) - 2*floor(trial / 8))*1.8
alter VB2 = $&drive
let drive = (floor(trial / 8) - 2*floor(trial / 16))*1.8
alter VB3 = $&drive
let drive = (floor(trial / 16) - 2*floor(trial / 32))*1.8
alter VB4 = $&drive
let drive = (floor(trial / 32) - 2*floor(trial / 64))*1.8
alter VB5 = $&drive
let drive = (floor(trial / 64) - 2*floor(trial / 128))*1.8
alter VB6 = $&drive
let drive = (floor(trial / 128) - 2*floor(trial / 256))*1.8
alter VB7 = $&drive
stop when time = 0.003498
resume
delete all
let endpoint = length(time)-1
let cmp = v(COMP)[endpoint]
let top = v(TOP)[endpoint]
let decision = 0
if cmp >= 0.9
let code = trial
let decision = 1
end
echo 194 6 $&trial $&cmp $&top 0.89765625 $&decision >> decisions.csv
let trial = code + 32
let drive = (floor(trial / 1) - 2*floor(trial / 2))*1.8
alter VB0 = $&drive
let drive = (floor(trial / 2) - 2*floor(trial / 4))*1.8
alter VB1 = $&drive
let drive = (floor(trial / 4) - 2*floor(trial / 8))*1.8
alter VB2 = $&drive
let drive = (floor(trial / 8) - 2*floor(trial / 16))*1.8
alter VB3 = $&drive
let drive = (floor(trial / 16) - 2*floor(trial / 32))*1.8
alter VB4 = $&drive
let drive = (floor(trial / 32) - 2*floor(trial / 64))*1.8
alter VB5 = $&drive
let drive = (floor(trial / 64) - 2*floor(trial / 128))*1.8
alter VB6 = $&drive
let drive = (floor(trial / 128) - 2*floor(trial / 256))*1.8
alter VB7 = $&drive
stop when time = 0.0035
resume
delete all
let endpoint = length(time)-1
let cmp = v(COMP)[endpoint]
let top = v(TOP)[endpoint]
let decision = 0
if cmp >= 0.9
let code = trial
let decision = 1
end
echo 194 5 $&trial $&cmp $&top 0.89765625 $&decision >> decisions.csv
let trial = code + 16
let drive = (floor(trial / 1) - 2*floor(trial / 2))*1.8
alter VB0 = $&drive
let drive = (floor(trial / 2) - 2*floor(trial / 4))*1.8
alter VB1 = $&drive
let drive = (floor(trial / 4) - 2*floor(trial / 8))*1.8
alter VB2 = $&drive
let drive = (floor(trial / 8) - 2*floor(trial / 16))*1.8
alter VB3 = $&drive
let drive = (floor(trial / 16) - 2*floor(trial / 32))*1.8
alter VB4 = $&drive
let drive = (floor(trial / 32) - 2*floor(trial / 64))*1.8
alter VB5 = $&drive
let drive = (floor(trial / 64) - 2*floor(trial / 128))*1.8
alter VB6 = $&drive
let drive = (floor(trial / 128) - 2*floor(trial / 256))*1.8
alter VB7 = $&drive
stop when time = 0.003502
resume
delete all
let endpoint = length(time)-1
let cmp = v(COMP)[endpoint]
let top = v(TOP)[endpoint]
let decision = 0
if cmp >= 0.9
let code = trial
let decision = 1
end
echo 194 4 $&trial $&cmp $&top 0.89765625 $&decision >> decisions.csv
let trial = code + 8
let drive = (floor(trial / 1) - 2*floor(trial / 2))*1.8
alter VB0 = $&drive
let drive = (floor(trial / 2) - 2*floor(trial / 4))*1.8
alter VB1 = $&drive
let drive = (floor(trial / 4) - 2*floor(trial / 8))*1.8
alter VB2 = $&drive
let drive = (floor(trial / 8) - 2*floor(trial / 16))*1.8
alter VB3 = $&drive
let drive = (floor(trial / 16) - 2*floor(trial / 32))*1.8
alter VB4 = $&drive
let drive = (floor(trial / 32) - 2*floor(trial / 64))*1.8
alter VB5 = $&drive
let drive = (floor(trial / 64) - 2*floor(trial / 128))*1.8
alter VB6 = $&drive
let drive = (floor(trial / 128) - 2*floor(trial / 256))*1.8
alter VB7 = $&drive
stop when time = 0.003504
resume
delete all
let endpoint = length(time)-1
let cmp = v(COMP)[endpoint]
let top = v(TOP)[endpoint]
let decision = 0
if cmp >= 0.9
let code = trial
let decision = 1
end
echo 194 3 $&trial $&cmp $&top 0.89765625 $&decision >> decisions.csv
let trial = code + 4
let drive = (floor(trial / 1) - 2*floor(trial / 2))*1.8
alter VB0 = $&drive
let drive = (floor(trial / 2) - 2*floor(trial / 4))*1.8
alter VB1 = $&drive
let drive = (floor(trial / 4) - 2*floor(trial / 8))*1.8
alter VB2 = $&drive
let drive = (floor(trial / 8) - 2*floor(trial / 16))*1.8
alter VB3 = $&drive
let drive = (floor(trial / 16) - 2*floor(trial / 32))*1.8
alter VB4 = $&drive
let drive = (floor(trial / 32) - 2*floor(trial / 64))*1.8
alter VB5 = $&drive
let drive = (floor(trial / 64) - 2*floor(trial / 128))*1.8
alter VB6 = $&drive
let drive = (floor(trial / 128) - 2*floor(trial / 256))*1.8
alter VB7 = $&drive
stop when time = 0.003506
resume
delete all
let endpoint = length(time)-1
let cmp = v(COMP)[endpoint]
let top = v(TOP)[endpoint]
let decision = 0
if cmp >= 0.9
let code = trial
let decision = 1
end
echo 194 2 $&trial $&cmp $&top 0.89765625 $&decision >> decisions.csv
let trial = code + 2
let drive = (floor(trial / 1) - 2*floor(trial / 2))*1.8
alter VB0 = $&drive
let drive = (floor(trial / 2) - 2*floor(trial / 4))*1.8
alter VB1 = $&drive
let drive = (floor(trial / 4) - 2*floor(trial / 8))*1.8
alter VB2 = $&drive
let drive = (floor(trial / 8) - 2*floor(trial / 16))*1.8
alter VB3 = $&drive
let drive = (floor(trial / 16) - 2*floor(trial / 32))*1.8
alter VB4 = $&drive
let drive = (floor(trial / 32) - 2*floor(trial / 64))*1.8
alter VB5 = $&drive
let drive = (floor(trial / 64) - 2*floor(trial / 128))*1.8
alter VB6 = $&drive
let drive = (floor(trial / 128) - 2*floor(trial / 256))*1.8
alter VB7 = $&drive
stop when time = 0.003508
resume
delete all
let endpoint = length(time)-1
let cmp = v(COMP)[endpoint]
let top = v(TOP)[endpoint]
let decision = 0
if cmp >= 0.9
let code = trial
let decision = 1
end
echo 194 1 $&trial $&cmp $&top 0.89765625 $&decision >> decisions.csv
let trial = code + 1
let drive = (floor(trial / 1) - 2*floor(trial / 2))*1.8
alter VB0 = $&drive
let drive = (floor(trial / 2) - 2*floor(trial / 4))*1.8
alter VB1 = $&drive
let drive = (floor(trial / 4) - 2*floor(trial / 8))*1.8
alter VB2 = $&drive
let drive = (floor(trial / 8) - 2*floor(trial / 16))*1.8
alter VB3 = $&drive
let drive = (floor(trial / 16) - 2*floor(trial / 32))*1.8
alter VB4 = $&drive
let drive = (floor(trial / 32) - 2*floor(trial / 64))*1.8
alter VB5 = $&drive
let drive = (floor(trial / 64) - 2*floor(trial / 128))*1.8
alter VB6 = $&drive
let drive = (floor(trial / 128) - 2*floor(trial / 256))*1.8
alter VB7 = $&drive
stop when time = 0.00351
resume
delete all
let endpoint = length(time)-1
let cmp = v(COMP)[endpoint]
let top = v(TOP)[endpoint]
let decision = 0
if cmp >= 0.9
let code = trial
let decision = 1
end
echo 194 0 $&trial $&cmp $&top 0.89765625 $&decision >> decisions.csv
alter VIN = 0.90234375
alter VSAMPLE = 1.8
alter VB0 = 0
alter VB1 = 0
alter VB2 = 0
alter VB3 = 0
alter VB4 = 0
alter VB5 = 0
alter VB6 = 0
alter VB7 = 0
let code = 0
stop when time = 0.003512
resume
delete all
alter VSAMPLE = 0
let trial = code + 128
let drive = (floor(trial / 1) - 2*floor(trial / 2))*1.8
alter VB0 = $&drive
let drive = (floor(trial / 2) - 2*floor(trial / 4))*1.8
alter VB1 = $&drive
let drive = (floor(trial / 4) - 2*floor(trial / 8))*1.8
alter VB2 = $&drive
let drive = (floor(trial / 8) - 2*floor(trial / 16))*1.8
alter VB3 = $&drive
let drive = (floor(trial / 16) - 2*floor(trial / 32))*1.8
alter VB4 = $&drive
let drive = (floor(trial / 32) - 2*floor(trial / 64))*1.8
alter VB5 = $&drive
let drive = (floor(trial / 64) - 2*floor(trial / 128))*1.8
alter VB6 = $&drive
let drive = (floor(trial / 128) - 2*floor(trial / 256))*1.8
alter VB7 = $&drive
stop when time = 0.003514
resume
delete all
let endpoint = length(time)-1
let cmp = v(COMP)[endpoint]
let top = v(TOP)[endpoint]
let decision = 0
if cmp >= 0.9
let code = trial
let decision = 1
end
echo 195 7 $&trial $&cmp $&top 0.90234375 $&decision >> decisions.csv
let trial = code + 64
let drive = (floor(trial / 1) - 2*floor(trial / 2))*1.8
alter VB0 = $&drive
let drive = (floor(trial / 2) - 2*floor(trial / 4))*1.8
alter VB1 = $&drive
let drive = (floor(trial / 4) - 2*floor(trial / 8))*1.8
alter VB2 = $&drive
let drive = (floor(trial / 8) - 2*floor(trial / 16))*1.8
alter VB3 = $&drive
let drive = (floor(trial / 16) - 2*floor(trial / 32))*1.8
alter VB4 = $&drive
let drive = (floor(trial / 32) - 2*floor(trial / 64))*1.8
alter VB5 = $&drive
let drive = (floor(trial / 64) - 2*floor(trial / 128))*1.8
alter VB6 = $&drive
let drive = (floor(trial / 128) - 2*floor(trial / 256))*1.8
alter VB7 = $&drive
stop when time = 0.003516
resume
delete all
let endpoint = length(time)-1
let cmp = v(COMP)[endpoint]
let top = v(TOP)[endpoint]
let decision = 0
if cmp >= 0.9
let code = trial
let decision = 1
end
echo 195 6 $&trial $&cmp $&top 0.90234375 $&decision >> decisions.csv
let trial = code + 32
let drive = (floor(trial / 1) - 2*floor(trial / 2))*1.8
alter VB0 = $&drive
let drive = (floor(trial / 2) - 2*floor(trial / 4))*1.8
alter VB1 = $&drive
let drive = (floor(trial / 4) - 2*floor(trial / 8))*1.8
alter VB2 = $&drive
let drive = (floor(trial / 8) - 2*floor(trial / 16))*1.8
alter VB3 = $&drive
let drive = (floor(trial / 16) - 2*floor(trial / 32))*1.8
alter VB4 = $&drive
let drive = (floor(trial / 32) - 2*floor(trial / 64))*1.8
alter VB5 = $&drive
let drive = (floor(trial / 64) - 2*floor(trial / 128))*1.8
alter VB6 = $&drive
let drive = (floor(trial / 128) - 2*floor(trial / 256))*1.8
alter VB7 = $&drive
stop when time = 0.003518
resume
delete all
let endpoint = length(time)-1
let cmp = v(COMP)[endpoint]
let top = v(TOP)[endpoint]
let decision = 0
if cmp >= 0.9
let code = trial
let decision = 1
end
echo 195 5 $&trial $&cmp $&top 0.90234375 $&decision >> decisions.csv
let trial = code + 16
let drive = (floor(trial / 1) - 2*floor(trial / 2))*1.8
alter VB0 = $&drive
let drive = (floor(trial / 2) - 2*floor(trial / 4))*1.8
alter VB1 = $&drive
let drive = (floor(trial / 4) - 2*floor(trial / 8))*1.8
alter VB2 = $&drive
let drive = (floor(trial / 8) - 2*floor(trial / 16))*1.8
alter VB3 = $&drive
let drive = (floor(trial / 16) - 2*floor(trial / 32))*1.8
alter VB4 = $&drive
let drive = (floor(trial / 32) - 2*floor(trial / 64))*1.8
alter VB5 = $&drive
let drive = (floor(trial / 64) - 2*floor(trial / 128))*1.8
alter VB6 = $&drive
let drive = (floor(trial / 128) - 2*floor(trial / 256))*1.8
alter VB7 = $&drive
stop when time = 0.00352
resume
delete all
let endpoint = length(time)-1
let cmp = v(COMP)[endpoint]
let top = v(TOP)[endpoint]
let decision = 0
if cmp >= 0.9
let code = trial
let decision = 1
end
echo 195 4 $&trial $&cmp $&top 0.90234375 $&decision >> decisions.csv
let trial = code + 8
let drive = (floor(trial / 1) - 2*floor(trial / 2))*1.8
alter VB0 = $&drive
let drive = (floor(trial / 2) - 2*floor(trial / 4))*1.8
alter VB1 = $&drive
let drive = (floor(trial / 4) - 2*floor(trial / 8))*1.8
alter VB2 = $&drive
let drive = (floor(trial / 8) - 2*floor(trial / 16))*1.8
alter VB3 = $&drive
let drive = (floor(trial / 16) - 2*floor(trial / 32))*1.8
alter VB4 = $&drive
let drive = (floor(trial / 32) - 2*floor(trial / 64))*1.8
alter VB5 = $&drive
let drive = (floor(trial / 64) - 2*floor(trial / 128))*1.8
alter VB6 = $&drive
let drive = (floor(trial / 128) - 2*floor(trial / 256))*1.8
alter VB7 = $&drive
stop when time = 0.003522
resume
delete all
let endpoint = length(time)-1
let cmp = v(COMP)[endpoint]
let top = v(TOP)[endpoint]
let decision = 0
if cmp >= 0.9
let code = trial
let decision = 1
end
echo 195 3 $&trial $&cmp $&top 0.90234375 $&decision >> decisions.csv
let trial = code + 4
let drive = (floor(trial / 1) - 2*floor(trial / 2))*1.8
alter VB0 = $&drive
let drive = (floor(trial / 2) - 2*floor(trial / 4))*1.8
alter VB1 = $&drive
let drive = (floor(trial / 4) - 2*floor(trial / 8))*1.8
alter VB2 = $&drive
let drive = (floor(trial / 8) - 2*floor(trial / 16))*1.8
alter VB3 = $&drive
let drive = (floor(trial / 16) - 2*floor(trial / 32))*1.8
alter VB4 = $&drive
let drive = (floor(trial / 32) - 2*floor(trial / 64))*1.8
alter VB5 = $&drive
let drive = (floor(trial / 64) - 2*floor(trial / 128))*1.8
alter VB6 = $&drive
let drive = (floor(trial / 128) - 2*floor(trial / 256))*1.8
alter VB7 = $&drive
stop when time = 0.003524
resume
delete all
let endpoint = length(time)-1
let cmp = v(COMP)[endpoint]
let top = v(TOP)[endpoint]
let decision = 0
if cmp >= 0.9
let code = trial
let decision = 1
end
echo 195 2 $&trial $&cmp $&top 0.90234375 $&decision >> decisions.csv
let trial = code + 2
let drive = (floor(trial / 1) - 2*floor(trial / 2))*1.8
alter VB0 = $&drive
let drive = (floor(trial / 2) - 2*floor(trial / 4))*1.8
alter VB1 = $&drive
let drive = (floor(trial / 4) - 2*floor(trial / 8))*1.8
alter VB2 = $&drive
let drive = (floor(trial / 8) - 2*floor(trial / 16))*1.8
alter VB3 = $&drive
let drive = (floor(trial / 16) - 2*floor(trial / 32))*1.8
alter VB4 = $&drive
let drive = (floor(trial / 32) - 2*floor(trial / 64))*1.8
alter VB5 = $&drive
let drive = (floor(trial / 64) - 2*floor(trial / 128))*1.8
alter VB6 = $&drive
let drive = (floor(trial / 128) - 2*floor(trial / 256))*1.8
alter VB7 = $&drive
stop when time = 0.003526
resume
delete all
let endpoint = length(time)-1
let cmp = v(COMP)[endpoint]
let top = v(TOP)[endpoint]
let decision = 0
if cmp >= 0.9
let code = trial
let decision = 1
end
echo 195 1 $&trial $&cmp $&top 0.90234375 $&decision >> decisions.csv
let trial = code + 1
let drive = (floor(trial / 1) - 2*floor(trial / 2))*1.8
alter VB0 = $&drive
let drive = (floor(trial / 2) - 2*floor(trial / 4))*1.8
alter VB1 = $&drive
let drive = (floor(trial / 4) - 2*floor(trial / 8))*1.8
alter VB2 = $&drive
let drive = (floor(trial / 8) - 2*floor(trial / 16))*1.8
alter VB3 = $&drive
let drive = (floor(trial / 16) - 2*floor(trial / 32))*1.8
alter VB4 = $&drive
let drive = (floor(trial / 32) - 2*floor(trial / 64))*1.8
alter VB5 = $&drive
let drive = (floor(trial / 64) - 2*floor(trial / 128))*1.8
alter VB6 = $&drive
let drive = (floor(trial / 128) - 2*floor(trial / 256))*1.8
alter VB7 = $&drive
stop when time = 0.003528
resume
delete all
let endpoint = length(time)-1
let cmp = v(COMP)[endpoint]
let top = v(TOP)[endpoint]
let decision = 0
if cmp >= 0.9
let code = trial
let decision = 1
end
echo 195 0 $&trial $&cmp $&top 0.90234375 $&decision >> decisions.csv
alter VIN = 0.90703125
alter VSAMPLE = 1.8
alter VB0 = 0
alter VB1 = 0
alter VB2 = 0
alter VB3 = 0
alter VB4 = 0
alter VB5 = 0
alter VB6 = 0
alter VB7 = 0
let code = 0
stop when time = 0.00353
resume
delete all
alter VSAMPLE = 0
let trial = code + 128
let drive = (floor(trial / 1) - 2*floor(trial / 2))*1.8
alter VB0 = $&drive
let drive = (floor(trial / 2) - 2*floor(trial / 4))*1.8
alter VB1 = $&drive
let drive = (floor(trial / 4) - 2*floor(trial / 8))*1.8
alter VB2 = $&drive
let drive = (floor(trial / 8) - 2*floor(trial / 16))*1.8
alter VB3 = $&drive
let drive = (floor(trial / 16) - 2*floor(trial / 32))*1.8
alter VB4 = $&drive
let drive = (floor(trial / 32) - 2*floor(trial / 64))*1.8
alter VB5 = $&drive
let drive = (floor(trial / 64) - 2*floor(trial / 128))*1.8
alter VB6 = $&drive
let drive = (floor(trial / 128) - 2*floor(trial / 256))*1.8
alter VB7 = $&drive
stop when time = 0.003532
resume
delete all
let endpoint = length(time)-1
let cmp = v(COMP)[endpoint]
let top = v(TOP)[endpoint]
let decision = 0
if cmp >= 0.9
let code = trial
let decision = 1
end
echo 196 7 $&trial $&cmp $&top 0.90703125 $&decision >> decisions.csv
let trial = code + 64
let drive = (floor(trial / 1) - 2*floor(trial / 2))*1.8
alter VB0 = $&drive
let drive = (floor(trial / 2) - 2*floor(trial / 4))*1.8
alter VB1 = $&drive
let drive = (floor(trial / 4) - 2*floor(trial / 8))*1.8
alter VB2 = $&drive
let drive = (floor(trial / 8) - 2*floor(trial / 16))*1.8
alter VB3 = $&drive
let drive = (floor(trial / 16) - 2*floor(trial / 32))*1.8
alter VB4 = $&drive
let drive = (floor(trial / 32) - 2*floor(trial / 64))*1.8
alter VB5 = $&drive
let drive = (floor(trial / 64) - 2*floor(trial / 128))*1.8
alter VB6 = $&drive
let drive = (floor(trial / 128) - 2*floor(trial / 256))*1.8
alter VB7 = $&drive
stop when time = 0.003534
resume
delete all
let endpoint = length(time)-1
let cmp = v(COMP)[endpoint]
let top = v(TOP)[endpoint]
let decision = 0
if cmp >= 0.9
let code = trial
let decision = 1
end
echo 196 6 $&trial $&cmp $&top 0.90703125 $&decision >> decisions.csv
let trial = code + 32
let drive = (floor(trial / 1) - 2*floor(trial / 2))*1.8
alter VB0 = $&drive
let drive = (floor(trial / 2) - 2*floor(trial / 4))*1.8
alter VB1 = $&drive
let drive = (floor(trial / 4) - 2*floor(trial / 8))*1.8
alter VB2 = $&drive
let drive = (floor(trial / 8) - 2*floor(trial / 16))*1.8
alter VB3 = $&drive
let drive = (floor(trial / 16) - 2*floor(trial / 32))*1.8
alter VB4 = $&drive
let drive = (floor(trial / 32) - 2*floor(trial / 64))*1.8
alter VB5 = $&drive
let drive = (floor(trial / 64) - 2*floor(trial / 128))*1.8
alter VB6 = $&drive
let drive = (floor(trial / 128) - 2*floor(trial / 256))*1.8
alter VB7 = $&drive
stop when time = 0.003536
resume
delete all
let endpoint = length(time)-1
let cmp = v(COMP)[endpoint]
let top = v(TOP)[endpoint]
let decision = 0
if cmp >= 0.9
let code = trial
let decision = 1
end
echo 196 5 $&trial $&cmp $&top 0.90703125 $&decision >> decisions.csv
let trial = code + 16
let drive = (floor(trial / 1) - 2*floor(trial / 2))*1.8
alter VB0 = $&drive
let drive = (floor(trial / 2) - 2*floor(trial / 4))*1.8
alter VB1 = $&drive
let drive = (floor(trial / 4) - 2*floor(trial / 8))*1.8
alter VB2 = $&drive
let drive = (floor(trial / 8) - 2*floor(trial / 16))*1.8
alter VB3 = $&drive
let drive = (floor(trial / 16) - 2*floor(trial / 32))*1.8
alter VB4 = $&drive
let drive = (floor(trial / 32) - 2*floor(trial / 64))*1.8
alter VB5 = $&drive
let drive = (floor(trial / 64) - 2*floor(trial / 128))*1.8
alter VB6 = $&drive
let drive = (floor(trial / 128) - 2*floor(trial / 256))*1.8
alter VB7 = $&drive
stop when time = 0.003538
resume
delete all
let endpoint = length(time)-1
let cmp = v(COMP)[endpoint]
let top = v(TOP)[endpoint]
let decision = 0
if cmp >= 0.9
let code = trial
let decision = 1
end
echo 196 4 $&trial $&cmp $&top 0.90703125 $&decision >> decisions.csv
let trial = code + 8
let drive = (floor(trial / 1) - 2*floor(trial / 2))*1.8
alter VB0 = $&drive
let drive = (floor(trial / 2) - 2*floor(trial / 4))*1.8
alter VB1 = $&drive
let drive = (floor(trial / 4) - 2*floor(trial / 8))*1.8
alter VB2 = $&drive
let drive = (floor(trial / 8) - 2*floor(trial / 16))*1.8
alter VB3 = $&drive
let drive = (floor(trial / 16) - 2*floor(trial / 32))*1.8
alter VB4 = $&drive
let drive = (floor(trial / 32) - 2*floor(trial / 64))*1.8
alter VB5 = $&drive
let drive = (floor(trial / 64) - 2*floor(trial / 128))*1.8
alter VB6 = $&drive
let drive = (floor(trial / 128) - 2*floor(trial / 256))*1.8
alter VB7 = $&drive
stop when time = 0.00354
resume
delete all
let endpoint = length(time)-1
let cmp = v(COMP)[endpoint]
let top = v(TOP)[endpoint]
let decision = 0
if cmp >= 0.9
let code = trial
let decision = 1
end
echo 196 3 $&trial $&cmp $&top 0.90703125 $&decision >> decisions.csv
let trial = code + 4
let drive = (floor(trial / 1) - 2*floor(trial / 2))*1.8
alter VB0 = $&drive
let drive = (floor(trial / 2) - 2*floor(trial / 4))*1.8
alter VB1 = $&drive
let drive = (floor(trial / 4) - 2*floor(trial / 8))*1.8
alter VB2 = $&drive
let drive = (floor(trial / 8) - 2*floor(trial / 16))*1.8
alter VB3 = $&drive
let drive = (floor(trial / 16) - 2*floor(trial / 32))*1.8
alter VB4 = $&drive
let drive = (floor(trial / 32) - 2*floor(trial / 64))*1.8
alter VB5 = $&drive
let drive = (floor(trial / 64) - 2*floor(trial / 128))*1.8
alter VB6 = $&drive
let drive = (floor(trial / 128) - 2*floor(trial / 256))*1.8
alter VB7 = $&drive
stop when time = 0.003542
resume
delete all
let endpoint = length(time)-1
let cmp = v(COMP)[endpoint]
let top = v(TOP)[endpoint]
let decision = 0
if cmp >= 0.9
let code = trial
let decision = 1
end
echo 196 2 $&trial $&cmp $&top 0.90703125 $&decision >> decisions.csv
let trial = code + 2
let drive = (floor(trial / 1) - 2*floor(trial / 2))*1.8
alter VB0 = $&drive
let drive = (floor(trial / 2) - 2*floor(trial / 4))*1.8
alter VB1 = $&drive
let drive = (floor(trial / 4) - 2*floor(trial / 8))*1.8
alter VB2 = $&drive
let drive = (floor(trial / 8) - 2*floor(trial / 16))*1.8
alter VB3 = $&drive
let drive = (floor(trial / 16) - 2*floor(trial / 32))*1.8
alter VB4 = $&drive
let drive = (floor(trial / 32) - 2*floor(trial / 64))*1.8
alter VB5 = $&drive
let drive = (floor(trial / 64) - 2*floor(trial / 128))*1.8
alter VB6 = $&drive
let drive = (floor(trial / 128) - 2*floor(trial / 256))*1.8
alter VB7 = $&drive
stop when time = 0.003544
resume
delete all
let endpoint = length(time)-1
let cmp = v(COMP)[endpoint]
let top = v(TOP)[endpoint]
let decision = 0
if cmp >= 0.9
let code = trial
let decision = 1
end
echo 196 1 $&trial $&cmp $&top 0.90703125 $&decision >> decisions.csv
let trial = code + 1
let drive = (floor(trial / 1) - 2*floor(trial / 2))*1.8
alter VB0 = $&drive
let drive = (floor(trial / 2) - 2*floor(trial / 4))*1.8
alter VB1 = $&drive
let drive = (floor(trial / 4) - 2*floor(trial / 8))*1.8
alter VB2 = $&drive
let drive = (floor(trial / 8) - 2*floor(trial / 16))*1.8
alter VB3 = $&drive
let drive = (floor(trial / 16) - 2*floor(trial / 32))*1.8
alter VB4 = $&drive
let drive = (floor(trial / 32) - 2*floor(trial / 64))*1.8
alter VB5 = $&drive
let drive = (floor(trial / 64) - 2*floor(trial / 128))*1.8
alter VB6 = $&drive
let drive = (floor(trial / 128) - 2*floor(trial / 256))*1.8
alter VB7 = $&drive
stop when time = 0.003546
resume
delete all
let endpoint = length(time)-1
let cmp = v(COMP)[endpoint]
let top = v(TOP)[endpoint]
let decision = 0
if cmp >= 0.9
let code = trial
let decision = 1
end
echo 196 0 $&trial $&cmp $&top 0.90703125 $&decision >> decisions.csv
alter VIN = 0.91171875
alter VSAMPLE = 1.8
alter VB0 = 0
alter VB1 = 0
alter VB2 = 0
alter VB3 = 0
alter VB4 = 0
alter VB5 = 0
alter VB6 = 0
alter VB7 = 0
let code = 0
stop when time = 0.003548
resume
delete all
alter VSAMPLE = 0
let trial = code + 128
let drive = (floor(trial / 1) - 2*floor(trial / 2))*1.8
alter VB0 = $&drive
let drive = (floor(trial / 2) - 2*floor(trial / 4))*1.8
alter VB1 = $&drive
let drive = (floor(trial / 4) - 2*floor(trial / 8))*1.8
alter VB2 = $&drive
let drive = (floor(trial / 8) - 2*floor(trial / 16))*1.8
alter VB3 = $&drive
let drive = (floor(trial / 16) - 2*floor(trial / 32))*1.8
alter VB4 = $&drive
let drive = (floor(trial / 32) - 2*floor(trial / 64))*1.8
alter VB5 = $&drive
let drive = (floor(trial / 64) - 2*floor(trial / 128))*1.8
alter VB6 = $&drive
let drive = (floor(trial / 128) - 2*floor(trial / 256))*1.8
alter VB7 = $&drive
stop when time = 0.00355
resume
delete all
let endpoint = length(time)-1
let cmp = v(COMP)[endpoint]
let top = v(TOP)[endpoint]
let decision = 0
if cmp >= 0.9
let code = trial
let decision = 1
end
echo 197 7 $&trial $&cmp $&top 0.91171875 $&decision >> decisions.csv
let trial = code + 64
let drive = (floor(trial / 1) - 2*floor(trial / 2))*1.8
alter VB0 = $&drive
let drive = (floor(trial / 2) - 2*floor(trial / 4))*1.8
alter VB1 = $&drive
let drive = (floor(trial / 4) - 2*floor(trial / 8))*1.8
alter VB2 = $&drive
let drive = (floor(trial / 8) - 2*floor(trial / 16))*1.8
alter VB3 = $&drive
let drive = (floor(trial / 16) - 2*floor(trial / 32))*1.8
alter VB4 = $&drive
let drive = (floor(trial / 32) - 2*floor(trial / 64))*1.8
alter VB5 = $&drive
let drive = (floor(trial / 64) - 2*floor(trial / 128))*1.8
alter VB6 = $&drive
let drive = (floor(trial / 128) - 2*floor(trial / 256))*1.8
alter VB7 = $&drive
stop when time = 0.003552
resume
delete all
let endpoint = length(time)-1
let cmp = v(COMP)[endpoint]
let top = v(TOP)[endpoint]
let decision = 0
if cmp >= 0.9
let code = trial
let decision = 1
end
echo 197 6 $&trial $&cmp $&top 0.91171875 $&decision >> decisions.csv
let trial = code + 32
let drive = (floor(trial / 1) - 2*floor(trial / 2))*1.8
alter VB0 = $&drive
let drive = (floor(trial / 2) - 2*floor(trial / 4))*1.8
alter VB1 = $&drive
let drive = (floor(trial / 4) - 2*floor(trial / 8))*1.8
alter VB2 = $&drive
let drive = (floor(trial / 8) - 2*floor(trial / 16))*1.8
alter VB3 = $&drive
let drive = (floor(trial / 16) - 2*floor(trial / 32))*1.8
alter VB4 = $&drive
let drive = (floor(trial / 32) - 2*floor(trial / 64))*1.8
alter VB5 = $&drive
let drive = (floor(trial / 64) - 2*floor(trial / 128))*1.8
alter VB6 = $&drive
let drive = (floor(trial / 128) - 2*floor(trial / 256))*1.8
alter VB7 = $&drive
stop when time = 0.003554
resume
delete all
let endpoint = length(time)-1
let cmp = v(COMP)[endpoint]
let top = v(TOP)[endpoint]
let decision = 0
if cmp >= 0.9
let code = trial
let decision = 1
end
echo 197 5 $&trial $&cmp $&top 0.91171875 $&decision >> decisions.csv
let trial = code + 16
let drive = (floor(trial / 1) - 2*floor(trial / 2))*1.8
alter VB0 = $&drive
let drive = (floor(trial / 2) - 2*floor(trial / 4))*1.8
alter VB1 = $&drive
let drive = (floor(trial / 4) - 2*floor(trial / 8))*1.8
alter VB2 = $&drive
let drive = (floor(trial / 8) - 2*floor(trial / 16))*1.8
alter VB3 = $&drive
let drive = (floor(trial / 16) - 2*floor(trial / 32))*1.8
alter VB4 = $&drive
let drive = (floor(trial / 32) - 2*floor(trial / 64))*1.8
alter VB5 = $&drive
let drive = (floor(trial / 64) - 2*floor(trial / 128))*1.8
alter VB6 = $&drive
let drive = (floor(trial / 128) - 2*floor(trial / 256))*1.8
alter VB7 = $&drive
stop when time = 0.003556
resume
delete all
let endpoint = length(time)-1
let cmp = v(COMP)[endpoint]
let top = v(TOP)[endpoint]
let decision = 0
if cmp >= 0.9
let code = trial
let decision = 1
end
echo 197 4 $&trial $&cmp $&top 0.91171875 $&decision >> decisions.csv
let trial = code + 8
let drive = (floor(trial / 1) - 2*floor(trial / 2))*1.8
alter VB0 = $&drive
let drive = (floor(trial / 2) - 2*floor(trial / 4))*1.8
alter VB1 = $&drive
let drive = (floor(trial / 4) - 2*floor(trial / 8))*1.8
alter VB2 = $&drive
let drive = (floor(trial / 8) - 2*floor(trial / 16))*1.8
alter VB3 = $&drive
let drive = (floor(trial / 16) - 2*floor(trial / 32))*1.8
alter VB4 = $&drive
let drive = (floor(trial / 32) - 2*floor(trial / 64))*1.8
alter VB5 = $&drive
let drive = (floor(trial / 64) - 2*floor(trial / 128))*1.8
alter VB6 = $&drive
let drive = (floor(trial / 128) - 2*floor(trial / 256))*1.8
alter VB7 = $&drive
stop when time = 0.003558
resume
delete all
let endpoint = length(time)-1
let cmp = v(COMP)[endpoint]
let top = v(TOP)[endpoint]
let decision = 0
if cmp >= 0.9
let code = trial
let decision = 1
end
echo 197 3 $&trial $&cmp $&top 0.91171875 $&decision >> decisions.csv
let trial = code + 4
let drive = (floor(trial / 1) - 2*floor(trial / 2))*1.8
alter VB0 = $&drive
let drive = (floor(trial / 2) - 2*floor(trial / 4))*1.8
alter VB1 = $&drive
let drive = (floor(trial / 4) - 2*floor(trial / 8))*1.8
alter VB2 = $&drive
let drive = (floor(trial / 8) - 2*floor(trial / 16))*1.8
alter VB3 = $&drive
let drive = (floor(trial / 16) - 2*floor(trial / 32))*1.8
alter VB4 = $&drive
let drive = (floor(trial / 32) - 2*floor(trial / 64))*1.8
alter VB5 = $&drive
let drive = (floor(trial / 64) - 2*floor(trial / 128))*1.8
alter VB6 = $&drive
let drive = (floor(trial / 128) - 2*floor(trial / 256))*1.8
alter VB7 = $&drive
stop when time = 0.00356
resume
delete all
let endpoint = length(time)-1
let cmp = v(COMP)[endpoint]
let top = v(TOP)[endpoint]
let decision = 0
if cmp >= 0.9
let code = trial
let decision = 1
end
echo 197 2 $&trial $&cmp $&top 0.91171875 $&decision >> decisions.csv
let trial = code + 2
let drive = (floor(trial / 1) - 2*floor(trial / 2))*1.8
alter VB0 = $&drive
let drive = (floor(trial / 2) - 2*floor(trial / 4))*1.8
alter VB1 = $&drive
let drive = (floor(trial / 4) - 2*floor(trial / 8))*1.8
alter VB2 = $&drive
let drive = (floor(trial / 8) - 2*floor(trial / 16))*1.8
alter VB3 = $&drive
let drive = (floor(trial / 16) - 2*floor(trial / 32))*1.8
alter VB4 = $&drive
let drive = (floor(trial / 32) - 2*floor(trial / 64))*1.8
alter VB5 = $&drive
let drive = (floor(trial / 64) - 2*floor(trial / 128))*1.8
alter VB6 = $&drive
let drive = (floor(trial / 128) - 2*floor(trial / 256))*1.8
alter VB7 = $&drive
stop when time = 0.003562
resume
delete all
let endpoint = length(time)-1
let cmp = v(COMP)[endpoint]
let top = v(TOP)[endpoint]
let decision = 0
if cmp >= 0.9
let code = trial
let decision = 1
end
echo 197 1 $&trial $&cmp $&top 0.91171875 $&decision >> decisions.csv
let trial = code + 1
let drive = (floor(trial / 1) - 2*floor(trial / 2))*1.8
alter VB0 = $&drive
let drive = (floor(trial / 2) - 2*floor(trial / 4))*1.8
alter VB1 = $&drive
let drive = (floor(trial / 4) - 2*floor(trial / 8))*1.8
alter VB2 = $&drive
let drive = (floor(trial / 8) - 2*floor(trial / 16))*1.8
alter VB3 = $&drive
let drive = (floor(trial / 16) - 2*floor(trial / 32))*1.8
alter VB4 = $&drive
let drive = (floor(trial / 32) - 2*floor(trial / 64))*1.8
alter VB5 = $&drive
let drive = (floor(trial / 64) - 2*floor(trial / 128))*1.8
alter VB6 = $&drive
let drive = (floor(trial / 128) - 2*floor(trial / 256))*1.8
alter VB7 = $&drive
stop when time = 0.003564
resume
delete all
let endpoint = length(time)-1
let cmp = v(COMP)[endpoint]
let top = v(TOP)[endpoint]
let decision = 0
if cmp >= 0.9
let code = trial
let decision = 1
end
echo 197 0 $&trial $&cmp $&top 0.91171875 $&decision >> decisions.csv
alter VIN = 0.91640625
alter VSAMPLE = 1.8
alter VB0 = 0
alter VB1 = 0
alter VB2 = 0
alter VB3 = 0
alter VB4 = 0
alter VB5 = 0
alter VB6 = 0
alter VB7 = 0
let code = 0
stop when time = 0.003566
resume
delete all
alter VSAMPLE = 0
let trial = code + 128
let drive = (floor(trial / 1) - 2*floor(trial / 2))*1.8
alter VB0 = $&drive
let drive = (floor(trial / 2) - 2*floor(trial / 4))*1.8
alter VB1 = $&drive
let drive = (floor(trial / 4) - 2*floor(trial / 8))*1.8
alter VB2 = $&drive
let drive = (floor(trial / 8) - 2*floor(trial / 16))*1.8
alter VB3 = $&drive
let drive = (floor(trial / 16) - 2*floor(trial / 32))*1.8
alter VB4 = $&drive
let drive = (floor(trial / 32) - 2*floor(trial / 64))*1.8
alter VB5 = $&drive
let drive = (floor(trial / 64) - 2*floor(trial / 128))*1.8
alter VB6 = $&drive
let drive = (floor(trial / 128) - 2*floor(trial / 256))*1.8
alter VB7 = $&drive
stop when time = 0.003568
resume
delete all
let endpoint = length(time)-1
let cmp = v(COMP)[endpoint]
let top = v(TOP)[endpoint]
let decision = 0
if cmp >= 0.9
let code = trial
let decision = 1
end
echo 198 7 $&trial $&cmp $&top 0.91640625 $&decision >> decisions.csv
let trial = code + 64
let drive = (floor(trial / 1) - 2*floor(trial / 2))*1.8
alter VB0 = $&drive
let drive = (floor(trial / 2) - 2*floor(trial / 4))*1.8
alter VB1 = $&drive
let drive = (floor(trial / 4) - 2*floor(trial / 8))*1.8
alter VB2 = $&drive
let drive = (floor(trial / 8) - 2*floor(trial / 16))*1.8
alter VB3 = $&drive
let drive = (floor(trial / 16) - 2*floor(trial / 32))*1.8
alter VB4 = $&drive
let drive = (floor(trial / 32) - 2*floor(trial / 64))*1.8
alter VB5 = $&drive
let drive = (floor(trial / 64) - 2*floor(trial / 128))*1.8
alter VB6 = $&drive
let drive = (floor(trial / 128) - 2*floor(trial / 256))*1.8
alter VB7 = $&drive
stop when time = 0.00357
resume
delete all
let endpoint = length(time)-1
let cmp = v(COMP)[endpoint]
let top = v(TOP)[endpoint]
let decision = 0
if cmp >= 0.9
let code = trial
let decision = 1
end
echo 198 6 $&trial $&cmp $&top 0.91640625 $&decision >> decisions.csv
let trial = code + 32
let drive = (floor(trial / 1) - 2*floor(trial / 2))*1.8
alter VB0 = $&drive
let drive = (floor(trial / 2) - 2*floor(trial / 4))*1.8
alter VB1 = $&drive
let drive = (floor(trial / 4) - 2*floor(trial / 8))*1.8
alter VB2 = $&drive
let drive = (floor(trial / 8) - 2*floor(trial / 16))*1.8
alter VB3 = $&drive
let drive = (floor(trial / 16) - 2*floor(trial / 32))*1.8
alter VB4 = $&drive
let drive = (floor(trial / 32) - 2*floor(trial / 64))*1.8
alter VB5 = $&drive
let drive = (floor(trial / 64) - 2*floor(trial / 128))*1.8
alter VB6 = $&drive
let drive = (floor(trial / 128) - 2*floor(trial / 256))*1.8
alter VB7 = $&drive
stop when time = 0.003572
resume
delete all
let endpoint = length(time)-1
let cmp = v(COMP)[endpoint]
let top = v(TOP)[endpoint]
let decision = 0
if cmp >= 0.9
let code = trial
let decision = 1
end
echo 198 5 $&trial $&cmp $&top 0.91640625 $&decision >> decisions.csv
let trial = code + 16
let drive = (floor(trial / 1) - 2*floor(trial / 2))*1.8
alter VB0 = $&drive
let drive = (floor(trial / 2) - 2*floor(trial / 4))*1.8
alter VB1 = $&drive
let drive = (floor(trial / 4) - 2*floor(trial / 8))*1.8
alter VB2 = $&drive
let drive = (floor(trial / 8) - 2*floor(trial / 16))*1.8
alter VB3 = $&drive
let drive = (floor(trial / 16) - 2*floor(trial / 32))*1.8
alter VB4 = $&drive
let drive = (floor(trial / 32) - 2*floor(trial / 64))*1.8
alter VB5 = $&drive
let drive = (floor(trial / 64) - 2*floor(trial / 128))*1.8
alter VB6 = $&drive
let drive = (floor(trial / 128) - 2*floor(trial / 256))*1.8
alter VB7 = $&drive
stop when time = 0.003574
resume
delete all
let endpoint = length(time)-1
let cmp = v(COMP)[endpoint]
let top = v(TOP)[endpoint]
let decision = 0
if cmp >= 0.9
let code = trial
let decision = 1
end
echo 198 4 $&trial $&cmp $&top 0.91640625 $&decision >> decisions.csv
let trial = code + 8
let drive = (floor(trial / 1) - 2*floor(trial / 2))*1.8
alter VB0 = $&drive
let drive = (floor(trial / 2) - 2*floor(trial / 4))*1.8
alter VB1 = $&drive
let drive = (floor(trial / 4) - 2*floor(trial / 8))*1.8
alter VB2 = $&drive
let drive = (floor(trial / 8) - 2*floor(trial / 16))*1.8
alter VB3 = $&drive
let drive = (floor(trial / 16) - 2*floor(trial / 32))*1.8
alter VB4 = $&drive
let drive = (floor(trial / 32) - 2*floor(trial / 64))*1.8
alter VB5 = $&drive
let drive = (floor(trial / 64) - 2*floor(trial / 128))*1.8
alter VB6 = $&drive
let drive = (floor(trial / 128) - 2*floor(trial / 256))*1.8
alter VB7 = $&drive
stop when time = 0.003576
resume
delete all
let endpoint = length(time)-1
let cmp = v(COMP)[endpoint]
let top = v(TOP)[endpoint]
let decision = 0
if cmp >= 0.9
let code = trial
let decision = 1
end
echo 198 3 $&trial $&cmp $&top 0.91640625 $&decision >> decisions.csv
let trial = code + 4
let drive = (floor(trial / 1) - 2*floor(trial / 2))*1.8
alter VB0 = $&drive
let drive = (floor(trial / 2) - 2*floor(trial / 4))*1.8
alter VB1 = $&drive
let drive = (floor(trial / 4) - 2*floor(trial / 8))*1.8
alter VB2 = $&drive
let drive = (floor(trial / 8) - 2*floor(trial / 16))*1.8
alter VB3 = $&drive
let drive = (floor(trial / 16) - 2*floor(trial / 32))*1.8
alter VB4 = $&drive
let drive = (floor(trial / 32) - 2*floor(trial / 64))*1.8
alter VB5 = $&drive
let drive = (floor(trial / 64) - 2*floor(trial / 128))*1.8
alter VB6 = $&drive
let drive = (floor(trial / 128) - 2*floor(trial / 256))*1.8
alter VB7 = $&drive
stop when time = 0.003578
resume
delete all
let endpoint = length(time)-1
let cmp = v(COMP)[endpoint]
let top = v(TOP)[endpoint]
let decision = 0
if cmp >= 0.9
let code = trial
let decision = 1
end
echo 198 2 $&trial $&cmp $&top 0.91640625 $&decision >> decisions.csv
let trial = code + 2
let drive = (floor(trial / 1) - 2*floor(trial / 2))*1.8
alter VB0 = $&drive
let drive = (floor(trial / 2) - 2*floor(trial / 4))*1.8
alter VB1 = $&drive
let drive = (floor(trial / 4) - 2*floor(trial / 8))*1.8
alter VB2 = $&drive
let drive = (floor(trial / 8) - 2*floor(trial / 16))*1.8
alter VB3 = $&drive
let drive = (floor(trial / 16) - 2*floor(trial / 32))*1.8
alter VB4 = $&drive
let drive = (floor(trial / 32) - 2*floor(trial / 64))*1.8
alter VB5 = $&drive
let drive = (floor(trial / 64) - 2*floor(trial / 128))*1.8
alter VB6 = $&drive
let drive = (floor(trial / 128) - 2*floor(trial / 256))*1.8
alter VB7 = $&drive
stop when time = 0.00358
resume
delete all
let endpoint = length(time)-1
let cmp = v(COMP)[endpoint]
let top = v(TOP)[endpoint]
let decision = 0
if cmp >= 0.9
let code = trial
let decision = 1
end
echo 198 1 $&trial $&cmp $&top 0.91640625 $&decision >> decisions.csv
let trial = code + 1
let drive = (floor(trial / 1) - 2*floor(trial / 2))*1.8
alter VB0 = $&drive
let drive = (floor(trial / 2) - 2*floor(trial / 4))*1.8
alter VB1 = $&drive
let drive = (floor(trial / 4) - 2*floor(trial / 8))*1.8
alter VB2 = $&drive
let drive = (floor(trial / 8) - 2*floor(trial / 16))*1.8
alter VB3 = $&drive
let drive = (floor(trial / 16) - 2*floor(trial / 32))*1.8
alter VB4 = $&drive
let drive = (floor(trial / 32) - 2*floor(trial / 64))*1.8
alter VB5 = $&drive
let drive = (floor(trial / 64) - 2*floor(trial / 128))*1.8
alter VB6 = $&drive
let drive = (floor(trial / 128) - 2*floor(trial / 256))*1.8
alter VB7 = $&drive
stop when time = 0.003582
resume
delete all
let endpoint = length(time)-1
let cmp = v(COMP)[endpoint]
let top = v(TOP)[endpoint]
let decision = 0
if cmp >= 0.9
let code = trial
let decision = 1
end
echo 198 0 $&trial $&cmp $&top 0.91640625 $&decision >> decisions.csv
alter VIN = 0.92109375
alter VSAMPLE = 1.8
alter VB0 = 0
alter VB1 = 0
alter VB2 = 0
alter VB3 = 0
alter VB4 = 0
alter VB5 = 0
alter VB6 = 0
alter VB7 = 0
let code = 0
stop when time = 0.003584
resume
delete all
alter VSAMPLE = 0
let trial = code + 128
let drive = (floor(trial / 1) - 2*floor(trial / 2))*1.8
alter VB0 = $&drive
let drive = (floor(trial / 2) - 2*floor(trial / 4))*1.8
alter VB1 = $&drive
let drive = (floor(trial / 4) - 2*floor(trial / 8))*1.8
alter VB2 = $&drive
let drive = (floor(trial / 8) - 2*floor(trial / 16))*1.8
alter VB3 = $&drive
let drive = (floor(trial / 16) - 2*floor(trial / 32))*1.8
alter VB4 = $&drive
let drive = (floor(trial / 32) - 2*floor(trial / 64))*1.8
alter VB5 = $&drive
let drive = (floor(trial / 64) - 2*floor(trial / 128))*1.8
alter VB6 = $&drive
let drive = (floor(trial / 128) - 2*floor(trial / 256))*1.8
alter VB7 = $&drive
stop when time = 0.003586
resume
delete all
let endpoint = length(time)-1
let cmp = v(COMP)[endpoint]
let top = v(TOP)[endpoint]
let decision = 0
if cmp >= 0.9
let code = trial
let decision = 1
end
echo 199 7 $&trial $&cmp $&top 0.92109375 $&decision >> decisions.csv
let trial = code + 64
let drive = (floor(trial / 1) - 2*floor(trial / 2))*1.8
alter VB0 = $&drive
let drive = (floor(trial / 2) - 2*floor(trial / 4))*1.8
alter VB1 = $&drive
let drive = (floor(trial / 4) - 2*floor(trial / 8))*1.8
alter VB2 = $&drive
let drive = (floor(trial / 8) - 2*floor(trial / 16))*1.8
alter VB3 = $&drive
let drive = (floor(trial / 16) - 2*floor(trial / 32))*1.8
alter VB4 = $&drive
let drive = (floor(trial / 32) - 2*floor(trial / 64))*1.8
alter VB5 = $&drive
let drive = (floor(trial / 64) - 2*floor(trial / 128))*1.8
alter VB6 = $&drive
let drive = (floor(trial / 128) - 2*floor(trial / 256))*1.8
alter VB7 = $&drive
stop when time = 0.003588
resume
delete all
let endpoint = length(time)-1
let cmp = v(COMP)[endpoint]
let top = v(TOP)[endpoint]
let decision = 0
if cmp >= 0.9
let code = trial
let decision = 1
end
echo 199 6 $&trial $&cmp $&top 0.92109375 $&decision >> decisions.csv
let trial = code + 32
let drive = (floor(trial / 1) - 2*floor(trial / 2))*1.8
alter VB0 = $&drive
let drive = (floor(trial / 2) - 2*floor(trial / 4))*1.8
alter VB1 = $&drive
let drive = (floor(trial / 4) - 2*floor(trial / 8))*1.8
alter VB2 = $&drive
let drive = (floor(trial / 8) - 2*floor(trial / 16))*1.8
alter VB3 = $&drive
let drive = (floor(trial / 16) - 2*floor(trial / 32))*1.8
alter VB4 = $&drive
let drive = (floor(trial / 32) - 2*floor(trial / 64))*1.8
alter VB5 = $&drive
let drive = (floor(trial / 64) - 2*floor(trial / 128))*1.8
alter VB6 = $&drive
let drive = (floor(trial / 128) - 2*floor(trial / 256))*1.8
alter VB7 = $&drive
stop when time = 0.00359
resume
delete all
let endpoint = length(time)-1
let cmp = v(COMP)[endpoint]
let top = v(TOP)[endpoint]
let decision = 0
if cmp >= 0.9
let code = trial
let decision = 1
end
echo 199 5 $&trial $&cmp $&top 0.92109375 $&decision >> decisions.csv
let trial = code + 16
let drive = (floor(trial / 1) - 2*floor(trial / 2))*1.8
alter VB0 = $&drive
let drive = (floor(trial / 2) - 2*floor(trial / 4))*1.8
alter VB1 = $&drive
let drive = (floor(trial / 4) - 2*floor(trial / 8))*1.8
alter VB2 = $&drive
let drive = (floor(trial / 8) - 2*floor(trial / 16))*1.8
alter VB3 = $&drive
let drive = (floor(trial / 16) - 2*floor(trial / 32))*1.8
alter VB4 = $&drive
let drive = (floor(trial / 32) - 2*floor(trial / 64))*1.8
alter VB5 = $&drive
let drive = (floor(trial / 64) - 2*floor(trial / 128))*1.8
alter VB6 = $&drive
let drive = (floor(trial / 128) - 2*floor(trial / 256))*1.8
alter VB7 = $&drive
stop when time = 0.003592
resume
delete all
let endpoint = length(time)-1
let cmp = v(COMP)[endpoint]
let top = v(TOP)[endpoint]
let decision = 0
if cmp >= 0.9
let code = trial
let decision = 1
end
echo 199 4 $&trial $&cmp $&top 0.92109375 $&decision >> decisions.csv
let trial = code + 8
let drive = (floor(trial / 1) - 2*floor(trial / 2))*1.8
alter VB0 = $&drive
let drive = (floor(trial / 2) - 2*floor(trial / 4))*1.8
alter VB1 = $&drive
let drive = (floor(trial / 4) - 2*floor(trial / 8))*1.8
alter VB2 = $&drive
let drive = (floor(trial / 8) - 2*floor(trial / 16))*1.8
alter VB3 = $&drive
let drive = (floor(trial / 16) - 2*floor(trial / 32))*1.8
alter VB4 = $&drive
let drive = (floor(trial / 32) - 2*floor(trial / 64))*1.8
alter VB5 = $&drive
let drive = (floor(trial / 64) - 2*floor(trial / 128))*1.8
alter VB6 = $&drive
let drive = (floor(trial / 128) - 2*floor(trial / 256))*1.8
alter VB7 = $&drive
stop when time = 0.003594
resume
delete all
let endpoint = length(time)-1
let cmp = v(COMP)[endpoint]
let top = v(TOP)[endpoint]
let decision = 0
if cmp >= 0.9
let code = trial
let decision = 1
end
echo 199 3 $&trial $&cmp $&top 0.92109375 $&decision >> decisions.csv
let trial = code + 4
let drive = (floor(trial / 1) - 2*floor(trial / 2))*1.8
alter VB0 = $&drive
let drive = (floor(trial / 2) - 2*floor(trial / 4))*1.8
alter VB1 = $&drive
let drive = (floor(trial / 4) - 2*floor(trial / 8))*1.8
alter VB2 = $&drive
let drive = (floor(trial / 8) - 2*floor(trial / 16))*1.8
alter VB3 = $&drive
let drive = (floor(trial / 16) - 2*floor(trial / 32))*1.8
alter VB4 = $&drive
let drive = (floor(trial / 32) - 2*floor(trial / 64))*1.8
alter VB5 = $&drive
let drive = (floor(trial / 64) - 2*floor(trial / 128))*1.8
alter VB6 = $&drive
let drive = (floor(trial / 128) - 2*floor(trial / 256))*1.8
alter VB7 = $&drive
stop when time = 0.003596
resume
delete all
let endpoint = length(time)-1
let cmp = v(COMP)[endpoint]
let top = v(TOP)[endpoint]
let decision = 0
if cmp >= 0.9
let code = trial
let decision = 1
end
echo 199 2 $&trial $&cmp $&top 0.92109375 $&decision >> decisions.csv
let trial = code + 2
let drive = (floor(trial / 1) - 2*floor(trial / 2))*1.8
alter VB0 = $&drive
let drive = (floor(trial / 2) - 2*floor(trial / 4))*1.8
alter VB1 = $&drive
let drive = (floor(trial / 4) - 2*floor(trial / 8))*1.8
alter VB2 = $&drive
let drive = (floor(trial / 8) - 2*floor(trial / 16))*1.8
alter VB3 = $&drive
let drive = (floor(trial / 16) - 2*floor(trial / 32))*1.8
alter VB4 = $&drive
let drive = (floor(trial / 32) - 2*floor(trial / 64))*1.8
alter VB5 = $&drive
let drive = (floor(trial / 64) - 2*floor(trial / 128))*1.8
alter VB6 = $&drive
let drive = (floor(trial / 128) - 2*floor(trial / 256))*1.8
alter VB7 = $&drive
stop when time = 0.003598
resume
delete all
let endpoint = length(time)-1
let cmp = v(COMP)[endpoint]
let top = v(TOP)[endpoint]
let decision = 0
if cmp >= 0.9
let code = trial
let decision = 1
end
echo 199 1 $&trial $&cmp $&top 0.92109375 $&decision >> decisions.csv
let trial = code + 1
let drive = (floor(trial / 1) - 2*floor(trial / 2))*1.8
alter VB0 = $&drive
let drive = (floor(trial / 2) - 2*floor(trial / 4))*1.8
alter VB1 = $&drive
let drive = (floor(trial / 4) - 2*floor(trial / 8))*1.8
alter VB2 = $&drive
let drive = (floor(trial / 8) - 2*floor(trial / 16))*1.8
alter VB3 = $&drive
let drive = (floor(trial / 16) - 2*floor(trial / 32))*1.8
alter VB4 = $&drive
let drive = (floor(trial / 32) - 2*floor(trial / 64))*1.8
alter VB5 = $&drive
let drive = (floor(trial / 64) - 2*floor(trial / 128))*1.8
alter VB6 = $&drive
let drive = (floor(trial / 128) - 2*floor(trial / 256))*1.8
alter VB7 = $&drive
stop when time = 0.0036
resume
delete all
let endpoint = length(time)-1
let cmp = v(COMP)[endpoint]
let top = v(TOP)[endpoint]
let decision = 0
if cmp >= 0.9
let code = trial
let decision = 1
end
echo 199 0 $&trial $&cmp $&top 0.92109375 $&decision >> decisions.csv
alter VIN = 0.92578125
alter VSAMPLE = 1.8
alter VB0 = 0
alter VB1 = 0
alter VB2 = 0
alter VB3 = 0
alter VB4 = 0
alter VB5 = 0
alter VB6 = 0
alter VB7 = 0
let code = 0
stop when time = 0.003602
resume
delete all
alter VSAMPLE = 0
let trial = code + 128
let drive = (floor(trial / 1) - 2*floor(trial / 2))*1.8
alter VB0 = $&drive
let drive = (floor(trial / 2) - 2*floor(trial / 4))*1.8
alter VB1 = $&drive
let drive = (floor(trial / 4) - 2*floor(trial / 8))*1.8
alter VB2 = $&drive
let drive = (floor(trial / 8) - 2*floor(trial / 16))*1.8
alter VB3 = $&drive
let drive = (floor(trial / 16) - 2*floor(trial / 32))*1.8
alter VB4 = $&drive
let drive = (floor(trial / 32) - 2*floor(trial / 64))*1.8
alter VB5 = $&drive
let drive = (floor(trial / 64) - 2*floor(trial / 128))*1.8
alter VB6 = $&drive
let drive = (floor(trial / 128) - 2*floor(trial / 256))*1.8
alter VB7 = $&drive
stop when time = 0.003604
resume
delete all
let endpoint = length(time)-1
let cmp = v(COMP)[endpoint]
let top = v(TOP)[endpoint]
let decision = 0
if cmp >= 0.9
let code = trial
let decision = 1
end
echo 200 7 $&trial $&cmp $&top 0.92578125 $&decision >> decisions.csv
let trial = code + 64
let drive = (floor(trial / 1) - 2*floor(trial / 2))*1.8
alter VB0 = $&drive
let drive = (floor(trial / 2) - 2*floor(trial / 4))*1.8
alter VB1 = $&drive
let drive = (floor(trial / 4) - 2*floor(trial / 8))*1.8
alter VB2 = $&drive
let drive = (floor(trial / 8) - 2*floor(trial / 16))*1.8
alter VB3 = $&drive
let drive = (floor(trial / 16) - 2*floor(trial / 32))*1.8
alter VB4 = $&drive
let drive = (floor(trial / 32) - 2*floor(trial / 64))*1.8
alter VB5 = $&drive
let drive = (floor(trial / 64) - 2*floor(trial / 128))*1.8
alter VB6 = $&drive
let drive = (floor(trial / 128) - 2*floor(trial / 256))*1.8
alter VB7 = $&drive
stop when time = 0.003606
resume
delete all
let endpoint = length(time)-1
let cmp = v(COMP)[endpoint]
let top = v(TOP)[endpoint]
let decision = 0
if cmp >= 0.9
let code = trial
let decision = 1
end
echo 200 6 $&trial $&cmp $&top 0.92578125 $&decision >> decisions.csv
let trial = code + 32
let drive = (floor(trial / 1) - 2*floor(trial / 2))*1.8
alter VB0 = $&drive
let drive = (floor(trial / 2) - 2*floor(trial / 4))*1.8
alter VB1 = $&drive
let drive = (floor(trial / 4) - 2*floor(trial / 8))*1.8
alter VB2 = $&drive
let drive = (floor(trial / 8) - 2*floor(trial / 16))*1.8
alter VB3 = $&drive
let drive = (floor(trial / 16) - 2*floor(trial / 32))*1.8
alter VB4 = $&drive
let drive = (floor(trial / 32) - 2*floor(trial / 64))*1.8
alter VB5 = $&drive
let drive = (floor(trial / 64) - 2*floor(trial / 128))*1.8
alter VB6 = $&drive
let drive = (floor(trial / 128) - 2*floor(trial / 256))*1.8
alter VB7 = $&drive
stop when time = 0.003608
resume
delete all
let endpoint = length(time)-1
let cmp = v(COMP)[endpoint]
let top = v(TOP)[endpoint]
let decision = 0
if cmp >= 0.9
let code = trial
let decision = 1
end
echo 200 5 $&trial $&cmp $&top 0.92578125 $&decision >> decisions.csv
let trial = code + 16
let drive = (floor(trial / 1) - 2*floor(trial / 2))*1.8
alter VB0 = $&drive
let drive = (floor(trial / 2) - 2*floor(trial / 4))*1.8
alter VB1 = $&drive
let drive = (floor(trial / 4) - 2*floor(trial / 8))*1.8
alter VB2 = $&drive
let drive = (floor(trial / 8) - 2*floor(trial / 16))*1.8
alter VB3 = $&drive
let drive = (floor(trial / 16) - 2*floor(trial / 32))*1.8
alter VB4 = $&drive
let drive = (floor(trial / 32) - 2*floor(trial / 64))*1.8
alter VB5 = $&drive
let drive = (floor(trial / 64) - 2*floor(trial / 128))*1.8
alter VB6 = $&drive
let drive = (floor(trial / 128) - 2*floor(trial / 256))*1.8
alter VB7 = $&drive
stop when time = 0.00361
resume
delete all
let endpoint = length(time)-1
let cmp = v(COMP)[endpoint]
let top = v(TOP)[endpoint]
let decision = 0
if cmp >= 0.9
let code = trial
let decision = 1
end
echo 200 4 $&trial $&cmp $&top 0.92578125 $&decision >> decisions.csv
let trial = code + 8
let drive = (floor(trial / 1) - 2*floor(trial / 2))*1.8
alter VB0 = $&drive
let drive = (floor(trial / 2) - 2*floor(trial / 4))*1.8
alter VB1 = $&drive
let drive = (floor(trial / 4) - 2*floor(trial / 8))*1.8
alter VB2 = $&drive
let drive = (floor(trial / 8) - 2*floor(trial / 16))*1.8
alter VB3 = $&drive
let drive = (floor(trial / 16) - 2*floor(trial / 32))*1.8
alter VB4 = $&drive
let drive = (floor(trial / 32) - 2*floor(trial / 64))*1.8
alter VB5 = $&drive
let drive = (floor(trial / 64) - 2*floor(trial / 128))*1.8
alter VB6 = $&drive
let drive = (floor(trial / 128) - 2*floor(trial / 256))*1.8
alter VB7 = $&drive
stop when time = 0.003612
resume
delete all
let endpoint = length(time)-1
let cmp = v(COMP)[endpoint]
let top = v(TOP)[endpoint]
let decision = 0
if cmp >= 0.9
let code = trial
let decision = 1
end
echo 200 3 $&trial $&cmp $&top 0.92578125 $&decision >> decisions.csv
let trial = code + 4
let drive = (floor(trial / 1) - 2*floor(trial / 2))*1.8
alter VB0 = $&drive
let drive = (floor(trial / 2) - 2*floor(trial / 4))*1.8
alter VB1 = $&drive
let drive = (floor(trial / 4) - 2*floor(trial / 8))*1.8
alter VB2 = $&drive
let drive = (floor(trial / 8) - 2*floor(trial / 16))*1.8
alter VB3 = $&drive
let drive = (floor(trial / 16) - 2*floor(trial / 32))*1.8
alter VB4 = $&drive
let drive = (floor(trial / 32) - 2*floor(trial / 64))*1.8
alter VB5 = $&drive
let drive = (floor(trial / 64) - 2*floor(trial / 128))*1.8
alter VB6 = $&drive
let drive = (floor(trial / 128) - 2*floor(trial / 256))*1.8
alter VB7 = $&drive
stop when time = 0.003614
resume
delete all
let endpoint = length(time)-1
let cmp = v(COMP)[endpoint]
let top = v(TOP)[endpoint]
let decision = 0
if cmp >= 0.9
let code = trial
let decision = 1
end
echo 200 2 $&trial $&cmp $&top 0.92578125 $&decision >> decisions.csv
let trial = code + 2
let drive = (floor(trial / 1) - 2*floor(trial / 2))*1.8
alter VB0 = $&drive
let drive = (floor(trial / 2) - 2*floor(trial / 4))*1.8
alter VB1 = $&drive
let drive = (floor(trial / 4) - 2*floor(trial / 8))*1.8
alter VB2 = $&drive
let drive = (floor(trial / 8) - 2*floor(trial / 16))*1.8
alter VB3 = $&drive
let drive = (floor(trial / 16) - 2*floor(trial / 32))*1.8
alter VB4 = $&drive
let drive = (floor(trial / 32) - 2*floor(trial / 64))*1.8
alter VB5 = $&drive
let drive = (floor(trial / 64) - 2*floor(trial / 128))*1.8
alter VB6 = $&drive
let drive = (floor(trial / 128) - 2*floor(trial / 256))*1.8
alter VB7 = $&drive
stop when time = 0.003616
resume
delete all
let endpoint = length(time)-1
let cmp = v(COMP)[endpoint]
let top = v(TOP)[endpoint]
let decision = 0
if cmp >= 0.9
let code = trial
let decision = 1
end
echo 200 1 $&trial $&cmp $&top 0.92578125 $&decision >> decisions.csv
let trial = code + 1
let drive = (floor(trial / 1) - 2*floor(trial / 2))*1.8
alter VB0 = $&drive
let drive = (floor(trial / 2) - 2*floor(trial / 4))*1.8
alter VB1 = $&drive
let drive = (floor(trial / 4) - 2*floor(trial / 8))*1.8
alter VB2 = $&drive
let drive = (floor(trial / 8) - 2*floor(trial / 16))*1.8
alter VB3 = $&drive
let drive = (floor(trial / 16) - 2*floor(trial / 32))*1.8
alter VB4 = $&drive
let drive = (floor(trial / 32) - 2*floor(trial / 64))*1.8
alter VB5 = $&drive
let drive = (floor(trial / 64) - 2*floor(trial / 128))*1.8
alter VB6 = $&drive
let drive = (floor(trial / 128) - 2*floor(trial / 256))*1.8
alter VB7 = $&drive
stop when time = 0.003618
resume
delete all
let endpoint = length(time)-1
let cmp = v(COMP)[endpoint]
let top = v(TOP)[endpoint]
let decision = 0
if cmp >= 0.9
let code = trial
let decision = 1
end
echo 200 0 $&trial $&cmp $&top 0.92578125 $&decision >> decisions.csv
alter VIN = 0.93046875
alter VSAMPLE = 1.8
alter VB0 = 0
alter VB1 = 0
alter VB2 = 0
alter VB3 = 0
alter VB4 = 0
alter VB5 = 0
alter VB6 = 0
alter VB7 = 0
let code = 0
stop when time = 0.00362
resume
delete all
alter VSAMPLE = 0
let trial = code + 128
let drive = (floor(trial / 1) - 2*floor(trial / 2))*1.8
alter VB0 = $&drive
let drive = (floor(trial / 2) - 2*floor(trial / 4))*1.8
alter VB1 = $&drive
let drive = (floor(trial / 4) - 2*floor(trial / 8))*1.8
alter VB2 = $&drive
let drive = (floor(trial / 8) - 2*floor(trial / 16))*1.8
alter VB3 = $&drive
let drive = (floor(trial / 16) - 2*floor(trial / 32))*1.8
alter VB4 = $&drive
let drive = (floor(trial / 32) - 2*floor(trial / 64))*1.8
alter VB5 = $&drive
let drive = (floor(trial / 64) - 2*floor(trial / 128))*1.8
alter VB6 = $&drive
let drive = (floor(trial / 128) - 2*floor(trial / 256))*1.8
alter VB7 = $&drive
stop when time = 0.003622
resume
delete all
let endpoint = length(time)-1
let cmp = v(COMP)[endpoint]
let top = v(TOP)[endpoint]
let decision = 0
if cmp >= 0.9
let code = trial
let decision = 1
end
echo 201 7 $&trial $&cmp $&top 0.93046875 $&decision >> decisions.csv
let trial = code + 64
let drive = (floor(trial / 1) - 2*floor(trial / 2))*1.8
alter VB0 = $&drive
let drive = (floor(trial / 2) - 2*floor(trial / 4))*1.8
alter VB1 = $&drive
let drive = (floor(trial / 4) - 2*floor(trial / 8))*1.8
alter VB2 = $&drive
let drive = (floor(trial / 8) - 2*floor(trial / 16))*1.8
alter VB3 = $&drive
let drive = (floor(trial / 16) - 2*floor(trial / 32))*1.8
alter VB4 = $&drive
let drive = (floor(trial / 32) - 2*floor(trial / 64))*1.8
alter VB5 = $&drive
let drive = (floor(trial / 64) - 2*floor(trial / 128))*1.8
alter VB6 = $&drive
let drive = (floor(trial / 128) - 2*floor(trial / 256))*1.8
alter VB7 = $&drive
stop when time = 0.003624
resume
delete all
let endpoint = length(time)-1
let cmp = v(COMP)[endpoint]
let top = v(TOP)[endpoint]
let decision = 0
if cmp >= 0.9
let code = trial
let decision = 1
end
echo 201 6 $&trial $&cmp $&top 0.93046875 $&decision >> decisions.csv
let trial = code + 32
let drive = (floor(trial / 1) - 2*floor(trial / 2))*1.8
alter VB0 = $&drive
let drive = (floor(trial / 2) - 2*floor(trial / 4))*1.8
alter VB1 = $&drive
let drive = (floor(trial / 4) - 2*floor(trial / 8))*1.8
alter VB2 = $&drive
let drive = (floor(trial / 8) - 2*floor(trial / 16))*1.8
alter VB3 = $&drive
let drive = (floor(trial / 16) - 2*floor(trial / 32))*1.8
alter VB4 = $&drive
let drive = (floor(trial / 32) - 2*floor(trial / 64))*1.8
alter VB5 = $&drive
let drive = (floor(trial / 64) - 2*floor(trial / 128))*1.8
alter VB6 = $&drive
let drive = (floor(trial / 128) - 2*floor(trial / 256))*1.8
alter VB7 = $&drive
stop when time = 0.003626
resume
delete all
let endpoint = length(time)-1
let cmp = v(COMP)[endpoint]
let top = v(TOP)[endpoint]
let decision = 0
if cmp >= 0.9
let code = trial
let decision = 1
end
echo 201 5 $&trial $&cmp $&top 0.93046875 $&decision >> decisions.csv
let trial = code + 16
let drive = (floor(trial / 1) - 2*floor(trial / 2))*1.8
alter VB0 = $&drive
let drive = (floor(trial / 2) - 2*floor(trial / 4))*1.8
alter VB1 = $&drive
let drive = (floor(trial / 4) - 2*floor(trial / 8))*1.8
alter VB2 = $&drive
let drive = (floor(trial / 8) - 2*floor(trial / 16))*1.8
alter VB3 = $&drive
let drive = (floor(trial / 16) - 2*floor(trial / 32))*1.8
alter VB4 = $&drive
let drive = (floor(trial / 32) - 2*floor(trial / 64))*1.8
alter VB5 = $&drive
let drive = (floor(trial / 64) - 2*floor(trial / 128))*1.8
alter VB6 = $&drive
let drive = (floor(trial / 128) - 2*floor(trial / 256))*1.8
alter VB7 = $&drive
stop when time = 0.003628
resume
delete all
let endpoint = length(time)-1
let cmp = v(COMP)[endpoint]
let top = v(TOP)[endpoint]
let decision = 0
if cmp >= 0.9
let code = trial
let decision = 1
end
echo 201 4 $&trial $&cmp $&top 0.93046875 $&decision >> decisions.csv
let trial = code + 8
let drive = (floor(trial / 1) - 2*floor(trial / 2))*1.8
alter VB0 = $&drive
let drive = (floor(trial / 2) - 2*floor(trial / 4))*1.8
alter VB1 = $&drive
let drive = (floor(trial / 4) - 2*floor(trial / 8))*1.8
alter VB2 = $&drive
let drive = (floor(trial / 8) - 2*floor(trial / 16))*1.8
alter VB3 = $&drive
let drive = (floor(trial / 16) - 2*floor(trial / 32))*1.8
alter VB4 = $&drive
let drive = (floor(trial / 32) - 2*floor(trial / 64))*1.8
alter VB5 = $&drive
let drive = (floor(trial / 64) - 2*floor(trial / 128))*1.8
alter VB6 = $&drive
let drive = (floor(trial / 128) - 2*floor(trial / 256))*1.8
alter VB7 = $&drive
stop when time = 0.00363
resume
delete all
let endpoint = length(time)-1
let cmp = v(COMP)[endpoint]
let top = v(TOP)[endpoint]
let decision = 0
if cmp >= 0.9
let code = trial
let decision = 1
end
echo 201 3 $&trial $&cmp $&top 0.93046875 $&decision >> decisions.csv
let trial = code + 4
let drive = (floor(trial / 1) - 2*floor(trial / 2))*1.8
alter VB0 = $&drive
let drive = (floor(trial / 2) - 2*floor(trial / 4))*1.8
alter VB1 = $&drive
let drive = (floor(trial / 4) - 2*floor(trial / 8))*1.8
alter VB2 = $&drive
let drive = (floor(trial / 8) - 2*floor(trial / 16))*1.8
alter VB3 = $&drive
let drive = (floor(trial / 16) - 2*floor(trial / 32))*1.8
alter VB4 = $&drive
let drive = (floor(trial / 32) - 2*floor(trial / 64))*1.8
alter VB5 = $&drive
let drive = (floor(trial / 64) - 2*floor(trial / 128))*1.8
alter VB6 = $&drive
let drive = (floor(trial / 128) - 2*floor(trial / 256))*1.8
alter VB7 = $&drive
stop when time = 0.003632
resume
delete all
let endpoint = length(time)-1
let cmp = v(COMP)[endpoint]
let top = v(TOP)[endpoint]
let decision = 0
if cmp >= 0.9
let code = trial
let decision = 1
end
echo 201 2 $&trial $&cmp $&top 0.93046875 $&decision >> decisions.csv
let trial = code + 2
let drive = (floor(trial / 1) - 2*floor(trial / 2))*1.8
alter VB0 = $&drive
let drive = (floor(trial / 2) - 2*floor(trial / 4))*1.8
alter VB1 = $&drive
let drive = (floor(trial / 4) - 2*floor(trial / 8))*1.8
alter VB2 = $&drive
let drive = (floor(trial / 8) - 2*floor(trial / 16))*1.8
alter VB3 = $&drive
let drive = (floor(trial / 16) - 2*floor(trial / 32))*1.8
alter VB4 = $&drive
let drive = (floor(trial / 32) - 2*floor(trial / 64))*1.8
alter VB5 = $&drive
let drive = (floor(trial / 64) - 2*floor(trial / 128))*1.8
alter VB6 = $&drive
let drive = (floor(trial / 128) - 2*floor(trial / 256))*1.8
alter VB7 = $&drive
stop when time = 0.003634
resume
delete all
let endpoint = length(time)-1
let cmp = v(COMP)[endpoint]
let top = v(TOP)[endpoint]
let decision = 0
if cmp >= 0.9
let code = trial
let decision = 1
end
echo 201 1 $&trial $&cmp $&top 0.93046875 $&decision >> decisions.csv
let trial = code + 1
let drive = (floor(trial / 1) - 2*floor(trial / 2))*1.8
alter VB0 = $&drive
let drive = (floor(trial / 2) - 2*floor(trial / 4))*1.8
alter VB1 = $&drive
let drive = (floor(trial / 4) - 2*floor(trial / 8))*1.8
alter VB2 = $&drive
let drive = (floor(trial / 8) - 2*floor(trial / 16))*1.8
alter VB3 = $&drive
let drive = (floor(trial / 16) - 2*floor(trial / 32))*1.8
alter VB4 = $&drive
let drive = (floor(trial / 32) - 2*floor(trial / 64))*1.8
alter VB5 = $&drive
let drive = (floor(trial / 64) - 2*floor(trial / 128))*1.8
alter VB6 = $&drive
let drive = (floor(trial / 128) - 2*floor(trial / 256))*1.8
alter VB7 = $&drive
stop when time = 0.003636
resume
delete all
let endpoint = length(time)-1
let cmp = v(COMP)[endpoint]
let top = v(TOP)[endpoint]
let decision = 0
if cmp >= 0.9
let code = trial
let decision = 1
end
echo 201 0 $&trial $&cmp $&top 0.93046875 $&decision >> decisions.csv
alter VIN = 0.93515625
alter VSAMPLE = 1.8
alter VB0 = 0
alter VB1 = 0
alter VB2 = 0
alter VB3 = 0
alter VB4 = 0
alter VB5 = 0
alter VB6 = 0
alter VB7 = 0
let code = 0
stop when time = 0.003638
resume
delete all
alter VSAMPLE = 0
let trial = code + 128
let drive = (floor(trial / 1) - 2*floor(trial / 2))*1.8
alter VB0 = $&drive
let drive = (floor(trial / 2) - 2*floor(trial / 4))*1.8
alter VB1 = $&drive
let drive = (floor(trial / 4) - 2*floor(trial / 8))*1.8
alter VB2 = $&drive
let drive = (floor(trial / 8) - 2*floor(trial / 16))*1.8
alter VB3 = $&drive
let drive = (floor(trial / 16) - 2*floor(trial / 32))*1.8
alter VB4 = $&drive
let drive = (floor(trial / 32) - 2*floor(trial / 64))*1.8
alter VB5 = $&drive
let drive = (floor(trial / 64) - 2*floor(trial / 128))*1.8
alter VB6 = $&drive
let drive = (floor(trial / 128) - 2*floor(trial / 256))*1.8
alter VB7 = $&drive
stop when time = 0.00364
resume
delete all
let endpoint = length(time)-1
let cmp = v(COMP)[endpoint]
let top = v(TOP)[endpoint]
let decision = 0
if cmp >= 0.9
let code = trial
let decision = 1
end
echo 202 7 $&trial $&cmp $&top 0.93515625 $&decision >> decisions.csv
let trial = code + 64
let drive = (floor(trial / 1) - 2*floor(trial / 2))*1.8
alter VB0 = $&drive
let drive = (floor(trial / 2) - 2*floor(trial / 4))*1.8
alter VB1 = $&drive
let drive = (floor(trial / 4) - 2*floor(trial / 8))*1.8
alter VB2 = $&drive
let drive = (floor(trial / 8) - 2*floor(trial / 16))*1.8
alter VB3 = $&drive
let drive = (floor(trial / 16) - 2*floor(trial / 32))*1.8
alter VB4 = $&drive
let drive = (floor(trial / 32) - 2*floor(trial / 64))*1.8
alter VB5 = $&drive
let drive = (floor(trial / 64) - 2*floor(trial / 128))*1.8
alter VB6 = $&drive
let drive = (floor(trial / 128) - 2*floor(trial / 256))*1.8
alter VB7 = $&drive
stop when time = 0.003642
resume
delete all
let endpoint = length(time)-1
let cmp = v(COMP)[endpoint]
let top = v(TOP)[endpoint]
let decision = 0
if cmp >= 0.9
let code = trial
let decision = 1
end
echo 202 6 $&trial $&cmp $&top 0.93515625 $&decision >> decisions.csv
let trial = code + 32
let drive = (floor(trial / 1) - 2*floor(trial / 2))*1.8
alter VB0 = $&drive
let drive = (floor(trial / 2) - 2*floor(trial / 4))*1.8
alter VB1 = $&drive
let drive = (floor(trial / 4) - 2*floor(trial / 8))*1.8
alter VB2 = $&drive
let drive = (floor(trial / 8) - 2*floor(trial / 16))*1.8
alter VB3 = $&drive
let drive = (floor(trial / 16) - 2*floor(trial / 32))*1.8
alter VB4 = $&drive
let drive = (floor(trial / 32) - 2*floor(trial / 64))*1.8
alter VB5 = $&drive
let drive = (floor(trial / 64) - 2*floor(trial / 128))*1.8
alter VB6 = $&drive
let drive = (floor(trial / 128) - 2*floor(trial / 256))*1.8
alter VB7 = $&drive
stop when time = 0.003644
resume
delete all
let endpoint = length(time)-1
let cmp = v(COMP)[endpoint]
let top = v(TOP)[endpoint]
let decision = 0
if cmp >= 0.9
let code = trial
let decision = 1
end
echo 202 5 $&trial $&cmp $&top 0.93515625 $&decision >> decisions.csv
let trial = code + 16
let drive = (floor(trial / 1) - 2*floor(trial / 2))*1.8
alter VB0 = $&drive
let drive = (floor(trial / 2) - 2*floor(trial / 4))*1.8
alter VB1 = $&drive
let drive = (floor(trial / 4) - 2*floor(trial / 8))*1.8
alter VB2 = $&drive
let drive = (floor(trial / 8) - 2*floor(trial / 16))*1.8
alter VB3 = $&drive
let drive = (floor(trial / 16) - 2*floor(trial / 32))*1.8
alter VB4 = $&drive
let drive = (floor(trial / 32) - 2*floor(trial / 64))*1.8
alter VB5 = $&drive
let drive = (floor(trial / 64) - 2*floor(trial / 128))*1.8
alter VB6 = $&drive
let drive = (floor(trial / 128) - 2*floor(trial / 256))*1.8
alter VB7 = $&drive
stop when time = 0.003646
resume
delete all
let endpoint = length(time)-1
let cmp = v(COMP)[endpoint]
let top = v(TOP)[endpoint]
let decision = 0
if cmp >= 0.9
let code = trial
let decision = 1
end
echo 202 4 $&trial $&cmp $&top 0.93515625 $&decision >> decisions.csv
let trial = code + 8
let drive = (floor(trial / 1) - 2*floor(trial / 2))*1.8
alter VB0 = $&drive
let drive = (floor(trial / 2) - 2*floor(trial / 4))*1.8
alter VB1 = $&drive
let drive = (floor(trial / 4) - 2*floor(trial / 8))*1.8
alter VB2 = $&drive
let drive = (floor(trial / 8) - 2*floor(trial / 16))*1.8
alter VB3 = $&drive
let drive = (floor(trial / 16) - 2*floor(trial / 32))*1.8
alter VB4 = $&drive
let drive = (floor(trial / 32) - 2*floor(trial / 64))*1.8
alter VB5 = $&drive
let drive = (floor(trial / 64) - 2*floor(trial / 128))*1.8
alter VB6 = $&drive
let drive = (floor(trial / 128) - 2*floor(trial / 256))*1.8
alter VB7 = $&drive
stop when time = 0.003648
resume
delete all
let endpoint = length(time)-1
let cmp = v(COMP)[endpoint]
let top = v(TOP)[endpoint]
let decision = 0
if cmp >= 0.9
let code = trial
let decision = 1
end
echo 202 3 $&trial $&cmp $&top 0.93515625 $&decision >> decisions.csv
let trial = code + 4
let drive = (floor(trial / 1) - 2*floor(trial / 2))*1.8
alter VB0 = $&drive
let drive = (floor(trial / 2) - 2*floor(trial / 4))*1.8
alter VB1 = $&drive
let drive = (floor(trial / 4) - 2*floor(trial / 8))*1.8
alter VB2 = $&drive
let drive = (floor(trial / 8) - 2*floor(trial / 16))*1.8
alter VB3 = $&drive
let drive = (floor(trial / 16) - 2*floor(trial / 32))*1.8
alter VB4 = $&drive
let drive = (floor(trial / 32) - 2*floor(trial / 64))*1.8
alter VB5 = $&drive
let drive = (floor(trial / 64) - 2*floor(trial / 128))*1.8
alter VB6 = $&drive
let drive = (floor(trial / 128) - 2*floor(trial / 256))*1.8
alter VB7 = $&drive
stop when time = 0.00365
resume
delete all
let endpoint = length(time)-1
let cmp = v(COMP)[endpoint]
let top = v(TOP)[endpoint]
let decision = 0
if cmp >= 0.9
let code = trial
let decision = 1
end
echo 202 2 $&trial $&cmp $&top 0.93515625 $&decision >> decisions.csv
let trial = code + 2
let drive = (floor(trial / 1) - 2*floor(trial / 2))*1.8
alter VB0 = $&drive
let drive = (floor(trial / 2) - 2*floor(trial / 4))*1.8
alter VB1 = $&drive
let drive = (floor(trial / 4) - 2*floor(trial / 8))*1.8
alter VB2 = $&drive
let drive = (floor(trial / 8) - 2*floor(trial / 16))*1.8
alter VB3 = $&drive
let drive = (floor(trial / 16) - 2*floor(trial / 32))*1.8
alter VB4 = $&drive
let drive = (floor(trial / 32) - 2*floor(trial / 64))*1.8
alter VB5 = $&drive
let drive = (floor(trial / 64) - 2*floor(trial / 128))*1.8
alter VB6 = $&drive
let drive = (floor(trial / 128) - 2*floor(trial / 256))*1.8
alter VB7 = $&drive
stop when time = 0.003652
resume
delete all
let endpoint = length(time)-1
let cmp = v(COMP)[endpoint]
let top = v(TOP)[endpoint]
let decision = 0
if cmp >= 0.9
let code = trial
let decision = 1
end
echo 202 1 $&trial $&cmp $&top 0.93515625 $&decision >> decisions.csv
let trial = code + 1
let drive = (floor(trial / 1) - 2*floor(trial / 2))*1.8
alter VB0 = $&drive
let drive = (floor(trial / 2) - 2*floor(trial / 4))*1.8
alter VB1 = $&drive
let drive = (floor(trial / 4) - 2*floor(trial / 8))*1.8
alter VB2 = $&drive
let drive = (floor(trial / 8) - 2*floor(trial / 16))*1.8
alter VB3 = $&drive
let drive = (floor(trial / 16) - 2*floor(trial / 32))*1.8
alter VB4 = $&drive
let drive = (floor(trial / 32) - 2*floor(trial / 64))*1.8
alter VB5 = $&drive
let drive = (floor(trial / 64) - 2*floor(trial / 128))*1.8
alter VB6 = $&drive
let drive = (floor(trial / 128) - 2*floor(trial / 256))*1.8
alter VB7 = $&drive
stop when time = 0.003654
resume
delete all
let endpoint = length(time)-1
let cmp = v(COMP)[endpoint]
let top = v(TOP)[endpoint]
let decision = 0
if cmp >= 0.9
let code = trial
let decision = 1
end
echo 202 0 $&trial $&cmp $&top 0.93515625 $&decision >> decisions.csv
alter VIN = 0.93984375
alter VSAMPLE = 1.8
alter VB0 = 0
alter VB1 = 0
alter VB2 = 0
alter VB3 = 0
alter VB4 = 0
alter VB5 = 0
alter VB6 = 0
alter VB7 = 0
let code = 0
stop when time = 0.003656
resume
delete all
alter VSAMPLE = 0
let trial = code + 128
let drive = (floor(trial / 1) - 2*floor(trial / 2))*1.8
alter VB0 = $&drive
let drive = (floor(trial / 2) - 2*floor(trial / 4))*1.8
alter VB1 = $&drive
let drive = (floor(trial / 4) - 2*floor(trial / 8))*1.8
alter VB2 = $&drive
let drive = (floor(trial / 8) - 2*floor(trial / 16))*1.8
alter VB3 = $&drive
let drive = (floor(trial / 16) - 2*floor(trial / 32))*1.8
alter VB4 = $&drive
let drive = (floor(trial / 32) - 2*floor(trial / 64))*1.8
alter VB5 = $&drive
let drive = (floor(trial / 64) - 2*floor(trial / 128))*1.8
alter VB6 = $&drive
let drive = (floor(trial / 128) - 2*floor(trial / 256))*1.8
alter VB7 = $&drive
stop when time = 0.003658
resume
delete all
let endpoint = length(time)-1
let cmp = v(COMP)[endpoint]
let top = v(TOP)[endpoint]
let decision = 0
if cmp >= 0.9
let code = trial
let decision = 1
end
echo 203 7 $&trial $&cmp $&top 0.93984375 $&decision >> decisions.csv
let trial = code + 64
let drive = (floor(trial / 1) - 2*floor(trial / 2))*1.8
alter VB0 = $&drive
let drive = (floor(trial / 2) - 2*floor(trial / 4))*1.8
alter VB1 = $&drive
let drive = (floor(trial / 4) - 2*floor(trial / 8))*1.8
alter VB2 = $&drive
let drive = (floor(trial / 8) - 2*floor(trial / 16))*1.8
alter VB3 = $&drive
let drive = (floor(trial / 16) - 2*floor(trial / 32))*1.8
alter VB4 = $&drive
let drive = (floor(trial / 32) - 2*floor(trial / 64))*1.8
alter VB5 = $&drive
let drive = (floor(trial / 64) - 2*floor(trial / 128))*1.8
alter VB6 = $&drive
let drive = (floor(trial / 128) - 2*floor(trial / 256))*1.8
alter VB7 = $&drive
stop when time = 0.00366
resume
delete all
let endpoint = length(time)-1
let cmp = v(COMP)[endpoint]
let top = v(TOP)[endpoint]
let decision = 0
if cmp >= 0.9
let code = trial
let decision = 1
end
echo 203 6 $&trial $&cmp $&top 0.93984375 $&decision >> decisions.csv
let trial = code + 32
let drive = (floor(trial / 1) - 2*floor(trial / 2))*1.8
alter VB0 = $&drive
let drive = (floor(trial / 2) - 2*floor(trial / 4))*1.8
alter VB1 = $&drive
let drive = (floor(trial / 4) - 2*floor(trial / 8))*1.8
alter VB2 = $&drive
let drive = (floor(trial / 8) - 2*floor(trial / 16))*1.8
alter VB3 = $&drive
let drive = (floor(trial / 16) - 2*floor(trial / 32))*1.8
alter VB4 = $&drive
let drive = (floor(trial / 32) - 2*floor(trial / 64))*1.8
alter VB5 = $&drive
let drive = (floor(trial / 64) - 2*floor(trial / 128))*1.8
alter VB6 = $&drive
let drive = (floor(trial / 128) - 2*floor(trial / 256))*1.8
alter VB7 = $&drive
stop when time = 0.003662
resume
delete all
let endpoint = length(time)-1
let cmp = v(COMP)[endpoint]
let top = v(TOP)[endpoint]
let decision = 0
if cmp >= 0.9
let code = trial
let decision = 1
end
echo 203 5 $&trial $&cmp $&top 0.93984375 $&decision >> decisions.csv
let trial = code + 16
let drive = (floor(trial / 1) - 2*floor(trial / 2))*1.8
alter VB0 = $&drive
let drive = (floor(trial / 2) - 2*floor(trial / 4))*1.8
alter VB1 = $&drive
let drive = (floor(trial / 4) - 2*floor(trial / 8))*1.8
alter VB2 = $&drive
let drive = (floor(trial / 8) - 2*floor(trial / 16))*1.8
alter VB3 = $&drive
let drive = (floor(trial / 16) - 2*floor(trial / 32))*1.8
alter VB4 = $&drive
let drive = (floor(trial / 32) - 2*floor(trial / 64))*1.8
alter VB5 = $&drive
let drive = (floor(trial / 64) - 2*floor(trial / 128))*1.8
alter VB6 = $&drive
let drive = (floor(trial / 128) - 2*floor(trial / 256))*1.8
alter VB7 = $&drive
stop when time = 0.003664
resume
delete all
let endpoint = length(time)-1
let cmp = v(COMP)[endpoint]
let top = v(TOP)[endpoint]
let decision = 0
if cmp >= 0.9
let code = trial
let decision = 1
end
echo 203 4 $&trial $&cmp $&top 0.93984375 $&decision >> decisions.csv
let trial = code + 8
let drive = (floor(trial / 1) - 2*floor(trial / 2))*1.8
alter VB0 = $&drive
let drive = (floor(trial / 2) - 2*floor(trial / 4))*1.8
alter VB1 = $&drive
let drive = (floor(trial / 4) - 2*floor(trial / 8))*1.8
alter VB2 = $&drive
let drive = (floor(trial / 8) - 2*floor(trial / 16))*1.8
alter VB3 = $&drive
let drive = (floor(trial / 16) - 2*floor(trial / 32))*1.8
alter VB4 = $&drive
let drive = (floor(trial / 32) - 2*floor(trial / 64))*1.8
alter VB5 = $&drive
let drive = (floor(trial / 64) - 2*floor(trial / 128))*1.8
alter VB6 = $&drive
let drive = (floor(trial / 128) - 2*floor(trial / 256))*1.8
alter VB7 = $&drive
stop when time = 0.003666
resume
delete all
let endpoint = length(time)-1
let cmp = v(COMP)[endpoint]
let top = v(TOP)[endpoint]
let decision = 0
if cmp >= 0.9
let code = trial
let decision = 1
end
echo 203 3 $&trial $&cmp $&top 0.93984375 $&decision >> decisions.csv
let trial = code + 4
let drive = (floor(trial / 1) - 2*floor(trial / 2))*1.8
alter VB0 = $&drive
let drive = (floor(trial / 2) - 2*floor(trial / 4))*1.8
alter VB1 = $&drive
let drive = (floor(trial / 4) - 2*floor(trial / 8))*1.8
alter VB2 = $&drive
let drive = (floor(trial / 8) - 2*floor(trial / 16))*1.8
alter VB3 = $&drive
let drive = (floor(trial / 16) - 2*floor(trial / 32))*1.8
alter VB4 = $&drive
let drive = (floor(trial / 32) - 2*floor(trial / 64))*1.8
alter VB5 = $&drive
let drive = (floor(trial / 64) - 2*floor(trial / 128))*1.8
alter VB6 = $&drive
let drive = (floor(trial / 128) - 2*floor(trial / 256))*1.8
alter VB7 = $&drive
stop when time = 0.003668
resume
delete all
let endpoint = length(time)-1
let cmp = v(COMP)[endpoint]
let top = v(TOP)[endpoint]
let decision = 0
if cmp >= 0.9
let code = trial
let decision = 1
end
echo 203 2 $&trial $&cmp $&top 0.93984375 $&decision >> decisions.csv
let trial = code + 2
let drive = (floor(trial / 1) - 2*floor(trial / 2))*1.8
alter VB0 = $&drive
let drive = (floor(trial / 2) - 2*floor(trial / 4))*1.8
alter VB1 = $&drive
let drive = (floor(trial / 4) - 2*floor(trial / 8))*1.8
alter VB2 = $&drive
let drive = (floor(trial / 8) - 2*floor(trial / 16))*1.8
alter VB3 = $&drive
let drive = (floor(trial / 16) - 2*floor(trial / 32))*1.8
alter VB4 = $&drive
let drive = (floor(trial / 32) - 2*floor(trial / 64))*1.8
alter VB5 = $&drive
let drive = (floor(trial / 64) - 2*floor(trial / 128))*1.8
alter VB6 = $&drive
let drive = (floor(trial / 128) - 2*floor(trial / 256))*1.8
alter VB7 = $&drive
stop when time = 0.00367
resume
delete all
let endpoint = length(time)-1
let cmp = v(COMP)[endpoint]
let top = v(TOP)[endpoint]
let decision = 0
if cmp >= 0.9
let code = trial
let decision = 1
end
echo 203 1 $&trial $&cmp $&top 0.93984375 $&decision >> decisions.csv
let trial = code + 1
let drive = (floor(trial / 1) - 2*floor(trial / 2))*1.8
alter VB0 = $&drive
let drive = (floor(trial / 2) - 2*floor(trial / 4))*1.8
alter VB1 = $&drive
let drive = (floor(trial / 4) - 2*floor(trial / 8))*1.8
alter VB2 = $&drive
let drive = (floor(trial / 8) - 2*floor(trial / 16))*1.8
alter VB3 = $&drive
let drive = (floor(trial / 16) - 2*floor(trial / 32))*1.8
alter VB4 = $&drive
let drive = (floor(trial / 32) - 2*floor(trial / 64))*1.8
alter VB5 = $&drive
let drive = (floor(trial / 64) - 2*floor(trial / 128))*1.8
alter VB6 = $&drive
let drive = (floor(trial / 128) - 2*floor(trial / 256))*1.8
alter VB7 = $&drive
stop when time = 0.003672
resume
delete all
let endpoint = length(time)-1
let cmp = v(COMP)[endpoint]
let top = v(TOP)[endpoint]
let decision = 0
if cmp >= 0.9
let code = trial
let decision = 1
end
echo 203 0 $&trial $&cmp $&top 0.93984375 $&decision >> decisions.csv
alter VIN = 0.94453125
alter VSAMPLE = 1.8
alter VB0 = 0
alter VB1 = 0
alter VB2 = 0
alter VB3 = 0
alter VB4 = 0
alter VB5 = 0
alter VB6 = 0
alter VB7 = 0
let code = 0
stop when time = 0.003674
resume
delete all
alter VSAMPLE = 0
let trial = code + 128
let drive = (floor(trial / 1) - 2*floor(trial / 2))*1.8
alter VB0 = $&drive
let drive = (floor(trial / 2) - 2*floor(trial / 4))*1.8
alter VB1 = $&drive
let drive = (floor(trial / 4) - 2*floor(trial / 8))*1.8
alter VB2 = $&drive
let drive = (floor(trial / 8) - 2*floor(trial / 16))*1.8
alter VB3 = $&drive
let drive = (floor(trial / 16) - 2*floor(trial / 32))*1.8
alter VB4 = $&drive
let drive = (floor(trial / 32) - 2*floor(trial / 64))*1.8
alter VB5 = $&drive
let drive = (floor(trial / 64) - 2*floor(trial / 128))*1.8
alter VB6 = $&drive
let drive = (floor(trial / 128) - 2*floor(trial / 256))*1.8
alter VB7 = $&drive
stop when time = 0.003676
resume
delete all
let endpoint = length(time)-1
let cmp = v(COMP)[endpoint]
let top = v(TOP)[endpoint]
let decision = 0
if cmp >= 0.9
let code = trial
let decision = 1
end
echo 204 7 $&trial $&cmp $&top 0.94453125 $&decision >> decisions.csv
let trial = code + 64
let drive = (floor(trial / 1) - 2*floor(trial / 2))*1.8
alter VB0 = $&drive
let drive = (floor(trial / 2) - 2*floor(trial / 4))*1.8
alter VB1 = $&drive
let drive = (floor(trial / 4) - 2*floor(trial / 8))*1.8
alter VB2 = $&drive
let drive = (floor(trial / 8) - 2*floor(trial / 16))*1.8
alter VB3 = $&drive
let drive = (floor(trial / 16) - 2*floor(trial / 32))*1.8
alter VB4 = $&drive
let drive = (floor(trial / 32) - 2*floor(trial / 64))*1.8
alter VB5 = $&drive
let drive = (floor(trial / 64) - 2*floor(trial / 128))*1.8
alter VB6 = $&drive
let drive = (floor(trial / 128) - 2*floor(trial / 256))*1.8
alter VB7 = $&drive
stop when time = 0.003678
resume
delete all
let endpoint = length(time)-1
let cmp = v(COMP)[endpoint]
let top = v(TOP)[endpoint]
let decision = 0
if cmp >= 0.9
let code = trial
let decision = 1
end
echo 204 6 $&trial $&cmp $&top 0.94453125 $&decision >> decisions.csv
let trial = code + 32
let drive = (floor(trial / 1) - 2*floor(trial / 2))*1.8
alter VB0 = $&drive
let drive = (floor(trial / 2) - 2*floor(trial / 4))*1.8
alter VB1 = $&drive
let drive = (floor(trial / 4) - 2*floor(trial / 8))*1.8
alter VB2 = $&drive
let drive = (floor(trial / 8) - 2*floor(trial / 16))*1.8
alter VB3 = $&drive
let drive = (floor(trial / 16) - 2*floor(trial / 32))*1.8
alter VB4 = $&drive
let drive = (floor(trial / 32) - 2*floor(trial / 64))*1.8
alter VB5 = $&drive
let drive = (floor(trial / 64) - 2*floor(trial / 128))*1.8
alter VB6 = $&drive
let drive = (floor(trial / 128) - 2*floor(trial / 256))*1.8
alter VB7 = $&drive
stop when time = 0.00368
resume
delete all
let endpoint = length(time)-1
let cmp = v(COMP)[endpoint]
let top = v(TOP)[endpoint]
let decision = 0
if cmp >= 0.9
let code = trial
let decision = 1
end
echo 204 5 $&trial $&cmp $&top 0.94453125 $&decision >> decisions.csv
let trial = code + 16
let drive = (floor(trial / 1) - 2*floor(trial / 2))*1.8
alter VB0 = $&drive
let drive = (floor(trial / 2) - 2*floor(trial / 4))*1.8
alter VB1 = $&drive
let drive = (floor(trial / 4) - 2*floor(trial / 8))*1.8
alter VB2 = $&drive
let drive = (floor(trial / 8) - 2*floor(trial / 16))*1.8
alter VB3 = $&drive
let drive = (floor(trial / 16) - 2*floor(trial / 32))*1.8
alter VB4 = $&drive
let drive = (floor(trial / 32) - 2*floor(trial / 64))*1.8
alter VB5 = $&drive
let drive = (floor(trial / 64) - 2*floor(trial / 128))*1.8
alter VB6 = $&drive
let drive = (floor(trial / 128) - 2*floor(trial / 256))*1.8
alter VB7 = $&drive
stop when time = 0.003682
resume
delete all
let endpoint = length(time)-1
let cmp = v(COMP)[endpoint]
let top = v(TOP)[endpoint]
let decision = 0
if cmp >= 0.9
let code = trial
let decision = 1
end
echo 204 4 $&trial $&cmp $&top 0.94453125 $&decision >> decisions.csv
let trial = code + 8
let drive = (floor(trial / 1) - 2*floor(trial / 2))*1.8
alter VB0 = $&drive
let drive = (floor(trial / 2) - 2*floor(trial / 4))*1.8
alter VB1 = $&drive
let drive = (floor(trial / 4) - 2*floor(trial / 8))*1.8
alter VB2 = $&drive
let drive = (floor(trial / 8) - 2*floor(trial / 16))*1.8
alter VB3 = $&drive
let drive = (floor(trial / 16) - 2*floor(trial / 32))*1.8
alter VB4 = $&drive
let drive = (floor(trial / 32) - 2*floor(trial / 64))*1.8
alter VB5 = $&drive
let drive = (floor(trial / 64) - 2*floor(trial / 128))*1.8
alter VB6 = $&drive
let drive = (floor(trial / 128) - 2*floor(trial / 256))*1.8
alter VB7 = $&drive
stop when time = 0.003684
resume
delete all
let endpoint = length(time)-1
let cmp = v(COMP)[endpoint]
let top = v(TOP)[endpoint]
let decision = 0
if cmp >= 0.9
let code = trial
let decision = 1
end
echo 204 3 $&trial $&cmp $&top 0.94453125 $&decision >> decisions.csv
let trial = code + 4
let drive = (floor(trial / 1) - 2*floor(trial / 2))*1.8
alter VB0 = $&drive
let drive = (floor(trial / 2) - 2*floor(trial / 4))*1.8
alter VB1 = $&drive
let drive = (floor(trial / 4) - 2*floor(trial / 8))*1.8
alter VB2 = $&drive
let drive = (floor(trial / 8) - 2*floor(trial / 16))*1.8
alter VB3 = $&drive
let drive = (floor(trial / 16) - 2*floor(trial / 32))*1.8
alter VB4 = $&drive
let drive = (floor(trial / 32) - 2*floor(trial / 64))*1.8
alter VB5 = $&drive
let drive = (floor(trial / 64) - 2*floor(trial / 128))*1.8
alter VB6 = $&drive
let drive = (floor(trial / 128) - 2*floor(trial / 256))*1.8
alter VB7 = $&drive
stop when time = 0.003686
resume
delete all
let endpoint = length(time)-1
let cmp = v(COMP)[endpoint]
let top = v(TOP)[endpoint]
let decision = 0
if cmp >= 0.9
let code = trial
let decision = 1
end
echo 204 2 $&trial $&cmp $&top 0.94453125 $&decision >> decisions.csv
let trial = code + 2
let drive = (floor(trial / 1) - 2*floor(trial / 2))*1.8
alter VB0 = $&drive
let drive = (floor(trial / 2) - 2*floor(trial / 4))*1.8
alter VB1 = $&drive
let drive = (floor(trial / 4) - 2*floor(trial / 8))*1.8
alter VB2 = $&drive
let drive = (floor(trial / 8) - 2*floor(trial / 16))*1.8
alter VB3 = $&drive
let drive = (floor(trial / 16) - 2*floor(trial / 32))*1.8
alter VB4 = $&drive
let drive = (floor(trial / 32) - 2*floor(trial / 64))*1.8
alter VB5 = $&drive
let drive = (floor(trial / 64) - 2*floor(trial / 128))*1.8
alter VB6 = $&drive
let drive = (floor(trial / 128) - 2*floor(trial / 256))*1.8
alter VB7 = $&drive
stop when time = 0.003688
resume
delete all
let endpoint = length(time)-1
let cmp = v(COMP)[endpoint]
let top = v(TOP)[endpoint]
let decision = 0
if cmp >= 0.9
let code = trial
let decision = 1
end
echo 204 1 $&trial $&cmp $&top 0.94453125 $&decision >> decisions.csv
let trial = code + 1
let drive = (floor(trial / 1) - 2*floor(trial / 2))*1.8
alter VB0 = $&drive
let drive = (floor(trial / 2) - 2*floor(trial / 4))*1.8
alter VB1 = $&drive
let drive = (floor(trial / 4) - 2*floor(trial / 8))*1.8
alter VB2 = $&drive
let drive = (floor(trial / 8) - 2*floor(trial / 16))*1.8
alter VB3 = $&drive
let drive = (floor(trial / 16) - 2*floor(trial / 32))*1.8
alter VB4 = $&drive
let drive = (floor(trial / 32) - 2*floor(trial / 64))*1.8
alter VB5 = $&drive
let drive = (floor(trial / 64) - 2*floor(trial / 128))*1.8
alter VB6 = $&drive
let drive = (floor(trial / 128) - 2*floor(trial / 256))*1.8
alter VB7 = $&drive
stop when time = 0.00369
resume
delete all
let endpoint = length(time)-1
let cmp = v(COMP)[endpoint]
let top = v(TOP)[endpoint]
let decision = 0
if cmp >= 0.9
let code = trial
let decision = 1
end
echo 204 0 $&trial $&cmp $&top 0.94453125 $&decision >> decisions.csv
alter VIN = 0.94921875
alter VSAMPLE = 1.8
alter VB0 = 0
alter VB1 = 0
alter VB2 = 0
alter VB3 = 0
alter VB4 = 0
alter VB5 = 0
alter VB6 = 0
alter VB7 = 0
let code = 0
stop when time = 0.003692
resume
delete all
alter VSAMPLE = 0
let trial = code + 128
let drive = (floor(trial / 1) - 2*floor(trial / 2))*1.8
alter VB0 = $&drive
let drive = (floor(trial / 2) - 2*floor(trial / 4))*1.8
alter VB1 = $&drive
let drive = (floor(trial / 4) - 2*floor(trial / 8))*1.8
alter VB2 = $&drive
let drive = (floor(trial / 8) - 2*floor(trial / 16))*1.8
alter VB3 = $&drive
let drive = (floor(trial / 16) - 2*floor(trial / 32))*1.8
alter VB4 = $&drive
let drive = (floor(trial / 32) - 2*floor(trial / 64))*1.8
alter VB5 = $&drive
let drive = (floor(trial / 64) - 2*floor(trial / 128))*1.8
alter VB6 = $&drive
let drive = (floor(trial / 128) - 2*floor(trial / 256))*1.8
alter VB7 = $&drive
stop when time = 0.003694
resume
delete all
let endpoint = length(time)-1
let cmp = v(COMP)[endpoint]
let top = v(TOP)[endpoint]
let decision = 0
if cmp >= 0.9
let code = trial
let decision = 1
end
echo 205 7 $&trial $&cmp $&top 0.94921875 $&decision >> decisions.csv
let trial = code + 64
let drive = (floor(trial / 1) - 2*floor(trial / 2))*1.8
alter VB0 = $&drive
let drive = (floor(trial / 2) - 2*floor(trial / 4))*1.8
alter VB1 = $&drive
let drive = (floor(trial / 4) - 2*floor(trial / 8))*1.8
alter VB2 = $&drive
let drive = (floor(trial / 8) - 2*floor(trial / 16))*1.8
alter VB3 = $&drive
let drive = (floor(trial / 16) - 2*floor(trial / 32))*1.8
alter VB4 = $&drive
let drive = (floor(trial / 32) - 2*floor(trial / 64))*1.8
alter VB5 = $&drive
let drive = (floor(trial / 64) - 2*floor(trial / 128))*1.8
alter VB6 = $&drive
let drive = (floor(trial / 128) - 2*floor(trial / 256))*1.8
alter VB7 = $&drive
stop when time = 0.003696
resume
delete all
let endpoint = length(time)-1
let cmp = v(COMP)[endpoint]
let top = v(TOP)[endpoint]
let decision = 0
if cmp >= 0.9
let code = trial
let decision = 1
end
echo 205 6 $&trial $&cmp $&top 0.94921875 $&decision >> decisions.csv
let trial = code + 32
let drive = (floor(trial / 1) - 2*floor(trial / 2))*1.8
alter VB0 = $&drive
let drive = (floor(trial / 2) - 2*floor(trial / 4))*1.8
alter VB1 = $&drive
let drive = (floor(trial / 4) - 2*floor(trial / 8))*1.8
alter VB2 = $&drive
let drive = (floor(trial / 8) - 2*floor(trial / 16))*1.8
alter VB3 = $&drive
let drive = (floor(trial / 16) - 2*floor(trial / 32))*1.8
alter VB4 = $&drive
let drive = (floor(trial / 32) - 2*floor(trial / 64))*1.8
alter VB5 = $&drive
let drive = (floor(trial / 64) - 2*floor(trial / 128))*1.8
alter VB6 = $&drive
let drive = (floor(trial / 128) - 2*floor(trial / 256))*1.8
alter VB7 = $&drive
stop when time = 0.003698
resume
delete all
let endpoint = length(time)-1
let cmp = v(COMP)[endpoint]
let top = v(TOP)[endpoint]
let decision = 0
if cmp >= 0.9
let code = trial
let decision = 1
end
echo 205 5 $&trial $&cmp $&top 0.94921875 $&decision >> decisions.csv
let trial = code + 16
let drive = (floor(trial / 1) - 2*floor(trial / 2))*1.8
alter VB0 = $&drive
let drive = (floor(trial / 2) - 2*floor(trial / 4))*1.8
alter VB1 = $&drive
let drive = (floor(trial / 4) - 2*floor(trial / 8))*1.8
alter VB2 = $&drive
let drive = (floor(trial / 8) - 2*floor(trial / 16))*1.8
alter VB3 = $&drive
let drive = (floor(trial / 16) - 2*floor(trial / 32))*1.8
alter VB4 = $&drive
let drive = (floor(trial / 32) - 2*floor(trial / 64))*1.8
alter VB5 = $&drive
let drive = (floor(trial / 64) - 2*floor(trial / 128))*1.8
alter VB6 = $&drive
let drive = (floor(trial / 128) - 2*floor(trial / 256))*1.8
alter VB7 = $&drive
stop when time = 0.0037
resume
delete all
let endpoint = length(time)-1
let cmp = v(COMP)[endpoint]
let top = v(TOP)[endpoint]
let decision = 0
if cmp >= 0.9
let code = trial
let decision = 1
end
echo 205 4 $&trial $&cmp $&top 0.94921875 $&decision >> decisions.csv
let trial = code + 8
let drive = (floor(trial / 1) - 2*floor(trial / 2))*1.8
alter VB0 = $&drive
let drive = (floor(trial / 2) - 2*floor(trial / 4))*1.8
alter VB1 = $&drive
let drive = (floor(trial / 4) - 2*floor(trial / 8))*1.8
alter VB2 = $&drive
let drive = (floor(trial / 8) - 2*floor(trial / 16))*1.8
alter VB3 = $&drive
let drive = (floor(trial / 16) - 2*floor(trial / 32))*1.8
alter VB4 = $&drive
let drive = (floor(trial / 32) - 2*floor(trial / 64))*1.8
alter VB5 = $&drive
let drive = (floor(trial / 64) - 2*floor(trial / 128))*1.8
alter VB6 = $&drive
let drive = (floor(trial / 128) - 2*floor(trial / 256))*1.8
alter VB7 = $&drive
stop when time = 0.003702
resume
delete all
let endpoint = length(time)-1
let cmp = v(COMP)[endpoint]
let top = v(TOP)[endpoint]
let decision = 0
if cmp >= 0.9
let code = trial
let decision = 1
end
echo 205 3 $&trial $&cmp $&top 0.94921875 $&decision >> decisions.csv
let trial = code + 4
let drive = (floor(trial / 1) - 2*floor(trial / 2))*1.8
alter VB0 = $&drive
let drive = (floor(trial / 2) - 2*floor(trial / 4))*1.8
alter VB1 = $&drive
let drive = (floor(trial / 4) - 2*floor(trial / 8))*1.8
alter VB2 = $&drive
let drive = (floor(trial / 8) - 2*floor(trial / 16))*1.8
alter VB3 = $&drive
let drive = (floor(trial / 16) - 2*floor(trial / 32))*1.8
alter VB4 = $&drive
let drive = (floor(trial / 32) - 2*floor(trial / 64))*1.8
alter VB5 = $&drive
let drive = (floor(trial / 64) - 2*floor(trial / 128))*1.8
alter VB6 = $&drive
let drive = (floor(trial / 128) - 2*floor(trial / 256))*1.8
alter VB7 = $&drive
stop when time = 0.003704
resume
delete all
let endpoint = length(time)-1
let cmp = v(COMP)[endpoint]
let top = v(TOP)[endpoint]
let decision = 0
if cmp >= 0.9
let code = trial
let decision = 1
end
echo 205 2 $&trial $&cmp $&top 0.94921875 $&decision >> decisions.csv
let trial = code + 2
let drive = (floor(trial / 1) - 2*floor(trial / 2))*1.8
alter VB0 = $&drive
let drive = (floor(trial / 2) - 2*floor(trial / 4))*1.8
alter VB1 = $&drive
let drive = (floor(trial / 4) - 2*floor(trial / 8))*1.8
alter VB2 = $&drive
let drive = (floor(trial / 8) - 2*floor(trial / 16))*1.8
alter VB3 = $&drive
let drive = (floor(trial / 16) - 2*floor(trial / 32))*1.8
alter VB4 = $&drive
let drive = (floor(trial / 32) - 2*floor(trial / 64))*1.8
alter VB5 = $&drive
let drive = (floor(trial / 64) - 2*floor(trial / 128))*1.8
alter VB6 = $&drive
let drive = (floor(trial / 128) - 2*floor(trial / 256))*1.8
alter VB7 = $&drive
stop when time = 0.003706
resume
delete all
let endpoint = length(time)-1
let cmp = v(COMP)[endpoint]
let top = v(TOP)[endpoint]
let decision = 0
if cmp >= 0.9
let code = trial
let decision = 1
end
echo 205 1 $&trial $&cmp $&top 0.94921875 $&decision >> decisions.csv
let trial = code + 1
let drive = (floor(trial / 1) - 2*floor(trial / 2))*1.8
alter VB0 = $&drive
let drive = (floor(trial / 2) - 2*floor(trial / 4))*1.8
alter VB1 = $&drive
let drive = (floor(trial / 4) - 2*floor(trial / 8))*1.8
alter VB2 = $&drive
let drive = (floor(trial / 8) - 2*floor(trial / 16))*1.8
alter VB3 = $&drive
let drive = (floor(trial / 16) - 2*floor(trial / 32))*1.8
alter VB4 = $&drive
let drive = (floor(trial / 32) - 2*floor(trial / 64))*1.8
alter VB5 = $&drive
let drive = (floor(trial / 64) - 2*floor(trial / 128))*1.8
alter VB6 = $&drive
let drive = (floor(trial / 128) - 2*floor(trial / 256))*1.8
alter VB7 = $&drive
stop when time = 0.003708
resume
delete all
let endpoint = length(time)-1
let cmp = v(COMP)[endpoint]
let top = v(TOP)[endpoint]
let decision = 0
if cmp >= 0.9
let code = trial
let decision = 1
end
echo 205 0 $&trial $&cmp $&top 0.94921875 $&decision >> decisions.csv
alter VIN = 0.95390625
alter VSAMPLE = 1.8
alter VB0 = 0
alter VB1 = 0
alter VB2 = 0
alter VB3 = 0
alter VB4 = 0
alter VB5 = 0
alter VB6 = 0
alter VB7 = 0
let code = 0
stop when time = 0.00371
resume
delete all
alter VSAMPLE = 0
let trial = code + 128
let drive = (floor(trial / 1) - 2*floor(trial / 2))*1.8
alter VB0 = $&drive
let drive = (floor(trial / 2) - 2*floor(trial / 4))*1.8
alter VB1 = $&drive
let drive = (floor(trial / 4) - 2*floor(trial / 8))*1.8
alter VB2 = $&drive
let drive = (floor(trial / 8) - 2*floor(trial / 16))*1.8
alter VB3 = $&drive
let drive = (floor(trial / 16) - 2*floor(trial / 32))*1.8
alter VB4 = $&drive
let drive = (floor(trial / 32) - 2*floor(trial / 64))*1.8
alter VB5 = $&drive
let drive = (floor(trial / 64) - 2*floor(trial / 128))*1.8
alter VB6 = $&drive
let drive = (floor(trial / 128) - 2*floor(trial / 256))*1.8
alter VB7 = $&drive
stop when time = 0.003712
resume
delete all
let endpoint = length(time)-1
let cmp = v(COMP)[endpoint]
let top = v(TOP)[endpoint]
let decision = 0
if cmp >= 0.9
let code = trial
let decision = 1
end
echo 206 7 $&trial $&cmp $&top 0.95390625 $&decision >> decisions.csv
let trial = code + 64
let drive = (floor(trial / 1) - 2*floor(trial / 2))*1.8
alter VB0 = $&drive
let drive = (floor(trial / 2) - 2*floor(trial / 4))*1.8
alter VB1 = $&drive
let drive = (floor(trial / 4) - 2*floor(trial / 8))*1.8
alter VB2 = $&drive
let drive = (floor(trial / 8) - 2*floor(trial / 16))*1.8
alter VB3 = $&drive
let drive = (floor(trial / 16) - 2*floor(trial / 32))*1.8
alter VB4 = $&drive
let drive = (floor(trial / 32) - 2*floor(trial / 64))*1.8
alter VB5 = $&drive
let drive = (floor(trial / 64) - 2*floor(trial / 128))*1.8
alter VB6 = $&drive
let drive = (floor(trial / 128) - 2*floor(trial / 256))*1.8
alter VB7 = $&drive
stop when time = 0.003714
resume
delete all
let endpoint = length(time)-1
let cmp = v(COMP)[endpoint]
let top = v(TOP)[endpoint]
let decision = 0
if cmp >= 0.9
let code = trial
let decision = 1
end
echo 206 6 $&trial $&cmp $&top 0.95390625 $&decision >> decisions.csv
let trial = code + 32
let drive = (floor(trial / 1) - 2*floor(trial / 2))*1.8
alter VB0 = $&drive
let drive = (floor(trial / 2) - 2*floor(trial / 4))*1.8
alter VB1 = $&drive
let drive = (floor(trial / 4) - 2*floor(trial / 8))*1.8
alter VB2 = $&drive
let drive = (floor(trial / 8) - 2*floor(trial / 16))*1.8
alter VB3 = $&drive
let drive = (floor(trial / 16) - 2*floor(trial / 32))*1.8
alter VB4 = $&drive
let drive = (floor(trial / 32) - 2*floor(trial / 64))*1.8
alter VB5 = $&drive
let drive = (floor(trial / 64) - 2*floor(trial / 128))*1.8
alter VB6 = $&drive
let drive = (floor(trial / 128) - 2*floor(trial / 256))*1.8
alter VB7 = $&drive
stop when time = 0.003716
resume
delete all
let endpoint = length(time)-1
let cmp = v(COMP)[endpoint]
let top = v(TOP)[endpoint]
let decision = 0
if cmp >= 0.9
let code = trial
let decision = 1
end
echo 206 5 $&trial $&cmp $&top 0.95390625 $&decision >> decisions.csv
let trial = code + 16
let drive = (floor(trial / 1) - 2*floor(trial / 2))*1.8
alter VB0 = $&drive
let drive = (floor(trial / 2) - 2*floor(trial / 4))*1.8
alter VB1 = $&drive
let drive = (floor(trial / 4) - 2*floor(trial / 8))*1.8
alter VB2 = $&drive
let drive = (floor(trial / 8) - 2*floor(trial / 16))*1.8
alter VB3 = $&drive
let drive = (floor(trial / 16) - 2*floor(trial / 32))*1.8
alter VB4 = $&drive
let drive = (floor(trial / 32) - 2*floor(trial / 64))*1.8
alter VB5 = $&drive
let drive = (floor(trial / 64) - 2*floor(trial / 128))*1.8
alter VB6 = $&drive
let drive = (floor(trial / 128) - 2*floor(trial / 256))*1.8
alter VB7 = $&drive
stop when time = 0.003718
resume
delete all
let endpoint = length(time)-1
let cmp = v(COMP)[endpoint]
let top = v(TOP)[endpoint]
let decision = 0
if cmp >= 0.9
let code = trial
let decision = 1
end
echo 206 4 $&trial $&cmp $&top 0.95390625 $&decision >> decisions.csv
let trial = code + 8
let drive = (floor(trial / 1) - 2*floor(trial / 2))*1.8
alter VB0 = $&drive
let drive = (floor(trial / 2) - 2*floor(trial / 4))*1.8
alter VB1 = $&drive
let drive = (floor(trial / 4) - 2*floor(trial / 8))*1.8
alter VB2 = $&drive
let drive = (floor(trial / 8) - 2*floor(trial / 16))*1.8
alter VB3 = $&drive
let drive = (floor(trial / 16) - 2*floor(trial / 32))*1.8
alter VB4 = $&drive
let drive = (floor(trial / 32) - 2*floor(trial / 64))*1.8
alter VB5 = $&drive
let drive = (floor(trial / 64) - 2*floor(trial / 128))*1.8
alter VB6 = $&drive
let drive = (floor(trial / 128) - 2*floor(trial / 256))*1.8
alter VB7 = $&drive
stop when time = 0.00372
resume
delete all
let endpoint = length(time)-1
let cmp = v(COMP)[endpoint]
let top = v(TOP)[endpoint]
let decision = 0
if cmp >= 0.9
let code = trial
let decision = 1
end
echo 206 3 $&trial $&cmp $&top 0.95390625 $&decision >> decisions.csv
let trial = code + 4
let drive = (floor(trial / 1) - 2*floor(trial / 2))*1.8
alter VB0 = $&drive
let drive = (floor(trial / 2) - 2*floor(trial / 4))*1.8
alter VB1 = $&drive
let drive = (floor(trial / 4) - 2*floor(trial / 8))*1.8
alter VB2 = $&drive
let drive = (floor(trial / 8) - 2*floor(trial / 16))*1.8
alter VB3 = $&drive
let drive = (floor(trial / 16) - 2*floor(trial / 32))*1.8
alter VB4 = $&drive
let drive = (floor(trial / 32) - 2*floor(trial / 64))*1.8
alter VB5 = $&drive
let drive = (floor(trial / 64) - 2*floor(trial / 128))*1.8
alter VB6 = $&drive
let drive = (floor(trial / 128) - 2*floor(trial / 256))*1.8
alter VB7 = $&drive
stop when time = 0.003722
resume
delete all
let endpoint = length(time)-1
let cmp = v(COMP)[endpoint]
let top = v(TOP)[endpoint]
let decision = 0
if cmp >= 0.9
let code = trial
let decision = 1
end
echo 206 2 $&trial $&cmp $&top 0.95390625 $&decision >> decisions.csv
let trial = code + 2
let drive = (floor(trial / 1) - 2*floor(trial / 2))*1.8
alter VB0 = $&drive
let drive = (floor(trial / 2) - 2*floor(trial / 4))*1.8
alter VB1 = $&drive
let drive = (floor(trial / 4) - 2*floor(trial / 8))*1.8
alter VB2 = $&drive
let drive = (floor(trial / 8) - 2*floor(trial / 16))*1.8
alter VB3 = $&drive
let drive = (floor(trial / 16) - 2*floor(trial / 32))*1.8
alter VB4 = $&drive
let drive = (floor(trial / 32) - 2*floor(trial / 64))*1.8
alter VB5 = $&drive
let drive = (floor(trial / 64) - 2*floor(trial / 128))*1.8
alter VB6 = $&drive
let drive = (floor(trial / 128) - 2*floor(trial / 256))*1.8
alter VB7 = $&drive
stop when time = 0.003724
resume
delete all
let endpoint = length(time)-1
let cmp = v(COMP)[endpoint]
let top = v(TOP)[endpoint]
let decision = 0
if cmp >= 0.9
let code = trial
let decision = 1
end
echo 206 1 $&trial $&cmp $&top 0.95390625 $&decision >> decisions.csv
let trial = code + 1
let drive = (floor(trial / 1) - 2*floor(trial / 2))*1.8
alter VB0 = $&drive
let drive = (floor(trial / 2) - 2*floor(trial / 4))*1.8
alter VB1 = $&drive
let drive = (floor(trial / 4) - 2*floor(trial / 8))*1.8
alter VB2 = $&drive
let drive = (floor(trial / 8) - 2*floor(trial / 16))*1.8
alter VB3 = $&drive
let drive = (floor(trial / 16) - 2*floor(trial / 32))*1.8
alter VB4 = $&drive
let drive = (floor(trial / 32) - 2*floor(trial / 64))*1.8
alter VB5 = $&drive
let drive = (floor(trial / 64) - 2*floor(trial / 128))*1.8
alter VB6 = $&drive
let drive = (floor(trial / 128) - 2*floor(trial / 256))*1.8
alter VB7 = $&drive
stop when time = 0.003726
resume
delete all
let endpoint = length(time)-1
let cmp = v(COMP)[endpoint]
let top = v(TOP)[endpoint]
let decision = 0
if cmp >= 0.9
let code = trial
let decision = 1
end
echo 206 0 $&trial $&cmp $&top 0.95390625 $&decision >> decisions.csv
alter VIN = 0.95859375
alter VSAMPLE = 1.8
alter VB0 = 0
alter VB1 = 0
alter VB2 = 0
alter VB3 = 0
alter VB4 = 0
alter VB5 = 0
alter VB6 = 0
alter VB7 = 0
let code = 0
stop when time = 0.003728
resume
delete all
alter VSAMPLE = 0
let trial = code + 128
let drive = (floor(trial / 1) - 2*floor(trial / 2))*1.8
alter VB0 = $&drive
let drive = (floor(trial / 2) - 2*floor(trial / 4))*1.8
alter VB1 = $&drive
let drive = (floor(trial / 4) - 2*floor(trial / 8))*1.8
alter VB2 = $&drive
let drive = (floor(trial / 8) - 2*floor(trial / 16))*1.8
alter VB3 = $&drive
let drive = (floor(trial / 16) - 2*floor(trial / 32))*1.8
alter VB4 = $&drive
let drive = (floor(trial / 32) - 2*floor(trial / 64))*1.8
alter VB5 = $&drive
let drive = (floor(trial / 64) - 2*floor(trial / 128))*1.8
alter VB6 = $&drive
let drive = (floor(trial / 128) - 2*floor(trial / 256))*1.8
alter VB7 = $&drive
stop when time = 0.00373
resume
delete all
let endpoint = length(time)-1
let cmp = v(COMP)[endpoint]
let top = v(TOP)[endpoint]
let decision = 0
if cmp >= 0.9
let code = trial
let decision = 1
end
echo 207 7 $&trial $&cmp $&top 0.95859375 $&decision >> decisions.csv
let trial = code + 64
let drive = (floor(trial / 1) - 2*floor(trial / 2))*1.8
alter VB0 = $&drive
let drive = (floor(trial / 2) - 2*floor(trial / 4))*1.8
alter VB1 = $&drive
let drive = (floor(trial / 4) - 2*floor(trial / 8))*1.8
alter VB2 = $&drive
let drive = (floor(trial / 8) - 2*floor(trial / 16))*1.8
alter VB3 = $&drive
let drive = (floor(trial / 16) - 2*floor(trial / 32))*1.8
alter VB4 = $&drive
let drive = (floor(trial / 32) - 2*floor(trial / 64))*1.8
alter VB5 = $&drive
let drive = (floor(trial / 64) - 2*floor(trial / 128))*1.8
alter VB6 = $&drive
let drive = (floor(trial / 128) - 2*floor(trial / 256))*1.8
alter VB7 = $&drive
stop when time = 0.003732
resume
delete all
let endpoint = length(time)-1
let cmp = v(COMP)[endpoint]
let top = v(TOP)[endpoint]
let decision = 0
if cmp >= 0.9
let code = trial
let decision = 1
end
echo 207 6 $&trial $&cmp $&top 0.95859375 $&decision >> decisions.csv
let trial = code + 32
let drive = (floor(trial / 1) - 2*floor(trial / 2))*1.8
alter VB0 = $&drive
let drive = (floor(trial / 2) - 2*floor(trial / 4))*1.8
alter VB1 = $&drive
let drive = (floor(trial / 4) - 2*floor(trial / 8))*1.8
alter VB2 = $&drive
let drive = (floor(trial / 8) - 2*floor(trial / 16))*1.8
alter VB3 = $&drive
let drive = (floor(trial / 16) - 2*floor(trial / 32))*1.8
alter VB4 = $&drive
let drive = (floor(trial / 32) - 2*floor(trial / 64))*1.8
alter VB5 = $&drive
let drive = (floor(trial / 64) - 2*floor(trial / 128))*1.8
alter VB6 = $&drive
let drive = (floor(trial / 128) - 2*floor(trial / 256))*1.8
alter VB7 = $&drive
stop when time = 0.003734
resume
delete all
let endpoint = length(time)-1
let cmp = v(COMP)[endpoint]
let top = v(TOP)[endpoint]
let decision = 0
if cmp >= 0.9
let code = trial
let decision = 1
end
echo 207 5 $&trial $&cmp $&top 0.95859375 $&decision >> decisions.csv
let trial = code + 16
let drive = (floor(trial / 1) - 2*floor(trial / 2))*1.8
alter VB0 = $&drive
let drive = (floor(trial / 2) - 2*floor(trial / 4))*1.8
alter VB1 = $&drive
let drive = (floor(trial / 4) - 2*floor(trial / 8))*1.8
alter VB2 = $&drive
let drive = (floor(trial / 8) - 2*floor(trial / 16))*1.8
alter VB3 = $&drive
let drive = (floor(trial / 16) - 2*floor(trial / 32))*1.8
alter VB4 = $&drive
let drive = (floor(trial / 32) - 2*floor(trial / 64))*1.8
alter VB5 = $&drive
let drive = (floor(trial / 64) - 2*floor(trial / 128))*1.8
alter VB6 = $&drive
let drive = (floor(trial / 128) - 2*floor(trial / 256))*1.8
alter VB7 = $&drive
stop when time = 0.003736
resume
delete all
let endpoint = length(time)-1
let cmp = v(COMP)[endpoint]
let top = v(TOP)[endpoint]
let decision = 0
if cmp >= 0.9
let code = trial
let decision = 1
end
echo 207 4 $&trial $&cmp $&top 0.95859375 $&decision >> decisions.csv
let trial = code + 8
let drive = (floor(trial / 1) - 2*floor(trial / 2))*1.8
alter VB0 = $&drive
let drive = (floor(trial / 2) - 2*floor(trial / 4))*1.8
alter VB1 = $&drive
let drive = (floor(trial / 4) - 2*floor(trial / 8))*1.8
alter VB2 = $&drive
let drive = (floor(trial / 8) - 2*floor(trial / 16))*1.8
alter VB3 = $&drive
let drive = (floor(trial / 16) - 2*floor(trial / 32))*1.8
alter VB4 = $&drive
let drive = (floor(trial / 32) - 2*floor(trial / 64))*1.8
alter VB5 = $&drive
let drive = (floor(trial / 64) - 2*floor(trial / 128))*1.8
alter VB6 = $&drive
let drive = (floor(trial / 128) - 2*floor(trial / 256))*1.8
alter VB7 = $&drive
stop when time = 0.003738
resume
delete all
let endpoint = length(time)-1
let cmp = v(COMP)[endpoint]
let top = v(TOP)[endpoint]
let decision = 0
if cmp >= 0.9
let code = trial
let decision = 1
end
echo 207 3 $&trial $&cmp $&top 0.95859375 $&decision >> decisions.csv
let trial = code + 4
let drive = (floor(trial / 1) - 2*floor(trial / 2))*1.8
alter VB0 = $&drive
let drive = (floor(trial / 2) - 2*floor(trial / 4))*1.8
alter VB1 = $&drive
let drive = (floor(trial / 4) - 2*floor(trial / 8))*1.8
alter VB2 = $&drive
let drive = (floor(trial / 8) - 2*floor(trial / 16))*1.8
alter VB3 = $&drive
let drive = (floor(trial / 16) - 2*floor(trial / 32))*1.8
alter VB4 = $&drive
let drive = (floor(trial / 32) - 2*floor(trial / 64))*1.8
alter VB5 = $&drive
let drive = (floor(trial / 64) - 2*floor(trial / 128))*1.8
alter VB6 = $&drive
let drive = (floor(trial / 128) - 2*floor(trial / 256))*1.8
alter VB7 = $&drive
stop when time = 0.00374
resume
delete all
let endpoint = length(time)-1
let cmp = v(COMP)[endpoint]
let top = v(TOP)[endpoint]
let decision = 0
if cmp >= 0.9
let code = trial
let decision = 1
end
echo 207 2 $&trial $&cmp $&top 0.95859375 $&decision >> decisions.csv
let trial = code + 2
let drive = (floor(trial / 1) - 2*floor(trial / 2))*1.8
alter VB0 = $&drive
let drive = (floor(trial / 2) - 2*floor(trial / 4))*1.8
alter VB1 = $&drive
let drive = (floor(trial / 4) - 2*floor(trial / 8))*1.8
alter VB2 = $&drive
let drive = (floor(trial / 8) - 2*floor(trial / 16))*1.8
alter VB3 = $&drive
let drive = (floor(trial / 16) - 2*floor(trial / 32))*1.8
alter VB4 = $&drive
let drive = (floor(trial / 32) - 2*floor(trial / 64))*1.8
alter VB5 = $&drive
let drive = (floor(trial / 64) - 2*floor(trial / 128))*1.8
alter VB6 = $&drive
let drive = (floor(trial / 128) - 2*floor(trial / 256))*1.8
alter VB7 = $&drive
stop when time = 0.003742
resume
delete all
let endpoint = length(time)-1
let cmp = v(COMP)[endpoint]
let top = v(TOP)[endpoint]
let decision = 0
if cmp >= 0.9
let code = trial
let decision = 1
end
echo 207 1 $&trial $&cmp $&top 0.95859375 $&decision >> decisions.csv
let trial = code + 1
let drive = (floor(trial / 1) - 2*floor(trial / 2))*1.8
alter VB0 = $&drive
let drive = (floor(trial / 2) - 2*floor(trial / 4))*1.8
alter VB1 = $&drive
let drive = (floor(trial / 4) - 2*floor(trial / 8))*1.8
alter VB2 = $&drive
let drive = (floor(trial / 8) - 2*floor(trial / 16))*1.8
alter VB3 = $&drive
let drive = (floor(trial / 16) - 2*floor(trial / 32))*1.8
alter VB4 = $&drive
let drive = (floor(trial / 32) - 2*floor(trial / 64))*1.8
alter VB5 = $&drive
let drive = (floor(trial / 64) - 2*floor(trial / 128))*1.8
alter VB6 = $&drive
let drive = (floor(trial / 128) - 2*floor(trial / 256))*1.8
alter VB7 = $&drive
stop when time = 0.003744
resume
delete all
let endpoint = length(time)-1
let cmp = v(COMP)[endpoint]
let top = v(TOP)[endpoint]
let decision = 0
if cmp >= 0.9
let code = trial
let decision = 1
end
echo 207 0 $&trial $&cmp $&top 0.95859375 $&decision >> decisions.csv
alter VIN = 0.96328125
alter VSAMPLE = 1.8
alter VB0 = 0
alter VB1 = 0
alter VB2 = 0
alter VB3 = 0
alter VB4 = 0
alter VB5 = 0
alter VB6 = 0
alter VB7 = 0
let code = 0
stop when time = 0.003746
resume
delete all
alter VSAMPLE = 0
let trial = code + 128
let drive = (floor(trial / 1) - 2*floor(trial / 2))*1.8
alter VB0 = $&drive
let drive = (floor(trial / 2) - 2*floor(trial / 4))*1.8
alter VB1 = $&drive
let drive = (floor(trial / 4) - 2*floor(trial / 8))*1.8
alter VB2 = $&drive
let drive = (floor(trial / 8) - 2*floor(trial / 16))*1.8
alter VB3 = $&drive
let drive = (floor(trial / 16) - 2*floor(trial / 32))*1.8
alter VB4 = $&drive
let drive = (floor(trial / 32) - 2*floor(trial / 64))*1.8
alter VB5 = $&drive
let drive = (floor(trial / 64) - 2*floor(trial / 128))*1.8
alter VB6 = $&drive
let drive = (floor(trial / 128) - 2*floor(trial / 256))*1.8
alter VB7 = $&drive
stop when time = 0.003748
resume
delete all
let endpoint = length(time)-1
let cmp = v(COMP)[endpoint]
let top = v(TOP)[endpoint]
let decision = 0
if cmp >= 0.9
let code = trial
let decision = 1
end
echo 208 7 $&trial $&cmp $&top 0.96328125 $&decision >> decisions.csv
let trial = code + 64
let drive = (floor(trial / 1) - 2*floor(trial / 2))*1.8
alter VB0 = $&drive
let drive = (floor(trial / 2) - 2*floor(trial / 4))*1.8
alter VB1 = $&drive
let drive = (floor(trial / 4) - 2*floor(trial / 8))*1.8
alter VB2 = $&drive
let drive = (floor(trial / 8) - 2*floor(trial / 16))*1.8
alter VB3 = $&drive
let drive = (floor(trial / 16) - 2*floor(trial / 32))*1.8
alter VB4 = $&drive
let drive = (floor(trial / 32) - 2*floor(trial / 64))*1.8
alter VB5 = $&drive
let drive = (floor(trial / 64) - 2*floor(trial / 128))*1.8
alter VB6 = $&drive
let drive = (floor(trial / 128) - 2*floor(trial / 256))*1.8
alter VB7 = $&drive
stop when time = 0.00375
resume
delete all
let endpoint = length(time)-1
let cmp = v(COMP)[endpoint]
let top = v(TOP)[endpoint]
let decision = 0
if cmp >= 0.9
let code = trial
let decision = 1
end
echo 208 6 $&trial $&cmp $&top 0.96328125 $&decision >> decisions.csv
let trial = code + 32
let drive = (floor(trial / 1) - 2*floor(trial / 2))*1.8
alter VB0 = $&drive
let drive = (floor(trial / 2) - 2*floor(trial / 4))*1.8
alter VB1 = $&drive
let drive = (floor(trial / 4) - 2*floor(trial / 8))*1.8
alter VB2 = $&drive
let drive = (floor(trial / 8) - 2*floor(trial / 16))*1.8
alter VB3 = $&drive
let drive = (floor(trial / 16) - 2*floor(trial / 32))*1.8
alter VB4 = $&drive
let drive = (floor(trial / 32) - 2*floor(trial / 64))*1.8
alter VB5 = $&drive
let drive = (floor(trial / 64) - 2*floor(trial / 128))*1.8
alter VB6 = $&drive
let drive = (floor(trial / 128) - 2*floor(trial / 256))*1.8
alter VB7 = $&drive
stop when time = 0.003752
resume
delete all
let endpoint = length(time)-1
let cmp = v(COMP)[endpoint]
let top = v(TOP)[endpoint]
let decision = 0
if cmp >= 0.9
let code = trial
let decision = 1
end
echo 208 5 $&trial $&cmp $&top 0.96328125 $&decision >> decisions.csv
let trial = code + 16
let drive = (floor(trial / 1) - 2*floor(trial / 2))*1.8
alter VB0 = $&drive
let drive = (floor(trial / 2) - 2*floor(trial / 4))*1.8
alter VB1 = $&drive
let drive = (floor(trial / 4) - 2*floor(trial / 8))*1.8
alter VB2 = $&drive
let drive = (floor(trial / 8) - 2*floor(trial / 16))*1.8
alter VB3 = $&drive
let drive = (floor(trial / 16) - 2*floor(trial / 32))*1.8
alter VB4 = $&drive
let drive = (floor(trial / 32) - 2*floor(trial / 64))*1.8
alter VB5 = $&drive
let drive = (floor(trial / 64) - 2*floor(trial / 128))*1.8
alter VB6 = $&drive
let drive = (floor(trial / 128) - 2*floor(trial / 256))*1.8
alter VB7 = $&drive
stop when time = 0.003754
resume
delete all
let endpoint = length(time)-1
let cmp = v(COMP)[endpoint]
let top = v(TOP)[endpoint]
let decision = 0
if cmp >= 0.9
let code = trial
let decision = 1
end
echo 208 4 $&trial $&cmp $&top 0.96328125 $&decision >> decisions.csv
let trial = code + 8
let drive = (floor(trial / 1) - 2*floor(trial / 2))*1.8
alter VB0 = $&drive
let drive = (floor(trial / 2) - 2*floor(trial / 4))*1.8
alter VB1 = $&drive
let drive = (floor(trial / 4) - 2*floor(trial / 8))*1.8
alter VB2 = $&drive
let drive = (floor(trial / 8) - 2*floor(trial / 16))*1.8
alter VB3 = $&drive
let drive = (floor(trial / 16) - 2*floor(trial / 32))*1.8
alter VB4 = $&drive
let drive = (floor(trial / 32) - 2*floor(trial / 64))*1.8
alter VB5 = $&drive
let drive = (floor(trial / 64) - 2*floor(trial / 128))*1.8
alter VB6 = $&drive
let drive = (floor(trial / 128) - 2*floor(trial / 256))*1.8
alter VB7 = $&drive
stop when time = 0.003756
resume
delete all
let endpoint = length(time)-1
let cmp = v(COMP)[endpoint]
let top = v(TOP)[endpoint]
let decision = 0
if cmp >= 0.9
let code = trial
let decision = 1
end
echo 208 3 $&trial $&cmp $&top 0.96328125 $&decision >> decisions.csv
let trial = code + 4
let drive = (floor(trial / 1) - 2*floor(trial / 2))*1.8
alter VB0 = $&drive
let drive = (floor(trial / 2) - 2*floor(trial / 4))*1.8
alter VB1 = $&drive
let drive = (floor(trial / 4) - 2*floor(trial / 8))*1.8
alter VB2 = $&drive
let drive = (floor(trial / 8) - 2*floor(trial / 16))*1.8
alter VB3 = $&drive
let drive = (floor(trial / 16) - 2*floor(trial / 32))*1.8
alter VB4 = $&drive
let drive = (floor(trial / 32) - 2*floor(trial / 64))*1.8
alter VB5 = $&drive
let drive = (floor(trial / 64) - 2*floor(trial / 128))*1.8
alter VB6 = $&drive
let drive = (floor(trial / 128) - 2*floor(trial / 256))*1.8
alter VB7 = $&drive
stop when time = 0.003758
resume
delete all
let endpoint = length(time)-1
let cmp = v(COMP)[endpoint]
let top = v(TOP)[endpoint]
let decision = 0
if cmp >= 0.9
let code = trial
let decision = 1
end
echo 208 2 $&trial $&cmp $&top 0.96328125 $&decision >> decisions.csv
let trial = code + 2
let drive = (floor(trial / 1) - 2*floor(trial / 2))*1.8
alter VB0 = $&drive
let drive = (floor(trial / 2) - 2*floor(trial / 4))*1.8
alter VB1 = $&drive
let drive = (floor(trial / 4) - 2*floor(trial / 8))*1.8
alter VB2 = $&drive
let drive = (floor(trial / 8) - 2*floor(trial / 16))*1.8
alter VB3 = $&drive
let drive = (floor(trial / 16) - 2*floor(trial / 32))*1.8
alter VB4 = $&drive
let drive = (floor(trial / 32) - 2*floor(trial / 64))*1.8
alter VB5 = $&drive
let drive = (floor(trial / 64) - 2*floor(trial / 128))*1.8
alter VB6 = $&drive
let drive = (floor(trial / 128) - 2*floor(trial / 256))*1.8
alter VB7 = $&drive
stop when time = 0.00376
resume
delete all
let endpoint = length(time)-1
let cmp = v(COMP)[endpoint]
let top = v(TOP)[endpoint]
let decision = 0
if cmp >= 0.9
let code = trial
let decision = 1
end
echo 208 1 $&trial $&cmp $&top 0.96328125 $&decision >> decisions.csv
let trial = code + 1
let drive = (floor(trial / 1) - 2*floor(trial / 2))*1.8
alter VB0 = $&drive
let drive = (floor(trial / 2) - 2*floor(trial / 4))*1.8
alter VB1 = $&drive
let drive = (floor(trial / 4) - 2*floor(trial / 8))*1.8
alter VB2 = $&drive
let drive = (floor(trial / 8) - 2*floor(trial / 16))*1.8
alter VB3 = $&drive
let drive = (floor(trial / 16) - 2*floor(trial / 32))*1.8
alter VB4 = $&drive
let drive = (floor(trial / 32) - 2*floor(trial / 64))*1.8
alter VB5 = $&drive
let drive = (floor(trial / 64) - 2*floor(trial / 128))*1.8
alter VB6 = $&drive
let drive = (floor(trial / 128) - 2*floor(trial / 256))*1.8
alter VB7 = $&drive
stop when time = 0.003762
resume
delete all
let endpoint = length(time)-1
let cmp = v(COMP)[endpoint]
let top = v(TOP)[endpoint]
let decision = 0
if cmp >= 0.9
let code = trial
let decision = 1
end
echo 208 0 $&trial $&cmp $&top 0.96328125 $&decision >> decisions.csv
alter VIN = 0.96796875
alter VSAMPLE = 1.8
alter VB0 = 0
alter VB1 = 0
alter VB2 = 0
alter VB3 = 0
alter VB4 = 0
alter VB5 = 0
alter VB6 = 0
alter VB7 = 0
let code = 0
stop when time = 0.003764
resume
delete all
alter VSAMPLE = 0
let trial = code + 128
let drive = (floor(trial / 1) - 2*floor(trial / 2))*1.8
alter VB0 = $&drive
let drive = (floor(trial / 2) - 2*floor(trial / 4))*1.8
alter VB1 = $&drive
let drive = (floor(trial / 4) - 2*floor(trial / 8))*1.8
alter VB2 = $&drive
let drive = (floor(trial / 8) - 2*floor(trial / 16))*1.8
alter VB3 = $&drive
let drive = (floor(trial / 16) - 2*floor(trial / 32))*1.8
alter VB4 = $&drive
let drive = (floor(trial / 32) - 2*floor(trial / 64))*1.8
alter VB5 = $&drive
let drive = (floor(trial / 64) - 2*floor(trial / 128))*1.8
alter VB6 = $&drive
let drive = (floor(trial / 128) - 2*floor(trial / 256))*1.8
alter VB7 = $&drive
stop when time = 0.003766
resume
delete all
let endpoint = length(time)-1
let cmp = v(COMP)[endpoint]
let top = v(TOP)[endpoint]
let decision = 0
if cmp >= 0.9
let code = trial
let decision = 1
end
echo 209 7 $&trial $&cmp $&top 0.96796875 $&decision >> decisions.csv
let trial = code + 64
let drive = (floor(trial / 1) - 2*floor(trial / 2))*1.8
alter VB0 = $&drive
let drive = (floor(trial / 2) - 2*floor(trial / 4))*1.8
alter VB1 = $&drive
let drive = (floor(trial / 4) - 2*floor(trial / 8))*1.8
alter VB2 = $&drive
let drive = (floor(trial / 8) - 2*floor(trial / 16))*1.8
alter VB3 = $&drive
let drive = (floor(trial / 16) - 2*floor(trial / 32))*1.8
alter VB4 = $&drive
let drive = (floor(trial / 32) - 2*floor(trial / 64))*1.8
alter VB5 = $&drive
let drive = (floor(trial / 64) - 2*floor(trial / 128))*1.8
alter VB6 = $&drive
let drive = (floor(trial / 128) - 2*floor(trial / 256))*1.8
alter VB7 = $&drive
stop when time = 0.003768
resume
delete all
let endpoint = length(time)-1
let cmp = v(COMP)[endpoint]
let top = v(TOP)[endpoint]
let decision = 0
if cmp >= 0.9
let code = trial
let decision = 1
end
echo 209 6 $&trial $&cmp $&top 0.96796875 $&decision >> decisions.csv
let trial = code + 32
let drive = (floor(trial / 1) - 2*floor(trial / 2))*1.8
alter VB0 = $&drive
let drive = (floor(trial / 2) - 2*floor(trial / 4))*1.8
alter VB1 = $&drive
let drive = (floor(trial / 4) - 2*floor(trial / 8))*1.8
alter VB2 = $&drive
let drive = (floor(trial / 8) - 2*floor(trial / 16))*1.8
alter VB3 = $&drive
let drive = (floor(trial / 16) - 2*floor(trial / 32))*1.8
alter VB4 = $&drive
let drive = (floor(trial / 32) - 2*floor(trial / 64))*1.8
alter VB5 = $&drive
let drive = (floor(trial / 64) - 2*floor(trial / 128))*1.8
alter VB6 = $&drive
let drive = (floor(trial / 128) - 2*floor(trial / 256))*1.8
alter VB7 = $&drive
stop when time = 0.00377
resume
delete all
let endpoint = length(time)-1
let cmp = v(COMP)[endpoint]
let top = v(TOP)[endpoint]
let decision = 0
if cmp >= 0.9
let code = trial
let decision = 1
end
echo 209 5 $&trial $&cmp $&top 0.96796875 $&decision >> decisions.csv
let trial = code + 16
let drive = (floor(trial / 1) - 2*floor(trial / 2))*1.8
alter VB0 = $&drive
let drive = (floor(trial / 2) - 2*floor(trial / 4))*1.8
alter VB1 = $&drive
let drive = (floor(trial / 4) - 2*floor(trial / 8))*1.8
alter VB2 = $&drive
let drive = (floor(trial / 8) - 2*floor(trial / 16))*1.8
alter VB3 = $&drive
let drive = (floor(trial / 16) - 2*floor(trial / 32))*1.8
alter VB4 = $&drive
let drive = (floor(trial / 32) - 2*floor(trial / 64))*1.8
alter VB5 = $&drive
let drive = (floor(trial / 64) - 2*floor(trial / 128))*1.8
alter VB6 = $&drive
let drive = (floor(trial / 128) - 2*floor(trial / 256))*1.8
alter VB7 = $&drive
stop when time = 0.003772
resume
delete all
let endpoint = length(time)-1
let cmp = v(COMP)[endpoint]
let top = v(TOP)[endpoint]
let decision = 0
if cmp >= 0.9
let code = trial
let decision = 1
end
echo 209 4 $&trial $&cmp $&top 0.96796875 $&decision >> decisions.csv
let trial = code + 8
let drive = (floor(trial / 1) - 2*floor(trial / 2))*1.8
alter VB0 = $&drive
let drive = (floor(trial / 2) - 2*floor(trial / 4))*1.8
alter VB1 = $&drive
let drive = (floor(trial / 4) - 2*floor(trial / 8))*1.8
alter VB2 = $&drive
let drive = (floor(trial / 8) - 2*floor(trial / 16))*1.8
alter VB3 = $&drive
let drive = (floor(trial / 16) - 2*floor(trial / 32))*1.8
alter VB4 = $&drive
let drive = (floor(trial / 32) - 2*floor(trial / 64))*1.8
alter VB5 = $&drive
let drive = (floor(trial / 64) - 2*floor(trial / 128))*1.8
alter VB6 = $&drive
let drive = (floor(trial / 128) - 2*floor(trial / 256))*1.8
alter VB7 = $&drive
stop when time = 0.003774
resume
delete all
let endpoint = length(time)-1
let cmp = v(COMP)[endpoint]
let top = v(TOP)[endpoint]
let decision = 0
if cmp >= 0.9
let code = trial
let decision = 1
end
echo 209 3 $&trial $&cmp $&top 0.96796875 $&decision >> decisions.csv
let trial = code + 4
let drive = (floor(trial / 1) - 2*floor(trial / 2))*1.8
alter VB0 = $&drive
let drive = (floor(trial / 2) - 2*floor(trial / 4))*1.8
alter VB1 = $&drive
let drive = (floor(trial / 4) - 2*floor(trial / 8))*1.8
alter VB2 = $&drive
let drive = (floor(trial / 8) - 2*floor(trial / 16))*1.8
alter VB3 = $&drive
let drive = (floor(trial / 16) - 2*floor(trial / 32))*1.8
alter VB4 = $&drive
let drive = (floor(trial / 32) - 2*floor(trial / 64))*1.8
alter VB5 = $&drive
let drive = (floor(trial / 64) - 2*floor(trial / 128))*1.8
alter VB6 = $&drive
let drive = (floor(trial / 128) - 2*floor(trial / 256))*1.8
alter VB7 = $&drive
stop when time = 0.003776
resume
delete all
let endpoint = length(time)-1
let cmp = v(COMP)[endpoint]
let top = v(TOP)[endpoint]
let decision = 0
if cmp >= 0.9
let code = trial
let decision = 1
end
echo 209 2 $&trial $&cmp $&top 0.96796875 $&decision >> decisions.csv
let trial = code + 2
let drive = (floor(trial / 1) - 2*floor(trial / 2))*1.8
alter VB0 = $&drive
let drive = (floor(trial / 2) - 2*floor(trial / 4))*1.8
alter VB1 = $&drive
let drive = (floor(trial / 4) - 2*floor(trial / 8))*1.8
alter VB2 = $&drive
let drive = (floor(trial / 8) - 2*floor(trial / 16))*1.8
alter VB3 = $&drive
let drive = (floor(trial / 16) - 2*floor(trial / 32))*1.8
alter VB4 = $&drive
let drive = (floor(trial / 32) - 2*floor(trial / 64))*1.8
alter VB5 = $&drive
let drive = (floor(trial / 64) - 2*floor(trial / 128))*1.8
alter VB6 = $&drive
let drive = (floor(trial / 128) - 2*floor(trial / 256))*1.8
alter VB7 = $&drive
stop when time = 0.003778
resume
delete all
let endpoint = length(time)-1
let cmp = v(COMP)[endpoint]
let top = v(TOP)[endpoint]
let decision = 0
if cmp >= 0.9
let code = trial
let decision = 1
end
echo 209 1 $&trial $&cmp $&top 0.96796875 $&decision >> decisions.csv
let trial = code + 1
let drive = (floor(trial / 1) - 2*floor(trial / 2))*1.8
alter VB0 = $&drive
let drive = (floor(trial / 2) - 2*floor(trial / 4))*1.8
alter VB1 = $&drive
let drive = (floor(trial / 4) - 2*floor(trial / 8))*1.8
alter VB2 = $&drive
let drive = (floor(trial / 8) - 2*floor(trial / 16))*1.8
alter VB3 = $&drive
let drive = (floor(trial / 16) - 2*floor(trial / 32))*1.8
alter VB4 = $&drive
let drive = (floor(trial / 32) - 2*floor(trial / 64))*1.8
alter VB5 = $&drive
let drive = (floor(trial / 64) - 2*floor(trial / 128))*1.8
alter VB6 = $&drive
let drive = (floor(trial / 128) - 2*floor(trial / 256))*1.8
alter VB7 = $&drive
stop when time = 0.00378
resume
delete all
let endpoint = length(time)-1
let cmp = v(COMP)[endpoint]
let top = v(TOP)[endpoint]
let decision = 0
if cmp >= 0.9
let code = trial
let decision = 1
end
echo 209 0 $&trial $&cmp $&top 0.96796875 $&decision >> decisions.csv
alter VIN = 0.97265625
alter VSAMPLE = 1.8
alter VB0 = 0
alter VB1 = 0
alter VB2 = 0
alter VB3 = 0
alter VB4 = 0
alter VB5 = 0
alter VB6 = 0
alter VB7 = 0
let code = 0
stop when time = 0.003782
resume
delete all
alter VSAMPLE = 0
let trial = code + 128
let drive = (floor(trial / 1) - 2*floor(trial / 2))*1.8
alter VB0 = $&drive
let drive = (floor(trial / 2) - 2*floor(trial / 4))*1.8
alter VB1 = $&drive
let drive = (floor(trial / 4) - 2*floor(trial / 8))*1.8
alter VB2 = $&drive
let drive = (floor(trial / 8) - 2*floor(trial / 16))*1.8
alter VB3 = $&drive
let drive = (floor(trial / 16) - 2*floor(trial / 32))*1.8
alter VB4 = $&drive
let drive = (floor(trial / 32) - 2*floor(trial / 64))*1.8
alter VB5 = $&drive
let drive = (floor(trial / 64) - 2*floor(trial / 128))*1.8
alter VB6 = $&drive
let drive = (floor(trial / 128) - 2*floor(trial / 256))*1.8
alter VB7 = $&drive
stop when time = 0.003784
resume
delete all
let endpoint = length(time)-1
let cmp = v(COMP)[endpoint]
let top = v(TOP)[endpoint]
let decision = 0
if cmp >= 0.9
let code = trial
let decision = 1
end
echo 210 7 $&trial $&cmp $&top 0.97265625 $&decision >> decisions.csv
let trial = code + 64
let drive = (floor(trial / 1) - 2*floor(trial / 2))*1.8
alter VB0 = $&drive
let drive = (floor(trial / 2) - 2*floor(trial / 4))*1.8
alter VB1 = $&drive
let drive = (floor(trial / 4) - 2*floor(trial / 8))*1.8
alter VB2 = $&drive
let drive = (floor(trial / 8) - 2*floor(trial / 16))*1.8
alter VB3 = $&drive
let drive = (floor(trial / 16) - 2*floor(trial / 32))*1.8
alter VB4 = $&drive
let drive = (floor(trial / 32) - 2*floor(trial / 64))*1.8
alter VB5 = $&drive
let drive = (floor(trial / 64) - 2*floor(trial / 128))*1.8
alter VB6 = $&drive
let drive = (floor(trial / 128) - 2*floor(trial / 256))*1.8
alter VB7 = $&drive
stop when time = 0.003786
resume
delete all
let endpoint = length(time)-1
let cmp = v(COMP)[endpoint]
let top = v(TOP)[endpoint]
let decision = 0
if cmp >= 0.9
let code = trial
let decision = 1
end
echo 210 6 $&trial $&cmp $&top 0.97265625 $&decision >> decisions.csv
let trial = code + 32
let drive = (floor(trial / 1) - 2*floor(trial / 2))*1.8
alter VB0 = $&drive
let drive = (floor(trial / 2) - 2*floor(trial / 4))*1.8
alter VB1 = $&drive
let drive = (floor(trial / 4) - 2*floor(trial / 8))*1.8
alter VB2 = $&drive
let drive = (floor(trial / 8) - 2*floor(trial / 16))*1.8
alter VB3 = $&drive
let drive = (floor(trial / 16) - 2*floor(trial / 32))*1.8
alter VB4 = $&drive
let drive = (floor(trial / 32) - 2*floor(trial / 64))*1.8
alter VB5 = $&drive
let drive = (floor(trial / 64) - 2*floor(trial / 128))*1.8
alter VB6 = $&drive
let drive = (floor(trial / 128) - 2*floor(trial / 256))*1.8
alter VB7 = $&drive
stop when time = 0.003788
resume
delete all
let endpoint = length(time)-1
let cmp = v(COMP)[endpoint]
let top = v(TOP)[endpoint]
let decision = 0
if cmp >= 0.9
let code = trial
let decision = 1
end
echo 210 5 $&trial $&cmp $&top 0.97265625 $&decision >> decisions.csv
let trial = code + 16
let drive = (floor(trial / 1) - 2*floor(trial / 2))*1.8
alter VB0 = $&drive
let drive = (floor(trial / 2) - 2*floor(trial / 4))*1.8
alter VB1 = $&drive
let drive = (floor(trial / 4) - 2*floor(trial / 8))*1.8
alter VB2 = $&drive
let drive = (floor(trial / 8) - 2*floor(trial / 16))*1.8
alter VB3 = $&drive
let drive = (floor(trial / 16) - 2*floor(trial / 32))*1.8
alter VB4 = $&drive
let drive = (floor(trial / 32) - 2*floor(trial / 64))*1.8
alter VB5 = $&drive
let drive = (floor(trial / 64) - 2*floor(trial / 128))*1.8
alter VB6 = $&drive
let drive = (floor(trial / 128) - 2*floor(trial / 256))*1.8
alter VB7 = $&drive
stop when time = 0.00379
resume
delete all
let endpoint = length(time)-1
let cmp = v(COMP)[endpoint]
let top = v(TOP)[endpoint]
let decision = 0
if cmp >= 0.9
let code = trial
let decision = 1
end
echo 210 4 $&trial $&cmp $&top 0.97265625 $&decision >> decisions.csv
let trial = code + 8
let drive = (floor(trial / 1) - 2*floor(trial / 2))*1.8
alter VB0 = $&drive
let drive = (floor(trial / 2) - 2*floor(trial / 4))*1.8
alter VB1 = $&drive
let drive = (floor(trial / 4) - 2*floor(trial / 8))*1.8
alter VB2 = $&drive
let drive = (floor(trial / 8) - 2*floor(trial / 16))*1.8
alter VB3 = $&drive
let drive = (floor(trial / 16) - 2*floor(trial / 32))*1.8
alter VB4 = $&drive
let drive = (floor(trial / 32) - 2*floor(trial / 64))*1.8
alter VB5 = $&drive
let drive = (floor(trial / 64) - 2*floor(trial / 128))*1.8
alter VB6 = $&drive
let drive = (floor(trial / 128) - 2*floor(trial / 256))*1.8
alter VB7 = $&drive
stop when time = 0.003792
resume
delete all
let endpoint = length(time)-1
let cmp = v(COMP)[endpoint]
let top = v(TOP)[endpoint]
let decision = 0
if cmp >= 0.9
let code = trial
let decision = 1
end
echo 210 3 $&trial $&cmp $&top 0.97265625 $&decision >> decisions.csv
let trial = code + 4
let drive = (floor(trial / 1) - 2*floor(trial / 2))*1.8
alter VB0 = $&drive
let drive = (floor(trial / 2) - 2*floor(trial / 4))*1.8
alter VB1 = $&drive
let drive = (floor(trial / 4) - 2*floor(trial / 8))*1.8
alter VB2 = $&drive
let drive = (floor(trial / 8) - 2*floor(trial / 16))*1.8
alter VB3 = $&drive
let drive = (floor(trial / 16) - 2*floor(trial / 32))*1.8
alter VB4 = $&drive
let drive = (floor(trial / 32) - 2*floor(trial / 64))*1.8
alter VB5 = $&drive
let drive = (floor(trial / 64) - 2*floor(trial / 128))*1.8
alter VB6 = $&drive
let drive = (floor(trial / 128) - 2*floor(trial / 256))*1.8
alter VB7 = $&drive
stop when time = 0.003794
resume
delete all
let endpoint = length(time)-1
let cmp = v(COMP)[endpoint]
let top = v(TOP)[endpoint]
let decision = 0
if cmp >= 0.9
let code = trial
let decision = 1
end
echo 210 2 $&trial $&cmp $&top 0.97265625 $&decision >> decisions.csv
let trial = code + 2
let drive = (floor(trial / 1) - 2*floor(trial / 2))*1.8
alter VB0 = $&drive
let drive = (floor(trial / 2) - 2*floor(trial / 4))*1.8
alter VB1 = $&drive
let drive = (floor(trial / 4) - 2*floor(trial / 8))*1.8
alter VB2 = $&drive
let drive = (floor(trial / 8) - 2*floor(trial / 16))*1.8
alter VB3 = $&drive
let drive = (floor(trial / 16) - 2*floor(trial / 32))*1.8
alter VB4 = $&drive
let drive = (floor(trial / 32) - 2*floor(trial / 64))*1.8
alter VB5 = $&drive
let drive = (floor(trial / 64) - 2*floor(trial / 128))*1.8
alter VB6 = $&drive
let drive = (floor(trial / 128) - 2*floor(trial / 256))*1.8
alter VB7 = $&drive
stop when time = 0.003796
resume
delete all
let endpoint = length(time)-1
let cmp = v(COMP)[endpoint]
let top = v(TOP)[endpoint]
let decision = 0
if cmp >= 0.9
let code = trial
let decision = 1
end
echo 210 1 $&trial $&cmp $&top 0.97265625 $&decision >> decisions.csv
let trial = code + 1
let drive = (floor(trial / 1) - 2*floor(trial / 2))*1.8
alter VB0 = $&drive
let drive = (floor(trial / 2) - 2*floor(trial / 4))*1.8
alter VB1 = $&drive
let drive = (floor(trial / 4) - 2*floor(trial / 8))*1.8
alter VB2 = $&drive
let drive = (floor(trial / 8) - 2*floor(trial / 16))*1.8
alter VB3 = $&drive
let drive = (floor(trial / 16) - 2*floor(trial / 32))*1.8
alter VB4 = $&drive
let drive = (floor(trial / 32) - 2*floor(trial / 64))*1.8
alter VB5 = $&drive
let drive = (floor(trial / 64) - 2*floor(trial / 128))*1.8
alter VB6 = $&drive
let drive = (floor(trial / 128) - 2*floor(trial / 256))*1.8
alter VB7 = $&drive
stop when time = 0.003798
resume
delete all
let endpoint = length(time)-1
let cmp = v(COMP)[endpoint]
let top = v(TOP)[endpoint]
let decision = 0
if cmp >= 0.9
let code = trial
let decision = 1
end
echo 210 0 $&trial $&cmp $&top 0.97265625 $&decision >> decisions.csv
alter VIN = 0.97734375
alter VSAMPLE = 1.8
alter VB0 = 0
alter VB1 = 0
alter VB2 = 0
alter VB3 = 0
alter VB4 = 0
alter VB5 = 0
alter VB6 = 0
alter VB7 = 0
let code = 0
stop when time = 0.0038
resume
delete all
alter VSAMPLE = 0
let trial = code + 128
let drive = (floor(trial / 1) - 2*floor(trial / 2))*1.8
alter VB0 = $&drive
let drive = (floor(trial / 2) - 2*floor(trial / 4))*1.8
alter VB1 = $&drive
let drive = (floor(trial / 4) - 2*floor(trial / 8))*1.8
alter VB2 = $&drive
let drive = (floor(trial / 8) - 2*floor(trial / 16))*1.8
alter VB3 = $&drive
let drive = (floor(trial / 16) - 2*floor(trial / 32))*1.8
alter VB4 = $&drive
let drive = (floor(trial / 32) - 2*floor(trial / 64))*1.8
alter VB5 = $&drive
let drive = (floor(trial / 64) - 2*floor(trial / 128))*1.8
alter VB6 = $&drive
let drive = (floor(trial / 128) - 2*floor(trial / 256))*1.8
alter VB7 = $&drive
stop when time = 0.003802
resume
delete all
let endpoint = length(time)-1
let cmp = v(COMP)[endpoint]
let top = v(TOP)[endpoint]
let decision = 0
if cmp >= 0.9
let code = trial
let decision = 1
end
echo 211 7 $&trial $&cmp $&top 0.97734375 $&decision >> decisions.csv
let trial = code + 64
let drive = (floor(trial / 1) - 2*floor(trial / 2))*1.8
alter VB0 = $&drive
let drive = (floor(trial / 2) - 2*floor(trial / 4))*1.8
alter VB1 = $&drive
let drive = (floor(trial / 4) - 2*floor(trial / 8))*1.8
alter VB2 = $&drive
let drive = (floor(trial / 8) - 2*floor(trial / 16))*1.8
alter VB3 = $&drive
let drive = (floor(trial / 16) - 2*floor(trial / 32))*1.8
alter VB4 = $&drive
let drive = (floor(trial / 32) - 2*floor(trial / 64))*1.8
alter VB5 = $&drive
let drive = (floor(trial / 64) - 2*floor(trial / 128))*1.8
alter VB6 = $&drive
let drive = (floor(trial / 128) - 2*floor(trial / 256))*1.8
alter VB7 = $&drive
stop when time = 0.003804
resume
delete all
let endpoint = length(time)-1
let cmp = v(COMP)[endpoint]
let top = v(TOP)[endpoint]
let decision = 0
if cmp >= 0.9
let code = trial
let decision = 1
end
echo 211 6 $&trial $&cmp $&top 0.97734375 $&decision >> decisions.csv
let trial = code + 32
let drive = (floor(trial / 1) - 2*floor(trial / 2))*1.8
alter VB0 = $&drive
let drive = (floor(trial / 2) - 2*floor(trial / 4))*1.8
alter VB1 = $&drive
let drive = (floor(trial / 4) - 2*floor(trial / 8))*1.8
alter VB2 = $&drive
let drive = (floor(trial / 8) - 2*floor(trial / 16))*1.8
alter VB3 = $&drive
let drive = (floor(trial / 16) - 2*floor(trial / 32))*1.8
alter VB4 = $&drive
let drive = (floor(trial / 32) - 2*floor(trial / 64))*1.8
alter VB5 = $&drive
let drive = (floor(trial / 64) - 2*floor(trial / 128))*1.8
alter VB6 = $&drive
let drive = (floor(trial / 128) - 2*floor(trial / 256))*1.8
alter VB7 = $&drive
stop when time = 0.003806
resume
delete all
let endpoint = length(time)-1
let cmp = v(COMP)[endpoint]
let top = v(TOP)[endpoint]
let decision = 0
if cmp >= 0.9
let code = trial
let decision = 1
end
echo 211 5 $&trial $&cmp $&top 0.97734375 $&decision >> decisions.csv
let trial = code + 16
let drive = (floor(trial / 1) - 2*floor(trial / 2))*1.8
alter VB0 = $&drive
let drive = (floor(trial / 2) - 2*floor(trial / 4))*1.8
alter VB1 = $&drive
let drive = (floor(trial / 4) - 2*floor(trial / 8))*1.8
alter VB2 = $&drive
let drive = (floor(trial / 8) - 2*floor(trial / 16))*1.8
alter VB3 = $&drive
let drive = (floor(trial / 16) - 2*floor(trial / 32))*1.8
alter VB4 = $&drive
let drive = (floor(trial / 32) - 2*floor(trial / 64))*1.8
alter VB5 = $&drive
let drive = (floor(trial / 64) - 2*floor(trial / 128))*1.8
alter VB6 = $&drive
let drive = (floor(trial / 128) - 2*floor(trial / 256))*1.8
alter VB7 = $&drive
stop when time = 0.003808
resume
delete all
let endpoint = length(time)-1
let cmp = v(COMP)[endpoint]
let top = v(TOP)[endpoint]
let decision = 0
if cmp >= 0.9
let code = trial
let decision = 1
end
echo 211 4 $&trial $&cmp $&top 0.97734375 $&decision >> decisions.csv
let trial = code + 8
let drive = (floor(trial / 1) - 2*floor(trial / 2))*1.8
alter VB0 = $&drive
let drive = (floor(trial / 2) - 2*floor(trial / 4))*1.8
alter VB1 = $&drive
let drive = (floor(trial / 4) - 2*floor(trial / 8))*1.8
alter VB2 = $&drive
let drive = (floor(trial / 8) - 2*floor(trial / 16))*1.8
alter VB3 = $&drive
let drive = (floor(trial / 16) - 2*floor(trial / 32))*1.8
alter VB4 = $&drive
let drive = (floor(trial / 32) - 2*floor(trial / 64))*1.8
alter VB5 = $&drive
let drive = (floor(trial / 64) - 2*floor(trial / 128))*1.8
alter VB6 = $&drive
let drive = (floor(trial / 128) - 2*floor(trial / 256))*1.8
alter VB7 = $&drive
stop when time = 0.00381
resume
delete all
let endpoint = length(time)-1
let cmp = v(COMP)[endpoint]
let top = v(TOP)[endpoint]
let decision = 0
if cmp >= 0.9
let code = trial
let decision = 1
end
echo 211 3 $&trial $&cmp $&top 0.97734375 $&decision >> decisions.csv
let trial = code + 4
let drive = (floor(trial / 1) - 2*floor(trial / 2))*1.8
alter VB0 = $&drive
let drive = (floor(trial / 2) - 2*floor(trial / 4))*1.8
alter VB1 = $&drive
let drive = (floor(trial / 4) - 2*floor(trial / 8))*1.8
alter VB2 = $&drive
let drive = (floor(trial / 8) - 2*floor(trial / 16))*1.8
alter VB3 = $&drive
let drive = (floor(trial / 16) - 2*floor(trial / 32))*1.8
alter VB4 = $&drive
let drive = (floor(trial / 32) - 2*floor(trial / 64))*1.8
alter VB5 = $&drive
let drive = (floor(trial / 64) - 2*floor(trial / 128))*1.8
alter VB6 = $&drive
let drive = (floor(trial / 128) - 2*floor(trial / 256))*1.8
alter VB7 = $&drive
stop when time = 0.003812
resume
delete all
let endpoint = length(time)-1
let cmp = v(COMP)[endpoint]
let top = v(TOP)[endpoint]
let decision = 0
if cmp >= 0.9
let code = trial
let decision = 1
end
echo 211 2 $&trial $&cmp $&top 0.97734375 $&decision >> decisions.csv
let trial = code + 2
let drive = (floor(trial / 1) - 2*floor(trial / 2))*1.8
alter VB0 = $&drive
let drive = (floor(trial / 2) - 2*floor(trial / 4))*1.8
alter VB1 = $&drive
let drive = (floor(trial / 4) - 2*floor(trial / 8))*1.8
alter VB2 = $&drive
let drive = (floor(trial / 8) - 2*floor(trial / 16))*1.8
alter VB3 = $&drive
let drive = (floor(trial / 16) - 2*floor(trial / 32))*1.8
alter VB4 = $&drive
let drive = (floor(trial / 32) - 2*floor(trial / 64))*1.8
alter VB5 = $&drive
let drive = (floor(trial / 64) - 2*floor(trial / 128))*1.8
alter VB6 = $&drive
let drive = (floor(trial / 128) - 2*floor(trial / 256))*1.8
alter VB7 = $&drive
stop when time = 0.003814
resume
delete all
let endpoint = length(time)-1
let cmp = v(COMP)[endpoint]
let top = v(TOP)[endpoint]
let decision = 0
if cmp >= 0.9
let code = trial
let decision = 1
end
echo 211 1 $&trial $&cmp $&top 0.97734375 $&decision >> decisions.csv
let trial = code + 1
let drive = (floor(trial / 1) - 2*floor(trial / 2))*1.8
alter VB0 = $&drive
let drive = (floor(trial / 2) - 2*floor(trial / 4))*1.8
alter VB1 = $&drive
let drive = (floor(trial / 4) - 2*floor(trial / 8))*1.8
alter VB2 = $&drive
let drive = (floor(trial / 8) - 2*floor(trial / 16))*1.8
alter VB3 = $&drive
let drive = (floor(trial / 16) - 2*floor(trial / 32))*1.8
alter VB4 = $&drive
let drive = (floor(trial / 32) - 2*floor(trial / 64))*1.8
alter VB5 = $&drive
let drive = (floor(trial / 64) - 2*floor(trial / 128))*1.8
alter VB6 = $&drive
let drive = (floor(trial / 128) - 2*floor(trial / 256))*1.8
alter VB7 = $&drive
stop when time = 0.003816
resume
delete all
let endpoint = length(time)-1
let cmp = v(COMP)[endpoint]
let top = v(TOP)[endpoint]
let decision = 0
if cmp >= 0.9
let code = trial
let decision = 1
end
echo 211 0 $&trial $&cmp $&top 0.97734375 $&decision >> decisions.csv
alter VIN = 0.98203125
alter VSAMPLE = 1.8
alter VB0 = 0
alter VB1 = 0
alter VB2 = 0
alter VB3 = 0
alter VB4 = 0
alter VB5 = 0
alter VB6 = 0
alter VB7 = 0
let code = 0
stop when time = 0.003818
resume
delete all
alter VSAMPLE = 0
let trial = code + 128
let drive = (floor(trial / 1) - 2*floor(trial / 2))*1.8
alter VB0 = $&drive
let drive = (floor(trial / 2) - 2*floor(trial / 4))*1.8
alter VB1 = $&drive
let drive = (floor(trial / 4) - 2*floor(trial / 8))*1.8
alter VB2 = $&drive
let drive = (floor(trial / 8) - 2*floor(trial / 16))*1.8
alter VB3 = $&drive
let drive = (floor(trial / 16) - 2*floor(trial / 32))*1.8
alter VB4 = $&drive
let drive = (floor(trial / 32) - 2*floor(trial / 64))*1.8
alter VB5 = $&drive
let drive = (floor(trial / 64) - 2*floor(trial / 128))*1.8
alter VB6 = $&drive
let drive = (floor(trial / 128) - 2*floor(trial / 256))*1.8
alter VB7 = $&drive
stop when time = 0.00382
resume
delete all
let endpoint = length(time)-1
let cmp = v(COMP)[endpoint]
let top = v(TOP)[endpoint]
let decision = 0
if cmp >= 0.9
let code = trial
let decision = 1
end
echo 212 7 $&trial $&cmp $&top 0.98203125 $&decision >> decisions.csv
let trial = code + 64
let drive = (floor(trial / 1) - 2*floor(trial / 2))*1.8
alter VB0 = $&drive
let drive = (floor(trial / 2) - 2*floor(trial / 4))*1.8
alter VB1 = $&drive
let drive = (floor(trial / 4) - 2*floor(trial / 8))*1.8
alter VB2 = $&drive
let drive = (floor(trial / 8) - 2*floor(trial / 16))*1.8
alter VB3 = $&drive
let drive = (floor(trial / 16) - 2*floor(trial / 32))*1.8
alter VB4 = $&drive
let drive = (floor(trial / 32) - 2*floor(trial / 64))*1.8
alter VB5 = $&drive
let drive = (floor(trial / 64) - 2*floor(trial / 128))*1.8
alter VB6 = $&drive
let drive = (floor(trial / 128) - 2*floor(trial / 256))*1.8
alter VB7 = $&drive
stop when time = 0.003822
resume
delete all
let endpoint = length(time)-1
let cmp = v(COMP)[endpoint]
let top = v(TOP)[endpoint]
let decision = 0
if cmp >= 0.9
let code = trial
let decision = 1
end
echo 212 6 $&trial $&cmp $&top 0.98203125 $&decision >> decisions.csv
let trial = code + 32
let drive = (floor(trial / 1) - 2*floor(trial / 2))*1.8
alter VB0 = $&drive
let drive = (floor(trial / 2) - 2*floor(trial / 4))*1.8
alter VB1 = $&drive
let drive = (floor(trial / 4) - 2*floor(trial / 8))*1.8
alter VB2 = $&drive
let drive = (floor(trial / 8) - 2*floor(trial / 16))*1.8
alter VB3 = $&drive
let drive = (floor(trial / 16) - 2*floor(trial / 32))*1.8
alter VB4 = $&drive
let drive = (floor(trial / 32) - 2*floor(trial / 64))*1.8
alter VB5 = $&drive
let drive = (floor(trial / 64) - 2*floor(trial / 128))*1.8
alter VB6 = $&drive
let drive = (floor(trial / 128) - 2*floor(trial / 256))*1.8
alter VB7 = $&drive
stop when time = 0.003824
resume
delete all
let endpoint = length(time)-1
let cmp = v(COMP)[endpoint]
let top = v(TOP)[endpoint]
let decision = 0
if cmp >= 0.9
let code = trial
let decision = 1
end
echo 212 5 $&trial $&cmp $&top 0.98203125 $&decision >> decisions.csv
let trial = code + 16
let drive = (floor(trial / 1) - 2*floor(trial / 2))*1.8
alter VB0 = $&drive
let drive = (floor(trial / 2) - 2*floor(trial / 4))*1.8
alter VB1 = $&drive
let drive = (floor(trial / 4) - 2*floor(trial / 8))*1.8
alter VB2 = $&drive
let drive = (floor(trial / 8) - 2*floor(trial / 16))*1.8
alter VB3 = $&drive
let drive = (floor(trial / 16) - 2*floor(trial / 32))*1.8
alter VB4 = $&drive
let drive = (floor(trial / 32) - 2*floor(trial / 64))*1.8
alter VB5 = $&drive
let drive = (floor(trial / 64) - 2*floor(trial / 128))*1.8
alter VB6 = $&drive
let drive = (floor(trial / 128) - 2*floor(trial / 256))*1.8
alter VB7 = $&drive
stop when time = 0.003826
resume
delete all
let endpoint = length(time)-1
let cmp = v(COMP)[endpoint]
let top = v(TOP)[endpoint]
let decision = 0
if cmp >= 0.9
let code = trial
let decision = 1
end
echo 212 4 $&trial $&cmp $&top 0.98203125 $&decision >> decisions.csv
let trial = code + 8
let drive = (floor(trial / 1) - 2*floor(trial / 2))*1.8
alter VB0 = $&drive
let drive = (floor(trial / 2) - 2*floor(trial / 4))*1.8
alter VB1 = $&drive
let drive = (floor(trial / 4) - 2*floor(trial / 8))*1.8
alter VB2 = $&drive
let drive = (floor(trial / 8) - 2*floor(trial / 16))*1.8
alter VB3 = $&drive
let drive = (floor(trial / 16) - 2*floor(trial / 32))*1.8
alter VB4 = $&drive
let drive = (floor(trial / 32) - 2*floor(trial / 64))*1.8
alter VB5 = $&drive
let drive = (floor(trial / 64) - 2*floor(trial / 128))*1.8
alter VB6 = $&drive
let drive = (floor(trial / 128) - 2*floor(trial / 256))*1.8
alter VB7 = $&drive
stop when time = 0.003828
resume
delete all
let endpoint = length(time)-1
let cmp = v(COMP)[endpoint]
let top = v(TOP)[endpoint]
let decision = 0
if cmp >= 0.9
let code = trial
let decision = 1
end
echo 212 3 $&trial $&cmp $&top 0.98203125 $&decision >> decisions.csv
let trial = code + 4
let drive = (floor(trial / 1) - 2*floor(trial / 2))*1.8
alter VB0 = $&drive
let drive = (floor(trial / 2) - 2*floor(trial / 4))*1.8
alter VB1 = $&drive
let drive = (floor(trial / 4) - 2*floor(trial / 8))*1.8
alter VB2 = $&drive
let drive = (floor(trial / 8) - 2*floor(trial / 16))*1.8
alter VB3 = $&drive
let drive = (floor(trial / 16) - 2*floor(trial / 32))*1.8
alter VB4 = $&drive
let drive = (floor(trial / 32) - 2*floor(trial / 64))*1.8
alter VB5 = $&drive
let drive = (floor(trial / 64) - 2*floor(trial / 128))*1.8
alter VB6 = $&drive
let drive = (floor(trial / 128) - 2*floor(trial / 256))*1.8
alter VB7 = $&drive
stop when time = 0.00383
resume
delete all
let endpoint = length(time)-1
let cmp = v(COMP)[endpoint]
let top = v(TOP)[endpoint]
let decision = 0
if cmp >= 0.9
let code = trial
let decision = 1
end
echo 212 2 $&trial $&cmp $&top 0.98203125 $&decision >> decisions.csv
let trial = code + 2
let drive = (floor(trial / 1) - 2*floor(trial / 2))*1.8
alter VB0 = $&drive
let drive = (floor(trial / 2) - 2*floor(trial / 4))*1.8
alter VB1 = $&drive
let drive = (floor(trial / 4) - 2*floor(trial / 8))*1.8
alter VB2 = $&drive
let drive = (floor(trial / 8) - 2*floor(trial / 16))*1.8
alter VB3 = $&drive
let drive = (floor(trial / 16) - 2*floor(trial / 32))*1.8
alter VB4 = $&drive
let drive = (floor(trial / 32) - 2*floor(trial / 64))*1.8
alter VB5 = $&drive
let drive = (floor(trial / 64) - 2*floor(trial / 128))*1.8
alter VB6 = $&drive
let drive = (floor(trial / 128) - 2*floor(trial / 256))*1.8
alter VB7 = $&drive
stop when time = 0.003832
resume
delete all
let endpoint = length(time)-1
let cmp = v(COMP)[endpoint]
let top = v(TOP)[endpoint]
let decision = 0
if cmp >= 0.9
let code = trial
let decision = 1
end
echo 212 1 $&trial $&cmp $&top 0.98203125 $&decision >> decisions.csv
let trial = code + 1
let drive = (floor(trial / 1) - 2*floor(trial / 2))*1.8
alter VB0 = $&drive
let drive = (floor(trial / 2) - 2*floor(trial / 4))*1.8
alter VB1 = $&drive
let drive = (floor(trial / 4) - 2*floor(trial / 8))*1.8
alter VB2 = $&drive
let drive = (floor(trial / 8) - 2*floor(trial / 16))*1.8
alter VB3 = $&drive
let drive = (floor(trial / 16) - 2*floor(trial / 32))*1.8
alter VB4 = $&drive
let drive = (floor(trial / 32) - 2*floor(trial / 64))*1.8
alter VB5 = $&drive
let drive = (floor(trial / 64) - 2*floor(trial / 128))*1.8
alter VB6 = $&drive
let drive = (floor(trial / 128) - 2*floor(trial / 256))*1.8
alter VB7 = $&drive
stop when time = 0.003834
resume
delete all
let endpoint = length(time)-1
let cmp = v(COMP)[endpoint]
let top = v(TOP)[endpoint]
let decision = 0
if cmp >= 0.9
let code = trial
let decision = 1
end
echo 212 0 $&trial $&cmp $&top 0.98203125 $&decision >> decisions.csv
alter VIN = 0.98671875
alter VSAMPLE = 1.8
alter VB0 = 0
alter VB1 = 0
alter VB2 = 0
alter VB3 = 0
alter VB4 = 0
alter VB5 = 0
alter VB6 = 0
alter VB7 = 0
let code = 0
stop when time = 0.003836
resume
delete all
alter VSAMPLE = 0
let trial = code + 128
let drive = (floor(trial / 1) - 2*floor(trial / 2))*1.8
alter VB0 = $&drive
let drive = (floor(trial / 2) - 2*floor(trial / 4))*1.8
alter VB1 = $&drive
let drive = (floor(trial / 4) - 2*floor(trial / 8))*1.8
alter VB2 = $&drive
let drive = (floor(trial / 8) - 2*floor(trial / 16))*1.8
alter VB3 = $&drive
let drive = (floor(trial / 16) - 2*floor(trial / 32))*1.8
alter VB4 = $&drive
let drive = (floor(trial / 32) - 2*floor(trial / 64))*1.8
alter VB5 = $&drive
let drive = (floor(trial / 64) - 2*floor(trial / 128))*1.8
alter VB6 = $&drive
let drive = (floor(trial / 128) - 2*floor(trial / 256))*1.8
alter VB7 = $&drive
stop when time = 0.003838
resume
delete all
let endpoint = length(time)-1
let cmp = v(COMP)[endpoint]
let top = v(TOP)[endpoint]
let decision = 0
if cmp >= 0.9
let code = trial
let decision = 1
end
echo 213 7 $&trial $&cmp $&top 0.98671875 $&decision >> decisions.csv
let trial = code + 64
let drive = (floor(trial / 1) - 2*floor(trial / 2))*1.8
alter VB0 = $&drive
let drive = (floor(trial / 2) - 2*floor(trial / 4))*1.8
alter VB1 = $&drive
let drive = (floor(trial / 4) - 2*floor(trial / 8))*1.8
alter VB2 = $&drive
let drive = (floor(trial / 8) - 2*floor(trial / 16))*1.8
alter VB3 = $&drive
let drive = (floor(trial / 16) - 2*floor(trial / 32))*1.8
alter VB4 = $&drive
let drive = (floor(trial / 32) - 2*floor(trial / 64))*1.8
alter VB5 = $&drive
let drive = (floor(trial / 64) - 2*floor(trial / 128))*1.8
alter VB6 = $&drive
let drive = (floor(trial / 128) - 2*floor(trial / 256))*1.8
alter VB7 = $&drive
stop when time = 0.00384
resume
delete all
let endpoint = length(time)-1
let cmp = v(COMP)[endpoint]
let top = v(TOP)[endpoint]
let decision = 0
if cmp >= 0.9
let code = trial
let decision = 1
end
echo 213 6 $&trial $&cmp $&top 0.98671875 $&decision >> decisions.csv
let trial = code + 32
let drive = (floor(trial / 1) - 2*floor(trial / 2))*1.8
alter VB0 = $&drive
let drive = (floor(trial / 2) - 2*floor(trial / 4))*1.8
alter VB1 = $&drive
let drive = (floor(trial / 4) - 2*floor(trial / 8))*1.8
alter VB2 = $&drive
let drive = (floor(trial / 8) - 2*floor(trial / 16))*1.8
alter VB3 = $&drive
let drive = (floor(trial / 16) - 2*floor(trial / 32))*1.8
alter VB4 = $&drive
let drive = (floor(trial / 32) - 2*floor(trial / 64))*1.8
alter VB5 = $&drive
let drive = (floor(trial / 64) - 2*floor(trial / 128))*1.8
alter VB6 = $&drive
let drive = (floor(trial / 128) - 2*floor(trial / 256))*1.8
alter VB7 = $&drive
stop when time = 0.003842
resume
delete all
let endpoint = length(time)-1
let cmp = v(COMP)[endpoint]
let top = v(TOP)[endpoint]
let decision = 0
if cmp >= 0.9
let code = trial
let decision = 1
end
echo 213 5 $&trial $&cmp $&top 0.98671875 $&decision >> decisions.csv
let trial = code + 16
let drive = (floor(trial / 1) - 2*floor(trial / 2))*1.8
alter VB0 = $&drive
let drive = (floor(trial / 2) - 2*floor(trial / 4))*1.8
alter VB1 = $&drive
let drive = (floor(trial / 4) - 2*floor(trial / 8))*1.8
alter VB2 = $&drive
let drive = (floor(trial / 8) - 2*floor(trial / 16))*1.8
alter VB3 = $&drive
let drive = (floor(trial / 16) - 2*floor(trial / 32))*1.8
alter VB4 = $&drive
let drive = (floor(trial / 32) - 2*floor(trial / 64))*1.8
alter VB5 = $&drive
let drive = (floor(trial / 64) - 2*floor(trial / 128))*1.8
alter VB6 = $&drive
let drive = (floor(trial / 128) - 2*floor(trial / 256))*1.8
alter VB7 = $&drive
stop when time = 0.003844
resume
delete all
let endpoint = length(time)-1
let cmp = v(COMP)[endpoint]
let top = v(TOP)[endpoint]
let decision = 0
if cmp >= 0.9
let code = trial
let decision = 1
end
echo 213 4 $&trial $&cmp $&top 0.98671875 $&decision >> decisions.csv
let trial = code + 8
let drive = (floor(trial / 1) - 2*floor(trial / 2))*1.8
alter VB0 = $&drive
let drive = (floor(trial / 2) - 2*floor(trial / 4))*1.8
alter VB1 = $&drive
let drive = (floor(trial / 4) - 2*floor(trial / 8))*1.8
alter VB2 = $&drive
let drive = (floor(trial / 8) - 2*floor(trial / 16))*1.8
alter VB3 = $&drive
let drive = (floor(trial / 16) - 2*floor(trial / 32))*1.8
alter VB4 = $&drive
let drive = (floor(trial / 32) - 2*floor(trial / 64))*1.8
alter VB5 = $&drive
let drive = (floor(trial / 64) - 2*floor(trial / 128))*1.8
alter VB6 = $&drive
let drive = (floor(trial / 128) - 2*floor(trial / 256))*1.8
alter VB7 = $&drive
stop when time = 0.003846
resume
delete all
let endpoint = length(time)-1
let cmp = v(COMP)[endpoint]
let top = v(TOP)[endpoint]
let decision = 0
if cmp >= 0.9
let code = trial
let decision = 1
end
echo 213 3 $&trial $&cmp $&top 0.98671875 $&decision >> decisions.csv
let trial = code + 4
let drive = (floor(trial / 1) - 2*floor(trial / 2))*1.8
alter VB0 = $&drive
let drive = (floor(trial / 2) - 2*floor(trial / 4))*1.8
alter VB1 = $&drive
let drive = (floor(trial / 4) - 2*floor(trial / 8))*1.8
alter VB2 = $&drive
let drive = (floor(trial / 8) - 2*floor(trial / 16))*1.8
alter VB3 = $&drive
let drive = (floor(trial / 16) - 2*floor(trial / 32))*1.8
alter VB4 = $&drive
let drive = (floor(trial / 32) - 2*floor(trial / 64))*1.8
alter VB5 = $&drive
let drive = (floor(trial / 64) - 2*floor(trial / 128))*1.8
alter VB6 = $&drive
let drive = (floor(trial / 128) - 2*floor(trial / 256))*1.8
alter VB7 = $&drive
stop when time = 0.003848
resume
delete all
let endpoint = length(time)-1
let cmp = v(COMP)[endpoint]
let top = v(TOP)[endpoint]
let decision = 0
if cmp >= 0.9
let code = trial
let decision = 1
end
echo 213 2 $&trial $&cmp $&top 0.98671875 $&decision >> decisions.csv
let trial = code + 2
let drive = (floor(trial / 1) - 2*floor(trial / 2))*1.8
alter VB0 = $&drive
let drive = (floor(trial / 2) - 2*floor(trial / 4))*1.8
alter VB1 = $&drive
let drive = (floor(trial / 4) - 2*floor(trial / 8))*1.8
alter VB2 = $&drive
let drive = (floor(trial / 8) - 2*floor(trial / 16))*1.8
alter VB3 = $&drive
let drive = (floor(trial / 16) - 2*floor(trial / 32))*1.8
alter VB4 = $&drive
let drive = (floor(trial / 32) - 2*floor(trial / 64))*1.8
alter VB5 = $&drive
let drive = (floor(trial / 64) - 2*floor(trial / 128))*1.8
alter VB6 = $&drive
let drive = (floor(trial / 128) - 2*floor(trial / 256))*1.8
alter VB7 = $&drive
stop when time = 0.00385
resume
delete all
let endpoint = length(time)-1
let cmp = v(COMP)[endpoint]
let top = v(TOP)[endpoint]
let decision = 0
if cmp >= 0.9
let code = trial
let decision = 1
end
echo 213 1 $&trial $&cmp $&top 0.98671875 $&decision >> decisions.csv
let trial = code + 1
let drive = (floor(trial / 1) - 2*floor(trial / 2))*1.8
alter VB0 = $&drive
let drive = (floor(trial / 2) - 2*floor(trial / 4))*1.8
alter VB1 = $&drive
let drive = (floor(trial / 4) - 2*floor(trial / 8))*1.8
alter VB2 = $&drive
let drive = (floor(trial / 8) - 2*floor(trial / 16))*1.8
alter VB3 = $&drive
let drive = (floor(trial / 16) - 2*floor(trial / 32))*1.8
alter VB4 = $&drive
let drive = (floor(trial / 32) - 2*floor(trial / 64))*1.8
alter VB5 = $&drive
let drive = (floor(trial / 64) - 2*floor(trial / 128))*1.8
alter VB6 = $&drive
let drive = (floor(trial / 128) - 2*floor(trial / 256))*1.8
alter VB7 = $&drive
stop when time = 0.003852
resume
delete all
let endpoint = length(time)-1
let cmp = v(COMP)[endpoint]
let top = v(TOP)[endpoint]
let decision = 0
if cmp >= 0.9
let code = trial
let decision = 1
end
echo 213 0 $&trial $&cmp $&top 0.98671875 $&decision >> decisions.csv
alter VIN = 0.99140625
alter VSAMPLE = 1.8
alter VB0 = 0
alter VB1 = 0
alter VB2 = 0
alter VB3 = 0
alter VB4 = 0
alter VB5 = 0
alter VB6 = 0
alter VB7 = 0
let code = 0
stop when time = 0.003854
resume
delete all
alter VSAMPLE = 0
let trial = code + 128
let drive = (floor(trial / 1) - 2*floor(trial / 2))*1.8
alter VB0 = $&drive
let drive = (floor(trial / 2) - 2*floor(trial / 4))*1.8
alter VB1 = $&drive
let drive = (floor(trial / 4) - 2*floor(trial / 8))*1.8
alter VB2 = $&drive
let drive = (floor(trial / 8) - 2*floor(trial / 16))*1.8
alter VB3 = $&drive
let drive = (floor(trial / 16) - 2*floor(trial / 32))*1.8
alter VB4 = $&drive
let drive = (floor(trial / 32) - 2*floor(trial / 64))*1.8
alter VB5 = $&drive
let drive = (floor(trial / 64) - 2*floor(trial / 128))*1.8
alter VB6 = $&drive
let drive = (floor(trial / 128) - 2*floor(trial / 256))*1.8
alter VB7 = $&drive
stop when time = 0.003856
resume
delete all
let endpoint = length(time)-1
let cmp = v(COMP)[endpoint]
let top = v(TOP)[endpoint]
let decision = 0
if cmp >= 0.9
let code = trial
let decision = 1
end
echo 214 7 $&trial $&cmp $&top 0.99140625 $&decision >> decisions.csv
let trial = code + 64
let drive = (floor(trial / 1) - 2*floor(trial / 2))*1.8
alter VB0 = $&drive
let drive = (floor(trial / 2) - 2*floor(trial / 4))*1.8
alter VB1 = $&drive
let drive = (floor(trial / 4) - 2*floor(trial / 8))*1.8
alter VB2 = $&drive
let drive = (floor(trial / 8) - 2*floor(trial / 16))*1.8
alter VB3 = $&drive
let drive = (floor(trial / 16) - 2*floor(trial / 32))*1.8
alter VB4 = $&drive
let drive = (floor(trial / 32) - 2*floor(trial / 64))*1.8
alter VB5 = $&drive
let drive = (floor(trial / 64) - 2*floor(trial / 128))*1.8
alter VB6 = $&drive
let drive = (floor(trial / 128) - 2*floor(trial / 256))*1.8
alter VB7 = $&drive
stop when time = 0.003858
resume
delete all
let endpoint = length(time)-1
let cmp = v(COMP)[endpoint]
let top = v(TOP)[endpoint]
let decision = 0
if cmp >= 0.9
let code = trial
let decision = 1
end
echo 214 6 $&trial $&cmp $&top 0.99140625 $&decision >> decisions.csv
let trial = code + 32
let drive = (floor(trial / 1) - 2*floor(trial / 2))*1.8
alter VB0 = $&drive
let drive = (floor(trial / 2) - 2*floor(trial / 4))*1.8
alter VB1 = $&drive
let drive = (floor(trial / 4) - 2*floor(trial / 8))*1.8
alter VB2 = $&drive
let drive = (floor(trial / 8) - 2*floor(trial / 16))*1.8
alter VB3 = $&drive
let drive = (floor(trial / 16) - 2*floor(trial / 32))*1.8
alter VB4 = $&drive
let drive = (floor(trial / 32) - 2*floor(trial / 64))*1.8
alter VB5 = $&drive
let drive = (floor(trial / 64) - 2*floor(trial / 128))*1.8
alter VB6 = $&drive
let drive = (floor(trial / 128) - 2*floor(trial / 256))*1.8
alter VB7 = $&drive
stop when time = 0.00386
resume
delete all
let endpoint = length(time)-1
let cmp = v(COMP)[endpoint]
let top = v(TOP)[endpoint]
let decision = 0
if cmp >= 0.9
let code = trial
let decision = 1
end
echo 214 5 $&trial $&cmp $&top 0.99140625 $&decision >> decisions.csv
let trial = code + 16
let drive = (floor(trial / 1) - 2*floor(trial / 2))*1.8
alter VB0 = $&drive
let drive = (floor(trial / 2) - 2*floor(trial / 4))*1.8
alter VB1 = $&drive
let drive = (floor(trial / 4) - 2*floor(trial / 8))*1.8
alter VB2 = $&drive
let drive = (floor(trial / 8) - 2*floor(trial / 16))*1.8
alter VB3 = $&drive
let drive = (floor(trial / 16) - 2*floor(trial / 32))*1.8
alter VB4 = $&drive
let drive = (floor(trial / 32) - 2*floor(trial / 64))*1.8
alter VB5 = $&drive
let drive = (floor(trial / 64) - 2*floor(trial / 128))*1.8
alter VB6 = $&drive
let drive = (floor(trial / 128) - 2*floor(trial / 256))*1.8
alter VB7 = $&drive
stop when time = 0.003862
resume
delete all
let endpoint = length(time)-1
let cmp = v(COMP)[endpoint]
let top = v(TOP)[endpoint]
let decision = 0
if cmp >= 0.9
let code = trial
let decision = 1
end
echo 214 4 $&trial $&cmp $&top 0.99140625 $&decision >> decisions.csv
let trial = code + 8
let drive = (floor(trial / 1) - 2*floor(trial / 2))*1.8
alter VB0 = $&drive
let drive = (floor(trial / 2) - 2*floor(trial / 4))*1.8
alter VB1 = $&drive
let drive = (floor(trial / 4) - 2*floor(trial / 8))*1.8
alter VB2 = $&drive
let drive = (floor(trial / 8) - 2*floor(trial / 16))*1.8
alter VB3 = $&drive
let drive = (floor(trial / 16) - 2*floor(trial / 32))*1.8
alter VB4 = $&drive
let drive = (floor(trial / 32) - 2*floor(trial / 64))*1.8
alter VB5 = $&drive
let drive = (floor(trial / 64) - 2*floor(trial / 128))*1.8
alter VB6 = $&drive
let drive = (floor(trial / 128) - 2*floor(trial / 256))*1.8
alter VB7 = $&drive
stop when time = 0.003864
resume
delete all
let endpoint = length(time)-1
let cmp = v(COMP)[endpoint]
let top = v(TOP)[endpoint]
let decision = 0
if cmp >= 0.9
let code = trial
let decision = 1
end
echo 214 3 $&trial $&cmp $&top 0.99140625 $&decision >> decisions.csv
let trial = code + 4
let drive = (floor(trial / 1) - 2*floor(trial / 2))*1.8
alter VB0 = $&drive
let drive = (floor(trial / 2) - 2*floor(trial / 4))*1.8
alter VB1 = $&drive
let drive = (floor(trial / 4) - 2*floor(trial / 8))*1.8
alter VB2 = $&drive
let drive = (floor(trial / 8) - 2*floor(trial / 16))*1.8
alter VB3 = $&drive
let drive = (floor(trial / 16) - 2*floor(trial / 32))*1.8
alter VB4 = $&drive
let drive = (floor(trial / 32) - 2*floor(trial / 64))*1.8
alter VB5 = $&drive
let drive = (floor(trial / 64) - 2*floor(trial / 128))*1.8
alter VB6 = $&drive
let drive = (floor(trial / 128) - 2*floor(trial / 256))*1.8
alter VB7 = $&drive
stop when time = 0.003866
resume
delete all
let endpoint = length(time)-1
let cmp = v(COMP)[endpoint]
let top = v(TOP)[endpoint]
let decision = 0
if cmp >= 0.9
let code = trial
let decision = 1
end
echo 214 2 $&trial $&cmp $&top 0.99140625 $&decision >> decisions.csv
let trial = code + 2
let drive = (floor(trial / 1) - 2*floor(trial / 2))*1.8
alter VB0 = $&drive
let drive = (floor(trial / 2) - 2*floor(trial / 4))*1.8
alter VB1 = $&drive
let drive = (floor(trial / 4) - 2*floor(trial / 8))*1.8
alter VB2 = $&drive
let drive = (floor(trial / 8) - 2*floor(trial / 16))*1.8
alter VB3 = $&drive
let drive = (floor(trial / 16) - 2*floor(trial / 32))*1.8
alter VB4 = $&drive
let drive = (floor(trial / 32) - 2*floor(trial / 64))*1.8
alter VB5 = $&drive
let drive = (floor(trial / 64) - 2*floor(trial / 128))*1.8
alter VB6 = $&drive
let drive = (floor(trial / 128) - 2*floor(trial / 256))*1.8
alter VB7 = $&drive
stop when time = 0.003868
resume
delete all
let endpoint = length(time)-1
let cmp = v(COMP)[endpoint]
let top = v(TOP)[endpoint]
let decision = 0
if cmp >= 0.9
let code = trial
let decision = 1
end
echo 214 1 $&trial $&cmp $&top 0.99140625 $&decision >> decisions.csv
let trial = code + 1
let drive = (floor(trial / 1) - 2*floor(trial / 2))*1.8
alter VB0 = $&drive
let drive = (floor(trial / 2) - 2*floor(trial / 4))*1.8
alter VB1 = $&drive
let drive = (floor(trial / 4) - 2*floor(trial / 8))*1.8
alter VB2 = $&drive
let drive = (floor(trial / 8) - 2*floor(trial / 16))*1.8
alter VB3 = $&drive
let drive = (floor(trial / 16) - 2*floor(trial / 32))*1.8
alter VB4 = $&drive
let drive = (floor(trial / 32) - 2*floor(trial / 64))*1.8
alter VB5 = $&drive
let drive = (floor(trial / 64) - 2*floor(trial / 128))*1.8
alter VB6 = $&drive
let drive = (floor(trial / 128) - 2*floor(trial / 256))*1.8
alter VB7 = $&drive
stop when time = 0.00387
resume
delete all
let endpoint = length(time)-1
let cmp = v(COMP)[endpoint]
let top = v(TOP)[endpoint]
let decision = 0
if cmp >= 0.9
let code = trial
let decision = 1
end
echo 214 0 $&trial $&cmp $&top 0.99140625 $&decision >> decisions.csv
alter VIN = 0.99609375
alter VSAMPLE = 1.8
alter VB0 = 0
alter VB1 = 0
alter VB2 = 0
alter VB3 = 0
alter VB4 = 0
alter VB5 = 0
alter VB6 = 0
alter VB7 = 0
let code = 0
stop when time = 0.003872
resume
delete all
alter VSAMPLE = 0
let trial = code + 128
let drive = (floor(trial / 1) - 2*floor(trial / 2))*1.8
alter VB0 = $&drive
let drive = (floor(trial / 2) - 2*floor(trial / 4))*1.8
alter VB1 = $&drive
let drive = (floor(trial / 4) - 2*floor(trial / 8))*1.8
alter VB2 = $&drive
let drive = (floor(trial / 8) - 2*floor(trial / 16))*1.8
alter VB3 = $&drive
let drive = (floor(trial / 16) - 2*floor(trial / 32))*1.8
alter VB4 = $&drive
let drive = (floor(trial / 32) - 2*floor(trial / 64))*1.8
alter VB5 = $&drive
let drive = (floor(trial / 64) - 2*floor(trial / 128))*1.8
alter VB6 = $&drive
let drive = (floor(trial / 128) - 2*floor(trial / 256))*1.8
alter VB7 = $&drive
stop when time = 0.003874
resume
delete all
let endpoint = length(time)-1
let cmp = v(COMP)[endpoint]
let top = v(TOP)[endpoint]
let decision = 0
if cmp >= 0.9
let code = trial
let decision = 1
end
echo 215 7 $&trial $&cmp $&top 0.99609375 $&decision >> decisions.csv
let trial = code + 64
let drive = (floor(trial / 1) - 2*floor(trial / 2))*1.8
alter VB0 = $&drive
let drive = (floor(trial / 2) - 2*floor(trial / 4))*1.8
alter VB1 = $&drive
let drive = (floor(trial / 4) - 2*floor(trial / 8))*1.8
alter VB2 = $&drive
let drive = (floor(trial / 8) - 2*floor(trial / 16))*1.8
alter VB3 = $&drive
let drive = (floor(trial / 16) - 2*floor(trial / 32))*1.8
alter VB4 = $&drive
let drive = (floor(trial / 32) - 2*floor(trial / 64))*1.8
alter VB5 = $&drive
let drive = (floor(trial / 64) - 2*floor(trial / 128))*1.8
alter VB6 = $&drive
let drive = (floor(trial / 128) - 2*floor(trial / 256))*1.8
alter VB7 = $&drive
stop when time = 0.003876
resume
delete all
let endpoint = length(time)-1
let cmp = v(COMP)[endpoint]
let top = v(TOP)[endpoint]
let decision = 0
if cmp >= 0.9
let code = trial
let decision = 1
end
echo 215 6 $&trial $&cmp $&top 0.99609375 $&decision >> decisions.csv
let trial = code + 32
let drive = (floor(trial / 1) - 2*floor(trial / 2))*1.8
alter VB0 = $&drive
let drive = (floor(trial / 2) - 2*floor(trial / 4))*1.8
alter VB1 = $&drive
let drive = (floor(trial / 4) - 2*floor(trial / 8))*1.8
alter VB2 = $&drive
let drive = (floor(trial / 8) - 2*floor(trial / 16))*1.8
alter VB3 = $&drive
let drive = (floor(trial / 16) - 2*floor(trial / 32))*1.8
alter VB4 = $&drive
let drive = (floor(trial / 32) - 2*floor(trial / 64))*1.8
alter VB5 = $&drive
let drive = (floor(trial / 64) - 2*floor(trial / 128))*1.8
alter VB6 = $&drive
let drive = (floor(trial / 128) - 2*floor(trial / 256))*1.8
alter VB7 = $&drive
stop when time = 0.003878
resume
delete all
let endpoint = length(time)-1
let cmp = v(COMP)[endpoint]
let top = v(TOP)[endpoint]
let decision = 0
if cmp >= 0.9
let code = trial
let decision = 1
end
echo 215 5 $&trial $&cmp $&top 0.99609375 $&decision >> decisions.csv
let trial = code + 16
let drive = (floor(trial / 1) - 2*floor(trial / 2))*1.8
alter VB0 = $&drive
let drive = (floor(trial / 2) - 2*floor(trial / 4))*1.8
alter VB1 = $&drive
let drive = (floor(trial / 4) - 2*floor(trial / 8))*1.8
alter VB2 = $&drive
let drive = (floor(trial / 8) - 2*floor(trial / 16))*1.8
alter VB3 = $&drive
let drive = (floor(trial / 16) - 2*floor(trial / 32))*1.8
alter VB4 = $&drive
let drive = (floor(trial / 32) - 2*floor(trial / 64))*1.8
alter VB5 = $&drive
let drive = (floor(trial / 64) - 2*floor(trial / 128))*1.8
alter VB6 = $&drive
let drive = (floor(trial / 128) - 2*floor(trial / 256))*1.8
alter VB7 = $&drive
stop when time = 0.00388
resume
delete all
let endpoint = length(time)-1
let cmp = v(COMP)[endpoint]
let top = v(TOP)[endpoint]
let decision = 0
if cmp >= 0.9
let code = trial
let decision = 1
end
echo 215 4 $&trial $&cmp $&top 0.99609375 $&decision >> decisions.csv
let trial = code + 8
let drive = (floor(trial / 1) - 2*floor(trial / 2))*1.8
alter VB0 = $&drive
let drive = (floor(trial / 2) - 2*floor(trial / 4))*1.8
alter VB1 = $&drive
let drive = (floor(trial / 4) - 2*floor(trial / 8))*1.8
alter VB2 = $&drive
let drive = (floor(trial / 8) - 2*floor(trial / 16))*1.8
alter VB3 = $&drive
let drive = (floor(trial / 16) - 2*floor(trial / 32))*1.8
alter VB4 = $&drive
let drive = (floor(trial / 32) - 2*floor(trial / 64))*1.8
alter VB5 = $&drive
let drive = (floor(trial / 64) - 2*floor(trial / 128))*1.8
alter VB6 = $&drive
let drive = (floor(trial / 128) - 2*floor(trial / 256))*1.8
alter VB7 = $&drive
stop when time = 0.003882
resume
delete all
let endpoint = length(time)-1
let cmp = v(COMP)[endpoint]
let top = v(TOP)[endpoint]
let decision = 0
if cmp >= 0.9
let code = trial
let decision = 1
end
echo 215 3 $&trial $&cmp $&top 0.99609375 $&decision >> decisions.csv
let trial = code + 4
let drive = (floor(trial / 1) - 2*floor(trial / 2))*1.8
alter VB0 = $&drive
let drive = (floor(trial / 2) - 2*floor(trial / 4))*1.8
alter VB1 = $&drive
let drive = (floor(trial / 4) - 2*floor(trial / 8))*1.8
alter VB2 = $&drive
let drive = (floor(trial / 8) - 2*floor(trial / 16))*1.8
alter VB3 = $&drive
let drive = (floor(trial / 16) - 2*floor(trial / 32))*1.8
alter VB4 = $&drive
let drive = (floor(trial / 32) - 2*floor(trial / 64))*1.8
alter VB5 = $&drive
let drive = (floor(trial / 64) - 2*floor(trial / 128))*1.8
alter VB6 = $&drive
let drive = (floor(trial / 128) - 2*floor(trial / 256))*1.8
alter VB7 = $&drive
stop when time = 0.003884
resume
delete all
let endpoint = length(time)-1
let cmp = v(COMP)[endpoint]
let top = v(TOP)[endpoint]
let decision = 0
if cmp >= 0.9
let code = trial
let decision = 1
end
echo 215 2 $&trial $&cmp $&top 0.99609375 $&decision >> decisions.csv
let trial = code + 2
let drive = (floor(trial / 1) - 2*floor(trial / 2))*1.8
alter VB0 = $&drive
let drive = (floor(trial / 2) - 2*floor(trial / 4))*1.8
alter VB1 = $&drive
let drive = (floor(trial / 4) - 2*floor(trial / 8))*1.8
alter VB2 = $&drive
let drive = (floor(trial / 8) - 2*floor(trial / 16))*1.8
alter VB3 = $&drive
let drive = (floor(trial / 16) - 2*floor(trial / 32))*1.8
alter VB4 = $&drive
let drive = (floor(trial / 32) - 2*floor(trial / 64))*1.8
alter VB5 = $&drive
let drive = (floor(trial / 64) - 2*floor(trial / 128))*1.8
alter VB6 = $&drive
let drive = (floor(trial / 128) - 2*floor(trial / 256))*1.8
alter VB7 = $&drive
stop when time = 0.003886
resume
delete all
let endpoint = length(time)-1
let cmp = v(COMP)[endpoint]
let top = v(TOP)[endpoint]
let decision = 0
if cmp >= 0.9
let code = trial
let decision = 1
end
echo 215 1 $&trial $&cmp $&top 0.99609375 $&decision >> decisions.csv
let trial = code + 1
let drive = (floor(trial / 1) - 2*floor(trial / 2))*1.8
alter VB0 = $&drive
let drive = (floor(trial / 2) - 2*floor(trial / 4))*1.8
alter VB1 = $&drive
let drive = (floor(trial / 4) - 2*floor(trial / 8))*1.8
alter VB2 = $&drive
let drive = (floor(trial / 8) - 2*floor(trial / 16))*1.8
alter VB3 = $&drive
let drive = (floor(trial / 16) - 2*floor(trial / 32))*1.8
alter VB4 = $&drive
let drive = (floor(trial / 32) - 2*floor(trial / 64))*1.8
alter VB5 = $&drive
let drive = (floor(trial / 64) - 2*floor(trial / 128))*1.8
alter VB6 = $&drive
let drive = (floor(trial / 128) - 2*floor(trial / 256))*1.8
alter VB7 = $&drive
stop when time = 0.003888
resume
delete all
let endpoint = length(time)-1
let cmp = v(COMP)[endpoint]
let top = v(TOP)[endpoint]
let decision = 0
if cmp >= 0.9
let code = trial
let decision = 1
end
echo 215 0 $&trial $&cmp $&top 0.99609375 $&decision >> decisions.csv
alter VIN = 1.00078125
alter VSAMPLE = 1.8
alter VB0 = 0
alter VB1 = 0
alter VB2 = 0
alter VB3 = 0
alter VB4 = 0
alter VB5 = 0
alter VB6 = 0
alter VB7 = 0
let code = 0
stop when time = 0.00389
resume
delete all
alter VSAMPLE = 0
let trial = code + 128
let drive = (floor(trial / 1) - 2*floor(trial / 2))*1.8
alter VB0 = $&drive
let drive = (floor(trial / 2) - 2*floor(trial / 4))*1.8
alter VB1 = $&drive
let drive = (floor(trial / 4) - 2*floor(trial / 8))*1.8
alter VB2 = $&drive
let drive = (floor(trial / 8) - 2*floor(trial / 16))*1.8
alter VB3 = $&drive
let drive = (floor(trial / 16) - 2*floor(trial / 32))*1.8
alter VB4 = $&drive
let drive = (floor(trial / 32) - 2*floor(trial / 64))*1.8
alter VB5 = $&drive
let drive = (floor(trial / 64) - 2*floor(trial / 128))*1.8
alter VB6 = $&drive
let drive = (floor(trial / 128) - 2*floor(trial / 256))*1.8
alter VB7 = $&drive
stop when time = 0.003892
resume
delete all
let endpoint = length(time)-1
let cmp = v(COMP)[endpoint]
let top = v(TOP)[endpoint]
let decision = 0
if cmp >= 0.9
let code = trial
let decision = 1
end
echo 216 7 $&trial $&cmp $&top 1.00078125 $&decision >> decisions.csv
let trial = code + 64
let drive = (floor(trial / 1) - 2*floor(trial / 2))*1.8
alter VB0 = $&drive
let drive = (floor(trial / 2) - 2*floor(trial / 4))*1.8
alter VB1 = $&drive
let drive = (floor(trial / 4) - 2*floor(trial / 8))*1.8
alter VB2 = $&drive
let drive = (floor(trial / 8) - 2*floor(trial / 16))*1.8
alter VB3 = $&drive
let drive = (floor(trial / 16) - 2*floor(trial / 32))*1.8
alter VB4 = $&drive
let drive = (floor(trial / 32) - 2*floor(trial / 64))*1.8
alter VB5 = $&drive
let drive = (floor(trial / 64) - 2*floor(trial / 128))*1.8
alter VB6 = $&drive
let drive = (floor(trial / 128) - 2*floor(trial / 256))*1.8
alter VB7 = $&drive
stop when time = 0.003894
resume
delete all
let endpoint = length(time)-1
let cmp = v(COMP)[endpoint]
let top = v(TOP)[endpoint]
let decision = 0
if cmp >= 0.9
let code = trial
let decision = 1
end
echo 216 6 $&trial $&cmp $&top 1.00078125 $&decision >> decisions.csv
let trial = code + 32
let drive = (floor(trial / 1) - 2*floor(trial / 2))*1.8
alter VB0 = $&drive
let drive = (floor(trial / 2) - 2*floor(trial / 4))*1.8
alter VB1 = $&drive
let drive = (floor(trial / 4) - 2*floor(trial / 8))*1.8
alter VB2 = $&drive
let drive = (floor(trial / 8) - 2*floor(trial / 16))*1.8
alter VB3 = $&drive
let drive = (floor(trial / 16) - 2*floor(trial / 32))*1.8
alter VB4 = $&drive
let drive = (floor(trial / 32) - 2*floor(trial / 64))*1.8
alter VB5 = $&drive
let drive = (floor(trial / 64) - 2*floor(trial / 128))*1.8
alter VB6 = $&drive
let drive = (floor(trial / 128) - 2*floor(trial / 256))*1.8
alter VB7 = $&drive
stop when time = 0.003896
resume
delete all
let endpoint = length(time)-1
let cmp = v(COMP)[endpoint]
let top = v(TOP)[endpoint]
let decision = 0
if cmp >= 0.9
let code = trial
let decision = 1
end
echo 216 5 $&trial $&cmp $&top 1.00078125 $&decision >> decisions.csv
let trial = code + 16
let drive = (floor(trial / 1) - 2*floor(trial / 2))*1.8
alter VB0 = $&drive
let drive = (floor(trial / 2) - 2*floor(trial / 4))*1.8
alter VB1 = $&drive
let drive = (floor(trial / 4) - 2*floor(trial / 8))*1.8
alter VB2 = $&drive
let drive = (floor(trial / 8) - 2*floor(trial / 16))*1.8
alter VB3 = $&drive
let drive = (floor(trial / 16) - 2*floor(trial / 32))*1.8
alter VB4 = $&drive
let drive = (floor(trial / 32) - 2*floor(trial / 64))*1.8
alter VB5 = $&drive
let drive = (floor(trial / 64) - 2*floor(trial / 128))*1.8
alter VB6 = $&drive
let drive = (floor(trial / 128) - 2*floor(trial / 256))*1.8
alter VB7 = $&drive
stop when time = 0.003898
resume
delete all
let endpoint = length(time)-1
let cmp = v(COMP)[endpoint]
let top = v(TOP)[endpoint]
let decision = 0
if cmp >= 0.9
let code = trial
let decision = 1
end
echo 216 4 $&trial $&cmp $&top 1.00078125 $&decision >> decisions.csv
let trial = code + 8
let drive = (floor(trial / 1) - 2*floor(trial / 2))*1.8
alter VB0 = $&drive
let drive = (floor(trial / 2) - 2*floor(trial / 4))*1.8
alter VB1 = $&drive
let drive = (floor(trial / 4) - 2*floor(trial / 8))*1.8
alter VB2 = $&drive
let drive = (floor(trial / 8) - 2*floor(trial / 16))*1.8
alter VB3 = $&drive
let drive = (floor(trial / 16) - 2*floor(trial / 32))*1.8
alter VB4 = $&drive
let drive = (floor(trial / 32) - 2*floor(trial / 64))*1.8
alter VB5 = $&drive
let drive = (floor(trial / 64) - 2*floor(trial / 128))*1.8
alter VB6 = $&drive
let drive = (floor(trial / 128) - 2*floor(trial / 256))*1.8
alter VB7 = $&drive
stop when time = 0.0039
resume
delete all
let endpoint = length(time)-1
let cmp = v(COMP)[endpoint]
let top = v(TOP)[endpoint]
let decision = 0
if cmp >= 0.9
let code = trial
let decision = 1
end
echo 216 3 $&trial $&cmp $&top 1.00078125 $&decision >> decisions.csv
let trial = code + 4
let drive = (floor(trial / 1) - 2*floor(trial / 2))*1.8
alter VB0 = $&drive
let drive = (floor(trial / 2) - 2*floor(trial / 4))*1.8
alter VB1 = $&drive
let drive = (floor(trial / 4) - 2*floor(trial / 8))*1.8
alter VB2 = $&drive
let drive = (floor(trial / 8) - 2*floor(trial / 16))*1.8
alter VB3 = $&drive
let drive = (floor(trial / 16) - 2*floor(trial / 32))*1.8
alter VB4 = $&drive
let drive = (floor(trial / 32) - 2*floor(trial / 64))*1.8
alter VB5 = $&drive
let drive = (floor(trial / 64) - 2*floor(trial / 128))*1.8
alter VB6 = $&drive
let drive = (floor(trial / 128) - 2*floor(trial / 256))*1.8
alter VB7 = $&drive
stop when time = 0.003902
resume
delete all
let endpoint = length(time)-1
let cmp = v(COMP)[endpoint]
let top = v(TOP)[endpoint]
let decision = 0
if cmp >= 0.9
let code = trial
let decision = 1
end
echo 216 2 $&trial $&cmp $&top 1.00078125 $&decision >> decisions.csv
let trial = code + 2
let drive = (floor(trial / 1) - 2*floor(trial / 2))*1.8
alter VB0 = $&drive
let drive = (floor(trial / 2) - 2*floor(trial / 4))*1.8
alter VB1 = $&drive
let drive = (floor(trial / 4) - 2*floor(trial / 8))*1.8
alter VB2 = $&drive
let drive = (floor(trial / 8) - 2*floor(trial / 16))*1.8
alter VB3 = $&drive
let drive = (floor(trial / 16) - 2*floor(trial / 32))*1.8
alter VB4 = $&drive
let drive = (floor(trial / 32) - 2*floor(trial / 64))*1.8
alter VB5 = $&drive
let drive = (floor(trial / 64) - 2*floor(trial / 128))*1.8
alter VB6 = $&drive
let drive = (floor(trial / 128) - 2*floor(trial / 256))*1.8
alter VB7 = $&drive
stop when time = 0.003904
resume
delete all
let endpoint = length(time)-1
let cmp = v(COMP)[endpoint]
let top = v(TOP)[endpoint]
let decision = 0
if cmp >= 0.9
let code = trial
let decision = 1
end
echo 216 1 $&trial $&cmp $&top 1.00078125 $&decision >> decisions.csv
let trial = code + 1
let drive = (floor(trial / 1) - 2*floor(trial / 2))*1.8
alter VB0 = $&drive
let drive = (floor(trial / 2) - 2*floor(trial / 4))*1.8
alter VB1 = $&drive
let drive = (floor(trial / 4) - 2*floor(trial / 8))*1.8
alter VB2 = $&drive
let drive = (floor(trial / 8) - 2*floor(trial / 16))*1.8
alter VB3 = $&drive
let drive = (floor(trial / 16) - 2*floor(trial / 32))*1.8
alter VB4 = $&drive
let drive = (floor(trial / 32) - 2*floor(trial / 64))*1.8
alter VB5 = $&drive
let drive = (floor(trial / 64) - 2*floor(trial / 128))*1.8
alter VB6 = $&drive
let drive = (floor(trial / 128) - 2*floor(trial / 256))*1.8
alter VB7 = $&drive
stop when time = 0.003906
resume
delete all
let endpoint = length(time)-1
let cmp = v(COMP)[endpoint]
let top = v(TOP)[endpoint]
let decision = 0
if cmp >= 0.9
let code = trial
let decision = 1
end
echo 216 0 $&trial $&cmp $&top 1.00078125 $&decision >> decisions.csv
alter VIN = 1.00546875
alter VSAMPLE = 1.8
alter VB0 = 0
alter VB1 = 0
alter VB2 = 0
alter VB3 = 0
alter VB4 = 0
alter VB5 = 0
alter VB6 = 0
alter VB7 = 0
let code = 0
stop when time = 0.003908
resume
delete all
alter VSAMPLE = 0
let trial = code + 128
let drive = (floor(trial / 1) - 2*floor(trial / 2))*1.8
alter VB0 = $&drive
let drive = (floor(trial / 2) - 2*floor(trial / 4))*1.8
alter VB1 = $&drive
let drive = (floor(trial / 4) - 2*floor(trial / 8))*1.8
alter VB2 = $&drive
let drive = (floor(trial / 8) - 2*floor(trial / 16))*1.8
alter VB3 = $&drive
let drive = (floor(trial / 16) - 2*floor(trial / 32))*1.8
alter VB4 = $&drive
let drive = (floor(trial / 32) - 2*floor(trial / 64))*1.8
alter VB5 = $&drive
let drive = (floor(trial / 64) - 2*floor(trial / 128))*1.8
alter VB6 = $&drive
let drive = (floor(trial / 128) - 2*floor(trial / 256))*1.8
alter VB7 = $&drive
stop when time = 0.00391
resume
delete all
let endpoint = length(time)-1
let cmp = v(COMP)[endpoint]
let top = v(TOP)[endpoint]
let decision = 0
if cmp >= 0.9
let code = trial
let decision = 1
end
echo 217 7 $&trial $&cmp $&top 1.00546875 $&decision >> decisions.csv
let trial = code + 64
let drive = (floor(trial / 1) - 2*floor(trial / 2))*1.8
alter VB0 = $&drive
let drive = (floor(trial / 2) - 2*floor(trial / 4))*1.8
alter VB1 = $&drive
let drive = (floor(trial / 4) - 2*floor(trial / 8))*1.8
alter VB2 = $&drive
let drive = (floor(trial / 8) - 2*floor(trial / 16))*1.8
alter VB3 = $&drive
let drive = (floor(trial / 16) - 2*floor(trial / 32))*1.8
alter VB4 = $&drive
let drive = (floor(trial / 32) - 2*floor(trial / 64))*1.8
alter VB5 = $&drive
let drive = (floor(trial / 64) - 2*floor(trial / 128))*1.8
alter VB6 = $&drive
let drive = (floor(trial / 128) - 2*floor(trial / 256))*1.8
alter VB7 = $&drive
stop when time = 0.003912
resume
delete all
let endpoint = length(time)-1
let cmp = v(COMP)[endpoint]
let top = v(TOP)[endpoint]
let decision = 0
if cmp >= 0.9
let code = trial
let decision = 1
end
echo 217 6 $&trial $&cmp $&top 1.00546875 $&decision >> decisions.csv
let trial = code + 32
let drive = (floor(trial / 1) - 2*floor(trial / 2))*1.8
alter VB0 = $&drive
let drive = (floor(trial / 2) - 2*floor(trial / 4))*1.8
alter VB1 = $&drive
let drive = (floor(trial / 4) - 2*floor(trial / 8))*1.8
alter VB2 = $&drive
let drive = (floor(trial / 8) - 2*floor(trial / 16))*1.8
alter VB3 = $&drive
let drive = (floor(trial / 16) - 2*floor(trial / 32))*1.8
alter VB4 = $&drive
let drive = (floor(trial / 32) - 2*floor(trial / 64))*1.8
alter VB5 = $&drive
let drive = (floor(trial / 64) - 2*floor(trial / 128))*1.8
alter VB6 = $&drive
let drive = (floor(trial / 128) - 2*floor(trial / 256))*1.8
alter VB7 = $&drive
stop when time = 0.003914
resume
delete all
let endpoint = length(time)-1
let cmp = v(COMP)[endpoint]
let top = v(TOP)[endpoint]
let decision = 0
if cmp >= 0.9
let code = trial
let decision = 1
end
echo 217 5 $&trial $&cmp $&top 1.00546875 $&decision >> decisions.csv
let trial = code + 16
let drive = (floor(trial / 1) - 2*floor(trial / 2))*1.8
alter VB0 = $&drive
let drive = (floor(trial / 2) - 2*floor(trial / 4))*1.8
alter VB1 = $&drive
let drive = (floor(trial / 4) - 2*floor(trial / 8))*1.8
alter VB2 = $&drive
let drive = (floor(trial / 8) - 2*floor(trial / 16))*1.8
alter VB3 = $&drive
let drive = (floor(trial / 16) - 2*floor(trial / 32))*1.8
alter VB4 = $&drive
let drive = (floor(trial / 32) - 2*floor(trial / 64))*1.8
alter VB5 = $&drive
let drive = (floor(trial / 64) - 2*floor(trial / 128))*1.8
alter VB6 = $&drive
let drive = (floor(trial / 128) - 2*floor(trial / 256))*1.8
alter VB7 = $&drive
stop when time = 0.003916
resume
delete all
let endpoint = length(time)-1
let cmp = v(COMP)[endpoint]
let top = v(TOP)[endpoint]
let decision = 0
if cmp >= 0.9
let code = trial
let decision = 1
end
echo 217 4 $&trial $&cmp $&top 1.00546875 $&decision >> decisions.csv
let trial = code + 8
let drive = (floor(trial / 1) - 2*floor(trial / 2))*1.8
alter VB0 = $&drive
let drive = (floor(trial / 2) - 2*floor(trial / 4))*1.8
alter VB1 = $&drive
let drive = (floor(trial / 4) - 2*floor(trial / 8))*1.8
alter VB2 = $&drive
let drive = (floor(trial / 8) - 2*floor(trial / 16))*1.8
alter VB3 = $&drive
let drive = (floor(trial / 16) - 2*floor(trial / 32))*1.8
alter VB4 = $&drive
let drive = (floor(trial / 32) - 2*floor(trial / 64))*1.8
alter VB5 = $&drive
let drive = (floor(trial / 64) - 2*floor(trial / 128))*1.8
alter VB6 = $&drive
let drive = (floor(trial / 128) - 2*floor(trial / 256))*1.8
alter VB7 = $&drive
stop when time = 0.003918
resume
delete all
let endpoint = length(time)-1
let cmp = v(COMP)[endpoint]
let top = v(TOP)[endpoint]
let decision = 0
if cmp >= 0.9
let code = trial
let decision = 1
end
echo 217 3 $&trial $&cmp $&top 1.00546875 $&decision >> decisions.csv
let trial = code + 4
let drive = (floor(trial / 1) - 2*floor(trial / 2))*1.8
alter VB0 = $&drive
let drive = (floor(trial / 2) - 2*floor(trial / 4))*1.8
alter VB1 = $&drive
let drive = (floor(trial / 4) - 2*floor(trial / 8))*1.8
alter VB2 = $&drive
let drive = (floor(trial / 8) - 2*floor(trial / 16))*1.8
alter VB3 = $&drive
let drive = (floor(trial / 16) - 2*floor(trial / 32))*1.8
alter VB4 = $&drive
let drive = (floor(trial / 32) - 2*floor(trial / 64))*1.8
alter VB5 = $&drive
let drive = (floor(trial / 64) - 2*floor(trial / 128))*1.8
alter VB6 = $&drive
let drive = (floor(trial / 128) - 2*floor(trial / 256))*1.8
alter VB7 = $&drive
stop when time = 0.00392
resume
delete all
let endpoint = length(time)-1
let cmp = v(COMP)[endpoint]
let top = v(TOP)[endpoint]
let decision = 0
if cmp >= 0.9
let code = trial
let decision = 1
end
echo 217 2 $&trial $&cmp $&top 1.00546875 $&decision >> decisions.csv
let trial = code + 2
let drive = (floor(trial / 1) - 2*floor(trial / 2))*1.8
alter VB0 = $&drive
let drive = (floor(trial / 2) - 2*floor(trial / 4))*1.8
alter VB1 = $&drive
let drive = (floor(trial / 4) - 2*floor(trial / 8))*1.8
alter VB2 = $&drive
let drive = (floor(trial / 8) - 2*floor(trial / 16))*1.8
alter VB3 = $&drive
let drive = (floor(trial / 16) - 2*floor(trial / 32))*1.8
alter VB4 = $&drive
let drive = (floor(trial / 32) - 2*floor(trial / 64))*1.8
alter VB5 = $&drive
let drive = (floor(trial / 64) - 2*floor(trial / 128))*1.8
alter VB6 = $&drive
let drive = (floor(trial / 128) - 2*floor(trial / 256))*1.8
alter VB7 = $&drive
stop when time = 0.003922
resume
delete all
let endpoint = length(time)-1
let cmp = v(COMP)[endpoint]
let top = v(TOP)[endpoint]
let decision = 0
if cmp >= 0.9
let code = trial
let decision = 1
end
echo 217 1 $&trial $&cmp $&top 1.00546875 $&decision >> decisions.csv
let trial = code + 1
let drive = (floor(trial / 1) - 2*floor(trial / 2))*1.8
alter VB0 = $&drive
let drive = (floor(trial / 2) - 2*floor(trial / 4))*1.8
alter VB1 = $&drive
let drive = (floor(trial / 4) - 2*floor(trial / 8))*1.8
alter VB2 = $&drive
let drive = (floor(trial / 8) - 2*floor(trial / 16))*1.8
alter VB3 = $&drive
let drive = (floor(trial / 16) - 2*floor(trial / 32))*1.8
alter VB4 = $&drive
let drive = (floor(trial / 32) - 2*floor(trial / 64))*1.8
alter VB5 = $&drive
let drive = (floor(trial / 64) - 2*floor(trial / 128))*1.8
alter VB6 = $&drive
let drive = (floor(trial / 128) - 2*floor(trial / 256))*1.8
alter VB7 = $&drive
stop when time = 0.003924
resume
delete all
let endpoint = length(time)-1
let cmp = v(COMP)[endpoint]
let top = v(TOP)[endpoint]
let decision = 0
if cmp >= 0.9
let code = trial
let decision = 1
end
echo 217 0 $&trial $&cmp $&top 1.00546875 $&decision >> decisions.csv
alter VIN = 1.01015625
alter VSAMPLE = 1.8
alter VB0 = 0
alter VB1 = 0
alter VB2 = 0
alter VB3 = 0
alter VB4 = 0
alter VB5 = 0
alter VB6 = 0
alter VB7 = 0
let code = 0
stop when time = 0.003926
resume
delete all
alter VSAMPLE = 0
let trial = code + 128
let drive = (floor(trial / 1) - 2*floor(trial / 2))*1.8
alter VB0 = $&drive
let drive = (floor(trial / 2) - 2*floor(trial / 4))*1.8
alter VB1 = $&drive
let drive = (floor(trial / 4) - 2*floor(trial / 8))*1.8
alter VB2 = $&drive
let drive = (floor(trial / 8) - 2*floor(trial / 16))*1.8
alter VB3 = $&drive
let drive = (floor(trial / 16) - 2*floor(trial / 32))*1.8
alter VB4 = $&drive
let drive = (floor(trial / 32) - 2*floor(trial / 64))*1.8
alter VB5 = $&drive
let drive = (floor(trial / 64) - 2*floor(trial / 128))*1.8
alter VB6 = $&drive
let drive = (floor(trial / 128) - 2*floor(trial / 256))*1.8
alter VB7 = $&drive
stop when time = 0.003928
resume
delete all
let endpoint = length(time)-1
let cmp = v(COMP)[endpoint]
let top = v(TOP)[endpoint]
let decision = 0
if cmp >= 0.9
let code = trial
let decision = 1
end
echo 218 7 $&trial $&cmp $&top 1.01015625 $&decision >> decisions.csv
let trial = code + 64
let drive = (floor(trial / 1) - 2*floor(trial / 2))*1.8
alter VB0 = $&drive
let drive = (floor(trial / 2) - 2*floor(trial / 4))*1.8
alter VB1 = $&drive
let drive = (floor(trial / 4) - 2*floor(trial / 8))*1.8
alter VB2 = $&drive
let drive = (floor(trial / 8) - 2*floor(trial / 16))*1.8
alter VB3 = $&drive
let drive = (floor(trial / 16) - 2*floor(trial / 32))*1.8
alter VB4 = $&drive
let drive = (floor(trial / 32) - 2*floor(trial / 64))*1.8
alter VB5 = $&drive
let drive = (floor(trial / 64) - 2*floor(trial / 128))*1.8
alter VB6 = $&drive
let drive = (floor(trial / 128) - 2*floor(trial / 256))*1.8
alter VB7 = $&drive
stop when time = 0.00393
resume
delete all
let endpoint = length(time)-1
let cmp = v(COMP)[endpoint]
let top = v(TOP)[endpoint]
let decision = 0
if cmp >= 0.9
let code = trial
let decision = 1
end
echo 218 6 $&trial $&cmp $&top 1.01015625 $&decision >> decisions.csv
let trial = code + 32
let drive = (floor(trial / 1) - 2*floor(trial / 2))*1.8
alter VB0 = $&drive
let drive = (floor(trial / 2) - 2*floor(trial / 4))*1.8
alter VB1 = $&drive
let drive = (floor(trial / 4) - 2*floor(trial / 8))*1.8
alter VB2 = $&drive
let drive = (floor(trial / 8) - 2*floor(trial / 16))*1.8
alter VB3 = $&drive
let drive = (floor(trial / 16) - 2*floor(trial / 32))*1.8
alter VB4 = $&drive
let drive = (floor(trial / 32) - 2*floor(trial / 64))*1.8
alter VB5 = $&drive
let drive = (floor(trial / 64) - 2*floor(trial / 128))*1.8
alter VB6 = $&drive
let drive = (floor(trial / 128) - 2*floor(trial / 256))*1.8
alter VB7 = $&drive
stop when time = 0.003932
resume
delete all
let endpoint = length(time)-1
let cmp = v(COMP)[endpoint]
let top = v(TOP)[endpoint]
let decision = 0
if cmp >= 0.9
let code = trial
let decision = 1
end
echo 218 5 $&trial $&cmp $&top 1.01015625 $&decision >> decisions.csv
let trial = code + 16
let drive = (floor(trial / 1) - 2*floor(trial / 2))*1.8
alter VB0 = $&drive
let drive = (floor(trial / 2) - 2*floor(trial / 4))*1.8
alter VB1 = $&drive
let drive = (floor(trial / 4) - 2*floor(trial / 8))*1.8
alter VB2 = $&drive
let drive = (floor(trial / 8) - 2*floor(trial / 16))*1.8
alter VB3 = $&drive
let drive = (floor(trial / 16) - 2*floor(trial / 32))*1.8
alter VB4 = $&drive
let drive = (floor(trial / 32) - 2*floor(trial / 64))*1.8
alter VB5 = $&drive
let drive = (floor(trial / 64) - 2*floor(trial / 128))*1.8
alter VB6 = $&drive
let drive = (floor(trial / 128) - 2*floor(trial / 256))*1.8
alter VB7 = $&drive
stop when time = 0.003934
resume
delete all
let endpoint = length(time)-1
let cmp = v(COMP)[endpoint]
let top = v(TOP)[endpoint]
let decision = 0
if cmp >= 0.9
let code = trial
let decision = 1
end
echo 218 4 $&trial $&cmp $&top 1.01015625 $&decision >> decisions.csv
let trial = code + 8
let drive = (floor(trial / 1) - 2*floor(trial / 2))*1.8
alter VB0 = $&drive
let drive = (floor(trial / 2) - 2*floor(trial / 4))*1.8
alter VB1 = $&drive
let drive = (floor(trial / 4) - 2*floor(trial / 8))*1.8
alter VB2 = $&drive
let drive = (floor(trial / 8) - 2*floor(trial / 16))*1.8
alter VB3 = $&drive
let drive = (floor(trial / 16) - 2*floor(trial / 32))*1.8
alter VB4 = $&drive
let drive = (floor(trial / 32) - 2*floor(trial / 64))*1.8
alter VB5 = $&drive
let drive = (floor(trial / 64) - 2*floor(trial / 128))*1.8
alter VB6 = $&drive
let drive = (floor(trial / 128) - 2*floor(trial / 256))*1.8
alter VB7 = $&drive
stop when time = 0.003936
resume
delete all
let endpoint = length(time)-1
let cmp = v(COMP)[endpoint]
let top = v(TOP)[endpoint]
let decision = 0
if cmp >= 0.9
let code = trial
let decision = 1
end
echo 218 3 $&trial $&cmp $&top 1.01015625 $&decision >> decisions.csv
let trial = code + 4
let drive = (floor(trial / 1) - 2*floor(trial / 2))*1.8
alter VB0 = $&drive
let drive = (floor(trial / 2) - 2*floor(trial / 4))*1.8
alter VB1 = $&drive
let drive = (floor(trial / 4) - 2*floor(trial / 8))*1.8
alter VB2 = $&drive
let drive = (floor(trial / 8) - 2*floor(trial / 16))*1.8
alter VB3 = $&drive
let drive = (floor(trial / 16) - 2*floor(trial / 32))*1.8
alter VB4 = $&drive
let drive = (floor(trial / 32) - 2*floor(trial / 64))*1.8
alter VB5 = $&drive
let drive = (floor(trial / 64) - 2*floor(trial / 128))*1.8
alter VB6 = $&drive
let drive = (floor(trial / 128) - 2*floor(trial / 256))*1.8
alter VB7 = $&drive
stop when time = 0.003938
resume
delete all
let endpoint = length(time)-1
let cmp = v(COMP)[endpoint]
let top = v(TOP)[endpoint]
let decision = 0
if cmp >= 0.9
let code = trial
let decision = 1
end
echo 218 2 $&trial $&cmp $&top 1.01015625 $&decision >> decisions.csv
let trial = code + 2
let drive = (floor(trial / 1) - 2*floor(trial / 2))*1.8
alter VB0 = $&drive
let drive = (floor(trial / 2) - 2*floor(trial / 4))*1.8
alter VB1 = $&drive
let drive = (floor(trial / 4) - 2*floor(trial / 8))*1.8
alter VB2 = $&drive
let drive = (floor(trial / 8) - 2*floor(trial / 16))*1.8
alter VB3 = $&drive
let drive = (floor(trial / 16) - 2*floor(trial / 32))*1.8
alter VB4 = $&drive
let drive = (floor(trial / 32) - 2*floor(trial / 64))*1.8
alter VB5 = $&drive
let drive = (floor(trial / 64) - 2*floor(trial / 128))*1.8
alter VB6 = $&drive
let drive = (floor(trial / 128) - 2*floor(trial / 256))*1.8
alter VB7 = $&drive
stop when time = 0.00394
resume
delete all
let endpoint = length(time)-1
let cmp = v(COMP)[endpoint]
let top = v(TOP)[endpoint]
let decision = 0
if cmp >= 0.9
let code = trial
let decision = 1
end
echo 218 1 $&trial $&cmp $&top 1.01015625 $&decision >> decisions.csv
let trial = code + 1
let drive = (floor(trial / 1) - 2*floor(trial / 2))*1.8
alter VB0 = $&drive
let drive = (floor(trial / 2) - 2*floor(trial / 4))*1.8
alter VB1 = $&drive
let drive = (floor(trial / 4) - 2*floor(trial / 8))*1.8
alter VB2 = $&drive
let drive = (floor(trial / 8) - 2*floor(trial / 16))*1.8
alter VB3 = $&drive
let drive = (floor(trial / 16) - 2*floor(trial / 32))*1.8
alter VB4 = $&drive
let drive = (floor(trial / 32) - 2*floor(trial / 64))*1.8
alter VB5 = $&drive
let drive = (floor(trial / 64) - 2*floor(trial / 128))*1.8
alter VB6 = $&drive
let drive = (floor(trial / 128) - 2*floor(trial / 256))*1.8
alter VB7 = $&drive
stop when time = 0.003942
resume
delete all
let endpoint = length(time)-1
let cmp = v(COMP)[endpoint]
let top = v(TOP)[endpoint]
let decision = 0
if cmp >= 0.9
let code = trial
let decision = 1
end
echo 218 0 $&trial $&cmp $&top 1.01015625 $&decision >> decisions.csv
alter VIN = 1.01484375
alter VSAMPLE = 1.8
alter VB0 = 0
alter VB1 = 0
alter VB2 = 0
alter VB3 = 0
alter VB4 = 0
alter VB5 = 0
alter VB6 = 0
alter VB7 = 0
let code = 0
stop when time = 0.003944
resume
delete all
alter VSAMPLE = 0
let trial = code + 128
let drive = (floor(trial / 1) - 2*floor(trial / 2))*1.8
alter VB0 = $&drive
let drive = (floor(trial / 2) - 2*floor(trial / 4))*1.8
alter VB1 = $&drive
let drive = (floor(trial / 4) - 2*floor(trial / 8))*1.8
alter VB2 = $&drive
let drive = (floor(trial / 8) - 2*floor(trial / 16))*1.8
alter VB3 = $&drive
let drive = (floor(trial / 16) - 2*floor(trial / 32))*1.8
alter VB4 = $&drive
let drive = (floor(trial / 32) - 2*floor(trial / 64))*1.8
alter VB5 = $&drive
let drive = (floor(trial / 64) - 2*floor(trial / 128))*1.8
alter VB6 = $&drive
let drive = (floor(trial / 128) - 2*floor(trial / 256))*1.8
alter VB7 = $&drive
stop when time = 0.003946
resume
delete all
let endpoint = length(time)-1
let cmp = v(COMP)[endpoint]
let top = v(TOP)[endpoint]
let decision = 0
if cmp >= 0.9
let code = trial
let decision = 1
end
echo 219 7 $&trial $&cmp $&top 1.01484375 $&decision >> decisions.csv
let trial = code + 64
let drive = (floor(trial / 1) - 2*floor(trial / 2))*1.8
alter VB0 = $&drive
let drive = (floor(trial / 2) - 2*floor(trial / 4))*1.8
alter VB1 = $&drive
let drive = (floor(trial / 4) - 2*floor(trial / 8))*1.8
alter VB2 = $&drive
let drive = (floor(trial / 8) - 2*floor(trial / 16))*1.8
alter VB3 = $&drive
let drive = (floor(trial / 16) - 2*floor(trial / 32))*1.8
alter VB4 = $&drive
let drive = (floor(trial / 32) - 2*floor(trial / 64))*1.8
alter VB5 = $&drive
let drive = (floor(trial / 64) - 2*floor(trial / 128))*1.8
alter VB6 = $&drive
let drive = (floor(trial / 128) - 2*floor(trial / 256))*1.8
alter VB7 = $&drive
stop when time = 0.003948
resume
delete all
let endpoint = length(time)-1
let cmp = v(COMP)[endpoint]
let top = v(TOP)[endpoint]
let decision = 0
if cmp >= 0.9
let code = trial
let decision = 1
end
echo 219 6 $&trial $&cmp $&top 1.01484375 $&decision >> decisions.csv
let trial = code + 32
let drive = (floor(trial / 1) - 2*floor(trial / 2))*1.8
alter VB0 = $&drive
let drive = (floor(trial / 2) - 2*floor(trial / 4))*1.8
alter VB1 = $&drive
let drive = (floor(trial / 4) - 2*floor(trial / 8))*1.8
alter VB2 = $&drive
let drive = (floor(trial / 8) - 2*floor(trial / 16))*1.8
alter VB3 = $&drive
let drive = (floor(trial / 16) - 2*floor(trial / 32))*1.8
alter VB4 = $&drive
let drive = (floor(trial / 32) - 2*floor(trial / 64))*1.8
alter VB5 = $&drive
let drive = (floor(trial / 64) - 2*floor(trial / 128))*1.8
alter VB6 = $&drive
let drive = (floor(trial / 128) - 2*floor(trial / 256))*1.8
alter VB7 = $&drive
stop when time = 0.00395
resume
delete all
let endpoint = length(time)-1
let cmp = v(COMP)[endpoint]
let top = v(TOP)[endpoint]
let decision = 0
if cmp >= 0.9
let code = trial
let decision = 1
end
echo 219 5 $&trial $&cmp $&top 1.01484375 $&decision >> decisions.csv
let trial = code + 16
let drive = (floor(trial / 1) - 2*floor(trial / 2))*1.8
alter VB0 = $&drive
let drive = (floor(trial / 2) - 2*floor(trial / 4))*1.8
alter VB1 = $&drive
let drive = (floor(trial / 4) - 2*floor(trial / 8))*1.8
alter VB2 = $&drive
let drive = (floor(trial / 8) - 2*floor(trial / 16))*1.8
alter VB3 = $&drive
let drive = (floor(trial / 16) - 2*floor(trial / 32))*1.8
alter VB4 = $&drive
let drive = (floor(trial / 32) - 2*floor(trial / 64))*1.8
alter VB5 = $&drive
let drive = (floor(trial / 64) - 2*floor(trial / 128))*1.8
alter VB6 = $&drive
let drive = (floor(trial / 128) - 2*floor(trial / 256))*1.8
alter VB7 = $&drive
stop when time = 0.003952
resume
delete all
let endpoint = length(time)-1
let cmp = v(COMP)[endpoint]
let top = v(TOP)[endpoint]
let decision = 0
if cmp >= 0.9
let code = trial
let decision = 1
end
echo 219 4 $&trial $&cmp $&top 1.01484375 $&decision >> decisions.csv
let trial = code + 8
let drive = (floor(trial / 1) - 2*floor(trial / 2))*1.8
alter VB0 = $&drive
let drive = (floor(trial / 2) - 2*floor(trial / 4))*1.8
alter VB1 = $&drive
let drive = (floor(trial / 4) - 2*floor(trial / 8))*1.8
alter VB2 = $&drive
let drive = (floor(trial / 8) - 2*floor(trial / 16))*1.8
alter VB3 = $&drive
let drive = (floor(trial / 16) - 2*floor(trial / 32))*1.8
alter VB4 = $&drive
let drive = (floor(trial / 32) - 2*floor(trial / 64))*1.8
alter VB5 = $&drive
let drive = (floor(trial / 64) - 2*floor(trial / 128))*1.8
alter VB6 = $&drive
let drive = (floor(trial / 128) - 2*floor(trial / 256))*1.8
alter VB7 = $&drive
stop when time = 0.003954
resume
delete all
let endpoint = length(time)-1
let cmp = v(COMP)[endpoint]
let top = v(TOP)[endpoint]
let decision = 0
if cmp >= 0.9
let code = trial
let decision = 1
end
echo 219 3 $&trial $&cmp $&top 1.01484375 $&decision >> decisions.csv
let trial = code + 4
let drive = (floor(trial / 1) - 2*floor(trial / 2))*1.8
alter VB0 = $&drive
let drive = (floor(trial / 2) - 2*floor(trial / 4))*1.8
alter VB1 = $&drive
let drive = (floor(trial / 4) - 2*floor(trial / 8))*1.8
alter VB2 = $&drive
let drive = (floor(trial / 8) - 2*floor(trial / 16))*1.8
alter VB3 = $&drive
let drive = (floor(trial / 16) - 2*floor(trial / 32))*1.8
alter VB4 = $&drive
let drive = (floor(trial / 32) - 2*floor(trial / 64))*1.8
alter VB5 = $&drive
let drive = (floor(trial / 64) - 2*floor(trial / 128))*1.8
alter VB6 = $&drive
let drive = (floor(trial / 128) - 2*floor(trial / 256))*1.8
alter VB7 = $&drive
stop when time = 0.003956
resume
delete all
let endpoint = length(time)-1
let cmp = v(COMP)[endpoint]
let top = v(TOP)[endpoint]
let decision = 0
if cmp >= 0.9
let code = trial
let decision = 1
end
echo 219 2 $&trial $&cmp $&top 1.01484375 $&decision >> decisions.csv
let trial = code + 2
let drive = (floor(trial / 1) - 2*floor(trial / 2))*1.8
alter VB0 = $&drive
let drive = (floor(trial / 2) - 2*floor(trial / 4))*1.8
alter VB1 = $&drive
let drive = (floor(trial / 4) - 2*floor(trial / 8))*1.8
alter VB2 = $&drive
let drive = (floor(trial / 8) - 2*floor(trial / 16))*1.8
alter VB3 = $&drive
let drive = (floor(trial / 16) - 2*floor(trial / 32))*1.8
alter VB4 = $&drive
let drive = (floor(trial / 32) - 2*floor(trial / 64))*1.8
alter VB5 = $&drive
let drive = (floor(trial / 64) - 2*floor(trial / 128))*1.8
alter VB6 = $&drive
let drive = (floor(trial / 128) - 2*floor(trial / 256))*1.8
alter VB7 = $&drive
stop when time = 0.003958
resume
delete all
let endpoint = length(time)-1
let cmp = v(COMP)[endpoint]
let top = v(TOP)[endpoint]
let decision = 0
if cmp >= 0.9
let code = trial
let decision = 1
end
echo 219 1 $&trial $&cmp $&top 1.01484375 $&decision >> decisions.csv
let trial = code + 1
let drive = (floor(trial / 1) - 2*floor(trial / 2))*1.8
alter VB0 = $&drive
let drive = (floor(trial / 2) - 2*floor(trial / 4))*1.8
alter VB1 = $&drive
let drive = (floor(trial / 4) - 2*floor(trial / 8))*1.8
alter VB2 = $&drive
let drive = (floor(trial / 8) - 2*floor(trial / 16))*1.8
alter VB3 = $&drive
let drive = (floor(trial / 16) - 2*floor(trial / 32))*1.8
alter VB4 = $&drive
let drive = (floor(trial / 32) - 2*floor(trial / 64))*1.8
alter VB5 = $&drive
let drive = (floor(trial / 64) - 2*floor(trial / 128))*1.8
alter VB6 = $&drive
let drive = (floor(trial / 128) - 2*floor(trial / 256))*1.8
alter VB7 = $&drive
stop when time = 0.00396
resume
delete all
let endpoint = length(time)-1
let cmp = v(COMP)[endpoint]
let top = v(TOP)[endpoint]
let decision = 0
if cmp >= 0.9
let code = trial
let decision = 1
end
echo 219 0 $&trial $&cmp $&top 1.01484375 $&decision >> decisions.csv
alter VIN = 1.01953125
alter VSAMPLE = 1.8
alter VB0 = 0
alter VB1 = 0
alter VB2 = 0
alter VB3 = 0
alter VB4 = 0
alter VB5 = 0
alter VB6 = 0
alter VB7 = 0
let code = 0
stop when time = 0.003962
resume
delete all
alter VSAMPLE = 0
let trial = code + 128
let drive = (floor(trial / 1) - 2*floor(trial / 2))*1.8
alter VB0 = $&drive
let drive = (floor(trial / 2) - 2*floor(trial / 4))*1.8
alter VB1 = $&drive
let drive = (floor(trial / 4) - 2*floor(trial / 8))*1.8
alter VB2 = $&drive
let drive = (floor(trial / 8) - 2*floor(trial / 16))*1.8
alter VB3 = $&drive
let drive = (floor(trial / 16) - 2*floor(trial / 32))*1.8
alter VB4 = $&drive
let drive = (floor(trial / 32) - 2*floor(trial / 64))*1.8
alter VB5 = $&drive
let drive = (floor(trial / 64) - 2*floor(trial / 128))*1.8
alter VB6 = $&drive
let drive = (floor(trial / 128) - 2*floor(trial / 256))*1.8
alter VB7 = $&drive
stop when time = 0.003964
resume
delete all
let endpoint = length(time)-1
let cmp = v(COMP)[endpoint]
let top = v(TOP)[endpoint]
let decision = 0
if cmp >= 0.9
let code = trial
let decision = 1
end
echo 220 7 $&trial $&cmp $&top 1.01953125 $&decision >> decisions.csv
let trial = code + 64
let drive = (floor(trial / 1) - 2*floor(trial / 2))*1.8
alter VB0 = $&drive
let drive = (floor(trial / 2) - 2*floor(trial / 4))*1.8
alter VB1 = $&drive
let drive = (floor(trial / 4) - 2*floor(trial / 8))*1.8
alter VB2 = $&drive
let drive = (floor(trial / 8) - 2*floor(trial / 16))*1.8
alter VB3 = $&drive
let drive = (floor(trial / 16) - 2*floor(trial / 32))*1.8
alter VB4 = $&drive
let drive = (floor(trial / 32) - 2*floor(trial / 64))*1.8
alter VB5 = $&drive
let drive = (floor(trial / 64) - 2*floor(trial / 128))*1.8
alter VB6 = $&drive
let drive = (floor(trial / 128) - 2*floor(trial / 256))*1.8
alter VB7 = $&drive
stop when time = 0.003966
resume
delete all
let endpoint = length(time)-1
let cmp = v(COMP)[endpoint]
let top = v(TOP)[endpoint]
let decision = 0
if cmp >= 0.9
let code = trial
let decision = 1
end
echo 220 6 $&trial $&cmp $&top 1.01953125 $&decision >> decisions.csv
let trial = code + 32
let drive = (floor(trial / 1) - 2*floor(trial / 2))*1.8
alter VB0 = $&drive
let drive = (floor(trial / 2) - 2*floor(trial / 4))*1.8
alter VB1 = $&drive
let drive = (floor(trial / 4) - 2*floor(trial / 8))*1.8
alter VB2 = $&drive
let drive = (floor(trial / 8) - 2*floor(trial / 16))*1.8
alter VB3 = $&drive
let drive = (floor(trial / 16) - 2*floor(trial / 32))*1.8
alter VB4 = $&drive
let drive = (floor(trial / 32) - 2*floor(trial / 64))*1.8
alter VB5 = $&drive
let drive = (floor(trial / 64) - 2*floor(trial / 128))*1.8
alter VB6 = $&drive
let drive = (floor(trial / 128) - 2*floor(trial / 256))*1.8
alter VB7 = $&drive
stop when time = 0.003968
resume
delete all
let endpoint = length(time)-1
let cmp = v(COMP)[endpoint]
let top = v(TOP)[endpoint]
let decision = 0
if cmp >= 0.9
let code = trial
let decision = 1
end
echo 220 5 $&trial $&cmp $&top 1.01953125 $&decision >> decisions.csv
let trial = code + 16
let drive = (floor(trial / 1) - 2*floor(trial / 2))*1.8
alter VB0 = $&drive
let drive = (floor(trial / 2) - 2*floor(trial / 4))*1.8
alter VB1 = $&drive
let drive = (floor(trial / 4) - 2*floor(trial / 8))*1.8
alter VB2 = $&drive
let drive = (floor(trial / 8) - 2*floor(trial / 16))*1.8
alter VB3 = $&drive
let drive = (floor(trial / 16) - 2*floor(trial / 32))*1.8
alter VB4 = $&drive
let drive = (floor(trial / 32) - 2*floor(trial / 64))*1.8
alter VB5 = $&drive
let drive = (floor(trial / 64) - 2*floor(trial / 128))*1.8
alter VB6 = $&drive
let drive = (floor(trial / 128) - 2*floor(trial / 256))*1.8
alter VB7 = $&drive
stop when time = 0.00397
resume
delete all
let endpoint = length(time)-1
let cmp = v(COMP)[endpoint]
let top = v(TOP)[endpoint]
let decision = 0
if cmp >= 0.9
let code = trial
let decision = 1
end
echo 220 4 $&trial $&cmp $&top 1.01953125 $&decision >> decisions.csv
let trial = code + 8
let drive = (floor(trial / 1) - 2*floor(trial / 2))*1.8
alter VB0 = $&drive
let drive = (floor(trial / 2) - 2*floor(trial / 4))*1.8
alter VB1 = $&drive
let drive = (floor(trial / 4) - 2*floor(trial / 8))*1.8
alter VB2 = $&drive
let drive = (floor(trial / 8) - 2*floor(trial / 16))*1.8
alter VB3 = $&drive
let drive = (floor(trial / 16) - 2*floor(trial / 32))*1.8
alter VB4 = $&drive
let drive = (floor(trial / 32) - 2*floor(trial / 64))*1.8
alter VB5 = $&drive
let drive = (floor(trial / 64) - 2*floor(trial / 128))*1.8
alter VB6 = $&drive
let drive = (floor(trial / 128) - 2*floor(trial / 256))*1.8
alter VB7 = $&drive
stop when time = 0.003972
resume
delete all
let endpoint = length(time)-1
let cmp = v(COMP)[endpoint]
let top = v(TOP)[endpoint]
let decision = 0
if cmp >= 0.9
let code = trial
let decision = 1
end
echo 220 3 $&trial $&cmp $&top 1.01953125 $&decision >> decisions.csv
let trial = code + 4
let drive = (floor(trial / 1) - 2*floor(trial / 2))*1.8
alter VB0 = $&drive
let drive = (floor(trial / 2) - 2*floor(trial / 4))*1.8
alter VB1 = $&drive
let drive = (floor(trial / 4) - 2*floor(trial / 8))*1.8
alter VB2 = $&drive
let drive = (floor(trial / 8) - 2*floor(trial / 16))*1.8
alter VB3 = $&drive
let drive = (floor(trial / 16) - 2*floor(trial / 32))*1.8
alter VB4 = $&drive
let drive = (floor(trial / 32) - 2*floor(trial / 64))*1.8
alter VB5 = $&drive
let drive = (floor(trial / 64) - 2*floor(trial / 128))*1.8
alter VB6 = $&drive
let drive = (floor(trial / 128) - 2*floor(trial / 256))*1.8
alter VB7 = $&drive
stop when time = 0.003974
resume
delete all
let endpoint = length(time)-1
let cmp = v(COMP)[endpoint]
let top = v(TOP)[endpoint]
let decision = 0
if cmp >= 0.9
let code = trial
let decision = 1
end
echo 220 2 $&trial $&cmp $&top 1.01953125 $&decision >> decisions.csv
let trial = code + 2
let drive = (floor(trial / 1) - 2*floor(trial / 2))*1.8
alter VB0 = $&drive
let drive = (floor(trial / 2) - 2*floor(trial / 4))*1.8
alter VB1 = $&drive
let drive = (floor(trial / 4) - 2*floor(trial / 8))*1.8
alter VB2 = $&drive
let drive = (floor(trial / 8) - 2*floor(trial / 16))*1.8
alter VB3 = $&drive
let drive = (floor(trial / 16) - 2*floor(trial / 32))*1.8
alter VB4 = $&drive
let drive = (floor(trial / 32) - 2*floor(trial / 64))*1.8
alter VB5 = $&drive
let drive = (floor(trial / 64) - 2*floor(trial / 128))*1.8
alter VB6 = $&drive
let drive = (floor(trial / 128) - 2*floor(trial / 256))*1.8
alter VB7 = $&drive
stop when time = 0.003976
resume
delete all
let endpoint = length(time)-1
let cmp = v(COMP)[endpoint]
let top = v(TOP)[endpoint]
let decision = 0
if cmp >= 0.9
let code = trial
let decision = 1
end
echo 220 1 $&trial $&cmp $&top 1.01953125 $&decision >> decisions.csv
let trial = code + 1
let drive = (floor(trial / 1) - 2*floor(trial / 2))*1.8
alter VB0 = $&drive
let drive = (floor(trial / 2) - 2*floor(trial / 4))*1.8
alter VB1 = $&drive
let drive = (floor(trial / 4) - 2*floor(trial / 8))*1.8
alter VB2 = $&drive
let drive = (floor(trial / 8) - 2*floor(trial / 16))*1.8
alter VB3 = $&drive
let drive = (floor(trial / 16) - 2*floor(trial / 32))*1.8
alter VB4 = $&drive
let drive = (floor(trial / 32) - 2*floor(trial / 64))*1.8
alter VB5 = $&drive
let drive = (floor(trial / 64) - 2*floor(trial / 128))*1.8
alter VB6 = $&drive
let drive = (floor(trial / 128) - 2*floor(trial / 256))*1.8
alter VB7 = $&drive
stop when time = 0.003978
resume
delete all
let endpoint = length(time)-1
let cmp = v(COMP)[endpoint]
let top = v(TOP)[endpoint]
let decision = 0
if cmp >= 0.9
let code = trial
let decision = 1
end
echo 220 0 $&trial $&cmp $&top 1.01953125 $&decision >> decisions.csv
alter VIN = 1.02421875
alter VSAMPLE = 1.8
alter VB0 = 0
alter VB1 = 0
alter VB2 = 0
alter VB3 = 0
alter VB4 = 0
alter VB5 = 0
alter VB6 = 0
alter VB7 = 0
let code = 0
stop when time = 0.00398
resume
delete all
alter VSAMPLE = 0
let trial = code + 128
let drive = (floor(trial / 1) - 2*floor(trial / 2))*1.8
alter VB0 = $&drive
let drive = (floor(trial / 2) - 2*floor(trial / 4))*1.8
alter VB1 = $&drive
let drive = (floor(trial / 4) - 2*floor(trial / 8))*1.8
alter VB2 = $&drive
let drive = (floor(trial / 8) - 2*floor(trial / 16))*1.8
alter VB3 = $&drive
let drive = (floor(trial / 16) - 2*floor(trial / 32))*1.8
alter VB4 = $&drive
let drive = (floor(trial / 32) - 2*floor(trial / 64))*1.8
alter VB5 = $&drive
let drive = (floor(trial / 64) - 2*floor(trial / 128))*1.8
alter VB6 = $&drive
let drive = (floor(trial / 128) - 2*floor(trial / 256))*1.8
alter VB7 = $&drive
stop when time = 0.003982
resume
delete all
let endpoint = length(time)-1
let cmp = v(COMP)[endpoint]
let top = v(TOP)[endpoint]
let decision = 0
if cmp >= 0.9
let code = trial
let decision = 1
end
echo 221 7 $&trial $&cmp $&top 1.02421875 $&decision >> decisions.csv
let trial = code + 64
let drive = (floor(trial / 1) - 2*floor(trial / 2))*1.8
alter VB0 = $&drive
let drive = (floor(trial / 2) - 2*floor(trial / 4))*1.8
alter VB1 = $&drive
let drive = (floor(trial / 4) - 2*floor(trial / 8))*1.8
alter VB2 = $&drive
let drive = (floor(trial / 8) - 2*floor(trial / 16))*1.8
alter VB3 = $&drive
let drive = (floor(trial / 16) - 2*floor(trial / 32))*1.8
alter VB4 = $&drive
let drive = (floor(trial / 32) - 2*floor(trial / 64))*1.8
alter VB5 = $&drive
let drive = (floor(trial / 64) - 2*floor(trial / 128))*1.8
alter VB6 = $&drive
let drive = (floor(trial / 128) - 2*floor(trial / 256))*1.8
alter VB7 = $&drive
stop when time = 0.003984
resume
delete all
let endpoint = length(time)-1
let cmp = v(COMP)[endpoint]
let top = v(TOP)[endpoint]
let decision = 0
if cmp >= 0.9
let code = trial
let decision = 1
end
echo 221 6 $&trial $&cmp $&top 1.02421875 $&decision >> decisions.csv
let trial = code + 32
let drive = (floor(trial / 1) - 2*floor(trial / 2))*1.8
alter VB0 = $&drive
let drive = (floor(trial / 2) - 2*floor(trial / 4))*1.8
alter VB1 = $&drive
let drive = (floor(trial / 4) - 2*floor(trial / 8))*1.8
alter VB2 = $&drive
let drive = (floor(trial / 8) - 2*floor(trial / 16))*1.8
alter VB3 = $&drive
let drive = (floor(trial / 16) - 2*floor(trial / 32))*1.8
alter VB4 = $&drive
let drive = (floor(trial / 32) - 2*floor(trial / 64))*1.8
alter VB5 = $&drive
let drive = (floor(trial / 64) - 2*floor(trial / 128))*1.8
alter VB6 = $&drive
let drive = (floor(trial / 128) - 2*floor(trial / 256))*1.8
alter VB7 = $&drive
stop when time = 0.003986
resume
delete all
let endpoint = length(time)-1
let cmp = v(COMP)[endpoint]
let top = v(TOP)[endpoint]
let decision = 0
if cmp >= 0.9
let code = trial
let decision = 1
end
echo 221 5 $&trial $&cmp $&top 1.02421875 $&decision >> decisions.csv
let trial = code + 16
let drive = (floor(trial / 1) - 2*floor(trial / 2))*1.8
alter VB0 = $&drive
let drive = (floor(trial / 2) - 2*floor(trial / 4))*1.8
alter VB1 = $&drive
let drive = (floor(trial / 4) - 2*floor(trial / 8))*1.8
alter VB2 = $&drive
let drive = (floor(trial / 8) - 2*floor(trial / 16))*1.8
alter VB3 = $&drive
let drive = (floor(trial / 16) - 2*floor(trial / 32))*1.8
alter VB4 = $&drive
let drive = (floor(trial / 32) - 2*floor(trial / 64))*1.8
alter VB5 = $&drive
let drive = (floor(trial / 64) - 2*floor(trial / 128))*1.8
alter VB6 = $&drive
let drive = (floor(trial / 128) - 2*floor(trial / 256))*1.8
alter VB7 = $&drive
stop when time = 0.003988
resume
delete all
let endpoint = length(time)-1
let cmp = v(COMP)[endpoint]
let top = v(TOP)[endpoint]
let decision = 0
if cmp >= 0.9
let code = trial
let decision = 1
end
echo 221 4 $&trial $&cmp $&top 1.02421875 $&decision >> decisions.csv
let trial = code + 8
let drive = (floor(trial / 1) - 2*floor(trial / 2))*1.8
alter VB0 = $&drive
let drive = (floor(trial / 2) - 2*floor(trial / 4))*1.8
alter VB1 = $&drive
let drive = (floor(trial / 4) - 2*floor(trial / 8))*1.8
alter VB2 = $&drive
let drive = (floor(trial / 8) - 2*floor(trial / 16))*1.8
alter VB3 = $&drive
let drive = (floor(trial / 16) - 2*floor(trial / 32))*1.8
alter VB4 = $&drive
let drive = (floor(trial / 32) - 2*floor(trial / 64))*1.8
alter VB5 = $&drive
let drive = (floor(trial / 64) - 2*floor(trial / 128))*1.8
alter VB6 = $&drive
let drive = (floor(trial / 128) - 2*floor(trial / 256))*1.8
alter VB7 = $&drive
stop when time = 0.00399
resume
delete all
let endpoint = length(time)-1
let cmp = v(COMP)[endpoint]
let top = v(TOP)[endpoint]
let decision = 0
if cmp >= 0.9
let code = trial
let decision = 1
end
echo 221 3 $&trial $&cmp $&top 1.02421875 $&decision >> decisions.csv
let trial = code + 4
let drive = (floor(trial / 1) - 2*floor(trial / 2))*1.8
alter VB0 = $&drive
let drive = (floor(trial / 2) - 2*floor(trial / 4))*1.8
alter VB1 = $&drive
let drive = (floor(trial / 4) - 2*floor(trial / 8))*1.8
alter VB2 = $&drive
let drive = (floor(trial / 8) - 2*floor(trial / 16))*1.8
alter VB3 = $&drive
let drive = (floor(trial / 16) - 2*floor(trial / 32))*1.8
alter VB4 = $&drive
let drive = (floor(trial / 32) - 2*floor(trial / 64))*1.8
alter VB5 = $&drive
let drive = (floor(trial / 64) - 2*floor(trial / 128))*1.8
alter VB6 = $&drive
let drive = (floor(trial / 128) - 2*floor(trial / 256))*1.8
alter VB7 = $&drive
stop when time = 0.003992
resume
delete all
let endpoint = length(time)-1
let cmp = v(COMP)[endpoint]
let top = v(TOP)[endpoint]
let decision = 0
if cmp >= 0.9
let code = trial
let decision = 1
end
echo 221 2 $&trial $&cmp $&top 1.02421875 $&decision >> decisions.csv
let trial = code + 2
let drive = (floor(trial / 1) - 2*floor(trial / 2))*1.8
alter VB0 = $&drive
let drive = (floor(trial / 2) - 2*floor(trial / 4))*1.8
alter VB1 = $&drive
let drive = (floor(trial / 4) - 2*floor(trial / 8))*1.8
alter VB2 = $&drive
let drive = (floor(trial / 8) - 2*floor(trial / 16))*1.8
alter VB3 = $&drive
let drive = (floor(trial / 16) - 2*floor(trial / 32))*1.8
alter VB4 = $&drive
let drive = (floor(trial / 32) - 2*floor(trial / 64))*1.8
alter VB5 = $&drive
let drive = (floor(trial / 64) - 2*floor(trial / 128))*1.8
alter VB6 = $&drive
let drive = (floor(trial / 128) - 2*floor(trial / 256))*1.8
alter VB7 = $&drive
stop when time = 0.003994
resume
delete all
let endpoint = length(time)-1
let cmp = v(COMP)[endpoint]
let top = v(TOP)[endpoint]
let decision = 0
if cmp >= 0.9
let code = trial
let decision = 1
end
echo 221 1 $&trial $&cmp $&top 1.02421875 $&decision >> decisions.csv
let trial = code + 1
let drive = (floor(trial / 1) - 2*floor(trial / 2))*1.8
alter VB0 = $&drive
let drive = (floor(trial / 2) - 2*floor(trial / 4))*1.8
alter VB1 = $&drive
let drive = (floor(trial / 4) - 2*floor(trial / 8))*1.8
alter VB2 = $&drive
let drive = (floor(trial / 8) - 2*floor(trial / 16))*1.8
alter VB3 = $&drive
let drive = (floor(trial / 16) - 2*floor(trial / 32))*1.8
alter VB4 = $&drive
let drive = (floor(trial / 32) - 2*floor(trial / 64))*1.8
alter VB5 = $&drive
let drive = (floor(trial / 64) - 2*floor(trial / 128))*1.8
alter VB6 = $&drive
let drive = (floor(trial / 128) - 2*floor(trial / 256))*1.8
alter VB7 = $&drive
stop when time = 0.003996
resume
delete all
let endpoint = length(time)-1
let cmp = v(COMP)[endpoint]
let top = v(TOP)[endpoint]
let decision = 0
if cmp >= 0.9
let code = trial
let decision = 1
end
echo 221 0 $&trial $&cmp $&top 1.02421875 $&decision >> decisions.csv
alter VIN = 1.02890625
alter VSAMPLE = 1.8
alter VB0 = 0
alter VB1 = 0
alter VB2 = 0
alter VB3 = 0
alter VB4 = 0
alter VB5 = 0
alter VB6 = 0
alter VB7 = 0
let code = 0
stop when time = 0.003998
resume
delete all
alter VSAMPLE = 0
let trial = code + 128
let drive = (floor(trial / 1) - 2*floor(trial / 2))*1.8
alter VB0 = $&drive
let drive = (floor(trial / 2) - 2*floor(trial / 4))*1.8
alter VB1 = $&drive
let drive = (floor(trial / 4) - 2*floor(trial / 8))*1.8
alter VB2 = $&drive
let drive = (floor(trial / 8) - 2*floor(trial / 16))*1.8
alter VB3 = $&drive
let drive = (floor(trial / 16) - 2*floor(trial / 32))*1.8
alter VB4 = $&drive
let drive = (floor(trial / 32) - 2*floor(trial / 64))*1.8
alter VB5 = $&drive
let drive = (floor(trial / 64) - 2*floor(trial / 128))*1.8
alter VB6 = $&drive
let drive = (floor(trial / 128) - 2*floor(trial / 256))*1.8
alter VB7 = $&drive
stop when time = 0.004
resume
delete all
let endpoint = length(time)-1
let cmp = v(COMP)[endpoint]
let top = v(TOP)[endpoint]
let decision = 0
if cmp >= 0.9
let code = trial
let decision = 1
end
echo 222 7 $&trial $&cmp $&top 1.02890625 $&decision >> decisions.csv
let trial = code + 64
let drive = (floor(trial / 1) - 2*floor(trial / 2))*1.8
alter VB0 = $&drive
let drive = (floor(trial / 2) - 2*floor(trial / 4))*1.8
alter VB1 = $&drive
let drive = (floor(trial / 4) - 2*floor(trial / 8))*1.8
alter VB2 = $&drive
let drive = (floor(trial / 8) - 2*floor(trial / 16))*1.8
alter VB3 = $&drive
let drive = (floor(trial / 16) - 2*floor(trial / 32))*1.8
alter VB4 = $&drive
let drive = (floor(trial / 32) - 2*floor(trial / 64))*1.8
alter VB5 = $&drive
let drive = (floor(trial / 64) - 2*floor(trial / 128))*1.8
alter VB6 = $&drive
let drive = (floor(trial / 128) - 2*floor(trial / 256))*1.8
alter VB7 = $&drive
stop when time = 0.004002
resume
delete all
let endpoint = length(time)-1
let cmp = v(COMP)[endpoint]
let top = v(TOP)[endpoint]
let decision = 0
if cmp >= 0.9
let code = trial
let decision = 1
end
echo 222 6 $&trial $&cmp $&top 1.02890625 $&decision >> decisions.csv
let trial = code + 32
let drive = (floor(trial / 1) - 2*floor(trial / 2))*1.8
alter VB0 = $&drive
let drive = (floor(trial / 2) - 2*floor(trial / 4))*1.8
alter VB1 = $&drive
let drive = (floor(trial / 4) - 2*floor(trial / 8))*1.8
alter VB2 = $&drive
let drive = (floor(trial / 8) - 2*floor(trial / 16))*1.8
alter VB3 = $&drive
let drive = (floor(trial / 16) - 2*floor(trial / 32))*1.8
alter VB4 = $&drive
let drive = (floor(trial / 32) - 2*floor(trial / 64))*1.8
alter VB5 = $&drive
let drive = (floor(trial / 64) - 2*floor(trial / 128))*1.8
alter VB6 = $&drive
let drive = (floor(trial / 128) - 2*floor(trial / 256))*1.8
alter VB7 = $&drive
stop when time = 0.004004
resume
delete all
let endpoint = length(time)-1
let cmp = v(COMP)[endpoint]
let top = v(TOP)[endpoint]
let decision = 0
if cmp >= 0.9
let code = trial
let decision = 1
end
echo 222 5 $&trial $&cmp $&top 1.02890625 $&decision >> decisions.csv
let trial = code + 16
let drive = (floor(trial / 1) - 2*floor(trial / 2))*1.8
alter VB0 = $&drive
let drive = (floor(trial / 2) - 2*floor(trial / 4))*1.8
alter VB1 = $&drive
let drive = (floor(trial / 4) - 2*floor(trial / 8))*1.8
alter VB2 = $&drive
let drive = (floor(trial / 8) - 2*floor(trial / 16))*1.8
alter VB3 = $&drive
let drive = (floor(trial / 16) - 2*floor(trial / 32))*1.8
alter VB4 = $&drive
let drive = (floor(trial / 32) - 2*floor(trial / 64))*1.8
alter VB5 = $&drive
let drive = (floor(trial / 64) - 2*floor(trial / 128))*1.8
alter VB6 = $&drive
let drive = (floor(trial / 128) - 2*floor(trial / 256))*1.8
alter VB7 = $&drive
stop when time = 0.004006
resume
delete all
let endpoint = length(time)-1
let cmp = v(COMP)[endpoint]
let top = v(TOP)[endpoint]
let decision = 0
if cmp >= 0.9
let code = trial
let decision = 1
end
echo 222 4 $&trial $&cmp $&top 1.02890625 $&decision >> decisions.csv
let trial = code + 8
let drive = (floor(trial / 1) - 2*floor(trial / 2))*1.8
alter VB0 = $&drive
let drive = (floor(trial / 2) - 2*floor(trial / 4))*1.8
alter VB1 = $&drive
let drive = (floor(trial / 4) - 2*floor(trial / 8))*1.8
alter VB2 = $&drive
let drive = (floor(trial / 8) - 2*floor(trial / 16))*1.8
alter VB3 = $&drive
let drive = (floor(trial / 16) - 2*floor(trial / 32))*1.8
alter VB4 = $&drive
let drive = (floor(trial / 32) - 2*floor(trial / 64))*1.8
alter VB5 = $&drive
let drive = (floor(trial / 64) - 2*floor(trial / 128))*1.8
alter VB6 = $&drive
let drive = (floor(trial / 128) - 2*floor(trial / 256))*1.8
alter VB7 = $&drive
stop when time = 0.004008
resume
delete all
let endpoint = length(time)-1
let cmp = v(COMP)[endpoint]
let top = v(TOP)[endpoint]
let decision = 0
if cmp >= 0.9
let code = trial
let decision = 1
end
echo 222 3 $&trial $&cmp $&top 1.02890625 $&decision >> decisions.csv
let trial = code + 4
let drive = (floor(trial / 1) - 2*floor(trial / 2))*1.8
alter VB0 = $&drive
let drive = (floor(trial / 2) - 2*floor(trial / 4))*1.8
alter VB1 = $&drive
let drive = (floor(trial / 4) - 2*floor(trial / 8))*1.8
alter VB2 = $&drive
let drive = (floor(trial / 8) - 2*floor(trial / 16))*1.8
alter VB3 = $&drive
let drive = (floor(trial / 16) - 2*floor(trial / 32))*1.8
alter VB4 = $&drive
let drive = (floor(trial / 32) - 2*floor(trial / 64))*1.8
alter VB5 = $&drive
let drive = (floor(trial / 64) - 2*floor(trial / 128))*1.8
alter VB6 = $&drive
let drive = (floor(trial / 128) - 2*floor(trial / 256))*1.8
alter VB7 = $&drive
stop when time = 0.00401
resume
delete all
let endpoint = length(time)-1
let cmp = v(COMP)[endpoint]
let top = v(TOP)[endpoint]
let decision = 0
if cmp >= 0.9
let code = trial
let decision = 1
end
echo 222 2 $&trial $&cmp $&top 1.02890625 $&decision >> decisions.csv
let trial = code + 2
let drive = (floor(trial / 1) - 2*floor(trial / 2))*1.8
alter VB0 = $&drive
let drive = (floor(trial / 2) - 2*floor(trial / 4))*1.8
alter VB1 = $&drive
let drive = (floor(trial / 4) - 2*floor(trial / 8))*1.8
alter VB2 = $&drive
let drive = (floor(trial / 8) - 2*floor(trial / 16))*1.8
alter VB3 = $&drive
let drive = (floor(trial / 16) - 2*floor(trial / 32))*1.8
alter VB4 = $&drive
let drive = (floor(trial / 32) - 2*floor(trial / 64))*1.8
alter VB5 = $&drive
let drive = (floor(trial / 64) - 2*floor(trial / 128))*1.8
alter VB6 = $&drive
let drive = (floor(trial / 128) - 2*floor(trial / 256))*1.8
alter VB7 = $&drive
stop when time = 0.004012
resume
delete all
let endpoint = length(time)-1
let cmp = v(COMP)[endpoint]
let top = v(TOP)[endpoint]
let decision = 0
if cmp >= 0.9
let code = trial
let decision = 1
end
echo 222 1 $&trial $&cmp $&top 1.02890625 $&decision >> decisions.csv
let trial = code + 1
let drive = (floor(trial / 1) - 2*floor(trial / 2))*1.8
alter VB0 = $&drive
let drive = (floor(trial / 2) - 2*floor(trial / 4))*1.8
alter VB1 = $&drive
let drive = (floor(trial / 4) - 2*floor(trial / 8))*1.8
alter VB2 = $&drive
let drive = (floor(trial / 8) - 2*floor(trial / 16))*1.8
alter VB3 = $&drive
let drive = (floor(trial / 16) - 2*floor(trial / 32))*1.8
alter VB4 = $&drive
let drive = (floor(trial / 32) - 2*floor(trial / 64))*1.8
alter VB5 = $&drive
let drive = (floor(trial / 64) - 2*floor(trial / 128))*1.8
alter VB6 = $&drive
let drive = (floor(trial / 128) - 2*floor(trial / 256))*1.8
alter VB7 = $&drive
stop when time = 0.004014
resume
delete all
let endpoint = length(time)-1
let cmp = v(COMP)[endpoint]
let top = v(TOP)[endpoint]
let decision = 0
if cmp >= 0.9
let code = trial
let decision = 1
end
echo 222 0 $&trial $&cmp $&top 1.02890625 $&decision >> decisions.csv
alter VIN = 1.03359375
alter VSAMPLE = 1.8
alter VB0 = 0
alter VB1 = 0
alter VB2 = 0
alter VB3 = 0
alter VB4 = 0
alter VB5 = 0
alter VB6 = 0
alter VB7 = 0
let code = 0
stop when time = 0.004016
resume
delete all
alter VSAMPLE = 0
let trial = code + 128
let drive = (floor(trial / 1) - 2*floor(trial / 2))*1.8
alter VB0 = $&drive
let drive = (floor(trial / 2) - 2*floor(trial / 4))*1.8
alter VB1 = $&drive
let drive = (floor(trial / 4) - 2*floor(trial / 8))*1.8
alter VB2 = $&drive
let drive = (floor(trial / 8) - 2*floor(trial / 16))*1.8
alter VB3 = $&drive
let drive = (floor(trial / 16) - 2*floor(trial / 32))*1.8
alter VB4 = $&drive
let drive = (floor(trial / 32) - 2*floor(trial / 64))*1.8
alter VB5 = $&drive
let drive = (floor(trial / 64) - 2*floor(trial / 128))*1.8
alter VB6 = $&drive
let drive = (floor(trial / 128) - 2*floor(trial / 256))*1.8
alter VB7 = $&drive
stop when time = 0.004018
resume
delete all
let endpoint = length(time)-1
let cmp = v(COMP)[endpoint]
let top = v(TOP)[endpoint]
let decision = 0
if cmp >= 0.9
let code = trial
let decision = 1
end
echo 223 7 $&trial $&cmp $&top 1.03359375 $&decision >> decisions.csv
let trial = code + 64
let drive = (floor(trial / 1) - 2*floor(trial / 2))*1.8
alter VB0 = $&drive
let drive = (floor(trial / 2) - 2*floor(trial / 4))*1.8
alter VB1 = $&drive
let drive = (floor(trial / 4) - 2*floor(trial / 8))*1.8
alter VB2 = $&drive
let drive = (floor(trial / 8) - 2*floor(trial / 16))*1.8
alter VB3 = $&drive
let drive = (floor(trial / 16) - 2*floor(trial / 32))*1.8
alter VB4 = $&drive
let drive = (floor(trial / 32) - 2*floor(trial / 64))*1.8
alter VB5 = $&drive
let drive = (floor(trial / 64) - 2*floor(trial / 128))*1.8
alter VB6 = $&drive
let drive = (floor(trial / 128) - 2*floor(trial / 256))*1.8
alter VB7 = $&drive
stop when time = 0.00402
resume
delete all
let endpoint = length(time)-1
let cmp = v(COMP)[endpoint]
let top = v(TOP)[endpoint]
let decision = 0
if cmp >= 0.9
let code = trial
let decision = 1
end
echo 223 6 $&trial $&cmp $&top 1.03359375 $&decision >> decisions.csv
let trial = code + 32
let drive = (floor(trial / 1) - 2*floor(trial / 2))*1.8
alter VB0 = $&drive
let drive = (floor(trial / 2) - 2*floor(trial / 4))*1.8
alter VB1 = $&drive
let drive = (floor(trial / 4) - 2*floor(trial / 8))*1.8
alter VB2 = $&drive
let drive = (floor(trial / 8) - 2*floor(trial / 16))*1.8
alter VB3 = $&drive
let drive = (floor(trial / 16) - 2*floor(trial / 32))*1.8
alter VB4 = $&drive
let drive = (floor(trial / 32) - 2*floor(trial / 64))*1.8
alter VB5 = $&drive
let drive = (floor(trial / 64) - 2*floor(trial / 128))*1.8
alter VB6 = $&drive
let drive = (floor(trial / 128) - 2*floor(trial / 256))*1.8
alter VB7 = $&drive
stop when time = 0.004022
resume
delete all
let endpoint = length(time)-1
let cmp = v(COMP)[endpoint]
let top = v(TOP)[endpoint]
let decision = 0
if cmp >= 0.9
let code = trial
let decision = 1
end
echo 223 5 $&trial $&cmp $&top 1.03359375 $&decision >> decisions.csv
let trial = code + 16
let drive = (floor(trial / 1) - 2*floor(trial / 2))*1.8
alter VB0 = $&drive
let drive = (floor(trial / 2) - 2*floor(trial / 4))*1.8
alter VB1 = $&drive
let drive = (floor(trial / 4) - 2*floor(trial / 8))*1.8
alter VB2 = $&drive
let drive = (floor(trial / 8) - 2*floor(trial / 16))*1.8
alter VB3 = $&drive
let drive = (floor(trial / 16) - 2*floor(trial / 32))*1.8
alter VB4 = $&drive
let drive = (floor(trial / 32) - 2*floor(trial / 64))*1.8
alter VB5 = $&drive
let drive = (floor(trial / 64) - 2*floor(trial / 128))*1.8
alter VB6 = $&drive
let drive = (floor(trial / 128) - 2*floor(trial / 256))*1.8
alter VB7 = $&drive
stop when time = 0.004024
resume
delete all
let endpoint = length(time)-1
let cmp = v(COMP)[endpoint]
let top = v(TOP)[endpoint]
let decision = 0
if cmp >= 0.9
let code = trial
let decision = 1
end
echo 223 4 $&trial $&cmp $&top 1.03359375 $&decision >> decisions.csv
let trial = code + 8
let drive = (floor(trial / 1) - 2*floor(trial / 2))*1.8
alter VB0 = $&drive
let drive = (floor(trial / 2) - 2*floor(trial / 4))*1.8
alter VB1 = $&drive
let drive = (floor(trial / 4) - 2*floor(trial / 8))*1.8
alter VB2 = $&drive
let drive = (floor(trial / 8) - 2*floor(trial / 16))*1.8
alter VB3 = $&drive
let drive = (floor(trial / 16) - 2*floor(trial / 32))*1.8
alter VB4 = $&drive
let drive = (floor(trial / 32) - 2*floor(trial / 64))*1.8
alter VB5 = $&drive
let drive = (floor(trial / 64) - 2*floor(trial / 128))*1.8
alter VB6 = $&drive
let drive = (floor(trial / 128) - 2*floor(trial / 256))*1.8
alter VB7 = $&drive
stop when time = 0.004026
resume
delete all
let endpoint = length(time)-1
let cmp = v(COMP)[endpoint]
let top = v(TOP)[endpoint]
let decision = 0
if cmp >= 0.9
let code = trial
let decision = 1
end
echo 223 3 $&trial $&cmp $&top 1.03359375 $&decision >> decisions.csv
let trial = code + 4
let drive = (floor(trial / 1) - 2*floor(trial / 2))*1.8
alter VB0 = $&drive
let drive = (floor(trial / 2) - 2*floor(trial / 4))*1.8
alter VB1 = $&drive
let drive = (floor(trial / 4) - 2*floor(trial / 8))*1.8
alter VB2 = $&drive
let drive = (floor(trial / 8) - 2*floor(trial / 16))*1.8
alter VB3 = $&drive
let drive = (floor(trial / 16) - 2*floor(trial / 32))*1.8
alter VB4 = $&drive
let drive = (floor(trial / 32) - 2*floor(trial / 64))*1.8
alter VB5 = $&drive
let drive = (floor(trial / 64) - 2*floor(trial / 128))*1.8
alter VB6 = $&drive
let drive = (floor(trial / 128) - 2*floor(trial / 256))*1.8
alter VB7 = $&drive
stop when time = 0.004028
resume
delete all
let endpoint = length(time)-1
let cmp = v(COMP)[endpoint]
let top = v(TOP)[endpoint]
let decision = 0
if cmp >= 0.9
let code = trial
let decision = 1
end
echo 223 2 $&trial $&cmp $&top 1.03359375 $&decision >> decisions.csv
let trial = code + 2
let drive = (floor(trial / 1) - 2*floor(trial / 2))*1.8
alter VB0 = $&drive
let drive = (floor(trial / 2) - 2*floor(trial / 4))*1.8
alter VB1 = $&drive
let drive = (floor(trial / 4) - 2*floor(trial / 8))*1.8
alter VB2 = $&drive
let drive = (floor(trial / 8) - 2*floor(trial / 16))*1.8
alter VB3 = $&drive
let drive = (floor(trial / 16) - 2*floor(trial / 32))*1.8
alter VB4 = $&drive
let drive = (floor(trial / 32) - 2*floor(trial / 64))*1.8
alter VB5 = $&drive
let drive = (floor(trial / 64) - 2*floor(trial / 128))*1.8
alter VB6 = $&drive
let drive = (floor(trial / 128) - 2*floor(trial / 256))*1.8
alter VB7 = $&drive
stop when time = 0.00403
resume
delete all
let endpoint = length(time)-1
let cmp = v(COMP)[endpoint]
let top = v(TOP)[endpoint]
let decision = 0
if cmp >= 0.9
let code = trial
let decision = 1
end
echo 223 1 $&trial $&cmp $&top 1.03359375 $&decision >> decisions.csv
let trial = code + 1
let drive = (floor(trial / 1) - 2*floor(trial / 2))*1.8
alter VB0 = $&drive
let drive = (floor(trial / 2) - 2*floor(trial / 4))*1.8
alter VB1 = $&drive
let drive = (floor(trial / 4) - 2*floor(trial / 8))*1.8
alter VB2 = $&drive
let drive = (floor(trial / 8) - 2*floor(trial / 16))*1.8
alter VB3 = $&drive
let drive = (floor(trial / 16) - 2*floor(trial / 32))*1.8
alter VB4 = $&drive
let drive = (floor(trial / 32) - 2*floor(trial / 64))*1.8
alter VB5 = $&drive
let drive = (floor(trial / 64) - 2*floor(trial / 128))*1.8
alter VB6 = $&drive
let drive = (floor(trial / 128) - 2*floor(trial / 256))*1.8
alter VB7 = $&drive
stop when time = 0.004032
resume
delete all
let endpoint = length(time)-1
let cmp = v(COMP)[endpoint]
let top = v(TOP)[endpoint]
let decision = 0
if cmp >= 0.9
let code = trial
let decision = 1
end
echo 223 0 $&trial $&cmp $&top 1.03359375 $&decision >> decisions.csv
alter VIN = 1.03828125
alter VSAMPLE = 1.8
alter VB0 = 0
alter VB1 = 0
alter VB2 = 0
alter VB3 = 0
alter VB4 = 0
alter VB5 = 0
alter VB6 = 0
alter VB7 = 0
let code = 0
stop when time = 0.004034
resume
delete all
alter VSAMPLE = 0
let trial = code + 128
let drive = (floor(trial / 1) - 2*floor(trial / 2))*1.8
alter VB0 = $&drive
let drive = (floor(trial / 2) - 2*floor(trial / 4))*1.8
alter VB1 = $&drive
let drive = (floor(trial / 4) - 2*floor(trial / 8))*1.8
alter VB2 = $&drive
let drive = (floor(trial / 8) - 2*floor(trial / 16))*1.8
alter VB3 = $&drive
let drive = (floor(trial / 16) - 2*floor(trial / 32))*1.8
alter VB4 = $&drive
let drive = (floor(trial / 32) - 2*floor(trial / 64))*1.8
alter VB5 = $&drive
let drive = (floor(trial / 64) - 2*floor(trial / 128))*1.8
alter VB6 = $&drive
let drive = (floor(trial / 128) - 2*floor(trial / 256))*1.8
alter VB7 = $&drive
stop when time = 0.004036
resume
delete all
let endpoint = length(time)-1
let cmp = v(COMP)[endpoint]
let top = v(TOP)[endpoint]
let decision = 0
if cmp >= 0.9
let code = trial
let decision = 1
end
echo 224 7 $&trial $&cmp $&top 1.03828125 $&decision >> decisions.csv
let trial = code + 64
let drive = (floor(trial / 1) - 2*floor(trial / 2))*1.8
alter VB0 = $&drive
let drive = (floor(trial / 2) - 2*floor(trial / 4))*1.8
alter VB1 = $&drive
let drive = (floor(trial / 4) - 2*floor(trial / 8))*1.8
alter VB2 = $&drive
let drive = (floor(trial / 8) - 2*floor(trial / 16))*1.8
alter VB3 = $&drive
let drive = (floor(trial / 16) - 2*floor(trial / 32))*1.8
alter VB4 = $&drive
let drive = (floor(trial / 32) - 2*floor(trial / 64))*1.8
alter VB5 = $&drive
let drive = (floor(trial / 64) - 2*floor(trial / 128))*1.8
alter VB6 = $&drive
let drive = (floor(trial / 128) - 2*floor(trial / 256))*1.8
alter VB7 = $&drive
stop when time = 0.004038
resume
delete all
let endpoint = length(time)-1
let cmp = v(COMP)[endpoint]
let top = v(TOP)[endpoint]
let decision = 0
if cmp >= 0.9
let code = trial
let decision = 1
end
echo 224 6 $&trial $&cmp $&top 1.03828125 $&decision >> decisions.csv
let trial = code + 32
let drive = (floor(trial / 1) - 2*floor(trial / 2))*1.8
alter VB0 = $&drive
let drive = (floor(trial / 2) - 2*floor(trial / 4))*1.8
alter VB1 = $&drive
let drive = (floor(trial / 4) - 2*floor(trial / 8))*1.8
alter VB2 = $&drive
let drive = (floor(trial / 8) - 2*floor(trial / 16))*1.8
alter VB3 = $&drive
let drive = (floor(trial / 16) - 2*floor(trial / 32))*1.8
alter VB4 = $&drive
let drive = (floor(trial / 32) - 2*floor(trial / 64))*1.8
alter VB5 = $&drive
let drive = (floor(trial / 64) - 2*floor(trial / 128))*1.8
alter VB6 = $&drive
let drive = (floor(trial / 128) - 2*floor(trial / 256))*1.8
alter VB7 = $&drive
stop when time = 0.00404
resume
delete all
let endpoint = length(time)-1
let cmp = v(COMP)[endpoint]
let top = v(TOP)[endpoint]
let decision = 0
if cmp >= 0.9
let code = trial
let decision = 1
end
echo 224 5 $&trial $&cmp $&top 1.03828125 $&decision >> decisions.csv
let trial = code + 16
let drive = (floor(trial / 1) - 2*floor(trial / 2))*1.8
alter VB0 = $&drive
let drive = (floor(trial / 2) - 2*floor(trial / 4))*1.8
alter VB1 = $&drive
let drive = (floor(trial / 4) - 2*floor(trial / 8))*1.8
alter VB2 = $&drive
let drive = (floor(trial / 8) - 2*floor(trial / 16))*1.8
alter VB3 = $&drive
let drive = (floor(trial / 16) - 2*floor(trial / 32))*1.8
alter VB4 = $&drive
let drive = (floor(trial / 32) - 2*floor(trial / 64))*1.8
alter VB5 = $&drive
let drive = (floor(trial / 64) - 2*floor(trial / 128))*1.8
alter VB6 = $&drive
let drive = (floor(trial / 128) - 2*floor(trial / 256))*1.8
alter VB7 = $&drive
stop when time = 0.004042
resume
delete all
let endpoint = length(time)-1
let cmp = v(COMP)[endpoint]
let top = v(TOP)[endpoint]
let decision = 0
if cmp >= 0.9
let code = trial
let decision = 1
end
echo 224 4 $&trial $&cmp $&top 1.03828125 $&decision >> decisions.csv
let trial = code + 8
let drive = (floor(trial / 1) - 2*floor(trial / 2))*1.8
alter VB0 = $&drive
let drive = (floor(trial / 2) - 2*floor(trial / 4))*1.8
alter VB1 = $&drive
let drive = (floor(trial / 4) - 2*floor(trial / 8))*1.8
alter VB2 = $&drive
let drive = (floor(trial / 8) - 2*floor(trial / 16))*1.8
alter VB3 = $&drive
let drive = (floor(trial / 16) - 2*floor(trial / 32))*1.8
alter VB4 = $&drive
let drive = (floor(trial / 32) - 2*floor(trial / 64))*1.8
alter VB5 = $&drive
let drive = (floor(trial / 64) - 2*floor(trial / 128))*1.8
alter VB6 = $&drive
let drive = (floor(trial / 128) - 2*floor(trial / 256))*1.8
alter VB7 = $&drive
stop when time = 0.004044
resume
delete all
let endpoint = length(time)-1
let cmp = v(COMP)[endpoint]
let top = v(TOP)[endpoint]
let decision = 0
if cmp >= 0.9
let code = trial
let decision = 1
end
echo 224 3 $&trial $&cmp $&top 1.03828125 $&decision >> decisions.csv
let trial = code + 4
let drive = (floor(trial / 1) - 2*floor(trial / 2))*1.8
alter VB0 = $&drive
let drive = (floor(trial / 2) - 2*floor(trial / 4))*1.8
alter VB1 = $&drive
let drive = (floor(trial / 4) - 2*floor(trial / 8))*1.8
alter VB2 = $&drive
let drive = (floor(trial / 8) - 2*floor(trial / 16))*1.8
alter VB3 = $&drive
let drive = (floor(trial / 16) - 2*floor(trial / 32))*1.8
alter VB4 = $&drive
let drive = (floor(trial / 32) - 2*floor(trial / 64))*1.8
alter VB5 = $&drive
let drive = (floor(trial / 64) - 2*floor(trial / 128))*1.8
alter VB6 = $&drive
let drive = (floor(trial / 128) - 2*floor(trial / 256))*1.8
alter VB7 = $&drive
stop when time = 0.004046
resume
delete all
let endpoint = length(time)-1
let cmp = v(COMP)[endpoint]
let top = v(TOP)[endpoint]
let decision = 0
if cmp >= 0.9
let code = trial
let decision = 1
end
echo 224 2 $&trial $&cmp $&top 1.03828125 $&decision >> decisions.csv
let trial = code + 2
let drive = (floor(trial / 1) - 2*floor(trial / 2))*1.8
alter VB0 = $&drive
let drive = (floor(trial / 2) - 2*floor(trial / 4))*1.8
alter VB1 = $&drive
let drive = (floor(trial / 4) - 2*floor(trial / 8))*1.8
alter VB2 = $&drive
let drive = (floor(trial / 8) - 2*floor(trial / 16))*1.8
alter VB3 = $&drive
let drive = (floor(trial / 16) - 2*floor(trial / 32))*1.8
alter VB4 = $&drive
let drive = (floor(trial / 32) - 2*floor(trial / 64))*1.8
alter VB5 = $&drive
let drive = (floor(trial / 64) - 2*floor(trial / 128))*1.8
alter VB6 = $&drive
let drive = (floor(trial / 128) - 2*floor(trial / 256))*1.8
alter VB7 = $&drive
stop when time = 0.004048
resume
delete all
let endpoint = length(time)-1
let cmp = v(COMP)[endpoint]
let top = v(TOP)[endpoint]
let decision = 0
if cmp >= 0.9
let code = trial
let decision = 1
end
echo 224 1 $&trial $&cmp $&top 1.03828125 $&decision >> decisions.csv
let trial = code + 1
let drive = (floor(trial / 1) - 2*floor(trial / 2))*1.8
alter VB0 = $&drive
let drive = (floor(trial / 2) - 2*floor(trial / 4))*1.8
alter VB1 = $&drive
let drive = (floor(trial / 4) - 2*floor(trial / 8))*1.8
alter VB2 = $&drive
let drive = (floor(trial / 8) - 2*floor(trial / 16))*1.8
alter VB3 = $&drive
let drive = (floor(trial / 16) - 2*floor(trial / 32))*1.8
alter VB4 = $&drive
let drive = (floor(trial / 32) - 2*floor(trial / 64))*1.8
alter VB5 = $&drive
let drive = (floor(trial / 64) - 2*floor(trial / 128))*1.8
alter VB6 = $&drive
let drive = (floor(trial / 128) - 2*floor(trial / 256))*1.8
alter VB7 = $&drive
stop when time = 0.00405
resume
delete all
let endpoint = length(time)-1
let cmp = v(COMP)[endpoint]
let top = v(TOP)[endpoint]
let decision = 0
if cmp >= 0.9
let code = trial
let decision = 1
end
echo 224 0 $&trial $&cmp $&top 1.03828125 $&decision >> decisions.csv
alter VIN = 1.04296875
alter VSAMPLE = 1.8
alter VB0 = 0
alter VB1 = 0
alter VB2 = 0
alter VB3 = 0
alter VB4 = 0
alter VB5 = 0
alter VB6 = 0
alter VB7 = 0
let code = 0
stop when time = 0.004052
resume
delete all
alter VSAMPLE = 0
let trial = code + 128
let drive = (floor(trial / 1) - 2*floor(trial / 2))*1.8
alter VB0 = $&drive
let drive = (floor(trial / 2) - 2*floor(trial / 4))*1.8
alter VB1 = $&drive
let drive = (floor(trial / 4) - 2*floor(trial / 8))*1.8
alter VB2 = $&drive
let drive = (floor(trial / 8) - 2*floor(trial / 16))*1.8
alter VB3 = $&drive
let drive = (floor(trial / 16) - 2*floor(trial / 32))*1.8
alter VB4 = $&drive
let drive = (floor(trial / 32) - 2*floor(trial / 64))*1.8
alter VB5 = $&drive
let drive = (floor(trial / 64) - 2*floor(trial / 128))*1.8
alter VB6 = $&drive
let drive = (floor(trial / 128) - 2*floor(trial / 256))*1.8
alter VB7 = $&drive
stop when time = 0.004054
resume
delete all
let endpoint = length(time)-1
let cmp = v(COMP)[endpoint]
let top = v(TOP)[endpoint]
let decision = 0
if cmp >= 0.9
let code = trial
let decision = 1
end
echo 225 7 $&trial $&cmp $&top 1.04296875 $&decision >> decisions.csv
let trial = code + 64
let drive = (floor(trial / 1) - 2*floor(trial / 2))*1.8
alter VB0 = $&drive
let drive = (floor(trial / 2) - 2*floor(trial / 4))*1.8
alter VB1 = $&drive
let drive = (floor(trial / 4) - 2*floor(trial / 8))*1.8
alter VB2 = $&drive
let drive = (floor(trial / 8) - 2*floor(trial / 16))*1.8
alter VB3 = $&drive
let drive = (floor(trial / 16) - 2*floor(trial / 32))*1.8
alter VB4 = $&drive
let drive = (floor(trial / 32) - 2*floor(trial / 64))*1.8
alter VB5 = $&drive
let drive = (floor(trial / 64) - 2*floor(trial / 128))*1.8
alter VB6 = $&drive
let drive = (floor(trial / 128) - 2*floor(trial / 256))*1.8
alter VB7 = $&drive
stop when time = 0.004056
resume
delete all
let endpoint = length(time)-1
let cmp = v(COMP)[endpoint]
let top = v(TOP)[endpoint]
let decision = 0
if cmp >= 0.9
let code = trial
let decision = 1
end
echo 225 6 $&trial $&cmp $&top 1.04296875 $&decision >> decisions.csv
let trial = code + 32
let drive = (floor(trial / 1) - 2*floor(trial / 2))*1.8
alter VB0 = $&drive
let drive = (floor(trial / 2) - 2*floor(trial / 4))*1.8
alter VB1 = $&drive
let drive = (floor(trial / 4) - 2*floor(trial / 8))*1.8
alter VB2 = $&drive
let drive = (floor(trial / 8) - 2*floor(trial / 16))*1.8
alter VB3 = $&drive
let drive = (floor(trial / 16) - 2*floor(trial / 32))*1.8
alter VB4 = $&drive
let drive = (floor(trial / 32) - 2*floor(trial / 64))*1.8
alter VB5 = $&drive
let drive = (floor(trial / 64) - 2*floor(trial / 128))*1.8
alter VB6 = $&drive
let drive = (floor(trial / 128) - 2*floor(trial / 256))*1.8
alter VB7 = $&drive
stop when time = 0.004058
resume
delete all
let endpoint = length(time)-1
let cmp = v(COMP)[endpoint]
let top = v(TOP)[endpoint]
let decision = 0
if cmp >= 0.9
let code = trial
let decision = 1
end
echo 225 5 $&trial $&cmp $&top 1.04296875 $&decision >> decisions.csv
let trial = code + 16
let drive = (floor(trial / 1) - 2*floor(trial / 2))*1.8
alter VB0 = $&drive
let drive = (floor(trial / 2) - 2*floor(trial / 4))*1.8
alter VB1 = $&drive
let drive = (floor(trial / 4) - 2*floor(trial / 8))*1.8
alter VB2 = $&drive
let drive = (floor(trial / 8) - 2*floor(trial / 16))*1.8
alter VB3 = $&drive
let drive = (floor(trial / 16) - 2*floor(trial / 32))*1.8
alter VB4 = $&drive
let drive = (floor(trial / 32) - 2*floor(trial / 64))*1.8
alter VB5 = $&drive
let drive = (floor(trial / 64) - 2*floor(trial / 128))*1.8
alter VB6 = $&drive
let drive = (floor(trial / 128) - 2*floor(trial / 256))*1.8
alter VB7 = $&drive
stop when time = 0.00406
resume
delete all
let endpoint = length(time)-1
let cmp = v(COMP)[endpoint]
let top = v(TOP)[endpoint]
let decision = 0
if cmp >= 0.9
let code = trial
let decision = 1
end
echo 225 4 $&trial $&cmp $&top 1.04296875 $&decision >> decisions.csv
let trial = code + 8
let drive = (floor(trial / 1) - 2*floor(trial / 2))*1.8
alter VB0 = $&drive
let drive = (floor(trial / 2) - 2*floor(trial / 4))*1.8
alter VB1 = $&drive
let drive = (floor(trial / 4) - 2*floor(trial / 8))*1.8
alter VB2 = $&drive
let drive = (floor(trial / 8) - 2*floor(trial / 16))*1.8
alter VB3 = $&drive
let drive = (floor(trial / 16) - 2*floor(trial / 32))*1.8
alter VB4 = $&drive
let drive = (floor(trial / 32) - 2*floor(trial / 64))*1.8
alter VB5 = $&drive
let drive = (floor(trial / 64) - 2*floor(trial / 128))*1.8
alter VB6 = $&drive
let drive = (floor(trial / 128) - 2*floor(trial / 256))*1.8
alter VB7 = $&drive
stop when time = 0.004062
resume
delete all
let endpoint = length(time)-1
let cmp = v(COMP)[endpoint]
let top = v(TOP)[endpoint]
let decision = 0
if cmp >= 0.9
let code = trial
let decision = 1
end
echo 225 3 $&trial $&cmp $&top 1.04296875 $&decision >> decisions.csv
let trial = code + 4
let drive = (floor(trial / 1) - 2*floor(trial / 2))*1.8
alter VB0 = $&drive
let drive = (floor(trial / 2) - 2*floor(trial / 4))*1.8
alter VB1 = $&drive
let drive = (floor(trial / 4) - 2*floor(trial / 8))*1.8
alter VB2 = $&drive
let drive = (floor(trial / 8) - 2*floor(trial / 16))*1.8
alter VB3 = $&drive
let drive = (floor(trial / 16) - 2*floor(trial / 32))*1.8
alter VB4 = $&drive
let drive = (floor(trial / 32) - 2*floor(trial / 64))*1.8
alter VB5 = $&drive
let drive = (floor(trial / 64) - 2*floor(trial / 128))*1.8
alter VB6 = $&drive
let drive = (floor(trial / 128) - 2*floor(trial / 256))*1.8
alter VB7 = $&drive
stop when time = 0.004064
resume
delete all
let endpoint = length(time)-1
let cmp = v(COMP)[endpoint]
let top = v(TOP)[endpoint]
let decision = 0
if cmp >= 0.9
let code = trial
let decision = 1
end
echo 225 2 $&trial $&cmp $&top 1.04296875 $&decision >> decisions.csv
let trial = code + 2
let drive = (floor(trial / 1) - 2*floor(trial / 2))*1.8
alter VB0 = $&drive
let drive = (floor(trial / 2) - 2*floor(trial / 4))*1.8
alter VB1 = $&drive
let drive = (floor(trial / 4) - 2*floor(trial / 8))*1.8
alter VB2 = $&drive
let drive = (floor(trial / 8) - 2*floor(trial / 16))*1.8
alter VB3 = $&drive
let drive = (floor(trial / 16) - 2*floor(trial / 32))*1.8
alter VB4 = $&drive
let drive = (floor(trial / 32) - 2*floor(trial / 64))*1.8
alter VB5 = $&drive
let drive = (floor(trial / 64) - 2*floor(trial / 128))*1.8
alter VB6 = $&drive
let drive = (floor(trial / 128) - 2*floor(trial / 256))*1.8
alter VB7 = $&drive
stop when time = 0.004066
resume
delete all
let endpoint = length(time)-1
let cmp = v(COMP)[endpoint]
let top = v(TOP)[endpoint]
let decision = 0
if cmp >= 0.9
let code = trial
let decision = 1
end
echo 225 1 $&trial $&cmp $&top 1.04296875 $&decision >> decisions.csv
let trial = code + 1
let drive = (floor(trial / 1) - 2*floor(trial / 2))*1.8
alter VB0 = $&drive
let drive = (floor(trial / 2) - 2*floor(trial / 4))*1.8
alter VB1 = $&drive
let drive = (floor(trial / 4) - 2*floor(trial / 8))*1.8
alter VB2 = $&drive
let drive = (floor(trial / 8) - 2*floor(trial / 16))*1.8
alter VB3 = $&drive
let drive = (floor(trial / 16) - 2*floor(trial / 32))*1.8
alter VB4 = $&drive
let drive = (floor(trial / 32) - 2*floor(trial / 64))*1.8
alter VB5 = $&drive
let drive = (floor(trial / 64) - 2*floor(trial / 128))*1.8
alter VB6 = $&drive
let drive = (floor(trial / 128) - 2*floor(trial / 256))*1.8
alter VB7 = $&drive
stop when time = 0.004068
resume
delete all
let endpoint = length(time)-1
let cmp = v(COMP)[endpoint]
let top = v(TOP)[endpoint]
let decision = 0
if cmp >= 0.9
let code = trial
let decision = 1
end
echo 225 0 $&trial $&cmp $&top 1.04296875 $&decision >> decisions.csv
alter VIN = 1.04765625
alter VSAMPLE = 1.8
alter VB0 = 0
alter VB1 = 0
alter VB2 = 0
alter VB3 = 0
alter VB4 = 0
alter VB5 = 0
alter VB6 = 0
alter VB7 = 0
let code = 0
stop when time = 0.00407
resume
delete all
alter VSAMPLE = 0
let trial = code + 128
let drive = (floor(trial / 1) - 2*floor(trial / 2))*1.8
alter VB0 = $&drive
let drive = (floor(trial / 2) - 2*floor(trial / 4))*1.8
alter VB1 = $&drive
let drive = (floor(trial / 4) - 2*floor(trial / 8))*1.8
alter VB2 = $&drive
let drive = (floor(trial / 8) - 2*floor(trial / 16))*1.8
alter VB3 = $&drive
let drive = (floor(trial / 16) - 2*floor(trial / 32))*1.8
alter VB4 = $&drive
let drive = (floor(trial / 32) - 2*floor(trial / 64))*1.8
alter VB5 = $&drive
let drive = (floor(trial / 64) - 2*floor(trial / 128))*1.8
alter VB6 = $&drive
let drive = (floor(trial / 128) - 2*floor(trial / 256))*1.8
alter VB7 = $&drive
stop when time = 0.004072
resume
delete all
let endpoint = length(time)-1
let cmp = v(COMP)[endpoint]
let top = v(TOP)[endpoint]
let decision = 0
if cmp >= 0.9
let code = trial
let decision = 1
end
echo 226 7 $&trial $&cmp $&top 1.04765625 $&decision >> decisions.csv
let trial = code + 64
let drive = (floor(trial / 1) - 2*floor(trial / 2))*1.8
alter VB0 = $&drive
let drive = (floor(trial / 2) - 2*floor(trial / 4))*1.8
alter VB1 = $&drive
let drive = (floor(trial / 4) - 2*floor(trial / 8))*1.8
alter VB2 = $&drive
let drive = (floor(trial / 8) - 2*floor(trial / 16))*1.8
alter VB3 = $&drive
let drive = (floor(trial / 16) - 2*floor(trial / 32))*1.8
alter VB4 = $&drive
let drive = (floor(trial / 32) - 2*floor(trial / 64))*1.8
alter VB5 = $&drive
let drive = (floor(trial / 64) - 2*floor(trial / 128))*1.8
alter VB6 = $&drive
let drive = (floor(trial / 128) - 2*floor(trial / 256))*1.8
alter VB7 = $&drive
stop when time = 0.004074
resume
delete all
let endpoint = length(time)-1
let cmp = v(COMP)[endpoint]
let top = v(TOP)[endpoint]
let decision = 0
if cmp >= 0.9
let code = trial
let decision = 1
end
echo 226 6 $&trial $&cmp $&top 1.04765625 $&decision >> decisions.csv
let trial = code + 32
let drive = (floor(trial / 1) - 2*floor(trial / 2))*1.8
alter VB0 = $&drive
let drive = (floor(trial / 2) - 2*floor(trial / 4))*1.8
alter VB1 = $&drive
let drive = (floor(trial / 4) - 2*floor(trial / 8))*1.8
alter VB2 = $&drive
let drive = (floor(trial / 8) - 2*floor(trial / 16))*1.8
alter VB3 = $&drive
let drive = (floor(trial / 16) - 2*floor(trial / 32))*1.8
alter VB4 = $&drive
let drive = (floor(trial / 32) - 2*floor(trial / 64))*1.8
alter VB5 = $&drive
let drive = (floor(trial / 64) - 2*floor(trial / 128))*1.8
alter VB6 = $&drive
let drive = (floor(trial / 128) - 2*floor(trial / 256))*1.8
alter VB7 = $&drive
stop when time = 0.004076
resume
delete all
let endpoint = length(time)-1
let cmp = v(COMP)[endpoint]
let top = v(TOP)[endpoint]
let decision = 0
if cmp >= 0.9
let code = trial
let decision = 1
end
echo 226 5 $&trial $&cmp $&top 1.04765625 $&decision >> decisions.csv
let trial = code + 16
let drive = (floor(trial / 1) - 2*floor(trial / 2))*1.8
alter VB0 = $&drive
let drive = (floor(trial / 2) - 2*floor(trial / 4))*1.8
alter VB1 = $&drive
let drive = (floor(trial / 4) - 2*floor(trial / 8))*1.8
alter VB2 = $&drive
let drive = (floor(trial / 8) - 2*floor(trial / 16))*1.8
alter VB3 = $&drive
let drive = (floor(trial / 16) - 2*floor(trial / 32))*1.8
alter VB4 = $&drive
let drive = (floor(trial / 32) - 2*floor(trial / 64))*1.8
alter VB5 = $&drive
let drive = (floor(trial / 64) - 2*floor(trial / 128))*1.8
alter VB6 = $&drive
let drive = (floor(trial / 128) - 2*floor(trial / 256))*1.8
alter VB7 = $&drive
stop when time = 0.004078
resume
delete all
let endpoint = length(time)-1
let cmp = v(COMP)[endpoint]
let top = v(TOP)[endpoint]
let decision = 0
if cmp >= 0.9
let code = trial
let decision = 1
end
echo 226 4 $&trial $&cmp $&top 1.04765625 $&decision >> decisions.csv
let trial = code + 8
let drive = (floor(trial / 1) - 2*floor(trial / 2))*1.8
alter VB0 = $&drive
let drive = (floor(trial / 2) - 2*floor(trial / 4))*1.8
alter VB1 = $&drive
let drive = (floor(trial / 4) - 2*floor(trial / 8))*1.8
alter VB2 = $&drive
let drive = (floor(trial / 8) - 2*floor(trial / 16))*1.8
alter VB3 = $&drive
let drive = (floor(trial / 16) - 2*floor(trial / 32))*1.8
alter VB4 = $&drive
let drive = (floor(trial / 32) - 2*floor(trial / 64))*1.8
alter VB5 = $&drive
let drive = (floor(trial / 64) - 2*floor(trial / 128))*1.8
alter VB6 = $&drive
let drive = (floor(trial / 128) - 2*floor(trial / 256))*1.8
alter VB7 = $&drive
stop when time = 0.00408
resume
delete all
let endpoint = length(time)-1
let cmp = v(COMP)[endpoint]
let top = v(TOP)[endpoint]
let decision = 0
if cmp >= 0.9
let code = trial
let decision = 1
end
echo 226 3 $&trial $&cmp $&top 1.04765625 $&decision >> decisions.csv
let trial = code + 4
let drive = (floor(trial / 1) - 2*floor(trial / 2))*1.8
alter VB0 = $&drive
let drive = (floor(trial / 2) - 2*floor(trial / 4))*1.8
alter VB1 = $&drive
let drive = (floor(trial / 4) - 2*floor(trial / 8))*1.8
alter VB2 = $&drive
let drive = (floor(trial / 8) - 2*floor(trial / 16))*1.8
alter VB3 = $&drive
let drive = (floor(trial / 16) - 2*floor(trial / 32))*1.8
alter VB4 = $&drive
let drive = (floor(trial / 32) - 2*floor(trial / 64))*1.8
alter VB5 = $&drive
let drive = (floor(trial / 64) - 2*floor(trial / 128))*1.8
alter VB6 = $&drive
let drive = (floor(trial / 128) - 2*floor(trial / 256))*1.8
alter VB7 = $&drive
stop when time = 0.004082
resume
delete all
let endpoint = length(time)-1
let cmp = v(COMP)[endpoint]
let top = v(TOP)[endpoint]
let decision = 0
if cmp >= 0.9
let code = trial
let decision = 1
end
echo 226 2 $&trial $&cmp $&top 1.04765625 $&decision >> decisions.csv
let trial = code + 2
let drive = (floor(trial / 1) - 2*floor(trial / 2))*1.8
alter VB0 = $&drive
let drive = (floor(trial / 2) - 2*floor(trial / 4))*1.8
alter VB1 = $&drive
let drive = (floor(trial / 4) - 2*floor(trial / 8))*1.8
alter VB2 = $&drive
let drive = (floor(trial / 8) - 2*floor(trial / 16))*1.8
alter VB3 = $&drive
let drive = (floor(trial / 16) - 2*floor(trial / 32))*1.8
alter VB4 = $&drive
let drive = (floor(trial / 32) - 2*floor(trial / 64))*1.8
alter VB5 = $&drive
let drive = (floor(trial / 64) - 2*floor(trial / 128))*1.8
alter VB6 = $&drive
let drive = (floor(trial / 128) - 2*floor(trial / 256))*1.8
alter VB7 = $&drive
stop when time = 0.004084
resume
delete all
let endpoint = length(time)-1
let cmp = v(COMP)[endpoint]
let top = v(TOP)[endpoint]
let decision = 0
if cmp >= 0.9
let code = trial
let decision = 1
end
echo 226 1 $&trial $&cmp $&top 1.04765625 $&decision >> decisions.csv
let trial = code + 1
let drive = (floor(trial / 1) - 2*floor(trial / 2))*1.8
alter VB0 = $&drive
let drive = (floor(trial / 2) - 2*floor(trial / 4))*1.8
alter VB1 = $&drive
let drive = (floor(trial / 4) - 2*floor(trial / 8))*1.8
alter VB2 = $&drive
let drive = (floor(trial / 8) - 2*floor(trial / 16))*1.8
alter VB3 = $&drive
let drive = (floor(trial / 16) - 2*floor(trial / 32))*1.8
alter VB4 = $&drive
let drive = (floor(trial / 32) - 2*floor(trial / 64))*1.8
alter VB5 = $&drive
let drive = (floor(trial / 64) - 2*floor(trial / 128))*1.8
alter VB6 = $&drive
let drive = (floor(trial / 128) - 2*floor(trial / 256))*1.8
alter VB7 = $&drive
stop when time = 0.004086
resume
delete all
let endpoint = length(time)-1
let cmp = v(COMP)[endpoint]
let top = v(TOP)[endpoint]
let decision = 0
if cmp >= 0.9
let code = trial
let decision = 1
end
echo 226 0 $&trial $&cmp $&top 1.04765625 $&decision >> decisions.csv
alter VIN = 1.05234375
alter VSAMPLE = 1.8
alter VB0 = 0
alter VB1 = 0
alter VB2 = 0
alter VB3 = 0
alter VB4 = 0
alter VB5 = 0
alter VB6 = 0
alter VB7 = 0
let code = 0
stop when time = 0.004088
resume
delete all
alter VSAMPLE = 0
let trial = code + 128
let drive = (floor(trial / 1) - 2*floor(trial / 2))*1.8
alter VB0 = $&drive
let drive = (floor(trial / 2) - 2*floor(trial / 4))*1.8
alter VB1 = $&drive
let drive = (floor(trial / 4) - 2*floor(trial / 8))*1.8
alter VB2 = $&drive
let drive = (floor(trial / 8) - 2*floor(trial / 16))*1.8
alter VB3 = $&drive
let drive = (floor(trial / 16) - 2*floor(trial / 32))*1.8
alter VB4 = $&drive
let drive = (floor(trial / 32) - 2*floor(trial / 64))*1.8
alter VB5 = $&drive
let drive = (floor(trial / 64) - 2*floor(trial / 128))*1.8
alter VB6 = $&drive
let drive = (floor(trial / 128) - 2*floor(trial / 256))*1.8
alter VB7 = $&drive
stop when time = 0.00409
resume
delete all
let endpoint = length(time)-1
let cmp = v(COMP)[endpoint]
let top = v(TOP)[endpoint]
let decision = 0
if cmp >= 0.9
let code = trial
let decision = 1
end
echo 227 7 $&trial $&cmp $&top 1.05234375 $&decision >> decisions.csv
let trial = code + 64
let drive = (floor(trial / 1) - 2*floor(trial / 2))*1.8
alter VB0 = $&drive
let drive = (floor(trial / 2) - 2*floor(trial / 4))*1.8
alter VB1 = $&drive
let drive = (floor(trial / 4) - 2*floor(trial / 8))*1.8
alter VB2 = $&drive
let drive = (floor(trial / 8) - 2*floor(trial / 16))*1.8
alter VB3 = $&drive
let drive = (floor(trial / 16) - 2*floor(trial / 32))*1.8
alter VB4 = $&drive
let drive = (floor(trial / 32) - 2*floor(trial / 64))*1.8
alter VB5 = $&drive
let drive = (floor(trial / 64) - 2*floor(trial / 128))*1.8
alter VB6 = $&drive
let drive = (floor(trial / 128) - 2*floor(trial / 256))*1.8
alter VB7 = $&drive
stop when time = 0.004092
resume
delete all
let endpoint = length(time)-1
let cmp = v(COMP)[endpoint]
let top = v(TOP)[endpoint]
let decision = 0
if cmp >= 0.9
let code = trial
let decision = 1
end
echo 227 6 $&trial $&cmp $&top 1.05234375 $&decision >> decisions.csv
let trial = code + 32
let drive = (floor(trial / 1) - 2*floor(trial / 2))*1.8
alter VB0 = $&drive
let drive = (floor(trial / 2) - 2*floor(trial / 4))*1.8
alter VB1 = $&drive
let drive = (floor(trial / 4) - 2*floor(trial / 8))*1.8
alter VB2 = $&drive
let drive = (floor(trial / 8) - 2*floor(trial / 16))*1.8
alter VB3 = $&drive
let drive = (floor(trial / 16) - 2*floor(trial / 32))*1.8
alter VB4 = $&drive
let drive = (floor(trial / 32) - 2*floor(trial / 64))*1.8
alter VB5 = $&drive
let drive = (floor(trial / 64) - 2*floor(trial / 128))*1.8
alter VB6 = $&drive
let drive = (floor(trial / 128) - 2*floor(trial / 256))*1.8
alter VB7 = $&drive
stop when time = 0.004094
resume
delete all
let endpoint = length(time)-1
let cmp = v(COMP)[endpoint]
let top = v(TOP)[endpoint]
let decision = 0
if cmp >= 0.9
let code = trial
let decision = 1
end
echo 227 5 $&trial $&cmp $&top 1.05234375 $&decision >> decisions.csv
let trial = code + 16
let drive = (floor(trial / 1) - 2*floor(trial / 2))*1.8
alter VB0 = $&drive
let drive = (floor(trial / 2) - 2*floor(trial / 4))*1.8
alter VB1 = $&drive
let drive = (floor(trial / 4) - 2*floor(trial / 8))*1.8
alter VB2 = $&drive
let drive = (floor(trial / 8) - 2*floor(trial / 16))*1.8
alter VB3 = $&drive
let drive = (floor(trial / 16) - 2*floor(trial / 32))*1.8
alter VB4 = $&drive
let drive = (floor(trial / 32) - 2*floor(trial / 64))*1.8
alter VB5 = $&drive
let drive = (floor(trial / 64) - 2*floor(trial / 128))*1.8
alter VB6 = $&drive
let drive = (floor(trial / 128) - 2*floor(trial / 256))*1.8
alter VB7 = $&drive
stop when time = 0.004096
resume
delete all
let endpoint = length(time)-1
let cmp = v(COMP)[endpoint]
let top = v(TOP)[endpoint]
let decision = 0
if cmp >= 0.9
let code = trial
let decision = 1
end
echo 227 4 $&trial $&cmp $&top 1.05234375 $&decision >> decisions.csv
let trial = code + 8
let drive = (floor(trial / 1) - 2*floor(trial / 2))*1.8
alter VB0 = $&drive
let drive = (floor(trial / 2) - 2*floor(trial / 4))*1.8
alter VB1 = $&drive
let drive = (floor(trial / 4) - 2*floor(trial / 8))*1.8
alter VB2 = $&drive
let drive = (floor(trial / 8) - 2*floor(trial / 16))*1.8
alter VB3 = $&drive
let drive = (floor(trial / 16) - 2*floor(trial / 32))*1.8
alter VB4 = $&drive
let drive = (floor(trial / 32) - 2*floor(trial / 64))*1.8
alter VB5 = $&drive
let drive = (floor(trial / 64) - 2*floor(trial / 128))*1.8
alter VB6 = $&drive
let drive = (floor(trial / 128) - 2*floor(trial / 256))*1.8
alter VB7 = $&drive
stop when time = 0.004098
resume
delete all
let endpoint = length(time)-1
let cmp = v(COMP)[endpoint]
let top = v(TOP)[endpoint]
let decision = 0
if cmp >= 0.9
let code = trial
let decision = 1
end
echo 227 3 $&trial $&cmp $&top 1.05234375 $&decision >> decisions.csv
let trial = code + 4
let drive = (floor(trial / 1) - 2*floor(trial / 2))*1.8
alter VB0 = $&drive
let drive = (floor(trial / 2) - 2*floor(trial / 4))*1.8
alter VB1 = $&drive
let drive = (floor(trial / 4) - 2*floor(trial / 8))*1.8
alter VB2 = $&drive
let drive = (floor(trial / 8) - 2*floor(trial / 16))*1.8
alter VB3 = $&drive
let drive = (floor(trial / 16) - 2*floor(trial / 32))*1.8
alter VB4 = $&drive
let drive = (floor(trial / 32) - 2*floor(trial / 64))*1.8
alter VB5 = $&drive
let drive = (floor(trial / 64) - 2*floor(trial / 128))*1.8
alter VB6 = $&drive
let drive = (floor(trial / 128) - 2*floor(trial / 256))*1.8
alter VB7 = $&drive
stop when time = 0.0041
resume
delete all
let endpoint = length(time)-1
let cmp = v(COMP)[endpoint]
let top = v(TOP)[endpoint]
let decision = 0
if cmp >= 0.9
let code = trial
let decision = 1
end
echo 227 2 $&trial $&cmp $&top 1.05234375 $&decision >> decisions.csv
let trial = code + 2
let drive = (floor(trial / 1) - 2*floor(trial / 2))*1.8
alter VB0 = $&drive
let drive = (floor(trial / 2) - 2*floor(trial / 4))*1.8
alter VB1 = $&drive
let drive = (floor(trial / 4) - 2*floor(trial / 8))*1.8
alter VB2 = $&drive
let drive = (floor(trial / 8) - 2*floor(trial / 16))*1.8
alter VB3 = $&drive
let drive = (floor(trial / 16) - 2*floor(trial / 32))*1.8
alter VB4 = $&drive
let drive = (floor(trial / 32) - 2*floor(trial / 64))*1.8
alter VB5 = $&drive
let drive = (floor(trial / 64) - 2*floor(trial / 128))*1.8
alter VB6 = $&drive
let drive = (floor(trial / 128) - 2*floor(trial / 256))*1.8
alter VB7 = $&drive
stop when time = 0.004102
resume
delete all
let endpoint = length(time)-1
let cmp = v(COMP)[endpoint]
let top = v(TOP)[endpoint]
let decision = 0
if cmp >= 0.9
let code = trial
let decision = 1
end
echo 227 1 $&trial $&cmp $&top 1.05234375 $&decision >> decisions.csv
let trial = code + 1
let drive = (floor(trial / 1) - 2*floor(trial / 2))*1.8
alter VB0 = $&drive
let drive = (floor(trial / 2) - 2*floor(trial / 4))*1.8
alter VB1 = $&drive
let drive = (floor(trial / 4) - 2*floor(trial / 8))*1.8
alter VB2 = $&drive
let drive = (floor(trial / 8) - 2*floor(trial / 16))*1.8
alter VB3 = $&drive
let drive = (floor(trial / 16) - 2*floor(trial / 32))*1.8
alter VB4 = $&drive
let drive = (floor(trial / 32) - 2*floor(trial / 64))*1.8
alter VB5 = $&drive
let drive = (floor(trial / 64) - 2*floor(trial / 128))*1.8
alter VB6 = $&drive
let drive = (floor(trial / 128) - 2*floor(trial / 256))*1.8
alter VB7 = $&drive
stop when time = 0.004104
resume
delete all
let endpoint = length(time)-1
let cmp = v(COMP)[endpoint]
let top = v(TOP)[endpoint]
let decision = 0
if cmp >= 0.9
let code = trial
let decision = 1
end
echo 227 0 $&trial $&cmp $&top 1.05234375 $&decision >> decisions.csv
alter VIN = 1.05703125
alter VSAMPLE = 1.8
alter VB0 = 0
alter VB1 = 0
alter VB2 = 0
alter VB3 = 0
alter VB4 = 0
alter VB5 = 0
alter VB6 = 0
alter VB7 = 0
let code = 0
stop when time = 0.004106
resume
delete all
alter VSAMPLE = 0
let trial = code + 128
let drive = (floor(trial / 1) - 2*floor(trial / 2))*1.8
alter VB0 = $&drive
let drive = (floor(trial / 2) - 2*floor(trial / 4))*1.8
alter VB1 = $&drive
let drive = (floor(trial / 4) - 2*floor(trial / 8))*1.8
alter VB2 = $&drive
let drive = (floor(trial / 8) - 2*floor(trial / 16))*1.8
alter VB3 = $&drive
let drive = (floor(trial / 16) - 2*floor(trial / 32))*1.8
alter VB4 = $&drive
let drive = (floor(trial / 32) - 2*floor(trial / 64))*1.8
alter VB5 = $&drive
let drive = (floor(trial / 64) - 2*floor(trial / 128))*1.8
alter VB6 = $&drive
let drive = (floor(trial / 128) - 2*floor(trial / 256))*1.8
alter VB7 = $&drive
stop when time = 0.004108
resume
delete all
let endpoint = length(time)-1
let cmp = v(COMP)[endpoint]
let top = v(TOP)[endpoint]
let decision = 0
if cmp >= 0.9
let code = trial
let decision = 1
end
echo 228 7 $&trial $&cmp $&top 1.05703125 $&decision >> decisions.csv
let trial = code + 64
let drive = (floor(trial / 1) - 2*floor(trial / 2))*1.8
alter VB0 = $&drive
let drive = (floor(trial / 2) - 2*floor(trial / 4))*1.8
alter VB1 = $&drive
let drive = (floor(trial / 4) - 2*floor(trial / 8))*1.8
alter VB2 = $&drive
let drive = (floor(trial / 8) - 2*floor(trial / 16))*1.8
alter VB3 = $&drive
let drive = (floor(trial / 16) - 2*floor(trial / 32))*1.8
alter VB4 = $&drive
let drive = (floor(trial / 32) - 2*floor(trial / 64))*1.8
alter VB5 = $&drive
let drive = (floor(trial / 64) - 2*floor(trial / 128))*1.8
alter VB6 = $&drive
let drive = (floor(trial / 128) - 2*floor(trial / 256))*1.8
alter VB7 = $&drive
stop when time = 0.00411
resume
delete all
let endpoint = length(time)-1
let cmp = v(COMP)[endpoint]
let top = v(TOP)[endpoint]
let decision = 0
if cmp >= 0.9
let code = trial
let decision = 1
end
echo 228 6 $&trial $&cmp $&top 1.05703125 $&decision >> decisions.csv
let trial = code + 32
let drive = (floor(trial / 1) - 2*floor(trial / 2))*1.8
alter VB0 = $&drive
let drive = (floor(trial / 2) - 2*floor(trial / 4))*1.8
alter VB1 = $&drive
let drive = (floor(trial / 4) - 2*floor(trial / 8))*1.8
alter VB2 = $&drive
let drive = (floor(trial / 8) - 2*floor(trial / 16))*1.8
alter VB3 = $&drive
let drive = (floor(trial / 16) - 2*floor(trial / 32))*1.8
alter VB4 = $&drive
let drive = (floor(trial / 32) - 2*floor(trial / 64))*1.8
alter VB5 = $&drive
let drive = (floor(trial / 64) - 2*floor(trial / 128))*1.8
alter VB6 = $&drive
let drive = (floor(trial / 128) - 2*floor(trial / 256))*1.8
alter VB7 = $&drive
stop when time = 0.004112
resume
delete all
let endpoint = length(time)-1
let cmp = v(COMP)[endpoint]
let top = v(TOP)[endpoint]
let decision = 0
if cmp >= 0.9
let code = trial
let decision = 1
end
echo 228 5 $&trial $&cmp $&top 1.05703125 $&decision >> decisions.csv
let trial = code + 16
let drive = (floor(trial / 1) - 2*floor(trial / 2))*1.8
alter VB0 = $&drive
let drive = (floor(trial / 2) - 2*floor(trial / 4))*1.8
alter VB1 = $&drive
let drive = (floor(trial / 4) - 2*floor(trial / 8))*1.8
alter VB2 = $&drive
let drive = (floor(trial / 8) - 2*floor(trial / 16))*1.8
alter VB3 = $&drive
let drive = (floor(trial / 16) - 2*floor(trial / 32))*1.8
alter VB4 = $&drive
let drive = (floor(trial / 32) - 2*floor(trial / 64))*1.8
alter VB5 = $&drive
let drive = (floor(trial / 64) - 2*floor(trial / 128))*1.8
alter VB6 = $&drive
let drive = (floor(trial / 128) - 2*floor(trial / 256))*1.8
alter VB7 = $&drive
stop when time = 0.004114
resume
delete all
let endpoint = length(time)-1
let cmp = v(COMP)[endpoint]
let top = v(TOP)[endpoint]
let decision = 0
if cmp >= 0.9
let code = trial
let decision = 1
end
echo 228 4 $&trial $&cmp $&top 1.05703125 $&decision >> decisions.csv
let trial = code + 8
let drive = (floor(trial / 1) - 2*floor(trial / 2))*1.8
alter VB0 = $&drive
let drive = (floor(trial / 2) - 2*floor(trial / 4))*1.8
alter VB1 = $&drive
let drive = (floor(trial / 4) - 2*floor(trial / 8))*1.8
alter VB2 = $&drive
let drive = (floor(trial / 8) - 2*floor(trial / 16))*1.8
alter VB3 = $&drive
let drive = (floor(trial / 16) - 2*floor(trial / 32))*1.8
alter VB4 = $&drive
let drive = (floor(trial / 32) - 2*floor(trial / 64))*1.8
alter VB5 = $&drive
let drive = (floor(trial / 64) - 2*floor(trial / 128))*1.8
alter VB6 = $&drive
let drive = (floor(trial / 128) - 2*floor(trial / 256))*1.8
alter VB7 = $&drive
stop when time = 0.004116
resume
delete all
let endpoint = length(time)-1
let cmp = v(COMP)[endpoint]
let top = v(TOP)[endpoint]
let decision = 0
if cmp >= 0.9
let code = trial
let decision = 1
end
echo 228 3 $&trial $&cmp $&top 1.05703125 $&decision >> decisions.csv
let trial = code + 4
let drive = (floor(trial / 1) - 2*floor(trial / 2))*1.8
alter VB0 = $&drive
let drive = (floor(trial / 2) - 2*floor(trial / 4))*1.8
alter VB1 = $&drive
let drive = (floor(trial / 4) - 2*floor(trial / 8))*1.8
alter VB2 = $&drive
let drive = (floor(trial / 8) - 2*floor(trial / 16))*1.8
alter VB3 = $&drive
let drive = (floor(trial / 16) - 2*floor(trial / 32))*1.8
alter VB4 = $&drive
let drive = (floor(trial / 32) - 2*floor(trial / 64))*1.8
alter VB5 = $&drive
let drive = (floor(trial / 64) - 2*floor(trial / 128))*1.8
alter VB6 = $&drive
let drive = (floor(trial / 128) - 2*floor(trial / 256))*1.8
alter VB7 = $&drive
stop when time = 0.004118
resume
delete all
let endpoint = length(time)-1
let cmp = v(COMP)[endpoint]
let top = v(TOP)[endpoint]
let decision = 0
if cmp >= 0.9
let code = trial
let decision = 1
end
echo 228 2 $&trial $&cmp $&top 1.05703125 $&decision >> decisions.csv
let trial = code + 2
let drive = (floor(trial / 1) - 2*floor(trial / 2))*1.8
alter VB0 = $&drive
let drive = (floor(trial / 2) - 2*floor(trial / 4))*1.8
alter VB1 = $&drive
let drive = (floor(trial / 4) - 2*floor(trial / 8))*1.8
alter VB2 = $&drive
let drive = (floor(trial / 8) - 2*floor(trial / 16))*1.8
alter VB3 = $&drive
let drive = (floor(trial / 16) - 2*floor(trial / 32))*1.8
alter VB4 = $&drive
let drive = (floor(trial / 32) - 2*floor(trial / 64))*1.8
alter VB5 = $&drive
let drive = (floor(trial / 64) - 2*floor(trial / 128))*1.8
alter VB6 = $&drive
let drive = (floor(trial / 128) - 2*floor(trial / 256))*1.8
alter VB7 = $&drive
stop when time = 0.00412
resume
delete all
let endpoint = length(time)-1
let cmp = v(COMP)[endpoint]
let top = v(TOP)[endpoint]
let decision = 0
if cmp >= 0.9
let code = trial
let decision = 1
end
echo 228 1 $&trial $&cmp $&top 1.05703125 $&decision >> decisions.csv
let trial = code + 1
let drive = (floor(trial / 1) - 2*floor(trial / 2))*1.8
alter VB0 = $&drive
let drive = (floor(trial / 2) - 2*floor(trial / 4))*1.8
alter VB1 = $&drive
let drive = (floor(trial / 4) - 2*floor(trial / 8))*1.8
alter VB2 = $&drive
let drive = (floor(trial / 8) - 2*floor(trial / 16))*1.8
alter VB3 = $&drive
let drive = (floor(trial / 16) - 2*floor(trial / 32))*1.8
alter VB4 = $&drive
let drive = (floor(trial / 32) - 2*floor(trial / 64))*1.8
alter VB5 = $&drive
let drive = (floor(trial / 64) - 2*floor(trial / 128))*1.8
alter VB6 = $&drive
let drive = (floor(trial / 128) - 2*floor(trial / 256))*1.8
alter VB7 = $&drive
stop when time = 0.004122
resume
delete all
let endpoint = length(time)-1
let cmp = v(COMP)[endpoint]
let top = v(TOP)[endpoint]
let decision = 0
if cmp >= 0.9
let code = trial
let decision = 1
end
echo 228 0 $&trial $&cmp $&top 1.05703125 $&decision >> decisions.csv
alter VIN = 1.06171875
alter VSAMPLE = 1.8
alter VB0 = 0
alter VB1 = 0
alter VB2 = 0
alter VB3 = 0
alter VB4 = 0
alter VB5 = 0
alter VB6 = 0
alter VB7 = 0
let code = 0
stop when time = 0.004124
resume
delete all
alter VSAMPLE = 0
let trial = code + 128
let drive = (floor(trial / 1) - 2*floor(trial / 2))*1.8
alter VB0 = $&drive
let drive = (floor(trial / 2) - 2*floor(trial / 4))*1.8
alter VB1 = $&drive
let drive = (floor(trial / 4) - 2*floor(trial / 8))*1.8
alter VB2 = $&drive
let drive = (floor(trial / 8) - 2*floor(trial / 16))*1.8
alter VB3 = $&drive
let drive = (floor(trial / 16) - 2*floor(trial / 32))*1.8
alter VB4 = $&drive
let drive = (floor(trial / 32) - 2*floor(trial / 64))*1.8
alter VB5 = $&drive
let drive = (floor(trial / 64) - 2*floor(trial / 128))*1.8
alter VB6 = $&drive
let drive = (floor(trial / 128) - 2*floor(trial / 256))*1.8
alter VB7 = $&drive
stop when time = 0.004126
resume
delete all
let endpoint = length(time)-1
let cmp = v(COMP)[endpoint]
let top = v(TOP)[endpoint]
let decision = 0
if cmp >= 0.9
let code = trial
let decision = 1
end
echo 229 7 $&trial $&cmp $&top 1.06171875 $&decision >> decisions.csv
let trial = code + 64
let drive = (floor(trial / 1) - 2*floor(trial / 2))*1.8
alter VB0 = $&drive
let drive = (floor(trial / 2) - 2*floor(trial / 4))*1.8
alter VB1 = $&drive
let drive = (floor(trial / 4) - 2*floor(trial / 8))*1.8
alter VB2 = $&drive
let drive = (floor(trial / 8) - 2*floor(trial / 16))*1.8
alter VB3 = $&drive
let drive = (floor(trial / 16) - 2*floor(trial / 32))*1.8
alter VB4 = $&drive
let drive = (floor(trial / 32) - 2*floor(trial / 64))*1.8
alter VB5 = $&drive
let drive = (floor(trial / 64) - 2*floor(trial / 128))*1.8
alter VB6 = $&drive
let drive = (floor(trial / 128) - 2*floor(trial / 256))*1.8
alter VB7 = $&drive
stop when time = 0.004128
resume
delete all
let endpoint = length(time)-1
let cmp = v(COMP)[endpoint]
let top = v(TOP)[endpoint]
let decision = 0
if cmp >= 0.9
let code = trial
let decision = 1
end
echo 229 6 $&trial $&cmp $&top 1.06171875 $&decision >> decisions.csv
let trial = code + 32
let drive = (floor(trial / 1) - 2*floor(trial / 2))*1.8
alter VB0 = $&drive
let drive = (floor(trial / 2) - 2*floor(trial / 4))*1.8
alter VB1 = $&drive
let drive = (floor(trial / 4) - 2*floor(trial / 8))*1.8
alter VB2 = $&drive
let drive = (floor(trial / 8) - 2*floor(trial / 16))*1.8
alter VB3 = $&drive
let drive = (floor(trial / 16) - 2*floor(trial / 32))*1.8
alter VB4 = $&drive
let drive = (floor(trial / 32) - 2*floor(trial / 64))*1.8
alter VB5 = $&drive
let drive = (floor(trial / 64) - 2*floor(trial / 128))*1.8
alter VB6 = $&drive
let drive = (floor(trial / 128) - 2*floor(trial / 256))*1.8
alter VB7 = $&drive
stop when time = 0.00413
resume
delete all
let endpoint = length(time)-1
let cmp = v(COMP)[endpoint]
let top = v(TOP)[endpoint]
let decision = 0
if cmp >= 0.9
let code = trial
let decision = 1
end
echo 229 5 $&trial $&cmp $&top 1.06171875 $&decision >> decisions.csv
let trial = code + 16
let drive = (floor(trial / 1) - 2*floor(trial / 2))*1.8
alter VB0 = $&drive
let drive = (floor(trial / 2) - 2*floor(trial / 4))*1.8
alter VB1 = $&drive
let drive = (floor(trial / 4) - 2*floor(trial / 8))*1.8
alter VB2 = $&drive
let drive = (floor(trial / 8) - 2*floor(trial / 16))*1.8
alter VB3 = $&drive
let drive = (floor(trial / 16) - 2*floor(trial / 32))*1.8
alter VB4 = $&drive
let drive = (floor(trial / 32) - 2*floor(trial / 64))*1.8
alter VB5 = $&drive
let drive = (floor(trial / 64) - 2*floor(trial / 128))*1.8
alter VB6 = $&drive
let drive = (floor(trial / 128) - 2*floor(trial / 256))*1.8
alter VB7 = $&drive
stop when time = 0.004132
resume
delete all
let endpoint = length(time)-1
let cmp = v(COMP)[endpoint]
let top = v(TOP)[endpoint]
let decision = 0
if cmp >= 0.9
let code = trial
let decision = 1
end
echo 229 4 $&trial $&cmp $&top 1.06171875 $&decision >> decisions.csv
let trial = code + 8
let drive = (floor(trial / 1) - 2*floor(trial / 2))*1.8
alter VB0 = $&drive
let drive = (floor(trial / 2) - 2*floor(trial / 4))*1.8
alter VB1 = $&drive
let drive = (floor(trial / 4) - 2*floor(trial / 8))*1.8
alter VB2 = $&drive
let drive = (floor(trial / 8) - 2*floor(trial / 16))*1.8
alter VB3 = $&drive
let drive = (floor(trial / 16) - 2*floor(trial / 32))*1.8
alter VB4 = $&drive
let drive = (floor(trial / 32) - 2*floor(trial / 64))*1.8
alter VB5 = $&drive
let drive = (floor(trial / 64) - 2*floor(trial / 128))*1.8
alter VB6 = $&drive
let drive = (floor(trial / 128) - 2*floor(trial / 256))*1.8
alter VB7 = $&drive
stop when time = 0.004134
resume
delete all
let endpoint = length(time)-1
let cmp = v(COMP)[endpoint]
let top = v(TOP)[endpoint]
let decision = 0
if cmp >= 0.9
let code = trial
let decision = 1
end
echo 229 3 $&trial $&cmp $&top 1.06171875 $&decision >> decisions.csv
let trial = code + 4
let drive = (floor(trial / 1) - 2*floor(trial / 2))*1.8
alter VB0 = $&drive
let drive = (floor(trial / 2) - 2*floor(trial / 4))*1.8
alter VB1 = $&drive
let drive = (floor(trial / 4) - 2*floor(trial / 8))*1.8
alter VB2 = $&drive
let drive = (floor(trial / 8) - 2*floor(trial / 16))*1.8
alter VB3 = $&drive
let drive = (floor(trial / 16) - 2*floor(trial / 32))*1.8
alter VB4 = $&drive
let drive = (floor(trial / 32) - 2*floor(trial / 64))*1.8
alter VB5 = $&drive
let drive = (floor(trial / 64) - 2*floor(trial / 128))*1.8
alter VB6 = $&drive
let drive = (floor(trial / 128) - 2*floor(trial / 256))*1.8
alter VB7 = $&drive
stop when time = 0.004136
resume
delete all
let endpoint = length(time)-1
let cmp = v(COMP)[endpoint]
let top = v(TOP)[endpoint]
let decision = 0
if cmp >= 0.9
let code = trial
let decision = 1
end
echo 229 2 $&trial $&cmp $&top 1.06171875 $&decision >> decisions.csv
let trial = code + 2
let drive = (floor(trial / 1) - 2*floor(trial / 2))*1.8
alter VB0 = $&drive
let drive = (floor(trial / 2) - 2*floor(trial / 4))*1.8
alter VB1 = $&drive
let drive = (floor(trial / 4) - 2*floor(trial / 8))*1.8
alter VB2 = $&drive
let drive = (floor(trial / 8) - 2*floor(trial / 16))*1.8
alter VB3 = $&drive
let drive = (floor(trial / 16) - 2*floor(trial / 32))*1.8
alter VB4 = $&drive
let drive = (floor(trial / 32) - 2*floor(trial / 64))*1.8
alter VB5 = $&drive
let drive = (floor(trial / 64) - 2*floor(trial / 128))*1.8
alter VB6 = $&drive
let drive = (floor(trial / 128) - 2*floor(trial / 256))*1.8
alter VB7 = $&drive
stop when time = 0.004138
resume
delete all
let endpoint = length(time)-1
let cmp = v(COMP)[endpoint]
let top = v(TOP)[endpoint]
let decision = 0
if cmp >= 0.9
let code = trial
let decision = 1
end
echo 229 1 $&trial $&cmp $&top 1.06171875 $&decision >> decisions.csv
let trial = code + 1
let drive = (floor(trial / 1) - 2*floor(trial / 2))*1.8
alter VB0 = $&drive
let drive = (floor(trial / 2) - 2*floor(trial / 4))*1.8
alter VB1 = $&drive
let drive = (floor(trial / 4) - 2*floor(trial / 8))*1.8
alter VB2 = $&drive
let drive = (floor(trial / 8) - 2*floor(trial / 16))*1.8
alter VB3 = $&drive
let drive = (floor(trial / 16) - 2*floor(trial / 32))*1.8
alter VB4 = $&drive
let drive = (floor(trial / 32) - 2*floor(trial / 64))*1.8
alter VB5 = $&drive
let drive = (floor(trial / 64) - 2*floor(trial / 128))*1.8
alter VB6 = $&drive
let drive = (floor(trial / 128) - 2*floor(trial / 256))*1.8
alter VB7 = $&drive
stop when time = 0.00414
resume
delete all
let endpoint = length(time)-1
let cmp = v(COMP)[endpoint]
let top = v(TOP)[endpoint]
let decision = 0
if cmp >= 0.9
let code = trial
let decision = 1
end
echo 229 0 $&trial $&cmp $&top 1.06171875 $&decision >> decisions.csv
alter VIN = 1.06640625
alter VSAMPLE = 1.8
alter VB0 = 0
alter VB1 = 0
alter VB2 = 0
alter VB3 = 0
alter VB4 = 0
alter VB5 = 0
alter VB6 = 0
alter VB7 = 0
let code = 0
stop when time = 0.004142
resume
delete all
alter VSAMPLE = 0
let trial = code + 128
let drive = (floor(trial / 1) - 2*floor(trial / 2))*1.8
alter VB0 = $&drive
let drive = (floor(trial / 2) - 2*floor(trial / 4))*1.8
alter VB1 = $&drive
let drive = (floor(trial / 4) - 2*floor(trial / 8))*1.8
alter VB2 = $&drive
let drive = (floor(trial / 8) - 2*floor(trial / 16))*1.8
alter VB3 = $&drive
let drive = (floor(trial / 16) - 2*floor(trial / 32))*1.8
alter VB4 = $&drive
let drive = (floor(trial / 32) - 2*floor(trial / 64))*1.8
alter VB5 = $&drive
let drive = (floor(trial / 64) - 2*floor(trial / 128))*1.8
alter VB6 = $&drive
let drive = (floor(trial / 128) - 2*floor(trial / 256))*1.8
alter VB7 = $&drive
stop when time = 0.004144
resume
delete all
let endpoint = length(time)-1
let cmp = v(COMP)[endpoint]
let top = v(TOP)[endpoint]
let decision = 0
if cmp >= 0.9
let code = trial
let decision = 1
end
echo 230 7 $&trial $&cmp $&top 1.06640625 $&decision >> decisions.csv
let trial = code + 64
let drive = (floor(trial / 1) - 2*floor(trial / 2))*1.8
alter VB0 = $&drive
let drive = (floor(trial / 2) - 2*floor(trial / 4))*1.8
alter VB1 = $&drive
let drive = (floor(trial / 4) - 2*floor(trial / 8))*1.8
alter VB2 = $&drive
let drive = (floor(trial / 8) - 2*floor(trial / 16))*1.8
alter VB3 = $&drive
let drive = (floor(trial / 16) - 2*floor(trial / 32))*1.8
alter VB4 = $&drive
let drive = (floor(trial / 32) - 2*floor(trial / 64))*1.8
alter VB5 = $&drive
let drive = (floor(trial / 64) - 2*floor(trial / 128))*1.8
alter VB6 = $&drive
let drive = (floor(trial / 128) - 2*floor(trial / 256))*1.8
alter VB7 = $&drive
stop when time = 0.004146
resume
delete all
let endpoint = length(time)-1
let cmp = v(COMP)[endpoint]
let top = v(TOP)[endpoint]
let decision = 0
if cmp >= 0.9
let code = trial
let decision = 1
end
echo 230 6 $&trial $&cmp $&top 1.06640625 $&decision >> decisions.csv
let trial = code + 32
let drive = (floor(trial / 1) - 2*floor(trial / 2))*1.8
alter VB0 = $&drive
let drive = (floor(trial / 2) - 2*floor(trial / 4))*1.8
alter VB1 = $&drive
let drive = (floor(trial / 4) - 2*floor(trial / 8))*1.8
alter VB2 = $&drive
let drive = (floor(trial / 8) - 2*floor(trial / 16))*1.8
alter VB3 = $&drive
let drive = (floor(trial / 16) - 2*floor(trial / 32))*1.8
alter VB4 = $&drive
let drive = (floor(trial / 32) - 2*floor(trial / 64))*1.8
alter VB5 = $&drive
let drive = (floor(trial / 64) - 2*floor(trial / 128))*1.8
alter VB6 = $&drive
let drive = (floor(trial / 128) - 2*floor(trial / 256))*1.8
alter VB7 = $&drive
stop when time = 0.004148
resume
delete all
let endpoint = length(time)-1
let cmp = v(COMP)[endpoint]
let top = v(TOP)[endpoint]
let decision = 0
if cmp >= 0.9
let code = trial
let decision = 1
end
echo 230 5 $&trial $&cmp $&top 1.06640625 $&decision >> decisions.csv
let trial = code + 16
let drive = (floor(trial / 1) - 2*floor(trial / 2))*1.8
alter VB0 = $&drive
let drive = (floor(trial / 2) - 2*floor(trial / 4))*1.8
alter VB1 = $&drive
let drive = (floor(trial / 4) - 2*floor(trial / 8))*1.8
alter VB2 = $&drive
let drive = (floor(trial / 8) - 2*floor(trial / 16))*1.8
alter VB3 = $&drive
let drive = (floor(trial / 16) - 2*floor(trial / 32))*1.8
alter VB4 = $&drive
let drive = (floor(trial / 32) - 2*floor(trial / 64))*1.8
alter VB5 = $&drive
let drive = (floor(trial / 64) - 2*floor(trial / 128))*1.8
alter VB6 = $&drive
let drive = (floor(trial / 128) - 2*floor(trial / 256))*1.8
alter VB7 = $&drive
stop when time = 0.00415
resume
delete all
let endpoint = length(time)-1
let cmp = v(COMP)[endpoint]
let top = v(TOP)[endpoint]
let decision = 0
if cmp >= 0.9
let code = trial
let decision = 1
end
echo 230 4 $&trial $&cmp $&top 1.06640625 $&decision >> decisions.csv
let trial = code + 8
let drive = (floor(trial / 1) - 2*floor(trial / 2))*1.8
alter VB0 = $&drive
let drive = (floor(trial / 2) - 2*floor(trial / 4))*1.8
alter VB1 = $&drive
let drive = (floor(trial / 4) - 2*floor(trial / 8))*1.8
alter VB2 = $&drive
let drive = (floor(trial / 8) - 2*floor(trial / 16))*1.8
alter VB3 = $&drive
let drive = (floor(trial / 16) - 2*floor(trial / 32))*1.8
alter VB4 = $&drive
let drive = (floor(trial / 32) - 2*floor(trial / 64))*1.8
alter VB5 = $&drive
let drive = (floor(trial / 64) - 2*floor(trial / 128))*1.8
alter VB6 = $&drive
let drive = (floor(trial / 128) - 2*floor(trial / 256))*1.8
alter VB7 = $&drive
stop when time = 0.004152
resume
delete all
let endpoint = length(time)-1
let cmp = v(COMP)[endpoint]
let top = v(TOP)[endpoint]
let decision = 0
if cmp >= 0.9
let code = trial
let decision = 1
end
echo 230 3 $&trial $&cmp $&top 1.06640625 $&decision >> decisions.csv
let trial = code + 4
let drive = (floor(trial / 1) - 2*floor(trial / 2))*1.8
alter VB0 = $&drive
let drive = (floor(trial / 2) - 2*floor(trial / 4))*1.8
alter VB1 = $&drive
let drive = (floor(trial / 4) - 2*floor(trial / 8))*1.8
alter VB2 = $&drive
let drive = (floor(trial / 8) - 2*floor(trial / 16))*1.8
alter VB3 = $&drive
let drive = (floor(trial / 16) - 2*floor(trial / 32))*1.8
alter VB4 = $&drive
let drive = (floor(trial / 32) - 2*floor(trial / 64))*1.8
alter VB5 = $&drive
let drive = (floor(trial / 64) - 2*floor(trial / 128))*1.8
alter VB6 = $&drive
let drive = (floor(trial / 128) - 2*floor(trial / 256))*1.8
alter VB7 = $&drive
stop when time = 0.004154
resume
delete all
let endpoint = length(time)-1
let cmp = v(COMP)[endpoint]
let top = v(TOP)[endpoint]
let decision = 0
if cmp >= 0.9
let code = trial
let decision = 1
end
echo 230 2 $&trial $&cmp $&top 1.06640625 $&decision >> decisions.csv
let trial = code + 2
let drive = (floor(trial / 1) - 2*floor(trial / 2))*1.8
alter VB0 = $&drive
let drive = (floor(trial / 2) - 2*floor(trial / 4))*1.8
alter VB1 = $&drive
let drive = (floor(trial / 4) - 2*floor(trial / 8))*1.8
alter VB2 = $&drive
let drive = (floor(trial / 8) - 2*floor(trial / 16))*1.8
alter VB3 = $&drive
let drive = (floor(trial / 16) - 2*floor(trial / 32))*1.8
alter VB4 = $&drive
let drive = (floor(trial / 32) - 2*floor(trial / 64))*1.8
alter VB5 = $&drive
let drive = (floor(trial / 64) - 2*floor(trial / 128))*1.8
alter VB6 = $&drive
let drive = (floor(trial / 128) - 2*floor(trial / 256))*1.8
alter VB7 = $&drive
stop when time = 0.004156
resume
delete all
let endpoint = length(time)-1
let cmp = v(COMP)[endpoint]
let top = v(TOP)[endpoint]
let decision = 0
if cmp >= 0.9
let code = trial
let decision = 1
end
echo 230 1 $&trial $&cmp $&top 1.06640625 $&decision >> decisions.csv
let trial = code + 1
let drive = (floor(trial / 1) - 2*floor(trial / 2))*1.8
alter VB0 = $&drive
let drive = (floor(trial / 2) - 2*floor(trial / 4))*1.8
alter VB1 = $&drive
let drive = (floor(trial / 4) - 2*floor(trial / 8))*1.8
alter VB2 = $&drive
let drive = (floor(trial / 8) - 2*floor(trial / 16))*1.8
alter VB3 = $&drive
let drive = (floor(trial / 16) - 2*floor(trial / 32))*1.8
alter VB4 = $&drive
let drive = (floor(trial / 32) - 2*floor(trial / 64))*1.8
alter VB5 = $&drive
let drive = (floor(trial / 64) - 2*floor(trial / 128))*1.8
alter VB6 = $&drive
let drive = (floor(trial / 128) - 2*floor(trial / 256))*1.8
alter VB7 = $&drive
stop when time = 0.004158
resume
delete all
let endpoint = length(time)-1
let cmp = v(COMP)[endpoint]
let top = v(TOP)[endpoint]
let decision = 0
if cmp >= 0.9
let code = trial
let decision = 1
end
echo 230 0 $&trial $&cmp $&top 1.06640625 $&decision >> decisions.csv
alter VIN = 1.07109375
alter VSAMPLE = 1.8
alter VB0 = 0
alter VB1 = 0
alter VB2 = 0
alter VB3 = 0
alter VB4 = 0
alter VB5 = 0
alter VB6 = 0
alter VB7 = 0
let code = 0
stop when time = 0.00416
resume
delete all
alter VSAMPLE = 0
let trial = code + 128
let drive = (floor(trial / 1) - 2*floor(trial / 2))*1.8
alter VB0 = $&drive
let drive = (floor(trial / 2) - 2*floor(trial / 4))*1.8
alter VB1 = $&drive
let drive = (floor(trial / 4) - 2*floor(trial / 8))*1.8
alter VB2 = $&drive
let drive = (floor(trial / 8) - 2*floor(trial / 16))*1.8
alter VB3 = $&drive
let drive = (floor(trial / 16) - 2*floor(trial / 32))*1.8
alter VB4 = $&drive
let drive = (floor(trial / 32) - 2*floor(trial / 64))*1.8
alter VB5 = $&drive
let drive = (floor(trial / 64) - 2*floor(trial / 128))*1.8
alter VB6 = $&drive
let drive = (floor(trial / 128) - 2*floor(trial / 256))*1.8
alter VB7 = $&drive
stop when time = 0.004162
resume
delete all
let endpoint = length(time)-1
let cmp = v(COMP)[endpoint]
let top = v(TOP)[endpoint]
let decision = 0
if cmp >= 0.9
let code = trial
let decision = 1
end
echo 231 7 $&trial $&cmp $&top 1.07109375 $&decision >> decisions.csv
let trial = code + 64
let drive = (floor(trial / 1) - 2*floor(trial / 2))*1.8
alter VB0 = $&drive
let drive = (floor(trial / 2) - 2*floor(trial / 4))*1.8
alter VB1 = $&drive
let drive = (floor(trial / 4) - 2*floor(trial / 8))*1.8
alter VB2 = $&drive
let drive = (floor(trial / 8) - 2*floor(trial / 16))*1.8
alter VB3 = $&drive
let drive = (floor(trial / 16) - 2*floor(trial / 32))*1.8
alter VB4 = $&drive
let drive = (floor(trial / 32) - 2*floor(trial / 64))*1.8
alter VB5 = $&drive
let drive = (floor(trial / 64) - 2*floor(trial / 128))*1.8
alter VB6 = $&drive
let drive = (floor(trial / 128) - 2*floor(trial / 256))*1.8
alter VB7 = $&drive
stop when time = 0.004164
resume
delete all
let endpoint = length(time)-1
let cmp = v(COMP)[endpoint]
let top = v(TOP)[endpoint]
let decision = 0
if cmp >= 0.9
let code = trial
let decision = 1
end
echo 231 6 $&trial $&cmp $&top 1.07109375 $&decision >> decisions.csv
let trial = code + 32
let drive = (floor(trial / 1) - 2*floor(trial / 2))*1.8
alter VB0 = $&drive
let drive = (floor(trial / 2) - 2*floor(trial / 4))*1.8
alter VB1 = $&drive
let drive = (floor(trial / 4) - 2*floor(trial / 8))*1.8
alter VB2 = $&drive
let drive = (floor(trial / 8) - 2*floor(trial / 16))*1.8
alter VB3 = $&drive
let drive = (floor(trial / 16) - 2*floor(trial / 32))*1.8
alter VB4 = $&drive
let drive = (floor(trial / 32) - 2*floor(trial / 64))*1.8
alter VB5 = $&drive
let drive = (floor(trial / 64) - 2*floor(trial / 128))*1.8
alter VB6 = $&drive
let drive = (floor(trial / 128) - 2*floor(trial / 256))*1.8
alter VB7 = $&drive
stop when time = 0.004166
resume
delete all
let endpoint = length(time)-1
let cmp = v(COMP)[endpoint]
let top = v(TOP)[endpoint]
let decision = 0
if cmp >= 0.9
let code = trial
let decision = 1
end
echo 231 5 $&trial $&cmp $&top 1.07109375 $&decision >> decisions.csv
let trial = code + 16
let drive = (floor(trial / 1) - 2*floor(trial / 2))*1.8
alter VB0 = $&drive
let drive = (floor(trial / 2) - 2*floor(trial / 4))*1.8
alter VB1 = $&drive
let drive = (floor(trial / 4) - 2*floor(trial / 8))*1.8
alter VB2 = $&drive
let drive = (floor(trial / 8) - 2*floor(trial / 16))*1.8
alter VB3 = $&drive
let drive = (floor(trial / 16) - 2*floor(trial / 32))*1.8
alter VB4 = $&drive
let drive = (floor(trial / 32) - 2*floor(trial / 64))*1.8
alter VB5 = $&drive
let drive = (floor(trial / 64) - 2*floor(trial / 128))*1.8
alter VB6 = $&drive
let drive = (floor(trial / 128) - 2*floor(trial / 256))*1.8
alter VB7 = $&drive
stop when time = 0.004168
resume
delete all
let endpoint = length(time)-1
let cmp = v(COMP)[endpoint]
let top = v(TOP)[endpoint]
let decision = 0
if cmp >= 0.9
let code = trial
let decision = 1
end
echo 231 4 $&trial $&cmp $&top 1.07109375 $&decision >> decisions.csv
let trial = code + 8
let drive = (floor(trial / 1) - 2*floor(trial / 2))*1.8
alter VB0 = $&drive
let drive = (floor(trial / 2) - 2*floor(trial / 4))*1.8
alter VB1 = $&drive
let drive = (floor(trial / 4) - 2*floor(trial / 8))*1.8
alter VB2 = $&drive
let drive = (floor(trial / 8) - 2*floor(trial / 16))*1.8
alter VB3 = $&drive
let drive = (floor(trial / 16) - 2*floor(trial / 32))*1.8
alter VB4 = $&drive
let drive = (floor(trial / 32) - 2*floor(trial / 64))*1.8
alter VB5 = $&drive
let drive = (floor(trial / 64) - 2*floor(trial / 128))*1.8
alter VB6 = $&drive
let drive = (floor(trial / 128) - 2*floor(trial / 256))*1.8
alter VB7 = $&drive
stop when time = 0.00417
resume
delete all
let endpoint = length(time)-1
let cmp = v(COMP)[endpoint]
let top = v(TOP)[endpoint]
let decision = 0
if cmp >= 0.9
let code = trial
let decision = 1
end
echo 231 3 $&trial $&cmp $&top 1.07109375 $&decision >> decisions.csv
let trial = code + 4
let drive = (floor(trial / 1) - 2*floor(trial / 2))*1.8
alter VB0 = $&drive
let drive = (floor(trial / 2) - 2*floor(trial / 4))*1.8
alter VB1 = $&drive
let drive = (floor(trial / 4) - 2*floor(trial / 8))*1.8
alter VB2 = $&drive
let drive = (floor(trial / 8) - 2*floor(trial / 16))*1.8
alter VB3 = $&drive
let drive = (floor(trial / 16) - 2*floor(trial / 32))*1.8
alter VB4 = $&drive
let drive = (floor(trial / 32) - 2*floor(trial / 64))*1.8
alter VB5 = $&drive
let drive = (floor(trial / 64) - 2*floor(trial / 128))*1.8
alter VB6 = $&drive
let drive = (floor(trial / 128) - 2*floor(trial / 256))*1.8
alter VB7 = $&drive
stop when time = 0.004172
resume
delete all
let endpoint = length(time)-1
let cmp = v(COMP)[endpoint]
let top = v(TOP)[endpoint]
let decision = 0
if cmp >= 0.9
let code = trial
let decision = 1
end
echo 231 2 $&trial $&cmp $&top 1.07109375 $&decision >> decisions.csv
let trial = code + 2
let drive = (floor(trial / 1) - 2*floor(trial / 2))*1.8
alter VB0 = $&drive
let drive = (floor(trial / 2) - 2*floor(trial / 4))*1.8
alter VB1 = $&drive
let drive = (floor(trial / 4) - 2*floor(trial / 8))*1.8
alter VB2 = $&drive
let drive = (floor(trial / 8) - 2*floor(trial / 16))*1.8
alter VB3 = $&drive
let drive = (floor(trial / 16) - 2*floor(trial / 32))*1.8
alter VB4 = $&drive
let drive = (floor(trial / 32) - 2*floor(trial / 64))*1.8
alter VB5 = $&drive
let drive = (floor(trial / 64) - 2*floor(trial / 128))*1.8
alter VB6 = $&drive
let drive = (floor(trial / 128) - 2*floor(trial / 256))*1.8
alter VB7 = $&drive
stop when time = 0.004174
resume
delete all
let endpoint = length(time)-1
let cmp = v(COMP)[endpoint]
let top = v(TOP)[endpoint]
let decision = 0
if cmp >= 0.9
let code = trial
let decision = 1
end
echo 231 1 $&trial $&cmp $&top 1.07109375 $&decision >> decisions.csv
let trial = code + 1
let drive = (floor(trial / 1) - 2*floor(trial / 2))*1.8
alter VB0 = $&drive
let drive = (floor(trial / 2) - 2*floor(trial / 4))*1.8
alter VB1 = $&drive
let drive = (floor(trial / 4) - 2*floor(trial / 8))*1.8
alter VB2 = $&drive
let drive = (floor(trial / 8) - 2*floor(trial / 16))*1.8
alter VB3 = $&drive
let drive = (floor(trial / 16) - 2*floor(trial / 32))*1.8
alter VB4 = $&drive
let drive = (floor(trial / 32) - 2*floor(trial / 64))*1.8
alter VB5 = $&drive
let drive = (floor(trial / 64) - 2*floor(trial / 128))*1.8
alter VB6 = $&drive
let drive = (floor(trial / 128) - 2*floor(trial / 256))*1.8
alter VB7 = $&drive
stop when time = 0.004176
resume
delete all
let endpoint = length(time)-1
let cmp = v(COMP)[endpoint]
let top = v(TOP)[endpoint]
let decision = 0
if cmp >= 0.9
let code = trial
let decision = 1
end
echo 231 0 $&trial $&cmp $&top 1.07109375 $&decision >> decisions.csv
alter VIN = 1.07578125
alter VSAMPLE = 1.8
alter VB0 = 0
alter VB1 = 0
alter VB2 = 0
alter VB3 = 0
alter VB4 = 0
alter VB5 = 0
alter VB6 = 0
alter VB7 = 0
let code = 0
stop when time = 0.004178
resume
delete all
alter VSAMPLE = 0
let trial = code + 128
let drive = (floor(trial / 1) - 2*floor(trial / 2))*1.8
alter VB0 = $&drive
let drive = (floor(trial / 2) - 2*floor(trial / 4))*1.8
alter VB1 = $&drive
let drive = (floor(trial / 4) - 2*floor(trial / 8))*1.8
alter VB2 = $&drive
let drive = (floor(trial / 8) - 2*floor(trial / 16))*1.8
alter VB3 = $&drive
let drive = (floor(trial / 16) - 2*floor(trial / 32))*1.8
alter VB4 = $&drive
let drive = (floor(trial / 32) - 2*floor(trial / 64))*1.8
alter VB5 = $&drive
let drive = (floor(trial / 64) - 2*floor(trial / 128))*1.8
alter VB6 = $&drive
let drive = (floor(trial / 128) - 2*floor(trial / 256))*1.8
alter VB7 = $&drive
stop when time = 0.00418
resume
delete all
let endpoint = length(time)-1
let cmp = v(COMP)[endpoint]
let top = v(TOP)[endpoint]
let decision = 0
if cmp >= 0.9
let code = trial
let decision = 1
end
echo 232 7 $&trial $&cmp $&top 1.07578125 $&decision >> decisions.csv
let trial = code + 64
let drive = (floor(trial / 1) - 2*floor(trial / 2))*1.8
alter VB0 = $&drive
let drive = (floor(trial / 2) - 2*floor(trial / 4))*1.8
alter VB1 = $&drive
let drive = (floor(trial / 4) - 2*floor(trial / 8))*1.8
alter VB2 = $&drive
let drive = (floor(trial / 8) - 2*floor(trial / 16))*1.8
alter VB3 = $&drive
let drive = (floor(trial / 16) - 2*floor(trial / 32))*1.8
alter VB4 = $&drive
let drive = (floor(trial / 32) - 2*floor(trial / 64))*1.8
alter VB5 = $&drive
let drive = (floor(trial / 64) - 2*floor(trial / 128))*1.8
alter VB6 = $&drive
let drive = (floor(trial / 128) - 2*floor(trial / 256))*1.8
alter VB7 = $&drive
stop when time = 0.004182
resume
delete all
let endpoint = length(time)-1
let cmp = v(COMP)[endpoint]
let top = v(TOP)[endpoint]
let decision = 0
if cmp >= 0.9
let code = trial
let decision = 1
end
echo 232 6 $&trial $&cmp $&top 1.07578125 $&decision >> decisions.csv
let trial = code + 32
let drive = (floor(trial / 1) - 2*floor(trial / 2))*1.8
alter VB0 = $&drive
let drive = (floor(trial / 2) - 2*floor(trial / 4))*1.8
alter VB1 = $&drive
let drive = (floor(trial / 4) - 2*floor(trial / 8))*1.8
alter VB2 = $&drive
let drive = (floor(trial / 8) - 2*floor(trial / 16))*1.8
alter VB3 = $&drive
let drive = (floor(trial / 16) - 2*floor(trial / 32))*1.8
alter VB4 = $&drive
let drive = (floor(trial / 32) - 2*floor(trial / 64))*1.8
alter VB5 = $&drive
let drive = (floor(trial / 64) - 2*floor(trial / 128))*1.8
alter VB6 = $&drive
let drive = (floor(trial / 128) - 2*floor(trial / 256))*1.8
alter VB7 = $&drive
stop when time = 0.004184
resume
delete all
let endpoint = length(time)-1
let cmp = v(COMP)[endpoint]
let top = v(TOP)[endpoint]
let decision = 0
if cmp >= 0.9
let code = trial
let decision = 1
end
echo 232 5 $&trial $&cmp $&top 1.07578125 $&decision >> decisions.csv
let trial = code + 16
let drive = (floor(trial / 1) - 2*floor(trial / 2))*1.8
alter VB0 = $&drive
let drive = (floor(trial / 2) - 2*floor(trial / 4))*1.8
alter VB1 = $&drive
let drive = (floor(trial / 4) - 2*floor(trial / 8))*1.8
alter VB2 = $&drive
let drive = (floor(trial / 8) - 2*floor(trial / 16))*1.8
alter VB3 = $&drive
let drive = (floor(trial / 16) - 2*floor(trial / 32))*1.8
alter VB4 = $&drive
let drive = (floor(trial / 32) - 2*floor(trial / 64))*1.8
alter VB5 = $&drive
let drive = (floor(trial / 64) - 2*floor(trial / 128))*1.8
alter VB6 = $&drive
let drive = (floor(trial / 128) - 2*floor(trial / 256))*1.8
alter VB7 = $&drive
stop when time = 0.004186
resume
delete all
let endpoint = length(time)-1
let cmp = v(COMP)[endpoint]
let top = v(TOP)[endpoint]
let decision = 0
if cmp >= 0.9
let code = trial
let decision = 1
end
echo 232 4 $&trial $&cmp $&top 1.07578125 $&decision >> decisions.csv
let trial = code + 8
let drive = (floor(trial / 1) - 2*floor(trial / 2))*1.8
alter VB0 = $&drive
let drive = (floor(trial / 2) - 2*floor(trial / 4))*1.8
alter VB1 = $&drive
let drive = (floor(trial / 4) - 2*floor(trial / 8))*1.8
alter VB2 = $&drive
let drive = (floor(trial / 8) - 2*floor(trial / 16))*1.8
alter VB3 = $&drive
let drive = (floor(trial / 16) - 2*floor(trial / 32))*1.8
alter VB4 = $&drive
let drive = (floor(trial / 32) - 2*floor(trial / 64))*1.8
alter VB5 = $&drive
let drive = (floor(trial / 64) - 2*floor(trial / 128))*1.8
alter VB6 = $&drive
let drive = (floor(trial / 128) - 2*floor(trial / 256))*1.8
alter VB7 = $&drive
stop when time = 0.004188
resume
delete all
let endpoint = length(time)-1
let cmp = v(COMP)[endpoint]
let top = v(TOP)[endpoint]
let decision = 0
if cmp >= 0.9
let code = trial
let decision = 1
end
echo 232 3 $&trial $&cmp $&top 1.07578125 $&decision >> decisions.csv
let trial = code + 4
let drive = (floor(trial / 1) - 2*floor(trial / 2))*1.8
alter VB0 = $&drive
let drive = (floor(trial / 2) - 2*floor(trial / 4))*1.8
alter VB1 = $&drive
let drive = (floor(trial / 4) - 2*floor(trial / 8))*1.8
alter VB2 = $&drive
let drive = (floor(trial / 8) - 2*floor(trial / 16))*1.8
alter VB3 = $&drive
let drive = (floor(trial / 16) - 2*floor(trial / 32))*1.8
alter VB4 = $&drive
let drive = (floor(trial / 32) - 2*floor(trial / 64))*1.8
alter VB5 = $&drive
let drive = (floor(trial / 64) - 2*floor(trial / 128))*1.8
alter VB6 = $&drive
let drive = (floor(trial / 128) - 2*floor(trial / 256))*1.8
alter VB7 = $&drive
stop when time = 0.00419
resume
delete all
let endpoint = length(time)-1
let cmp = v(COMP)[endpoint]
let top = v(TOP)[endpoint]
let decision = 0
if cmp >= 0.9
let code = trial
let decision = 1
end
echo 232 2 $&trial $&cmp $&top 1.07578125 $&decision >> decisions.csv
let trial = code + 2
let drive = (floor(trial / 1) - 2*floor(trial / 2))*1.8
alter VB0 = $&drive
let drive = (floor(trial / 2) - 2*floor(trial / 4))*1.8
alter VB1 = $&drive
let drive = (floor(trial / 4) - 2*floor(trial / 8))*1.8
alter VB2 = $&drive
let drive = (floor(trial / 8) - 2*floor(trial / 16))*1.8
alter VB3 = $&drive
let drive = (floor(trial / 16) - 2*floor(trial / 32))*1.8
alter VB4 = $&drive
let drive = (floor(trial / 32) - 2*floor(trial / 64))*1.8
alter VB5 = $&drive
let drive = (floor(trial / 64) - 2*floor(trial / 128))*1.8
alter VB6 = $&drive
let drive = (floor(trial / 128) - 2*floor(trial / 256))*1.8
alter VB7 = $&drive
stop when time = 0.004192
resume
delete all
let endpoint = length(time)-1
let cmp = v(COMP)[endpoint]
let top = v(TOP)[endpoint]
let decision = 0
if cmp >= 0.9
let code = trial
let decision = 1
end
echo 232 1 $&trial $&cmp $&top 1.07578125 $&decision >> decisions.csv
let trial = code + 1
let drive = (floor(trial / 1) - 2*floor(trial / 2))*1.8
alter VB0 = $&drive
let drive = (floor(trial / 2) - 2*floor(trial / 4))*1.8
alter VB1 = $&drive
let drive = (floor(trial / 4) - 2*floor(trial / 8))*1.8
alter VB2 = $&drive
let drive = (floor(trial / 8) - 2*floor(trial / 16))*1.8
alter VB3 = $&drive
let drive = (floor(trial / 16) - 2*floor(trial / 32))*1.8
alter VB4 = $&drive
let drive = (floor(trial / 32) - 2*floor(trial / 64))*1.8
alter VB5 = $&drive
let drive = (floor(trial / 64) - 2*floor(trial / 128))*1.8
alter VB6 = $&drive
let drive = (floor(trial / 128) - 2*floor(trial / 256))*1.8
alter VB7 = $&drive
stop when time = 0.004194
resume
delete all
let endpoint = length(time)-1
let cmp = v(COMP)[endpoint]
let top = v(TOP)[endpoint]
let decision = 0
if cmp >= 0.9
let code = trial
let decision = 1
end
echo 232 0 $&trial $&cmp $&top 1.07578125 $&decision >> decisions.csv
alter VIN = 1.08046875
alter VSAMPLE = 1.8
alter VB0 = 0
alter VB1 = 0
alter VB2 = 0
alter VB3 = 0
alter VB4 = 0
alter VB5 = 0
alter VB6 = 0
alter VB7 = 0
let code = 0
stop when time = 0.004196
resume
delete all
alter VSAMPLE = 0
let trial = code + 128
let drive = (floor(trial / 1) - 2*floor(trial / 2))*1.8
alter VB0 = $&drive
let drive = (floor(trial / 2) - 2*floor(trial / 4))*1.8
alter VB1 = $&drive
let drive = (floor(trial / 4) - 2*floor(trial / 8))*1.8
alter VB2 = $&drive
let drive = (floor(trial / 8) - 2*floor(trial / 16))*1.8
alter VB3 = $&drive
let drive = (floor(trial / 16) - 2*floor(trial / 32))*1.8
alter VB4 = $&drive
let drive = (floor(trial / 32) - 2*floor(trial / 64))*1.8
alter VB5 = $&drive
let drive = (floor(trial / 64) - 2*floor(trial / 128))*1.8
alter VB6 = $&drive
let drive = (floor(trial / 128) - 2*floor(trial / 256))*1.8
alter VB7 = $&drive
stop when time = 0.004198
resume
delete all
let endpoint = length(time)-1
let cmp = v(COMP)[endpoint]
let top = v(TOP)[endpoint]
let decision = 0
if cmp >= 0.9
let code = trial
let decision = 1
end
echo 233 7 $&trial $&cmp $&top 1.08046875 $&decision >> decisions.csv
let trial = code + 64
let drive = (floor(trial / 1) - 2*floor(trial / 2))*1.8
alter VB0 = $&drive
let drive = (floor(trial / 2) - 2*floor(trial / 4))*1.8
alter VB1 = $&drive
let drive = (floor(trial / 4) - 2*floor(trial / 8))*1.8
alter VB2 = $&drive
let drive = (floor(trial / 8) - 2*floor(trial / 16))*1.8
alter VB3 = $&drive
let drive = (floor(trial / 16) - 2*floor(trial / 32))*1.8
alter VB4 = $&drive
let drive = (floor(trial / 32) - 2*floor(trial / 64))*1.8
alter VB5 = $&drive
let drive = (floor(trial / 64) - 2*floor(trial / 128))*1.8
alter VB6 = $&drive
let drive = (floor(trial / 128) - 2*floor(trial / 256))*1.8
alter VB7 = $&drive
stop when time = 0.0042
resume
delete all
let endpoint = length(time)-1
let cmp = v(COMP)[endpoint]
let top = v(TOP)[endpoint]
let decision = 0
if cmp >= 0.9
let code = trial
let decision = 1
end
echo 233 6 $&trial $&cmp $&top 1.08046875 $&decision >> decisions.csv
let trial = code + 32
let drive = (floor(trial / 1) - 2*floor(trial / 2))*1.8
alter VB0 = $&drive
let drive = (floor(trial / 2) - 2*floor(trial / 4))*1.8
alter VB1 = $&drive
let drive = (floor(trial / 4) - 2*floor(trial / 8))*1.8
alter VB2 = $&drive
let drive = (floor(trial / 8) - 2*floor(trial / 16))*1.8
alter VB3 = $&drive
let drive = (floor(trial / 16) - 2*floor(trial / 32))*1.8
alter VB4 = $&drive
let drive = (floor(trial / 32) - 2*floor(trial / 64))*1.8
alter VB5 = $&drive
let drive = (floor(trial / 64) - 2*floor(trial / 128))*1.8
alter VB6 = $&drive
let drive = (floor(trial / 128) - 2*floor(trial / 256))*1.8
alter VB7 = $&drive
stop when time = 0.004202
resume
delete all
let endpoint = length(time)-1
let cmp = v(COMP)[endpoint]
let top = v(TOP)[endpoint]
let decision = 0
if cmp >= 0.9
let code = trial
let decision = 1
end
echo 233 5 $&trial $&cmp $&top 1.08046875 $&decision >> decisions.csv
let trial = code + 16
let drive = (floor(trial / 1) - 2*floor(trial / 2))*1.8
alter VB0 = $&drive
let drive = (floor(trial / 2) - 2*floor(trial / 4))*1.8
alter VB1 = $&drive
let drive = (floor(trial / 4) - 2*floor(trial / 8))*1.8
alter VB2 = $&drive
let drive = (floor(trial / 8) - 2*floor(trial / 16))*1.8
alter VB3 = $&drive
let drive = (floor(trial / 16) - 2*floor(trial / 32))*1.8
alter VB4 = $&drive
let drive = (floor(trial / 32) - 2*floor(trial / 64))*1.8
alter VB5 = $&drive
let drive = (floor(trial / 64) - 2*floor(trial / 128))*1.8
alter VB6 = $&drive
let drive = (floor(trial / 128) - 2*floor(trial / 256))*1.8
alter VB7 = $&drive
stop when time = 0.004204
resume
delete all
let endpoint = length(time)-1
let cmp = v(COMP)[endpoint]
let top = v(TOP)[endpoint]
let decision = 0
if cmp >= 0.9
let code = trial
let decision = 1
end
echo 233 4 $&trial $&cmp $&top 1.08046875 $&decision >> decisions.csv
let trial = code + 8
let drive = (floor(trial / 1) - 2*floor(trial / 2))*1.8
alter VB0 = $&drive
let drive = (floor(trial / 2) - 2*floor(trial / 4))*1.8
alter VB1 = $&drive
let drive = (floor(trial / 4) - 2*floor(trial / 8))*1.8
alter VB2 = $&drive
let drive = (floor(trial / 8) - 2*floor(trial / 16))*1.8
alter VB3 = $&drive
let drive = (floor(trial / 16) - 2*floor(trial / 32))*1.8
alter VB4 = $&drive
let drive = (floor(trial / 32) - 2*floor(trial / 64))*1.8
alter VB5 = $&drive
let drive = (floor(trial / 64) - 2*floor(trial / 128))*1.8
alter VB6 = $&drive
let drive = (floor(trial / 128) - 2*floor(trial / 256))*1.8
alter VB7 = $&drive
stop when time = 0.004206
resume
delete all
let endpoint = length(time)-1
let cmp = v(COMP)[endpoint]
let top = v(TOP)[endpoint]
let decision = 0
if cmp >= 0.9
let code = trial
let decision = 1
end
echo 233 3 $&trial $&cmp $&top 1.08046875 $&decision >> decisions.csv
let trial = code + 4
let drive = (floor(trial / 1) - 2*floor(trial / 2))*1.8
alter VB0 = $&drive
let drive = (floor(trial / 2) - 2*floor(trial / 4))*1.8
alter VB1 = $&drive
let drive = (floor(trial / 4) - 2*floor(trial / 8))*1.8
alter VB2 = $&drive
let drive = (floor(trial / 8) - 2*floor(trial / 16))*1.8
alter VB3 = $&drive
let drive = (floor(trial / 16) - 2*floor(trial / 32))*1.8
alter VB4 = $&drive
let drive = (floor(trial / 32) - 2*floor(trial / 64))*1.8
alter VB5 = $&drive
let drive = (floor(trial / 64) - 2*floor(trial / 128))*1.8
alter VB6 = $&drive
let drive = (floor(trial / 128) - 2*floor(trial / 256))*1.8
alter VB7 = $&drive
stop when time = 0.004208
resume
delete all
let endpoint = length(time)-1
let cmp = v(COMP)[endpoint]
let top = v(TOP)[endpoint]
let decision = 0
if cmp >= 0.9
let code = trial
let decision = 1
end
echo 233 2 $&trial $&cmp $&top 1.08046875 $&decision >> decisions.csv
let trial = code + 2
let drive = (floor(trial / 1) - 2*floor(trial / 2))*1.8
alter VB0 = $&drive
let drive = (floor(trial / 2) - 2*floor(trial / 4))*1.8
alter VB1 = $&drive
let drive = (floor(trial / 4) - 2*floor(trial / 8))*1.8
alter VB2 = $&drive
let drive = (floor(trial / 8) - 2*floor(trial / 16))*1.8
alter VB3 = $&drive
let drive = (floor(trial / 16) - 2*floor(trial / 32))*1.8
alter VB4 = $&drive
let drive = (floor(trial / 32) - 2*floor(trial / 64))*1.8
alter VB5 = $&drive
let drive = (floor(trial / 64) - 2*floor(trial / 128))*1.8
alter VB6 = $&drive
let drive = (floor(trial / 128) - 2*floor(trial / 256))*1.8
alter VB7 = $&drive
stop when time = 0.00421
resume
delete all
let endpoint = length(time)-1
let cmp = v(COMP)[endpoint]
let top = v(TOP)[endpoint]
let decision = 0
if cmp >= 0.9
let code = trial
let decision = 1
end
echo 233 1 $&trial $&cmp $&top 1.08046875 $&decision >> decisions.csv
let trial = code + 1
let drive = (floor(trial / 1) - 2*floor(trial / 2))*1.8
alter VB0 = $&drive
let drive = (floor(trial / 2) - 2*floor(trial / 4))*1.8
alter VB1 = $&drive
let drive = (floor(trial / 4) - 2*floor(trial / 8))*1.8
alter VB2 = $&drive
let drive = (floor(trial / 8) - 2*floor(trial / 16))*1.8
alter VB3 = $&drive
let drive = (floor(trial / 16) - 2*floor(trial / 32))*1.8
alter VB4 = $&drive
let drive = (floor(trial / 32) - 2*floor(trial / 64))*1.8
alter VB5 = $&drive
let drive = (floor(trial / 64) - 2*floor(trial / 128))*1.8
alter VB6 = $&drive
let drive = (floor(trial / 128) - 2*floor(trial / 256))*1.8
alter VB7 = $&drive
stop when time = 0.004212
resume
delete all
let endpoint = length(time)-1
let cmp = v(COMP)[endpoint]
let top = v(TOP)[endpoint]
let decision = 0
if cmp >= 0.9
let code = trial
let decision = 1
end
echo 233 0 $&trial $&cmp $&top 1.08046875 $&decision >> decisions.csv
alter VIN = 1.08515625
alter VSAMPLE = 1.8
alter VB0 = 0
alter VB1 = 0
alter VB2 = 0
alter VB3 = 0
alter VB4 = 0
alter VB5 = 0
alter VB6 = 0
alter VB7 = 0
let code = 0
stop when time = 0.004214
resume
delete all
alter VSAMPLE = 0
let trial = code + 128
let drive = (floor(trial / 1) - 2*floor(trial / 2))*1.8
alter VB0 = $&drive
let drive = (floor(trial / 2) - 2*floor(trial / 4))*1.8
alter VB1 = $&drive
let drive = (floor(trial / 4) - 2*floor(trial / 8))*1.8
alter VB2 = $&drive
let drive = (floor(trial / 8) - 2*floor(trial / 16))*1.8
alter VB3 = $&drive
let drive = (floor(trial / 16) - 2*floor(trial / 32))*1.8
alter VB4 = $&drive
let drive = (floor(trial / 32) - 2*floor(trial / 64))*1.8
alter VB5 = $&drive
let drive = (floor(trial / 64) - 2*floor(trial / 128))*1.8
alter VB6 = $&drive
let drive = (floor(trial / 128) - 2*floor(trial / 256))*1.8
alter VB7 = $&drive
stop when time = 0.004216
resume
delete all
let endpoint = length(time)-1
let cmp = v(COMP)[endpoint]
let top = v(TOP)[endpoint]
let decision = 0
if cmp >= 0.9
let code = trial
let decision = 1
end
echo 234 7 $&trial $&cmp $&top 1.08515625 $&decision >> decisions.csv
let trial = code + 64
let drive = (floor(trial / 1) - 2*floor(trial / 2))*1.8
alter VB0 = $&drive
let drive = (floor(trial / 2) - 2*floor(trial / 4))*1.8
alter VB1 = $&drive
let drive = (floor(trial / 4) - 2*floor(trial / 8))*1.8
alter VB2 = $&drive
let drive = (floor(trial / 8) - 2*floor(trial / 16))*1.8
alter VB3 = $&drive
let drive = (floor(trial / 16) - 2*floor(trial / 32))*1.8
alter VB4 = $&drive
let drive = (floor(trial / 32) - 2*floor(trial / 64))*1.8
alter VB5 = $&drive
let drive = (floor(trial / 64) - 2*floor(trial / 128))*1.8
alter VB6 = $&drive
let drive = (floor(trial / 128) - 2*floor(trial / 256))*1.8
alter VB7 = $&drive
stop when time = 0.004218
resume
delete all
let endpoint = length(time)-1
let cmp = v(COMP)[endpoint]
let top = v(TOP)[endpoint]
let decision = 0
if cmp >= 0.9
let code = trial
let decision = 1
end
echo 234 6 $&trial $&cmp $&top 1.08515625 $&decision >> decisions.csv
let trial = code + 32
let drive = (floor(trial / 1) - 2*floor(trial / 2))*1.8
alter VB0 = $&drive
let drive = (floor(trial / 2) - 2*floor(trial / 4))*1.8
alter VB1 = $&drive
let drive = (floor(trial / 4) - 2*floor(trial / 8))*1.8
alter VB2 = $&drive
let drive = (floor(trial / 8) - 2*floor(trial / 16))*1.8
alter VB3 = $&drive
let drive = (floor(trial / 16) - 2*floor(trial / 32))*1.8
alter VB4 = $&drive
let drive = (floor(trial / 32) - 2*floor(trial / 64))*1.8
alter VB5 = $&drive
let drive = (floor(trial / 64) - 2*floor(trial / 128))*1.8
alter VB6 = $&drive
let drive = (floor(trial / 128) - 2*floor(trial / 256))*1.8
alter VB7 = $&drive
stop when time = 0.00422
resume
delete all
let endpoint = length(time)-1
let cmp = v(COMP)[endpoint]
let top = v(TOP)[endpoint]
let decision = 0
if cmp >= 0.9
let code = trial
let decision = 1
end
echo 234 5 $&trial $&cmp $&top 1.08515625 $&decision >> decisions.csv
let trial = code + 16
let drive = (floor(trial / 1) - 2*floor(trial / 2))*1.8
alter VB0 = $&drive
let drive = (floor(trial / 2) - 2*floor(trial / 4))*1.8
alter VB1 = $&drive
let drive = (floor(trial / 4) - 2*floor(trial / 8))*1.8
alter VB2 = $&drive
let drive = (floor(trial / 8) - 2*floor(trial / 16))*1.8
alter VB3 = $&drive
let drive = (floor(trial / 16) - 2*floor(trial / 32))*1.8
alter VB4 = $&drive
let drive = (floor(trial / 32) - 2*floor(trial / 64))*1.8
alter VB5 = $&drive
let drive = (floor(trial / 64) - 2*floor(trial / 128))*1.8
alter VB6 = $&drive
let drive = (floor(trial / 128) - 2*floor(trial / 256))*1.8
alter VB7 = $&drive
stop when time = 0.004222
resume
delete all
let endpoint = length(time)-1
let cmp = v(COMP)[endpoint]
let top = v(TOP)[endpoint]
let decision = 0
if cmp >= 0.9
let code = trial
let decision = 1
end
echo 234 4 $&trial $&cmp $&top 1.08515625 $&decision >> decisions.csv
let trial = code + 8
let drive = (floor(trial / 1) - 2*floor(trial / 2))*1.8
alter VB0 = $&drive
let drive = (floor(trial / 2) - 2*floor(trial / 4))*1.8
alter VB1 = $&drive
let drive = (floor(trial / 4) - 2*floor(trial / 8))*1.8
alter VB2 = $&drive
let drive = (floor(trial / 8) - 2*floor(trial / 16))*1.8
alter VB3 = $&drive
let drive = (floor(trial / 16) - 2*floor(trial / 32))*1.8
alter VB4 = $&drive
let drive = (floor(trial / 32) - 2*floor(trial / 64))*1.8
alter VB5 = $&drive
let drive = (floor(trial / 64) - 2*floor(trial / 128))*1.8
alter VB6 = $&drive
let drive = (floor(trial / 128) - 2*floor(trial / 256))*1.8
alter VB7 = $&drive
stop when time = 0.004224
resume
delete all
let endpoint = length(time)-1
let cmp = v(COMP)[endpoint]
let top = v(TOP)[endpoint]
let decision = 0
if cmp >= 0.9
let code = trial
let decision = 1
end
echo 234 3 $&trial $&cmp $&top 1.08515625 $&decision >> decisions.csv
let trial = code + 4
let drive = (floor(trial / 1) - 2*floor(trial / 2))*1.8
alter VB0 = $&drive
let drive = (floor(trial / 2) - 2*floor(trial / 4))*1.8
alter VB1 = $&drive
let drive = (floor(trial / 4) - 2*floor(trial / 8))*1.8
alter VB2 = $&drive
let drive = (floor(trial / 8) - 2*floor(trial / 16))*1.8
alter VB3 = $&drive
let drive = (floor(trial / 16) - 2*floor(trial / 32))*1.8
alter VB4 = $&drive
let drive = (floor(trial / 32) - 2*floor(trial / 64))*1.8
alter VB5 = $&drive
let drive = (floor(trial / 64) - 2*floor(trial / 128))*1.8
alter VB6 = $&drive
let drive = (floor(trial / 128) - 2*floor(trial / 256))*1.8
alter VB7 = $&drive
stop when time = 0.004226
resume
delete all
let endpoint = length(time)-1
let cmp = v(COMP)[endpoint]
let top = v(TOP)[endpoint]
let decision = 0
if cmp >= 0.9
let code = trial
let decision = 1
end
echo 234 2 $&trial $&cmp $&top 1.08515625 $&decision >> decisions.csv
let trial = code + 2
let drive = (floor(trial / 1) - 2*floor(trial / 2))*1.8
alter VB0 = $&drive
let drive = (floor(trial / 2) - 2*floor(trial / 4))*1.8
alter VB1 = $&drive
let drive = (floor(trial / 4) - 2*floor(trial / 8))*1.8
alter VB2 = $&drive
let drive = (floor(trial / 8) - 2*floor(trial / 16))*1.8
alter VB3 = $&drive
let drive = (floor(trial / 16) - 2*floor(trial / 32))*1.8
alter VB4 = $&drive
let drive = (floor(trial / 32) - 2*floor(trial / 64))*1.8
alter VB5 = $&drive
let drive = (floor(trial / 64) - 2*floor(trial / 128))*1.8
alter VB6 = $&drive
let drive = (floor(trial / 128) - 2*floor(trial / 256))*1.8
alter VB7 = $&drive
stop when time = 0.004228
resume
delete all
let endpoint = length(time)-1
let cmp = v(COMP)[endpoint]
let top = v(TOP)[endpoint]
let decision = 0
if cmp >= 0.9
let code = trial
let decision = 1
end
echo 234 1 $&trial $&cmp $&top 1.08515625 $&decision >> decisions.csv
let trial = code + 1
let drive = (floor(trial / 1) - 2*floor(trial / 2))*1.8
alter VB0 = $&drive
let drive = (floor(trial / 2) - 2*floor(trial / 4))*1.8
alter VB1 = $&drive
let drive = (floor(trial / 4) - 2*floor(trial / 8))*1.8
alter VB2 = $&drive
let drive = (floor(trial / 8) - 2*floor(trial / 16))*1.8
alter VB3 = $&drive
let drive = (floor(trial / 16) - 2*floor(trial / 32))*1.8
alter VB4 = $&drive
let drive = (floor(trial / 32) - 2*floor(trial / 64))*1.8
alter VB5 = $&drive
let drive = (floor(trial / 64) - 2*floor(trial / 128))*1.8
alter VB6 = $&drive
let drive = (floor(trial / 128) - 2*floor(trial / 256))*1.8
alter VB7 = $&drive
stop when time = 0.00423
resume
delete all
let endpoint = length(time)-1
let cmp = v(COMP)[endpoint]
let top = v(TOP)[endpoint]
let decision = 0
if cmp >= 0.9
let code = trial
let decision = 1
end
echo 234 0 $&trial $&cmp $&top 1.08515625 $&decision >> decisions.csv
alter VIN = 1.08984375
alter VSAMPLE = 1.8
alter VB0 = 0
alter VB1 = 0
alter VB2 = 0
alter VB3 = 0
alter VB4 = 0
alter VB5 = 0
alter VB6 = 0
alter VB7 = 0
let code = 0
stop when time = 0.004232
resume
delete all
alter VSAMPLE = 0
let trial = code + 128
let drive = (floor(trial / 1) - 2*floor(trial / 2))*1.8
alter VB0 = $&drive
let drive = (floor(trial / 2) - 2*floor(trial / 4))*1.8
alter VB1 = $&drive
let drive = (floor(trial / 4) - 2*floor(trial / 8))*1.8
alter VB2 = $&drive
let drive = (floor(trial / 8) - 2*floor(trial / 16))*1.8
alter VB3 = $&drive
let drive = (floor(trial / 16) - 2*floor(trial / 32))*1.8
alter VB4 = $&drive
let drive = (floor(trial / 32) - 2*floor(trial / 64))*1.8
alter VB5 = $&drive
let drive = (floor(trial / 64) - 2*floor(trial / 128))*1.8
alter VB6 = $&drive
let drive = (floor(trial / 128) - 2*floor(trial / 256))*1.8
alter VB7 = $&drive
stop when time = 0.004234
resume
delete all
let endpoint = length(time)-1
let cmp = v(COMP)[endpoint]
let top = v(TOP)[endpoint]
let decision = 0
if cmp >= 0.9
let code = trial
let decision = 1
end
echo 235 7 $&trial $&cmp $&top 1.08984375 $&decision >> decisions.csv
let trial = code + 64
let drive = (floor(trial / 1) - 2*floor(trial / 2))*1.8
alter VB0 = $&drive
let drive = (floor(trial / 2) - 2*floor(trial / 4))*1.8
alter VB1 = $&drive
let drive = (floor(trial / 4) - 2*floor(trial / 8))*1.8
alter VB2 = $&drive
let drive = (floor(trial / 8) - 2*floor(trial / 16))*1.8
alter VB3 = $&drive
let drive = (floor(trial / 16) - 2*floor(trial / 32))*1.8
alter VB4 = $&drive
let drive = (floor(trial / 32) - 2*floor(trial / 64))*1.8
alter VB5 = $&drive
let drive = (floor(trial / 64) - 2*floor(trial / 128))*1.8
alter VB6 = $&drive
let drive = (floor(trial / 128) - 2*floor(trial / 256))*1.8
alter VB7 = $&drive
stop when time = 0.004236
resume
delete all
let endpoint = length(time)-1
let cmp = v(COMP)[endpoint]
let top = v(TOP)[endpoint]
let decision = 0
if cmp >= 0.9
let code = trial
let decision = 1
end
echo 235 6 $&trial $&cmp $&top 1.08984375 $&decision >> decisions.csv
let trial = code + 32
let drive = (floor(trial / 1) - 2*floor(trial / 2))*1.8
alter VB0 = $&drive
let drive = (floor(trial / 2) - 2*floor(trial / 4))*1.8
alter VB1 = $&drive
let drive = (floor(trial / 4) - 2*floor(trial / 8))*1.8
alter VB2 = $&drive
let drive = (floor(trial / 8) - 2*floor(trial / 16))*1.8
alter VB3 = $&drive
let drive = (floor(trial / 16) - 2*floor(trial / 32))*1.8
alter VB4 = $&drive
let drive = (floor(trial / 32) - 2*floor(trial / 64))*1.8
alter VB5 = $&drive
let drive = (floor(trial / 64) - 2*floor(trial / 128))*1.8
alter VB6 = $&drive
let drive = (floor(trial / 128) - 2*floor(trial / 256))*1.8
alter VB7 = $&drive
stop when time = 0.004238
resume
delete all
let endpoint = length(time)-1
let cmp = v(COMP)[endpoint]
let top = v(TOP)[endpoint]
let decision = 0
if cmp >= 0.9
let code = trial
let decision = 1
end
echo 235 5 $&trial $&cmp $&top 1.08984375 $&decision >> decisions.csv
let trial = code + 16
let drive = (floor(trial / 1) - 2*floor(trial / 2))*1.8
alter VB0 = $&drive
let drive = (floor(trial / 2) - 2*floor(trial / 4))*1.8
alter VB1 = $&drive
let drive = (floor(trial / 4) - 2*floor(trial / 8))*1.8
alter VB2 = $&drive
let drive = (floor(trial / 8) - 2*floor(trial / 16))*1.8
alter VB3 = $&drive
let drive = (floor(trial / 16) - 2*floor(trial / 32))*1.8
alter VB4 = $&drive
let drive = (floor(trial / 32) - 2*floor(trial / 64))*1.8
alter VB5 = $&drive
let drive = (floor(trial / 64) - 2*floor(trial / 128))*1.8
alter VB6 = $&drive
let drive = (floor(trial / 128) - 2*floor(trial / 256))*1.8
alter VB7 = $&drive
stop when time = 0.00424
resume
delete all
let endpoint = length(time)-1
let cmp = v(COMP)[endpoint]
let top = v(TOP)[endpoint]
let decision = 0
if cmp >= 0.9
let code = trial
let decision = 1
end
echo 235 4 $&trial $&cmp $&top 1.08984375 $&decision >> decisions.csv
let trial = code + 8
let drive = (floor(trial / 1) - 2*floor(trial / 2))*1.8
alter VB0 = $&drive
let drive = (floor(trial / 2) - 2*floor(trial / 4))*1.8
alter VB1 = $&drive
let drive = (floor(trial / 4) - 2*floor(trial / 8))*1.8
alter VB2 = $&drive
let drive = (floor(trial / 8) - 2*floor(trial / 16))*1.8
alter VB3 = $&drive
let drive = (floor(trial / 16) - 2*floor(trial / 32))*1.8
alter VB4 = $&drive
let drive = (floor(trial / 32) - 2*floor(trial / 64))*1.8
alter VB5 = $&drive
let drive = (floor(trial / 64) - 2*floor(trial / 128))*1.8
alter VB6 = $&drive
let drive = (floor(trial / 128) - 2*floor(trial / 256))*1.8
alter VB7 = $&drive
stop when time = 0.004242
resume
delete all
let endpoint = length(time)-1
let cmp = v(COMP)[endpoint]
let top = v(TOP)[endpoint]
let decision = 0
if cmp >= 0.9
let code = trial
let decision = 1
end
echo 235 3 $&trial $&cmp $&top 1.08984375 $&decision >> decisions.csv
let trial = code + 4
let drive = (floor(trial / 1) - 2*floor(trial / 2))*1.8
alter VB0 = $&drive
let drive = (floor(trial / 2) - 2*floor(trial / 4))*1.8
alter VB1 = $&drive
let drive = (floor(trial / 4) - 2*floor(trial / 8))*1.8
alter VB2 = $&drive
let drive = (floor(trial / 8) - 2*floor(trial / 16))*1.8
alter VB3 = $&drive
let drive = (floor(trial / 16) - 2*floor(trial / 32))*1.8
alter VB4 = $&drive
let drive = (floor(trial / 32) - 2*floor(trial / 64))*1.8
alter VB5 = $&drive
let drive = (floor(trial / 64) - 2*floor(trial / 128))*1.8
alter VB6 = $&drive
let drive = (floor(trial / 128) - 2*floor(trial / 256))*1.8
alter VB7 = $&drive
stop when time = 0.004244
resume
delete all
let endpoint = length(time)-1
let cmp = v(COMP)[endpoint]
let top = v(TOP)[endpoint]
let decision = 0
if cmp >= 0.9
let code = trial
let decision = 1
end
echo 235 2 $&trial $&cmp $&top 1.08984375 $&decision >> decisions.csv
let trial = code + 2
let drive = (floor(trial / 1) - 2*floor(trial / 2))*1.8
alter VB0 = $&drive
let drive = (floor(trial / 2) - 2*floor(trial / 4))*1.8
alter VB1 = $&drive
let drive = (floor(trial / 4) - 2*floor(trial / 8))*1.8
alter VB2 = $&drive
let drive = (floor(trial / 8) - 2*floor(trial / 16))*1.8
alter VB3 = $&drive
let drive = (floor(trial / 16) - 2*floor(trial / 32))*1.8
alter VB4 = $&drive
let drive = (floor(trial / 32) - 2*floor(trial / 64))*1.8
alter VB5 = $&drive
let drive = (floor(trial / 64) - 2*floor(trial / 128))*1.8
alter VB6 = $&drive
let drive = (floor(trial / 128) - 2*floor(trial / 256))*1.8
alter VB7 = $&drive
stop when time = 0.004246
resume
delete all
let endpoint = length(time)-1
let cmp = v(COMP)[endpoint]
let top = v(TOP)[endpoint]
let decision = 0
if cmp >= 0.9
let code = trial
let decision = 1
end
echo 235 1 $&trial $&cmp $&top 1.08984375 $&decision >> decisions.csv
let trial = code + 1
let drive = (floor(trial / 1) - 2*floor(trial / 2))*1.8
alter VB0 = $&drive
let drive = (floor(trial / 2) - 2*floor(trial / 4))*1.8
alter VB1 = $&drive
let drive = (floor(trial / 4) - 2*floor(trial / 8))*1.8
alter VB2 = $&drive
let drive = (floor(trial / 8) - 2*floor(trial / 16))*1.8
alter VB3 = $&drive
let drive = (floor(trial / 16) - 2*floor(trial / 32))*1.8
alter VB4 = $&drive
let drive = (floor(trial / 32) - 2*floor(trial / 64))*1.8
alter VB5 = $&drive
let drive = (floor(trial / 64) - 2*floor(trial / 128))*1.8
alter VB6 = $&drive
let drive = (floor(trial / 128) - 2*floor(trial / 256))*1.8
alter VB7 = $&drive
stop when time = 0.004248
resume
delete all
let endpoint = length(time)-1
let cmp = v(COMP)[endpoint]
let top = v(TOP)[endpoint]
let decision = 0
if cmp >= 0.9
let code = trial
let decision = 1
end
echo 235 0 $&trial $&cmp $&top 1.08984375 $&decision >> decisions.csv
alter VIN = 1.09453125
alter VSAMPLE = 1.8
alter VB0 = 0
alter VB1 = 0
alter VB2 = 0
alter VB3 = 0
alter VB4 = 0
alter VB5 = 0
alter VB6 = 0
alter VB7 = 0
let code = 0
stop when time = 0.00425
resume
delete all
alter VSAMPLE = 0
let trial = code + 128
let drive = (floor(trial / 1) - 2*floor(trial / 2))*1.8
alter VB0 = $&drive
let drive = (floor(trial / 2) - 2*floor(trial / 4))*1.8
alter VB1 = $&drive
let drive = (floor(trial / 4) - 2*floor(trial / 8))*1.8
alter VB2 = $&drive
let drive = (floor(trial / 8) - 2*floor(trial / 16))*1.8
alter VB3 = $&drive
let drive = (floor(trial / 16) - 2*floor(trial / 32))*1.8
alter VB4 = $&drive
let drive = (floor(trial / 32) - 2*floor(trial / 64))*1.8
alter VB5 = $&drive
let drive = (floor(trial / 64) - 2*floor(trial / 128))*1.8
alter VB6 = $&drive
let drive = (floor(trial / 128) - 2*floor(trial / 256))*1.8
alter VB7 = $&drive
stop when time = 0.004252
resume
delete all
let endpoint = length(time)-1
let cmp = v(COMP)[endpoint]
let top = v(TOP)[endpoint]
let decision = 0
if cmp >= 0.9
let code = trial
let decision = 1
end
echo 236 7 $&trial $&cmp $&top 1.09453125 $&decision >> decisions.csv
let trial = code + 64
let drive = (floor(trial / 1) - 2*floor(trial / 2))*1.8
alter VB0 = $&drive
let drive = (floor(trial / 2) - 2*floor(trial / 4))*1.8
alter VB1 = $&drive
let drive = (floor(trial / 4) - 2*floor(trial / 8))*1.8
alter VB2 = $&drive
let drive = (floor(trial / 8) - 2*floor(trial / 16))*1.8
alter VB3 = $&drive
let drive = (floor(trial / 16) - 2*floor(trial / 32))*1.8
alter VB4 = $&drive
let drive = (floor(trial / 32) - 2*floor(trial / 64))*1.8
alter VB5 = $&drive
let drive = (floor(trial / 64) - 2*floor(trial / 128))*1.8
alter VB6 = $&drive
let drive = (floor(trial / 128) - 2*floor(trial / 256))*1.8
alter VB7 = $&drive
stop when time = 0.004254
resume
delete all
let endpoint = length(time)-1
let cmp = v(COMP)[endpoint]
let top = v(TOP)[endpoint]
let decision = 0
if cmp >= 0.9
let code = trial
let decision = 1
end
echo 236 6 $&trial $&cmp $&top 1.09453125 $&decision >> decisions.csv
let trial = code + 32
let drive = (floor(trial / 1) - 2*floor(trial / 2))*1.8
alter VB0 = $&drive
let drive = (floor(trial / 2) - 2*floor(trial / 4))*1.8
alter VB1 = $&drive
let drive = (floor(trial / 4) - 2*floor(trial / 8))*1.8
alter VB2 = $&drive
let drive = (floor(trial / 8) - 2*floor(trial / 16))*1.8
alter VB3 = $&drive
let drive = (floor(trial / 16) - 2*floor(trial / 32))*1.8
alter VB4 = $&drive
let drive = (floor(trial / 32) - 2*floor(trial / 64))*1.8
alter VB5 = $&drive
let drive = (floor(trial / 64) - 2*floor(trial / 128))*1.8
alter VB6 = $&drive
let drive = (floor(trial / 128) - 2*floor(trial / 256))*1.8
alter VB7 = $&drive
stop when time = 0.004256
resume
delete all
let endpoint = length(time)-1
let cmp = v(COMP)[endpoint]
let top = v(TOP)[endpoint]
let decision = 0
if cmp >= 0.9
let code = trial
let decision = 1
end
echo 236 5 $&trial $&cmp $&top 1.09453125 $&decision >> decisions.csv
let trial = code + 16
let drive = (floor(trial / 1) - 2*floor(trial / 2))*1.8
alter VB0 = $&drive
let drive = (floor(trial / 2) - 2*floor(trial / 4))*1.8
alter VB1 = $&drive
let drive = (floor(trial / 4) - 2*floor(trial / 8))*1.8
alter VB2 = $&drive
let drive = (floor(trial / 8) - 2*floor(trial / 16))*1.8
alter VB3 = $&drive
let drive = (floor(trial / 16) - 2*floor(trial / 32))*1.8
alter VB4 = $&drive
let drive = (floor(trial / 32) - 2*floor(trial / 64))*1.8
alter VB5 = $&drive
let drive = (floor(trial / 64) - 2*floor(trial / 128))*1.8
alter VB6 = $&drive
let drive = (floor(trial / 128) - 2*floor(trial / 256))*1.8
alter VB7 = $&drive
stop when time = 0.004258
resume
delete all
let endpoint = length(time)-1
let cmp = v(COMP)[endpoint]
let top = v(TOP)[endpoint]
let decision = 0
if cmp >= 0.9
let code = trial
let decision = 1
end
echo 236 4 $&trial $&cmp $&top 1.09453125 $&decision >> decisions.csv
let trial = code + 8
let drive = (floor(trial / 1) - 2*floor(trial / 2))*1.8
alter VB0 = $&drive
let drive = (floor(trial / 2) - 2*floor(trial / 4))*1.8
alter VB1 = $&drive
let drive = (floor(trial / 4) - 2*floor(trial / 8))*1.8
alter VB2 = $&drive
let drive = (floor(trial / 8) - 2*floor(trial / 16))*1.8
alter VB3 = $&drive
let drive = (floor(trial / 16) - 2*floor(trial / 32))*1.8
alter VB4 = $&drive
let drive = (floor(trial / 32) - 2*floor(trial / 64))*1.8
alter VB5 = $&drive
let drive = (floor(trial / 64) - 2*floor(trial / 128))*1.8
alter VB6 = $&drive
let drive = (floor(trial / 128) - 2*floor(trial / 256))*1.8
alter VB7 = $&drive
stop when time = 0.00426
resume
delete all
let endpoint = length(time)-1
let cmp = v(COMP)[endpoint]
let top = v(TOP)[endpoint]
let decision = 0
if cmp >= 0.9
let code = trial
let decision = 1
end
echo 236 3 $&trial $&cmp $&top 1.09453125 $&decision >> decisions.csv
let trial = code + 4
let drive = (floor(trial / 1) - 2*floor(trial / 2))*1.8
alter VB0 = $&drive
let drive = (floor(trial / 2) - 2*floor(trial / 4))*1.8
alter VB1 = $&drive
let drive = (floor(trial / 4) - 2*floor(trial / 8))*1.8
alter VB2 = $&drive
let drive = (floor(trial / 8) - 2*floor(trial / 16))*1.8
alter VB3 = $&drive
let drive = (floor(trial / 16) - 2*floor(trial / 32))*1.8
alter VB4 = $&drive
let drive = (floor(trial / 32) - 2*floor(trial / 64))*1.8
alter VB5 = $&drive
let drive = (floor(trial / 64) - 2*floor(trial / 128))*1.8
alter VB6 = $&drive
let drive = (floor(trial / 128) - 2*floor(trial / 256))*1.8
alter VB7 = $&drive
stop when time = 0.004262
resume
delete all
let endpoint = length(time)-1
let cmp = v(COMP)[endpoint]
let top = v(TOP)[endpoint]
let decision = 0
if cmp >= 0.9
let code = trial
let decision = 1
end
echo 236 2 $&trial $&cmp $&top 1.09453125 $&decision >> decisions.csv
let trial = code + 2
let drive = (floor(trial / 1) - 2*floor(trial / 2))*1.8
alter VB0 = $&drive
let drive = (floor(trial / 2) - 2*floor(trial / 4))*1.8
alter VB1 = $&drive
let drive = (floor(trial / 4) - 2*floor(trial / 8))*1.8
alter VB2 = $&drive
let drive = (floor(trial / 8) - 2*floor(trial / 16))*1.8
alter VB3 = $&drive
let drive = (floor(trial / 16) - 2*floor(trial / 32))*1.8
alter VB4 = $&drive
let drive = (floor(trial / 32) - 2*floor(trial / 64))*1.8
alter VB5 = $&drive
let drive = (floor(trial / 64) - 2*floor(trial / 128))*1.8
alter VB6 = $&drive
let drive = (floor(trial / 128) - 2*floor(trial / 256))*1.8
alter VB7 = $&drive
stop when time = 0.004264
resume
delete all
let endpoint = length(time)-1
let cmp = v(COMP)[endpoint]
let top = v(TOP)[endpoint]
let decision = 0
if cmp >= 0.9
let code = trial
let decision = 1
end
echo 236 1 $&trial $&cmp $&top 1.09453125 $&decision >> decisions.csv
let trial = code + 1
let drive = (floor(trial / 1) - 2*floor(trial / 2))*1.8
alter VB0 = $&drive
let drive = (floor(trial / 2) - 2*floor(trial / 4))*1.8
alter VB1 = $&drive
let drive = (floor(trial / 4) - 2*floor(trial / 8))*1.8
alter VB2 = $&drive
let drive = (floor(trial / 8) - 2*floor(trial / 16))*1.8
alter VB3 = $&drive
let drive = (floor(trial / 16) - 2*floor(trial / 32))*1.8
alter VB4 = $&drive
let drive = (floor(trial / 32) - 2*floor(trial / 64))*1.8
alter VB5 = $&drive
let drive = (floor(trial / 64) - 2*floor(trial / 128))*1.8
alter VB6 = $&drive
let drive = (floor(trial / 128) - 2*floor(trial / 256))*1.8
alter VB7 = $&drive
stop when time = 0.004266
resume
delete all
let endpoint = length(time)-1
let cmp = v(COMP)[endpoint]
let top = v(TOP)[endpoint]
let decision = 0
if cmp >= 0.9
let code = trial
let decision = 1
end
echo 236 0 $&trial $&cmp $&top 1.09453125 $&decision >> decisions.csv
alter VIN = 1.09921875
alter VSAMPLE = 1.8
alter VB0 = 0
alter VB1 = 0
alter VB2 = 0
alter VB3 = 0
alter VB4 = 0
alter VB5 = 0
alter VB6 = 0
alter VB7 = 0
let code = 0
stop when time = 0.004268
resume
delete all
alter VSAMPLE = 0
let trial = code + 128
let drive = (floor(trial / 1) - 2*floor(trial / 2))*1.8
alter VB0 = $&drive
let drive = (floor(trial / 2) - 2*floor(trial / 4))*1.8
alter VB1 = $&drive
let drive = (floor(trial / 4) - 2*floor(trial / 8))*1.8
alter VB2 = $&drive
let drive = (floor(trial / 8) - 2*floor(trial / 16))*1.8
alter VB3 = $&drive
let drive = (floor(trial / 16) - 2*floor(trial / 32))*1.8
alter VB4 = $&drive
let drive = (floor(trial / 32) - 2*floor(trial / 64))*1.8
alter VB5 = $&drive
let drive = (floor(trial / 64) - 2*floor(trial / 128))*1.8
alter VB6 = $&drive
let drive = (floor(trial / 128) - 2*floor(trial / 256))*1.8
alter VB7 = $&drive
stop when time = 0.00427
resume
delete all
let endpoint = length(time)-1
let cmp = v(COMP)[endpoint]
let top = v(TOP)[endpoint]
let decision = 0
if cmp >= 0.9
let code = trial
let decision = 1
end
echo 237 7 $&trial $&cmp $&top 1.09921875 $&decision >> decisions.csv
let trial = code + 64
let drive = (floor(trial / 1) - 2*floor(trial / 2))*1.8
alter VB0 = $&drive
let drive = (floor(trial / 2) - 2*floor(trial / 4))*1.8
alter VB1 = $&drive
let drive = (floor(trial / 4) - 2*floor(trial / 8))*1.8
alter VB2 = $&drive
let drive = (floor(trial / 8) - 2*floor(trial / 16))*1.8
alter VB3 = $&drive
let drive = (floor(trial / 16) - 2*floor(trial / 32))*1.8
alter VB4 = $&drive
let drive = (floor(trial / 32) - 2*floor(trial / 64))*1.8
alter VB5 = $&drive
let drive = (floor(trial / 64) - 2*floor(trial / 128))*1.8
alter VB6 = $&drive
let drive = (floor(trial / 128) - 2*floor(trial / 256))*1.8
alter VB7 = $&drive
stop when time = 0.004272
resume
delete all
let endpoint = length(time)-1
let cmp = v(COMP)[endpoint]
let top = v(TOP)[endpoint]
let decision = 0
if cmp >= 0.9
let code = trial
let decision = 1
end
echo 237 6 $&trial $&cmp $&top 1.09921875 $&decision >> decisions.csv
let trial = code + 32
let drive = (floor(trial / 1) - 2*floor(trial / 2))*1.8
alter VB0 = $&drive
let drive = (floor(trial / 2) - 2*floor(trial / 4))*1.8
alter VB1 = $&drive
let drive = (floor(trial / 4) - 2*floor(trial / 8))*1.8
alter VB2 = $&drive
let drive = (floor(trial / 8) - 2*floor(trial / 16))*1.8
alter VB3 = $&drive
let drive = (floor(trial / 16) - 2*floor(trial / 32))*1.8
alter VB4 = $&drive
let drive = (floor(trial / 32) - 2*floor(trial / 64))*1.8
alter VB5 = $&drive
let drive = (floor(trial / 64) - 2*floor(trial / 128))*1.8
alter VB6 = $&drive
let drive = (floor(trial / 128) - 2*floor(trial / 256))*1.8
alter VB7 = $&drive
stop when time = 0.004274
resume
delete all
let endpoint = length(time)-1
let cmp = v(COMP)[endpoint]
let top = v(TOP)[endpoint]
let decision = 0
if cmp >= 0.9
let code = trial
let decision = 1
end
echo 237 5 $&trial $&cmp $&top 1.09921875 $&decision >> decisions.csv
let trial = code + 16
let drive = (floor(trial / 1) - 2*floor(trial / 2))*1.8
alter VB0 = $&drive
let drive = (floor(trial / 2) - 2*floor(trial / 4))*1.8
alter VB1 = $&drive
let drive = (floor(trial / 4) - 2*floor(trial / 8))*1.8
alter VB2 = $&drive
let drive = (floor(trial / 8) - 2*floor(trial / 16))*1.8
alter VB3 = $&drive
let drive = (floor(trial / 16) - 2*floor(trial / 32))*1.8
alter VB4 = $&drive
let drive = (floor(trial / 32) - 2*floor(trial / 64))*1.8
alter VB5 = $&drive
let drive = (floor(trial / 64) - 2*floor(trial / 128))*1.8
alter VB6 = $&drive
let drive = (floor(trial / 128) - 2*floor(trial / 256))*1.8
alter VB7 = $&drive
stop when time = 0.004276
resume
delete all
let endpoint = length(time)-1
let cmp = v(COMP)[endpoint]
let top = v(TOP)[endpoint]
let decision = 0
if cmp >= 0.9
let code = trial
let decision = 1
end
echo 237 4 $&trial $&cmp $&top 1.09921875 $&decision >> decisions.csv
let trial = code + 8
let drive = (floor(trial / 1) - 2*floor(trial / 2))*1.8
alter VB0 = $&drive
let drive = (floor(trial / 2) - 2*floor(trial / 4))*1.8
alter VB1 = $&drive
let drive = (floor(trial / 4) - 2*floor(trial / 8))*1.8
alter VB2 = $&drive
let drive = (floor(trial / 8) - 2*floor(trial / 16))*1.8
alter VB3 = $&drive
let drive = (floor(trial / 16) - 2*floor(trial / 32))*1.8
alter VB4 = $&drive
let drive = (floor(trial / 32) - 2*floor(trial / 64))*1.8
alter VB5 = $&drive
let drive = (floor(trial / 64) - 2*floor(trial / 128))*1.8
alter VB6 = $&drive
let drive = (floor(trial / 128) - 2*floor(trial / 256))*1.8
alter VB7 = $&drive
stop when time = 0.004278
resume
delete all
let endpoint = length(time)-1
let cmp = v(COMP)[endpoint]
let top = v(TOP)[endpoint]
let decision = 0
if cmp >= 0.9
let code = trial
let decision = 1
end
echo 237 3 $&trial $&cmp $&top 1.09921875 $&decision >> decisions.csv
let trial = code + 4
let drive = (floor(trial / 1) - 2*floor(trial / 2))*1.8
alter VB0 = $&drive
let drive = (floor(trial / 2) - 2*floor(trial / 4))*1.8
alter VB1 = $&drive
let drive = (floor(trial / 4) - 2*floor(trial / 8))*1.8
alter VB2 = $&drive
let drive = (floor(trial / 8) - 2*floor(trial / 16))*1.8
alter VB3 = $&drive
let drive = (floor(trial / 16) - 2*floor(trial / 32))*1.8
alter VB4 = $&drive
let drive = (floor(trial / 32) - 2*floor(trial / 64))*1.8
alter VB5 = $&drive
let drive = (floor(trial / 64) - 2*floor(trial / 128))*1.8
alter VB6 = $&drive
let drive = (floor(trial / 128) - 2*floor(trial / 256))*1.8
alter VB7 = $&drive
stop when time = 0.00428
resume
delete all
let endpoint = length(time)-1
let cmp = v(COMP)[endpoint]
let top = v(TOP)[endpoint]
let decision = 0
if cmp >= 0.9
let code = trial
let decision = 1
end
echo 237 2 $&trial $&cmp $&top 1.09921875 $&decision >> decisions.csv
let trial = code + 2
let drive = (floor(trial / 1) - 2*floor(trial / 2))*1.8
alter VB0 = $&drive
let drive = (floor(trial / 2) - 2*floor(trial / 4))*1.8
alter VB1 = $&drive
let drive = (floor(trial / 4) - 2*floor(trial / 8))*1.8
alter VB2 = $&drive
let drive = (floor(trial / 8) - 2*floor(trial / 16))*1.8
alter VB3 = $&drive
let drive = (floor(trial / 16) - 2*floor(trial / 32))*1.8
alter VB4 = $&drive
let drive = (floor(trial / 32) - 2*floor(trial / 64))*1.8
alter VB5 = $&drive
let drive = (floor(trial / 64) - 2*floor(trial / 128))*1.8
alter VB6 = $&drive
let drive = (floor(trial / 128) - 2*floor(trial / 256))*1.8
alter VB7 = $&drive
stop when time = 0.004282
resume
delete all
let endpoint = length(time)-1
let cmp = v(COMP)[endpoint]
let top = v(TOP)[endpoint]
let decision = 0
if cmp >= 0.9
let code = trial
let decision = 1
end
echo 237 1 $&trial $&cmp $&top 1.09921875 $&decision >> decisions.csv
let trial = code + 1
let drive = (floor(trial / 1) - 2*floor(trial / 2))*1.8
alter VB0 = $&drive
let drive = (floor(trial / 2) - 2*floor(trial / 4))*1.8
alter VB1 = $&drive
let drive = (floor(trial / 4) - 2*floor(trial / 8))*1.8
alter VB2 = $&drive
let drive = (floor(trial / 8) - 2*floor(trial / 16))*1.8
alter VB3 = $&drive
let drive = (floor(trial / 16) - 2*floor(trial / 32))*1.8
alter VB4 = $&drive
let drive = (floor(trial / 32) - 2*floor(trial / 64))*1.8
alter VB5 = $&drive
let drive = (floor(trial / 64) - 2*floor(trial / 128))*1.8
alter VB6 = $&drive
let drive = (floor(trial / 128) - 2*floor(trial / 256))*1.8
alter VB7 = $&drive
stop when time = 0.004284
resume
delete all
let endpoint = length(time)-1
let cmp = v(COMP)[endpoint]
let top = v(TOP)[endpoint]
let decision = 0
if cmp >= 0.9
let code = trial
let decision = 1
end
echo 237 0 $&trial $&cmp $&top 1.09921875 $&decision >> decisions.csv
alter VIN = 1.10390625
alter VSAMPLE = 1.8
alter VB0 = 0
alter VB1 = 0
alter VB2 = 0
alter VB3 = 0
alter VB4 = 0
alter VB5 = 0
alter VB6 = 0
alter VB7 = 0
let code = 0
stop when time = 0.004286
resume
delete all
alter VSAMPLE = 0
let trial = code + 128
let drive = (floor(trial / 1) - 2*floor(trial / 2))*1.8
alter VB0 = $&drive
let drive = (floor(trial / 2) - 2*floor(trial / 4))*1.8
alter VB1 = $&drive
let drive = (floor(trial / 4) - 2*floor(trial / 8))*1.8
alter VB2 = $&drive
let drive = (floor(trial / 8) - 2*floor(trial / 16))*1.8
alter VB3 = $&drive
let drive = (floor(trial / 16) - 2*floor(trial / 32))*1.8
alter VB4 = $&drive
let drive = (floor(trial / 32) - 2*floor(trial / 64))*1.8
alter VB5 = $&drive
let drive = (floor(trial / 64) - 2*floor(trial / 128))*1.8
alter VB6 = $&drive
let drive = (floor(trial / 128) - 2*floor(trial / 256))*1.8
alter VB7 = $&drive
stop when time = 0.004288
resume
delete all
let endpoint = length(time)-1
let cmp = v(COMP)[endpoint]
let top = v(TOP)[endpoint]
let decision = 0
if cmp >= 0.9
let code = trial
let decision = 1
end
echo 238 7 $&trial $&cmp $&top 1.10390625 $&decision >> decisions.csv
let trial = code + 64
let drive = (floor(trial / 1) - 2*floor(trial / 2))*1.8
alter VB0 = $&drive
let drive = (floor(trial / 2) - 2*floor(trial / 4))*1.8
alter VB1 = $&drive
let drive = (floor(trial / 4) - 2*floor(trial / 8))*1.8
alter VB2 = $&drive
let drive = (floor(trial / 8) - 2*floor(trial / 16))*1.8
alter VB3 = $&drive
let drive = (floor(trial / 16) - 2*floor(trial / 32))*1.8
alter VB4 = $&drive
let drive = (floor(trial / 32) - 2*floor(trial / 64))*1.8
alter VB5 = $&drive
let drive = (floor(trial / 64) - 2*floor(trial / 128))*1.8
alter VB6 = $&drive
let drive = (floor(trial / 128) - 2*floor(trial / 256))*1.8
alter VB7 = $&drive
stop when time = 0.00429
resume
delete all
let endpoint = length(time)-1
let cmp = v(COMP)[endpoint]
let top = v(TOP)[endpoint]
let decision = 0
if cmp >= 0.9
let code = trial
let decision = 1
end
echo 238 6 $&trial $&cmp $&top 1.10390625 $&decision >> decisions.csv
let trial = code + 32
let drive = (floor(trial / 1) - 2*floor(trial / 2))*1.8
alter VB0 = $&drive
let drive = (floor(trial / 2) - 2*floor(trial / 4))*1.8
alter VB1 = $&drive
let drive = (floor(trial / 4) - 2*floor(trial / 8))*1.8
alter VB2 = $&drive
let drive = (floor(trial / 8) - 2*floor(trial / 16))*1.8
alter VB3 = $&drive
let drive = (floor(trial / 16) - 2*floor(trial / 32))*1.8
alter VB4 = $&drive
let drive = (floor(trial / 32) - 2*floor(trial / 64))*1.8
alter VB5 = $&drive
let drive = (floor(trial / 64) - 2*floor(trial / 128))*1.8
alter VB6 = $&drive
let drive = (floor(trial / 128) - 2*floor(trial / 256))*1.8
alter VB7 = $&drive
stop when time = 0.004292
resume
delete all
let endpoint = length(time)-1
let cmp = v(COMP)[endpoint]
let top = v(TOP)[endpoint]
let decision = 0
if cmp >= 0.9
let code = trial
let decision = 1
end
echo 238 5 $&trial $&cmp $&top 1.10390625 $&decision >> decisions.csv
let trial = code + 16
let drive = (floor(trial / 1) - 2*floor(trial / 2))*1.8
alter VB0 = $&drive
let drive = (floor(trial / 2) - 2*floor(trial / 4))*1.8
alter VB1 = $&drive
let drive = (floor(trial / 4) - 2*floor(trial / 8))*1.8
alter VB2 = $&drive
let drive = (floor(trial / 8) - 2*floor(trial / 16))*1.8
alter VB3 = $&drive
let drive = (floor(trial / 16) - 2*floor(trial / 32))*1.8
alter VB4 = $&drive
let drive = (floor(trial / 32) - 2*floor(trial / 64))*1.8
alter VB5 = $&drive
let drive = (floor(trial / 64) - 2*floor(trial / 128))*1.8
alter VB6 = $&drive
let drive = (floor(trial / 128) - 2*floor(trial / 256))*1.8
alter VB7 = $&drive
stop when time = 0.004294
resume
delete all
let endpoint = length(time)-1
let cmp = v(COMP)[endpoint]
let top = v(TOP)[endpoint]
let decision = 0
if cmp >= 0.9
let code = trial
let decision = 1
end
echo 238 4 $&trial $&cmp $&top 1.10390625 $&decision >> decisions.csv
let trial = code + 8
let drive = (floor(trial / 1) - 2*floor(trial / 2))*1.8
alter VB0 = $&drive
let drive = (floor(trial / 2) - 2*floor(trial / 4))*1.8
alter VB1 = $&drive
let drive = (floor(trial / 4) - 2*floor(trial / 8))*1.8
alter VB2 = $&drive
let drive = (floor(trial / 8) - 2*floor(trial / 16))*1.8
alter VB3 = $&drive
let drive = (floor(trial / 16) - 2*floor(trial / 32))*1.8
alter VB4 = $&drive
let drive = (floor(trial / 32) - 2*floor(trial / 64))*1.8
alter VB5 = $&drive
let drive = (floor(trial / 64) - 2*floor(trial / 128))*1.8
alter VB6 = $&drive
let drive = (floor(trial / 128) - 2*floor(trial / 256))*1.8
alter VB7 = $&drive
stop when time = 0.004296
resume
delete all
let endpoint = length(time)-1
let cmp = v(COMP)[endpoint]
let top = v(TOP)[endpoint]
let decision = 0
if cmp >= 0.9
let code = trial
let decision = 1
end
echo 238 3 $&trial $&cmp $&top 1.10390625 $&decision >> decisions.csv
let trial = code + 4
let drive = (floor(trial / 1) - 2*floor(trial / 2))*1.8
alter VB0 = $&drive
let drive = (floor(trial / 2) - 2*floor(trial / 4))*1.8
alter VB1 = $&drive
let drive = (floor(trial / 4) - 2*floor(trial / 8))*1.8
alter VB2 = $&drive
let drive = (floor(trial / 8) - 2*floor(trial / 16))*1.8
alter VB3 = $&drive
let drive = (floor(trial / 16) - 2*floor(trial / 32))*1.8
alter VB4 = $&drive
let drive = (floor(trial / 32) - 2*floor(trial / 64))*1.8
alter VB5 = $&drive
let drive = (floor(trial / 64) - 2*floor(trial / 128))*1.8
alter VB6 = $&drive
let drive = (floor(trial / 128) - 2*floor(trial / 256))*1.8
alter VB7 = $&drive
stop when time = 0.004298
resume
delete all
let endpoint = length(time)-1
let cmp = v(COMP)[endpoint]
let top = v(TOP)[endpoint]
let decision = 0
if cmp >= 0.9
let code = trial
let decision = 1
end
echo 238 2 $&trial $&cmp $&top 1.10390625 $&decision >> decisions.csv
let trial = code + 2
let drive = (floor(trial / 1) - 2*floor(trial / 2))*1.8
alter VB0 = $&drive
let drive = (floor(trial / 2) - 2*floor(trial / 4))*1.8
alter VB1 = $&drive
let drive = (floor(trial / 4) - 2*floor(trial / 8))*1.8
alter VB2 = $&drive
let drive = (floor(trial / 8) - 2*floor(trial / 16))*1.8
alter VB3 = $&drive
let drive = (floor(trial / 16) - 2*floor(trial / 32))*1.8
alter VB4 = $&drive
let drive = (floor(trial / 32) - 2*floor(trial / 64))*1.8
alter VB5 = $&drive
let drive = (floor(trial / 64) - 2*floor(trial / 128))*1.8
alter VB6 = $&drive
let drive = (floor(trial / 128) - 2*floor(trial / 256))*1.8
alter VB7 = $&drive
stop when time = 0.0043
resume
delete all
let endpoint = length(time)-1
let cmp = v(COMP)[endpoint]
let top = v(TOP)[endpoint]
let decision = 0
if cmp >= 0.9
let code = trial
let decision = 1
end
echo 238 1 $&trial $&cmp $&top 1.10390625 $&decision >> decisions.csv
let trial = code + 1
let drive = (floor(trial / 1) - 2*floor(trial / 2))*1.8
alter VB0 = $&drive
let drive = (floor(trial / 2) - 2*floor(trial / 4))*1.8
alter VB1 = $&drive
let drive = (floor(trial / 4) - 2*floor(trial / 8))*1.8
alter VB2 = $&drive
let drive = (floor(trial / 8) - 2*floor(trial / 16))*1.8
alter VB3 = $&drive
let drive = (floor(trial / 16) - 2*floor(trial / 32))*1.8
alter VB4 = $&drive
let drive = (floor(trial / 32) - 2*floor(trial / 64))*1.8
alter VB5 = $&drive
let drive = (floor(trial / 64) - 2*floor(trial / 128))*1.8
alter VB6 = $&drive
let drive = (floor(trial / 128) - 2*floor(trial / 256))*1.8
alter VB7 = $&drive
stop when time = 0.004302
resume
delete all
let endpoint = length(time)-1
let cmp = v(COMP)[endpoint]
let top = v(TOP)[endpoint]
let decision = 0
if cmp >= 0.9
let code = trial
let decision = 1
end
echo 238 0 $&trial $&cmp $&top 1.10390625 $&decision >> decisions.csv
alter VIN = 1.10859375
alter VSAMPLE = 1.8
alter VB0 = 0
alter VB1 = 0
alter VB2 = 0
alter VB3 = 0
alter VB4 = 0
alter VB5 = 0
alter VB6 = 0
alter VB7 = 0
let code = 0
stop when time = 0.004304
resume
delete all
alter VSAMPLE = 0
let trial = code + 128
let drive = (floor(trial / 1) - 2*floor(trial / 2))*1.8
alter VB0 = $&drive
let drive = (floor(trial / 2) - 2*floor(trial / 4))*1.8
alter VB1 = $&drive
let drive = (floor(trial / 4) - 2*floor(trial / 8))*1.8
alter VB2 = $&drive
let drive = (floor(trial / 8) - 2*floor(trial / 16))*1.8
alter VB3 = $&drive
let drive = (floor(trial / 16) - 2*floor(trial / 32))*1.8
alter VB4 = $&drive
let drive = (floor(trial / 32) - 2*floor(trial / 64))*1.8
alter VB5 = $&drive
let drive = (floor(trial / 64) - 2*floor(trial / 128))*1.8
alter VB6 = $&drive
let drive = (floor(trial / 128) - 2*floor(trial / 256))*1.8
alter VB7 = $&drive
stop when time = 0.004306
resume
delete all
let endpoint = length(time)-1
let cmp = v(COMP)[endpoint]
let top = v(TOP)[endpoint]
let decision = 0
if cmp >= 0.9
let code = trial
let decision = 1
end
echo 239 7 $&trial $&cmp $&top 1.10859375 $&decision >> decisions.csv
let trial = code + 64
let drive = (floor(trial / 1) - 2*floor(trial / 2))*1.8
alter VB0 = $&drive
let drive = (floor(trial / 2) - 2*floor(trial / 4))*1.8
alter VB1 = $&drive
let drive = (floor(trial / 4) - 2*floor(trial / 8))*1.8
alter VB2 = $&drive
let drive = (floor(trial / 8) - 2*floor(trial / 16))*1.8
alter VB3 = $&drive
let drive = (floor(trial / 16) - 2*floor(trial / 32))*1.8
alter VB4 = $&drive
let drive = (floor(trial / 32) - 2*floor(trial / 64))*1.8
alter VB5 = $&drive
let drive = (floor(trial / 64) - 2*floor(trial / 128))*1.8
alter VB6 = $&drive
let drive = (floor(trial / 128) - 2*floor(trial / 256))*1.8
alter VB7 = $&drive
stop when time = 0.004308
resume
delete all
let endpoint = length(time)-1
let cmp = v(COMP)[endpoint]
let top = v(TOP)[endpoint]
let decision = 0
if cmp >= 0.9
let code = trial
let decision = 1
end
echo 239 6 $&trial $&cmp $&top 1.10859375 $&decision >> decisions.csv
let trial = code + 32
let drive = (floor(trial / 1) - 2*floor(trial / 2))*1.8
alter VB0 = $&drive
let drive = (floor(trial / 2) - 2*floor(trial / 4))*1.8
alter VB1 = $&drive
let drive = (floor(trial / 4) - 2*floor(trial / 8))*1.8
alter VB2 = $&drive
let drive = (floor(trial / 8) - 2*floor(trial / 16))*1.8
alter VB3 = $&drive
let drive = (floor(trial / 16) - 2*floor(trial / 32))*1.8
alter VB4 = $&drive
let drive = (floor(trial / 32) - 2*floor(trial / 64))*1.8
alter VB5 = $&drive
let drive = (floor(trial / 64) - 2*floor(trial / 128))*1.8
alter VB6 = $&drive
let drive = (floor(trial / 128) - 2*floor(trial / 256))*1.8
alter VB7 = $&drive
stop when time = 0.00431
resume
delete all
let endpoint = length(time)-1
let cmp = v(COMP)[endpoint]
let top = v(TOP)[endpoint]
let decision = 0
if cmp >= 0.9
let code = trial
let decision = 1
end
echo 239 5 $&trial $&cmp $&top 1.10859375 $&decision >> decisions.csv
let trial = code + 16
let drive = (floor(trial / 1) - 2*floor(trial / 2))*1.8
alter VB0 = $&drive
let drive = (floor(trial / 2) - 2*floor(trial / 4))*1.8
alter VB1 = $&drive
let drive = (floor(trial / 4) - 2*floor(trial / 8))*1.8
alter VB2 = $&drive
let drive = (floor(trial / 8) - 2*floor(trial / 16))*1.8
alter VB3 = $&drive
let drive = (floor(trial / 16) - 2*floor(trial / 32))*1.8
alter VB4 = $&drive
let drive = (floor(trial / 32) - 2*floor(trial / 64))*1.8
alter VB5 = $&drive
let drive = (floor(trial / 64) - 2*floor(trial / 128))*1.8
alter VB6 = $&drive
let drive = (floor(trial / 128) - 2*floor(trial / 256))*1.8
alter VB7 = $&drive
stop when time = 0.004312
resume
delete all
let endpoint = length(time)-1
let cmp = v(COMP)[endpoint]
let top = v(TOP)[endpoint]
let decision = 0
if cmp >= 0.9
let code = trial
let decision = 1
end
echo 239 4 $&trial $&cmp $&top 1.10859375 $&decision >> decisions.csv
let trial = code + 8
let drive = (floor(trial / 1) - 2*floor(trial / 2))*1.8
alter VB0 = $&drive
let drive = (floor(trial / 2) - 2*floor(trial / 4))*1.8
alter VB1 = $&drive
let drive = (floor(trial / 4) - 2*floor(trial / 8))*1.8
alter VB2 = $&drive
let drive = (floor(trial / 8) - 2*floor(trial / 16))*1.8
alter VB3 = $&drive
let drive = (floor(trial / 16) - 2*floor(trial / 32))*1.8
alter VB4 = $&drive
let drive = (floor(trial / 32) - 2*floor(trial / 64))*1.8
alter VB5 = $&drive
let drive = (floor(trial / 64) - 2*floor(trial / 128))*1.8
alter VB6 = $&drive
let drive = (floor(trial / 128) - 2*floor(trial / 256))*1.8
alter VB7 = $&drive
stop when time = 0.004314
resume
delete all
let endpoint = length(time)-1
let cmp = v(COMP)[endpoint]
let top = v(TOP)[endpoint]
let decision = 0
if cmp >= 0.9
let code = trial
let decision = 1
end
echo 239 3 $&trial $&cmp $&top 1.10859375 $&decision >> decisions.csv
let trial = code + 4
let drive = (floor(trial / 1) - 2*floor(trial / 2))*1.8
alter VB0 = $&drive
let drive = (floor(trial / 2) - 2*floor(trial / 4))*1.8
alter VB1 = $&drive
let drive = (floor(trial / 4) - 2*floor(trial / 8))*1.8
alter VB2 = $&drive
let drive = (floor(trial / 8) - 2*floor(trial / 16))*1.8
alter VB3 = $&drive
let drive = (floor(trial / 16) - 2*floor(trial / 32))*1.8
alter VB4 = $&drive
let drive = (floor(trial / 32) - 2*floor(trial / 64))*1.8
alter VB5 = $&drive
let drive = (floor(trial / 64) - 2*floor(trial / 128))*1.8
alter VB6 = $&drive
let drive = (floor(trial / 128) - 2*floor(trial / 256))*1.8
alter VB7 = $&drive
stop when time = 0.004316
resume
delete all
let endpoint = length(time)-1
let cmp = v(COMP)[endpoint]
let top = v(TOP)[endpoint]
let decision = 0
if cmp >= 0.9
let code = trial
let decision = 1
end
echo 239 2 $&trial $&cmp $&top 1.10859375 $&decision >> decisions.csv
let trial = code + 2
let drive = (floor(trial / 1) - 2*floor(trial / 2))*1.8
alter VB0 = $&drive
let drive = (floor(trial / 2) - 2*floor(trial / 4))*1.8
alter VB1 = $&drive
let drive = (floor(trial / 4) - 2*floor(trial / 8))*1.8
alter VB2 = $&drive
let drive = (floor(trial / 8) - 2*floor(trial / 16))*1.8
alter VB3 = $&drive
let drive = (floor(trial / 16) - 2*floor(trial / 32))*1.8
alter VB4 = $&drive
let drive = (floor(trial / 32) - 2*floor(trial / 64))*1.8
alter VB5 = $&drive
let drive = (floor(trial / 64) - 2*floor(trial / 128))*1.8
alter VB6 = $&drive
let drive = (floor(trial / 128) - 2*floor(trial / 256))*1.8
alter VB7 = $&drive
stop when time = 0.004318
resume
delete all
let endpoint = length(time)-1
let cmp = v(COMP)[endpoint]
let top = v(TOP)[endpoint]
let decision = 0
if cmp >= 0.9
let code = trial
let decision = 1
end
echo 239 1 $&trial $&cmp $&top 1.10859375 $&decision >> decisions.csv
let trial = code + 1
let drive = (floor(trial / 1) - 2*floor(trial / 2))*1.8
alter VB0 = $&drive
let drive = (floor(trial / 2) - 2*floor(trial / 4))*1.8
alter VB1 = $&drive
let drive = (floor(trial / 4) - 2*floor(trial / 8))*1.8
alter VB2 = $&drive
let drive = (floor(trial / 8) - 2*floor(trial / 16))*1.8
alter VB3 = $&drive
let drive = (floor(trial / 16) - 2*floor(trial / 32))*1.8
alter VB4 = $&drive
let drive = (floor(trial / 32) - 2*floor(trial / 64))*1.8
alter VB5 = $&drive
let drive = (floor(trial / 64) - 2*floor(trial / 128))*1.8
alter VB6 = $&drive
let drive = (floor(trial / 128) - 2*floor(trial / 256))*1.8
alter VB7 = $&drive
stop when time = 0.00432
resume
delete all
let endpoint = length(time)-1
let cmp = v(COMP)[endpoint]
let top = v(TOP)[endpoint]
let decision = 0
if cmp >= 0.9
let code = trial
let decision = 1
end
echo 239 0 $&trial $&cmp $&top 1.10859375 $&decision >> decisions.csv
alter VIN = 1.11328125
alter VSAMPLE = 1.8
alter VB0 = 0
alter VB1 = 0
alter VB2 = 0
alter VB3 = 0
alter VB4 = 0
alter VB5 = 0
alter VB6 = 0
alter VB7 = 0
let code = 0
stop when time = 0.004322
resume
delete all
alter VSAMPLE = 0
let trial = code + 128
let drive = (floor(trial / 1) - 2*floor(trial / 2))*1.8
alter VB0 = $&drive
let drive = (floor(trial / 2) - 2*floor(trial / 4))*1.8
alter VB1 = $&drive
let drive = (floor(trial / 4) - 2*floor(trial / 8))*1.8
alter VB2 = $&drive
let drive = (floor(trial / 8) - 2*floor(trial / 16))*1.8
alter VB3 = $&drive
let drive = (floor(trial / 16) - 2*floor(trial / 32))*1.8
alter VB4 = $&drive
let drive = (floor(trial / 32) - 2*floor(trial / 64))*1.8
alter VB5 = $&drive
let drive = (floor(trial / 64) - 2*floor(trial / 128))*1.8
alter VB6 = $&drive
let drive = (floor(trial / 128) - 2*floor(trial / 256))*1.8
alter VB7 = $&drive
stop when time = 0.004324
resume
delete all
let endpoint = length(time)-1
let cmp = v(COMP)[endpoint]
let top = v(TOP)[endpoint]
let decision = 0
if cmp >= 0.9
let code = trial
let decision = 1
end
echo 240 7 $&trial $&cmp $&top 1.11328125 $&decision >> decisions.csv
let trial = code + 64
let drive = (floor(trial / 1) - 2*floor(trial / 2))*1.8
alter VB0 = $&drive
let drive = (floor(trial / 2) - 2*floor(trial / 4))*1.8
alter VB1 = $&drive
let drive = (floor(trial / 4) - 2*floor(trial / 8))*1.8
alter VB2 = $&drive
let drive = (floor(trial / 8) - 2*floor(trial / 16))*1.8
alter VB3 = $&drive
let drive = (floor(trial / 16) - 2*floor(trial / 32))*1.8
alter VB4 = $&drive
let drive = (floor(trial / 32) - 2*floor(trial / 64))*1.8
alter VB5 = $&drive
let drive = (floor(trial / 64) - 2*floor(trial / 128))*1.8
alter VB6 = $&drive
let drive = (floor(trial / 128) - 2*floor(trial / 256))*1.8
alter VB7 = $&drive
stop when time = 0.004326
resume
delete all
let endpoint = length(time)-1
let cmp = v(COMP)[endpoint]
let top = v(TOP)[endpoint]
let decision = 0
if cmp >= 0.9
let code = trial
let decision = 1
end
echo 240 6 $&trial $&cmp $&top 1.11328125 $&decision >> decisions.csv
let trial = code + 32
let drive = (floor(trial / 1) - 2*floor(trial / 2))*1.8
alter VB0 = $&drive
let drive = (floor(trial / 2) - 2*floor(trial / 4))*1.8
alter VB1 = $&drive
let drive = (floor(trial / 4) - 2*floor(trial / 8))*1.8
alter VB2 = $&drive
let drive = (floor(trial / 8) - 2*floor(trial / 16))*1.8
alter VB3 = $&drive
let drive = (floor(trial / 16) - 2*floor(trial / 32))*1.8
alter VB4 = $&drive
let drive = (floor(trial / 32) - 2*floor(trial / 64))*1.8
alter VB5 = $&drive
let drive = (floor(trial / 64) - 2*floor(trial / 128))*1.8
alter VB6 = $&drive
let drive = (floor(trial / 128) - 2*floor(trial / 256))*1.8
alter VB7 = $&drive
stop when time = 0.004328
resume
delete all
let endpoint = length(time)-1
let cmp = v(COMP)[endpoint]
let top = v(TOP)[endpoint]
let decision = 0
if cmp >= 0.9
let code = trial
let decision = 1
end
echo 240 5 $&trial $&cmp $&top 1.11328125 $&decision >> decisions.csv
let trial = code + 16
let drive = (floor(trial / 1) - 2*floor(trial / 2))*1.8
alter VB0 = $&drive
let drive = (floor(trial / 2) - 2*floor(trial / 4))*1.8
alter VB1 = $&drive
let drive = (floor(trial / 4) - 2*floor(trial / 8))*1.8
alter VB2 = $&drive
let drive = (floor(trial / 8) - 2*floor(trial / 16))*1.8
alter VB3 = $&drive
let drive = (floor(trial / 16) - 2*floor(trial / 32))*1.8
alter VB4 = $&drive
let drive = (floor(trial / 32) - 2*floor(trial / 64))*1.8
alter VB5 = $&drive
let drive = (floor(trial / 64) - 2*floor(trial / 128))*1.8
alter VB6 = $&drive
let drive = (floor(trial / 128) - 2*floor(trial / 256))*1.8
alter VB7 = $&drive
stop when time = 0.00433
resume
delete all
let endpoint = length(time)-1
let cmp = v(COMP)[endpoint]
let top = v(TOP)[endpoint]
let decision = 0
if cmp >= 0.9
let code = trial
let decision = 1
end
echo 240 4 $&trial $&cmp $&top 1.11328125 $&decision >> decisions.csv
let trial = code + 8
let drive = (floor(trial / 1) - 2*floor(trial / 2))*1.8
alter VB0 = $&drive
let drive = (floor(trial / 2) - 2*floor(trial / 4))*1.8
alter VB1 = $&drive
let drive = (floor(trial / 4) - 2*floor(trial / 8))*1.8
alter VB2 = $&drive
let drive = (floor(trial / 8) - 2*floor(trial / 16))*1.8
alter VB3 = $&drive
let drive = (floor(trial / 16) - 2*floor(trial / 32))*1.8
alter VB4 = $&drive
let drive = (floor(trial / 32) - 2*floor(trial / 64))*1.8
alter VB5 = $&drive
let drive = (floor(trial / 64) - 2*floor(trial / 128))*1.8
alter VB6 = $&drive
let drive = (floor(trial / 128) - 2*floor(trial / 256))*1.8
alter VB7 = $&drive
stop when time = 0.004332
resume
delete all
let endpoint = length(time)-1
let cmp = v(COMP)[endpoint]
let top = v(TOP)[endpoint]
let decision = 0
if cmp >= 0.9
let code = trial
let decision = 1
end
echo 240 3 $&trial $&cmp $&top 1.11328125 $&decision >> decisions.csv
let trial = code + 4
let drive = (floor(trial / 1) - 2*floor(trial / 2))*1.8
alter VB0 = $&drive
let drive = (floor(trial / 2) - 2*floor(trial / 4))*1.8
alter VB1 = $&drive
let drive = (floor(trial / 4) - 2*floor(trial / 8))*1.8
alter VB2 = $&drive
let drive = (floor(trial / 8) - 2*floor(trial / 16))*1.8
alter VB3 = $&drive
let drive = (floor(trial / 16) - 2*floor(trial / 32))*1.8
alter VB4 = $&drive
let drive = (floor(trial / 32) - 2*floor(trial / 64))*1.8
alter VB5 = $&drive
let drive = (floor(trial / 64) - 2*floor(trial / 128))*1.8
alter VB6 = $&drive
let drive = (floor(trial / 128) - 2*floor(trial / 256))*1.8
alter VB7 = $&drive
stop when time = 0.004334
resume
delete all
let endpoint = length(time)-1
let cmp = v(COMP)[endpoint]
let top = v(TOP)[endpoint]
let decision = 0
if cmp >= 0.9
let code = trial
let decision = 1
end
echo 240 2 $&trial $&cmp $&top 1.11328125 $&decision >> decisions.csv
let trial = code + 2
let drive = (floor(trial / 1) - 2*floor(trial / 2))*1.8
alter VB0 = $&drive
let drive = (floor(trial / 2) - 2*floor(trial / 4))*1.8
alter VB1 = $&drive
let drive = (floor(trial / 4) - 2*floor(trial / 8))*1.8
alter VB2 = $&drive
let drive = (floor(trial / 8) - 2*floor(trial / 16))*1.8
alter VB3 = $&drive
let drive = (floor(trial / 16) - 2*floor(trial / 32))*1.8
alter VB4 = $&drive
let drive = (floor(trial / 32) - 2*floor(trial / 64))*1.8
alter VB5 = $&drive
let drive = (floor(trial / 64) - 2*floor(trial / 128))*1.8
alter VB6 = $&drive
let drive = (floor(trial / 128) - 2*floor(trial / 256))*1.8
alter VB7 = $&drive
stop when time = 0.004336
resume
delete all
let endpoint = length(time)-1
let cmp = v(COMP)[endpoint]
let top = v(TOP)[endpoint]
let decision = 0
if cmp >= 0.9
let code = trial
let decision = 1
end
echo 240 1 $&trial $&cmp $&top 1.11328125 $&decision >> decisions.csv
let trial = code + 1
let drive = (floor(trial / 1) - 2*floor(trial / 2))*1.8
alter VB0 = $&drive
let drive = (floor(trial / 2) - 2*floor(trial / 4))*1.8
alter VB1 = $&drive
let drive = (floor(trial / 4) - 2*floor(trial / 8))*1.8
alter VB2 = $&drive
let drive = (floor(trial / 8) - 2*floor(trial / 16))*1.8
alter VB3 = $&drive
let drive = (floor(trial / 16) - 2*floor(trial / 32))*1.8
alter VB4 = $&drive
let drive = (floor(trial / 32) - 2*floor(trial / 64))*1.8
alter VB5 = $&drive
let drive = (floor(trial / 64) - 2*floor(trial / 128))*1.8
alter VB6 = $&drive
let drive = (floor(trial / 128) - 2*floor(trial / 256))*1.8
alter VB7 = $&drive
stop when time = 0.004338
resume
delete all
let endpoint = length(time)-1
let cmp = v(COMP)[endpoint]
let top = v(TOP)[endpoint]
let decision = 0
if cmp >= 0.9
let code = trial
let decision = 1
end
echo 240 0 $&trial $&cmp $&top 1.11328125 $&decision >> decisions.csv
alter VIN = 1.11796875
alter VSAMPLE = 1.8
alter VB0 = 0
alter VB1 = 0
alter VB2 = 0
alter VB3 = 0
alter VB4 = 0
alter VB5 = 0
alter VB6 = 0
alter VB7 = 0
let code = 0
stop when time = 0.00434
resume
delete all
alter VSAMPLE = 0
let trial = code + 128
let drive = (floor(trial / 1) - 2*floor(trial / 2))*1.8
alter VB0 = $&drive
let drive = (floor(trial / 2) - 2*floor(trial / 4))*1.8
alter VB1 = $&drive
let drive = (floor(trial / 4) - 2*floor(trial / 8))*1.8
alter VB2 = $&drive
let drive = (floor(trial / 8) - 2*floor(trial / 16))*1.8
alter VB3 = $&drive
let drive = (floor(trial / 16) - 2*floor(trial / 32))*1.8
alter VB4 = $&drive
let drive = (floor(trial / 32) - 2*floor(trial / 64))*1.8
alter VB5 = $&drive
let drive = (floor(trial / 64) - 2*floor(trial / 128))*1.8
alter VB6 = $&drive
let drive = (floor(trial / 128) - 2*floor(trial / 256))*1.8
alter VB7 = $&drive
stop when time = 0.004342
resume
delete all
let endpoint = length(time)-1
let cmp = v(COMP)[endpoint]
let top = v(TOP)[endpoint]
let decision = 0
if cmp >= 0.9
let code = trial
let decision = 1
end
echo 241 7 $&trial $&cmp $&top 1.11796875 $&decision >> decisions.csv
let trial = code + 64
let drive = (floor(trial / 1) - 2*floor(trial / 2))*1.8
alter VB0 = $&drive
let drive = (floor(trial / 2) - 2*floor(trial / 4))*1.8
alter VB1 = $&drive
let drive = (floor(trial / 4) - 2*floor(trial / 8))*1.8
alter VB2 = $&drive
let drive = (floor(trial / 8) - 2*floor(trial / 16))*1.8
alter VB3 = $&drive
let drive = (floor(trial / 16) - 2*floor(trial / 32))*1.8
alter VB4 = $&drive
let drive = (floor(trial / 32) - 2*floor(trial / 64))*1.8
alter VB5 = $&drive
let drive = (floor(trial / 64) - 2*floor(trial / 128))*1.8
alter VB6 = $&drive
let drive = (floor(trial / 128) - 2*floor(trial / 256))*1.8
alter VB7 = $&drive
stop when time = 0.004344
resume
delete all
let endpoint = length(time)-1
let cmp = v(COMP)[endpoint]
let top = v(TOP)[endpoint]
let decision = 0
if cmp >= 0.9
let code = trial
let decision = 1
end
echo 241 6 $&trial $&cmp $&top 1.11796875 $&decision >> decisions.csv
let trial = code + 32
let drive = (floor(trial / 1) - 2*floor(trial / 2))*1.8
alter VB0 = $&drive
let drive = (floor(trial / 2) - 2*floor(trial / 4))*1.8
alter VB1 = $&drive
let drive = (floor(trial / 4) - 2*floor(trial / 8))*1.8
alter VB2 = $&drive
let drive = (floor(trial / 8) - 2*floor(trial / 16))*1.8
alter VB3 = $&drive
let drive = (floor(trial / 16) - 2*floor(trial / 32))*1.8
alter VB4 = $&drive
let drive = (floor(trial / 32) - 2*floor(trial / 64))*1.8
alter VB5 = $&drive
let drive = (floor(trial / 64) - 2*floor(trial / 128))*1.8
alter VB6 = $&drive
let drive = (floor(trial / 128) - 2*floor(trial / 256))*1.8
alter VB7 = $&drive
stop when time = 0.004346
resume
delete all
let endpoint = length(time)-1
let cmp = v(COMP)[endpoint]
let top = v(TOP)[endpoint]
let decision = 0
if cmp >= 0.9
let code = trial
let decision = 1
end
echo 241 5 $&trial $&cmp $&top 1.11796875 $&decision >> decisions.csv
let trial = code + 16
let drive = (floor(trial / 1) - 2*floor(trial / 2))*1.8
alter VB0 = $&drive
let drive = (floor(trial / 2) - 2*floor(trial / 4))*1.8
alter VB1 = $&drive
let drive = (floor(trial / 4) - 2*floor(trial / 8))*1.8
alter VB2 = $&drive
let drive = (floor(trial / 8) - 2*floor(trial / 16))*1.8
alter VB3 = $&drive
let drive = (floor(trial / 16) - 2*floor(trial / 32))*1.8
alter VB4 = $&drive
let drive = (floor(trial / 32) - 2*floor(trial / 64))*1.8
alter VB5 = $&drive
let drive = (floor(trial / 64) - 2*floor(trial / 128))*1.8
alter VB6 = $&drive
let drive = (floor(trial / 128) - 2*floor(trial / 256))*1.8
alter VB7 = $&drive
stop when time = 0.004348
resume
delete all
let endpoint = length(time)-1
let cmp = v(COMP)[endpoint]
let top = v(TOP)[endpoint]
let decision = 0
if cmp >= 0.9
let code = trial
let decision = 1
end
echo 241 4 $&trial $&cmp $&top 1.11796875 $&decision >> decisions.csv
let trial = code + 8
let drive = (floor(trial / 1) - 2*floor(trial / 2))*1.8
alter VB0 = $&drive
let drive = (floor(trial / 2) - 2*floor(trial / 4))*1.8
alter VB1 = $&drive
let drive = (floor(trial / 4) - 2*floor(trial / 8))*1.8
alter VB2 = $&drive
let drive = (floor(trial / 8) - 2*floor(trial / 16))*1.8
alter VB3 = $&drive
let drive = (floor(trial / 16) - 2*floor(trial / 32))*1.8
alter VB4 = $&drive
let drive = (floor(trial / 32) - 2*floor(trial / 64))*1.8
alter VB5 = $&drive
let drive = (floor(trial / 64) - 2*floor(trial / 128))*1.8
alter VB6 = $&drive
let drive = (floor(trial / 128) - 2*floor(trial / 256))*1.8
alter VB7 = $&drive
stop when time = 0.00435
resume
delete all
let endpoint = length(time)-1
let cmp = v(COMP)[endpoint]
let top = v(TOP)[endpoint]
let decision = 0
if cmp >= 0.9
let code = trial
let decision = 1
end
echo 241 3 $&trial $&cmp $&top 1.11796875 $&decision >> decisions.csv
let trial = code + 4
let drive = (floor(trial / 1) - 2*floor(trial / 2))*1.8
alter VB0 = $&drive
let drive = (floor(trial / 2) - 2*floor(trial / 4))*1.8
alter VB1 = $&drive
let drive = (floor(trial / 4) - 2*floor(trial / 8))*1.8
alter VB2 = $&drive
let drive = (floor(trial / 8) - 2*floor(trial / 16))*1.8
alter VB3 = $&drive
let drive = (floor(trial / 16) - 2*floor(trial / 32))*1.8
alter VB4 = $&drive
let drive = (floor(trial / 32) - 2*floor(trial / 64))*1.8
alter VB5 = $&drive
let drive = (floor(trial / 64) - 2*floor(trial / 128))*1.8
alter VB6 = $&drive
let drive = (floor(trial / 128) - 2*floor(trial / 256))*1.8
alter VB7 = $&drive
stop when time = 0.004352
resume
delete all
let endpoint = length(time)-1
let cmp = v(COMP)[endpoint]
let top = v(TOP)[endpoint]
let decision = 0
if cmp >= 0.9
let code = trial
let decision = 1
end
echo 241 2 $&trial $&cmp $&top 1.11796875 $&decision >> decisions.csv
let trial = code + 2
let drive = (floor(trial / 1) - 2*floor(trial / 2))*1.8
alter VB0 = $&drive
let drive = (floor(trial / 2) - 2*floor(trial / 4))*1.8
alter VB1 = $&drive
let drive = (floor(trial / 4) - 2*floor(trial / 8))*1.8
alter VB2 = $&drive
let drive = (floor(trial / 8) - 2*floor(trial / 16))*1.8
alter VB3 = $&drive
let drive = (floor(trial / 16) - 2*floor(trial / 32))*1.8
alter VB4 = $&drive
let drive = (floor(trial / 32) - 2*floor(trial / 64))*1.8
alter VB5 = $&drive
let drive = (floor(trial / 64) - 2*floor(trial / 128))*1.8
alter VB6 = $&drive
let drive = (floor(trial / 128) - 2*floor(trial / 256))*1.8
alter VB7 = $&drive
stop when time = 0.004354
resume
delete all
let endpoint = length(time)-1
let cmp = v(COMP)[endpoint]
let top = v(TOP)[endpoint]
let decision = 0
if cmp >= 0.9
let code = trial
let decision = 1
end
echo 241 1 $&trial $&cmp $&top 1.11796875 $&decision >> decisions.csv
let trial = code + 1
let drive = (floor(trial / 1) - 2*floor(trial / 2))*1.8
alter VB0 = $&drive
let drive = (floor(trial / 2) - 2*floor(trial / 4))*1.8
alter VB1 = $&drive
let drive = (floor(trial / 4) - 2*floor(trial / 8))*1.8
alter VB2 = $&drive
let drive = (floor(trial / 8) - 2*floor(trial / 16))*1.8
alter VB3 = $&drive
let drive = (floor(trial / 16) - 2*floor(trial / 32))*1.8
alter VB4 = $&drive
let drive = (floor(trial / 32) - 2*floor(trial / 64))*1.8
alter VB5 = $&drive
let drive = (floor(trial / 64) - 2*floor(trial / 128))*1.8
alter VB6 = $&drive
let drive = (floor(trial / 128) - 2*floor(trial / 256))*1.8
alter VB7 = $&drive
stop when time = 0.004356
resume
delete all
let endpoint = length(time)-1
let cmp = v(COMP)[endpoint]
let top = v(TOP)[endpoint]
let decision = 0
if cmp >= 0.9
let code = trial
let decision = 1
end
echo 241 0 $&trial $&cmp $&top 1.11796875 $&decision >> decisions.csv
alter VIN = 1.12265625
alter VSAMPLE = 1.8
alter VB0 = 0
alter VB1 = 0
alter VB2 = 0
alter VB3 = 0
alter VB4 = 0
alter VB5 = 0
alter VB6 = 0
alter VB7 = 0
let code = 0
stop when time = 0.004358
resume
delete all
alter VSAMPLE = 0
let trial = code + 128
let drive = (floor(trial / 1) - 2*floor(trial / 2))*1.8
alter VB0 = $&drive
let drive = (floor(trial / 2) - 2*floor(trial / 4))*1.8
alter VB1 = $&drive
let drive = (floor(trial / 4) - 2*floor(trial / 8))*1.8
alter VB2 = $&drive
let drive = (floor(trial / 8) - 2*floor(trial / 16))*1.8
alter VB3 = $&drive
let drive = (floor(trial / 16) - 2*floor(trial / 32))*1.8
alter VB4 = $&drive
let drive = (floor(trial / 32) - 2*floor(trial / 64))*1.8
alter VB5 = $&drive
let drive = (floor(trial / 64) - 2*floor(trial / 128))*1.8
alter VB6 = $&drive
let drive = (floor(trial / 128) - 2*floor(trial / 256))*1.8
alter VB7 = $&drive
stop when time = 0.00436
resume
delete all
let endpoint = length(time)-1
let cmp = v(COMP)[endpoint]
let top = v(TOP)[endpoint]
let decision = 0
if cmp >= 0.9
let code = trial
let decision = 1
end
echo 242 7 $&trial $&cmp $&top 1.12265625 $&decision >> decisions.csv
let trial = code + 64
let drive = (floor(trial / 1) - 2*floor(trial / 2))*1.8
alter VB0 = $&drive
let drive = (floor(trial / 2) - 2*floor(trial / 4))*1.8
alter VB1 = $&drive
let drive = (floor(trial / 4) - 2*floor(trial / 8))*1.8
alter VB2 = $&drive
let drive = (floor(trial / 8) - 2*floor(trial / 16))*1.8
alter VB3 = $&drive
let drive = (floor(trial / 16) - 2*floor(trial / 32))*1.8
alter VB4 = $&drive
let drive = (floor(trial / 32) - 2*floor(trial / 64))*1.8
alter VB5 = $&drive
let drive = (floor(trial / 64) - 2*floor(trial / 128))*1.8
alter VB6 = $&drive
let drive = (floor(trial / 128) - 2*floor(trial / 256))*1.8
alter VB7 = $&drive
stop when time = 0.004362
resume
delete all
let endpoint = length(time)-1
let cmp = v(COMP)[endpoint]
let top = v(TOP)[endpoint]
let decision = 0
if cmp >= 0.9
let code = trial
let decision = 1
end
echo 242 6 $&trial $&cmp $&top 1.12265625 $&decision >> decisions.csv
let trial = code + 32
let drive = (floor(trial / 1) - 2*floor(trial / 2))*1.8
alter VB0 = $&drive
let drive = (floor(trial / 2) - 2*floor(trial / 4))*1.8
alter VB1 = $&drive
let drive = (floor(trial / 4) - 2*floor(trial / 8))*1.8
alter VB2 = $&drive
let drive = (floor(trial / 8) - 2*floor(trial / 16))*1.8
alter VB3 = $&drive
let drive = (floor(trial / 16) - 2*floor(trial / 32))*1.8
alter VB4 = $&drive
let drive = (floor(trial / 32) - 2*floor(trial / 64))*1.8
alter VB5 = $&drive
let drive = (floor(trial / 64) - 2*floor(trial / 128))*1.8
alter VB6 = $&drive
let drive = (floor(trial / 128) - 2*floor(trial / 256))*1.8
alter VB7 = $&drive
stop when time = 0.004364
resume
delete all
let endpoint = length(time)-1
let cmp = v(COMP)[endpoint]
let top = v(TOP)[endpoint]
let decision = 0
if cmp >= 0.9
let code = trial
let decision = 1
end
echo 242 5 $&trial $&cmp $&top 1.12265625 $&decision >> decisions.csv
let trial = code + 16
let drive = (floor(trial / 1) - 2*floor(trial / 2))*1.8
alter VB0 = $&drive
let drive = (floor(trial / 2) - 2*floor(trial / 4))*1.8
alter VB1 = $&drive
let drive = (floor(trial / 4) - 2*floor(trial / 8))*1.8
alter VB2 = $&drive
let drive = (floor(trial / 8) - 2*floor(trial / 16))*1.8
alter VB3 = $&drive
let drive = (floor(trial / 16) - 2*floor(trial / 32))*1.8
alter VB4 = $&drive
let drive = (floor(trial / 32) - 2*floor(trial / 64))*1.8
alter VB5 = $&drive
let drive = (floor(trial / 64) - 2*floor(trial / 128))*1.8
alter VB6 = $&drive
let drive = (floor(trial / 128) - 2*floor(trial / 256))*1.8
alter VB7 = $&drive
stop when time = 0.004366
resume
delete all
let endpoint = length(time)-1
let cmp = v(COMP)[endpoint]
let top = v(TOP)[endpoint]
let decision = 0
if cmp >= 0.9
let code = trial
let decision = 1
end
echo 242 4 $&trial $&cmp $&top 1.12265625 $&decision >> decisions.csv
let trial = code + 8
let drive = (floor(trial / 1) - 2*floor(trial / 2))*1.8
alter VB0 = $&drive
let drive = (floor(trial / 2) - 2*floor(trial / 4))*1.8
alter VB1 = $&drive
let drive = (floor(trial / 4) - 2*floor(trial / 8))*1.8
alter VB2 = $&drive
let drive = (floor(trial / 8) - 2*floor(trial / 16))*1.8
alter VB3 = $&drive
let drive = (floor(trial / 16) - 2*floor(trial / 32))*1.8
alter VB4 = $&drive
let drive = (floor(trial / 32) - 2*floor(trial / 64))*1.8
alter VB5 = $&drive
let drive = (floor(trial / 64) - 2*floor(trial / 128))*1.8
alter VB6 = $&drive
let drive = (floor(trial / 128) - 2*floor(trial / 256))*1.8
alter VB7 = $&drive
stop when time = 0.004368
resume
delete all
let endpoint = length(time)-1
let cmp = v(COMP)[endpoint]
let top = v(TOP)[endpoint]
let decision = 0
if cmp >= 0.9
let code = trial
let decision = 1
end
echo 242 3 $&trial $&cmp $&top 1.12265625 $&decision >> decisions.csv
let trial = code + 4
let drive = (floor(trial / 1) - 2*floor(trial / 2))*1.8
alter VB0 = $&drive
let drive = (floor(trial / 2) - 2*floor(trial / 4))*1.8
alter VB1 = $&drive
let drive = (floor(trial / 4) - 2*floor(trial / 8))*1.8
alter VB2 = $&drive
let drive = (floor(trial / 8) - 2*floor(trial / 16))*1.8
alter VB3 = $&drive
let drive = (floor(trial / 16) - 2*floor(trial / 32))*1.8
alter VB4 = $&drive
let drive = (floor(trial / 32) - 2*floor(trial / 64))*1.8
alter VB5 = $&drive
let drive = (floor(trial / 64) - 2*floor(trial / 128))*1.8
alter VB6 = $&drive
let drive = (floor(trial / 128) - 2*floor(trial / 256))*1.8
alter VB7 = $&drive
stop when time = 0.00437
resume
delete all
let endpoint = length(time)-1
let cmp = v(COMP)[endpoint]
let top = v(TOP)[endpoint]
let decision = 0
if cmp >= 0.9
let code = trial
let decision = 1
end
echo 242 2 $&trial $&cmp $&top 1.12265625 $&decision >> decisions.csv
let trial = code + 2
let drive = (floor(trial / 1) - 2*floor(trial / 2))*1.8
alter VB0 = $&drive
let drive = (floor(trial / 2) - 2*floor(trial / 4))*1.8
alter VB1 = $&drive
let drive = (floor(trial / 4) - 2*floor(trial / 8))*1.8
alter VB2 = $&drive
let drive = (floor(trial / 8) - 2*floor(trial / 16))*1.8
alter VB3 = $&drive
let drive = (floor(trial / 16) - 2*floor(trial / 32))*1.8
alter VB4 = $&drive
let drive = (floor(trial / 32) - 2*floor(trial / 64))*1.8
alter VB5 = $&drive
let drive = (floor(trial / 64) - 2*floor(trial / 128))*1.8
alter VB6 = $&drive
let drive = (floor(trial / 128) - 2*floor(trial / 256))*1.8
alter VB7 = $&drive
stop when time = 0.004372
resume
delete all
let endpoint = length(time)-1
let cmp = v(COMP)[endpoint]
let top = v(TOP)[endpoint]
let decision = 0
if cmp >= 0.9
let code = trial
let decision = 1
end
echo 242 1 $&trial $&cmp $&top 1.12265625 $&decision >> decisions.csv
let trial = code + 1
let drive = (floor(trial / 1) - 2*floor(trial / 2))*1.8
alter VB0 = $&drive
let drive = (floor(trial / 2) - 2*floor(trial / 4))*1.8
alter VB1 = $&drive
let drive = (floor(trial / 4) - 2*floor(trial / 8))*1.8
alter VB2 = $&drive
let drive = (floor(trial / 8) - 2*floor(trial / 16))*1.8
alter VB3 = $&drive
let drive = (floor(trial / 16) - 2*floor(trial / 32))*1.8
alter VB4 = $&drive
let drive = (floor(trial / 32) - 2*floor(trial / 64))*1.8
alter VB5 = $&drive
let drive = (floor(trial / 64) - 2*floor(trial / 128))*1.8
alter VB6 = $&drive
let drive = (floor(trial / 128) - 2*floor(trial / 256))*1.8
alter VB7 = $&drive
stop when time = 0.004374
resume
delete all
let endpoint = length(time)-1
let cmp = v(COMP)[endpoint]
let top = v(TOP)[endpoint]
let decision = 0
if cmp >= 0.9
let code = trial
let decision = 1
end
echo 242 0 $&trial $&cmp $&top 1.12265625 $&decision >> decisions.csv
alter VIN = 1.12734375
alter VSAMPLE = 1.8
alter VB0 = 0
alter VB1 = 0
alter VB2 = 0
alter VB3 = 0
alter VB4 = 0
alter VB5 = 0
alter VB6 = 0
alter VB7 = 0
let code = 0
stop when time = 0.004376
resume
delete all
alter VSAMPLE = 0
let trial = code + 128
let drive = (floor(trial / 1) - 2*floor(trial / 2))*1.8
alter VB0 = $&drive
let drive = (floor(trial / 2) - 2*floor(trial / 4))*1.8
alter VB1 = $&drive
let drive = (floor(trial / 4) - 2*floor(trial / 8))*1.8
alter VB2 = $&drive
let drive = (floor(trial / 8) - 2*floor(trial / 16))*1.8
alter VB3 = $&drive
let drive = (floor(trial / 16) - 2*floor(trial / 32))*1.8
alter VB4 = $&drive
let drive = (floor(trial / 32) - 2*floor(trial / 64))*1.8
alter VB5 = $&drive
let drive = (floor(trial / 64) - 2*floor(trial / 128))*1.8
alter VB6 = $&drive
let drive = (floor(trial / 128) - 2*floor(trial / 256))*1.8
alter VB7 = $&drive
stop when time = 0.004378
resume
delete all
let endpoint = length(time)-1
let cmp = v(COMP)[endpoint]
let top = v(TOP)[endpoint]
let decision = 0
if cmp >= 0.9
let code = trial
let decision = 1
end
echo 243 7 $&trial $&cmp $&top 1.12734375 $&decision >> decisions.csv
let trial = code + 64
let drive = (floor(trial / 1) - 2*floor(trial / 2))*1.8
alter VB0 = $&drive
let drive = (floor(trial / 2) - 2*floor(trial / 4))*1.8
alter VB1 = $&drive
let drive = (floor(trial / 4) - 2*floor(trial / 8))*1.8
alter VB2 = $&drive
let drive = (floor(trial / 8) - 2*floor(trial / 16))*1.8
alter VB3 = $&drive
let drive = (floor(trial / 16) - 2*floor(trial / 32))*1.8
alter VB4 = $&drive
let drive = (floor(trial / 32) - 2*floor(trial / 64))*1.8
alter VB5 = $&drive
let drive = (floor(trial / 64) - 2*floor(trial / 128))*1.8
alter VB6 = $&drive
let drive = (floor(trial / 128) - 2*floor(trial / 256))*1.8
alter VB7 = $&drive
stop when time = 0.00438
resume
delete all
let endpoint = length(time)-1
let cmp = v(COMP)[endpoint]
let top = v(TOP)[endpoint]
let decision = 0
if cmp >= 0.9
let code = trial
let decision = 1
end
echo 243 6 $&trial $&cmp $&top 1.12734375 $&decision >> decisions.csv
let trial = code + 32
let drive = (floor(trial / 1) - 2*floor(trial / 2))*1.8
alter VB0 = $&drive
let drive = (floor(trial / 2) - 2*floor(trial / 4))*1.8
alter VB1 = $&drive
let drive = (floor(trial / 4) - 2*floor(trial / 8))*1.8
alter VB2 = $&drive
let drive = (floor(trial / 8) - 2*floor(trial / 16))*1.8
alter VB3 = $&drive
let drive = (floor(trial / 16) - 2*floor(trial / 32))*1.8
alter VB4 = $&drive
let drive = (floor(trial / 32) - 2*floor(trial / 64))*1.8
alter VB5 = $&drive
let drive = (floor(trial / 64) - 2*floor(trial / 128))*1.8
alter VB6 = $&drive
let drive = (floor(trial / 128) - 2*floor(trial / 256))*1.8
alter VB7 = $&drive
stop when time = 0.004382
resume
delete all
let endpoint = length(time)-1
let cmp = v(COMP)[endpoint]
let top = v(TOP)[endpoint]
let decision = 0
if cmp >= 0.9
let code = trial
let decision = 1
end
echo 243 5 $&trial $&cmp $&top 1.12734375 $&decision >> decisions.csv
let trial = code + 16
let drive = (floor(trial / 1) - 2*floor(trial / 2))*1.8
alter VB0 = $&drive
let drive = (floor(trial / 2) - 2*floor(trial / 4))*1.8
alter VB1 = $&drive
let drive = (floor(trial / 4) - 2*floor(trial / 8))*1.8
alter VB2 = $&drive
let drive = (floor(trial / 8) - 2*floor(trial / 16))*1.8
alter VB3 = $&drive
let drive = (floor(trial / 16) - 2*floor(trial / 32))*1.8
alter VB4 = $&drive
let drive = (floor(trial / 32) - 2*floor(trial / 64))*1.8
alter VB5 = $&drive
let drive = (floor(trial / 64) - 2*floor(trial / 128))*1.8
alter VB6 = $&drive
let drive = (floor(trial / 128) - 2*floor(trial / 256))*1.8
alter VB7 = $&drive
stop when time = 0.004384
resume
delete all
let endpoint = length(time)-1
let cmp = v(COMP)[endpoint]
let top = v(TOP)[endpoint]
let decision = 0
if cmp >= 0.9
let code = trial
let decision = 1
end
echo 243 4 $&trial $&cmp $&top 1.12734375 $&decision >> decisions.csv
let trial = code + 8
let drive = (floor(trial / 1) - 2*floor(trial / 2))*1.8
alter VB0 = $&drive
let drive = (floor(trial / 2) - 2*floor(trial / 4))*1.8
alter VB1 = $&drive
let drive = (floor(trial / 4) - 2*floor(trial / 8))*1.8
alter VB2 = $&drive
let drive = (floor(trial / 8) - 2*floor(trial / 16))*1.8
alter VB3 = $&drive
let drive = (floor(trial / 16) - 2*floor(trial / 32))*1.8
alter VB4 = $&drive
let drive = (floor(trial / 32) - 2*floor(trial / 64))*1.8
alter VB5 = $&drive
let drive = (floor(trial / 64) - 2*floor(trial / 128))*1.8
alter VB6 = $&drive
let drive = (floor(trial / 128) - 2*floor(trial / 256))*1.8
alter VB7 = $&drive
stop when time = 0.004386
resume
delete all
let endpoint = length(time)-1
let cmp = v(COMP)[endpoint]
let top = v(TOP)[endpoint]
let decision = 0
if cmp >= 0.9
let code = trial
let decision = 1
end
echo 243 3 $&trial $&cmp $&top 1.12734375 $&decision >> decisions.csv
let trial = code + 4
let drive = (floor(trial / 1) - 2*floor(trial / 2))*1.8
alter VB0 = $&drive
let drive = (floor(trial / 2) - 2*floor(trial / 4))*1.8
alter VB1 = $&drive
let drive = (floor(trial / 4) - 2*floor(trial / 8))*1.8
alter VB2 = $&drive
let drive = (floor(trial / 8) - 2*floor(trial / 16))*1.8
alter VB3 = $&drive
let drive = (floor(trial / 16) - 2*floor(trial / 32))*1.8
alter VB4 = $&drive
let drive = (floor(trial / 32) - 2*floor(trial / 64))*1.8
alter VB5 = $&drive
let drive = (floor(trial / 64) - 2*floor(trial / 128))*1.8
alter VB6 = $&drive
let drive = (floor(trial / 128) - 2*floor(trial / 256))*1.8
alter VB7 = $&drive
stop when time = 0.004388
resume
delete all
let endpoint = length(time)-1
let cmp = v(COMP)[endpoint]
let top = v(TOP)[endpoint]
let decision = 0
if cmp >= 0.9
let code = trial
let decision = 1
end
echo 243 2 $&trial $&cmp $&top 1.12734375 $&decision >> decisions.csv
let trial = code + 2
let drive = (floor(trial / 1) - 2*floor(trial / 2))*1.8
alter VB0 = $&drive
let drive = (floor(trial / 2) - 2*floor(trial / 4))*1.8
alter VB1 = $&drive
let drive = (floor(trial / 4) - 2*floor(trial / 8))*1.8
alter VB2 = $&drive
let drive = (floor(trial / 8) - 2*floor(trial / 16))*1.8
alter VB3 = $&drive
let drive = (floor(trial / 16) - 2*floor(trial / 32))*1.8
alter VB4 = $&drive
let drive = (floor(trial / 32) - 2*floor(trial / 64))*1.8
alter VB5 = $&drive
let drive = (floor(trial / 64) - 2*floor(trial / 128))*1.8
alter VB6 = $&drive
let drive = (floor(trial / 128) - 2*floor(trial / 256))*1.8
alter VB7 = $&drive
stop when time = 0.00439
resume
delete all
let endpoint = length(time)-1
let cmp = v(COMP)[endpoint]
let top = v(TOP)[endpoint]
let decision = 0
if cmp >= 0.9
let code = trial
let decision = 1
end
echo 243 1 $&trial $&cmp $&top 1.12734375 $&decision >> decisions.csv
let trial = code + 1
let drive = (floor(trial / 1) - 2*floor(trial / 2))*1.8
alter VB0 = $&drive
let drive = (floor(trial / 2) - 2*floor(trial / 4))*1.8
alter VB1 = $&drive
let drive = (floor(trial / 4) - 2*floor(trial / 8))*1.8
alter VB2 = $&drive
let drive = (floor(trial / 8) - 2*floor(trial / 16))*1.8
alter VB3 = $&drive
let drive = (floor(trial / 16) - 2*floor(trial / 32))*1.8
alter VB4 = $&drive
let drive = (floor(trial / 32) - 2*floor(trial / 64))*1.8
alter VB5 = $&drive
let drive = (floor(trial / 64) - 2*floor(trial / 128))*1.8
alter VB6 = $&drive
let drive = (floor(trial / 128) - 2*floor(trial / 256))*1.8
alter VB7 = $&drive
stop when time = 0.004392
resume
delete all
let endpoint = length(time)-1
let cmp = v(COMP)[endpoint]
let top = v(TOP)[endpoint]
let decision = 0
if cmp >= 0.9
let code = trial
let decision = 1
end
echo 243 0 $&trial $&cmp $&top 1.12734375 $&decision >> decisions.csv
alter VIN = 1.13203125
alter VSAMPLE = 1.8
alter VB0 = 0
alter VB1 = 0
alter VB2 = 0
alter VB3 = 0
alter VB4 = 0
alter VB5 = 0
alter VB6 = 0
alter VB7 = 0
let code = 0
stop when time = 0.004394
resume
delete all
alter VSAMPLE = 0
let trial = code + 128
let drive = (floor(trial / 1) - 2*floor(trial / 2))*1.8
alter VB0 = $&drive
let drive = (floor(trial / 2) - 2*floor(trial / 4))*1.8
alter VB1 = $&drive
let drive = (floor(trial / 4) - 2*floor(trial / 8))*1.8
alter VB2 = $&drive
let drive = (floor(trial / 8) - 2*floor(trial / 16))*1.8
alter VB3 = $&drive
let drive = (floor(trial / 16) - 2*floor(trial / 32))*1.8
alter VB4 = $&drive
let drive = (floor(trial / 32) - 2*floor(trial / 64))*1.8
alter VB5 = $&drive
let drive = (floor(trial / 64) - 2*floor(trial / 128))*1.8
alter VB6 = $&drive
let drive = (floor(trial / 128) - 2*floor(trial / 256))*1.8
alter VB7 = $&drive
stop when time = 0.004396
resume
delete all
let endpoint = length(time)-1
let cmp = v(COMP)[endpoint]
let top = v(TOP)[endpoint]
let decision = 0
if cmp >= 0.9
let code = trial
let decision = 1
end
echo 244 7 $&trial $&cmp $&top 1.13203125 $&decision >> decisions.csv
let trial = code + 64
let drive = (floor(trial / 1) - 2*floor(trial / 2))*1.8
alter VB0 = $&drive
let drive = (floor(trial / 2) - 2*floor(trial / 4))*1.8
alter VB1 = $&drive
let drive = (floor(trial / 4) - 2*floor(trial / 8))*1.8
alter VB2 = $&drive
let drive = (floor(trial / 8) - 2*floor(trial / 16))*1.8
alter VB3 = $&drive
let drive = (floor(trial / 16) - 2*floor(trial / 32))*1.8
alter VB4 = $&drive
let drive = (floor(trial / 32) - 2*floor(trial / 64))*1.8
alter VB5 = $&drive
let drive = (floor(trial / 64) - 2*floor(trial / 128))*1.8
alter VB6 = $&drive
let drive = (floor(trial / 128) - 2*floor(trial / 256))*1.8
alter VB7 = $&drive
stop when time = 0.004398
resume
delete all
let endpoint = length(time)-1
let cmp = v(COMP)[endpoint]
let top = v(TOP)[endpoint]
let decision = 0
if cmp >= 0.9
let code = trial
let decision = 1
end
echo 244 6 $&trial $&cmp $&top 1.13203125 $&decision >> decisions.csv
let trial = code + 32
let drive = (floor(trial / 1) - 2*floor(trial / 2))*1.8
alter VB0 = $&drive
let drive = (floor(trial / 2) - 2*floor(trial / 4))*1.8
alter VB1 = $&drive
let drive = (floor(trial / 4) - 2*floor(trial / 8))*1.8
alter VB2 = $&drive
let drive = (floor(trial / 8) - 2*floor(trial / 16))*1.8
alter VB3 = $&drive
let drive = (floor(trial / 16) - 2*floor(trial / 32))*1.8
alter VB4 = $&drive
let drive = (floor(trial / 32) - 2*floor(trial / 64))*1.8
alter VB5 = $&drive
let drive = (floor(trial / 64) - 2*floor(trial / 128))*1.8
alter VB6 = $&drive
let drive = (floor(trial / 128) - 2*floor(trial / 256))*1.8
alter VB7 = $&drive
stop when time = 0.0044
resume
delete all
let endpoint = length(time)-1
let cmp = v(COMP)[endpoint]
let top = v(TOP)[endpoint]
let decision = 0
if cmp >= 0.9
let code = trial
let decision = 1
end
echo 244 5 $&trial $&cmp $&top 1.13203125 $&decision >> decisions.csv
let trial = code + 16
let drive = (floor(trial / 1) - 2*floor(trial / 2))*1.8
alter VB0 = $&drive
let drive = (floor(trial / 2) - 2*floor(trial / 4))*1.8
alter VB1 = $&drive
let drive = (floor(trial / 4) - 2*floor(trial / 8))*1.8
alter VB2 = $&drive
let drive = (floor(trial / 8) - 2*floor(trial / 16))*1.8
alter VB3 = $&drive
let drive = (floor(trial / 16) - 2*floor(trial / 32))*1.8
alter VB4 = $&drive
let drive = (floor(trial / 32) - 2*floor(trial / 64))*1.8
alter VB5 = $&drive
let drive = (floor(trial / 64) - 2*floor(trial / 128))*1.8
alter VB6 = $&drive
let drive = (floor(trial / 128) - 2*floor(trial / 256))*1.8
alter VB7 = $&drive
stop when time = 0.004402
resume
delete all
let endpoint = length(time)-1
let cmp = v(COMP)[endpoint]
let top = v(TOP)[endpoint]
let decision = 0
if cmp >= 0.9
let code = trial
let decision = 1
end
echo 244 4 $&trial $&cmp $&top 1.13203125 $&decision >> decisions.csv
let trial = code + 8
let drive = (floor(trial / 1) - 2*floor(trial / 2))*1.8
alter VB0 = $&drive
let drive = (floor(trial / 2) - 2*floor(trial / 4))*1.8
alter VB1 = $&drive
let drive = (floor(trial / 4) - 2*floor(trial / 8))*1.8
alter VB2 = $&drive
let drive = (floor(trial / 8) - 2*floor(trial / 16))*1.8
alter VB3 = $&drive
let drive = (floor(trial / 16) - 2*floor(trial / 32))*1.8
alter VB4 = $&drive
let drive = (floor(trial / 32) - 2*floor(trial / 64))*1.8
alter VB5 = $&drive
let drive = (floor(trial / 64) - 2*floor(trial / 128))*1.8
alter VB6 = $&drive
let drive = (floor(trial / 128) - 2*floor(trial / 256))*1.8
alter VB7 = $&drive
stop when time = 0.004404
resume
delete all
let endpoint = length(time)-1
let cmp = v(COMP)[endpoint]
let top = v(TOP)[endpoint]
let decision = 0
if cmp >= 0.9
let code = trial
let decision = 1
end
echo 244 3 $&trial $&cmp $&top 1.13203125 $&decision >> decisions.csv
let trial = code + 4
let drive = (floor(trial / 1) - 2*floor(trial / 2))*1.8
alter VB0 = $&drive
let drive = (floor(trial / 2) - 2*floor(trial / 4))*1.8
alter VB1 = $&drive
let drive = (floor(trial / 4) - 2*floor(trial / 8))*1.8
alter VB2 = $&drive
let drive = (floor(trial / 8) - 2*floor(trial / 16))*1.8
alter VB3 = $&drive
let drive = (floor(trial / 16) - 2*floor(trial / 32))*1.8
alter VB4 = $&drive
let drive = (floor(trial / 32) - 2*floor(trial / 64))*1.8
alter VB5 = $&drive
let drive = (floor(trial / 64) - 2*floor(trial / 128))*1.8
alter VB6 = $&drive
let drive = (floor(trial / 128) - 2*floor(trial / 256))*1.8
alter VB7 = $&drive
stop when time = 0.004406
resume
delete all
let endpoint = length(time)-1
let cmp = v(COMP)[endpoint]
let top = v(TOP)[endpoint]
let decision = 0
if cmp >= 0.9
let code = trial
let decision = 1
end
echo 244 2 $&trial $&cmp $&top 1.13203125 $&decision >> decisions.csv
let trial = code + 2
let drive = (floor(trial / 1) - 2*floor(trial / 2))*1.8
alter VB0 = $&drive
let drive = (floor(trial / 2) - 2*floor(trial / 4))*1.8
alter VB1 = $&drive
let drive = (floor(trial / 4) - 2*floor(trial / 8))*1.8
alter VB2 = $&drive
let drive = (floor(trial / 8) - 2*floor(trial / 16))*1.8
alter VB3 = $&drive
let drive = (floor(trial / 16) - 2*floor(trial / 32))*1.8
alter VB4 = $&drive
let drive = (floor(trial / 32) - 2*floor(trial / 64))*1.8
alter VB5 = $&drive
let drive = (floor(trial / 64) - 2*floor(trial / 128))*1.8
alter VB6 = $&drive
let drive = (floor(trial / 128) - 2*floor(trial / 256))*1.8
alter VB7 = $&drive
stop when time = 0.004408
resume
delete all
let endpoint = length(time)-1
let cmp = v(COMP)[endpoint]
let top = v(TOP)[endpoint]
let decision = 0
if cmp >= 0.9
let code = trial
let decision = 1
end
echo 244 1 $&trial $&cmp $&top 1.13203125 $&decision >> decisions.csv
let trial = code + 1
let drive = (floor(trial / 1) - 2*floor(trial / 2))*1.8
alter VB0 = $&drive
let drive = (floor(trial / 2) - 2*floor(trial / 4))*1.8
alter VB1 = $&drive
let drive = (floor(trial / 4) - 2*floor(trial / 8))*1.8
alter VB2 = $&drive
let drive = (floor(trial / 8) - 2*floor(trial / 16))*1.8
alter VB3 = $&drive
let drive = (floor(trial / 16) - 2*floor(trial / 32))*1.8
alter VB4 = $&drive
let drive = (floor(trial / 32) - 2*floor(trial / 64))*1.8
alter VB5 = $&drive
let drive = (floor(trial / 64) - 2*floor(trial / 128))*1.8
alter VB6 = $&drive
let drive = (floor(trial / 128) - 2*floor(trial / 256))*1.8
alter VB7 = $&drive
stop when time = 0.00441
resume
delete all
let endpoint = length(time)-1
let cmp = v(COMP)[endpoint]
let top = v(TOP)[endpoint]
let decision = 0
if cmp >= 0.9
let code = trial
let decision = 1
end
echo 244 0 $&trial $&cmp $&top 1.13203125 $&decision >> decisions.csv
alter VIN = 1.13671875
alter VSAMPLE = 1.8
alter VB0 = 0
alter VB1 = 0
alter VB2 = 0
alter VB3 = 0
alter VB4 = 0
alter VB5 = 0
alter VB6 = 0
alter VB7 = 0
let code = 0
stop when time = 0.004412
resume
delete all
alter VSAMPLE = 0
let trial = code + 128
let drive = (floor(trial / 1) - 2*floor(trial / 2))*1.8
alter VB0 = $&drive
let drive = (floor(trial / 2) - 2*floor(trial / 4))*1.8
alter VB1 = $&drive
let drive = (floor(trial / 4) - 2*floor(trial / 8))*1.8
alter VB2 = $&drive
let drive = (floor(trial / 8) - 2*floor(trial / 16))*1.8
alter VB3 = $&drive
let drive = (floor(trial / 16) - 2*floor(trial / 32))*1.8
alter VB4 = $&drive
let drive = (floor(trial / 32) - 2*floor(trial / 64))*1.8
alter VB5 = $&drive
let drive = (floor(trial / 64) - 2*floor(trial / 128))*1.8
alter VB6 = $&drive
let drive = (floor(trial / 128) - 2*floor(trial / 256))*1.8
alter VB7 = $&drive
stop when time = 0.004414
resume
delete all
let endpoint = length(time)-1
let cmp = v(COMP)[endpoint]
let top = v(TOP)[endpoint]
let decision = 0
if cmp >= 0.9
let code = trial
let decision = 1
end
echo 245 7 $&trial $&cmp $&top 1.13671875 $&decision >> decisions.csv
let trial = code + 64
let drive = (floor(trial / 1) - 2*floor(trial / 2))*1.8
alter VB0 = $&drive
let drive = (floor(trial / 2) - 2*floor(trial / 4))*1.8
alter VB1 = $&drive
let drive = (floor(trial / 4) - 2*floor(trial / 8))*1.8
alter VB2 = $&drive
let drive = (floor(trial / 8) - 2*floor(trial / 16))*1.8
alter VB3 = $&drive
let drive = (floor(trial / 16) - 2*floor(trial / 32))*1.8
alter VB4 = $&drive
let drive = (floor(trial / 32) - 2*floor(trial / 64))*1.8
alter VB5 = $&drive
let drive = (floor(trial / 64) - 2*floor(trial / 128))*1.8
alter VB6 = $&drive
let drive = (floor(trial / 128) - 2*floor(trial / 256))*1.8
alter VB7 = $&drive
stop when time = 0.004416
resume
delete all
let endpoint = length(time)-1
let cmp = v(COMP)[endpoint]
let top = v(TOP)[endpoint]
let decision = 0
if cmp >= 0.9
let code = trial
let decision = 1
end
echo 245 6 $&trial $&cmp $&top 1.13671875 $&decision >> decisions.csv
let trial = code + 32
let drive = (floor(trial / 1) - 2*floor(trial / 2))*1.8
alter VB0 = $&drive
let drive = (floor(trial / 2) - 2*floor(trial / 4))*1.8
alter VB1 = $&drive
let drive = (floor(trial / 4) - 2*floor(trial / 8))*1.8
alter VB2 = $&drive
let drive = (floor(trial / 8) - 2*floor(trial / 16))*1.8
alter VB3 = $&drive
let drive = (floor(trial / 16) - 2*floor(trial / 32))*1.8
alter VB4 = $&drive
let drive = (floor(trial / 32) - 2*floor(trial / 64))*1.8
alter VB5 = $&drive
let drive = (floor(trial / 64) - 2*floor(trial / 128))*1.8
alter VB6 = $&drive
let drive = (floor(trial / 128) - 2*floor(trial / 256))*1.8
alter VB7 = $&drive
stop when time = 0.004418
resume
delete all
let endpoint = length(time)-1
let cmp = v(COMP)[endpoint]
let top = v(TOP)[endpoint]
let decision = 0
if cmp >= 0.9
let code = trial
let decision = 1
end
echo 245 5 $&trial $&cmp $&top 1.13671875 $&decision >> decisions.csv
let trial = code + 16
let drive = (floor(trial / 1) - 2*floor(trial / 2))*1.8
alter VB0 = $&drive
let drive = (floor(trial / 2) - 2*floor(trial / 4))*1.8
alter VB1 = $&drive
let drive = (floor(trial / 4) - 2*floor(trial / 8))*1.8
alter VB2 = $&drive
let drive = (floor(trial / 8) - 2*floor(trial / 16))*1.8
alter VB3 = $&drive
let drive = (floor(trial / 16) - 2*floor(trial / 32))*1.8
alter VB4 = $&drive
let drive = (floor(trial / 32) - 2*floor(trial / 64))*1.8
alter VB5 = $&drive
let drive = (floor(trial / 64) - 2*floor(trial / 128))*1.8
alter VB6 = $&drive
let drive = (floor(trial / 128) - 2*floor(trial / 256))*1.8
alter VB7 = $&drive
stop when time = 0.00442
resume
delete all
let endpoint = length(time)-1
let cmp = v(COMP)[endpoint]
let top = v(TOP)[endpoint]
let decision = 0
if cmp >= 0.9
let code = trial
let decision = 1
end
echo 245 4 $&trial $&cmp $&top 1.13671875 $&decision >> decisions.csv
let trial = code + 8
let drive = (floor(trial / 1) - 2*floor(trial / 2))*1.8
alter VB0 = $&drive
let drive = (floor(trial / 2) - 2*floor(trial / 4))*1.8
alter VB1 = $&drive
let drive = (floor(trial / 4) - 2*floor(trial / 8))*1.8
alter VB2 = $&drive
let drive = (floor(trial / 8) - 2*floor(trial / 16))*1.8
alter VB3 = $&drive
let drive = (floor(trial / 16) - 2*floor(trial / 32))*1.8
alter VB4 = $&drive
let drive = (floor(trial / 32) - 2*floor(trial / 64))*1.8
alter VB5 = $&drive
let drive = (floor(trial / 64) - 2*floor(trial / 128))*1.8
alter VB6 = $&drive
let drive = (floor(trial / 128) - 2*floor(trial / 256))*1.8
alter VB7 = $&drive
stop when time = 0.004422
resume
delete all
let endpoint = length(time)-1
let cmp = v(COMP)[endpoint]
let top = v(TOP)[endpoint]
let decision = 0
if cmp >= 0.9
let code = trial
let decision = 1
end
echo 245 3 $&trial $&cmp $&top 1.13671875 $&decision >> decisions.csv
let trial = code + 4
let drive = (floor(trial / 1) - 2*floor(trial / 2))*1.8
alter VB0 = $&drive
let drive = (floor(trial / 2) - 2*floor(trial / 4))*1.8
alter VB1 = $&drive
let drive = (floor(trial / 4) - 2*floor(trial / 8))*1.8
alter VB2 = $&drive
let drive = (floor(trial / 8) - 2*floor(trial / 16))*1.8
alter VB3 = $&drive
let drive = (floor(trial / 16) - 2*floor(trial / 32))*1.8
alter VB4 = $&drive
let drive = (floor(trial / 32) - 2*floor(trial / 64))*1.8
alter VB5 = $&drive
let drive = (floor(trial / 64) - 2*floor(trial / 128))*1.8
alter VB6 = $&drive
let drive = (floor(trial / 128) - 2*floor(trial / 256))*1.8
alter VB7 = $&drive
stop when time = 0.004424
resume
delete all
let endpoint = length(time)-1
let cmp = v(COMP)[endpoint]
let top = v(TOP)[endpoint]
let decision = 0
if cmp >= 0.9
let code = trial
let decision = 1
end
echo 245 2 $&trial $&cmp $&top 1.13671875 $&decision >> decisions.csv
let trial = code + 2
let drive = (floor(trial / 1) - 2*floor(trial / 2))*1.8
alter VB0 = $&drive
let drive = (floor(trial / 2) - 2*floor(trial / 4))*1.8
alter VB1 = $&drive
let drive = (floor(trial / 4) - 2*floor(trial / 8))*1.8
alter VB2 = $&drive
let drive = (floor(trial / 8) - 2*floor(trial / 16))*1.8
alter VB3 = $&drive
let drive = (floor(trial / 16) - 2*floor(trial / 32))*1.8
alter VB4 = $&drive
let drive = (floor(trial / 32) - 2*floor(trial / 64))*1.8
alter VB5 = $&drive
let drive = (floor(trial / 64) - 2*floor(trial / 128))*1.8
alter VB6 = $&drive
let drive = (floor(trial / 128) - 2*floor(trial / 256))*1.8
alter VB7 = $&drive
stop when time = 0.004426
resume
delete all
let endpoint = length(time)-1
let cmp = v(COMP)[endpoint]
let top = v(TOP)[endpoint]
let decision = 0
if cmp >= 0.9
let code = trial
let decision = 1
end
echo 245 1 $&trial $&cmp $&top 1.13671875 $&decision >> decisions.csv
let trial = code + 1
let drive = (floor(trial / 1) - 2*floor(trial / 2))*1.8
alter VB0 = $&drive
let drive = (floor(trial / 2) - 2*floor(trial / 4))*1.8
alter VB1 = $&drive
let drive = (floor(trial / 4) - 2*floor(trial / 8))*1.8
alter VB2 = $&drive
let drive = (floor(trial / 8) - 2*floor(trial / 16))*1.8
alter VB3 = $&drive
let drive = (floor(trial / 16) - 2*floor(trial / 32))*1.8
alter VB4 = $&drive
let drive = (floor(trial / 32) - 2*floor(trial / 64))*1.8
alter VB5 = $&drive
let drive = (floor(trial / 64) - 2*floor(trial / 128))*1.8
alter VB6 = $&drive
let drive = (floor(trial / 128) - 2*floor(trial / 256))*1.8
alter VB7 = $&drive
stop when time = 0.004428
resume
delete all
let endpoint = length(time)-1
let cmp = v(COMP)[endpoint]
let top = v(TOP)[endpoint]
let decision = 0
if cmp >= 0.9
let code = trial
let decision = 1
end
echo 245 0 $&trial $&cmp $&top 1.13671875 $&decision >> decisions.csv
alter VIN = 1.14140625
alter VSAMPLE = 1.8
alter VB0 = 0
alter VB1 = 0
alter VB2 = 0
alter VB3 = 0
alter VB4 = 0
alter VB5 = 0
alter VB6 = 0
alter VB7 = 0
let code = 0
stop when time = 0.00443
resume
delete all
alter VSAMPLE = 0
let trial = code + 128
let drive = (floor(trial / 1) - 2*floor(trial / 2))*1.8
alter VB0 = $&drive
let drive = (floor(trial / 2) - 2*floor(trial / 4))*1.8
alter VB1 = $&drive
let drive = (floor(trial / 4) - 2*floor(trial / 8))*1.8
alter VB2 = $&drive
let drive = (floor(trial / 8) - 2*floor(trial / 16))*1.8
alter VB3 = $&drive
let drive = (floor(trial / 16) - 2*floor(trial / 32))*1.8
alter VB4 = $&drive
let drive = (floor(trial / 32) - 2*floor(trial / 64))*1.8
alter VB5 = $&drive
let drive = (floor(trial / 64) - 2*floor(trial / 128))*1.8
alter VB6 = $&drive
let drive = (floor(trial / 128) - 2*floor(trial / 256))*1.8
alter VB7 = $&drive
stop when time = 0.004432
resume
delete all
let endpoint = length(time)-1
let cmp = v(COMP)[endpoint]
let top = v(TOP)[endpoint]
let decision = 0
if cmp >= 0.9
let code = trial
let decision = 1
end
echo 246 7 $&trial $&cmp $&top 1.14140625 $&decision >> decisions.csv
let trial = code + 64
let drive = (floor(trial / 1) - 2*floor(trial / 2))*1.8
alter VB0 = $&drive
let drive = (floor(trial / 2) - 2*floor(trial / 4))*1.8
alter VB1 = $&drive
let drive = (floor(trial / 4) - 2*floor(trial / 8))*1.8
alter VB2 = $&drive
let drive = (floor(trial / 8) - 2*floor(trial / 16))*1.8
alter VB3 = $&drive
let drive = (floor(trial / 16) - 2*floor(trial / 32))*1.8
alter VB4 = $&drive
let drive = (floor(trial / 32) - 2*floor(trial / 64))*1.8
alter VB5 = $&drive
let drive = (floor(trial / 64) - 2*floor(trial / 128))*1.8
alter VB6 = $&drive
let drive = (floor(trial / 128) - 2*floor(trial / 256))*1.8
alter VB7 = $&drive
stop when time = 0.004434
resume
delete all
let endpoint = length(time)-1
let cmp = v(COMP)[endpoint]
let top = v(TOP)[endpoint]
let decision = 0
if cmp >= 0.9
let code = trial
let decision = 1
end
echo 246 6 $&trial $&cmp $&top 1.14140625 $&decision >> decisions.csv
let trial = code + 32
let drive = (floor(trial / 1) - 2*floor(trial / 2))*1.8
alter VB0 = $&drive
let drive = (floor(trial / 2) - 2*floor(trial / 4))*1.8
alter VB1 = $&drive
let drive = (floor(trial / 4) - 2*floor(trial / 8))*1.8
alter VB2 = $&drive
let drive = (floor(trial / 8) - 2*floor(trial / 16))*1.8
alter VB3 = $&drive
let drive = (floor(trial / 16) - 2*floor(trial / 32))*1.8
alter VB4 = $&drive
let drive = (floor(trial / 32) - 2*floor(trial / 64))*1.8
alter VB5 = $&drive
let drive = (floor(trial / 64) - 2*floor(trial / 128))*1.8
alter VB6 = $&drive
let drive = (floor(trial / 128) - 2*floor(trial / 256))*1.8
alter VB7 = $&drive
stop when time = 0.004436
resume
delete all
let endpoint = length(time)-1
let cmp = v(COMP)[endpoint]
let top = v(TOP)[endpoint]
let decision = 0
if cmp >= 0.9
let code = trial
let decision = 1
end
echo 246 5 $&trial $&cmp $&top 1.14140625 $&decision >> decisions.csv
let trial = code + 16
let drive = (floor(trial / 1) - 2*floor(trial / 2))*1.8
alter VB0 = $&drive
let drive = (floor(trial / 2) - 2*floor(trial / 4))*1.8
alter VB1 = $&drive
let drive = (floor(trial / 4) - 2*floor(trial / 8))*1.8
alter VB2 = $&drive
let drive = (floor(trial / 8) - 2*floor(trial / 16))*1.8
alter VB3 = $&drive
let drive = (floor(trial / 16) - 2*floor(trial / 32))*1.8
alter VB4 = $&drive
let drive = (floor(trial / 32) - 2*floor(trial / 64))*1.8
alter VB5 = $&drive
let drive = (floor(trial / 64) - 2*floor(trial / 128))*1.8
alter VB6 = $&drive
let drive = (floor(trial / 128) - 2*floor(trial / 256))*1.8
alter VB7 = $&drive
stop when time = 0.004438
resume
delete all
let endpoint = length(time)-1
let cmp = v(COMP)[endpoint]
let top = v(TOP)[endpoint]
let decision = 0
if cmp >= 0.9
let code = trial
let decision = 1
end
echo 246 4 $&trial $&cmp $&top 1.14140625 $&decision >> decisions.csv
let trial = code + 8
let drive = (floor(trial / 1) - 2*floor(trial / 2))*1.8
alter VB0 = $&drive
let drive = (floor(trial / 2) - 2*floor(trial / 4))*1.8
alter VB1 = $&drive
let drive = (floor(trial / 4) - 2*floor(trial / 8))*1.8
alter VB2 = $&drive
let drive = (floor(trial / 8) - 2*floor(trial / 16))*1.8
alter VB3 = $&drive
let drive = (floor(trial / 16) - 2*floor(trial / 32))*1.8
alter VB4 = $&drive
let drive = (floor(trial / 32) - 2*floor(trial / 64))*1.8
alter VB5 = $&drive
let drive = (floor(trial / 64) - 2*floor(trial / 128))*1.8
alter VB6 = $&drive
let drive = (floor(trial / 128) - 2*floor(trial / 256))*1.8
alter VB7 = $&drive
stop when time = 0.00444
resume
delete all
let endpoint = length(time)-1
let cmp = v(COMP)[endpoint]
let top = v(TOP)[endpoint]
let decision = 0
if cmp >= 0.9
let code = trial
let decision = 1
end
echo 246 3 $&trial $&cmp $&top 1.14140625 $&decision >> decisions.csv
let trial = code + 4
let drive = (floor(trial / 1) - 2*floor(trial / 2))*1.8
alter VB0 = $&drive
let drive = (floor(trial / 2) - 2*floor(trial / 4))*1.8
alter VB1 = $&drive
let drive = (floor(trial / 4) - 2*floor(trial / 8))*1.8
alter VB2 = $&drive
let drive = (floor(trial / 8) - 2*floor(trial / 16))*1.8
alter VB3 = $&drive
let drive = (floor(trial / 16) - 2*floor(trial / 32))*1.8
alter VB4 = $&drive
let drive = (floor(trial / 32) - 2*floor(trial / 64))*1.8
alter VB5 = $&drive
let drive = (floor(trial / 64) - 2*floor(trial / 128))*1.8
alter VB6 = $&drive
let drive = (floor(trial / 128) - 2*floor(trial / 256))*1.8
alter VB7 = $&drive
stop when time = 0.004442
resume
delete all
let endpoint = length(time)-1
let cmp = v(COMP)[endpoint]
let top = v(TOP)[endpoint]
let decision = 0
if cmp >= 0.9
let code = trial
let decision = 1
end
echo 246 2 $&trial $&cmp $&top 1.14140625 $&decision >> decisions.csv
let trial = code + 2
let drive = (floor(trial / 1) - 2*floor(trial / 2))*1.8
alter VB0 = $&drive
let drive = (floor(trial / 2) - 2*floor(trial / 4))*1.8
alter VB1 = $&drive
let drive = (floor(trial / 4) - 2*floor(trial / 8))*1.8
alter VB2 = $&drive
let drive = (floor(trial / 8) - 2*floor(trial / 16))*1.8
alter VB3 = $&drive
let drive = (floor(trial / 16) - 2*floor(trial / 32))*1.8
alter VB4 = $&drive
let drive = (floor(trial / 32) - 2*floor(trial / 64))*1.8
alter VB5 = $&drive
let drive = (floor(trial / 64) - 2*floor(trial / 128))*1.8
alter VB6 = $&drive
let drive = (floor(trial / 128) - 2*floor(trial / 256))*1.8
alter VB7 = $&drive
stop when time = 0.004444
resume
delete all
let endpoint = length(time)-1
let cmp = v(COMP)[endpoint]
let top = v(TOP)[endpoint]
let decision = 0
if cmp >= 0.9
let code = trial
let decision = 1
end
echo 246 1 $&trial $&cmp $&top 1.14140625 $&decision >> decisions.csv
let trial = code + 1
let drive = (floor(trial / 1) - 2*floor(trial / 2))*1.8
alter VB0 = $&drive
let drive = (floor(trial / 2) - 2*floor(trial / 4))*1.8
alter VB1 = $&drive
let drive = (floor(trial / 4) - 2*floor(trial / 8))*1.8
alter VB2 = $&drive
let drive = (floor(trial / 8) - 2*floor(trial / 16))*1.8
alter VB3 = $&drive
let drive = (floor(trial / 16) - 2*floor(trial / 32))*1.8
alter VB4 = $&drive
let drive = (floor(trial / 32) - 2*floor(trial / 64))*1.8
alter VB5 = $&drive
let drive = (floor(trial / 64) - 2*floor(trial / 128))*1.8
alter VB6 = $&drive
let drive = (floor(trial / 128) - 2*floor(trial / 256))*1.8
alter VB7 = $&drive
stop when time = 0.004446
resume
delete all
let endpoint = length(time)-1
let cmp = v(COMP)[endpoint]
let top = v(TOP)[endpoint]
let decision = 0
if cmp >= 0.9
let code = trial
let decision = 1
end
echo 246 0 $&trial $&cmp $&top 1.14140625 $&decision >> decisions.csv
alter VIN = 1.14609375
alter VSAMPLE = 1.8
alter VB0 = 0
alter VB1 = 0
alter VB2 = 0
alter VB3 = 0
alter VB4 = 0
alter VB5 = 0
alter VB6 = 0
alter VB7 = 0
let code = 0
stop when time = 0.004448
resume
delete all
alter VSAMPLE = 0
let trial = code + 128
let drive = (floor(trial / 1) - 2*floor(trial / 2))*1.8
alter VB0 = $&drive
let drive = (floor(trial / 2) - 2*floor(trial / 4))*1.8
alter VB1 = $&drive
let drive = (floor(trial / 4) - 2*floor(trial / 8))*1.8
alter VB2 = $&drive
let drive = (floor(trial / 8) - 2*floor(trial / 16))*1.8
alter VB3 = $&drive
let drive = (floor(trial / 16) - 2*floor(trial / 32))*1.8
alter VB4 = $&drive
let drive = (floor(trial / 32) - 2*floor(trial / 64))*1.8
alter VB5 = $&drive
let drive = (floor(trial / 64) - 2*floor(trial / 128))*1.8
alter VB6 = $&drive
let drive = (floor(trial / 128) - 2*floor(trial / 256))*1.8
alter VB7 = $&drive
stop when time = 0.00445
resume
delete all
let endpoint = length(time)-1
let cmp = v(COMP)[endpoint]
let top = v(TOP)[endpoint]
let decision = 0
if cmp >= 0.9
let code = trial
let decision = 1
end
echo 247 7 $&trial $&cmp $&top 1.14609375 $&decision >> decisions.csv
let trial = code + 64
let drive = (floor(trial / 1) - 2*floor(trial / 2))*1.8
alter VB0 = $&drive
let drive = (floor(trial / 2) - 2*floor(trial / 4))*1.8
alter VB1 = $&drive
let drive = (floor(trial / 4) - 2*floor(trial / 8))*1.8
alter VB2 = $&drive
let drive = (floor(trial / 8) - 2*floor(trial / 16))*1.8
alter VB3 = $&drive
let drive = (floor(trial / 16) - 2*floor(trial / 32))*1.8
alter VB4 = $&drive
let drive = (floor(trial / 32) - 2*floor(trial / 64))*1.8
alter VB5 = $&drive
let drive = (floor(trial / 64) - 2*floor(trial / 128))*1.8
alter VB6 = $&drive
let drive = (floor(trial / 128) - 2*floor(trial / 256))*1.8
alter VB7 = $&drive
stop when time = 0.004452
resume
delete all
let endpoint = length(time)-1
let cmp = v(COMP)[endpoint]
let top = v(TOP)[endpoint]
let decision = 0
if cmp >= 0.9
let code = trial
let decision = 1
end
echo 247 6 $&trial $&cmp $&top 1.14609375 $&decision >> decisions.csv
let trial = code + 32
let drive = (floor(trial / 1) - 2*floor(trial / 2))*1.8
alter VB0 = $&drive
let drive = (floor(trial / 2) - 2*floor(trial / 4))*1.8
alter VB1 = $&drive
let drive = (floor(trial / 4) - 2*floor(trial / 8))*1.8
alter VB2 = $&drive
let drive = (floor(trial / 8) - 2*floor(trial / 16))*1.8
alter VB3 = $&drive
let drive = (floor(trial / 16) - 2*floor(trial / 32))*1.8
alter VB4 = $&drive
let drive = (floor(trial / 32) - 2*floor(trial / 64))*1.8
alter VB5 = $&drive
let drive = (floor(trial / 64) - 2*floor(trial / 128))*1.8
alter VB6 = $&drive
let drive = (floor(trial / 128) - 2*floor(trial / 256))*1.8
alter VB7 = $&drive
stop when time = 0.004454
resume
delete all
let endpoint = length(time)-1
let cmp = v(COMP)[endpoint]
let top = v(TOP)[endpoint]
let decision = 0
if cmp >= 0.9
let code = trial
let decision = 1
end
echo 247 5 $&trial $&cmp $&top 1.14609375 $&decision >> decisions.csv
let trial = code + 16
let drive = (floor(trial / 1) - 2*floor(trial / 2))*1.8
alter VB0 = $&drive
let drive = (floor(trial / 2) - 2*floor(trial / 4))*1.8
alter VB1 = $&drive
let drive = (floor(trial / 4) - 2*floor(trial / 8))*1.8
alter VB2 = $&drive
let drive = (floor(trial / 8) - 2*floor(trial / 16))*1.8
alter VB3 = $&drive
let drive = (floor(trial / 16) - 2*floor(trial / 32))*1.8
alter VB4 = $&drive
let drive = (floor(trial / 32) - 2*floor(trial / 64))*1.8
alter VB5 = $&drive
let drive = (floor(trial / 64) - 2*floor(trial / 128))*1.8
alter VB6 = $&drive
let drive = (floor(trial / 128) - 2*floor(trial / 256))*1.8
alter VB7 = $&drive
stop when time = 0.004456
resume
delete all
let endpoint = length(time)-1
let cmp = v(COMP)[endpoint]
let top = v(TOP)[endpoint]
let decision = 0
if cmp >= 0.9
let code = trial
let decision = 1
end
echo 247 4 $&trial $&cmp $&top 1.14609375 $&decision >> decisions.csv
let trial = code + 8
let drive = (floor(trial / 1) - 2*floor(trial / 2))*1.8
alter VB0 = $&drive
let drive = (floor(trial / 2) - 2*floor(trial / 4))*1.8
alter VB1 = $&drive
let drive = (floor(trial / 4) - 2*floor(trial / 8))*1.8
alter VB2 = $&drive
let drive = (floor(trial / 8) - 2*floor(trial / 16))*1.8
alter VB3 = $&drive
let drive = (floor(trial / 16) - 2*floor(trial / 32))*1.8
alter VB4 = $&drive
let drive = (floor(trial / 32) - 2*floor(trial / 64))*1.8
alter VB5 = $&drive
let drive = (floor(trial / 64) - 2*floor(trial / 128))*1.8
alter VB6 = $&drive
let drive = (floor(trial / 128) - 2*floor(trial / 256))*1.8
alter VB7 = $&drive
stop when time = 0.004458
resume
delete all
let endpoint = length(time)-1
let cmp = v(COMP)[endpoint]
let top = v(TOP)[endpoint]
let decision = 0
if cmp >= 0.9
let code = trial
let decision = 1
end
echo 247 3 $&trial $&cmp $&top 1.14609375 $&decision >> decisions.csv
let trial = code + 4
let drive = (floor(trial / 1) - 2*floor(trial / 2))*1.8
alter VB0 = $&drive
let drive = (floor(trial / 2) - 2*floor(trial / 4))*1.8
alter VB1 = $&drive
let drive = (floor(trial / 4) - 2*floor(trial / 8))*1.8
alter VB2 = $&drive
let drive = (floor(trial / 8) - 2*floor(trial / 16))*1.8
alter VB3 = $&drive
let drive = (floor(trial / 16) - 2*floor(trial / 32))*1.8
alter VB4 = $&drive
let drive = (floor(trial / 32) - 2*floor(trial / 64))*1.8
alter VB5 = $&drive
let drive = (floor(trial / 64) - 2*floor(trial / 128))*1.8
alter VB6 = $&drive
let drive = (floor(trial / 128) - 2*floor(trial / 256))*1.8
alter VB7 = $&drive
stop when time = 0.00446
resume
delete all
let endpoint = length(time)-1
let cmp = v(COMP)[endpoint]
let top = v(TOP)[endpoint]
let decision = 0
if cmp >= 0.9
let code = trial
let decision = 1
end
echo 247 2 $&trial $&cmp $&top 1.14609375 $&decision >> decisions.csv
let trial = code + 2
let drive = (floor(trial / 1) - 2*floor(trial / 2))*1.8
alter VB0 = $&drive
let drive = (floor(trial / 2) - 2*floor(trial / 4))*1.8
alter VB1 = $&drive
let drive = (floor(trial / 4) - 2*floor(trial / 8))*1.8
alter VB2 = $&drive
let drive = (floor(trial / 8) - 2*floor(trial / 16))*1.8
alter VB3 = $&drive
let drive = (floor(trial / 16) - 2*floor(trial / 32))*1.8
alter VB4 = $&drive
let drive = (floor(trial / 32) - 2*floor(trial / 64))*1.8
alter VB5 = $&drive
let drive = (floor(trial / 64) - 2*floor(trial / 128))*1.8
alter VB6 = $&drive
let drive = (floor(trial / 128) - 2*floor(trial / 256))*1.8
alter VB7 = $&drive
stop when time = 0.004462
resume
delete all
let endpoint = length(time)-1
let cmp = v(COMP)[endpoint]
let top = v(TOP)[endpoint]
let decision = 0
if cmp >= 0.9
let code = trial
let decision = 1
end
echo 247 1 $&trial $&cmp $&top 1.14609375 $&decision >> decisions.csv
let trial = code + 1
let drive = (floor(trial / 1) - 2*floor(trial / 2))*1.8
alter VB0 = $&drive
let drive = (floor(trial / 2) - 2*floor(trial / 4))*1.8
alter VB1 = $&drive
let drive = (floor(trial / 4) - 2*floor(trial / 8))*1.8
alter VB2 = $&drive
let drive = (floor(trial / 8) - 2*floor(trial / 16))*1.8
alter VB3 = $&drive
let drive = (floor(trial / 16) - 2*floor(trial / 32))*1.8
alter VB4 = $&drive
let drive = (floor(trial / 32) - 2*floor(trial / 64))*1.8
alter VB5 = $&drive
let drive = (floor(trial / 64) - 2*floor(trial / 128))*1.8
alter VB6 = $&drive
let drive = (floor(trial / 128) - 2*floor(trial / 256))*1.8
alter VB7 = $&drive
stop when time = 0.004464
resume
delete all
let endpoint = length(time)-1
let cmp = v(COMP)[endpoint]
let top = v(TOP)[endpoint]
let decision = 0
if cmp >= 0.9
let code = trial
let decision = 1
end
echo 247 0 $&trial $&cmp $&top 1.14609375 $&decision >> decisions.csv
alter VIN = 1.15078125
alter VSAMPLE = 1.8
alter VB0 = 0
alter VB1 = 0
alter VB2 = 0
alter VB3 = 0
alter VB4 = 0
alter VB5 = 0
alter VB6 = 0
alter VB7 = 0
let code = 0
stop when time = 0.004466
resume
delete all
alter VSAMPLE = 0
let trial = code + 128
let drive = (floor(trial / 1) - 2*floor(trial / 2))*1.8
alter VB0 = $&drive
let drive = (floor(trial / 2) - 2*floor(trial / 4))*1.8
alter VB1 = $&drive
let drive = (floor(trial / 4) - 2*floor(trial / 8))*1.8
alter VB2 = $&drive
let drive = (floor(trial / 8) - 2*floor(trial / 16))*1.8
alter VB3 = $&drive
let drive = (floor(trial / 16) - 2*floor(trial / 32))*1.8
alter VB4 = $&drive
let drive = (floor(trial / 32) - 2*floor(trial / 64))*1.8
alter VB5 = $&drive
let drive = (floor(trial / 64) - 2*floor(trial / 128))*1.8
alter VB6 = $&drive
let drive = (floor(trial / 128) - 2*floor(trial / 256))*1.8
alter VB7 = $&drive
stop when time = 0.004468
resume
delete all
let endpoint = length(time)-1
let cmp = v(COMP)[endpoint]
let top = v(TOP)[endpoint]
let decision = 0
if cmp >= 0.9
let code = trial
let decision = 1
end
echo 248 7 $&trial $&cmp $&top 1.15078125 $&decision >> decisions.csv
let trial = code + 64
let drive = (floor(trial / 1) - 2*floor(trial / 2))*1.8
alter VB0 = $&drive
let drive = (floor(trial / 2) - 2*floor(trial / 4))*1.8
alter VB1 = $&drive
let drive = (floor(trial / 4) - 2*floor(trial / 8))*1.8
alter VB2 = $&drive
let drive = (floor(trial / 8) - 2*floor(trial / 16))*1.8
alter VB3 = $&drive
let drive = (floor(trial / 16) - 2*floor(trial / 32))*1.8
alter VB4 = $&drive
let drive = (floor(trial / 32) - 2*floor(trial / 64))*1.8
alter VB5 = $&drive
let drive = (floor(trial / 64) - 2*floor(trial / 128))*1.8
alter VB6 = $&drive
let drive = (floor(trial / 128) - 2*floor(trial / 256))*1.8
alter VB7 = $&drive
stop when time = 0.00447
resume
delete all
let endpoint = length(time)-1
let cmp = v(COMP)[endpoint]
let top = v(TOP)[endpoint]
let decision = 0
if cmp >= 0.9
let code = trial
let decision = 1
end
echo 248 6 $&trial $&cmp $&top 1.15078125 $&decision >> decisions.csv
let trial = code + 32
let drive = (floor(trial / 1) - 2*floor(trial / 2))*1.8
alter VB0 = $&drive
let drive = (floor(trial / 2) - 2*floor(trial / 4))*1.8
alter VB1 = $&drive
let drive = (floor(trial / 4) - 2*floor(trial / 8))*1.8
alter VB2 = $&drive
let drive = (floor(trial / 8) - 2*floor(trial / 16))*1.8
alter VB3 = $&drive
let drive = (floor(trial / 16) - 2*floor(trial / 32))*1.8
alter VB4 = $&drive
let drive = (floor(trial / 32) - 2*floor(trial / 64))*1.8
alter VB5 = $&drive
let drive = (floor(trial / 64) - 2*floor(trial / 128))*1.8
alter VB6 = $&drive
let drive = (floor(trial / 128) - 2*floor(trial / 256))*1.8
alter VB7 = $&drive
stop when time = 0.004472
resume
delete all
let endpoint = length(time)-1
let cmp = v(COMP)[endpoint]
let top = v(TOP)[endpoint]
let decision = 0
if cmp >= 0.9
let code = trial
let decision = 1
end
echo 248 5 $&trial $&cmp $&top 1.15078125 $&decision >> decisions.csv
let trial = code + 16
let drive = (floor(trial / 1) - 2*floor(trial / 2))*1.8
alter VB0 = $&drive
let drive = (floor(trial / 2) - 2*floor(trial / 4))*1.8
alter VB1 = $&drive
let drive = (floor(trial / 4) - 2*floor(trial / 8))*1.8
alter VB2 = $&drive
let drive = (floor(trial / 8) - 2*floor(trial / 16))*1.8
alter VB3 = $&drive
let drive = (floor(trial / 16) - 2*floor(trial / 32))*1.8
alter VB4 = $&drive
let drive = (floor(trial / 32) - 2*floor(trial / 64))*1.8
alter VB5 = $&drive
let drive = (floor(trial / 64) - 2*floor(trial / 128))*1.8
alter VB6 = $&drive
let drive = (floor(trial / 128) - 2*floor(trial / 256))*1.8
alter VB7 = $&drive
stop when time = 0.004474
resume
delete all
let endpoint = length(time)-1
let cmp = v(COMP)[endpoint]
let top = v(TOP)[endpoint]
let decision = 0
if cmp >= 0.9
let code = trial
let decision = 1
end
echo 248 4 $&trial $&cmp $&top 1.15078125 $&decision >> decisions.csv
let trial = code + 8
let drive = (floor(trial / 1) - 2*floor(trial / 2))*1.8
alter VB0 = $&drive
let drive = (floor(trial / 2) - 2*floor(trial / 4))*1.8
alter VB1 = $&drive
let drive = (floor(trial / 4) - 2*floor(trial / 8))*1.8
alter VB2 = $&drive
let drive = (floor(trial / 8) - 2*floor(trial / 16))*1.8
alter VB3 = $&drive
let drive = (floor(trial / 16) - 2*floor(trial / 32))*1.8
alter VB4 = $&drive
let drive = (floor(trial / 32) - 2*floor(trial / 64))*1.8
alter VB5 = $&drive
let drive = (floor(trial / 64) - 2*floor(trial / 128))*1.8
alter VB6 = $&drive
let drive = (floor(trial / 128) - 2*floor(trial / 256))*1.8
alter VB7 = $&drive
stop when time = 0.004476
resume
delete all
let endpoint = length(time)-1
let cmp = v(COMP)[endpoint]
let top = v(TOP)[endpoint]
let decision = 0
if cmp >= 0.9
let code = trial
let decision = 1
end
echo 248 3 $&trial $&cmp $&top 1.15078125 $&decision >> decisions.csv
let trial = code + 4
let drive = (floor(trial / 1) - 2*floor(trial / 2))*1.8
alter VB0 = $&drive
let drive = (floor(trial / 2) - 2*floor(trial / 4))*1.8
alter VB1 = $&drive
let drive = (floor(trial / 4) - 2*floor(trial / 8))*1.8
alter VB2 = $&drive
let drive = (floor(trial / 8) - 2*floor(trial / 16))*1.8
alter VB3 = $&drive
let drive = (floor(trial / 16) - 2*floor(trial / 32))*1.8
alter VB4 = $&drive
let drive = (floor(trial / 32) - 2*floor(trial / 64))*1.8
alter VB5 = $&drive
let drive = (floor(trial / 64) - 2*floor(trial / 128))*1.8
alter VB6 = $&drive
let drive = (floor(trial / 128) - 2*floor(trial / 256))*1.8
alter VB7 = $&drive
stop when time = 0.004478
resume
delete all
let endpoint = length(time)-1
let cmp = v(COMP)[endpoint]
let top = v(TOP)[endpoint]
let decision = 0
if cmp >= 0.9
let code = trial
let decision = 1
end
echo 248 2 $&trial $&cmp $&top 1.15078125 $&decision >> decisions.csv
let trial = code + 2
let drive = (floor(trial / 1) - 2*floor(trial / 2))*1.8
alter VB0 = $&drive
let drive = (floor(trial / 2) - 2*floor(trial / 4))*1.8
alter VB1 = $&drive
let drive = (floor(trial / 4) - 2*floor(trial / 8))*1.8
alter VB2 = $&drive
let drive = (floor(trial / 8) - 2*floor(trial / 16))*1.8
alter VB3 = $&drive
let drive = (floor(trial / 16) - 2*floor(trial / 32))*1.8
alter VB4 = $&drive
let drive = (floor(trial / 32) - 2*floor(trial / 64))*1.8
alter VB5 = $&drive
let drive = (floor(trial / 64) - 2*floor(trial / 128))*1.8
alter VB6 = $&drive
let drive = (floor(trial / 128) - 2*floor(trial / 256))*1.8
alter VB7 = $&drive
stop when time = 0.00448
resume
delete all
let endpoint = length(time)-1
let cmp = v(COMP)[endpoint]
let top = v(TOP)[endpoint]
let decision = 0
if cmp >= 0.9
let code = trial
let decision = 1
end
echo 248 1 $&trial $&cmp $&top 1.15078125 $&decision >> decisions.csv
let trial = code + 1
let drive = (floor(trial / 1) - 2*floor(trial / 2))*1.8
alter VB0 = $&drive
let drive = (floor(trial / 2) - 2*floor(trial / 4))*1.8
alter VB1 = $&drive
let drive = (floor(trial / 4) - 2*floor(trial / 8))*1.8
alter VB2 = $&drive
let drive = (floor(trial / 8) - 2*floor(trial / 16))*1.8
alter VB3 = $&drive
let drive = (floor(trial / 16) - 2*floor(trial / 32))*1.8
alter VB4 = $&drive
let drive = (floor(trial / 32) - 2*floor(trial / 64))*1.8
alter VB5 = $&drive
let drive = (floor(trial / 64) - 2*floor(trial / 128))*1.8
alter VB6 = $&drive
let drive = (floor(trial / 128) - 2*floor(trial / 256))*1.8
alter VB7 = $&drive
stop when time = 0.004482
resume
delete all
let endpoint = length(time)-1
let cmp = v(COMP)[endpoint]
let top = v(TOP)[endpoint]
let decision = 0
if cmp >= 0.9
let code = trial
let decision = 1
end
echo 248 0 $&trial $&cmp $&top 1.15078125 $&decision >> decisions.csv
alter VIN = 1.15546875
alter VSAMPLE = 1.8
alter VB0 = 0
alter VB1 = 0
alter VB2 = 0
alter VB3 = 0
alter VB4 = 0
alter VB5 = 0
alter VB6 = 0
alter VB7 = 0
let code = 0
stop when time = 0.004484
resume
delete all
alter VSAMPLE = 0
let trial = code + 128
let drive = (floor(trial / 1) - 2*floor(trial / 2))*1.8
alter VB0 = $&drive
let drive = (floor(trial / 2) - 2*floor(trial / 4))*1.8
alter VB1 = $&drive
let drive = (floor(trial / 4) - 2*floor(trial / 8))*1.8
alter VB2 = $&drive
let drive = (floor(trial / 8) - 2*floor(trial / 16))*1.8
alter VB3 = $&drive
let drive = (floor(trial / 16) - 2*floor(trial / 32))*1.8
alter VB4 = $&drive
let drive = (floor(trial / 32) - 2*floor(trial / 64))*1.8
alter VB5 = $&drive
let drive = (floor(trial / 64) - 2*floor(trial / 128))*1.8
alter VB6 = $&drive
let drive = (floor(trial / 128) - 2*floor(trial / 256))*1.8
alter VB7 = $&drive
stop when time = 0.004486
resume
delete all
let endpoint = length(time)-1
let cmp = v(COMP)[endpoint]
let top = v(TOP)[endpoint]
let decision = 0
if cmp >= 0.9
let code = trial
let decision = 1
end
echo 249 7 $&trial $&cmp $&top 1.15546875 $&decision >> decisions.csv
let trial = code + 64
let drive = (floor(trial / 1) - 2*floor(trial / 2))*1.8
alter VB0 = $&drive
let drive = (floor(trial / 2) - 2*floor(trial / 4))*1.8
alter VB1 = $&drive
let drive = (floor(trial / 4) - 2*floor(trial / 8))*1.8
alter VB2 = $&drive
let drive = (floor(trial / 8) - 2*floor(trial / 16))*1.8
alter VB3 = $&drive
let drive = (floor(trial / 16) - 2*floor(trial / 32))*1.8
alter VB4 = $&drive
let drive = (floor(trial / 32) - 2*floor(trial / 64))*1.8
alter VB5 = $&drive
let drive = (floor(trial / 64) - 2*floor(trial / 128))*1.8
alter VB6 = $&drive
let drive = (floor(trial / 128) - 2*floor(trial / 256))*1.8
alter VB7 = $&drive
stop when time = 0.004488
resume
delete all
let endpoint = length(time)-1
let cmp = v(COMP)[endpoint]
let top = v(TOP)[endpoint]
let decision = 0
if cmp >= 0.9
let code = trial
let decision = 1
end
echo 249 6 $&trial $&cmp $&top 1.15546875 $&decision >> decisions.csv
let trial = code + 32
let drive = (floor(trial / 1) - 2*floor(trial / 2))*1.8
alter VB0 = $&drive
let drive = (floor(trial / 2) - 2*floor(trial / 4))*1.8
alter VB1 = $&drive
let drive = (floor(trial / 4) - 2*floor(trial / 8))*1.8
alter VB2 = $&drive
let drive = (floor(trial / 8) - 2*floor(trial / 16))*1.8
alter VB3 = $&drive
let drive = (floor(trial / 16) - 2*floor(trial / 32))*1.8
alter VB4 = $&drive
let drive = (floor(trial / 32) - 2*floor(trial / 64))*1.8
alter VB5 = $&drive
let drive = (floor(trial / 64) - 2*floor(trial / 128))*1.8
alter VB6 = $&drive
let drive = (floor(trial / 128) - 2*floor(trial / 256))*1.8
alter VB7 = $&drive
stop when time = 0.00449
resume
delete all
let endpoint = length(time)-1
let cmp = v(COMP)[endpoint]
let top = v(TOP)[endpoint]
let decision = 0
if cmp >= 0.9
let code = trial
let decision = 1
end
echo 249 5 $&trial $&cmp $&top 1.15546875 $&decision >> decisions.csv
let trial = code + 16
let drive = (floor(trial / 1) - 2*floor(trial / 2))*1.8
alter VB0 = $&drive
let drive = (floor(trial / 2) - 2*floor(trial / 4))*1.8
alter VB1 = $&drive
let drive = (floor(trial / 4) - 2*floor(trial / 8))*1.8
alter VB2 = $&drive
let drive = (floor(trial / 8) - 2*floor(trial / 16))*1.8
alter VB3 = $&drive
let drive = (floor(trial / 16) - 2*floor(trial / 32))*1.8
alter VB4 = $&drive
let drive = (floor(trial / 32) - 2*floor(trial / 64))*1.8
alter VB5 = $&drive
let drive = (floor(trial / 64) - 2*floor(trial / 128))*1.8
alter VB6 = $&drive
let drive = (floor(trial / 128) - 2*floor(trial / 256))*1.8
alter VB7 = $&drive
stop when time = 0.004492
resume
delete all
let endpoint = length(time)-1
let cmp = v(COMP)[endpoint]
let top = v(TOP)[endpoint]
let decision = 0
if cmp >= 0.9
let code = trial
let decision = 1
end
echo 249 4 $&trial $&cmp $&top 1.15546875 $&decision >> decisions.csv
let trial = code + 8
let drive = (floor(trial / 1) - 2*floor(trial / 2))*1.8
alter VB0 = $&drive
let drive = (floor(trial / 2) - 2*floor(trial / 4))*1.8
alter VB1 = $&drive
let drive = (floor(trial / 4) - 2*floor(trial / 8))*1.8
alter VB2 = $&drive
let drive = (floor(trial / 8) - 2*floor(trial / 16))*1.8
alter VB3 = $&drive
let drive = (floor(trial / 16) - 2*floor(trial / 32))*1.8
alter VB4 = $&drive
let drive = (floor(trial / 32) - 2*floor(trial / 64))*1.8
alter VB5 = $&drive
let drive = (floor(trial / 64) - 2*floor(trial / 128))*1.8
alter VB6 = $&drive
let drive = (floor(trial / 128) - 2*floor(trial / 256))*1.8
alter VB7 = $&drive
stop when time = 0.004494
resume
delete all
let endpoint = length(time)-1
let cmp = v(COMP)[endpoint]
let top = v(TOP)[endpoint]
let decision = 0
if cmp >= 0.9
let code = trial
let decision = 1
end
echo 249 3 $&trial $&cmp $&top 1.15546875 $&decision >> decisions.csv
let trial = code + 4
let drive = (floor(trial / 1) - 2*floor(trial / 2))*1.8
alter VB0 = $&drive
let drive = (floor(trial / 2) - 2*floor(trial / 4))*1.8
alter VB1 = $&drive
let drive = (floor(trial / 4) - 2*floor(trial / 8))*1.8
alter VB2 = $&drive
let drive = (floor(trial / 8) - 2*floor(trial / 16))*1.8
alter VB3 = $&drive
let drive = (floor(trial / 16) - 2*floor(trial / 32))*1.8
alter VB4 = $&drive
let drive = (floor(trial / 32) - 2*floor(trial / 64))*1.8
alter VB5 = $&drive
let drive = (floor(trial / 64) - 2*floor(trial / 128))*1.8
alter VB6 = $&drive
let drive = (floor(trial / 128) - 2*floor(trial / 256))*1.8
alter VB7 = $&drive
stop when time = 0.004496
resume
delete all
let endpoint = length(time)-1
let cmp = v(COMP)[endpoint]
let top = v(TOP)[endpoint]
let decision = 0
if cmp >= 0.9
let code = trial
let decision = 1
end
echo 249 2 $&trial $&cmp $&top 1.15546875 $&decision >> decisions.csv
let trial = code + 2
let drive = (floor(trial / 1) - 2*floor(trial / 2))*1.8
alter VB0 = $&drive
let drive = (floor(trial / 2) - 2*floor(trial / 4))*1.8
alter VB1 = $&drive
let drive = (floor(trial / 4) - 2*floor(trial / 8))*1.8
alter VB2 = $&drive
let drive = (floor(trial / 8) - 2*floor(trial / 16))*1.8
alter VB3 = $&drive
let drive = (floor(trial / 16) - 2*floor(trial / 32))*1.8
alter VB4 = $&drive
let drive = (floor(trial / 32) - 2*floor(trial / 64))*1.8
alter VB5 = $&drive
let drive = (floor(trial / 64) - 2*floor(trial / 128))*1.8
alter VB6 = $&drive
let drive = (floor(trial / 128) - 2*floor(trial / 256))*1.8
alter VB7 = $&drive
stop when time = 0.004498
resume
delete all
let endpoint = length(time)-1
let cmp = v(COMP)[endpoint]
let top = v(TOP)[endpoint]
let decision = 0
if cmp >= 0.9
let code = trial
let decision = 1
end
echo 249 1 $&trial $&cmp $&top 1.15546875 $&decision >> decisions.csv
let trial = code + 1
let drive = (floor(trial / 1) - 2*floor(trial / 2))*1.8
alter VB0 = $&drive
let drive = (floor(trial / 2) - 2*floor(trial / 4))*1.8
alter VB1 = $&drive
let drive = (floor(trial / 4) - 2*floor(trial / 8))*1.8
alter VB2 = $&drive
let drive = (floor(trial / 8) - 2*floor(trial / 16))*1.8
alter VB3 = $&drive
let drive = (floor(trial / 16) - 2*floor(trial / 32))*1.8
alter VB4 = $&drive
let drive = (floor(trial / 32) - 2*floor(trial / 64))*1.8
alter VB5 = $&drive
let drive = (floor(trial / 64) - 2*floor(trial / 128))*1.8
alter VB6 = $&drive
let drive = (floor(trial / 128) - 2*floor(trial / 256))*1.8
alter VB7 = $&drive
stop when time = 0.0045
resume
delete all
let endpoint = length(time)-1
let cmp = v(COMP)[endpoint]
let top = v(TOP)[endpoint]
let decision = 0
if cmp >= 0.9
let code = trial
let decision = 1
end
echo 249 0 $&trial $&cmp $&top 1.15546875 $&decision >> decisions.csv
alter VIN = 1.16015625
alter VSAMPLE = 1.8
alter VB0 = 0
alter VB1 = 0
alter VB2 = 0
alter VB3 = 0
alter VB4 = 0
alter VB5 = 0
alter VB6 = 0
alter VB7 = 0
let code = 0
stop when time = 0.004502
resume
delete all
alter VSAMPLE = 0
let trial = code + 128
let drive = (floor(trial / 1) - 2*floor(trial / 2))*1.8
alter VB0 = $&drive
let drive = (floor(trial / 2) - 2*floor(trial / 4))*1.8
alter VB1 = $&drive
let drive = (floor(trial / 4) - 2*floor(trial / 8))*1.8
alter VB2 = $&drive
let drive = (floor(trial / 8) - 2*floor(trial / 16))*1.8
alter VB3 = $&drive
let drive = (floor(trial / 16) - 2*floor(trial / 32))*1.8
alter VB4 = $&drive
let drive = (floor(trial / 32) - 2*floor(trial / 64))*1.8
alter VB5 = $&drive
let drive = (floor(trial / 64) - 2*floor(trial / 128))*1.8
alter VB6 = $&drive
let drive = (floor(trial / 128) - 2*floor(trial / 256))*1.8
alter VB7 = $&drive
stop when time = 0.004504
resume
delete all
let endpoint = length(time)-1
let cmp = v(COMP)[endpoint]
let top = v(TOP)[endpoint]
let decision = 0
if cmp >= 0.9
let code = trial
let decision = 1
end
echo 250 7 $&trial $&cmp $&top 1.16015625 $&decision >> decisions.csv
let trial = code + 64
let drive = (floor(trial / 1) - 2*floor(trial / 2))*1.8
alter VB0 = $&drive
let drive = (floor(trial / 2) - 2*floor(trial / 4))*1.8
alter VB1 = $&drive
let drive = (floor(trial / 4) - 2*floor(trial / 8))*1.8
alter VB2 = $&drive
let drive = (floor(trial / 8) - 2*floor(trial / 16))*1.8
alter VB3 = $&drive
let drive = (floor(trial / 16) - 2*floor(trial / 32))*1.8
alter VB4 = $&drive
let drive = (floor(trial / 32) - 2*floor(trial / 64))*1.8
alter VB5 = $&drive
let drive = (floor(trial / 64) - 2*floor(trial / 128))*1.8
alter VB6 = $&drive
let drive = (floor(trial / 128) - 2*floor(trial / 256))*1.8
alter VB7 = $&drive
stop when time = 0.004506
resume
delete all
let endpoint = length(time)-1
let cmp = v(COMP)[endpoint]
let top = v(TOP)[endpoint]
let decision = 0
if cmp >= 0.9
let code = trial
let decision = 1
end
echo 250 6 $&trial $&cmp $&top 1.16015625 $&decision >> decisions.csv
let trial = code + 32
let drive = (floor(trial / 1) - 2*floor(trial / 2))*1.8
alter VB0 = $&drive
let drive = (floor(trial / 2) - 2*floor(trial / 4))*1.8
alter VB1 = $&drive
let drive = (floor(trial / 4) - 2*floor(trial / 8))*1.8
alter VB2 = $&drive
let drive = (floor(trial / 8) - 2*floor(trial / 16))*1.8
alter VB3 = $&drive
let drive = (floor(trial / 16) - 2*floor(trial / 32))*1.8
alter VB4 = $&drive
let drive = (floor(trial / 32) - 2*floor(trial / 64))*1.8
alter VB5 = $&drive
let drive = (floor(trial / 64) - 2*floor(trial / 128))*1.8
alter VB6 = $&drive
let drive = (floor(trial / 128) - 2*floor(trial / 256))*1.8
alter VB7 = $&drive
stop when time = 0.004508
resume
delete all
let endpoint = length(time)-1
let cmp = v(COMP)[endpoint]
let top = v(TOP)[endpoint]
let decision = 0
if cmp >= 0.9
let code = trial
let decision = 1
end
echo 250 5 $&trial $&cmp $&top 1.16015625 $&decision >> decisions.csv
let trial = code + 16
let drive = (floor(trial / 1) - 2*floor(trial / 2))*1.8
alter VB0 = $&drive
let drive = (floor(trial / 2) - 2*floor(trial / 4))*1.8
alter VB1 = $&drive
let drive = (floor(trial / 4) - 2*floor(trial / 8))*1.8
alter VB2 = $&drive
let drive = (floor(trial / 8) - 2*floor(trial / 16))*1.8
alter VB3 = $&drive
let drive = (floor(trial / 16) - 2*floor(trial / 32))*1.8
alter VB4 = $&drive
let drive = (floor(trial / 32) - 2*floor(trial / 64))*1.8
alter VB5 = $&drive
let drive = (floor(trial / 64) - 2*floor(trial / 128))*1.8
alter VB6 = $&drive
let drive = (floor(trial / 128) - 2*floor(trial / 256))*1.8
alter VB7 = $&drive
stop when time = 0.00451
resume
delete all
let endpoint = length(time)-1
let cmp = v(COMP)[endpoint]
let top = v(TOP)[endpoint]
let decision = 0
if cmp >= 0.9
let code = trial
let decision = 1
end
echo 250 4 $&trial $&cmp $&top 1.16015625 $&decision >> decisions.csv
let trial = code + 8
let drive = (floor(trial / 1) - 2*floor(trial / 2))*1.8
alter VB0 = $&drive
let drive = (floor(trial / 2) - 2*floor(trial / 4))*1.8
alter VB1 = $&drive
let drive = (floor(trial / 4) - 2*floor(trial / 8))*1.8
alter VB2 = $&drive
let drive = (floor(trial / 8) - 2*floor(trial / 16))*1.8
alter VB3 = $&drive
let drive = (floor(trial / 16) - 2*floor(trial / 32))*1.8
alter VB4 = $&drive
let drive = (floor(trial / 32) - 2*floor(trial / 64))*1.8
alter VB5 = $&drive
let drive = (floor(trial / 64) - 2*floor(trial / 128))*1.8
alter VB6 = $&drive
let drive = (floor(trial / 128) - 2*floor(trial / 256))*1.8
alter VB7 = $&drive
stop when time = 0.004512
resume
delete all
let endpoint = length(time)-1
let cmp = v(COMP)[endpoint]
let top = v(TOP)[endpoint]
let decision = 0
if cmp >= 0.9
let code = trial
let decision = 1
end
echo 250 3 $&trial $&cmp $&top 1.16015625 $&decision >> decisions.csv
let trial = code + 4
let drive = (floor(trial / 1) - 2*floor(trial / 2))*1.8
alter VB0 = $&drive
let drive = (floor(trial / 2) - 2*floor(trial / 4))*1.8
alter VB1 = $&drive
let drive = (floor(trial / 4) - 2*floor(trial / 8))*1.8
alter VB2 = $&drive
let drive = (floor(trial / 8) - 2*floor(trial / 16))*1.8
alter VB3 = $&drive
let drive = (floor(trial / 16) - 2*floor(trial / 32))*1.8
alter VB4 = $&drive
let drive = (floor(trial / 32) - 2*floor(trial / 64))*1.8
alter VB5 = $&drive
let drive = (floor(trial / 64) - 2*floor(trial / 128))*1.8
alter VB6 = $&drive
let drive = (floor(trial / 128) - 2*floor(trial / 256))*1.8
alter VB7 = $&drive
stop when time = 0.004514
resume
delete all
let endpoint = length(time)-1
let cmp = v(COMP)[endpoint]
let top = v(TOP)[endpoint]
let decision = 0
if cmp >= 0.9
let code = trial
let decision = 1
end
echo 250 2 $&trial $&cmp $&top 1.16015625 $&decision >> decisions.csv
let trial = code + 2
let drive = (floor(trial / 1) - 2*floor(trial / 2))*1.8
alter VB0 = $&drive
let drive = (floor(trial / 2) - 2*floor(trial / 4))*1.8
alter VB1 = $&drive
let drive = (floor(trial / 4) - 2*floor(trial / 8))*1.8
alter VB2 = $&drive
let drive = (floor(trial / 8) - 2*floor(trial / 16))*1.8
alter VB3 = $&drive
let drive = (floor(trial / 16) - 2*floor(trial / 32))*1.8
alter VB4 = $&drive
let drive = (floor(trial / 32) - 2*floor(trial / 64))*1.8
alter VB5 = $&drive
let drive = (floor(trial / 64) - 2*floor(trial / 128))*1.8
alter VB6 = $&drive
let drive = (floor(trial / 128) - 2*floor(trial / 256))*1.8
alter VB7 = $&drive
stop when time = 0.004516
resume
delete all
let endpoint = length(time)-1
let cmp = v(COMP)[endpoint]
let top = v(TOP)[endpoint]
let decision = 0
if cmp >= 0.9
let code = trial
let decision = 1
end
echo 250 1 $&trial $&cmp $&top 1.16015625 $&decision >> decisions.csv
let trial = code + 1
let drive = (floor(trial / 1) - 2*floor(trial / 2))*1.8
alter VB0 = $&drive
let drive = (floor(trial / 2) - 2*floor(trial / 4))*1.8
alter VB1 = $&drive
let drive = (floor(trial / 4) - 2*floor(trial / 8))*1.8
alter VB2 = $&drive
let drive = (floor(trial / 8) - 2*floor(trial / 16))*1.8
alter VB3 = $&drive
let drive = (floor(trial / 16) - 2*floor(trial / 32))*1.8
alter VB4 = $&drive
let drive = (floor(trial / 32) - 2*floor(trial / 64))*1.8
alter VB5 = $&drive
let drive = (floor(trial / 64) - 2*floor(trial / 128))*1.8
alter VB6 = $&drive
let drive = (floor(trial / 128) - 2*floor(trial / 256))*1.8
alter VB7 = $&drive
stop when time = 0.004518
resume
delete all
let endpoint = length(time)-1
let cmp = v(COMP)[endpoint]
let top = v(TOP)[endpoint]
let decision = 0
if cmp >= 0.9
let code = trial
let decision = 1
end
echo 250 0 $&trial $&cmp $&top 1.16015625 $&decision >> decisions.csv
alter VIN = 1.16484375
alter VSAMPLE = 1.8
alter VB0 = 0
alter VB1 = 0
alter VB2 = 0
alter VB3 = 0
alter VB4 = 0
alter VB5 = 0
alter VB6 = 0
alter VB7 = 0
let code = 0
stop when time = 0.00452
resume
delete all
alter VSAMPLE = 0
let trial = code + 128
let drive = (floor(trial / 1) - 2*floor(trial / 2))*1.8
alter VB0 = $&drive
let drive = (floor(trial / 2) - 2*floor(trial / 4))*1.8
alter VB1 = $&drive
let drive = (floor(trial / 4) - 2*floor(trial / 8))*1.8
alter VB2 = $&drive
let drive = (floor(trial / 8) - 2*floor(trial / 16))*1.8
alter VB3 = $&drive
let drive = (floor(trial / 16) - 2*floor(trial / 32))*1.8
alter VB4 = $&drive
let drive = (floor(trial / 32) - 2*floor(trial / 64))*1.8
alter VB5 = $&drive
let drive = (floor(trial / 64) - 2*floor(trial / 128))*1.8
alter VB6 = $&drive
let drive = (floor(trial / 128) - 2*floor(trial / 256))*1.8
alter VB7 = $&drive
stop when time = 0.004522
resume
delete all
let endpoint = length(time)-1
let cmp = v(COMP)[endpoint]
let top = v(TOP)[endpoint]
let decision = 0
if cmp >= 0.9
let code = trial
let decision = 1
end
echo 251 7 $&trial $&cmp $&top 1.16484375 $&decision >> decisions.csv
let trial = code + 64
let drive = (floor(trial / 1) - 2*floor(trial / 2))*1.8
alter VB0 = $&drive
let drive = (floor(trial / 2) - 2*floor(trial / 4))*1.8
alter VB1 = $&drive
let drive = (floor(trial / 4) - 2*floor(trial / 8))*1.8
alter VB2 = $&drive
let drive = (floor(trial / 8) - 2*floor(trial / 16))*1.8
alter VB3 = $&drive
let drive = (floor(trial / 16) - 2*floor(trial / 32))*1.8
alter VB4 = $&drive
let drive = (floor(trial / 32) - 2*floor(trial / 64))*1.8
alter VB5 = $&drive
let drive = (floor(trial / 64) - 2*floor(trial / 128))*1.8
alter VB6 = $&drive
let drive = (floor(trial / 128) - 2*floor(trial / 256))*1.8
alter VB7 = $&drive
stop when time = 0.004524
resume
delete all
let endpoint = length(time)-1
let cmp = v(COMP)[endpoint]
let top = v(TOP)[endpoint]
let decision = 0
if cmp >= 0.9
let code = trial
let decision = 1
end
echo 251 6 $&trial $&cmp $&top 1.16484375 $&decision >> decisions.csv
let trial = code + 32
let drive = (floor(trial / 1) - 2*floor(trial / 2))*1.8
alter VB0 = $&drive
let drive = (floor(trial / 2) - 2*floor(trial / 4))*1.8
alter VB1 = $&drive
let drive = (floor(trial / 4) - 2*floor(trial / 8))*1.8
alter VB2 = $&drive
let drive = (floor(trial / 8) - 2*floor(trial / 16))*1.8
alter VB3 = $&drive
let drive = (floor(trial / 16) - 2*floor(trial / 32))*1.8
alter VB4 = $&drive
let drive = (floor(trial / 32) - 2*floor(trial / 64))*1.8
alter VB5 = $&drive
let drive = (floor(trial / 64) - 2*floor(trial / 128))*1.8
alter VB6 = $&drive
let drive = (floor(trial / 128) - 2*floor(trial / 256))*1.8
alter VB7 = $&drive
stop when time = 0.004526
resume
delete all
let endpoint = length(time)-1
let cmp = v(COMP)[endpoint]
let top = v(TOP)[endpoint]
let decision = 0
if cmp >= 0.9
let code = trial
let decision = 1
end
echo 251 5 $&trial $&cmp $&top 1.16484375 $&decision >> decisions.csv
let trial = code + 16
let drive = (floor(trial / 1) - 2*floor(trial / 2))*1.8
alter VB0 = $&drive
let drive = (floor(trial / 2) - 2*floor(trial / 4))*1.8
alter VB1 = $&drive
let drive = (floor(trial / 4) - 2*floor(trial / 8))*1.8
alter VB2 = $&drive
let drive = (floor(trial / 8) - 2*floor(trial / 16))*1.8
alter VB3 = $&drive
let drive = (floor(trial / 16) - 2*floor(trial / 32))*1.8
alter VB4 = $&drive
let drive = (floor(trial / 32) - 2*floor(trial / 64))*1.8
alter VB5 = $&drive
let drive = (floor(trial / 64) - 2*floor(trial / 128))*1.8
alter VB6 = $&drive
let drive = (floor(trial / 128) - 2*floor(trial / 256))*1.8
alter VB7 = $&drive
stop when time = 0.004528
resume
delete all
let endpoint = length(time)-1
let cmp = v(COMP)[endpoint]
let top = v(TOP)[endpoint]
let decision = 0
if cmp >= 0.9
let code = trial
let decision = 1
end
echo 251 4 $&trial $&cmp $&top 1.16484375 $&decision >> decisions.csv
let trial = code + 8
let drive = (floor(trial / 1) - 2*floor(trial / 2))*1.8
alter VB0 = $&drive
let drive = (floor(trial / 2) - 2*floor(trial / 4))*1.8
alter VB1 = $&drive
let drive = (floor(trial / 4) - 2*floor(trial / 8))*1.8
alter VB2 = $&drive
let drive = (floor(trial / 8) - 2*floor(trial / 16))*1.8
alter VB3 = $&drive
let drive = (floor(trial / 16) - 2*floor(trial / 32))*1.8
alter VB4 = $&drive
let drive = (floor(trial / 32) - 2*floor(trial / 64))*1.8
alter VB5 = $&drive
let drive = (floor(trial / 64) - 2*floor(trial / 128))*1.8
alter VB6 = $&drive
let drive = (floor(trial / 128) - 2*floor(trial / 256))*1.8
alter VB7 = $&drive
stop when time = 0.00453
resume
delete all
let endpoint = length(time)-1
let cmp = v(COMP)[endpoint]
let top = v(TOP)[endpoint]
let decision = 0
if cmp >= 0.9
let code = trial
let decision = 1
end
echo 251 3 $&trial $&cmp $&top 1.16484375 $&decision >> decisions.csv
let trial = code + 4
let drive = (floor(trial / 1) - 2*floor(trial / 2))*1.8
alter VB0 = $&drive
let drive = (floor(trial / 2) - 2*floor(trial / 4))*1.8
alter VB1 = $&drive
let drive = (floor(trial / 4) - 2*floor(trial / 8))*1.8
alter VB2 = $&drive
let drive = (floor(trial / 8) - 2*floor(trial / 16))*1.8
alter VB3 = $&drive
let drive = (floor(trial / 16) - 2*floor(trial / 32))*1.8
alter VB4 = $&drive
let drive = (floor(trial / 32) - 2*floor(trial / 64))*1.8
alter VB5 = $&drive
let drive = (floor(trial / 64) - 2*floor(trial / 128))*1.8
alter VB6 = $&drive
let drive = (floor(trial / 128) - 2*floor(trial / 256))*1.8
alter VB7 = $&drive
stop when time = 0.004532
resume
delete all
let endpoint = length(time)-1
let cmp = v(COMP)[endpoint]
let top = v(TOP)[endpoint]
let decision = 0
if cmp >= 0.9
let code = trial
let decision = 1
end
echo 251 2 $&trial $&cmp $&top 1.16484375 $&decision >> decisions.csv
let trial = code + 2
let drive = (floor(trial / 1) - 2*floor(trial / 2))*1.8
alter VB0 = $&drive
let drive = (floor(trial / 2) - 2*floor(trial / 4))*1.8
alter VB1 = $&drive
let drive = (floor(trial / 4) - 2*floor(trial / 8))*1.8
alter VB2 = $&drive
let drive = (floor(trial / 8) - 2*floor(trial / 16))*1.8
alter VB3 = $&drive
let drive = (floor(trial / 16) - 2*floor(trial / 32))*1.8
alter VB4 = $&drive
let drive = (floor(trial / 32) - 2*floor(trial / 64))*1.8
alter VB5 = $&drive
let drive = (floor(trial / 64) - 2*floor(trial / 128))*1.8
alter VB6 = $&drive
let drive = (floor(trial / 128) - 2*floor(trial / 256))*1.8
alter VB7 = $&drive
stop when time = 0.004534
resume
delete all
let endpoint = length(time)-1
let cmp = v(COMP)[endpoint]
let top = v(TOP)[endpoint]
let decision = 0
if cmp >= 0.9
let code = trial
let decision = 1
end
echo 251 1 $&trial $&cmp $&top 1.16484375 $&decision >> decisions.csv
let trial = code + 1
let drive = (floor(trial / 1) - 2*floor(trial / 2))*1.8
alter VB0 = $&drive
let drive = (floor(trial / 2) - 2*floor(trial / 4))*1.8
alter VB1 = $&drive
let drive = (floor(trial / 4) - 2*floor(trial / 8))*1.8
alter VB2 = $&drive
let drive = (floor(trial / 8) - 2*floor(trial / 16))*1.8
alter VB3 = $&drive
let drive = (floor(trial / 16) - 2*floor(trial / 32))*1.8
alter VB4 = $&drive
let drive = (floor(trial / 32) - 2*floor(trial / 64))*1.8
alter VB5 = $&drive
let drive = (floor(trial / 64) - 2*floor(trial / 128))*1.8
alter VB6 = $&drive
let drive = (floor(trial / 128) - 2*floor(trial / 256))*1.8
alter VB7 = $&drive
stop when time = 0.004536
resume
delete all
let endpoint = length(time)-1
let cmp = v(COMP)[endpoint]
let top = v(TOP)[endpoint]
let decision = 0
if cmp >= 0.9
let code = trial
let decision = 1
end
echo 251 0 $&trial $&cmp $&top 1.16484375 $&decision >> decisions.csv
alter VIN = 1.16953125
alter VSAMPLE = 1.8
alter VB0 = 0
alter VB1 = 0
alter VB2 = 0
alter VB3 = 0
alter VB4 = 0
alter VB5 = 0
alter VB6 = 0
alter VB7 = 0
let code = 0
stop when time = 0.004538
resume
delete all
alter VSAMPLE = 0
let trial = code + 128
let drive = (floor(trial / 1) - 2*floor(trial / 2))*1.8
alter VB0 = $&drive
let drive = (floor(trial / 2) - 2*floor(trial / 4))*1.8
alter VB1 = $&drive
let drive = (floor(trial / 4) - 2*floor(trial / 8))*1.8
alter VB2 = $&drive
let drive = (floor(trial / 8) - 2*floor(trial / 16))*1.8
alter VB3 = $&drive
let drive = (floor(trial / 16) - 2*floor(trial / 32))*1.8
alter VB4 = $&drive
let drive = (floor(trial / 32) - 2*floor(trial / 64))*1.8
alter VB5 = $&drive
let drive = (floor(trial / 64) - 2*floor(trial / 128))*1.8
alter VB6 = $&drive
let drive = (floor(trial / 128) - 2*floor(trial / 256))*1.8
alter VB7 = $&drive
stop when time = 0.00454
resume
delete all
let endpoint = length(time)-1
let cmp = v(COMP)[endpoint]
let top = v(TOP)[endpoint]
let decision = 0
if cmp >= 0.9
let code = trial
let decision = 1
end
echo 252 7 $&trial $&cmp $&top 1.16953125 $&decision >> decisions.csv
let trial = code + 64
let drive = (floor(trial / 1) - 2*floor(trial / 2))*1.8
alter VB0 = $&drive
let drive = (floor(trial / 2) - 2*floor(trial / 4))*1.8
alter VB1 = $&drive
let drive = (floor(trial / 4) - 2*floor(trial / 8))*1.8
alter VB2 = $&drive
let drive = (floor(trial / 8) - 2*floor(trial / 16))*1.8
alter VB3 = $&drive
let drive = (floor(trial / 16) - 2*floor(trial / 32))*1.8
alter VB4 = $&drive
let drive = (floor(trial / 32) - 2*floor(trial / 64))*1.8
alter VB5 = $&drive
let drive = (floor(trial / 64) - 2*floor(trial / 128))*1.8
alter VB6 = $&drive
let drive = (floor(trial / 128) - 2*floor(trial / 256))*1.8
alter VB7 = $&drive
stop when time = 0.004542
resume
delete all
let endpoint = length(time)-1
let cmp = v(COMP)[endpoint]
let top = v(TOP)[endpoint]
let decision = 0
if cmp >= 0.9
let code = trial
let decision = 1
end
echo 252 6 $&trial $&cmp $&top 1.16953125 $&decision >> decisions.csv
let trial = code + 32
let drive = (floor(trial / 1) - 2*floor(trial / 2))*1.8
alter VB0 = $&drive
let drive = (floor(trial / 2) - 2*floor(trial / 4))*1.8
alter VB1 = $&drive
let drive = (floor(trial / 4) - 2*floor(trial / 8))*1.8
alter VB2 = $&drive
let drive = (floor(trial / 8) - 2*floor(trial / 16))*1.8
alter VB3 = $&drive
let drive = (floor(trial / 16) - 2*floor(trial / 32))*1.8
alter VB4 = $&drive
let drive = (floor(trial / 32) - 2*floor(trial / 64))*1.8
alter VB5 = $&drive
let drive = (floor(trial / 64) - 2*floor(trial / 128))*1.8
alter VB6 = $&drive
let drive = (floor(trial / 128) - 2*floor(trial / 256))*1.8
alter VB7 = $&drive
stop when time = 0.004544
resume
delete all
let endpoint = length(time)-1
let cmp = v(COMP)[endpoint]
let top = v(TOP)[endpoint]
let decision = 0
if cmp >= 0.9
let code = trial
let decision = 1
end
echo 252 5 $&trial $&cmp $&top 1.16953125 $&decision >> decisions.csv
let trial = code + 16
let drive = (floor(trial / 1) - 2*floor(trial / 2))*1.8
alter VB0 = $&drive
let drive = (floor(trial / 2) - 2*floor(trial / 4))*1.8
alter VB1 = $&drive
let drive = (floor(trial / 4) - 2*floor(trial / 8))*1.8
alter VB2 = $&drive
let drive = (floor(trial / 8) - 2*floor(trial / 16))*1.8
alter VB3 = $&drive
let drive = (floor(trial / 16) - 2*floor(trial / 32))*1.8
alter VB4 = $&drive
let drive = (floor(trial / 32) - 2*floor(trial / 64))*1.8
alter VB5 = $&drive
let drive = (floor(trial / 64) - 2*floor(trial / 128))*1.8
alter VB6 = $&drive
let drive = (floor(trial / 128) - 2*floor(trial / 256))*1.8
alter VB7 = $&drive
stop when time = 0.004546
resume
delete all
let endpoint = length(time)-1
let cmp = v(COMP)[endpoint]
let top = v(TOP)[endpoint]
let decision = 0
if cmp >= 0.9
let code = trial
let decision = 1
end
echo 252 4 $&trial $&cmp $&top 1.16953125 $&decision >> decisions.csv
let trial = code + 8
let drive = (floor(trial / 1) - 2*floor(trial / 2))*1.8
alter VB0 = $&drive
let drive = (floor(trial / 2) - 2*floor(trial / 4))*1.8
alter VB1 = $&drive
let drive = (floor(trial / 4) - 2*floor(trial / 8))*1.8
alter VB2 = $&drive
let drive = (floor(trial / 8) - 2*floor(trial / 16))*1.8
alter VB3 = $&drive
let drive = (floor(trial / 16) - 2*floor(trial / 32))*1.8
alter VB4 = $&drive
let drive = (floor(trial / 32) - 2*floor(trial / 64))*1.8
alter VB5 = $&drive
let drive = (floor(trial / 64) - 2*floor(trial / 128))*1.8
alter VB6 = $&drive
let drive = (floor(trial / 128) - 2*floor(trial / 256))*1.8
alter VB7 = $&drive
stop when time = 0.004548
resume
delete all
let endpoint = length(time)-1
let cmp = v(COMP)[endpoint]
let top = v(TOP)[endpoint]
let decision = 0
if cmp >= 0.9
let code = trial
let decision = 1
end
echo 252 3 $&trial $&cmp $&top 1.16953125 $&decision >> decisions.csv
let trial = code + 4
let drive = (floor(trial / 1) - 2*floor(trial / 2))*1.8
alter VB0 = $&drive
let drive = (floor(trial / 2) - 2*floor(trial / 4))*1.8
alter VB1 = $&drive
let drive = (floor(trial / 4) - 2*floor(trial / 8))*1.8
alter VB2 = $&drive
let drive = (floor(trial / 8) - 2*floor(trial / 16))*1.8
alter VB3 = $&drive
let drive = (floor(trial / 16) - 2*floor(trial / 32))*1.8
alter VB4 = $&drive
let drive = (floor(trial / 32) - 2*floor(trial / 64))*1.8
alter VB5 = $&drive
let drive = (floor(trial / 64) - 2*floor(trial / 128))*1.8
alter VB6 = $&drive
let drive = (floor(trial / 128) - 2*floor(trial / 256))*1.8
alter VB7 = $&drive
stop when time = 0.00455
resume
delete all
let endpoint = length(time)-1
let cmp = v(COMP)[endpoint]
let top = v(TOP)[endpoint]
let decision = 0
if cmp >= 0.9
let code = trial
let decision = 1
end
echo 252 2 $&trial $&cmp $&top 1.16953125 $&decision >> decisions.csv
let trial = code + 2
let drive = (floor(trial / 1) - 2*floor(trial / 2))*1.8
alter VB0 = $&drive
let drive = (floor(trial / 2) - 2*floor(trial / 4))*1.8
alter VB1 = $&drive
let drive = (floor(trial / 4) - 2*floor(trial / 8))*1.8
alter VB2 = $&drive
let drive = (floor(trial / 8) - 2*floor(trial / 16))*1.8
alter VB3 = $&drive
let drive = (floor(trial / 16) - 2*floor(trial / 32))*1.8
alter VB4 = $&drive
let drive = (floor(trial / 32) - 2*floor(trial / 64))*1.8
alter VB5 = $&drive
let drive = (floor(trial / 64) - 2*floor(trial / 128))*1.8
alter VB6 = $&drive
let drive = (floor(trial / 128) - 2*floor(trial / 256))*1.8
alter VB7 = $&drive
stop when time = 0.004552
resume
delete all
let endpoint = length(time)-1
let cmp = v(COMP)[endpoint]
let top = v(TOP)[endpoint]
let decision = 0
if cmp >= 0.9
let code = trial
let decision = 1
end
echo 252 1 $&trial $&cmp $&top 1.16953125 $&decision >> decisions.csv
let trial = code + 1
let drive = (floor(trial / 1) - 2*floor(trial / 2))*1.8
alter VB0 = $&drive
let drive = (floor(trial / 2) - 2*floor(trial / 4))*1.8
alter VB1 = $&drive
let drive = (floor(trial / 4) - 2*floor(trial / 8))*1.8
alter VB2 = $&drive
let drive = (floor(trial / 8) - 2*floor(trial / 16))*1.8
alter VB3 = $&drive
let drive = (floor(trial / 16) - 2*floor(trial / 32))*1.8
alter VB4 = $&drive
let drive = (floor(trial / 32) - 2*floor(trial / 64))*1.8
alter VB5 = $&drive
let drive = (floor(trial / 64) - 2*floor(trial / 128))*1.8
alter VB6 = $&drive
let drive = (floor(trial / 128) - 2*floor(trial / 256))*1.8
alter VB7 = $&drive
stop when time = 0.004554
resume
delete all
let endpoint = length(time)-1
let cmp = v(COMP)[endpoint]
let top = v(TOP)[endpoint]
let decision = 0
if cmp >= 0.9
let code = trial
let decision = 1
end
echo 252 0 $&trial $&cmp $&top 1.16953125 $&decision >> decisions.csv
alter VIN = 1.17421875
alter VSAMPLE = 1.8
alter VB0 = 0
alter VB1 = 0
alter VB2 = 0
alter VB3 = 0
alter VB4 = 0
alter VB5 = 0
alter VB6 = 0
alter VB7 = 0
let code = 0
stop when time = 0.004556
resume
delete all
alter VSAMPLE = 0
let trial = code + 128
let drive = (floor(trial / 1) - 2*floor(trial / 2))*1.8
alter VB0 = $&drive
let drive = (floor(trial / 2) - 2*floor(trial / 4))*1.8
alter VB1 = $&drive
let drive = (floor(trial / 4) - 2*floor(trial / 8))*1.8
alter VB2 = $&drive
let drive = (floor(trial / 8) - 2*floor(trial / 16))*1.8
alter VB3 = $&drive
let drive = (floor(trial / 16) - 2*floor(trial / 32))*1.8
alter VB4 = $&drive
let drive = (floor(trial / 32) - 2*floor(trial / 64))*1.8
alter VB5 = $&drive
let drive = (floor(trial / 64) - 2*floor(trial / 128))*1.8
alter VB6 = $&drive
let drive = (floor(trial / 128) - 2*floor(trial / 256))*1.8
alter VB7 = $&drive
stop when time = 0.004558
resume
delete all
let endpoint = length(time)-1
let cmp = v(COMP)[endpoint]
let top = v(TOP)[endpoint]
let decision = 0
if cmp >= 0.9
let code = trial
let decision = 1
end
echo 253 7 $&trial $&cmp $&top 1.17421875 $&decision >> decisions.csv
let trial = code + 64
let drive = (floor(trial / 1) - 2*floor(trial / 2))*1.8
alter VB0 = $&drive
let drive = (floor(trial / 2) - 2*floor(trial / 4))*1.8
alter VB1 = $&drive
let drive = (floor(trial / 4) - 2*floor(trial / 8))*1.8
alter VB2 = $&drive
let drive = (floor(trial / 8) - 2*floor(trial / 16))*1.8
alter VB3 = $&drive
let drive = (floor(trial / 16) - 2*floor(trial / 32))*1.8
alter VB4 = $&drive
let drive = (floor(trial / 32) - 2*floor(trial / 64))*1.8
alter VB5 = $&drive
let drive = (floor(trial / 64) - 2*floor(trial / 128))*1.8
alter VB6 = $&drive
let drive = (floor(trial / 128) - 2*floor(trial / 256))*1.8
alter VB7 = $&drive
stop when time = 0.00456
resume
delete all
let endpoint = length(time)-1
let cmp = v(COMP)[endpoint]
let top = v(TOP)[endpoint]
let decision = 0
if cmp >= 0.9
let code = trial
let decision = 1
end
echo 253 6 $&trial $&cmp $&top 1.17421875 $&decision >> decisions.csv
let trial = code + 32
let drive = (floor(trial / 1) - 2*floor(trial / 2))*1.8
alter VB0 = $&drive
let drive = (floor(trial / 2) - 2*floor(trial / 4))*1.8
alter VB1 = $&drive
let drive = (floor(trial / 4) - 2*floor(trial / 8))*1.8
alter VB2 = $&drive
let drive = (floor(trial / 8) - 2*floor(trial / 16))*1.8
alter VB3 = $&drive
let drive = (floor(trial / 16) - 2*floor(trial / 32))*1.8
alter VB4 = $&drive
let drive = (floor(trial / 32) - 2*floor(trial / 64))*1.8
alter VB5 = $&drive
let drive = (floor(trial / 64) - 2*floor(trial / 128))*1.8
alter VB6 = $&drive
let drive = (floor(trial / 128) - 2*floor(trial / 256))*1.8
alter VB7 = $&drive
stop when time = 0.004562
resume
delete all
let endpoint = length(time)-1
let cmp = v(COMP)[endpoint]
let top = v(TOP)[endpoint]
let decision = 0
if cmp >= 0.9
let code = trial
let decision = 1
end
echo 253 5 $&trial $&cmp $&top 1.17421875 $&decision >> decisions.csv
let trial = code + 16
let drive = (floor(trial / 1) - 2*floor(trial / 2))*1.8
alter VB0 = $&drive
let drive = (floor(trial / 2) - 2*floor(trial / 4))*1.8
alter VB1 = $&drive
let drive = (floor(trial / 4) - 2*floor(trial / 8))*1.8
alter VB2 = $&drive
let drive = (floor(trial / 8) - 2*floor(trial / 16))*1.8
alter VB3 = $&drive
let drive = (floor(trial / 16) - 2*floor(trial / 32))*1.8
alter VB4 = $&drive
let drive = (floor(trial / 32) - 2*floor(trial / 64))*1.8
alter VB5 = $&drive
let drive = (floor(trial / 64) - 2*floor(trial / 128))*1.8
alter VB6 = $&drive
let drive = (floor(trial / 128) - 2*floor(trial / 256))*1.8
alter VB7 = $&drive
stop when time = 0.004564
resume
delete all
let endpoint = length(time)-1
let cmp = v(COMP)[endpoint]
let top = v(TOP)[endpoint]
let decision = 0
if cmp >= 0.9
let code = trial
let decision = 1
end
echo 253 4 $&trial $&cmp $&top 1.17421875 $&decision >> decisions.csv
let trial = code + 8
let drive = (floor(trial / 1) - 2*floor(trial / 2))*1.8
alter VB0 = $&drive
let drive = (floor(trial / 2) - 2*floor(trial / 4))*1.8
alter VB1 = $&drive
let drive = (floor(trial / 4) - 2*floor(trial / 8))*1.8
alter VB2 = $&drive
let drive = (floor(trial / 8) - 2*floor(trial / 16))*1.8
alter VB3 = $&drive
let drive = (floor(trial / 16) - 2*floor(trial / 32))*1.8
alter VB4 = $&drive
let drive = (floor(trial / 32) - 2*floor(trial / 64))*1.8
alter VB5 = $&drive
let drive = (floor(trial / 64) - 2*floor(trial / 128))*1.8
alter VB6 = $&drive
let drive = (floor(trial / 128) - 2*floor(trial / 256))*1.8
alter VB7 = $&drive
stop when time = 0.004566
resume
delete all
let endpoint = length(time)-1
let cmp = v(COMP)[endpoint]
let top = v(TOP)[endpoint]
let decision = 0
if cmp >= 0.9
let code = trial
let decision = 1
end
echo 253 3 $&trial $&cmp $&top 1.17421875 $&decision >> decisions.csv
let trial = code + 4
let drive = (floor(trial / 1) - 2*floor(trial / 2))*1.8
alter VB0 = $&drive
let drive = (floor(trial / 2) - 2*floor(trial / 4))*1.8
alter VB1 = $&drive
let drive = (floor(trial / 4) - 2*floor(trial / 8))*1.8
alter VB2 = $&drive
let drive = (floor(trial / 8) - 2*floor(trial / 16))*1.8
alter VB3 = $&drive
let drive = (floor(trial / 16) - 2*floor(trial / 32))*1.8
alter VB4 = $&drive
let drive = (floor(trial / 32) - 2*floor(trial / 64))*1.8
alter VB5 = $&drive
let drive = (floor(trial / 64) - 2*floor(trial / 128))*1.8
alter VB6 = $&drive
let drive = (floor(trial / 128) - 2*floor(trial / 256))*1.8
alter VB7 = $&drive
stop when time = 0.004568
resume
delete all
let endpoint = length(time)-1
let cmp = v(COMP)[endpoint]
let top = v(TOP)[endpoint]
let decision = 0
if cmp >= 0.9
let code = trial
let decision = 1
end
echo 253 2 $&trial $&cmp $&top 1.17421875 $&decision >> decisions.csv
let trial = code + 2
let drive = (floor(trial / 1) - 2*floor(trial / 2))*1.8
alter VB0 = $&drive
let drive = (floor(trial / 2) - 2*floor(trial / 4))*1.8
alter VB1 = $&drive
let drive = (floor(trial / 4) - 2*floor(trial / 8))*1.8
alter VB2 = $&drive
let drive = (floor(trial / 8) - 2*floor(trial / 16))*1.8
alter VB3 = $&drive
let drive = (floor(trial / 16) - 2*floor(trial / 32))*1.8
alter VB4 = $&drive
let drive = (floor(trial / 32) - 2*floor(trial / 64))*1.8
alter VB5 = $&drive
let drive = (floor(trial / 64) - 2*floor(trial / 128))*1.8
alter VB6 = $&drive
let drive = (floor(trial / 128) - 2*floor(trial / 256))*1.8
alter VB7 = $&drive
stop when time = 0.00457
resume
delete all
let endpoint = length(time)-1
let cmp = v(COMP)[endpoint]
let top = v(TOP)[endpoint]
let decision = 0
if cmp >= 0.9
let code = trial
let decision = 1
end
echo 253 1 $&trial $&cmp $&top 1.17421875 $&decision >> decisions.csv
let trial = code + 1
let drive = (floor(trial / 1) - 2*floor(trial / 2))*1.8
alter VB0 = $&drive
let drive = (floor(trial / 2) - 2*floor(trial / 4))*1.8
alter VB1 = $&drive
let drive = (floor(trial / 4) - 2*floor(trial / 8))*1.8
alter VB2 = $&drive
let drive = (floor(trial / 8) - 2*floor(trial / 16))*1.8
alter VB3 = $&drive
let drive = (floor(trial / 16) - 2*floor(trial / 32))*1.8
alter VB4 = $&drive
let drive = (floor(trial / 32) - 2*floor(trial / 64))*1.8
alter VB5 = $&drive
let drive = (floor(trial / 64) - 2*floor(trial / 128))*1.8
alter VB6 = $&drive
let drive = (floor(trial / 128) - 2*floor(trial / 256))*1.8
alter VB7 = $&drive
stop when time = 0.004572
resume
delete all
let endpoint = length(time)-1
let cmp = v(COMP)[endpoint]
let top = v(TOP)[endpoint]
let decision = 0
if cmp >= 0.9
let code = trial
let decision = 1
end
echo 253 0 $&trial $&cmp $&top 1.17421875 $&decision >> decisions.csv
alter VIN = 1.17890625
alter VSAMPLE = 1.8
alter VB0 = 0
alter VB1 = 0
alter VB2 = 0
alter VB3 = 0
alter VB4 = 0
alter VB5 = 0
alter VB6 = 0
alter VB7 = 0
let code = 0
stop when time = 0.004574
resume
delete all
alter VSAMPLE = 0
let trial = code + 128
let drive = (floor(trial / 1) - 2*floor(trial / 2))*1.8
alter VB0 = $&drive
let drive = (floor(trial / 2) - 2*floor(trial / 4))*1.8
alter VB1 = $&drive
let drive = (floor(trial / 4) - 2*floor(trial / 8))*1.8
alter VB2 = $&drive
let drive = (floor(trial / 8) - 2*floor(trial / 16))*1.8
alter VB3 = $&drive
let drive = (floor(trial / 16) - 2*floor(trial / 32))*1.8
alter VB4 = $&drive
let drive = (floor(trial / 32) - 2*floor(trial / 64))*1.8
alter VB5 = $&drive
let drive = (floor(trial / 64) - 2*floor(trial / 128))*1.8
alter VB6 = $&drive
let drive = (floor(trial / 128) - 2*floor(trial / 256))*1.8
alter VB7 = $&drive
stop when time = 0.004576
resume
delete all
let endpoint = length(time)-1
let cmp = v(COMP)[endpoint]
let top = v(TOP)[endpoint]
let decision = 0
if cmp >= 0.9
let code = trial
let decision = 1
end
echo 254 7 $&trial $&cmp $&top 1.17890625 $&decision >> decisions.csv
let trial = code + 64
let drive = (floor(trial / 1) - 2*floor(trial / 2))*1.8
alter VB0 = $&drive
let drive = (floor(trial / 2) - 2*floor(trial / 4))*1.8
alter VB1 = $&drive
let drive = (floor(trial / 4) - 2*floor(trial / 8))*1.8
alter VB2 = $&drive
let drive = (floor(trial / 8) - 2*floor(trial / 16))*1.8
alter VB3 = $&drive
let drive = (floor(trial / 16) - 2*floor(trial / 32))*1.8
alter VB4 = $&drive
let drive = (floor(trial / 32) - 2*floor(trial / 64))*1.8
alter VB5 = $&drive
let drive = (floor(trial / 64) - 2*floor(trial / 128))*1.8
alter VB6 = $&drive
let drive = (floor(trial / 128) - 2*floor(trial / 256))*1.8
alter VB7 = $&drive
stop when time = 0.004578
resume
delete all
let endpoint = length(time)-1
let cmp = v(COMP)[endpoint]
let top = v(TOP)[endpoint]
let decision = 0
if cmp >= 0.9
let code = trial
let decision = 1
end
echo 254 6 $&trial $&cmp $&top 1.17890625 $&decision >> decisions.csv
let trial = code + 32
let drive = (floor(trial / 1) - 2*floor(trial / 2))*1.8
alter VB0 = $&drive
let drive = (floor(trial / 2) - 2*floor(trial / 4))*1.8
alter VB1 = $&drive
let drive = (floor(trial / 4) - 2*floor(trial / 8))*1.8
alter VB2 = $&drive
let drive = (floor(trial / 8) - 2*floor(trial / 16))*1.8
alter VB3 = $&drive
let drive = (floor(trial / 16) - 2*floor(trial / 32))*1.8
alter VB4 = $&drive
let drive = (floor(trial / 32) - 2*floor(trial / 64))*1.8
alter VB5 = $&drive
let drive = (floor(trial / 64) - 2*floor(trial / 128))*1.8
alter VB6 = $&drive
let drive = (floor(trial / 128) - 2*floor(trial / 256))*1.8
alter VB7 = $&drive
stop when time = 0.00458
resume
delete all
let endpoint = length(time)-1
let cmp = v(COMP)[endpoint]
let top = v(TOP)[endpoint]
let decision = 0
if cmp >= 0.9
let code = trial
let decision = 1
end
echo 254 5 $&trial $&cmp $&top 1.17890625 $&decision >> decisions.csv
let trial = code + 16
let drive = (floor(trial / 1) - 2*floor(trial / 2))*1.8
alter VB0 = $&drive
let drive = (floor(trial / 2) - 2*floor(trial / 4))*1.8
alter VB1 = $&drive
let drive = (floor(trial / 4) - 2*floor(trial / 8))*1.8
alter VB2 = $&drive
let drive = (floor(trial / 8) - 2*floor(trial / 16))*1.8
alter VB3 = $&drive
let drive = (floor(trial / 16) - 2*floor(trial / 32))*1.8
alter VB4 = $&drive
let drive = (floor(trial / 32) - 2*floor(trial / 64))*1.8
alter VB5 = $&drive
let drive = (floor(trial / 64) - 2*floor(trial / 128))*1.8
alter VB6 = $&drive
let drive = (floor(trial / 128) - 2*floor(trial / 256))*1.8
alter VB7 = $&drive
stop when time = 0.004582
resume
delete all
let endpoint = length(time)-1
let cmp = v(COMP)[endpoint]
let top = v(TOP)[endpoint]
let decision = 0
if cmp >= 0.9
let code = trial
let decision = 1
end
echo 254 4 $&trial $&cmp $&top 1.17890625 $&decision >> decisions.csv
let trial = code + 8
let drive = (floor(trial / 1) - 2*floor(trial / 2))*1.8
alter VB0 = $&drive
let drive = (floor(trial / 2) - 2*floor(trial / 4))*1.8
alter VB1 = $&drive
let drive = (floor(trial / 4) - 2*floor(trial / 8))*1.8
alter VB2 = $&drive
let drive = (floor(trial / 8) - 2*floor(trial / 16))*1.8
alter VB3 = $&drive
let drive = (floor(trial / 16) - 2*floor(trial / 32))*1.8
alter VB4 = $&drive
let drive = (floor(trial / 32) - 2*floor(trial / 64))*1.8
alter VB5 = $&drive
let drive = (floor(trial / 64) - 2*floor(trial / 128))*1.8
alter VB6 = $&drive
let drive = (floor(trial / 128) - 2*floor(trial / 256))*1.8
alter VB7 = $&drive
stop when time = 0.004584
resume
delete all
let endpoint = length(time)-1
let cmp = v(COMP)[endpoint]
let top = v(TOP)[endpoint]
let decision = 0
if cmp >= 0.9
let code = trial
let decision = 1
end
echo 254 3 $&trial $&cmp $&top 1.17890625 $&decision >> decisions.csv
let trial = code + 4
let drive = (floor(trial / 1) - 2*floor(trial / 2))*1.8
alter VB0 = $&drive
let drive = (floor(trial / 2) - 2*floor(trial / 4))*1.8
alter VB1 = $&drive
let drive = (floor(trial / 4) - 2*floor(trial / 8))*1.8
alter VB2 = $&drive
let drive = (floor(trial / 8) - 2*floor(trial / 16))*1.8
alter VB3 = $&drive
let drive = (floor(trial / 16) - 2*floor(trial / 32))*1.8
alter VB4 = $&drive
let drive = (floor(trial / 32) - 2*floor(trial / 64))*1.8
alter VB5 = $&drive
let drive = (floor(trial / 64) - 2*floor(trial / 128))*1.8
alter VB6 = $&drive
let drive = (floor(trial / 128) - 2*floor(trial / 256))*1.8
alter VB7 = $&drive
stop when time = 0.004586
resume
delete all
let endpoint = length(time)-1
let cmp = v(COMP)[endpoint]
let top = v(TOP)[endpoint]
let decision = 0
if cmp >= 0.9
let code = trial
let decision = 1
end
echo 254 2 $&trial $&cmp $&top 1.17890625 $&decision >> decisions.csv
let trial = code + 2
let drive = (floor(trial / 1) - 2*floor(trial / 2))*1.8
alter VB0 = $&drive
let drive = (floor(trial / 2) - 2*floor(trial / 4))*1.8
alter VB1 = $&drive
let drive = (floor(trial / 4) - 2*floor(trial / 8))*1.8
alter VB2 = $&drive
let drive = (floor(trial / 8) - 2*floor(trial / 16))*1.8
alter VB3 = $&drive
let drive = (floor(trial / 16) - 2*floor(trial / 32))*1.8
alter VB4 = $&drive
let drive = (floor(trial / 32) - 2*floor(trial / 64))*1.8
alter VB5 = $&drive
let drive = (floor(trial / 64) - 2*floor(trial / 128))*1.8
alter VB6 = $&drive
let drive = (floor(trial / 128) - 2*floor(trial / 256))*1.8
alter VB7 = $&drive
stop when time = 0.004588
resume
delete all
let endpoint = length(time)-1
let cmp = v(COMP)[endpoint]
let top = v(TOP)[endpoint]
let decision = 0
if cmp >= 0.9
let code = trial
let decision = 1
end
echo 254 1 $&trial $&cmp $&top 1.17890625 $&decision >> decisions.csv
let trial = code + 1
let drive = (floor(trial / 1) - 2*floor(trial / 2))*1.8
alter VB0 = $&drive
let drive = (floor(trial / 2) - 2*floor(trial / 4))*1.8
alter VB1 = $&drive
let drive = (floor(trial / 4) - 2*floor(trial / 8))*1.8
alter VB2 = $&drive
let drive = (floor(trial / 8) - 2*floor(trial / 16))*1.8
alter VB3 = $&drive
let drive = (floor(trial / 16) - 2*floor(trial / 32))*1.8
alter VB4 = $&drive
let drive = (floor(trial / 32) - 2*floor(trial / 64))*1.8
alter VB5 = $&drive
let drive = (floor(trial / 64) - 2*floor(trial / 128))*1.8
alter VB6 = $&drive
let drive = (floor(trial / 128) - 2*floor(trial / 256))*1.8
alter VB7 = $&drive
stop when time = 0.00459
resume
delete all
let endpoint = length(time)-1
let cmp = v(COMP)[endpoint]
let top = v(TOP)[endpoint]
let decision = 0
if cmp >= 0.9
let code = trial
let decision = 1
end
echo 254 0 $&trial $&cmp $&top 1.17890625 $&decision >> decisions.csv
alter VIN = 1.18359375
alter VSAMPLE = 1.8
alter VB0 = 0
alter VB1 = 0
alter VB2 = 0
alter VB3 = 0
alter VB4 = 0
alter VB5 = 0
alter VB6 = 0
alter VB7 = 0
let code = 0
stop when time = 0.004592
resume
delete all
alter VSAMPLE = 0
let trial = code + 128
let drive = (floor(trial / 1) - 2*floor(trial / 2))*1.8
alter VB0 = $&drive
let drive = (floor(trial / 2) - 2*floor(trial / 4))*1.8
alter VB1 = $&drive
let drive = (floor(trial / 4) - 2*floor(trial / 8))*1.8
alter VB2 = $&drive
let drive = (floor(trial / 8) - 2*floor(trial / 16))*1.8
alter VB3 = $&drive
let drive = (floor(trial / 16) - 2*floor(trial / 32))*1.8
alter VB4 = $&drive
let drive = (floor(trial / 32) - 2*floor(trial / 64))*1.8
alter VB5 = $&drive
let drive = (floor(trial / 64) - 2*floor(trial / 128))*1.8
alter VB6 = $&drive
let drive = (floor(trial / 128) - 2*floor(trial / 256))*1.8
alter VB7 = $&drive
stop when time = 0.004594
resume
delete all
let endpoint = length(time)-1
let cmp = v(COMP)[endpoint]
let top = v(TOP)[endpoint]
let decision = 0
if cmp >= 0.9
let code = trial
let decision = 1
end
echo 255 7 $&trial $&cmp $&top 1.18359375 $&decision >> decisions.csv
let trial = code + 64
let drive = (floor(trial / 1) - 2*floor(trial / 2))*1.8
alter VB0 = $&drive
let drive = (floor(trial / 2) - 2*floor(trial / 4))*1.8
alter VB1 = $&drive
let drive = (floor(trial / 4) - 2*floor(trial / 8))*1.8
alter VB2 = $&drive
let drive = (floor(trial / 8) - 2*floor(trial / 16))*1.8
alter VB3 = $&drive
let drive = (floor(trial / 16) - 2*floor(trial / 32))*1.8
alter VB4 = $&drive
let drive = (floor(trial / 32) - 2*floor(trial / 64))*1.8
alter VB5 = $&drive
let drive = (floor(trial / 64) - 2*floor(trial / 128))*1.8
alter VB6 = $&drive
let drive = (floor(trial / 128) - 2*floor(trial / 256))*1.8
alter VB7 = $&drive
stop when time = 0.004596
resume
delete all
let endpoint = length(time)-1
let cmp = v(COMP)[endpoint]
let top = v(TOP)[endpoint]
let decision = 0
if cmp >= 0.9
let code = trial
let decision = 1
end
echo 255 6 $&trial $&cmp $&top 1.18359375 $&decision >> decisions.csv
let trial = code + 32
let drive = (floor(trial / 1) - 2*floor(trial / 2))*1.8
alter VB0 = $&drive
let drive = (floor(trial / 2) - 2*floor(trial / 4))*1.8
alter VB1 = $&drive
let drive = (floor(trial / 4) - 2*floor(trial / 8))*1.8
alter VB2 = $&drive
let drive = (floor(trial / 8) - 2*floor(trial / 16))*1.8
alter VB3 = $&drive
let drive = (floor(trial / 16) - 2*floor(trial / 32))*1.8
alter VB4 = $&drive
let drive = (floor(trial / 32) - 2*floor(trial / 64))*1.8
alter VB5 = $&drive
let drive = (floor(trial / 64) - 2*floor(trial / 128))*1.8
alter VB6 = $&drive
let drive = (floor(trial / 128) - 2*floor(trial / 256))*1.8
alter VB7 = $&drive
stop when time = 0.004598
resume
delete all
let endpoint = length(time)-1
let cmp = v(COMP)[endpoint]
let top = v(TOP)[endpoint]
let decision = 0
if cmp >= 0.9
let code = trial
let decision = 1
end
echo 255 5 $&trial $&cmp $&top 1.18359375 $&decision >> decisions.csv
let trial = code + 16
let drive = (floor(trial / 1) - 2*floor(trial / 2))*1.8
alter VB0 = $&drive
let drive = (floor(trial / 2) - 2*floor(trial / 4))*1.8
alter VB1 = $&drive
let drive = (floor(trial / 4) - 2*floor(trial / 8))*1.8
alter VB2 = $&drive
let drive = (floor(trial / 8) - 2*floor(trial / 16))*1.8
alter VB3 = $&drive
let drive = (floor(trial / 16) - 2*floor(trial / 32))*1.8
alter VB4 = $&drive
let drive = (floor(trial / 32) - 2*floor(trial / 64))*1.8
alter VB5 = $&drive
let drive = (floor(trial / 64) - 2*floor(trial / 128))*1.8
alter VB6 = $&drive
let drive = (floor(trial / 128) - 2*floor(trial / 256))*1.8
alter VB7 = $&drive
stop when time = 0.0046
resume
delete all
let endpoint = length(time)-1
let cmp = v(COMP)[endpoint]
let top = v(TOP)[endpoint]
let decision = 0
if cmp >= 0.9
let code = trial
let decision = 1
end
echo 255 4 $&trial $&cmp $&top 1.18359375 $&decision >> decisions.csv
let trial = code + 8
let drive = (floor(trial / 1) - 2*floor(trial / 2))*1.8
alter VB0 = $&drive
let drive = (floor(trial / 2) - 2*floor(trial / 4))*1.8
alter VB1 = $&drive
let drive = (floor(trial / 4) - 2*floor(trial / 8))*1.8
alter VB2 = $&drive
let drive = (floor(trial / 8) - 2*floor(trial / 16))*1.8
alter VB3 = $&drive
let drive = (floor(trial / 16) - 2*floor(trial / 32))*1.8
alter VB4 = $&drive
let drive = (floor(trial / 32) - 2*floor(trial / 64))*1.8
alter VB5 = $&drive
let drive = (floor(trial / 64) - 2*floor(trial / 128))*1.8
alter VB6 = $&drive
let drive = (floor(trial / 128) - 2*floor(trial / 256))*1.8
alter VB7 = $&drive
stop when time = 0.004602
resume
delete all
let endpoint = length(time)-1
let cmp = v(COMP)[endpoint]
let top = v(TOP)[endpoint]
let decision = 0
if cmp >= 0.9
let code = trial
let decision = 1
end
echo 255 3 $&trial $&cmp $&top 1.18359375 $&decision >> decisions.csv
let trial = code + 4
let drive = (floor(trial / 1) - 2*floor(trial / 2))*1.8
alter VB0 = $&drive
let drive = (floor(trial / 2) - 2*floor(trial / 4))*1.8
alter VB1 = $&drive
let drive = (floor(trial / 4) - 2*floor(trial / 8))*1.8
alter VB2 = $&drive
let drive = (floor(trial / 8) - 2*floor(trial / 16))*1.8
alter VB3 = $&drive
let drive = (floor(trial / 16) - 2*floor(trial / 32))*1.8
alter VB4 = $&drive
let drive = (floor(trial / 32) - 2*floor(trial / 64))*1.8
alter VB5 = $&drive
let drive = (floor(trial / 64) - 2*floor(trial / 128))*1.8
alter VB6 = $&drive
let drive = (floor(trial / 128) - 2*floor(trial / 256))*1.8
alter VB7 = $&drive
stop when time = 0.004604
resume
delete all
let endpoint = length(time)-1
let cmp = v(COMP)[endpoint]
let top = v(TOP)[endpoint]
let decision = 0
if cmp >= 0.9
let code = trial
let decision = 1
end
echo 255 2 $&trial $&cmp $&top 1.18359375 $&decision >> decisions.csv
let trial = code + 2
let drive = (floor(trial / 1) - 2*floor(trial / 2))*1.8
alter VB0 = $&drive
let drive = (floor(trial / 2) - 2*floor(trial / 4))*1.8
alter VB1 = $&drive
let drive = (floor(trial / 4) - 2*floor(trial / 8))*1.8
alter VB2 = $&drive
let drive = (floor(trial / 8) - 2*floor(trial / 16))*1.8
alter VB3 = $&drive
let drive = (floor(trial / 16) - 2*floor(trial / 32))*1.8
alter VB4 = $&drive
let drive = (floor(trial / 32) - 2*floor(trial / 64))*1.8
alter VB5 = $&drive
let drive = (floor(trial / 64) - 2*floor(trial / 128))*1.8
alter VB6 = $&drive
let drive = (floor(trial / 128) - 2*floor(trial / 256))*1.8
alter VB7 = $&drive
stop when time = 0.004606
resume
delete all
let endpoint = length(time)-1
let cmp = v(COMP)[endpoint]
let top = v(TOP)[endpoint]
let decision = 0
if cmp >= 0.9
let code = trial
let decision = 1
end
echo 255 1 $&trial $&cmp $&top 1.18359375 $&decision >> decisions.csv
let trial = code + 1
let drive = (floor(trial / 1) - 2*floor(trial / 2))*1.8
alter VB0 = $&drive
let drive = (floor(trial / 2) - 2*floor(trial / 4))*1.8
alter VB1 = $&drive
let drive = (floor(trial / 4) - 2*floor(trial / 8))*1.8
alter VB2 = $&drive
let drive = (floor(trial / 8) - 2*floor(trial / 16))*1.8
alter VB3 = $&drive
let drive = (floor(trial / 16) - 2*floor(trial / 32))*1.8
alter VB4 = $&drive
let drive = (floor(trial / 32) - 2*floor(trial / 64))*1.8
alter VB5 = $&drive
let drive = (floor(trial / 64) - 2*floor(trial / 128))*1.8
alter VB6 = $&drive
let drive = (floor(trial / 128) - 2*floor(trial / 256))*1.8
alter VB7 = $&drive
stop when time = 0.004608
resume
delete all
let endpoint = length(time)-1
let cmp = v(COMP)[endpoint]
let top = v(TOP)[endpoint]
let decision = 0
if cmp >= 0.9
let code = trial
let decision = 1
end
echo 255 0 $&trial $&cmp $&top 1.18359375 $&decision >> decisions.csv
alter VIN = 1.18828125
alter VSAMPLE = 1.8
alter VB0 = 0
alter VB1 = 0
alter VB2 = 0
alter VB3 = 0
alter VB4 = 0
alter VB5 = 0
alter VB6 = 0
alter VB7 = 0
let code = 0
stop when time = 0.00461
resume
delete all
alter VSAMPLE = 0
let trial = code + 128
let drive = (floor(trial / 1) - 2*floor(trial / 2))*1.8
alter VB0 = $&drive
let drive = (floor(trial / 2) - 2*floor(trial / 4))*1.8
alter VB1 = $&drive
let drive = (floor(trial / 4) - 2*floor(trial / 8))*1.8
alter VB2 = $&drive
let drive = (floor(trial / 8) - 2*floor(trial / 16))*1.8
alter VB3 = $&drive
let drive = (floor(trial / 16) - 2*floor(trial / 32))*1.8
alter VB4 = $&drive
let drive = (floor(trial / 32) - 2*floor(trial / 64))*1.8
alter VB5 = $&drive
let drive = (floor(trial / 64) - 2*floor(trial / 128))*1.8
alter VB6 = $&drive
let drive = (floor(trial / 128) - 2*floor(trial / 256))*1.8
alter VB7 = $&drive
stop when time = 0.004612
resume
delete all
let endpoint = length(time)-1
let cmp = v(COMP)[endpoint]
let top = v(TOP)[endpoint]
let decision = 0
if cmp >= 0.9
let code = trial
let decision = 1
end
echo 256 7 $&trial $&cmp $&top 1.18828125 $&decision >> decisions.csv
let trial = code + 64
let drive = (floor(trial / 1) - 2*floor(trial / 2))*1.8
alter VB0 = $&drive
let drive = (floor(trial / 2) - 2*floor(trial / 4))*1.8
alter VB1 = $&drive
let drive = (floor(trial / 4) - 2*floor(trial / 8))*1.8
alter VB2 = $&drive
let drive = (floor(trial / 8) - 2*floor(trial / 16))*1.8
alter VB3 = $&drive
let drive = (floor(trial / 16) - 2*floor(trial / 32))*1.8
alter VB4 = $&drive
let drive = (floor(trial / 32) - 2*floor(trial / 64))*1.8
alter VB5 = $&drive
let drive = (floor(trial / 64) - 2*floor(trial / 128))*1.8
alter VB6 = $&drive
let drive = (floor(trial / 128) - 2*floor(trial / 256))*1.8
alter VB7 = $&drive
stop when time = 0.004614
resume
delete all
let endpoint = length(time)-1
let cmp = v(COMP)[endpoint]
let top = v(TOP)[endpoint]
let decision = 0
if cmp >= 0.9
let code = trial
let decision = 1
end
echo 256 6 $&trial $&cmp $&top 1.18828125 $&decision >> decisions.csv
let trial = code + 32
let drive = (floor(trial / 1) - 2*floor(trial / 2))*1.8
alter VB0 = $&drive
let drive = (floor(trial / 2) - 2*floor(trial / 4))*1.8
alter VB1 = $&drive
let drive = (floor(trial / 4) - 2*floor(trial / 8))*1.8
alter VB2 = $&drive
let drive = (floor(trial / 8) - 2*floor(trial / 16))*1.8
alter VB3 = $&drive
let drive = (floor(trial / 16) - 2*floor(trial / 32))*1.8
alter VB4 = $&drive
let drive = (floor(trial / 32) - 2*floor(trial / 64))*1.8
alter VB5 = $&drive
let drive = (floor(trial / 64) - 2*floor(trial / 128))*1.8
alter VB6 = $&drive
let drive = (floor(trial / 128) - 2*floor(trial / 256))*1.8
alter VB7 = $&drive
stop when time = 0.004616
resume
delete all
let endpoint = length(time)-1
let cmp = v(COMP)[endpoint]
let top = v(TOP)[endpoint]
let decision = 0
if cmp >= 0.9
let code = trial
let decision = 1
end
echo 256 5 $&trial $&cmp $&top 1.18828125 $&decision >> decisions.csv
let trial = code + 16
let drive = (floor(trial / 1) - 2*floor(trial / 2))*1.8
alter VB0 = $&drive
let drive = (floor(trial / 2) - 2*floor(trial / 4))*1.8
alter VB1 = $&drive
let drive = (floor(trial / 4) - 2*floor(trial / 8))*1.8
alter VB2 = $&drive
let drive = (floor(trial / 8) - 2*floor(trial / 16))*1.8
alter VB3 = $&drive
let drive = (floor(trial / 16) - 2*floor(trial / 32))*1.8
alter VB4 = $&drive
let drive = (floor(trial / 32) - 2*floor(trial / 64))*1.8
alter VB5 = $&drive
let drive = (floor(trial / 64) - 2*floor(trial / 128))*1.8
alter VB6 = $&drive
let drive = (floor(trial / 128) - 2*floor(trial / 256))*1.8
alter VB7 = $&drive
stop when time = 0.004618
resume
delete all
let endpoint = length(time)-1
let cmp = v(COMP)[endpoint]
let top = v(TOP)[endpoint]
let decision = 0
if cmp >= 0.9
let code = trial
let decision = 1
end
echo 256 4 $&trial $&cmp $&top 1.18828125 $&decision >> decisions.csv
let trial = code + 8
let drive = (floor(trial / 1) - 2*floor(trial / 2))*1.8
alter VB0 = $&drive
let drive = (floor(trial / 2) - 2*floor(trial / 4))*1.8
alter VB1 = $&drive
let drive = (floor(trial / 4) - 2*floor(trial / 8))*1.8
alter VB2 = $&drive
let drive = (floor(trial / 8) - 2*floor(trial / 16))*1.8
alter VB3 = $&drive
let drive = (floor(trial / 16) - 2*floor(trial / 32))*1.8
alter VB4 = $&drive
let drive = (floor(trial / 32) - 2*floor(trial / 64))*1.8
alter VB5 = $&drive
let drive = (floor(trial / 64) - 2*floor(trial / 128))*1.8
alter VB6 = $&drive
let drive = (floor(trial / 128) - 2*floor(trial / 256))*1.8
alter VB7 = $&drive
stop when time = 0.00462
resume
delete all
let endpoint = length(time)-1
let cmp = v(COMP)[endpoint]
let top = v(TOP)[endpoint]
let decision = 0
if cmp >= 0.9
let code = trial
let decision = 1
end
echo 256 3 $&trial $&cmp $&top 1.18828125 $&decision >> decisions.csv
let trial = code + 4
let drive = (floor(trial / 1) - 2*floor(trial / 2))*1.8
alter VB0 = $&drive
let drive = (floor(trial / 2) - 2*floor(trial / 4))*1.8
alter VB1 = $&drive
let drive = (floor(trial / 4) - 2*floor(trial / 8))*1.8
alter VB2 = $&drive
let drive = (floor(trial / 8) - 2*floor(trial / 16))*1.8
alter VB3 = $&drive
let drive = (floor(trial / 16) - 2*floor(trial / 32))*1.8
alter VB4 = $&drive
let drive = (floor(trial / 32) - 2*floor(trial / 64))*1.8
alter VB5 = $&drive
let drive = (floor(trial / 64) - 2*floor(trial / 128))*1.8
alter VB6 = $&drive
let drive = (floor(trial / 128) - 2*floor(trial / 256))*1.8
alter VB7 = $&drive
stop when time = 0.004622
resume
delete all
let endpoint = length(time)-1
let cmp = v(COMP)[endpoint]
let top = v(TOP)[endpoint]
let decision = 0
if cmp >= 0.9
let code = trial
let decision = 1
end
echo 256 2 $&trial $&cmp $&top 1.18828125 $&decision >> decisions.csv
let trial = code + 2
let drive = (floor(trial / 1) - 2*floor(trial / 2))*1.8
alter VB0 = $&drive
let drive = (floor(trial / 2) - 2*floor(trial / 4))*1.8
alter VB1 = $&drive
let drive = (floor(trial / 4) - 2*floor(trial / 8))*1.8
alter VB2 = $&drive
let drive = (floor(trial / 8) - 2*floor(trial / 16))*1.8
alter VB3 = $&drive
let drive = (floor(trial / 16) - 2*floor(trial / 32))*1.8
alter VB4 = $&drive
let drive = (floor(trial / 32) - 2*floor(trial / 64))*1.8
alter VB5 = $&drive
let drive = (floor(trial / 64) - 2*floor(trial / 128))*1.8
alter VB6 = $&drive
let drive = (floor(trial / 128) - 2*floor(trial / 256))*1.8
alter VB7 = $&drive
stop when time = 0.004624
resume
delete all
let endpoint = length(time)-1
let cmp = v(COMP)[endpoint]
let top = v(TOP)[endpoint]
let decision = 0
if cmp >= 0.9
let code = trial
let decision = 1
end
echo 256 1 $&trial $&cmp $&top 1.18828125 $&decision >> decisions.csv
let trial = code + 1
let drive = (floor(trial / 1) - 2*floor(trial / 2))*1.8
alter VB0 = $&drive
let drive = (floor(trial / 2) - 2*floor(trial / 4))*1.8
alter VB1 = $&drive
let drive = (floor(trial / 4) - 2*floor(trial / 8))*1.8
alter VB2 = $&drive
let drive = (floor(trial / 8) - 2*floor(trial / 16))*1.8
alter VB3 = $&drive
let drive = (floor(trial / 16) - 2*floor(trial / 32))*1.8
alter VB4 = $&drive
let drive = (floor(trial / 32) - 2*floor(trial / 64))*1.8
alter VB5 = $&drive
let drive = (floor(trial / 64) - 2*floor(trial / 128))*1.8
alter VB6 = $&drive
let drive = (floor(trial / 128) - 2*floor(trial / 256))*1.8
alter VB7 = $&drive
stop when time = 0.004626
resume
delete all
let endpoint = length(time)-1
let cmp = v(COMP)[endpoint]
let top = v(TOP)[endpoint]
let decision = 0
if cmp >= 0.9
let code = trial
let decision = 1
end
echo 256 0 $&trial $&cmp $&top 1.18828125 $&decision >> decisions.csv
alter VIN = 1.19296875
alter VSAMPLE = 1.8
alter VB0 = 0
alter VB1 = 0
alter VB2 = 0
alter VB3 = 0
alter VB4 = 0
alter VB5 = 0
alter VB6 = 0
alter VB7 = 0
let code = 0
stop when time = 0.004628
resume
delete all
alter VSAMPLE = 0
let trial = code + 128
let drive = (floor(trial / 1) - 2*floor(trial / 2))*1.8
alter VB0 = $&drive
let drive = (floor(trial / 2) - 2*floor(trial / 4))*1.8
alter VB1 = $&drive
let drive = (floor(trial / 4) - 2*floor(trial / 8))*1.8
alter VB2 = $&drive
let drive = (floor(trial / 8) - 2*floor(trial / 16))*1.8
alter VB3 = $&drive
let drive = (floor(trial / 16) - 2*floor(trial / 32))*1.8
alter VB4 = $&drive
let drive = (floor(trial / 32) - 2*floor(trial / 64))*1.8
alter VB5 = $&drive
let drive = (floor(trial / 64) - 2*floor(trial / 128))*1.8
alter VB6 = $&drive
let drive = (floor(trial / 128) - 2*floor(trial / 256))*1.8
alter VB7 = $&drive
stop when time = 0.00463
resume
delete all
let endpoint = length(time)-1
let cmp = v(COMP)[endpoint]
let top = v(TOP)[endpoint]
let decision = 0
if cmp >= 0.9
let code = trial
let decision = 1
end
echo 257 7 $&trial $&cmp $&top 1.19296875 $&decision >> decisions.csv
let trial = code + 64
let drive = (floor(trial / 1) - 2*floor(trial / 2))*1.8
alter VB0 = $&drive
let drive = (floor(trial / 2) - 2*floor(trial / 4))*1.8
alter VB1 = $&drive
let drive = (floor(trial / 4) - 2*floor(trial / 8))*1.8
alter VB2 = $&drive
let drive = (floor(trial / 8) - 2*floor(trial / 16))*1.8
alter VB3 = $&drive
let drive = (floor(trial / 16) - 2*floor(trial / 32))*1.8
alter VB4 = $&drive
let drive = (floor(trial / 32) - 2*floor(trial / 64))*1.8
alter VB5 = $&drive
let drive = (floor(trial / 64) - 2*floor(trial / 128))*1.8
alter VB6 = $&drive
let drive = (floor(trial / 128) - 2*floor(trial / 256))*1.8
alter VB7 = $&drive
stop when time = 0.004632
resume
delete all
let endpoint = length(time)-1
let cmp = v(COMP)[endpoint]
let top = v(TOP)[endpoint]
let decision = 0
if cmp >= 0.9
let code = trial
let decision = 1
end
echo 257 6 $&trial $&cmp $&top 1.19296875 $&decision >> decisions.csv
let trial = code + 32
let drive = (floor(trial / 1) - 2*floor(trial / 2))*1.8
alter VB0 = $&drive
let drive = (floor(trial / 2) - 2*floor(trial / 4))*1.8
alter VB1 = $&drive
let drive = (floor(trial / 4) - 2*floor(trial / 8))*1.8
alter VB2 = $&drive
let drive = (floor(trial / 8) - 2*floor(trial / 16))*1.8
alter VB3 = $&drive
let drive = (floor(trial / 16) - 2*floor(trial / 32))*1.8
alter VB4 = $&drive
let drive = (floor(trial / 32) - 2*floor(trial / 64))*1.8
alter VB5 = $&drive
let drive = (floor(trial / 64) - 2*floor(trial / 128))*1.8
alter VB6 = $&drive
let drive = (floor(trial / 128) - 2*floor(trial / 256))*1.8
alter VB7 = $&drive
stop when time = 0.004634
resume
delete all
let endpoint = length(time)-1
let cmp = v(COMP)[endpoint]
let top = v(TOP)[endpoint]
let decision = 0
if cmp >= 0.9
let code = trial
let decision = 1
end
echo 257 5 $&trial $&cmp $&top 1.19296875 $&decision >> decisions.csv
let trial = code + 16
let drive = (floor(trial / 1) - 2*floor(trial / 2))*1.8
alter VB0 = $&drive
let drive = (floor(trial / 2) - 2*floor(trial / 4))*1.8
alter VB1 = $&drive
let drive = (floor(trial / 4) - 2*floor(trial / 8))*1.8
alter VB2 = $&drive
let drive = (floor(trial / 8) - 2*floor(trial / 16))*1.8
alter VB3 = $&drive
let drive = (floor(trial / 16) - 2*floor(trial / 32))*1.8
alter VB4 = $&drive
let drive = (floor(trial / 32) - 2*floor(trial / 64))*1.8
alter VB5 = $&drive
let drive = (floor(trial / 64) - 2*floor(trial / 128))*1.8
alter VB6 = $&drive
let drive = (floor(trial / 128) - 2*floor(trial / 256))*1.8
alter VB7 = $&drive
stop when time = 0.004636
resume
delete all
let endpoint = length(time)-1
let cmp = v(COMP)[endpoint]
let top = v(TOP)[endpoint]
let decision = 0
if cmp >= 0.9
let code = trial
let decision = 1
end
echo 257 4 $&trial $&cmp $&top 1.19296875 $&decision >> decisions.csv
let trial = code + 8
let drive = (floor(trial / 1) - 2*floor(trial / 2))*1.8
alter VB0 = $&drive
let drive = (floor(trial / 2) - 2*floor(trial / 4))*1.8
alter VB1 = $&drive
let drive = (floor(trial / 4) - 2*floor(trial / 8))*1.8
alter VB2 = $&drive
let drive = (floor(trial / 8) - 2*floor(trial / 16))*1.8
alter VB3 = $&drive
let drive = (floor(trial / 16) - 2*floor(trial / 32))*1.8
alter VB4 = $&drive
let drive = (floor(trial / 32) - 2*floor(trial / 64))*1.8
alter VB5 = $&drive
let drive = (floor(trial / 64) - 2*floor(trial / 128))*1.8
alter VB6 = $&drive
let drive = (floor(trial / 128) - 2*floor(trial / 256))*1.8
alter VB7 = $&drive
stop when time = 0.004638
resume
delete all
let endpoint = length(time)-1
let cmp = v(COMP)[endpoint]
let top = v(TOP)[endpoint]
let decision = 0
if cmp >= 0.9
let code = trial
let decision = 1
end
echo 257 3 $&trial $&cmp $&top 1.19296875 $&decision >> decisions.csv
let trial = code + 4
let drive = (floor(trial / 1) - 2*floor(trial / 2))*1.8
alter VB0 = $&drive
let drive = (floor(trial / 2) - 2*floor(trial / 4))*1.8
alter VB1 = $&drive
let drive = (floor(trial / 4) - 2*floor(trial / 8))*1.8
alter VB2 = $&drive
let drive = (floor(trial / 8) - 2*floor(trial / 16))*1.8
alter VB3 = $&drive
let drive = (floor(trial / 16) - 2*floor(trial / 32))*1.8
alter VB4 = $&drive
let drive = (floor(trial / 32) - 2*floor(trial / 64))*1.8
alter VB5 = $&drive
let drive = (floor(trial / 64) - 2*floor(trial / 128))*1.8
alter VB6 = $&drive
let drive = (floor(trial / 128) - 2*floor(trial / 256))*1.8
alter VB7 = $&drive
stop when time = 0.00464
resume
delete all
let endpoint = length(time)-1
let cmp = v(COMP)[endpoint]
let top = v(TOP)[endpoint]
let decision = 0
if cmp >= 0.9
let code = trial
let decision = 1
end
echo 257 2 $&trial $&cmp $&top 1.19296875 $&decision >> decisions.csv
let trial = code + 2
let drive = (floor(trial / 1) - 2*floor(trial / 2))*1.8
alter VB0 = $&drive
let drive = (floor(trial / 2) - 2*floor(trial / 4))*1.8
alter VB1 = $&drive
let drive = (floor(trial / 4) - 2*floor(trial / 8))*1.8
alter VB2 = $&drive
let drive = (floor(trial / 8) - 2*floor(trial / 16))*1.8
alter VB3 = $&drive
let drive = (floor(trial / 16) - 2*floor(trial / 32))*1.8
alter VB4 = $&drive
let drive = (floor(trial / 32) - 2*floor(trial / 64))*1.8
alter VB5 = $&drive
let drive = (floor(trial / 64) - 2*floor(trial / 128))*1.8
alter VB6 = $&drive
let drive = (floor(trial / 128) - 2*floor(trial / 256))*1.8
alter VB7 = $&drive
stop when time = 0.004642
resume
delete all
let endpoint = length(time)-1
let cmp = v(COMP)[endpoint]
let top = v(TOP)[endpoint]
let decision = 0
if cmp >= 0.9
let code = trial
let decision = 1
end
echo 257 1 $&trial $&cmp $&top 1.19296875 $&decision >> decisions.csv
let trial = code + 1
let drive = (floor(trial / 1) - 2*floor(trial / 2))*1.8
alter VB0 = $&drive
let drive = (floor(trial / 2) - 2*floor(trial / 4))*1.8
alter VB1 = $&drive
let drive = (floor(trial / 4) - 2*floor(trial / 8))*1.8
alter VB2 = $&drive
let drive = (floor(trial / 8) - 2*floor(trial / 16))*1.8
alter VB3 = $&drive
let drive = (floor(trial / 16) - 2*floor(trial / 32))*1.8
alter VB4 = $&drive
let drive = (floor(trial / 32) - 2*floor(trial / 64))*1.8
alter VB5 = $&drive
let drive = (floor(trial / 64) - 2*floor(trial / 128))*1.8
alter VB6 = $&drive
let drive = (floor(trial / 128) - 2*floor(trial / 256))*1.8
alter VB7 = $&drive
stop when time = 0.004644
resume
delete all
let endpoint = length(time)-1
let cmp = v(COMP)[endpoint]
let top = v(TOP)[endpoint]
let decision = 0
if cmp >= 0.9
let code = trial
let decision = 1
end
echo 257 0 $&trial $&cmp $&top 1.19296875 $&decision >> decisions.csv
alter VIN = 1.19765625
alter VSAMPLE = 1.8
alter VB0 = 0
alter VB1 = 0
alter VB2 = 0
alter VB3 = 0
alter VB4 = 0
alter VB5 = 0
alter VB6 = 0
alter VB7 = 0
let code = 0
stop when time = 0.004646
resume
delete all
alter VSAMPLE = 0
let trial = code + 128
let drive = (floor(trial / 1) - 2*floor(trial / 2))*1.8
alter VB0 = $&drive
let drive = (floor(trial / 2) - 2*floor(trial / 4))*1.8
alter VB1 = $&drive
let drive = (floor(trial / 4) - 2*floor(trial / 8))*1.8
alter VB2 = $&drive
let drive = (floor(trial / 8) - 2*floor(trial / 16))*1.8
alter VB3 = $&drive
let drive = (floor(trial / 16) - 2*floor(trial / 32))*1.8
alter VB4 = $&drive
let drive = (floor(trial / 32) - 2*floor(trial / 64))*1.8
alter VB5 = $&drive
let drive = (floor(trial / 64) - 2*floor(trial / 128))*1.8
alter VB6 = $&drive
let drive = (floor(trial / 128) - 2*floor(trial / 256))*1.8
alter VB7 = $&drive
stop when time = 0.004648
resume
delete all
let endpoint = length(time)-1
let cmp = v(COMP)[endpoint]
let top = v(TOP)[endpoint]
let decision = 0
if cmp >= 0.9
let code = trial
let decision = 1
end
echo 258 7 $&trial $&cmp $&top 1.19765625 $&decision >> decisions.csv
let trial = code + 64
let drive = (floor(trial / 1) - 2*floor(trial / 2))*1.8
alter VB0 = $&drive
let drive = (floor(trial / 2) - 2*floor(trial / 4))*1.8
alter VB1 = $&drive
let drive = (floor(trial / 4) - 2*floor(trial / 8))*1.8
alter VB2 = $&drive
let drive = (floor(trial / 8) - 2*floor(trial / 16))*1.8
alter VB3 = $&drive
let drive = (floor(trial / 16) - 2*floor(trial / 32))*1.8
alter VB4 = $&drive
let drive = (floor(trial / 32) - 2*floor(trial / 64))*1.8
alter VB5 = $&drive
let drive = (floor(trial / 64) - 2*floor(trial / 128))*1.8
alter VB6 = $&drive
let drive = (floor(trial / 128) - 2*floor(trial / 256))*1.8
alter VB7 = $&drive
stop when time = 0.00465
resume
delete all
let endpoint = length(time)-1
let cmp = v(COMP)[endpoint]
let top = v(TOP)[endpoint]
let decision = 0
if cmp >= 0.9
let code = trial
let decision = 1
end
echo 258 6 $&trial $&cmp $&top 1.19765625 $&decision >> decisions.csv
let trial = code + 32
let drive = (floor(trial / 1) - 2*floor(trial / 2))*1.8
alter VB0 = $&drive
let drive = (floor(trial / 2) - 2*floor(trial / 4))*1.8
alter VB1 = $&drive
let drive = (floor(trial / 4) - 2*floor(trial / 8))*1.8
alter VB2 = $&drive
let drive = (floor(trial / 8) - 2*floor(trial / 16))*1.8
alter VB3 = $&drive
let drive = (floor(trial / 16) - 2*floor(trial / 32))*1.8
alter VB4 = $&drive
let drive = (floor(trial / 32) - 2*floor(trial / 64))*1.8
alter VB5 = $&drive
let drive = (floor(trial / 64) - 2*floor(trial / 128))*1.8
alter VB6 = $&drive
let drive = (floor(trial / 128) - 2*floor(trial / 256))*1.8
alter VB7 = $&drive
stop when time = 0.004652
resume
delete all
let endpoint = length(time)-1
let cmp = v(COMP)[endpoint]
let top = v(TOP)[endpoint]
let decision = 0
if cmp >= 0.9
let code = trial
let decision = 1
end
echo 258 5 $&trial $&cmp $&top 1.19765625 $&decision >> decisions.csv
let trial = code + 16
let drive = (floor(trial / 1) - 2*floor(trial / 2))*1.8
alter VB0 = $&drive
let drive = (floor(trial / 2) - 2*floor(trial / 4))*1.8
alter VB1 = $&drive
let drive = (floor(trial / 4) - 2*floor(trial / 8))*1.8
alter VB2 = $&drive
let drive = (floor(trial / 8) - 2*floor(trial / 16))*1.8
alter VB3 = $&drive
let drive = (floor(trial / 16) - 2*floor(trial / 32))*1.8
alter VB4 = $&drive
let drive = (floor(trial / 32) - 2*floor(trial / 64))*1.8
alter VB5 = $&drive
let drive = (floor(trial / 64) - 2*floor(trial / 128))*1.8
alter VB6 = $&drive
let drive = (floor(trial / 128) - 2*floor(trial / 256))*1.8
alter VB7 = $&drive
stop when time = 0.004654
resume
delete all
let endpoint = length(time)-1
let cmp = v(COMP)[endpoint]
let top = v(TOP)[endpoint]
let decision = 0
if cmp >= 0.9
let code = trial
let decision = 1
end
echo 258 4 $&trial $&cmp $&top 1.19765625 $&decision >> decisions.csv
let trial = code + 8
let drive = (floor(trial / 1) - 2*floor(trial / 2))*1.8
alter VB0 = $&drive
let drive = (floor(trial / 2) - 2*floor(trial / 4))*1.8
alter VB1 = $&drive
let drive = (floor(trial / 4) - 2*floor(trial / 8))*1.8
alter VB2 = $&drive
let drive = (floor(trial / 8) - 2*floor(trial / 16))*1.8
alter VB3 = $&drive
let drive = (floor(trial / 16) - 2*floor(trial / 32))*1.8
alter VB4 = $&drive
let drive = (floor(trial / 32) - 2*floor(trial / 64))*1.8
alter VB5 = $&drive
let drive = (floor(trial / 64) - 2*floor(trial / 128))*1.8
alter VB6 = $&drive
let drive = (floor(trial / 128) - 2*floor(trial / 256))*1.8
alter VB7 = $&drive
stop when time = 0.004656
resume
delete all
let endpoint = length(time)-1
let cmp = v(COMP)[endpoint]
let top = v(TOP)[endpoint]
let decision = 0
if cmp >= 0.9
let code = trial
let decision = 1
end
echo 258 3 $&trial $&cmp $&top 1.19765625 $&decision >> decisions.csv
let trial = code + 4
let drive = (floor(trial / 1) - 2*floor(trial / 2))*1.8
alter VB0 = $&drive
let drive = (floor(trial / 2) - 2*floor(trial / 4))*1.8
alter VB1 = $&drive
let drive = (floor(trial / 4) - 2*floor(trial / 8))*1.8
alter VB2 = $&drive
let drive = (floor(trial / 8) - 2*floor(trial / 16))*1.8
alter VB3 = $&drive
let drive = (floor(trial / 16) - 2*floor(trial / 32))*1.8
alter VB4 = $&drive
let drive = (floor(trial / 32) - 2*floor(trial / 64))*1.8
alter VB5 = $&drive
let drive = (floor(trial / 64) - 2*floor(trial / 128))*1.8
alter VB6 = $&drive
let drive = (floor(trial / 128) - 2*floor(trial / 256))*1.8
alter VB7 = $&drive
stop when time = 0.004658
resume
delete all
let endpoint = length(time)-1
let cmp = v(COMP)[endpoint]
let top = v(TOP)[endpoint]
let decision = 0
if cmp >= 0.9
let code = trial
let decision = 1
end
echo 258 2 $&trial $&cmp $&top 1.19765625 $&decision >> decisions.csv
let trial = code + 2
let drive = (floor(trial / 1) - 2*floor(trial / 2))*1.8
alter VB0 = $&drive
let drive = (floor(trial / 2) - 2*floor(trial / 4))*1.8
alter VB1 = $&drive
let drive = (floor(trial / 4) - 2*floor(trial / 8))*1.8
alter VB2 = $&drive
let drive = (floor(trial / 8) - 2*floor(trial / 16))*1.8
alter VB3 = $&drive
let drive = (floor(trial / 16) - 2*floor(trial / 32))*1.8
alter VB4 = $&drive
let drive = (floor(trial / 32) - 2*floor(trial / 64))*1.8
alter VB5 = $&drive
let drive = (floor(trial / 64) - 2*floor(trial / 128))*1.8
alter VB6 = $&drive
let drive = (floor(trial / 128) - 2*floor(trial / 256))*1.8
alter VB7 = $&drive
stop when time = 0.00466
resume
delete all
let endpoint = length(time)-1
let cmp = v(COMP)[endpoint]
let top = v(TOP)[endpoint]
let decision = 0
if cmp >= 0.9
let code = trial
let decision = 1
end
echo 258 1 $&trial $&cmp $&top 1.19765625 $&decision >> decisions.csv
let trial = code + 1
let drive = (floor(trial / 1) - 2*floor(trial / 2))*1.8
alter VB0 = $&drive
let drive = (floor(trial / 2) - 2*floor(trial / 4))*1.8
alter VB1 = $&drive
let drive = (floor(trial / 4) - 2*floor(trial / 8))*1.8
alter VB2 = $&drive
let drive = (floor(trial / 8) - 2*floor(trial / 16))*1.8
alter VB3 = $&drive
let drive = (floor(trial / 16) - 2*floor(trial / 32))*1.8
alter VB4 = $&drive
let drive = (floor(trial / 32) - 2*floor(trial / 64))*1.8
alter VB5 = $&drive
let drive = (floor(trial / 64) - 2*floor(trial / 128))*1.8
alter VB6 = $&drive
let drive = (floor(trial / 128) - 2*floor(trial / 256))*1.8
alter VB7 = $&drive
stop when time = 0.004662
resume
delete all
let endpoint = length(time)-1
let cmp = v(COMP)[endpoint]
let top = v(TOP)[endpoint]
let decision = 0
if cmp >= 0.9
let code = trial
let decision = 1
end
echo 258 0 $&trial $&cmp $&top 1.19765625 $&decision >> decisions.csv
resume
let supply_current = -i(VDD)
let reference_current = -i(VREF)
wrdata waveform.dat v(VIN) v(SAMPLE) v(TOP) v(COMP) v(VCM) supply_current reference_current v(B0) v(B1) v(B2) v(B3) v(B4) v(B5) v(B6) v(B7)
echo SAR_NATIVE_COMPLETE
quit
.endc
.end

* NGSPICE file created from sar8_analog.ext - technology: sky130A

.subckt sar8_analog VREF VPWR VGND B0 B1 B7 VIN BIAS B6 COMP B4 B2 B5 B3 SAMPLE VCM
+ TOP
X0 TOP DAC__BOTTOM7 sky130_fd_pr__cap_mim_m3_1 l=6.89 w=6.89
X1 VGND SAMPLE DAC__SAMPLEB VGND sky130_fd_pr__nfet_01v8 ad=0.1885 pd=1.88 as=0.1885 ps=1.88 w=0.65 l=0.15
X2 DAC__BIT3__REFSEL DAC__SAMPLEB DAC__BOTTOM3 VGND sky130_fd_pr__nfet_01v8 ad=1.16 pd=8.58 as=1.16 ps=8.58 w=4 l=0.15
X3 TOP DAC__BOTTOM7 sky130_fd_pr__cap_mim_m3_1 l=6.89 w=6.89
X4 VPWR B7 DAC__BIT7__BITB VPWR sky130_fd_pr__pfet_01v8_hvt ad=0.1885 pd=1.88 as=0.1885 ps=1.88 w=0.65 l=0.15
X5 VIN SAMPLE DAC__BOTTOM5 VGND sky130_fd_pr__nfet_01v8 ad=1.16 pd=8.58 as=1.16 ps=8.58 w=4 l=0.15
X6 TOP DAC__BOTTOM3 sky130_fd_pr__cap_mim_m3_1 l=6.89 w=6.89
X7 VIN SAMPLE DAC__BOTTOM1 VGND sky130_fd_pr__nfet_01v8 ad=1.16 pd=8.58 as=1.16 ps=8.58 w=4 l=0.15
X8 VGND B2 DAC__BIT2__REFSEL VPWR sky130_fd_pr__pfet_01v8_hvt ad=2.32 pd=16.58 as=2.32 ps=16.58 w=8 l=0.15
X9 TOP DAC__BOTTOM7 sky130_fd_pr__cap_mim_m3_1 l=6.89 w=6.89
X10 TOP DAC__BOTTOM6 sky130_fd_pr__cap_mim_m3_1 l=6.89 w=6.89
X11 TOP DAC__BOTTOM7 sky130_fd_pr__cap_mim_m3_1 l=6.89 w=6.89
X12 TOP DAC__BOTTOM6 sky130_fd_pr__cap_mim_m3_1 l=6.89 w=6.89
X13 TOP DAC__BOTTOM7 sky130_fd_pr__cap_mim_m3_1 l=6.89 w=6.89
X14 TOP DAC__BOTTOM7 sky130_fd_pr__cap_mim_m3_1 l=6.89 w=6.89
X15 TOP DAC__BOTTOM5 sky130_fd_pr__cap_mim_m3_1 l=6.89 w=6.89
X16 DAC__BIT4__REFSEL DAC__SAMPLEB DAC__BOTTOM4 VGND sky130_fd_pr__nfet_01v8 ad=1.16 pd=8.58 as=1.16 ps=8.58 w=4 l=0.15
X17 TOP DAC__BOTTOM7 sky130_fd_pr__cap_mim_m3_1 l=6.89 w=6.89
X18 TOP DAC__BOTTOM6 sky130_fd_pr__cap_mim_m3_1 l=6.89 w=6.89
X19 TOP DAC__BOTTOM6 sky130_fd_pr__cap_mim_m3_1 l=6.89 w=6.89
X20 TOP DAC__BOTTOM3 sky130_fd_pr__cap_mim_m3_1 l=6.89 w=6.89
X21 TOP DAC__BOTTOM2 sky130_fd_pr__cap_mim_m3_1 l=6.89 w=6.89
X22 TOP DAC__BOTTOM4 sky130_fd_pr__cap_mim_m3_1 l=6.89 w=6.89
X23 TOP DAC__BOTTOM6 sky130_fd_pr__cap_mim_m3_1 l=6.89 w=6.89
X24 TOP DAC__BOTTOM3 sky130_fd_pr__cap_mim_m3_1 l=6.89 w=6.89
X25 TOP DAC__BOTTOM7 sky130_fd_pr__cap_mim_m3_1 l=6.89 w=6.89
X26 VIN DAC__SAMPLEB DAC__BOTTOM6 VPWR sky130_fd_pr__pfet_01v8_hvt ad=2.32 pd=16.58 as=2.32 ps=16.58 w=8 l=0.15
X27 TOP DAC__BOTTOM7 sky130_fd_pr__cap_mim_m3_1 l=6.89 w=6.89
X28 TOP DAC__BOTTOM7 sky130_fd_pr__cap_mim_m3_1 l=6.89 w=6.89
X29 TOP DAC__BOTTOM5 sky130_fd_pr__cap_mim_m3_1 l=6.89 w=6.89
X30 TOP DAC__BOTTOM6 sky130_fd_pr__cap_mim_m3_1 l=6.89 w=6.89
X31 TOP DAC__BOTTOM7 sky130_fd_pr__cap_mim_m3_1 l=6.89 w=6.89
X32 TOP DAC__BOTTOM7 sky130_fd_pr__cap_mim_m3_1 l=6.89 w=6.89
X33 TOP DAC__BOTTOM7 sky130_fd_pr__cap_mim_m3_1 l=6.89 w=6.89
X34 TOP DAC__BOTTOM6 sky130_fd_pr__cap_mim_m3_1 l=6.89 w=6.89
X35 DAC__BIT0__REFSEL DAC__SAMPLEB DAC__BOTTOM0 VGND sky130_fd_pr__nfet_01v8 ad=1.16 pd=8.58 as=1.16 ps=8.58 w=4 l=0.15
X36 VGND B5 DAC__BIT5__REFSEL VPWR sky130_fd_pr__pfet_01v8_hvt ad=2.32 pd=16.58 as=2.32 ps=16.58 w=8 l=0.15
X37 VIN SAMPLE DAC__BOTTOM0 VGND sky130_fd_pr__nfet_01v8 ad=1.16 pd=8.58 as=1.16 ps=8.58 w=4 l=0.15
X38 TOP DAC__BOTTOM7 sky130_fd_pr__cap_mim_m3_1 l=6.89 w=6.89
X39 TOP DAC__BOTTOM6 sky130_fd_pr__cap_mim_m3_1 l=6.89 w=6.89
X40 DAC__BIT6__REFSEL SAMPLE DAC__BOTTOM6 VPWR sky130_fd_pr__pfet_01v8_hvt ad=2.32 pd=16.58 as=2.32 ps=16.58 w=8 l=0.15
X41 TOP DAC__BOTTOM7 sky130_fd_pr__cap_mim_m3_1 l=6.89 w=6.89
X42 TOP DAC__BOTTOM7 sky130_fd_pr__cap_mim_m3_1 l=6.89 w=6.89
X43 TOP DAC__BOTTOM6 sky130_fd_pr__cap_mim_m3_1 l=6.89 w=6.89
X44 TOP DAC__BOTTOM6 sky130_fd_pr__cap_mim_m3_1 l=6.89 w=6.89
X45 VIN DAC__SAMPLEB DAC__BOTTOM2 VPWR sky130_fd_pr__pfet_01v8_hvt ad=2.32 pd=16.58 as=2.32 ps=16.58 w=8 l=0.15
X46 TOP DAC__BOTTOM7 sky130_fd_pr__cap_mim_m3_1 l=6.89 w=6.89
X47 TOP DAC__BOTTOM7 sky130_fd_pr__cap_mim_m3_1 l=6.89 w=6.89
X48 VIN DAC__SAMPLEB DAC__BOTTOM5 VPWR sky130_fd_pr__pfet_01v8_hvt ad=2.32 pd=16.58 as=2.32 ps=16.58 w=8 l=0.15
X49 TOP DAC__BOTTOM7 sky130_fd_pr__cap_mim_m3_1 l=6.89 w=6.89
X50 TOP DAC__BOTTOM7 sky130_fd_pr__cap_mim_m3_1 l=6.89 w=6.89
X51 TOP DAC__BOTTOM4 sky130_fd_pr__cap_mim_m3_1 l=6.89 w=6.89
X52 VGND B1 DAC__BIT1__BITB VGND sky130_fd_pr__nfet_01v8 ad=0.1885 pd=1.88 as=0.1885 ps=1.88 w=0.65 l=0.15
X53 TOP DAC__BOTTOM4 sky130_fd_pr__cap_mim_m3_1 l=6.89 w=6.89
X54 VREF B0 DAC__BIT0__REFSEL VGND sky130_fd_pr__nfet_01v8 ad=1.16 pd=8.58 as=1.16 ps=8.58 w=4 l=0.15
X55 TOP DAC__BOTTOM7 sky130_fd_pr__cap_mim_m3_1 l=6.89 w=6.89
X56 TOP DAC__BOTTOM5 sky130_fd_pr__cap_mim_m3_1 l=6.89 w=6.89
X57 TOP DAC__BOTTOM5 sky130_fd_pr__cap_mim_m3_1 l=6.89 w=6.89
X58 VIN SAMPLE DAC__BOTTOM3 VGND sky130_fd_pr__nfet_01v8 ad=1.16 pd=8.58 as=1.16 ps=8.58 w=4 l=0.15
X59 TOP DAC__BOTTOM7 sky130_fd_pr__cap_mim_m3_1 l=6.89 w=6.89
X60 TOP DAC__BOTTOM6 sky130_fd_pr__cap_mim_m3_1 l=6.89 w=6.89
X61 TOP DAC__BOTTOM6 sky130_fd_pr__cap_mim_m3_1 l=6.89 w=6.89
X62 TOP DAC__BOTTOM5 sky130_fd_pr__cap_mim_m3_1 l=6.89 w=6.89
X63 DAC__BIT2__REFSEL DAC__SAMPLEB DAC__BOTTOM2 VGND sky130_fd_pr__nfet_01v8 ad=1.16 pd=8.58 as=1.16 ps=8.58 w=4 l=0.15
X64 VGND DAC__BIT3__BITB DAC__BIT3__REFSEL VGND sky130_fd_pr__nfet_01v8 ad=1.16 pd=8.58 as=1.16 ps=8.58 w=4 l=0.15
X65 TOP DAC__BOTTOM7 sky130_fd_pr__cap_mim_m3_1 l=6.89 w=6.89
X66 TOP DAC__BOTTOM7 sky130_fd_pr__cap_mim_m3_1 l=6.89 w=6.89
X67 TOP DAC__BOTTOM7 sky130_fd_pr__cap_mim_m3_1 l=6.89 w=6.89
X68 TOP DAC__BOTTOM6 sky130_fd_pr__cap_mim_m3_1 l=6.89 w=6.89
X69 TOP DAC__BOTTOM6 sky130_fd_pr__cap_mim_m3_1 l=6.89 w=6.89
X70 TOP DAC__BOTTOM6 sky130_fd_pr__cap_mim_m3_1 l=6.89 w=6.89
X71 TOP DAC__BOTTOM6 sky130_fd_pr__cap_mim_m3_1 l=6.89 w=6.89
X72 TOP DAC__BOTTOM7 sky130_fd_pr__cap_mim_m3_1 l=6.89 w=6.89
X73 VGND DAC__BIT2__BITB DAC__BIT2__REFSEL VGND sky130_fd_pr__nfet_01v8 ad=1.16 pd=8.58 as=1.16 ps=8.58 w=4 l=0.15
X74 TOP DAC__BOTTOM7 sky130_fd_pr__cap_mim_m3_1 l=6.89 w=6.89
X75 TOP DAC__BOTTOM7 sky130_fd_pr__cap_mim_m3_1 l=6.89 w=6.89
X76 TOP DAC__BOTTOM7 sky130_fd_pr__cap_mim_m3_1 l=6.89 w=6.89
X77 TOP DAC__BOTTOM7 sky130_fd_pr__cap_mim_m3_1 l=6.89 w=6.89
X78 TOP DAC__BOTTOM6 sky130_fd_pr__cap_mim_m3_1 l=6.89 w=6.89
X79 TOP DAC__BOTTOM4 sky130_fd_pr__cap_mim_m3_1 l=6.89 w=6.89
X80 TOP DAC__BOTTOM6 sky130_fd_pr__cap_mim_m3_1 l=6.89 w=6.89
X81 DAC__BIT1__REFSEL SAMPLE DAC__BOTTOM1 VPWR sky130_fd_pr__pfet_01v8_hvt ad=2.32 pd=16.58 as=2.32 ps=16.58 w=8 l=0.15
X82 TOP DAC__BOTTOM7 sky130_fd_pr__cap_mim_m3_1 l=6.89 w=6.89
X83 TOP DAC__BOTTOM7 sky130_fd_pr__cap_mim_m3_1 l=6.89 w=6.89
X84 TOP DAC__BOTTOM7 sky130_fd_pr__cap_mim_m3_1 l=6.89 w=6.89
X85 TOP DAC__BOTTOM3 sky130_fd_pr__cap_mim_m3_1 l=6.89 w=6.89
X86 TOP DAC__BOTTOM5 sky130_fd_pr__cap_mim_m3_1 l=6.89 w=6.89
X87 TOP DAC__BOTTOM6 sky130_fd_pr__cap_mim_m3_1 l=6.89 w=6.89
X88 VGND DAC__BIT0__BITB DAC__BIT0__REFSEL VGND sky130_fd_pr__nfet_01v8 ad=1.16 pd=8.58 as=1.16 ps=8.58 w=4 l=0.15
X89 TOP DAC__BOTTOM7 sky130_fd_pr__cap_mim_m3_1 l=6.89 w=6.89
X90 TOP DAC__BOTTOM6 sky130_fd_pr__cap_mim_m3_1 l=6.89 w=6.89
X91 TOP DAC__BOTTOM6 sky130_fd_pr__cap_mim_m3_1 l=6.89 w=6.89
X92 VGND B3 DAC__BIT3__BITB VGND sky130_fd_pr__nfet_01v8 ad=0.1885 pd=1.88 as=0.1885 ps=1.88 w=0.65 l=0.15
X93 TOP DAC__BOTTOM7 sky130_fd_pr__cap_mim_m3_1 l=6.89 w=6.89
X94 TOP DAC__BOTTOM7 sky130_fd_pr__cap_mim_m3_1 l=6.89 w=6.89
X95 TOP DAC__BOTTOM5 sky130_fd_pr__cap_mim_m3_1 l=6.89 w=6.89
X96 VPWR B1 DAC__BIT1__BITB VPWR sky130_fd_pr__pfet_01v8_hvt ad=0.1885 pd=1.88 as=0.1885 ps=1.88 w=0.65 l=0.15
X97 TOP DAC__BOTTOM7 sky130_fd_pr__cap_mim_m3_1 l=6.89 w=6.89
X98 TOP DAC__BOTTOM7 sky130_fd_pr__cap_mim_m3_1 l=6.89 w=6.89
X99 TOP DAC__BOTTOM6 sky130_fd_pr__cap_mim_m3_1 l=6.89 w=6.89
X100 TOP DAC__BOTTOM6 sky130_fd_pr__cap_mim_m3_1 l=6.89 w=6.89
X101 VREF DAC__BIT1__BITB DAC__BIT1__REFSEL VPWR sky130_fd_pr__pfet_01v8_hvt ad=2.32 pd=16.58 as=2.32 ps=16.58 w=8 l=0.15
X102 TOP DAC__BOTTOM7 sky130_fd_pr__cap_mim_m3_1 l=6.89 w=6.89
X103 TOP DAC__BOTTOM6 sky130_fd_pr__cap_mim_m3_1 l=6.89 w=6.89
X104 TOP DAC__BOTTOM7 sky130_fd_pr__cap_mim_m3_1 l=6.89 w=6.89
X105 TOP DAC__BOTTOM7 sky130_fd_pr__cap_mim_m3_1 l=6.89 w=6.89
X106 TOP DAC__BOTTOM5 sky130_fd_pr__cap_mim_m3_1 l=6.89 w=6.89
X107 VIN SAMPLE DAC__BOTTOM2 VGND sky130_fd_pr__nfet_01v8 ad=1.16 pd=8.58 as=1.16 ps=8.58 w=4 l=0.15
X108 VGND B4 DAC__BIT4__BITB VGND sky130_fd_pr__nfet_01v8 ad=0.1885 pd=1.88 as=0.1885 ps=1.88 w=0.65 l=0.15
X109 TOP DAC__BOTTOM7 sky130_fd_pr__cap_mim_m3_1 l=6.89 w=6.89
X110 TOP DAC__BOTTOM5 sky130_fd_pr__cap_mim_m3_1 l=6.89 w=6.89
X111 TOP DAC__BOTTOM7 sky130_fd_pr__cap_mim_m3_1 l=6.89 w=6.89
X112 TOP DAC__BOTTOM7 sky130_fd_pr__cap_mim_m3_1 l=6.89 w=6.89
X113 VREF B4 DAC__BIT4__REFSEL VGND sky130_fd_pr__nfet_01v8 ad=1.16 pd=8.58 as=1.16 ps=8.58 w=4 l=0.15
X114 TOP DAC__BOTTOM7 sky130_fd_pr__cap_mim_m3_1 l=6.89 w=6.89
X115 TOP DAC__BOTTOM7 sky130_fd_pr__cap_mim_m3_1 l=6.89 w=6.89
X116 TOP DAC__BOTTOM6 sky130_fd_pr__cap_mim_m3_1 l=6.89 w=6.89
X117 TOP DAC__BOTTOM6 sky130_fd_pr__cap_mim_m3_1 l=6.89 w=6.89
X118 TOP DAC__BOTTOM0 sky130_fd_pr__cap_mim_m3_1 l=6.89 w=6.89
X119 TOP DAC__BOTTOM6 sky130_fd_pr__cap_mim_m3_1 l=6.89 w=6.89
X120 TOP DAC__BOTTOM5 sky130_fd_pr__cap_mim_m3_1 l=6.89 w=6.89
X121 VREF B7 DAC__BIT7__REFSEL VGND sky130_fd_pr__nfet_01v8 ad=1.16 pd=8.58 as=1.16 ps=8.58 w=4 l=0.15
X122 TOP DAC__BOTTOM7 sky130_fd_pr__cap_mim_m3_1 l=6.89 w=6.89
X123 TOP DAC__BOTTOM7 sky130_fd_pr__cap_mim_m3_1 l=6.89 w=6.89
X124 TOP DAC__BOTTOM3 sky130_fd_pr__cap_mim_m3_1 l=6.89 w=6.89
X125 TOP DAC__BOTTOM5 sky130_fd_pr__cap_mim_m3_1 l=6.89 w=6.89
X126 TOP DAC__BOTTOM6 sky130_fd_pr__cap_mim_m3_1 l=6.89 w=6.89
X127 VGND B0 DAC__BIT0__BITB VGND sky130_fd_pr__nfet_01v8 ad=0.1885 pd=1.88 as=0.1885 ps=1.88 w=0.65 l=0.15
X128 TOP DAC__BOTTOM7 sky130_fd_pr__cap_mim_m3_1 l=6.89 w=6.89
X129 TOP DAC__BOTTOM7 sky130_fd_pr__cap_mim_m3_1 l=6.89 w=6.89
X130 TOP DAC__BOTTOM7 sky130_fd_pr__cap_mim_m3_1 l=6.89 w=6.89
X131 TOP DAC__BOTTOM7 sky130_fd_pr__cap_mim_m3_1 l=6.89 w=6.89
X132 TOP DAC__BOTTOM7 sky130_fd_pr__cap_mim_m3_1 l=6.89 w=6.89
X133 TOP DAC__BOTTOM5 sky130_fd_pr__cap_mim_m3_1 l=6.89 w=6.89
X134 VREF B6 DAC__BIT6__REFSEL VGND sky130_fd_pr__nfet_01v8 ad=1.16 pd=8.58 as=1.16 ps=8.58 w=4 l=0.15
X135 VREF DAC__BIT6__BITB DAC__BIT6__REFSEL VPWR sky130_fd_pr__pfet_01v8_hvt ad=2.32 pd=16.58 as=2.32 ps=16.58 w=8 l=0.15
X136 TOP DAC__DUMMY sky130_fd_pr__cap_mim_m3_1 l=6.89 w=6.89
X137 TOP DAC__BOTTOM6 sky130_fd_pr__cap_mim_m3_1 l=6.89 w=6.89
X138 COMPARE__PREAMP__TAIL TOP COMPARE__PREAMP__MIR VGND sky130_fd_pr__nfet_01v8 ad=2.9 pd=20.58 as=2.9 ps=20.58 w=10 l=1
X139 VGND B1 DAC__BIT1__REFSEL VPWR sky130_fd_pr__pfet_01v8_hvt ad=2.32 pd=16.58 as=2.32 ps=16.58 w=8 l=0.15
X140 VREF B3 DAC__BIT3__REFSEL VGND sky130_fd_pr__nfet_01v8 ad=1.16 pd=8.58 as=1.16 ps=8.58 w=4 l=0.15
X141 TOP DAC__BOTTOM4 sky130_fd_pr__cap_mim_m3_1 l=6.89 w=6.89
X142 VGND B5 DAC__BIT5__BITB VGND sky130_fd_pr__nfet_01v8 ad=0.1885 pd=1.88 as=0.1885 ps=1.88 w=0.65 l=0.15
X143 TOP DAC__BOTTOM7 sky130_fd_pr__cap_mim_m3_1 l=6.89 w=6.89
X144 TOP DAC__BOTTOM7 sky130_fd_pr__cap_mim_m3_1 l=6.89 w=6.89
X145 TOP DAC__BOTTOM6 sky130_fd_pr__cap_mim_m3_1 l=6.89 w=6.89
X146 VPWR COMPARE__PRE COMP VPWR sky130_fd_pr__pfet_01v8_hvt ad=2.32 pd=16.58 as=2.32 ps=16.58 w=8 l=0.15
X147 TOP DAC__BOTTOM7 sky130_fd_pr__cap_mim_m3_1 l=6.89 w=6.89
X148 TOP DAC__BOTTOM7 sky130_fd_pr__cap_mim_m3_1 l=6.89 w=6.89
X149 TOP DAC__BOTTOM5 sky130_fd_pr__cap_mim_m3_1 l=6.89 w=6.89
X150 TOP DAC__BOTTOM6 sky130_fd_pr__cap_mim_m3_1 l=6.89 w=6.89
X151 DAC__DUMMY_SWITCH__REFSEL SAMPLE DAC__DUMMY VPWR sky130_fd_pr__pfet_01v8_hvt ad=2.32 pd=16.58 as=2.32 ps=16.58 w=8 l=0.15
X152 TOP DAC__BOTTOM7 sky130_fd_pr__cap_mim_m3_1 l=6.89 w=6.89
X153 VGND B2 DAC__BIT2__BITB VGND sky130_fd_pr__nfet_01v8 ad=0.1885 pd=1.88 as=0.1885 ps=1.88 w=0.65 l=0.15
X154 VGND DAC__BIT4__BITB DAC__BIT4__REFSEL VGND sky130_fd_pr__nfet_01v8 ad=1.16 pd=8.58 as=1.16 ps=8.58 w=4 l=0.15
X155 VGND COMPARE__PRE COMP VGND sky130_fd_pr__nfet_01v8 ad=1.16 pd=8.58 as=1.16 ps=8.58 w=4 l=0.15
X156 TOP DAC__BOTTOM7 sky130_fd_pr__cap_mim_m3_1 l=6.89 w=6.89
X157 TOP DAC__BOTTOM7 sky130_fd_pr__cap_mim_m3_1 l=6.89 w=6.89
X158 TOP DAC__BOTTOM5 sky130_fd_pr__cap_mim_m3_1 l=6.89 w=6.89
X159 VREF B2 DAC__BIT2__REFSEL VGND sky130_fd_pr__nfet_01v8 ad=1.16 pd=8.58 as=1.16 ps=8.58 w=4 l=0.15
X160 TOP DAC__BOTTOM7 sky130_fd_pr__cap_mim_m3_1 l=6.89 w=6.89
X161 VREF DAC__BIT7__BITB DAC__BIT7__REFSEL VPWR sky130_fd_pr__pfet_01v8_hvt ad=2.32 pd=16.58 as=2.32 ps=16.58 w=8 l=0.15
X162 TOP DAC__BOTTOM6 sky130_fd_pr__cap_mim_m3_1 l=6.89 w=6.89
X163 TOP DAC__BOTTOM6 sky130_fd_pr__cap_mim_m3_1 l=6.89 w=6.89
X164 TOP DAC__BOTTOM7 sky130_fd_pr__cap_mim_m3_1 l=6.89 w=6.89
X165 VIN DAC__SAMPLEB DAC__BOTTOM0 VPWR sky130_fd_pr__pfet_01v8_hvt ad=2.32 pd=16.58 as=2.32 ps=16.58 w=8 l=0.15
X166 TOP DAC__BOTTOM7 sky130_fd_pr__cap_mim_m3_1 l=6.89 w=6.89
X167 TOP DAC__BOTTOM5 sky130_fd_pr__cap_mim_m3_1 l=6.89 w=6.89
X168 DAC__BIT5__REFSEL DAC__SAMPLEB DAC__BOTTOM5 VGND sky130_fd_pr__nfet_01v8 ad=1.16 pd=8.58 as=1.16 ps=8.58 w=4 l=0.15
X169 VGND B0 DAC__BIT0__REFSEL VPWR sky130_fd_pr__pfet_01v8_hvt ad=2.32 pd=16.58 as=2.32 ps=16.58 w=8 l=0.15
X170 TOP DAC__BOTTOM7 sky130_fd_pr__cap_mim_m3_1 l=6.89 w=6.89
X171 VGND DAC__BIT7__BITB DAC__BIT7__REFSEL VGND sky130_fd_pr__nfet_01v8 ad=1.16 pd=8.58 as=1.16 ps=8.58 w=4 l=0.15
X172 VGND B7 DAC__BIT7__REFSEL VPWR sky130_fd_pr__pfet_01v8_hvt ad=2.32 pd=16.58 as=2.32 ps=16.58 w=8 l=0.15
X173 VPWR SAMPLE DAC__SAMPLEB VPWR sky130_fd_pr__pfet_01v8_hvt ad=0.1885 pd=1.88 as=0.1885 ps=1.88 w=0.65 l=0.15
X174 TOP DAC__BOTTOM7 sky130_fd_pr__cap_mim_m3_1 l=6.89 w=6.89
X175 TOP DAC__BOTTOM7 sky130_fd_pr__cap_mim_m3_1 l=6.89 w=6.89
X176 TOP DAC__BOTTOM2 sky130_fd_pr__cap_mim_m3_1 l=6.89 w=6.89
X177 TOP DAC__BOTTOM5 sky130_fd_pr__cap_mim_m3_1 l=6.89 w=6.89
X178 VGND BIAS COMPARE__PREAMP__TAIL VGND sky130_fd_pr__nfet_01v8 ad=0.58 pd=4.58 as=0.58 ps=4.58 w=2 l=1
X179 TOP DAC__BOTTOM7 sky130_fd_pr__cap_mim_m3_1 l=6.89 w=6.89
X180 TOP DAC__BOTTOM6 sky130_fd_pr__cap_mim_m3_1 l=6.89 w=6.89
X181 TOP DAC__BOTTOM5 sky130_fd_pr__cap_mim_m3_1 l=6.89 w=6.89
X182 TOP DAC__BOTTOM5 sky130_fd_pr__cap_mim_m3_1 l=6.89 w=6.89
X183 VPWR B0 DAC__BIT0__BITB VPWR sky130_fd_pr__pfet_01v8_hvt ad=0.1885 pd=1.88 as=0.1885 ps=1.88 w=0.65 l=0.15
X184 VIN DAC__SAMPLEB DAC__BOTTOM1 VPWR sky130_fd_pr__pfet_01v8_hvt ad=2.32 pd=16.58 as=2.32 ps=16.58 w=8 l=0.15
X185 TOP DAC__BOTTOM7 sky130_fd_pr__cap_mim_m3_1 l=6.89 w=6.89
X186 TOP DAC__BOTTOM7 sky130_fd_pr__cap_mim_m3_1 l=6.89 w=6.89
X187 TOP DAC__BOTTOM7 sky130_fd_pr__cap_mim_m3_1 l=6.89 w=6.89
X188 TOP DAC__BOTTOM2 sky130_fd_pr__cap_mim_m3_1 l=6.89 w=6.89
X189 VGND B6 DAC__BIT6__REFSEL VPWR sky130_fd_pr__pfet_01v8_hvt ad=2.32 pd=16.58 as=2.32 ps=16.58 w=8 l=0.15
X190 TOP DAC__BOTTOM5 sky130_fd_pr__cap_mim_m3_1 l=6.89 w=6.89
X191 TOP DAC__BOTTOM6 sky130_fd_pr__cap_mim_m3_1 l=6.89 w=6.89
X192 TOP DAC__BOTTOM7 sky130_fd_pr__cap_mim_m3_1 l=6.89 w=6.89
X193 TOP DAC__BOTTOM7 sky130_fd_pr__cap_mim_m3_1 l=6.89 w=6.89
X194 TOP DAC__BOTTOM1 sky130_fd_pr__cap_mim_m3_1 l=6.89 w=6.89
X195 TOP DAC__BOTTOM6 sky130_fd_pr__cap_mim_m3_1 l=6.89 w=6.89
X196 VIN SAMPLE DAC__BOTTOM6 VGND sky130_fd_pr__nfet_01v8 ad=1.16 pd=8.58 as=1.16 ps=8.58 w=4 l=0.15
X197 TOP DAC__BOTTOM7 sky130_fd_pr__cap_mim_m3_1 l=6.89 w=6.89
X198 TOP DAC__BOTTOM7 sky130_fd_pr__cap_mim_m3_1 l=6.89 w=6.89
X199 TOP DAC__BOTTOM7 sky130_fd_pr__cap_mim_m3_1 l=6.89 w=6.89
X200 TOP DAC__BOTTOM5 sky130_fd_pr__cap_mim_m3_1 l=6.89 w=6.89
X201 TOP DAC__BOTTOM7 sky130_fd_pr__cap_mim_m3_1 l=6.89 w=6.89
X202 TOP DAC__BOTTOM6 sky130_fd_pr__cap_mim_m3_1 l=6.89 w=6.89
X203 TOP DAC__BOTTOM6 sky130_fd_pr__cap_mim_m3_1 l=6.89 w=6.89
X204 DAC__BIT0__REFSEL SAMPLE DAC__BOTTOM0 VPWR sky130_fd_pr__pfet_01v8_hvt ad=2.32 pd=16.58 as=2.32 ps=16.58 w=8 l=0.15
X205 COMPARE__PREAMP__TAIL VCM COMPARE__PRE VGND sky130_fd_pr__nfet_01v8 ad=2.9 pd=20.58 as=2.9 ps=20.58 w=10 l=1
X206 TOP DAC__BOTTOM7 sky130_fd_pr__cap_mim_m3_1 l=6.89 w=6.89
X207 TOP DAC__BOTTOM7 sky130_fd_pr__cap_mim_m3_1 l=6.89 w=6.89
X208 TOP DAC__BOTTOM7 sky130_fd_pr__cap_mim_m3_1 l=6.89 w=6.89
X209 TOP DAC__BOTTOM4 sky130_fd_pr__cap_mim_m3_1 l=6.89 w=6.89
X210 TOP DAC__BOTTOM6 sky130_fd_pr__cap_mim_m3_1 l=6.89 w=6.89
X211 TOP DAC__BOTTOM7 sky130_fd_pr__cap_mim_m3_1 l=6.89 w=6.89
X212 DAC__BIT5__REFSEL SAMPLE DAC__BOTTOM5 VPWR sky130_fd_pr__pfet_01v8_hvt ad=2.32 pd=16.58 as=2.32 ps=16.58 w=8 l=0.15
X213 TOP DAC__BOTTOM7 sky130_fd_pr__cap_mim_m3_1 l=6.89 w=6.89
X214 TOP DAC__BOTTOM7 sky130_fd_pr__cap_mim_m3_1 l=6.89 w=6.89
X215 TOP DAC__BOTTOM5 sky130_fd_pr__cap_mim_m3_1 l=6.89 w=6.89
X216 VCM DAC__SAMPLEB TOP VPWR sky130_fd_pr__pfet_01v8_hvt ad=2.32 pd=16.58 as=2.32 ps=16.58 w=8 l=0.15
X217 TOP DAC__BOTTOM7 sky130_fd_pr__cap_mim_m3_1 l=6.89 w=6.89
X218 TOP DAC__BOTTOM7 sky130_fd_pr__cap_mim_m3_1 l=6.89 w=6.89
X219 TOP DAC__BOTTOM6 sky130_fd_pr__cap_mim_m3_1 l=6.89 w=6.89
X220 TOP DAC__BOTTOM6 sky130_fd_pr__cap_mim_m3_1 l=6.89 w=6.89
X221 VREF DAC__BIT0__BITB DAC__BIT0__REFSEL VPWR sky130_fd_pr__pfet_01v8_hvt ad=2.32 pd=16.58 as=2.32 ps=16.58 w=8 l=0.15
X222 TOP DAC__BOTTOM7 sky130_fd_pr__cap_mim_m3_1 l=6.89 w=6.89
X223 TOP DAC__BOTTOM7 sky130_fd_pr__cap_mim_m3_1 l=6.89 w=6.89
X224 TOP DAC__BOTTOM4 sky130_fd_pr__cap_mim_m3_1 l=6.89 w=6.89
X225 TOP DAC__BOTTOM5 sky130_fd_pr__cap_mim_m3_1 l=6.89 w=6.89
X226 DAC__BIT2__REFSEL SAMPLE DAC__BOTTOM2 VPWR sky130_fd_pr__pfet_01v8_hvt ad=2.32 pd=16.58 as=2.32 ps=16.58 w=8 l=0.15
X227 TOP DAC__BOTTOM7 sky130_fd_pr__cap_mim_m3_1 l=6.89 w=6.89
X228 TOP DAC__BOTTOM5 sky130_fd_pr__cap_mim_m3_1 l=6.89 w=6.89
X229 VGND B7 DAC__BIT7__BITB VGND sky130_fd_pr__nfet_01v8 ad=0.1885 pd=1.88 as=0.1885 ps=1.88 w=0.65 l=0.15
X230 TOP DAC__BOTTOM7 sky130_fd_pr__cap_mim_m3_1 l=6.89 w=6.89
X231 TOP DAC__BOTTOM6 sky130_fd_pr__cap_mim_m3_1 l=6.89 w=6.89
X232 TOP DAC__BOTTOM5 sky130_fd_pr__cap_mim_m3_1 l=6.89 w=6.89
X233 TOP DAC__BOTTOM7 sky130_fd_pr__cap_mim_m3_1 l=6.89 w=6.89
X234 TOP DAC__BOTTOM7 sky130_fd_pr__cap_mim_m3_1 l=6.89 w=6.89
X235 TOP DAC__BOTTOM7 sky130_fd_pr__cap_mim_m3_1 l=6.89 w=6.89
X236 TOP DAC__BOTTOM6 sky130_fd_pr__cap_mim_m3_1 l=6.89 w=6.89
X237 TOP DAC__BOTTOM6 sky130_fd_pr__cap_mim_m3_1 l=6.89 w=6.89
X238 TOP DAC__BOTTOM7 sky130_fd_pr__cap_mim_m3_1 l=6.89 w=6.89
X239 TOP DAC__BOTTOM6 sky130_fd_pr__cap_mim_m3_1 l=6.89 w=6.89
X240 VREF VGND DAC__DUMMY_SWITCH__REFSEL VGND sky130_fd_pr__nfet_01v8 ad=1.16 pd=8.58 as=1.16 ps=8.58 w=4 l=0.15
X241 VIN DAC__SAMPLEB DAC__BOTTOM7 VPWR sky130_fd_pr__pfet_01v8_hvt ad=2.32 pd=16.58 as=2.32 ps=16.58 w=8 l=0.15
X242 TOP DAC__BOTTOM7 sky130_fd_pr__cap_mim_m3_1 l=6.89 w=6.89
X243 VPWR VGND DAC__DUMMY_SWITCH__BITB VPWR sky130_fd_pr__pfet_01v8_hvt ad=0.1885 pd=1.88 as=0.1885 ps=1.88 w=0.65 l=0.15
X244 TOP DAC__BOTTOM7 sky130_fd_pr__cap_mim_m3_1 l=6.89 w=6.89
X245 TOP DAC__BOTTOM7 sky130_fd_pr__cap_mim_m3_1 l=6.89 w=6.89
X246 TOP DAC__BOTTOM5 sky130_fd_pr__cap_mim_m3_1 l=6.89 w=6.89
X247 TOP DAC__BOTTOM7 sky130_fd_pr__cap_mim_m3_1 l=6.89 w=6.89
X248 DAC__BIT7__REFSEL DAC__SAMPLEB DAC__BOTTOM7 VGND sky130_fd_pr__nfet_01v8 ad=1.16 pd=8.58 as=1.16 ps=8.58 w=4 l=0.15
X249 VIN DAC__SAMPLEB DAC__BOTTOM3 VPWR sky130_fd_pr__pfet_01v8_hvt ad=2.32 pd=16.58 as=2.32 ps=16.58 w=8 l=0.15
X250 TOP DAC__BOTTOM6 sky130_fd_pr__cap_mim_m3_1 l=6.89 w=6.89
X251 TOP DAC__BOTTOM6 sky130_fd_pr__cap_mim_m3_1 l=6.89 w=6.89
X252 TOP DAC__BOTTOM3 sky130_fd_pr__cap_mim_m3_1 l=6.89 w=6.89
X253 TOP DAC__BOTTOM7 sky130_fd_pr__cap_mim_m3_1 l=6.89 w=6.89
X254 TOP DAC__BOTTOM7 sky130_fd_pr__cap_mim_m3_1 l=6.89 w=6.89
X255 TOP DAC__BOTTOM7 sky130_fd_pr__cap_mim_m3_1 l=6.89 w=6.89
X256 TOP DAC__BOTTOM6 sky130_fd_pr__cap_mim_m3_1 l=6.89 w=6.89
X257 VGND DAC__BIT6__BITB DAC__BIT6__REFSEL VGND sky130_fd_pr__nfet_01v8 ad=1.16 pd=8.58 as=1.16 ps=8.58 w=4 l=0.15
X258 VPWR B3 DAC__BIT3__BITB VPWR sky130_fd_pr__pfet_01v8_hvt ad=0.1885 pd=1.88 as=0.1885 ps=1.88 w=0.65 l=0.15
X259 DAC__BIT4__REFSEL SAMPLE DAC__BOTTOM4 VPWR sky130_fd_pr__pfet_01v8_hvt ad=2.32 pd=16.58 as=2.32 ps=16.58 w=8 l=0.15
X260 TOP DAC__BOTTOM7 sky130_fd_pr__cap_mim_m3_1 l=6.89 w=6.89
X261 VIN DAC__SAMPLEB DAC__BOTTOM4 VPWR sky130_fd_pr__pfet_01v8_hvt ad=2.32 pd=16.58 as=2.32 ps=16.58 w=8 l=0.15
X262 TOP DAC__BOTTOM7 sky130_fd_pr__cap_mim_m3_1 l=6.89 w=6.89
X263 TOP DAC__BOTTOM7 sky130_fd_pr__cap_mim_m3_1 l=6.89 w=6.89
X264 TOP DAC__BOTTOM7 sky130_fd_pr__cap_mim_m3_1 l=6.89 w=6.89
X265 TOP DAC__BOTTOM4 sky130_fd_pr__cap_mim_m3_1 l=6.89 w=6.89
X266 TOP DAC__BOTTOM4 sky130_fd_pr__cap_mim_m3_1 l=6.89 w=6.89
X267 DAC__BIT1__REFSEL DAC__SAMPLEB DAC__BOTTOM1 VGND sky130_fd_pr__nfet_01v8 ad=1.16 pd=8.58 as=1.16 ps=8.58 w=4 l=0.15
X268 TOP DAC__BOTTOM4 sky130_fd_pr__cap_mim_m3_1 l=6.89 w=6.89
X269 TOP DAC__BOTTOM6 sky130_fd_pr__cap_mim_m3_1 l=6.89 w=6.89
X270 TOP DAC__BOTTOM7 sky130_fd_pr__cap_mim_m3_1 l=6.89 w=6.89
X271 TOP DAC__BOTTOM6 sky130_fd_pr__cap_mim_m3_1 l=6.89 w=6.89
X272 VCM SAMPLE TOP VGND sky130_fd_pr__nfet_01v8 ad=1.16 pd=8.58 as=1.16 ps=8.58 w=4 l=0.15
X273 VPWR B4 DAC__BIT4__BITB VPWR sky130_fd_pr__pfet_01v8_hvt ad=0.1885 pd=1.88 as=0.1885 ps=1.88 w=0.65 l=0.15
X274 TOP DAC__BOTTOM7 sky130_fd_pr__cap_mim_m3_1 l=6.89 w=6.89
X275 TOP DAC__BOTTOM5 sky130_fd_pr__cap_mim_m3_1 l=6.89 w=6.89
X276 VPWR COMPARE__PREAMP__MIR COMPARE__PREAMP__MIR VPWR sky130_fd_pr__pfet_01v8_hvt ad=5.8 pd=40.58 as=5.8 ps=40.58 w=20 l=1
X277 VREF DAC__BIT4__BITB DAC__BIT4__REFSEL VPWR sky130_fd_pr__pfet_01v8_hvt ad=2.32 pd=16.58 as=2.32 ps=16.58 w=8 l=0.15
X278 VREF DAC__DUMMY_SWITCH__BITB DAC__DUMMY_SWITCH__REFSEL VPWR sky130_fd_pr__pfet_01v8_hvt ad=2.32 pd=16.58 as=2.32 ps=16.58 w=8 l=0.15
X279 VREF B1 DAC__BIT1__REFSEL VGND sky130_fd_pr__nfet_01v8 ad=1.16 pd=8.58 as=1.16 ps=8.58 w=4 l=0.15
X280 TOP DAC__BOTTOM4 sky130_fd_pr__cap_mim_m3_1 l=6.89 w=6.89
X281 TOP DAC__BOTTOM3 sky130_fd_pr__cap_mim_m3_1 l=6.89 w=6.89
X282 TOP DAC__BOTTOM5 sky130_fd_pr__cap_mim_m3_1 l=6.89 w=6.89
X283 VPWR B6 DAC__BIT6__BITB VPWR sky130_fd_pr__pfet_01v8_hvt ad=0.1885 pd=1.88 as=0.1885 ps=1.88 w=0.65 l=0.15
X284 DAC__BIT3__REFSEL SAMPLE DAC__BOTTOM3 VPWR sky130_fd_pr__pfet_01v8_hvt ad=2.32 pd=16.58 as=2.32 ps=16.58 w=8 l=0.15
X285 TOP DAC__BOTTOM7 sky130_fd_pr__cap_mim_m3_1 l=6.89 w=6.89
X286 TOP DAC__BOTTOM2 sky130_fd_pr__cap_mim_m3_1 l=6.89 w=6.89
X287 TOP DAC__BOTTOM7 sky130_fd_pr__cap_mim_m3_1 l=6.89 w=6.89
X288 TOP DAC__BOTTOM7 sky130_fd_pr__cap_mim_m3_1 l=6.89 w=6.89
X289 TOP DAC__BOTTOM6 sky130_fd_pr__cap_mim_m3_1 l=6.89 w=6.89
X290 TOP DAC__BOTTOM6 sky130_fd_pr__cap_mim_m3_1 l=6.89 w=6.89
X291 TOP DAC__BOTTOM5 sky130_fd_pr__cap_mim_m3_1 l=6.89 w=6.89
X292 VGND DAC__DUMMY_SWITCH__BITB DAC__DUMMY_SWITCH__REFSEL VGND sky130_fd_pr__nfet_01v8 ad=1.16 pd=8.58 as=1.16 ps=8.58 w=4 l=0.15
X293 DAC__BIT7__REFSEL SAMPLE DAC__BOTTOM7 VPWR sky130_fd_pr__pfet_01v8_hvt ad=2.32 pd=16.58 as=2.32 ps=16.58 w=8 l=0.15
X294 TOP DAC__BOTTOM7 sky130_fd_pr__cap_mim_m3_1 l=6.89 w=6.89
X295 TOP DAC__BOTTOM7 sky130_fd_pr__cap_mim_m3_1 l=6.89 w=6.89
X296 TOP DAC__BOTTOM6 sky130_fd_pr__cap_mim_m3_1 l=6.89 w=6.89
X297 TOP DAC__BOTTOM7 sky130_fd_pr__cap_mim_m3_1 l=6.89 w=6.89
X298 TOP DAC__BOTTOM1 sky130_fd_pr__cap_mim_m3_1 l=6.89 w=6.89
X299 VREF B5 DAC__BIT5__REFSEL VGND sky130_fd_pr__nfet_01v8 ad=1.16 pd=8.58 as=1.16 ps=8.58 w=4 l=0.15
X300 TOP DAC__BOTTOM7 sky130_fd_pr__cap_mim_m3_1 l=6.89 w=6.89
X301 TOP DAC__BOTTOM6 sky130_fd_pr__cap_mim_m3_1 l=6.89 w=6.89
X302 TOP DAC__BOTTOM5 sky130_fd_pr__cap_mim_m3_1 l=6.89 w=6.89
X303 VPWR COMPARE__PREAMP__MIR COMPARE__PRE VPWR sky130_fd_pr__pfet_01v8_hvt ad=5.8 pd=40.58 as=5.8 ps=40.58 w=20 l=1
X304 VPWR B5 DAC__BIT5__BITB VPWR sky130_fd_pr__pfet_01v8_hvt ad=0.1885 pd=1.88 as=0.1885 ps=1.88 w=0.65 l=0.15
X305 VREF DAC__BIT5__BITB DAC__BIT5__REFSEL VPWR sky130_fd_pr__pfet_01v8_hvt ad=2.32 pd=16.58 as=2.32 ps=16.58 w=8 l=0.15
X306 VREF DAC__BIT3__BITB DAC__BIT3__REFSEL VPWR sky130_fd_pr__pfet_01v8_hvt ad=2.32 pd=16.58 as=2.32 ps=16.58 w=8 l=0.15
X307 TOP DAC__BOTTOM7 sky130_fd_pr__cap_mim_m3_1 l=6.89 w=6.89
X308 TOP DAC__BOTTOM7 sky130_fd_pr__cap_mim_m3_1 l=6.89 w=6.89
X309 TOP DAC__BOTTOM7 sky130_fd_pr__cap_mim_m3_1 l=6.89 w=6.89
X310 TOP DAC__BOTTOM4 sky130_fd_pr__cap_mim_m3_1 l=6.89 w=6.89
X311 TOP DAC__BOTTOM6 sky130_fd_pr__cap_mim_m3_1 l=6.89 w=6.89
X312 TOP DAC__BOTTOM6 sky130_fd_pr__cap_mim_m3_1 l=6.89 w=6.89
X313 VGND DAC__BIT5__BITB DAC__BIT5__REFSEL VGND sky130_fd_pr__nfet_01v8 ad=1.16 pd=8.58 as=1.16 ps=8.58 w=4 l=0.15
X314 TOP DAC__BOTTOM6 sky130_fd_pr__cap_mim_m3_1 l=6.89 w=6.89
X315 VPWR B2 DAC__BIT2__BITB VPWR sky130_fd_pr__pfet_01v8_hvt ad=0.1885 pd=1.88 as=0.1885 ps=1.88 w=0.65 l=0.15
X316 VGND B4 DAC__BIT4__REFSEL VPWR sky130_fd_pr__pfet_01v8_hvt ad=2.32 pd=16.58 as=2.32 ps=16.58 w=8 l=0.15
X317 TOP DAC__BOTTOM7 sky130_fd_pr__cap_mim_m3_1 l=6.89 w=6.89
X318 VGND VGND DAC__DUMMY_SWITCH__BITB VGND sky130_fd_pr__nfet_01v8 ad=0.1885 pd=1.88 as=0.1885 ps=1.88 w=0.65 l=0.15
X319 VGND B6 DAC__BIT6__BITB VGND sky130_fd_pr__nfet_01v8 ad=0.1885 pd=1.88 as=0.1885 ps=1.88 w=0.65 l=0.15
X320 TOP DAC__BOTTOM7 sky130_fd_pr__cap_mim_m3_1 l=6.89 w=6.89
X321 TOP DAC__BOTTOM7 sky130_fd_pr__cap_mim_m3_1 l=6.89 w=6.89
X322 TOP DAC__BOTTOM3 sky130_fd_pr__cap_mim_m3_1 l=6.89 w=6.89
X323 TOP DAC__BOTTOM6 sky130_fd_pr__cap_mim_m3_1 l=6.89 w=6.89
X324 VGND DAC__BIT1__BITB DAC__BIT1__REFSEL VGND sky130_fd_pr__nfet_01v8 ad=1.16 pd=8.58 as=1.16 ps=8.58 w=4 l=0.15
X325 VREF DAC__BIT2__BITB DAC__BIT2__REFSEL VPWR sky130_fd_pr__pfet_01v8_hvt ad=2.32 pd=16.58 as=2.32 ps=16.58 w=8 l=0.15
X326 TOP DAC__BOTTOM7 sky130_fd_pr__cap_mim_m3_1 l=6.89 w=6.89
X327 VGND VGND DAC__DUMMY_SWITCH__REFSEL VPWR sky130_fd_pr__pfet_01v8_hvt ad=2.32 pd=16.58 as=2.32 ps=16.58 w=8 l=0.15
X328 VIN SAMPLE DAC__BOTTOM7 VGND sky130_fd_pr__nfet_01v8 ad=1.16 pd=8.58 as=1.16 ps=8.58 w=4 l=0.15
X329 TOP DAC__BOTTOM7 sky130_fd_pr__cap_mim_m3_1 l=6.89 w=6.89
X330 TOP DAC__BOTTOM6 sky130_fd_pr__cap_mim_m3_1 l=6.89 w=6.89
X331 VIN SAMPLE DAC__BOTTOM4 VGND sky130_fd_pr__nfet_01v8 ad=1.16 pd=8.58 as=1.16 ps=8.58 w=4 l=0.15
X332 TOP DAC__BOTTOM7 sky130_fd_pr__cap_mim_m3_1 l=6.89 w=6.89
X333 TOP DAC__BOTTOM4 sky130_fd_pr__cap_mim_m3_1 l=6.89 w=6.89
X334 TOP DAC__BOTTOM6 sky130_fd_pr__cap_mim_m3_1 l=6.89 w=6.89
X335 TOP DAC__BOTTOM7 sky130_fd_pr__cap_mim_m3_1 l=6.89 w=6.89
X336 TOP DAC__BOTTOM6 sky130_fd_pr__cap_mim_m3_1 l=6.89 w=6.89
X337 TOP DAC__BOTTOM4 sky130_fd_pr__cap_mim_m3_1 l=6.89 w=6.89
X338 TOP DAC__BOTTOM6 sky130_fd_pr__cap_mim_m3_1 l=6.89 w=6.89
X339 VIN SAMPLE DAC__DUMMY VGND sky130_fd_pr__nfet_01v8 ad=1.16 pd=8.58 as=1.16 ps=8.58 w=4 l=0.15
X340 VIN DAC__SAMPLEB DAC__DUMMY VPWR sky130_fd_pr__pfet_01v8_hvt ad=2.32 pd=16.58 as=2.32 ps=16.58 w=8 l=0.15
X341 TOP DAC__BOTTOM4 sky130_fd_pr__cap_mim_m3_1 l=6.89 w=6.89
X342 TOP DAC__BOTTOM7 sky130_fd_pr__cap_mim_m3_1 l=6.89 w=6.89
X343 TOP DAC__BOTTOM7 sky130_fd_pr__cap_mim_m3_1 l=6.89 w=6.89
X344 TOP DAC__BOTTOM5 sky130_fd_pr__cap_mim_m3_1 l=6.89 w=6.89
X345 DAC__DUMMY_SWITCH__REFSEL DAC__SAMPLEB DAC__DUMMY VGND sky130_fd_pr__nfet_01v8 ad=1.16 pd=8.58 as=1.16 ps=8.58 w=4 l=0.15
X346 VGND B3 DAC__BIT3__REFSEL VPWR sky130_fd_pr__pfet_01v8_hvt ad=2.32 pd=16.58 as=2.32 ps=16.58 w=8 l=0.15
X347 TOP DAC__BOTTOM7 sky130_fd_pr__cap_mim_m3_1 l=6.89 w=6.89
X348 TOP DAC__BOTTOM7 sky130_fd_pr__cap_mim_m3_1 l=6.89 w=6.89
X349 TOP DAC__BOTTOM5 sky130_fd_pr__cap_mim_m3_1 l=6.89 w=6.89
X350 TOP DAC__BOTTOM5 sky130_fd_pr__cap_mim_m3_1 l=6.89 w=6.89
X351 TOP DAC__BOTTOM4 sky130_fd_pr__cap_mim_m3_1 l=6.89 w=6.89
X352 DAC__BIT6__REFSEL DAC__SAMPLEB DAC__BOTTOM6 VGND sky130_fd_pr__nfet_01v8 ad=1.16 pd=8.58 as=1.16 ps=8.58 w=4 l=0.15
X353 TOP DAC__BOTTOM7 sky130_fd_pr__cap_mim_m3_1 l=6.89 w=6.89
X354 TOP DAC__BOTTOM7 sky130_fd_pr__cap_mim_m3_1 l=6.89 w=6.89
X355 TOP DAC__BOTTOM6 sky130_fd_pr__cap_mim_m3_1 l=6.89 w=6.89
X356 TOP DAC__BOTTOM6 sky130_fd_pr__cap_mim_m3_1 l=6.89 w=6.89
.ends

* NGSPICE file created from sar8_analog.ext - technology: sky130A

.subckt sar8_analog VREF VPWR VIN VGND B1 B2 SAMPLE B4 B5 B3 TOP B0 COMP B6 B7 BIAS
+ VCM
X0 VREF B5 DAC__BIT5__REFSEL VGND sky130_fd_pr__nfet_01v8 ad=1.16 pd=8.58 as=1.16 ps=8.58 w=4 l=0.15
X1 TOP DAC__BOTTOM7 sky130_fd_pr__cap_mim_m3_1 l=13.96 w=13.96
X2 TOP DAC__BOTTOM6 sky130_fd_pr__cap_mim_m3_1 l=13.96 w=13.96
X3 VPWR B5 DAC__BIT5__BITB VPWR sky130_fd_pr__pfet_01v8_hvt ad=0.1885 pd=1.88 as=0.1885 ps=1.88 w=0.65 l=0.15
X4 VREF DAC__BIT4__BITB DAC__BIT4__REFSEL VPWR sky130_fd_pr__pfet_01v8_hvt ad=2.32 pd=16.58 as=2.32 ps=16.58 w=8 l=0.15
X5 TOP DAC__BOTTOM7 sky130_fd_pr__cap_mim_m3_1 l=13.96 w=13.96
X6 TOP DAC__BOTTOM7 sky130_fd_pr__cap_mim_m3_1 l=13.96 w=13.96
X7 TOP DAC__BOTTOM6 sky130_fd_pr__cap_mim_m3_1 l=13.96 w=13.96
X8 TOP DAC__BOTTOM6 sky130_fd_pr__cap_mim_m3_1 l=13.96 w=13.96
X9 VIN SAMPLE DAC__BOTTOM6 VGND sky130_fd_pr__nfet_01v8 ad=1.16 pd=8.58 as=1.16 ps=8.58 w=4 l=0.15
X10 TOP DAC__BOTTOM5 sky130_fd_pr__cap_mim_m3_1 l=13.96 w=13.96
X11 TOP DAC__BOTTOM7 sky130_fd_pr__cap_mim_m3_1 l=13.96 w=13.96
X12 VREF DAC__BIT6__BITB DAC__BIT6__REFSEL VPWR sky130_fd_pr__pfet_01v8_hvt ad=2.32 pd=16.58 as=2.32 ps=16.58 w=8 l=0.15
X13 DAC__BIT6__REFSEL DAC__SAMPLEB DAC__BOTTOM6 VGND sky130_fd_pr__nfet_01v8 ad=1.16 pd=8.58 as=1.16 ps=8.58 w=4 l=0.15
X14 VREF B3 DAC__BIT3__REFSEL VGND sky130_fd_pr__nfet_01v8 ad=1.16 pd=8.58 as=1.16 ps=8.58 w=4 l=0.15
X15 VPWR B4 DAC__BIT4__BITB VPWR sky130_fd_pr__pfet_01v8_hvt ad=0.1885 pd=1.88 as=0.1885 ps=1.88 w=0.65 l=0.15
X16 TOP DAC__BOTTOM7 sky130_fd_pr__cap_mim_m3_1 l=13.96 w=13.96
X17 TOP DAC__BOTTOM7 sky130_fd_pr__cap_mim_m3_1 l=13.96 w=13.96
X18 TOP DAC__BOTTOM4 sky130_fd_pr__cap_mim_m3_1 l=13.96 w=13.96
X19 TOP DAC__BOTTOM6 sky130_fd_pr__cap_mim_m3_1 l=13.96 w=13.96
X20 VREF B2 DAC__BIT2__REFSEL VGND sky130_fd_pr__nfet_01v8 ad=1.16 pd=8.58 as=1.16 ps=8.58 w=4 l=0.15
X21 VGND DAC__BIT3__BITB DAC__BIT3__REFSEL VGND sky130_fd_pr__nfet_01v8 ad=1.16 pd=8.58 as=1.16 ps=8.58 w=4 l=0.15
X22 TOP DAC__BOTTOM5 sky130_fd_pr__cap_mim_m3_1 l=13.96 w=13.96
X23 TOP DAC__BOTTOM7 sky130_fd_pr__cap_mim_m3_1 l=13.96 w=13.96
X24 TOP DAC__BOTTOM7 sky130_fd_pr__cap_mim_m3_1 l=13.96 w=13.96
X25 TOP DAC__BOTTOM7 sky130_fd_pr__cap_mim_m3_1 l=13.96 w=13.96
X26 TOP DAC__BOTTOM7 sky130_fd_pr__cap_mim_m3_1 l=13.96 w=13.96
X27 TOP DAC__BOTTOM7 sky130_fd_pr__cap_mim_m3_1 l=13.96 w=13.96
X28 TOP DAC__BOTTOM5 sky130_fd_pr__cap_mim_m3_1 l=13.96 w=13.96
X29 TOP DAC__BOTTOM6 sky130_fd_pr__cap_mim_m3_1 l=13.96 w=13.96
X30 TOP DAC__BOTTOM4 sky130_fd_pr__cap_mim_m3_1 l=13.96 w=13.96
X31 TOP DAC__BOTTOM6 sky130_fd_pr__cap_mim_m3_1 l=13.96 w=13.96
X32 DAC__BIT3__REFSEL DAC__SAMPLEB DAC__BOTTOM3 VGND sky130_fd_pr__nfet_01v8 ad=1.16 pd=8.58 as=1.16 ps=8.58 w=4 l=0.15
X33 TOP DAC__BOTTOM7 sky130_fd_pr__cap_mim_m3_1 l=13.96 w=13.96
X34 TOP DAC__BOTTOM0 sky130_fd_pr__cap_mim_m3_1 l=13.96 w=13.96
X35 TOP DAC__BOTTOM7 sky130_fd_pr__cap_mim_m3_1 l=13.96 w=13.96
X36 TOP DAC__BOTTOM4 sky130_fd_pr__cap_mim_m3_1 l=13.96 w=13.96
X37 TOP DAC__BOTTOM5 sky130_fd_pr__cap_mim_m3_1 l=13.96 w=13.96
X38 TOP DAC__BOTTOM7 sky130_fd_pr__cap_mim_m3_1 l=13.96 w=13.96
X39 TOP DAC__BOTTOM7 sky130_fd_pr__cap_mim_m3_1 l=13.96 w=13.96
X40 TOP DAC__BOTTOM6 sky130_fd_pr__cap_mim_m3_1 l=13.96 w=13.96
X41 TOP DAC__BOTTOM6 sky130_fd_pr__cap_mim_m3_1 l=13.96 w=13.96
X42 VGND B6 DAC__BIT6__REFSEL VPWR sky130_fd_pr__pfet_01v8_hvt ad=2.32 pd=16.58 as=2.32 ps=16.58 w=8 l=0.15
X43 TOP DAC__BOTTOM7 sky130_fd_pr__cap_mim_m3_1 l=13.96 w=13.96
X44 TOP DAC__BOTTOM7 sky130_fd_pr__cap_mim_m3_1 l=13.96 w=13.96
X45 TOP DAC__BOTTOM7 sky130_fd_pr__cap_mim_m3_1 l=13.96 w=13.96
X46 TOP DAC__BOTTOM6 sky130_fd_pr__cap_mim_m3_1 l=13.96 w=13.96
X47 TOP DAC__BOTTOM5 sky130_fd_pr__cap_mim_m3_1 l=13.96 w=13.96
X48 TOP DAC__BOTTOM7 sky130_fd_pr__cap_mim_m3_1 l=13.96 w=13.96
X49 TOP DAC__BOTTOM6 sky130_fd_pr__cap_mim_m3_1 l=13.96 w=13.96
X50 VGND SAMPLE DAC__SAMPLEB VGND sky130_fd_pr__nfet_01v8 ad=0.1885 pd=1.88 as=0.1885 ps=1.88 w=0.65 l=0.15
X51 TOP DAC__BOTTOM7 sky130_fd_pr__cap_mim_m3_1 l=13.96 w=13.96
X52 TOP DAC__BOTTOM4 sky130_fd_pr__cap_mim_m3_1 l=13.96 w=13.96
X53 VIN DAC__SAMPLEB DAC__BOTTOM6 VPWR sky130_fd_pr__pfet_01v8_hvt ad=2.32 pd=16.58 as=2.32 ps=16.58 w=8 l=0.15
X54 DAC__BIT4__REFSEL DAC__SAMPLEB DAC__BOTTOM4 VGND sky130_fd_pr__nfet_01v8 ad=1.16 pd=8.58 as=1.16 ps=8.58 w=4 l=0.15
X55 TOP DAC__BOTTOM7 sky130_fd_pr__cap_mim_m3_1 l=13.96 w=13.96
X56 TOP DAC__BOTTOM6 sky130_fd_pr__cap_mim_m3_1 l=13.96 w=13.96
X57 TOP DAC__BOTTOM2 sky130_fd_pr__cap_mim_m3_1 l=13.96 w=13.96
X58 TOP DAC__BOTTOM7 sky130_fd_pr__cap_mim_m3_1 l=13.96 w=13.96
X59 TOP DAC__BOTTOM6 sky130_fd_pr__cap_mim_m3_1 l=13.96 w=13.96
X60 TOP DAC__BOTTOM7 sky130_fd_pr__cap_mim_m3_1 l=13.96 w=13.96
X61 TOP DAC__BOTTOM7 sky130_fd_pr__cap_mim_m3_1 l=13.96 w=13.96
X62 DAC__BIT6__REFSEL SAMPLE DAC__BOTTOM6 VPWR sky130_fd_pr__pfet_01v8_hvt ad=2.32 pd=16.58 as=2.32 ps=16.58 w=8 l=0.15
X63 TOP DAC__BOTTOM4 sky130_fd_pr__cap_mim_m3_1 l=13.96 w=13.96
X64 TOP DAC__BOTTOM6 sky130_fd_pr__cap_mim_m3_1 l=13.96 w=13.96
X65 TOP DAC__BOTTOM5 sky130_fd_pr__cap_mim_m3_1 l=13.96 w=13.96
X66 TOP DAC__BOTTOM7 sky130_fd_pr__cap_mim_m3_1 l=13.96 w=13.96
X67 TOP DAC__BOTTOM7 sky130_fd_pr__cap_mim_m3_1 l=13.96 w=13.96
X68 TOP DAC__BOTTOM6 sky130_fd_pr__cap_mim_m3_1 l=13.96 w=13.96
X69 TOP DAC__BOTTOM4 sky130_fd_pr__cap_mim_m3_1 l=13.96 w=13.96
X70 DAC__BIT1__REFSEL SAMPLE DAC__BOTTOM1 VPWR sky130_fd_pr__pfet_01v8_hvt ad=2.32 pd=16.58 as=2.32 ps=16.58 w=8 l=0.15
X71 TOP DAC__BOTTOM7 sky130_fd_pr__cap_mim_m3_1 l=13.96 w=13.96
X72 TOP DAC__BOTTOM6 sky130_fd_pr__cap_mim_m3_1 l=13.96 w=13.96
X73 TOP DAC__BOTTOM6 sky130_fd_pr__cap_mim_m3_1 l=13.96 w=13.96
X74 VIN DAC__SAMPLEB DAC__BOTTOM1 VPWR sky130_fd_pr__pfet_01v8_hvt ad=2.32 pd=16.58 as=2.32 ps=16.58 w=8 l=0.15
X75 TOP DAC__BOTTOM7 sky130_fd_pr__cap_mim_m3_1 l=13.96 w=13.96
X76 TOP DAC__BOTTOM7 sky130_fd_pr__cap_mim_m3_1 l=13.96 w=13.96
X77 TOP DAC__BOTTOM7 sky130_fd_pr__cap_mim_m3_1 l=13.96 w=13.96
X78 TOP DAC__BOTTOM7 sky130_fd_pr__cap_mim_m3_1 l=13.96 w=13.96
X79 VIN SAMPLE DAC__BOTTOM5 VGND sky130_fd_pr__nfet_01v8 ad=1.16 pd=8.58 as=1.16 ps=8.58 w=4 l=0.15
X80 VIN SAMPLE DAC__BOTTOM3 VGND sky130_fd_pr__nfet_01v8 ad=1.16 pd=8.58 as=1.16 ps=8.58 w=4 l=0.15
X81 TOP DAC__BOTTOM7 sky130_fd_pr__cap_mim_m3_1 l=13.96 w=13.96
X82 TOP DAC__BOTTOM2 sky130_fd_pr__cap_mim_m3_1 l=13.96 w=13.96
X83 VIN DAC__SAMPLEB DAC__BOTTOM5 VPWR sky130_fd_pr__pfet_01v8_hvt ad=2.32 pd=16.58 as=2.32 ps=16.58 w=8 l=0.15
X84 DAC__BIT0__REFSEL DAC__SAMPLEB DAC__BOTTOM0 VGND sky130_fd_pr__nfet_01v8 ad=1.16 pd=8.58 as=1.16 ps=8.58 w=4 l=0.15
X85 TOP DAC__BOTTOM7 sky130_fd_pr__cap_mim_m3_1 l=13.96 w=13.96
X86 TOP DAC__BOTTOM6 sky130_fd_pr__cap_mim_m3_1 l=13.96 w=13.96
X87 TOP DAC__BOTTOM5 sky130_fd_pr__cap_mim_m3_1 l=13.96 w=13.96
X88 TOP DAC__BOTTOM6 sky130_fd_pr__cap_mim_m3_1 l=13.96 w=13.96
X89 VIN SAMPLE DAC__BOTTOM0 VGND sky130_fd_pr__nfet_01v8 ad=1.16 pd=8.58 as=1.16 ps=8.58 w=4 l=0.15
X90 TOP DAC__BOTTOM7 sky130_fd_pr__cap_mim_m3_1 l=13.96 w=13.96
X91 TOP DAC__BOTTOM7 sky130_fd_pr__cap_mim_m3_1 l=13.96 w=13.96
X92 TOP DAC__BOTTOM6 sky130_fd_pr__cap_mim_m3_1 l=13.96 w=13.96
X93 TOP DAC__BOTTOM7 sky130_fd_pr__cap_mim_m3_1 l=13.96 w=13.96
X94 TOP DAC__BOTTOM7 sky130_fd_pr__cap_mim_m3_1 l=13.96 w=13.96
X95 VPWR B7 DAC__BIT7__BITB VPWR sky130_fd_pr__pfet_01v8_hvt ad=0.1885 pd=1.88 as=0.1885 ps=1.88 w=0.65 l=0.15
X96 TOP DAC__BOTTOM7 sky130_fd_pr__cap_mim_m3_1 l=13.96 w=13.96
X97 TOP DAC__BOTTOM6 sky130_fd_pr__cap_mim_m3_1 l=13.96 w=13.96
X98 TOP DAC__BOTTOM7 sky130_fd_pr__cap_mim_m3_1 l=13.96 w=13.96
X99 TOP DAC__BOTTOM6 sky130_fd_pr__cap_mim_m3_1 l=13.96 w=13.96
X100 TOP DAC__BOTTOM5 sky130_fd_pr__cap_mim_m3_1 l=13.96 w=13.96
X101 TOP DAC__BOTTOM4 sky130_fd_pr__cap_mim_m3_1 l=13.96 w=13.96
X102 VPWR COMPARE__PRE COMP VPWR sky130_fd_pr__pfet_01v8_hvt ad=2.32 pd=16.58 as=2.32 ps=16.58 w=8 l=0.15
X103 VREF B0 DAC__BIT0__REFSEL VGND sky130_fd_pr__nfet_01v8 ad=1.16 pd=8.58 as=1.16 ps=8.58 w=4 l=0.15
X104 VIN DAC__SAMPLEB DAC__BOTTOM2 VPWR sky130_fd_pr__pfet_01v8_hvt ad=2.32 pd=16.58 as=2.32 ps=16.58 w=8 l=0.15
X105 TOP DAC__BOTTOM7 sky130_fd_pr__cap_mim_m3_1 l=13.96 w=13.96
X106 TOP DAC__BOTTOM7 sky130_fd_pr__cap_mim_m3_1 l=13.96 w=13.96
X107 TOP DAC__BOTTOM7 sky130_fd_pr__cap_mim_m3_1 l=13.96 w=13.96
X108 TOP DAC__BOTTOM7 sky130_fd_pr__cap_mim_m3_1 l=13.96 w=13.96
X109 TOP DAC__BOTTOM6 sky130_fd_pr__cap_mim_m3_1 l=13.96 w=13.96
X110 VGND VGND DAC__DUMMY_SWITCH__REFSEL VPWR sky130_fd_pr__pfet_01v8_hvt ad=2.32 pd=16.58 as=2.32 ps=16.58 w=8 l=0.15
X111 VGND B2 DAC__BIT2__REFSEL VPWR sky130_fd_pr__pfet_01v8_hvt ad=2.32 pd=16.58 as=2.32 ps=16.58 w=8 l=0.15
X112 TOP DAC__BOTTOM2 sky130_fd_pr__cap_mim_m3_1 l=13.96 w=13.96
X113 TOP DAC__BOTTOM5 sky130_fd_pr__cap_mim_m3_1 l=13.96 w=13.96
X114 TOP DAC__BOTTOM4 sky130_fd_pr__cap_mim_m3_1 l=13.96 w=13.96
X115 TOP DAC__BOTTOM7 sky130_fd_pr__cap_mim_m3_1 l=13.96 w=13.96
X116 TOP DAC__BOTTOM5 sky130_fd_pr__cap_mim_m3_1 l=13.96 w=13.96
X117 VIN SAMPLE DAC__DUMMY VGND sky130_fd_pr__nfet_01v8 ad=1.16 pd=8.58 as=1.16 ps=8.58 w=4 l=0.15
X118 VIN DAC__SAMPLEB DAC__DUMMY VPWR sky130_fd_pr__pfet_01v8_hvt ad=2.32 pd=16.58 as=2.32 ps=16.58 w=8 l=0.15
X119 VREF DAC__BIT1__BITB DAC__BIT1__REFSEL VPWR sky130_fd_pr__pfet_01v8_hvt ad=2.32 pd=16.58 as=2.32 ps=16.58 w=8 l=0.15
X120 TOP DAC__BOTTOM7 sky130_fd_pr__cap_mim_m3_1 l=13.96 w=13.96
X121 TOP DAC__BOTTOM4 sky130_fd_pr__cap_mim_m3_1 l=13.96 w=13.96
X122 VREF B7 DAC__BIT7__REFSEL VGND sky130_fd_pr__nfet_01v8 ad=1.16 pd=8.58 as=1.16 ps=8.58 w=4 l=0.15
X123 TOP DAC__BOTTOM7 sky130_fd_pr__cap_mim_m3_1 l=13.96 w=13.96
X124 TOP DAC__BOTTOM7 sky130_fd_pr__cap_mim_m3_1 l=13.96 w=13.96
X125 TOP DAC__BOTTOM6 sky130_fd_pr__cap_mim_m3_1 l=13.96 w=13.96
X126 TOP DAC__BOTTOM7 sky130_fd_pr__cap_mim_m3_1 l=13.96 w=13.96
X127 TOP DAC__BOTTOM5 sky130_fd_pr__cap_mim_m3_1 l=13.96 w=13.96
X128 TOP DAC__BOTTOM6 sky130_fd_pr__cap_mim_m3_1 l=13.96 w=13.96
X129 DAC__DUMMY_SWITCH__REFSEL DAC__SAMPLEB DAC__DUMMY VGND sky130_fd_pr__nfet_01v8 ad=1.16 pd=8.58 as=1.16 ps=8.58 w=4 l=0.15
X130 VGND BIAS COMPARE__PREAMP__TAIL VGND sky130_fd_pr__nfet_01v8 ad=0.58 pd=4.58 as=0.58 ps=4.58 w=2 l=1
X131 VPWR B1 DAC__BIT1__BITB VPWR sky130_fd_pr__pfet_01v8_hvt ad=0.1885 pd=1.88 as=0.1885 ps=1.88 w=0.65 l=0.15
X132 VPWR B3 DAC__BIT3__BITB VPWR sky130_fd_pr__pfet_01v8_hvt ad=0.1885 pd=1.88 as=0.1885 ps=1.88 w=0.65 l=0.15
X133 TOP DAC__BOTTOM7 sky130_fd_pr__cap_mim_m3_1 l=13.96 w=13.96
X134 VGND DAC__BIT7__BITB DAC__BIT7__REFSEL VGND sky130_fd_pr__nfet_01v8 ad=1.16 pd=8.58 as=1.16 ps=8.58 w=4 l=0.15
X135 VPWR B2 DAC__BIT2__BITB VPWR sky130_fd_pr__pfet_01v8_hvt ad=0.1885 pd=1.88 as=0.1885 ps=1.88 w=0.65 l=0.15
X136 TOP DAC__BOTTOM7 sky130_fd_pr__cap_mim_m3_1 l=13.96 w=13.96
X137 TOP DAC__BOTTOM7 sky130_fd_pr__cap_mim_m3_1 l=13.96 w=13.96
X138 TOP DAC__BOTTOM7 sky130_fd_pr__cap_mim_m3_1 l=13.96 w=13.96
X139 VGND DAC__BIT0__BITB DAC__BIT0__REFSEL VGND sky130_fd_pr__nfet_01v8 ad=1.16 pd=8.58 as=1.16 ps=8.58 w=4 l=0.15
X140 TOP DAC__BOTTOM7 sky130_fd_pr__cap_mim_m3_1 l=13.96 w=13.96
X141 VREF B6 DAC__BIT6__REFSEL VGND sky130_fd_pr__nfet_01v8 ad=1.16 pd=8.58 as=1.16 ps=8.58 w=4 l=0.15
X142 TOP DAC__BOTTOM7 sky130_fd_pr__cap_mim_m3_1 l=13.96 w=13.96
X143 TOP DAC__BOTTOM7 sky130_fd_pr__cap_mim_m3_1 l=13.96 w=13.96
X144 TOP DAC__BOTTOM5 sky130_fd_pr__cap_mim_m3_1 l=13.96 w=13.96
X145 VPWR COMPARE__PREAMP__MIR COMPARE__PRE VPWR sky130_fd_pr__pfet_01v8_hvt ad=5.8 pd=40.58 as=5.8 ps=40.58 w=20 l=1
X146 TOP DAC__BOTTOM7 sky130_fd_pr__cap_mim_m3_1 l=13.96 w=13.96
X147 TOP DAC__BOTTOM7 sky130_fd_pr__cap_mim_m3_1 l=13.96 w=13.96
X148 TOP DAC__BOTTOM5 sky130_fd_pr__cap_mim_m3_1 l=13.96 w=13.96
X149 TOP DAC__BOTTOM5 sky130_fd_pr__cap_mim_m3_1 l=13.96 w=13.96
X150 TOP DAC__BOTTOM7 sky130_fd_pr__cap_mim_m3_1 l=13.96 w=13.96
X151 TOP DAC__BOTTOM7 sky130_fd_pr__cap_mim_m3_1 l=13.96 w=13.96
X152 TOP DAC__BOTTOM7 sky130_fd_pr__cap_mim_m3_1 l=13.96 w=13.96
X153 TOP DAC__BOTTOM6 sky130_fd_pr__cap_mim_m3_1 l=13.96 w=13.96
X154 TOP DAC__BOTTOM5 sky130_fd_pr__cap_mim_m3_1 l=13.96 w=13.96
X155 TOP DAC__BOTTOM6 sky130_fd_pr__cap_mim_m3_1 l=13.96 w=13.96
X156 TOP DAC__BOTTOM6 sky130_fd_pr__cap_mim_m3_1 l=13.96 w=13.96
X157 VPWR COMPARE__PREAMP__MIR COMPARE__PREAMP__MIR VPWR sky130_fd_pr__pfet_01v8_hvt ad=5.8 pd=40.58 as=5.8 ps=40.58 w=20 l=1
X158 VGND B1 DAC__BIT1__REFSEL VPWR sky130_fd_pr__pfet_01v8_hvt ad=2.32 pd=16.58 as=2.32 ps=16.58 w=8 l=0.15
X159 VREF DAC__BIT2__BITB DAC__BIT2__REFSEL VPWR sky130_fd_pr__pfet_01v8_hvt ad=2.32 pd=16.58 as=2.32 ps=16.58 w=8 l=0.15
X160 TOP DAC__BOTTOM7 sky130_fd_pr__cap_mim_m3_1 l=13.96 w=13.96
X161 TOP DAC__BOTTOM7 sky130_fd_pr__cap_mim_m3_1 l=13.96 w=13.96
X162 TOP DAC__BOTTOM6 sky130_fd_pr__cap_mim_m3_1 l=13.96 w=13.96
X163 TOP DAC__BOTTOM3 sky130_fd_pr__cap_mim_m3_1 l=13.96 w=13.96
X164 TOP DAC__BOTTOM5 sky130_fd_pr__cap_mim_m3_1 l=13.96 w=13.96
X165 DAC__DUMMY_SWITCH__REFSEL SAMPLE DAC__DUMMY VPWR sky130_fd_pr__pfet_01v8_hvt ad=2.32 pd=16.58 as=2.32 ps=16.58 w=8 l=0.15
X166 TOP DAC__BOTTOM1 sky130_fd_pr__cap_mim_m3_1 l=13.96 w=13.96
X167 TOP DAC__BOTTOM5 sky130_fd_pr__cap_mim_m3_1 l=13.96 w=13.96
X168 VREF DAC__BIT7__BITB DAC__BIT7__REFSEL VPWR sky130_fd_pr__pfet_01v8_hvt ad=2.32 pd=16.58 as=2.32 ps=16.58 w=8 l=0.15
X169 TOP DAC__BOTTOM7 sky130_fd_pr__cap_mim_m3_1 l=13.96 w=13.96
X170 TOP DAC__BOTTOM6 sky130_fd_pr__cap_mim_m3_1 l=13.96 w=13.96
X171 TOP DAC__BOTTOM7 sky130_fd_pr__cap_mim_m3_1 l=13.96 w=13.96
X172 TOP DAC__BOTTOM7 sky130_fd_pr__cap_mim_m3_1 l=13.96 w=13.96
X173 TOP DAC__BOTTOM6 sky130_fd_pr__cap_mim_m3_1 l=13.96 w=13.96
X174 TOP DAC__BOTTOM6 sky130_fd_pr__cap_mim_m3_1 l=13.96 w=13.96
X175 TOP DAC__BOTTOM7 sky130_fd_pr__cap_mim_m3_1 l=13.96 w=13.96
X176 VGND B0 DAC__BIT0__BITB VGND sky130_fd_pr__nfet_01v8 ad=0.1885 pd=1.88 as=0.1885 ps=1.88 w=0.65 l=0.15
X177 TOP DAC__BOTTOM7 sky130_fd_pr__cap_mim_m3_1 l=13.96 w=13.96
X178 TOP DAC__BOTTOM4 sky130_fd_pr__cap_mim_m3_1 l=13.96 w=13.96
X179 DAC__BIT3__REFSEL SAMPLE DAC__BOTTOM3 VPWR sky130_fd_pr__pfet_01v8_hvt ad=2.32 pd=16.58 as=2.32 ps=16.58 w=8 l=0.15
X180 VIN SAMPLE DAC__BOTTOM4 VGND sky130_fd_pr__nfet_01v8 ad=1.16 pd=8.58 as=1.16 ps=8.58 w=4 l=0.15
X181 TOP DAC__BOTTOM7 sky130_fd_pr__cap_mim_m3_1 l=13.96 w=13.96
X182 TOP DAC__BOTTOM7 sky130_fd_pr__cap_mim_m3_1 l=13.96 w=13.96
X183 TOP DAC__BOTTOM7 sky130_fd_pr__cap_mim_m3_1 l=13.96 w=13.96
X184 TOP DAC__DUMMY sky130_fd_pr__cap_mim_m3_1 l=13.96 w=13.96
X185 TOP DAC__BOTTOM7 sky130_fd_pr__cap_mim_m3_1 l=13.96 w=13.96
X186 TOP DAC__BOTTOM6 sky130_fd_pr__cap_mim_m3_1 l=13.96 w=13.96
X187 TOP DAC__BOTTOM6 sky130_fd_pr__cap_mim_m3_1 l=13.96 w=13.96
X188 TOP DAC__BOTTOM3 sky130_fd_pr__cap_mim_m3_1 l=13.96 w=13.96
X189 TOP DAC__BOTTOM6 sky130_fd_pr__cap_mim_m3_1 l=13.96 w=13.96
X190 TOP DAC__BOTTOM7 sky130_fd_pr__cap_mim_m3_1 l=13.96 w=13.96
X191 TOP DAC__BOTTOM7 sky130_fd_pr__cap_mim_m3_1 l=13.96 w=13.96
X192 TOP DAC__BOTTOM3 sky130_fd_pr__cap_mim_m3_1 l=13.96 w=13.96
X193 TOP DAC__BOTTOM5 sky130_fd_pr__cap_mim_m3_1 l=13.96 w=13.96
X194 TOP DAC__BOTTOM6 sky130_fd_pr__cap_mim_m3_1 l=13.96 w=13.96
X195 TOP DAC__BOTTOM7 sky130_fd_pr__cap_mim_m3_1 l=13.96 w=13.96
X196 TOP DAC__BOTTOM7 sky130_fd_pr__cap_mim_m3_1 l=13.96 w=13.96
X197 TOP DAC__BOTTOM7 sky130_fd_pr__cap_mim_m3_1 l=13.96 w=13.96
X198 VREF B4 DAC__BIT4__REFSEL VGND sky130_fd_pr__nfet_01v8 ad=1.16 pd=8.58 as=1.16 ps=8.58 w=4 l=0.15
X199 TOP DAC__BOTTOM7 sky130_fd_pr__cap_mim_m3_1 l=13.96 w=13.96
X200 VIN DAC__SAMPLEB DAC__BOTTOM0 VPWR sky130_fd_pr__pfet_01v8_hvt ad=2.32 pd=16.58 as=2.32 ps=16.58 w=8 l=0.15
X201 TOP DAC__BOTTOM7 sky130_fd_pr__cap_mim_m3_1 l=13.96 w=13.96
X202 TOP DAC__BOTTOM7 sky130_fd_pr__cap_mim_m3_1 l=13.96 w=13.96
X203 TOP DAC__BOTTOM6 sky130_fd_pr__cap_mim_m3_1 l=13.96 w=13.96
X204 TOP DAC__BOTTOM6 sky130_fd_pr__cap_mim_m3_1 l=13.96 w=13.96
X205 VGND B0 DAC__BIT0__REFSEL VPWR sky130_fd_pr__pfet_01v8_hvt ad=2.32 pd=16.58 as=2.32 ps=16.58 w=8 l=0.15
X206 VREF B1 DAC__BIT1__REFSEL VGND sky130_fd_pr__nfet_01v8 ad=1.16 pd=8.58 as=1.16 ps=8.58 w=4 l=0.15
X207 TOP DAC__BOTTOM7 sky130_fd_pr__cap_mim_m3_1 l=13.96 w=13.96
X208 TOP DAC__BOTTOM4 sky130_fd_pr__cap_mim_m3_1 l=13.96 w=13.96
X209 TOP DAC__BOTTOM6 sky130_fd_pr__cap_mim_m3_1 l=13.96 w=13.96
X210 TOP DAC__BOTTOM6 sky130_fd_pr__cap_mim_m3_1 l=13.96 w=13.96
X211 VGND B7 DAC__BIT7__BITB VGND sky130_fd_pr__nfet_01v8 ad=0.1885 pd=1.88 as=0.1885 ps=1.88 w=0.65 l=0.15
X212 TOP DAC__BOTTOM7 sky130_fd_pr__cap_mim_m3_1 l=13.96 w=13.96
X213 TOP DAC__BOTTOM7 sky130_fd_pr__cap_mim_m3_1 l=13.96 w=13.96
X214 TOP DAC__BOTTOM7 sky130_fd_pr__cap_mim_m3_1 l=13.96 w=13.96
X215 TOP DAC__BOTTOM5 sky130_fd_pr__cap_mim_m3_1 l=13.96 w=13.96
X216 TOP DAC__BOTTOM7 sky130_fd_pr__cap_mim_m3_1 l=13.96 w=13.96
X217 TOP DAC__BOTTOM5 sky130_fd_pr__cap_mim_m3_1 l=13.96 w=13.96
X218 VGND COMPARE__PRE COMP VGND sky130_fd_pr__nfet_01v8 ad=1.16 pd=8.58 as=1.16 ps=8.58 w=4 l=0.15
X219 VPWR B6 DAC__BIT6__BITB VPWR sky130_fd_pr__pfet_01v8_hvt ad=0.1885 pd=1.88 as=0.1885 ps=1.88 w=0.65 l=0.15
X220 TOP DAC__BOTTOM7 sky130_fd_pr__cap_mim_m3_1 l=13.96 w=13.96
X221 TOP DAC__BOTTOM7 sky130_fd_pr__cap_mim_m3_1 l=13.96 w=13.96
X222 TOP DAC__BOTTOM1 sky130_fd_pr__cap_mim_m3_1 l=13.96 w=13.96
X223 TOP DAC__BOTTOM6 sky130_fd_pr__cap_mim_m3_1 l=13.96 w=13.96
X224 TOP DAC__BOTTOM6 sky130_fd_pr__cap_mim_m3_1 l=13.96 w=13.96
X225 TOP DAC__BOTTOM5 sky130_fd_pr__cap_mim_m3_1 l=13.96 w=13.96
X226 TOP DAC__BOTTOM4 sky130_fd_pr__cap_mim_m3_1 l=13.96 w=13.96
X227 VGND B5 DAC__BIT5__BITB VGND sky130_fd_pr__nfet_01v8 ad=0.1885 pd=1.88 as=0.1885 ps=1.88 w=0.65 l=0.15
X228 TOP DAC__BOTTOM7 sky130_fd_pr__cap_mim_m3_1 l=13.96 w=13.96
X229 TOP DAC__BOTTOM7 sky130_fd_pr__cap_mim_m3_1 l=13.96 w=13.96
X230 TOP DAC__BOTTOM5 sky130_fd_pr__cap_mim_m3_1 l=13.96 w=13.96
X231 VPWR SAMPLE DAC__SAMPLEB VPWR sky130_fd_pr__pfet_01v8_hvt ad=0.1885 pd=1.88 as=0.1885 ps=1.88 w=0.65 l=0.15
X232 DAC__BIT2__REFSEL DAC__SAMPLEB DAC__BOTTOM2 VGND sky130_fd_pr__nfet_01v8 ad=1.16 pd=8.58 as=1.16 ps=8.58 w=4 l=0.15
X233 VPWR VGND DAC__DUMMY_SWITCH__BITB VPWR sky130_fd_pr__pfet_01v8_hvt ad=0.1885 pd=1.88 as=0.1885 ps=1.88 w=0.65 l=0.15
X234 VPWR B0 DAC__BIT0__BITB VPWR sky130_fd_pr__pfet_01v8_hvt ad=0.1885 pd=1.88 as=0.1885 ps=1.88 w=0.65 l=0.15
X235 TOP DAC__BOTTOM6 sky130_fd_pr__cap_mim_m3_1 l=13.96 w=13.96
X236 VIN SAMPLE DAC__BOTTOM2 VGND sky130_fd_pr__nfet_01v8 ad=1.16 pd=8.58 as=1.16 ps=8.58 w=4 l=0.15
X237 TOP DAC__BOTTOM6 sky130_fd_pr__cap_mim_m3_1 l=13.96 w=13.96
X238 TOP DAC__BOTTOM5 sky130_fd_pr__cap_mim_m3_1 l=13.96 w=13.96
X239 TOP DAC__BOTTOM4 sky130_fd_pr__cap_mim_m3_1 l=13.96 w=13.96
X240 VGND DAC__BIT4__BITB DAC__BIT4__REFSEL VGND sky130_fd_pr__nfet_01v8 ad=1.16 pd=8.58 as=1.16 ps=8.58 w=4 l=0.15
X241 TOP DAC__BOTTOM7 sky130_fd_pr__cap_mim_m3_1 l=13.96 w=13.96
X242 TOP DAC__BOTTOM2 sky130_fd_pr__cap_mim_m3_1 l=13.96 w=13.96
X243 DAC__BIT0__REFSEL SAMPLE DAC__BOTTOM0 VPWR sky130_fd_pr__pfet_01v8_hvt ad=2.32 pd=16.58 as=2.32 ps=16.58 w=8 l=0.15
X244 DAC__BIT2__REFSEL SAMPLE DAC__BOTTOM2 VPWR sky130_fd_pr__pfet_01v8_hvt ad=2.32 pd=16.58 as=2.32 ps=16.58 w=8 l=0.15
X245 TOP DAC__BOTTOM4 sky130_fd_pr__cap_mim_m3_1 l=13.96 w=13.96
X246 TOP DAC__BOTTOM7 sky130_fd_pr__cap_mim_m3_1 l=13.96 w=13.96
X247 VGND DAC__BIT1__BITB DAC__BIT1__REFSEL VGND sky130_fd_pr__nfet_01v8 ad=1.16 pd=8.58 as=1.16 ps=8.58 w=4 l=0.15
X248 TOP DAC__BOTTOM7 sky130_fd_pr__cap_mim_m3_1 l=13.96 w=13.96
X249 TOP DAC__BOTTOM7 sky130_fd_pr__cap_mim_m3_1 l=13.96 w=13.96
X250 TOP DAC__BOTTOM7 sky130_fd_pr__cap_mim_m3_1 l=13.96 w=13.96
X251 TOP DAC__BOTTOM5 sky130_fd_pr__cap_mim_m3_1 l=13.96 w=13.96
X252 DAC__BIT5__REFSEL DAC__SAMPLEB DAC__BOTTOM5 VGND sky130_fd_pr__nfet_01v8 ad=1.16 pd=8.58 as=1.16 ps=8.58 w=4 l=0.15
X253 TOP DAC__BOTTOM7 sky130_fd_pr__cap_mim_m3_1 l=13.96 w=13.96
X254 VGND B6 DAC__BIT6__BITB VGND sky130_fd_pr__nfet_01v8 ad=0.1885 pd=1.88 as=0.1885 ps=1.88 w=0.65 l=0.15
X255 TOP DAC__BOTTOM6 sky130_fd_pr__cap_mim_m3_1 l=13.96 w=13.96
X256 TOP DAC__BOTTOM6 sky130_fd_pr__cap_mim_m3_1 l=13.96 w=13.96
X257 VIN DAC__SAMPLEB DAC__BOTTOM7 VPWR sky130_fd_pr__pfet_01v8_hvt ad=2.32 pd=16.58 as=2.32 ps=16.58 w=8 l=0.15
X258 VCM DAC__SAMPLEB TOP VPWR sky130_fd_pr__pfet_01v8_hvt ad=2.32 pd=16.58 as=2.32 ps=16.58 w=8 l=0.15
X259 VREF DAC__BIT3__BITB DAC__BIT3__REFSEL VPWR sky130_fd_pr__pfet_01v8_hvt ad=2.32 pd=16.58 as=2.32 ps=16.58 w=8 l=0.15
X260 TOP DAC__BOTTOM3 sky130_fd_pr__cap_mim_m3_1 l=13.96 w=13.96
X261 VREF DAC__BIT0__BITB DAC__BIT0__REFSEL VPWR sky130_fd_pr__pfet_01v8_hvt ad=2.32 pd=16.58 as=2.32 ps=16.58 w=8 l=0.15
X262 TOP DAC__BOTTOM7 sky130_fd_pr__cap_mim_m3_1 l=13.96 w=13.96
X263 TOP DAC__BOTTOM7 sky130_fd_pr__cap_mim_m3_1 l=13.96 w=13.96
X264 TOP DAC__BOTTOM7 sky130_fd_pr__cap_mim_m3_1 l=13.96 w=13.96
X265 TOP DAC__BOTTOM6 sky130_fd_pr__cap_mim_m3_1 l=13.96 w=13.96
X266 TOP DAC__BOTTOM5 sky130_fd_pr__cap_mim_m3_1 l=13.96 w=13.96
X267 DAC__BIT7__REFSEL DAC__SAMPLEB DAC__BOTTOM7 VGND sky130_fd_pr__nfet_01v8 ad=1.16 pd=8.58 as=1.16 ps=8.58 w=4 l=0.15
X268 DAC__BIT7__REFSEL SAMPLE DAC__BOTTOM7 VPWR sky130_fd_pr__pfet_01v8_hvt ad=2.32 pd=16.58 as=2.32 ps=16.58 w=8 l=0.15
X269 TOP DAC__BOTTOM6 sky130_fd_pr__cap_mim_m3_1 l=13.96 w=13.96
X270 VREF VGND DAC__DUMMY_SWITCH__REFSEL VGND sky130_fd_pr__nfet_01v8 ad=1.16 pd=8.58 as=1.16 ps=8.58 w=4 l=0.15
X271 VIN DAC__SAMPLEB DAC__BOTTOM3 VPWR sky130_fd_pr__pfet_01v8_hvt ad=2.32 pd=16.58 as=2.32 ps=16.58 w=8 l=0.15
X272 TOP DAC__BOTTOM7 sky130_fd_pr__cap_mim_m3_1 l=13.96 w=13.96
X273 TOP DAC__BOTTOM7 sky130_fd_pr__cap_mim_m3_1 l=13.96 w=13.96
X274 TOP DAC__BOTTOM7 sky130_fd_pr__cap_mim_m3_1 l=13.96 w=13.96
X275 TOP DAC__BOTTOM7 sky130_fd_pr__cap_mim_m3_1 l=13.96 w=13.96
X276 TOP DAC__BOTTOM5 sky130_fd_pr__cap_mim_m3_1 l=13.96 w=13.96
X277 TOP DAC__BOTTOM7 sky130_fd_pr__cap_mim_m3_1 l=13.96 w=13.96
X278 VGND B4 DAC__BIT4__BITB VGND sky130_fd_pr__nfet_01v8 ad=0.1885 pd=1.88 as=0.1885 ps=1.88 w=0.65 l=0.15
X279 TOP DAC__BOTTOM7 sky130_fd_pr__cap_mim_m3_1 l=13.96 w=13.96
X280 TOP DAC__BOTTOM7 sky130_fd_pr__cap_mim_m3_1 l=13.96 w=13.96
X281 TOP DAC__BOTTOM6 sky130_fd_pr__cap_mim_m3_1 l=13.96 w=13.96
X282 VGND DAC__DUMMY_SWITCH__BITB DAC__DUMMY_SWITCH__REFSEL VGND sky130_fd_pr__nfet_01v8 ad=1.16 pd=8.58 as=1.16 ps=8.58 w=4 l=0.15
X283 TOP DAC__BOTTOM7 sky130_fd_pr__cap_mim_m3_1 l=13.96 w=13.96
X284 VIN SAMPLE DAC__BOTTOM1 VGND sky130_fd_pr__nfet_01v8 ad=1.16 pd=8.58 as=1.16 ps=8.58 w=4 l=0.15
X285 DAC__BIT1__REFSEL DAC__SAMPLEB DAC__BOTTOM1 VGND sky130_fd_pr__nfet_01v8 ad=1.16 pd=8.58 as=1.16 ps=8.58 w=4 l=0.15
X286 TOP DAC__BOTTOM7 sky130_fd_pr__cap_mim_m3_1 l=13.96 w=13.96
X287 TOP DAC__BOTTOM6 sky130_fd_pr__cap_mim_m3_1 l=13.96 w=13.96
X288 TOP DAC__BOTTOM5 sky130_fd_pr__cap_mim_m3_1 l=13.96 w=13.96
X289 VGND B1 DAC__BIT1__BITB VGND sky130_fd_pr__nfet_01v8 ad=0.1885 pd=1.88 as=0.1885 ps=1.88 w=0.65 l=0.15
X290 TOP DAC__BOTTOM7 sky130_fd_pr__cap_mim_m3_1 l=13.96 w=13.96
X291 TOP DAC__BOTTOM3 sky130_fd_pr__cap_mim_m3_1 l=13.96 w=13.96
X292 TOP DAC__BOTTOM7 sky130_fd_pr__cap_mim_m3_1 l=13.96 w=13.96
X293 DAC__BIT5__REFSEL SAMPLE DAC__BOTTOM5 VPWR sky130_fd_pr__pfet_01v8_hvt ad=2.32 pd=16.58 as=2.32 ps=16.58 w=8 l=0.15
X294 VGND B3 DAC__BIT3__REFSEL VPWR sky130_fd_pr__pfet_01v8_hvt ad=2.32 pd=16.58 as=2.32 ps=16.58 w=8 l=0.15
X295 TOP DAC__BOTTOM7 sky130_fd_pr__cap_mim_m3_1 l=13.96 w=13.96
X296 TOP DAC__BOTTOM7 sky130_fd_pr__cap_mim_m3_1 l=13.96 w=13.96
X297 TOP DAC__BOTTOM3 sky130_fd_pr__cap_mim_m3_1 l=13.96 w=13.96
X298 TOP DAC__BOTTOM6 sky130_fd_pr__cap_mim_m3_1 l=13.96 w=13.96
X299 TOP DAC__BOTTOM5 sky130_fd_pr__cap_mim_m3_1 l=13.96 w=13.96
X300 TOP DAC__BOTTOM6 sky130_fd_pr__cap_mim_m3_1 l=13.96 w=13.96
X301 TOP DAC__BOTTOM7 sky130_fd_pr__cap_mim_m3_1 l=13.96 w=13.96
X302 VREF DAC__BIT5__BITB DAC__BIT5__REFSEL VPWR sky130_fd_pr__pfet_01v8_hvt ad=2.32 pd=16.58 as=2.32 ps=16.58 w=8 l=0.15
X303 TOP DAC__BOTTOM6 sky130_fd_pr__cap_mim_m3_1 l=13.96 w=13.96
X304 VIN SAMPLE DAC__BOTTOM7 VGND sky130_fd_pr__nfet_01v8 ad=1.16 pd=8.58 as=1.16 ps=8.58 w=4 l=0.15
X305 VGND B4 DAC__BIT4__REFSEL VPWR sky130_fd_pr__pfet_01v8_hvt ad=2.32 pd=16.58 as=2.32 ps=16.58 w=8 l=0.15
X306 TOP DAC__BOTTOM7 sky130_fd_pr__cap_mim_m3_1 l=13.96 w=13.96
X307 TOP DAC__BOTTOM5 sky130_fd_pr__cap_mim_m3_1 l=13.96 w=13.96
X308 TOP DAC__BOTTOM6 sky130_fd_pr__cap_mim_m3_1 l=13.96 w=13.96
X309 TOP DAC__BOTTOM7 sky130_fd_pr__cap_mim_m3_1 l=13.96 w=13.96
X310 TOP DAC__BOTTOM7 sky130_fd_pr__cap_mim_m3_1 l=13.96 w=13.96
X311 VGND VGND DAC__DUMMY_SWITCH__BITB VGND sky130_fd_pr__nfet_01v8 ad=0.1885 pd=1.88 as=0.1885 ps=1.88 w=0.65 l=0.15
X312 TOP DAC__BOTTOM7 sky130_fd_pr__cap_mim_m3_1 l=13.96 w=13.96
X313 TOP DAC__BOTTOM6 sky130_fd_pr__cap_mim_m3_1 l=13.96 w=13.96
X314 TOP DAC__BOTTOM6 sky130_fd_pr__cap_mim_m3_1 l=13.96 w=13.96
X315 TOP DAC__BOTTOM5 sky130_fd_pr__cap_mim_m3_1 l=13.96 w=13.96
X316 VREF DAC__DUMMY_SWITCH__BITB DAC__DUMMY_SWITCH__REFSEL VPWR sky130_fd_pr__pfet_01v8_hvt ad=2.32 pd=16.58 as=2.32 ps=16.58 w=8 l=0.15
X317 VGND DAC__BIT5__BITB DAC__BIT5__REFSEL VGND sky130_fd_pr__nfet_01v8 ad=1.16 pd=8.58 as=1.16 ps=8.58 w=4 l=0.15
X318 VGND B5 DAC__BIT5__REFSEL VPWR sky130_fd_pr__pfet_01v8_hvt ad=2.32 pd=16.58 as=2.32 ps=16.58 w=8 l=0.15
X319 TOP DAC__BOTTOM7 sky130_fd_pr__cap_mim_m3_1 l=13.96 w=13.96
X320 TOP DAC__BOTTOM7 sky130_fd_pr__cap_mim_m3_1 l=13.96 w=13.96
X321 VGND DAC__BIT6__BITB DAC__BIT6__REFSEL VGND sky130_fd_pr__nfet_01v8 ad=1.16 pd=8.58 as=1.16 ps=8.58 w=4 l=0.15
X322 TOP DAC__BOTTOM7 sky130_fd_pr__cap_mim_m3_1 l=13.96 w=13.96
X323 TOP DAC__BOTTOM7 sky130_fd_pr__cap_mim_m3_1 l=13.96 w=13.96
X324 TOP DAC__BOTTOM3 sky130_fd_pr__cap_mim_m3_1 l=13.96 w=13.96
X325 TOP DAC__BOTTOM6 sky130_fd_pr__cap_mim_m3_1 l=13.96 w=13.96
X326 COMPARE__PREAMP__TAIL VCM COMPARE__PRE VGND sky130_fd_pr__nfet_01v8 ad=2.9 pd=20.58 as=2.9 ps=20.58 w=10 l=1
X327 VGND DAC__BIT2__BITB DAC__BIT2__REFSEL VGND sky130_fd_pr__nfet_01v8 ad=1.16 pd=8.58 as=1.16 ps=8.58 w=4 l=0.15
X328 TOP DAC__BOTTOM7 sky130_fd_pr__cap_mim_m3_1 l=13.96 w=13.96
X329 TOP DAC__BOTTOM6 sky130_fd_pr__cap_mim_m3_1 l=13.96 w=13.96
X330 VGND B3 DAC__BIT3__BITB VGND sky130_fd_pr__nfet_01v8 ad=0.1885 pd=1.88 as=0.1885 ps=1.88 w=0.65 l=0.15
X331 TOP DAC__BOTTOM7 sky130_fd_pr__cap_mim_m3_1 l=13.96 w=13.96
X332 TOP DAC__BOTTOM7 sky130_fd_pr__cap_mim_m3_1 l=13.96 w=13.96
X333 TOP DAC__BOTTOM4 sky130_fd_pr__cap_mim_m3_1 l=13.96 w=13.96
X334 TOP DAC__BOTTOM6 sky130_fd_pr__cap_mim_m3_1 l=13.96 w=13.96
X335 VGND B2 DAC__BIT2__BITB VGND sky130_fd_pr__nfet_01v8 ad=0.1885 pd=1.88 as=0.1885 ps=1.88 w=0.65 l=0.15
X336 TOP DAC__BOTTOM7 sky130_fd_pr__cap_mim_m3_1 l=13.96 w=13.96
X337 TOP DAC__BOTTOM6 sky130_fd_pr__cap_mim_m3_1 l=13.96 w=13.96
X338 TOP DAC__BOTTOM6 sky130_fd_pr__cap_mim_m3_1 l=13.96 w=13.96
X339 TOP DAC__BOTTOM5 sky130_fd_pr__cap_mim_m3_1 l=13.96 w=13.96
X340 DAC__BIT4__REFSEL SAMPLE DAC__BOTTOM4 VPWR sky130_fd_pr__pfet_01v8_hvt ad=2.32 pd=16.58 as=2.32 ps=16.58 w=8 l=0.15
X341 TOP DAC__BOTTOM7 sky130_fd_pr__cap_mim_m3_1 l=13.96 w=13.96
X342 COMPARE__PREAMP__TAIL TOP COMPARE__PREAMP__MIR VGND sky130_fd_pr__nfet_01v8 ad=2.9 pd=20.58 as=2.9 ps=20.58 w=10 l=1
X343 VGND B7 DAC__BIT7__REFSEL VPWR sky130_fd_pr__pfet_01v8_hvt ad=2.32 pd=16.58 as=2.32 ps=16.58 w=8 l=0.15
X344 TOP DAC__BOTTOM7 sky130_fd_pr__cap_mim_m3_1 l=13.96 w=13.96
X345 TOP DAC__BOTTOM6 sky130_fd_pr__cap_mim_m3_1 l=13.96 w=13.96
X346 VCM SAMPLE TOP VGND sky130_fd_pr__nfet_01v8 ad=1.16 pd=8.58 as=1.16 ps=8.58 w=4 l=0.15
X347 VIN DAC__SAMPLEB DAC__BOTTOM4 VPWR sky130_fd_pr__pfet_01v8_hvt ad=2.32 pd=16.58 as=2.32 ps=16.58 w=8 l=0.15
X348 TOP DAC__BOTTOM6 sky130_fd_pr__cap_mim_m3_1 l=13.96 w=13.96
X349 TOP DAC__BOTTOM4 sky130_fd_pr__cap_mim_m3_1 l=13.96 w=13.96
X350 TOP DAC__BOTTOM3 sky130_fd_pr__cap_mim_m3_1 l=13.96 w=13.96
X351 TOP DAC__BOTTOM6 sky130_fd_pr__cap_mim_m3_1 l=13.96 w=13.96
X352 TOP DAC__BOTTOM7 sky130_fd_pr__cap_mim_m3_1 l=13.96 w=13.96
X353 TOP DAC__BOTTOM7 sky130_fd_pr__cap_mim_m3_1 l=13.96 w=13.96
X354 TOP DAC__BOTTOM7 sky130_fd_pr__cap_mim_m3_1 l=13.96 w=13.96
X355 TOP DAC__BOTTOM6 sky130_fd_pr__cap_mim_m3_1 l=13.96 w=13.96
X356 TOP DAC__BOTTOM5 sky130_fd_pr__cap_mim_m3_1 l=13.96 w=13.96
.ends

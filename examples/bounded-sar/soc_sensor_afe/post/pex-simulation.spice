* NGSPICE file created from soc_sensor_afe.ext - technology: sky130A

.subckt soc_sensor_afe VIN VGND VCM RESET OUT VPWR DATA GAIN CLK BIAS
X0 VGND.t31 GAIN.t0 PGA__GAINB.t1 VGND.t30 sky130_fd_pr__nfet_01v8 ad=0.1885 pd=1.88 as=0.1885 ps=1.88 w=0.65 l=0.15
X1 VPWR PGA__GAIN2__AMP__FIRST__MIR.t0 PGA__GAIN2__AMP__FIRST__MIR.t1 VPWR sky130_fd_pr__pfet_01v8_hvt ad=5.8 pd=40.58 as=5.8 ps=40.58 w=20 l=1
X2 BIAS_SOURCE__VCM_BUFFER__PRE.t3 BIAS_SOURCE__VCM_BUFFER__COMP.t3 sky130_fd_pr__cap_mim_m3_1 l=28.68 w=28.68
X3 FILTER__FILTER0.t1 VGND.t136 sky130_fd_pr__cap_mim_m3_1 l=28.68 w=28.68
X4 VPWR RESET.t0 RESET_MUX__SB.t0 VPWR sky130_fd_pr__pfet_01v8_hvt ad=0.1885 pd=1.88 as=0.1885 ps=1.88 w=0.65 l=0.15
X5 VPWR PGA__GAIN8__AMP__FIRST__MIR.t4 PGA__GAIN8__AMP__PRE.t1 VPWR sky130_fd_pr__pfet_01v8_hvt ad=5.8 pd=40.58 as=5.8 ps=40.58 w=20 l=1
X6 VPWR SAMPLE__TB.t2 DATA.t1 VPWR sky130_fd_pr__pfet_01v8_hvt ad=0.1885 pd=1.88 as=0.1885 ps=1.88 w=0.65 l=0.15
X7 VGND.t82 BIAS.t3 PGA__OUTPUT_BUFFER__FIRST__TAIL.t0 VGND.t81 sky130_fd_pr__nfet_01v8 ad=0.58 pd=4.58 as=0.58 ps=4.58 w=2 l=1
X8 PGA__GAIN8__AMP__COMP.t0 PGA__V8.t0 VGND.t26 sky130_fd_pr__res_xhigh_po_1p41 l=3.36
X9 FILTER__FILTER1.t1 VGND.t40 sky130_fd_pr__cap_mim_m3_1 l=28.68 w=28.68
X10 FILTER__MID.t0 FILTER__FILTER1.t0 VGND.t18 sky130_fd_pr__res_xhigh_po_1p41 l=28.04
X11 PGA__GAIN2__AMP__COMP.t0 PGA__V2.t0 VGND.t3 sky130_fd_pr__res_xhigh_po_1p41 l=3.36
X12 BIAS_SOURCE__VCM_RAW.t2 VGND.t87 sky130_fd_pr__cap_mim_m3_1 l=28.68 w=28.68
X13 VPWR FILTER__BUFFER1__FIRST__MIR.t0 FILTER__BUFFER1__FIRST__MIR.t1 VPWR sky130_fd_pr__pfet_01v8_hvt ad=5.8 pd=40.58 as=5.8 ps=40.58 w=20 l=1
X14 FILTER__BUFFER1__FIRST__TAIL.t2 FILTER__FILTER1.t2 FILTER__BUFFER1__PRE.t1 VGND.t133 sky130_fd_pr__nfet_01v8 ad=1.45 pd=10.58 as=1.45 ps=10.58 w=5 l=1
X15 PGA__OUTPUT_BUFFER__FIRST__TAIL.t3 AMPLIFIED.t4 PGA__OUTPUT_BUFFER__FIRST__MIR.t3 VGND.t84 sky130_fd_pr__nfet_01v8 ad=1.45 pd=10.58 as=1.45 ps=10.58 w=5 l=1
X16 PGA__OUTPUT_BUFFER__PRE.t3 PGA__OUTPUT_BUFFER__COMP.t2 sky130_fd_pr__cap_mim_m3_1 l=28.68 w=28.68
X17 FILTER__FILTER1.t3 VGND.t42 sky130_fd_pr__cap_mim_m3_1 l=28.68 w=28.68
X18 VPWR COMPARATOR__PREAMP__MIR.t0 COMPARATOR__PREAMP__MIR.t1 VPWR sky130_fd_pr__pfet_01v8_hvt ad=5.8 pd=40.58 as=5.8 ps=40.58 w=20 l=1
X19 PGA__V8.t5 PGA_GAIN8_R_FEEDBACK_R0_N0.t1 VGND.t106 sky130_fd_pr__res_xhigh_po_1p41 l=24.51
X20 FILTER__FILTER0.t2 VGND.t126 sky130_fd_pr__cap_mim_m3_1 l=28.68 w=28.68
X21 BIAS_SOURCE_R_VCM_BOTTOM_R0_N1.t0 VGND.t25 VGND.t24 sky130_fd_pr__res_xhigh_po_1p41 l=23.34
X22 COMPARATOR__PREAMP__TAIL.t1 OUT.t3 COMPARATOR__PRE.t1 VGND.t9 sky130_fd_pr__nfet_01v8 ad=2.9 pd=20.58 as=2.9 ps=20.58 w=10 l=1
X23 PGA__GAIN2__AMP__PRE.t3 PGA__GAIN2__AMP__COMP.t2 sky130_fd_pr__cap_mim_m3_1 l=28.68 w=28.68
X24 VGND.t28 BIAS.t4 OUT.t2 VGND.t27 sky130_fd_pr__nfet_01v8 ad=0.58 pd=4.58 as=0.58 ps=4.58 w=2 l=1
X25 FILTER__FILTER0.t3 VGND.t117 sky130_fd_pr__cap_mim_m3_1 l=28.68 w=28.68
X26 FILTER__FILTER1.t4 VGND.t6 sky130_fd_pr__cap_mim_m3_1 l=28.68 w=28.68
X27 FILTER__BUFFER0__PRE.t3 FILTER__BUFFER0__COMP.t2 sky130_fd_pr__cap_mim_m3_1 l=28.68 w=28.68
X28 PGA__OUTPUT_BUFFER__COMP.t3 AMPLIFIED.t3 VGND.t90 sky130_fd_pr__res_xhigh_po_1p41 l=3.36
X29 PGA__OUTPUT_BUFFER__FIRST__TAIL.t2 PGA__SELECTED.t4 PGA__OUTPUT_BUFFER__PRE.t2 VGND.t83 sky130_fd_pr__nfet_01v8 ad=1.45 pd=10.58 as=1.45 ps=10.58 w=5 l=1
X30 VPWR PGA__GAIN8__AMP__PRE.t3 PGA__V8.t4 VPWR sky130_fd_pr__pfet_01v8_hvt ad=11.6 pd=80.58 as=11.6 ps=80.58 w=40 l=1
X31 BIAS_SOURCE__VCM_RAW.t3 VGND.t4 sky130_fd_pr__cap_mim_m3_1 l=28.68 w=28.68
X32 VGND.t38 RESET.t1 RESET_MUX__SB.t1 VGND.t37 sky130_fd_pr__nfet_01v8 ad=0.1885 pd=1.88 as=0.1885 ps=1.88 w=0.65 l=0.15
X33 FILTER__FILTER1.t5 VGND.t113 sky130_fd_pr__cap_mim_m3_1 l=28.68 w=28.68
X34 VGND.t51 SAMPLE__TB.t3 DATA.t2 VGND.t50 sky130_fd_pr__nfet_01v8 ad=0.1885 pd=1.88 as=0.1885 ps=1.88 w=0.65 l=0.15
X35 PGA__GAIN2__AMP__PRE.t4 PGA__GAIN2__AMP__COMP.t1 sky130_fd_pr__cap_mim_m3_1 l=28.68 w=28.68
X36 BIAS_SOURCE__VCM_BUFFER__COMP.t0 VCM.t2 VGND.t17 sky130_fd_pr__res_xhigh_po_1p41 l=3.36
X37 PGA_GAIN8_R_FEEDBACK_R0_N0.t0 PGA__GAIN8__FB.t1 VGND.t103 sky130_fd_pr__res_xhigh_po_1p41 l=24.51
X38 FILTER__FILTER1.t6 VGND.t72 sky130_fd_pr__cap_mim_m3_1 l=28.68 w=28.68
X39 FILTER__BUFFER0__FIRST__TAIL.t1 FILTER__MID.t4 FILTER__BUFFER0__FIRST__MIR.t0 VGND.t43 sky130_fd_pr__nfet_01v8 ad=1.45 pd=10.58 as=1.45 ps=10.58 w=5 l=1
X40 PGA__GAIN8__AMP__PRE.t4 PGA__GAIN8__AMP__COMP.t3 sky130_fd_pr__cap_mim_m3_1 l=28.68 w=28.68
X41 BIAS_SOURCE_R_VCM_TOP_R0_N0.t1 BIAS_SOURCE_R_VCM_TOP_R0_N1.t1 VGND.t102 sky130_fd_pr__res_xhigh_po_1p41 l=23.34
X42 FILTER__BUFFER0__COMP.t3 FILTER__MID.t3 VGND.t101 sky130_fd_pr__res_xhigh_po_1p41 l=3.36
X43 BIAS_SOURCE__VCM_RAW.t4 VGND.t60 sky130_fd_pr__cap_mim_m3_1 l=28.68 w=28.68
X44 FILTER__FILTER1.t7 VGND.t119 sky130_fd_pr__cap_mim_m3_1 l=28.68 w=28.68
X45 VPWR PGA__GAIN8__AMP__FIRST__MIR.t2 PGA__GAIN8__AMP__FIRST__MIR.t3 VPWR sky130_fd_pr__pfet_01v8_hvt ad=5.8 pd=40.58 as=5.8 ps=40.58 w=20 l=1
X46 VGND.t74 BIAS.t5 FILTER__BUFFER1__FIRST__TAIL.t3 VGND.t73 sky130_fd_pr__nfet_01v8 ad=0.58 pd=4.58 as=0.58 ps=4.58 w=2 l=1
X47 FILTER__BUFFER0__FIRST__TAIL.t0 FILTER__MID.t5 FILTER__BUFFER0__FIRST__MIR.t1 VGND.t21 sky130_fd_pr__nfet_01v8 ad=1.45 pd=10.58 as=1.45 ps=10.58 w=5 l=1
X48 BIAS_SOURCE__VCM_RAW.t5 VGND.t105 sky130_fd_pr__cap_mim_m3_1 l=28.68 w=28.68
X49 VPWR BIAS_SOURCE__VCM_BUFFER__FIRST__MIR.t4 BIAS_SOURCE__VCM_BUFFER__PRE.t1 VPWR sky130_fd_pr__pfet_01v8_hvt ad=5.8 pd=40.58 as=5.8 ps=40.58 w=20 l=1
X50 FILTER__BUFFER1__PRE.t3 FILTER__BUFFER1__COMP.t3 sky130_fd_pr__cap_mim_m3_1 l=28.68 w=28.68
X51 VGND.t131 BIAS.t6 VCM.t3 VGND.t130 sky130_fd_pr__nfet_01v8 ad=0.58 pd=4.58 as=0.58 ps=4.58 w=2 l=1
X52 VPWR COMPARATOR__PRE.t2 CMP.t0 VPWR sky130_fd_pr__pfet_01v8_hvt ad=2.32 pd=16.58 as=2.32 ps=16.58 w=8 l=0.15
X53 VPWR GAIN.t1 PGA__GAINB.t0 VPWR sky130_fd_pr__pfet_01v8_hvt ad=0.1885 pd=1.88 as=0.1885 ps=1.88 w=0.65 l=0.15
X54 BIAS_SOURCE__VCM_BUFFER__FIRST__TAIL.t4 VCM.t5 BIAS_SOURCE__VCM_BUFFER__FIRST__MIR.t2 VGND.t99 sky130_fd_pr__nfet_01v8 ad=1.45 pd=10.58 as=1.45 ps=10.58 w=5 l=1
X55 VPWR PGA__OUTPUT_BUFFER__FIRST__MIR.t4 PGA__OUTPUT_BUFFER__PRE.t0 VPWR sky130_fd_pr__pfet_01v8_hvt ad=5.8 pd=40.58 as=5.8 ps=40.58 w=20 l=1
X56 BIAS_SOURCE__VCM_RAW.t1 BIAS_SOURCE_R_VCM_BOTTOM_R0_N0.t0 VGND.t100 sky130_fd_pr__res_xhigh_po_1p41 l=23.34
X57 FILTER__FILTER1.t8 VGND.t120 sky130_fd_pr__cap_mim_m3_1 l=28.68 w=28.68
X58 D.t3 CLK.t0 SAMPLE__M.t2 VPWR sky130_fd_pr__pfet_01v8_hvt ad=0.1885 pd=1.88 as=0.1885 ps=1.88 w=0.65 l=0.15
X59 FILTER__FILTER0.t4 VGND.t127 sky130_fd_pr__cap_mim_m3_1 l=28.68 w=28.68
X60 BIAS_SOURCE__VCM_RAW.t6 VGND.t44 sky130_fd_pr__cap_mim_m3_1 l=28.68 w=28.68
X61 FILTER__FILTER0.t5 VGND.t89 sky130_fd_pr__cap_mim_m3_1 l=28.68 w=28.68
X62 SAMPLE__MF.t3 SAMPLE__CLKB.t2 SAMPLE__M.t0 VPWR sky130_fd_pr__pfet_01v8_hvt ad=0.1885 pd=1.88 as=0.1885 ps=1.88 w=0.65 l=0.15
X63 FILTER__BUFFER0__PRE.t4 FILTER__BUFFER0__COMP.t1 sky130_fd_pr__cap_mim_m3_1 l=28.68 w=28.68
X64 PGA__GAIN2__AMP__PRE.t5 PGA__GAIN2__AMP__COMP.t3 sky130_fd_pr__cap_mim_m3_1 l=28.68 w=28.68
X65 VPWR FILTER__BUFFER1__PRE.t4 OUT.t1 VPWR sky130_fd_pr__pfet_01v8_hvt ad=11.6 pd=80.58 as=11.6 ps=80.58 w=40 l=1
X66 VPWR FILTER__BUFFER0__PRE.t5 FILTER__MID.t2 VPWR sky130_fd_pr__pfet_01v8_hvt ad=11.6 pd=80.58 as=11.6 ps=80.58 w=40 l=1
X67 VPWR BIAS.t2 VGND.t95 sky130_fd_pr__res_xhigh_po_1p41 l=20.99
X68 SAMPLE__MF.t2 SAMPLE__CLKB.t3 SAMPLE__T.t1 VPWR sky130_fd_pr__pfet_01v8_hvt ad=0.1885 pd=1.88 as=0.1885 ps=1.88 w=0.65 l=0.15
X69 PGA__GAIN8__AMP__FIRST__TAIL.t2 VIN.t0 PGA__GAIN8__AMP__PRE.t2 VGND.t121 sky130_fd_pr__nfet_01v8 ad=1.45 pd=10.58 as=1.45 ps=10.58 w=5 l=1
X70 BIAS_SOURCE__VCM_RAW.t7 VGND.t67 sky130_fd_pr__cap_mim_m3_1 l=28.68 w=28.68
X71 FILTER__FILTER1.t9 VGND.t39 sky130_fd_pr__cap_mim_m3_1 l=28.68 w=28.68
X72 VGND.t66 BIAS.t7 AMPLIFIED.t1 VGND.t65 sky130_fd_pr__nfet_01v8 ad=0.58 pd=4.58 as=0.58 ps=4.58 w=2 l=1
X73 D.t0 SAMPLE__CLKB.t4 SAMPLE__M.t1 VGND.t52 sky130_fd_pr__nfet_01v8 ad=0.1885 pd=1.88 as=0.1885 ps=1.88 w=0.65 l=0.15
X74 BIAS_SOURCE__VCM_RAW.t8 VGND.t47 sky130_fd_pr__cap_mim_m3_1 l=28.68 w=28.68
X75 PGA__OUTPUT_BUFFER__PRE.t4 PGA__OUTPUT_BUFFER__COMP.t1 sky130_fd_pr__cap_mim_m3_1 l=28.68 w=28.68
X76 FILTER__BUFFER0__FIRST__TAIL.t4 FILTER__FILTER0.t6 FILTER__BUFFER0__PRE.t2 VGND.t110 sky130_fd_pr__nfet_01v8 ad=1.45 pd=10.58 as=1.45 ps=10.58 w=5 l=1
X77 VGND.t94 BIAS.t8 PGA__V2.t4 VGND.t93 sky130_fd_pr__nfet_01v8 ad=0.58 pd=4.58 as=0.58 ps=4.58 w=2 l=1
X78 SAMPLE__MF.t4 CLK.t1 SAMPLE__M.t3 VGND.t118 sky130_fd_pr__nfet_01v8 ad=0.1885 pd=1.88 as=0.1885 ps=1.88 w=0.65 l=0.15
X79 FILTER__FILTER0.t7 VGND.t98 sky130_fd_pr__cap_mim_m3_1 l=28.68 w=28.68
X80 PGA__GAIN8__AMP__PRE.t5 PGA__GAIN8__AMP__COMP.t2 sky130_fd_pr__cap_mim_m3_1 l=28.68 w=28.68
X81 VPWR FILTER__BUFFER1__FIRST__MIR.t4 FILTER__BUFFER1__PRE.t0 VPWR sky130_fd_pr__pfet_01v8_hvt ad=5.8 pd=40.58 as=5.8 ps=40.58 w=20 l=1
X82 FILTER__BUFFER0__FIRST__TAIL.t3 FILTER__FILTER0.t8 FILTER__BUFFER0__PRE.t1 VGND.t35 sky130_fd_pr__nfet_01v8 ad=1.45 pd=10.58 as=1.45 ps=10.58 w=5 l=1
X83 FILTER__BUFFER1__FIRST__TAIL.t0 OUT.t4 FILTER__BUFFER1__FIRST__MIR.t2 VGND.t10 sky130_fd_pr__nfet_01v8 ad=1.45 pd=10.58 as=1.45 ps=10.58 w=5 l=1
X84 PGA__GAIN2__AMP__FIRST__TAIL.t2 PGA__GAIN2__FB.t2 PGA__GAIN2__AMP__FIRST__MIR.t2 VGND.t79 sky130_fd_pr__nfet_01v8 ad=1.45 pd=10.58 as=1.45 ps=10.58 w=5 l=1
X85 PGA__GAIN8__AMP__FIRST__TAIL.t4 PGA__GAIN8__FB.t2 PGA__GAIN8__AMP__FIRST__MIR.t1 VGND.t34 sky130_fd_pr__nfet_01v8 ad=1.45 pd=10.58 as=1.45 ps=10.58 w=5 l=1
X86 VGND.t58 CLK.t2 SAMPLE__CLKB.t1 VGND.t57 sky130_fd_pr__nfet_01v8 ad=0.1885 pd=1.88 as=0.1885 ps=1.88 w=0.65 l=0.15
X87 VPWR SAMPLE__M.t4 SAMPLE__MB.t0 VPWR sky130_fd_pr__pfet_01v8_hvt ad=0.1885 pd=1.88 as=0.1885 ps=1.88 w=0.65 l=0.15
X88 VPWR FILTER__BUFFER0__FIRST__MIR.t2 FILTER__BUFFER0__FIRST__MIR.t3 VPWR sky130_fd_pr__pfet_01v8_hvt ad=5.8 pd=40.58 as=5.8 ps=40.58 w=20 l=1
X89 BIAS_SOURCE__VCM_BUFFER__FIRST__TAIL.t1 BIAS_SOURCE__VCM_RAW.t9 BIAS_SOURCE__VCM_BUFFER__PRE.t2 VGND.t88 sky130_fd_pr__nfet_01v8 ad=1.45 pd=10.58 as=1.45 ps=10.58 w=5 l=1
X90 BIAS_SOURCE__VCM_BUFFER__PRE.t4 BIAS_SOURCE__VCM_BUFFER__COMP.t2 sky130_fd_pr__cap_mim_m3_1 l=28.68 w=28.68
X91 VPWR SAMPLE__MB.t2 SAMPLE__MF.t0 VPWR sky130_fd_pr__pfet_01v8_hvt ad=0.1885 pd=1.88 as=0.1885 ps=1.88 w=0.65 l=0.15
X92 VGND.t123 BIAS.t9 PGA__GAIN2__AMP__FIRST__TAIL.t0 VGND.t122 sky130_fd_pr__nfet_01v8 ad=0.58 pd=4.58 as=0.58 ps=4.58 w=2 l=1
X93 BIAS_SOURCE__VCM_RAW.t10 VGND.t61 sky130_fd_pr__cap_mim_m3_1 l=28.68 w=28.68
X94 VPWR PGA__OUTPUT_BUFFER__PRE.t5 AMPLIFIED.t2 VPWR sky130_fd_pr__pfet_01v8_hvt ad=11.6 pd=80.58 as=11.6 ps=80.58 w=40 l=1
X95 FILTER__FILTER0.t9 VGND.t11 sky130_fd_pr__cap_mim_m3_1 l=28.68 w=28.68
X96 VPWR SAMPLE__T.t4 SAMPLE__TB.t1 VPWR sky130_fd_pr__pfet_01v8_hvt ad=0.1885 pd=1.88 as=0.1885 ps=1.88 w=0.65 l=0.15
X97 PGA__OUTPUT_BUFFER__FIRST__TAIL.t4 AMPLIFIED.t5 PGA__OUTPUT_BUFFER__FIRST__MIR.t2 VGND.t97 sky130_fd_pr__nfet_01v8 ad=1.45 pd=10.58 as=1.45 ps=10.58 w=5 l=1
X98 PGA__SELECTED.t1 GAIN.t2 PGA__V2.t1 VPWR sky130_fd_pr__pfet_01v8_hvt ad=5.8 pd=40.58 as=5.8 ps=40.58 w=20 l=0.15
X99 VPWR FILTER__BUFFER0__FIRST__MIR.t4 FILTER__BUFFER0__PRE.t0 VPWR sky130_fd_pr__pfet_01v8_hvt ad=5.8 pd=40.58 as=5.8 ps=40.58 w=20 l=1
X100 FILTER__FILTER1.t10 VGND.t132 sky130_fd_pr__cap_mim_m3_1 l=28.68 w=28.68
X101 VPWR BIAS_SOURCE__VCM_BUFFER__PRE.t5 VCM.t4 VPWR sky130_fd_pr__pfet_01v8_hvt ad=11.6 pd=80.58 as=11.6 ps=80.58 w=40 l=1
X102 BIAS_SOURCE_R_VCM_BOTTOM_R0_N0.t1 BIAS_SOURCE_R_VCM_BOTTOM_R0_N1.t1 VGND.t112 sky130_fd_pr__res_xhigh_po_1p41 l=23.34
X103 VGND.t49 SAMPLE__M.t5 SAMPLE__MB.t1 VGND.t48 sky130_fd_pr__nfet_01v8 ad=0.1885 pd=1.88 as=0.1885 ps=1.88 w=0.65 l=0.15
X104 SAMPLE__MF.t5 CLK.t3 SAMPLE__T.t3 VGND.t76 sky130_fd_pr__nfet_01v8 ad=0.1885 pd=1.88 as=0.1885 ps=1.88 w=0.65 l=0.15
X105 VPWR PGA__OUTPUT_BUFFER__FIRST__MIR.t0 PGA__OUTPUT_BUFFER__FIRST__MIR.t1 VPWR sky130_fd_pr__pfet_01v8_hvt ad=5.8 pd=40.58 as=5.8 ps=40.58 w=20 l=1
X106 PGA__SELECTED.t3 PGA__GAINB.t2 PGA__V2.t2 VGND.t33 sky130_fd_pr__nfet_01v8 ad=5.8 pd=40.58 as=5.8 ps=40.58 w=20 l=0.15
X107 DATA.t0 SAMPLE__CLKB.t5 SAMPLE__T.t0 VGND.t68 sky130_fd_pr__nfet_01v8 ad=0.1885 pd=1.88 as=0.1885 ps=1.88 w=0.65 l=0.15
X108 CMP.t3 RESET.t2 D.t5 VPWR sky130_fd_pr__pfet_01v8_hvt ad=0.1885 pd=1.88 as=0.1885 ps=1.88 w=0.65 l=0.15
X109 VGND.t56 BIAS.t10 FILTER__MID.t1 VGND.t55 sky130_fd_pr__nfet_01v8 ad=0.58 pd=4.58 as=0.58 ps=4.58 w=2 l=1
X110 FILTER__BUFFER1__FIRST__TAIL.t1 FILTER__FILTER1.t11 FILTER__BUFFER1__PRE.t2 VGND.t7 sky130_fd_pr__nfet_01v8 ad=1.45 pd=10.58 as=1.45 ps=10.58 w=5 l=1
X111 BIAS_SOURCE__VCM_BUFFER__FIRST__TAIL.t0 BIAS_SOURCE__VCM_RAW.t11 BIAS_SOURCE__VCM_BUFFER__PRE.t0 VGND.t2 sky130_fd_pr__nfet_01v8 ad=1.45 pd=10.58 as=1.45 ps=10.58 w=5 l=1
X112 PGA__GAIN8__AMP__PRE.t6 PGA__GAIN8__AMP__COMP.t1 sky130_fd_pr__cap_mim_m3_1 l=28.68 w=28.68
X113 VGND.t12 RESET_MUX__SB.t2 D.t1 VPWR sky130_fd_pr__pfet_01v8_hvt ad=0.1885 pd=1.88 as=0.1885 ps=1.88 w=0.65 l=0.15
X114 PGA__GAIN8__FB.t0 VCM.t1 VGND.t16 sky130_fd_pr__res_xhigh_po_1p41 l=6.89
X115 PGA__GAIN2__FB.t0 VCM.t0 VGND.t15 sky130_fd_pr__res_xhigh_po_1p41 l=6.89
X116 FILTER__FILTER1.t12 VGND.t1 sky130_fd_pr__cap_mim_m3_1 l=28.68 w=28.68
X117 PGA__SELECTED.t2 PGA__GAINB.t3 PGA__V8.t2 VPWR sky130_fd_pr__pfet_01v8_hvt ad=5.8 pd=40.58 as=5.8 ps=40.58 w=20 l=0.15
X118 BIAS_SOURCE__VCM_BUFFER__FIRST__TAIL.t3 VCM.t6 BIAS_SOURCE__VCM_BUFFER__FIRST__MIR.t3 VGND.t19 sky130_fd_pr__nfet_01v8 ad=1.45 pd=10.58 as=1.45 ps=10.58 w=5 l=1
X119 VPWR BIAS_SOURCE_R_VCM_TOP_R0_N0.t0 VGND.t14 sky130_fd_pr__res_xhigh_po_1p41 l=23.34
X120 VGND.t92 BIAS.t11 COMPARATOR__PREAMP__TAIL.t0 VGND.t91 sky130_fd_pr__nfet_01v8 ad=0.58 pd=4.58 as=0.58 ps=4.58 w=2 l=1
X121 VPWR PGA__GAIN2__AMP__PRE.t6 PGA__V2.t3 VPWR sky130_fd_pr__pfet_01v8_hvt ad=11.6 pd=80.58 as=11.6 ps=80.58 w=40 l=1
X122 VPWR PGA__GAIN2__AMP__FIRST__MIR.t4 PGA__GAIN2__AMP__PRE.t0 VPWR sky130_fd_pr__pfet_01v8_hvt ad=5.8 pd=40.58 as=5.8 ps=40.58 w=20 l=1
X123 PGA__GAIN8__AMP__FIRST__TAIL.t3 PGA__GAIN8__FB.t3 PGA__GAIN8__AMP__FIRST__MIR.t0 VGND.t0 sky130_fd_pr__nfet_01v8 ad=1.45 pd=10.58 as=1.45 ps=10.58 w=5 l=1
X124 FILTER__BUFFER1__PRE.t5 FILTER__BUFFER1__COMP.t2 sky130_fd_pr__cap_mim_m3_1 l=28.68 w=28.68
X125 VGND.t71 SAMPLE__MB.t3 SAMPLE__MF.t1 VGND.t70 sky130_fd_pr__nfet_01v8 ad=0.1885 pd=1.88 as=0.1885 ps=1.88 w=0.65 l=0.15
X126 FILTER__FILTER0.t10 VGND.t5 sky130_fd_pr__cap_mim_m3_1 l=28.68 w=28.68
X127 VPWR BIAS_SOURCE__VCM_BUFFER__FIRST__MIR.t0 BIAS_SOURCE__VCM_BUFFER__FIRST__MIR.t1 VPWR sky130_fd_pr__pfet_01v8_hvt ad=5.8 pd=40.58 as=5.8 ps=40.58 w=20 l=1
X128 COMPARATOR__PREAMP__TAIL.t2 VCM.t7 COMPARATOR__PREAMP__MIR.t2 VGND.t107 sky130_fd_pr__nfet_01v8 ad=2.9 pd=20.58 as=2.9 ps=20.58 w=10 l=1
X129 PGA__GAIN2__AMP__FIRST__TAIL.t4 VIN.t1 PGA__GAIN2__AMP__PRE.t1 VGND.t59 sky130_fd_pr__nfet_01v8 ad=1.45 pd=10.58 as=1.45 ps=10.58 w=5 l=1
X130 PGA__V2.t5 PGA__GAIN2__FB.t1 VGND.t115 sky130_fd_pr__res_xhigh_po_1p41 l=6.89
X131 VGND.t23 SAMPLE__T.t5 SAMPLE__TB.t0 VGND.t22 sky130_fd_pr__nfet_01v8 ad=0.1885 pd=1.88 as=0.1885 ps=1.88 w=0.65 l=0.15
X132 BIAS_SOURCE_R_VCM_TOP_R0_N1.t0 BIAS_SOURCE__VCM_RAW.t0 VGND.t62 sky130_fd_pr__res_xhigh_po_1p41 l=23.34
X133 AMPLIFIED.t0 FILTER__FILTER0.t0 VGND.t36 sky130_fd_pr__res_xhigh_po_1p41 l=28.04
X134 VGND.t109 BIAS.t12 FILTER__BUFFER0__FIRST__TAIL.t2 VGND.t108 sky130_fd_pr__nfet_01v8 ad=0.58 pd=4.58 as=0.58 ps=4.58 w=2 l=1
X135 PGA__GAIN8__AMP__FIRST__TAIL.t1 VIN.t2 PGA__GAIN8__AMP__PRE.t0 VGND.t78 sky130_fd_pr__nfet_01v8 ad=1.45 pd=10.58 as=1.45 ps=10.58 w=5 l=1
X136 BIAS_SOURCE__VCM_RAW.t12 VGND.t20 sky130_fd_pr__cap_mim_m3_1 l=28.68 w=28.68
X137 PGA__SELECTED.t0 GAIN.t3 PGA__V8.t1 VGND.t29 sky130_fd_pr__nfet_01v8 ad=5.8 pd=40.58 as=5.8 ps=40.58 w=20 l=0.15
X138 PGA__GAIN2__AMP__FIRST__TAIL.t3 VIN.t3 PGA__GAIN2__AMP__PRE.t2 VGND.t114 sky130_fd_pr__nfet_01v8 ad=1.45 pd=10.58 as=1.45 ps=10.58 w=5 l=1
X139 FILTER__FILTER1.t13 VGND.t8 sky130_fd_pr__cap_mim_m3_1 l=28.68 w=28.68
X140 FILTER__BUFFER0__PRE.t6 FILTER__BUFFER0__COMP.t0 sky130_fd_pr__cap_mim_m3_1 l=28.68 w=28.68
X141 VGND.t129 BIAS.t13 PGA__GAIN8__AMP__FIRST__TAIL.t0 VGND.t128 sky130_fd_pr__nfet_01v8 ad=0.58 pd=4.58 as=0.58 ps=4.58 w=2 l=1
X142 VGND.t125 BIAS.t14 BIAS_SOURCE__VCM_BUFFER__FIRST__TAIL.t2 VGND.t124 sky130_fd_pr__nfet_01v8 ad=0.58 pd=4.58 as=0.58 ps=4.58 w=2 l=1
X143 PGA__GAIN2__AMP__FIRST__TAIL.t1 PGA__GAIN2__FB.t3 PGA__GAIN2__AMP__FIRST__MIR.t3 VGND.t111 sky130_fd_pr__nfet_01v8 ad=1.45 pd=10.58 as=1.45 ps=10.58 w=5 l=1
X144 CMP.t2 RESET_MUX__SB.t3 D.t2 VGND.t96 sky130_fd_pr__nfet_01v8 ad=0.1885 pd=1.88 as=0.1885 ps=1.88 w=0.65 l=0.15
X145 FILTER__FILTER1.t14 VGND.t77 sky130_fd_pr__cap_mim_m3_1 l=28.68 w=28.68
X146 PGA__OUTPUT_BUFFER__FIRST__TAIL.t1 PGA__SELECTED.t5 PGA__OUTPUT_BUFFER__PRE.t1 VGND.t41 sky130_fd_pr__nfet_01v8 ad=1.45 pd=10.58 as=1.45 ps=10.58 w=5 l=1
X147 VGND.t54 RESET.t3 D.t4 VGND.t53 sky130_fd_pr__nfet_01v8 ad=0.1885 pd=1.88 as=0.1885 ps=1.88 w=0.65 l=0.15
X148 BIAS_SOURCE__VCM_RAW.t13 VGND.t104 sky130_fd_pr__cap_mim_m3_1 l=28.68 w=28.68
X149 FILTER__FILTER0.t11 VGND.t75 sky130_fd_pr__cap_mim_m3_1 l=28.68 w=28.68
X150 FILTER__BUFFER1__COMP.t0 OUT.t0 VGND.t13 sky130_fd_pr__res_xhigh_po_1p41 l=3.36
X151 VPWR COMPARATOR__PREAMP__MIR.t3 COMPARATOR__PRE.t0 VPWR sky130_fd_pr__pfet_01v8_hvt ad=5.8 pd=40.58 as=5.8 ps=40.58 w=20 l=1
X152 DATA.t3 CLK.t4 SAMPLE__T.t2 VPWR sky130_fd_pr__pfet_01v8_hvt ad=0.1885 pd=1.88 as=0.1885 ps=1.88 w=0.65 l=0.15
X153 BIAS_SOURCE__VCM_BUFFER__PRE.t6 BIAS_SOURCE__VCM_BUFFER__COMP.t1 sky130_fd_pr__cap_mim_m3_1 l=28.68 w=28.68
X154 BIAS_SOURCE__VCM_RAW.t14 VGND.t32 sky130_fd_pr__cap_mim_m3_1 l=28.68 w=28.68
X155 VGND.t135 COMPARATOR__PRE.t3 CMP.t1 VGND.t134 sky130_fd_pr__nfet_01v8 ad=1.16 pd=8.58 as=1.16 ps=8.58 w=4 l=0.15
X156 VGND.t64 BIAS.t15 PGA__V8.t3 VGND.t63 sky130_fd_pr__nfet_01v8 ad=0.58 pd=4.58 as=0.58 ps=4.58 w=2 l=1
X157 FILTER__FILTER0.t12 VGND.t86 sky130_fd_pr__cap_mim_m3_1 l=28.68 w=28.68
X158 BIAS_SOURCE__VCM_RAW.t15 VGND.t116 sky130_fd_pr__cap_mim_m3_1 l=28.68 w=28.68
X159 VGND.t46 BIAS.t0 BIAS.t1 VGND.t45 sky130_fd_pr__nfet_01v8 ad=0.58 pd=4.58 as=0.58 ps=4.58 w=2 l=1
X160 FILTER__FILTER0.t13 VGND.t85 sky130_fd_pr__cap_mim_m3_1 l=28.68 w=28.68
X161 FILTER__BUFFER1__PRE.t6 FILTER__BUFFER1__COMP.t1 sky130_fd_pr__cap_mim_m3_1 l=28.68 w=28.68
X162 FILTER__BUFFER1__FIRST__TAIL.t4 OUT.t5 FILTER__BUFFER1__FIRST__MIR.t3 VGND.t69 sky130_fd_pr__nfet_01v8 ad=1.45 pd=10.58 as=1.45 ps=10.58 w=5 l=1
X163 PGA__OUTPUT_BUFFER__PRE.t6 PGA__OUTPUT_BUFFER__COMP.t0 sky130_fd_pr__cap_mim_m3_1 l=28.68 w=28.68
X164 VPWR CLK.t5 SAMPLE__CLKB.t0 VPWR sky130_fd_pr__pfet_01v8_hvt ad=0.1885 pd=1.88 as=0.1885 ps=1.88 w=0.65 l=0.15
X165 FILTER__FILTER0.t14 VGND.t80 sky130_fd_pr__cap_mim_m3_1 l=28.68 w=28.68
C0 PGA__V8 PGA__OUTPUT_BUFFER__PRE 0
C1 PGA__OUTPUT_BUFFER__PRE VPWR 10.9545f
C2 PGA__V8 BIAS 0.67466f
C3 PGA__GAIN8__AMP__PRE PGA__GAIN8__FB 0.51385f
C4 SAMPLE__MF SAMPLE__MB 27.1453f
C5 SAMPLE__M SAMPLE__TB 0
C6 PGA__GAIN8__FB VIN 0.19902f
C7 D SAMPLE__M 0.43673f
C8 SAMPLE__T DATA 28.525f
C9 FILTER__BUFFER0__PRE VCM 0.08452f
C10 SAMPLE__MB CLK 0.51973f
C11 VPWR BIAS 5.1605f
C12 PGA__GAINB VCM 0.08468f
C13 FILTER__FILTER1 VPWR 0.60737f
C14 D RESET 1.75855f
C15 FILTER__BUFFER1__FIRST__MIR OUT 63.9553f
C16 PGA__GAIN8__AMP__PRE PGA__GAIN8__AMP__FIRST__TAIL 13.5247f
C17 BIAS_SOURCE__VCM_BUFFER__PRE VPWR 8.75992f
C18 CMP VPWR 7.13026f
C19 PGA__GAIN8__AMP__FIRST__TAIL VIN 3.42118f
C20 PGA__V2 PGA__GAIN2__AMP__PRE 2.08976f
C21 COMPARATOR__PRE BIAS 18.2912f
C22 PGA__GAIN2__FB VCM 50.7512f
C23 COMPARATOR__PRE CMP 19.8786f
C24 PGA__GAIN2__FB BIAS_SOURCE__VCM_RAW 0.00283f
C25 PGA__GAIN2__AMP__FIRST__MIR VCM 0.09803f
C26 PGA__OUTPUT_BUFFER__FIRST__TAIL GAIN 0
C27 FILTER__FILTER0 VCM 0.18438f
C28 COMPARATOR__PREAMP__MIR D 0
C29 FILTER__BUFFER0__PRE FILTER__BUFFER0__FIRST__MIR 1.0973f
C30 PGA__OUTPUT_BUFFER__PRE BIAS 32.629f
C31 PGA__GAIN8__AMP__FIRST__MIR VPWR 10.0941f
C32 SAMPLE__MF SAMPLE__TB 0.00141f
C33 SAMPLE__T SAMPLE__MB 26.7727f
C34 PGA__OUTPUT_BUFFER__FIRST__MIR GAIN 0
C35 PGA__GAIN8__FB GAIN 0.26402f
C36 D SAMPLE__MF 0.00141f
C37 SAMPLE__CLKB SAMPLE__M 0.92822f
C38 SAMPLE__MB DATA 0.30167f
C39 SAMPLE__TB CLK 0
C40 VPWR OUT 8.74371f
C41 PGA__SELECTED VCM 0.08453f
C42 D CLK 5.16921f
C43 SAMPLE__CLKB RESET 0.00174f
C44 FILTER__BUFFER1__FIRST__MIR VCM 0.17704f
C45 BIAS_SOURCE__VCM_BUFFER__PRE BIAS 0.45993f
C46 FILTER__BUFFER1__PRE FILTER__BUFFER0__PRE 0.00149f
C47 CMP BIAS 0.45619f
C48 RESET_MUX__SB VPWR 3.85423f
C49 PGA__V2 PGA__OUTPUT_BUFFER__FIRST__TAIL 0
C50 PGA__GAIN8__AMP__FIRST__TAIL GAIN 0
C51 PGA__GAIN2__AMP__FIRST__TAIL VCM 0.09268f
C52 PGA__GAIN2__FB PGA__GAIN2__AMP__PRE 4.81377f
C53 FILTER__BUFFER0__PRE FILTER__MID 2.06548f
C54 COMPARATOR__PRE OUT 0.69962f
C55 PGA__V2 PGA__OUTPUT_BUFFER__FIRST__MIR 0
C56 PGA__V2 PGA__GAIN8__FB 23.9164f
C57 PGA__GAINB AMPLIFIED 0
C58 PGA__GAIN2__AMP__PRE PGA__GAIN2__AMP__FIRST__MIR 1.24471f
C59 COMPARATOR__PRE RESET_MUX__SB 0.41523f
C60 PGA__GAIN2__FB BIAS_SOURCE__VCM_BUFFER__FIRST__TAIL 0.00112f
C61 FILTER__BUFFER0__FIRST__MIR FILTER__FILTER0 19.0331f
C62 FILTER__BUFFER0__PRE FILTER__BUFFER0__FIRST__TAIL 0.87685f
C63 PGA__V2 PGA__GAIN8__AMP__FIRST__TAIL 0.26751f
C64 PGA__GAINB PGA__OUTPUT_BUFFER__FIRST__TAIL 0.00189f
C65 BIAS_SOURCE__VCM_BUFFER__FIRST__TAIL PGA__GAIN2__AMP__FIRST__MIR 0
C66 PGA__GAIN2__FB BIAS_SOURCE__VCM_BUFFER__FIRST__MIR 0
C67 PGA__V8 VCM 0.53655f
C68 PGA__GAIN8__AMP__FIRST__MIR BIAS 0
C69 SAMPLE__T SAMPLE__TB 0.83918f
C70 FILTER__BUFFER1__FIRST__TAIL FILTER__BUFFER0__PRE 0.00102f
C71 FILTER__BUFFER1__FIRST__MIR FILTER__BUFFER0__FIRST__MIR 0
C72 PGA__GAINB PGA__OUTPUT_BUFFER__FIRST__MIR 0.11583f
C73 PGA__GAIN8__FB PGA__GAINB 0.36067f
C74 BIAS_SOURCE__VCM_BUFFER__FIRST__MIR PGA__GAIN2__AMP__FIRST__MIR 0
C75 SAMPLE__CLKB SAMPLE__MF 7.81803f
C76 D SAMPLE__T 0
C77 PGA__GAIN8__AMP__PRE VIN 0.54529f
C78 SAMPLE__TB DATA 29.1257f
C79 VPWR VCM 9.68981f
C80 BIAS OUT 0.55248f
C81 PGA__GAIN2__AMP__PRE PGA__GAIN2__AMP__FIRST__TAIL 0.90781f
C82 FILTER__FILTER1 OUT 1.82686f
C83 D DATA 0
C84 SAMPLE__CLKB CLK 25.1278f
C85 FILTER__FILTER0 FILTER__MID 0.20026f
C86 RESET_MUX__SB BIAS 0
C87 CMP OUT 0
C88 FILTER__FILTER0 AMPLIFIED 42.6155f
C89 BIAS_SOURCE__VCM_RAW VPWR 0.17644f
C90 FILTER__BUFFER1__PRE FILTER__BUFFER1__FIRST__MIR 1.33792f
C91 BIAS_SOURCE__VCM_BUFFER__FIRST__TAIL PGA__GAIN2__AMP__FIRST__TAIL 0
C92 COMPARATOR__PREAMP__TAIL D 0
C93 CMP RESET_MUX__SB 3.61192f
C94 FILTER__FILTER0 FILTER__BUFFER0__FIRST__TAIL 3.06596f
C95 COMPARATOR__PRE VCM 0.08629f
C96 FILTER__FILTER0 PGA__OUTPUT_BUFFER__FIRST__TAIL 0
C97 FILTER__BUFFER1__FIRST__MIR FILTER__MID 29.9f
C98 PGA__SELECTED AMPLIFIED 0.19954f
C99 PGA__GAIN2__FB PGA__GAIN8__AMP__FIRST__TAIL 0.00125f
C100 FILTER__FILTER0 PGA__OUTPUT_BUFFER__FIRST__MIR 0
C101 FILTER__BUFFER1__FIRST__MIR FILTER__BUFFER0__FIRST__TAIL 0
C102 PGA__SELECTED PGA__OUTPUT_BUFFER__FIRST__TAIL 4.88578f
C103 FILTER__BUFFER1__FIRST__MIR COMPARATOR__PREAMP__MIR 0
C104 PGA__GAIN2__AMP__PRE VPWR 10.7197f
C105 PGA__OUTPUT_BUFFER__PRE VCM 0.08452f
C106 FILTER__BUFFER0__FIRST__MIR VPWR 9.57068f
C107 SAMPLE__MB SAMPLE__TB 0.57215f
C108 SAMPLE__M VPWR 10.6599f
C109 PGA__SELECTED PGA__OUTPUT_BUFFER__FIRST__MIR 30.3661f
C110 PGA__GAIN8__FB PGA__SELECTED 0
C111 PGA__GAIN8__AMP__PRE GAIN 0.00102f
C112 D SAMPLE__MB 0
C113 SAMPLE__CLKB SAMPLE__T 1.86854f
C114 FILTER__BUFFER1__FIRST__MIR FILTER__BUFFER1__FIRST__TAIL 9.41663f
C115 BIAS VCM 1.47096f
C116 VPWR RESET 5.583f
C117 BIAS_SOURCE__VCM_BUFFER__FIRST__TAIL VPWR 0.64669f
C118 FILTER__FILTER1 VCM 0.09219f
C119 SAMPLE__CLKB DATA 3.83661f
C120 BIAS_SOURCE__VCM_BUFFER__PRE VCM 2.16962f
C121 CMP VCM 0
C122 FILTER__BUFFER1__PRE VPWR 8.72866f
C123 BIAS_SOURCE__VCM_RAW BIAS 0.2536f
C124 BIAS_SOURCE__VCM_BUFFER__FIRST__MIR VPWR 10.3469f
C125 BIAS_SOURCE__VCM_BUFFER__PRE BIAS_SOURCE__VCM_RAW 0.55654f
C126 COMPARATOR__PREAMP__TAIL SAMPLE__CLKB 0
C127 COMPARATOR__PRE SAMPLE__M 0
C128 FILTER__MID VPWR 8.24226f
C129 COMPARATOR__PRE RESET 0.00417f
C130 PGA__GAIN8__AMP__PRE PGA__V2 0.2687f
C131 AMPLIFIED VPWR 9.90871f
C132 PGA__V8 PGA__OUTPUT_BUFFER__FIRST__TAIL 0.00128f
C133 PGA__V2 VIN 0.26385f
C134 FILTER__BUFFER1__PRE COMPARATOR__PRE 0
C135 FILTER__BUFFER0__FIRST__TAIL VPWR 0.5683f
C136 PGA__OUTPUT_BUFFER__FIRST__TAIL VPWR 1.4443f
C137 COMPARATOR__PREAMP__MIR VPWR 10.9575f
C138 PGA__V8 PGA__OUTPUT_BUFFER__FIRST__MIR 0.00232f
C139 PGA__GAIN8__FB PGA__V8 0.6271f
C140 PGA__GAIN2__AMP__PRE BIAS 57.7782f
C141 PGA__GAIN8__AMP__FIRST__MIR VCM 0.17561f
C142 FILTER__BUFFER0__FIRST__MIR BIAS 0.04261f
C143 PGA__OUTPUT_BUFFER__FIRST__MIR VPWR 13.0631f
C144 PGA__GAIN8__FB VPWR 0.60951f
C145 SAMPLE__MF VPWR 8.83445f
C146 PGA__GAIN8__AMP__FIRST__TAIL PGA__V8 0
C147 FILTER__BUFFER1__FIRST__TAIL VPWR 1.16085f
C148 SAMPLE__CLKB SAMPLE__MB 0.00128f
C149 BIAS RESET 0.00145f
C150 OUT VCM 12.6209f
C151 VPWR CLK 7.03659f
C152 BIAS_SOURCE__VCM_BUFFER__FIRST__TAIL BIAS 0.31443f
C153 CMP SAMPLE__M 0
C154 COMPARATOR__PREAMP__MIR COMPARATOR__PRE 1.07908f
C155 BIAS_SOURCE__VCM_BUFFER__PRE BIAS_SOURCE__VCM_BUFFER__FIRST__TAIL 45.0557f
C156 PGA__GAIN8__AMP__FIRST__TAIL VPWR 0.5683f
C157 RESET_MUX__SB VCM 0
C158 CMP RESET 21.9763f
C159 FILTER__BUFFER1__PRE BIAS 0.20749f
C160 FILTER__BUFFER1__PRE FILTER__FILTER1 2.07989f
C161 PGA__OUTPUT_BUFFER__PRE AMPLIFIED 2.47716f
C162 BIAS_SOURCE__VCM_BUFFER__FIRST__MIR BIAS 0.25371f
C163 FILTER__BUFFER1__FIRST__MIR COMPARATOR__PREAMP__TAIL 0
C164 BIAS_SOURCE__VCM_BUFFER__PRE BIAS_SOURCE__VCM_BUFFER__FIRST__MIR 1.15383f
C165 FILTER__MID BIAS 0.74413f
C166 COMPARATOR__PRE CLK 0
C167 PGA__GAIN8__AMP__PRE PGA__GAIN2__FB 0.24867f
C168 AMPLIFIED BIAS 2.1302f
C169 FILTER__MID FILTER__FILTER1 0.06004f
C170 PGA__OUTPUT_BUFFER__PRE PGA__OUTPUT_BUFFER__FIRST__TAIL 0.87642f
C171 PGA__V2 GAIN 26.3929f
C172 PGA__GAIN2__FB VIN 59.4778f
C173 PGA__GAIN8__AMP__FIRST__MIR PGA__GAIN2__AMP__PRE 0.00125f
C174 FILTER__BUFFER0__FIRST__TAIL BIAS 20.3164f
C175 PGA__OUTPUT_BUFFER__FIRST__TAIL BIAS 31.143f
C176 PGA__OUTPUT_BUFFER__PRE PGA__OUTPUT_BUFFER__FIRST__MIR 1.29889f
C177 PGA__GAIN2__AMP__FIRST__MIR VIN 53.6856f
C178 COMPARATOR__PREAMP__MIR BIAS 0.21025f
C179 COMPARATOR__PREAMP__MIR CMP 0
C180 FILTER__BUFFER0__FIRST__MIR OUT 0
C181 PGA__OUTPUT_BUFFER__FIRST__MIR BIAS 0.21091f
C182 PGA__GAIN8__FB BIAS 0.16777f
C183 SAMPLE__T VPWR 11.7063f
C184 FILTER__BUFFER1__FIRST__TAIL BIAS 0.0609f
C185 SAMPLE__CLKB SAMPLE__TB 0
C186 FILTER__BUFFER1__FIRST__TAIL FILTER__FILTER1 69.6814f
C187 OUT RESET 0
C188 VPWR DATA 7.4209f
C189 BIAS CLK 0.00539f
C190 PGA__GAINB GAIN 1.05158f
C191 CMP SAMPLE__MF 0
C192 D SAMPLE__CLKB 25.3856f
C193 RESET_MUX__SB SAMPLE__M 0
C194 PGA__GAIN8__AMP__FIRST__TAIL BIAS 0.06083f
C195 RESET_MUX__SB RESET 19.7503f
C196 CMP CLK 0.05993f
C197 FILTER__BUFFER1__PRE OUT 66.42071f
C198 BIAS_SOURCE__VCM_RAW VCM 0.20311f
C199 COMPARATOR__PREAMP__TAIL VPWR 1.08603f
C200 PGA__GAIN2__AMP__FIRST__TAIL VIN 4.4731f
C201 FILTER__MID OUT 0.00536f
C202 PGA__V2 PGA__GAINB 0.77917f
C203 COMPARATOR__PRE COMPARATOR__PREAMP__TAIL 0.72583f
C204 FILTER__BUFFER0__FIRST__TAIL OUT 0
C205 COMPARATOR__PREAMP__MIR OUT 1.3155f
C206 PGA__GAIN8__AMP__FIRST__MIR PGA__GAIN8__FB 0.82118f
C207 PGA__GAIN8__AMP__PRE PGA__V8 1.62072f
C208 PGA__GAIN2__AMP__PRE VCM 0.51488f
C209 FILTER__BUFFER0__FIRST__MIR VCM 0.08452f
C210 COMPARATOR__PREAMP__MIR RESET_MUX__SB 0
C211 PGA__GAIN8__AMP__PRE VPWR 8.57024f
C212 SAMPLE__MB VPWR 9.21582f
C213 FILTER__BUFFER1__FIRST__TAIL OUT 4.11157f
C214 PGA__V2 PGA__GAIN2__FB 0.58032f
C215 PGA__GAIN8__AMP__FIRST__MIR PGA__GAIN8__AMP__FIRST__TAIL 13.6947f
C216 VPWR VIN 4.91278f
C217 VCM RESET 0
C218 BIAS_SOURCE__VCM_BUFFER__FIRST__TAIL VCM 3.60685f
C219 PGA__SELECTED GAIN 5.74027f
C220 RESET_MUX__SB SAMPLE__MF 0
C221 PGA__V2 PGA__GAIN2__AMP__FIRST__MIR 0.00469f
C222 RESET_MUX__SB CLK 0.00731f
C223 FILTER__BUFFER1__PRE VCM 0.1723f
C224 BIAS_SOURCE__VCM_RAW BIAS_SOURCE__VCM_BUFFER__FIRST__TAIL 3.56898f
C225 COMPARATOR__PREAMP__TAIL BIAS 17.9458f
C226 BIAS_SOURCE__VCM_BUFFER__FIRST__MIR VCM 0.83563f
C227 FILTER__MID VCM 0.08452f
C228 COMPARATOR__PREAMP__TAIL CMP 0.00156f
C229 AMPLIFIED VCM 0.08452f
C230 BIAS_SOURCE__VCM_RAW BIAS_SOURCE__VCM_BUFFER__FIRST__MIR 43.5065f
C231 PGA__V2 PGA__SELECTED 6.76006f
C232 FILTER__BUFFER0__FIRST__TAIL VCM 0.08452f
C233 PGA__OUTPUT_BUFFER__FIRST__TAIL VCM 0.08452f
C234 FILTER__BUFFER0__PRE FILTER__FILTER0 0.54744f
C235 PGA__V2 PGA__GAIN2__AMP__FIRST__TAIL 55.029f
C236 COMPARATOR__PREAMP__MIR VCM 13.7291f
C237 PGA__V8 GAIN 27.5697f
C238 PGA__OUTPUT_BUFFER__FIRST__MIR VCM 0.08452f
C239 PGA__GAIN8__FB VCM 0.4352f
C240 PGA__GAIN8__AMP__PRE BIAS 0.20634f
C241 SAMPLE__M RESET 0
C242 SAMPLE__TB VPWR 10.0636f
C243 FILTER__BUFFER1__FIRST__TAIL VCM 0.16924f
C244 FILTER__BUFFER1__FIRST__MIR FILTER__BUFFER0__PRE 0.00432f
C245 PGA__GAINB PGA__SELECTED 33.1907f
C246 BIAS VIN 0.51415f
C247 D VPWR 7.50212f
C248 VPWR GAIN 5.23951f
C249 RESET_MUX__SB SAMPLE__T 0
C250 BIAS_SOURCE__VCM_BUFFER__PRE VIN 0.00237f
C251 PGA__GAIN8__AMP__FIRST__TAIL VCM 0.17154f
C252 PGA__GAIN2__FB PGA__GAIN2__AMP__FIRST__MIR 1.93352f
C253 FILTER__BUFFER0__FIRST__MIR FILTER__MID 0.77998f
C254 COMPARATOR__PREAMP__TAIL OUT 1.69683f
C255 PGA__V2 PGA__V8 0.34622f
C256 BIAS_SOURCE__VCM_BUFFER__FIRST__MIR BIAS_SOURCE__VCM_BUFFER__FIRST__TAIL 45.239f
C257 COMPARATOR__PRE D 0
C258 COMPARATOR__PREAMP__TAIL RESET_MUX__SB 0
C259 FILTER__BUFFER0__FIRST__MIR FILTER__BUFFER0__FIRST__TAIL 21.1825f
C260 PGA__V2 VPWR 14.0377f
C261 FILTER__BUFFER1__PRE FILTER__MID 0.00232f
C262 PGA__GAIN2__FB PGA__GAIN2__AMP__FIRST__TAIL 4.30553f
C263 COMPARATOR__PREAMP__MIR RESET 0
C264 FILTER__FILTER0 PGA__SELECTED 0
C265 PGA__GAIN8__AMP__PRE PGA__GAIN8__AMP__FIRST__MIR 1.14004f
C266 FILTER__BUFFER1__PRE FILTER__BUFFER0__FIRST__TAIL 0
C267 FILTER__BUFFER1__FIRST__MIR FILTER__FILTER0 0
C268 PGA__V8 PGA__GAINB 26.9661f
C269 PGA__OUTPUT_BUFFER__PRE GAIN 0
C270 SAMPLE__M SAMPLE__MF 26.5829f
C271 PGA__GAIN8__AMP__FIRST__MIR VIN 10.4335f
C272 FILTER__BUFFER1__PRE COMPARATOR__PREAMP__MIR 0.00204f
C273 PGA__GAIN2__AMP__FIRST__MIR PGA__GAIN2__AMP__FIRST__TAIL 57.1842f
C274 PGA__GAIN8__AMP__FIRST__TAIL PGA__GAIN2__AMP__PRE 0
C275 SAMPLE__MF RESET 0
C276 FILTER__BUFFER0__PRE VPWR 8.33188f
C277 SAMPLE__M CLK 26.5388f
C278 PGA__GAINB VPWR 3.59163f
C279 FILTER__BUFFER0__FIRST__TAIL FILTER__MID 3.11863f
C280 D BIAS 0
C281 SAMPLE__CLKB VPWR 4.75007f
C282 BIAS GAIN 0.32861f
C283 RESET CLK 0
C284 PGA__OUTPUT_BUFFER__FIRST__TAIL AMPLIFIED 4.94604f
C285 RESET_MUX__SB SAMPLE__MB 0
C286 FILTER__BUFFER1__PRE FILTER__BUFFER1__FIRST__TAIL 73.7633f
C287 CMP D 1.27517f
C288 COMPARATOR__PREAMP__TAIL VCM 1.84337f
C289 FILTER__BUFFER1__FIRST__TAIL FILTER__MID 0.00128f
C290 PGA__OUTPUT_BUFFER__FIRST__MIR AMPLIFIED 0.98711f
C291 COMPARATOR__PRE SAMPLE__CLKB 0
C292 PGA__GAIN2__FB VPWR 0.77014f
C293 PGA__V2 BIAS 57.4858f
C294 PGA__OUTPUT_BUFFER__FIRST__MIR PGA__OUTPUT_BUFFER__FIRST__TAIL 32.0453f
C295 PGA__GAIN8__FB PGA__OUTPUT_BUFFER__FIRST__TAIL 0
C296 PGA__V2 BIAS_SOURCE__VCM_BUFFER__PRE 0
C297 FILTER__BUFFER1__FIRST__TAIL COMPARATOR__PREAMP__MIR 0
C298 PGA__GAIN2__AMP__FIRST__MIR VPWR 12.083f
C299 FILTER__FILTER0 VPWR 1.90907f
C300 PGA__OUTPUT_BUFFER__PRE PGA__GAINB 0.35087f
C301 PGA__GAIN8__FB PGA__OUTPUT_BUFFER__FIRST__MIR 0
C302 PGA__V8 PGA__SELECTED 7.20106f
C303 SAMPLE__M SAMPLE__T 0.34264f
C304 PGA__GAIN8__AMP__PRE VCM 0.17905f
C305 SAMPLE__M DATA 0.19025f
C306 SAMPLE__MF CLK 8.04271f
C307 FILTER__BUFFER0__PRE BIAS 21.9681f
C308 PGA__GAINB BIAS 0.20646f
C309 PGA__SELECTED VPWR 9.49361f
C310 FILTER__BUFFER0__PRE FILTER__FILTER1 0
C311 SAMPLE__CLKB BIAS 0
C312 VCM VIN 0.41428f
C313 PGA__GAIN8__AMP__FIRST__TAIL PGA__GAIN8__FB 3.4836f
C314 FILTER__BUFFER1__FIRST__MIR VPWR 10.0271f
C315 CMP SAMPLE__CLKB 0
C316 RESET_MUX__SB D 20.3658f
C317 PGA__GAIN2__AMP__FIRST__TAIL VPWR 1.16198f
C318 BIAS_SOURCE__VCM_RAW VIN 0
C319 COMPARATOR__PREAMP__TAIL RESET 0
C320 PGA__GAIN8__AMP__FIRST__MIR PGA__V2 0.27192f
C321 FILTER__BUFFER1__PRE COMPARATOR__PREAMP__TAIL 0.00128f
C322 PGA__GAIN2__FB BIAS 0.52273f
C323 FILTER__FILTER0 PGA__OUTPUT_BUFFER__PRE 0.00432f
C324 PGA__GAIN2__FB BIAS_SOURCE__VCM_BUFFER__PRE 0.00432f
C325 PGA__GAIN2__AMP__FIRST__MIR BIAS 0.44906f
C326 FILTER__FILTER0 BIAS 0.00642f
C327 PGA__GAIN8__AMP__PRE PGA__GAIN2__AMP__PRE 0
C328 BIAS_SOURCE__VCM_BUFFER__PRE PGA__GAIN2__AMP__FIRST__MIR 0.00149f
C329 PGA__V8 VPWR 13.0701f
C330 PGA__OUTPUT_BUFFER__PRE PGA__SELECTED 0.69685f
C331 PGA__GAIN2__AMP__PRE VIN 0.70832f
C332 SAMPLE__MF SAMPLE__T 0.70687f
C333 SAMPLE__M SAMPLE__MB 0.83173f
C334 FILTER__BUFFER0__PRE OUT 0.00237f
C335 COMPARATOR__PREAMP__MIR COMPARATOR__PREAMP__TAIL 18.6244f
C336 SAMPLE__MB RESET 0
C337 SAMPLE__MF DATA 0.17251f
C338 SAMPLE__T CLK 0.92918f
C339 PGA__SELECTED BIAS 0.17063f
C340 FILTER__BUFFER1__FIRST__MIR BIAS 0
C341 CLK DATA 4.55313f
C342 VCM GAIN 0.08489f
C343 BIAS_SOURCE__VCM_BUFFER__FIRST__TAIL VIN 0
C344 FILTER__BUFFER1__FIRST__MIR FILTER__FILTER1 2.18028f
C345 RESET_MUX__SB SAMPLE__CLKB 0.47677f
C346 FILTER__BUFFER1__FIRST__TAIL COMPARATOR__PREAMP__TAIL 0
C347 PGA__GAIN2__AMP__FIRST__TAIL BIAS 1.00623f
C348 BIAS_SOURCE__VCM_BUFFER__FIRST__MIR VIN 0
C349 PGA__GAIN8__AMP__FIRST__MIR PGA__GAIN2__FB 0.81749f
C350 BIAS_SOURCE__VCM_BUFFER__PRE PGA__GAIN2__AMP__FIRST__TAIL 0.00102f
C351 COMPARATOR__PRE VPWR 9.33482f
C352 PGA__V2 VCM 0.61336f
C353 GAIN VGND 40.64631f
C354 VIN VGND 35.74971f
C355 DATA VGND 41.72659f
C356 CLK VGND 46.64253f
C357 RESET VGND 34.11952f
C358 VCM VGND 86.48993f
C359 OUT VGND 43.15819f
C360 BIAS VGND 0.15322p
C361 VPWR VGND 0.60958p
C362 PGA__GAIN2__AMP__FIRST__TAIL VGND 32.45383f $ **FLOATING
C363 PGA__GAIN2__AMP__FIRST__MIR VGND 31.67165f $ **FLOATING
C364 PGA__GAIN2__AMP__PRE VGND 0.20422p $ **FLOATING
C365 BIAS_SOURCE__VCM_BUFFER__FIRST__TAIL VGND 26.39275f $ **FLOATING
C366 BIAS_SOURCE__VCM_BUFFER__FIRST__MIR VGND 25.77223f $ **FLOATING
C367 BIAS_SOURCE__VCM_RAW VGND 0.98442p $ **FLOATING
C368 BIAS_SOURCE__VCM_BUFFER__PRE VGND 0.18701p $ **FLOATING
C369 AMPLIFIED VGND 40.84047f $ **FLOATING
C370 PGA__OUTPUT_BUFFER__FIRST__TAIL VGND 27.21733f $ **FLOATING
C371 PGA__OUTPUT_BUFFER__FIRST__MIR VGND 26.13841f $ **FLOATING
C372 PGA__SELECTED VGND 31.4823f $ **FLOATING
C373 PGA__GAINB VGND 17.65254f $ **FLOATING
C374 PGA__OUTPUT_BUFFER__PRE VGND 0.18101p $ **FLOATING
C375 PGA__V8 VGND 30.73531f $ **FLOATING
C376 PGA__GAIN8__FB VGND 22.97401f $ **FLOATING
C377 PGA__GAIN8__AMP__FIRST__TAIL VGND 17.42788f $ **FLOATING
C378 PGA__GAIN2__FB VGND 35.20316f $ **FLOATING
C379 PGA__V2 VGND 52.36965f $ **FLOATING
C380 PGA__GAIN8__AMP__FIRST__MIR VGND 16.3643f $ **FLOATING
C381 PGA__GAIN8__AMP__PRE VGND 0.15376p $ **FLOATING
C382 FILTER__FILTER1 VGND 1.05083p $ **FLOATING
C383 FILTER__MID VGND 27.55106f $ **FLOATING
C384 FILTER__BUFFER0__FIRST__TAIL VGND 18.25682f $ **FLOATING
C385 FILTER__FILTER0 VGND 1.07103p $ **FLOATING
C386 FILTER__BUFFER0__FIRST__MIR VGND 17.74172f $ **FLOATING
C387 FILTER__BUFFER0__PRE VGND 0.16133p $ **FLOATING
C388 SAMPLE__TB VGND 53.52327f $ **FLOATING
C389 SAMPLE__MB VGND 23.44366f $ **FLOATING
C390 SAMPLE__T VGND 30.04408f $ **FLOATING
C391 SAMPLE__MF VGND 21.10629f $ **FLOATING
C392 SAMPLE__M VGND 27.79856f $ **FLOATING
C393 SAMPLE__CLKB VGND 23.5902f $ **FLOATING
C394 D VGND 22.03778f $ **FLOATING
C395 RESET_MUX__SB VGND 19.28559f $ **FLOATING
C396 CMP VGND 16.26899f $ **FLOATING
C397 COMPARATOR__PREAMP__TAIL VGND 15.00638f $ **FLOATING
C398 COMPARATOR__PRE VGND 19.23853f $ **FLOATING
C399 COMPARATOR__PREAMP__MIR VGND 16.25252f $ **FLOATING
C400 FILTER__BUFFER1__FIRST__TAIL VGND 34.00734f $ **FLOATING
C401 FILTER__BUFFER1__FIRST__MIR VGND 52.10983f $ **FLOATING
C402 FILTER__BUFFER1__PRE VGND 0.21084p $ **FLOATING
C403 SAMPLE__MB.n0 VGND 0.0121f $ **FLOATING
C404 SAMPLE__MB.t3 VGND 0.04998f $ **FLOATING
C405 SAMPLE__MB.t2 VGND 0.05194f $ **FLOATING
C406 SAMPLE__MB.n1 VGND 7.11582f $ **FLOATING
C407 SAMPLE__MB.n2 VGND 0.01382f $ **FLOATING
C408 SAMPLE__MB.t1 VGND 0.0336f $ **FLOATING
C409 SAMPLE__MB.n3 VGND 0.01382f $ **FLOATING
C410 SAMPLE__MB.n4 VGND 1.78754f $ **FLOATING
C411 SAMPLE__MB.n5 VGND 49.0513f $ **FLOATING
C412 SAMPLE__MB.n6 VGND 2.82913f $ **FLOATING
C413 SAMPLE__MB.t0 VGND 0.03705f $ **FLOATING
C414 SAMPLE__MB.n7 VGND 0.0121f $ **FLOATING
C415 PGA__GAIN2__AMP__FIRST__TAIL.n0 VGND 0.03188f $ **FLOATING
C416 PGA__GAIN2__AMP__FIRST__TAIL.t0 VGND 0.05195f $ **FLOATING
C417 PGA__GAIN2__AMP__FIRST__TAIL.n1 VGND 0.04308f $ **FLOATING
C418 PGA__GAIN2__AMP__FIRST__TAIL.t3 VGND 0.0526f $ **FLOATING
C419 PGA__GAIN2__AMP__FIRST__TAIL.n2 VGND 0.04308f $ **FLOATING
C420 PGA__GAIN2__AMP__FIRST__TAIL.n3 VGND 4.81479f $ **FLOATING
C421 PGA__GAIN2__AMP__FIRST__TAIL.n4 VGND 0.04308f $ **FLOATING
C422 PGA__GAIN2__AMP__FIRST__TAIL.t2 VGND 0.0526f $ **FLOATING
C423 PGA__GAIN2__AMP__FIRST__TAIL.n5 VGND 0.04308f $ **FLOATING
C424 PGA__GAIN2__AMP__FIRST__TAIL.n6 VGND 2.16092f $ **FLOATING
C425 PGA__GAIN2__AMP__FIRST__TAIL.n7 VGND 97.5978f $ **FLOATING
C426 PGA__GAIN2__AMP__FIRST__TAIL.n8 VGND 0.04308f $ **FLOATING
C427 PGA__GAIN2__AMP__FIRST__TAIL.t1 VGND 0.0526f $ **FLOATING
C428 PGA__GAIN2__AMP__FIRST__TAIL.n9 VGND 0.04308f $ **FLOATING
C429 PGA__GAIN2__AMP__FIRST__TAIL.n10 VGND 2.16092f $ **FLOATING
C430 PGA__GAIN2__AMP__FIRST__TAIL.n11 VGND 2.77599f $ **FLOATING
C431 PGA__GAIN2__AMP__FIRST__TAIL.n12 VGND 0.04308f $ **FLOATING
C432 PGA__GAIN2__AMP__FIRST__TAIL.t4 VGND 0.0526f $ **FLOATING
C433 PGA__GAIN2__AMP__FIRST__TAIL.n13 VGND 0.04308f $ **FLOATING
C434 PGA__GAIN2__AMP__FIRST__TAIL.n14 VGND 2.16092f $ **FLOATING
C435 PGA__GAIN2__AMP__FIRST__TAIL.n15 VGND 6.66151f $ **FLOATING
C436 PGA__GAIN2__AMP__FIRST__TAIL.n16 VGND 1.94355f $ **FLOATING
C437 PGA__GAIN2__AMP__FIRST__TAIL.n17 VGND 0.03074f $ **FLOATING
C438 PGA__GAIN2__FB.t3 VGND 1.05998f $ **FLOATING
C439 PGA__GAIN2__FB.t1 VGND 2.07599f $ **FLOATING
C440 PGA__GAIN2__FB.t0 VGND 1.63275f $ **FLOATING
C441 PGA__GAIN2__FB.n0 VGND 53.8909f $ **FLOATING
C442 PGA__GAIN2__FB.t2 VGND 1.05998f $ **FLOATING
C443 PGA__GAIN2__FB.n1 VGND 65.6809f $ **FLOATING
C444 PGA__GAIN8__AMP__FIRST__TAIL.n0 VGND 0.02848f $ **FLOATING
C445 PGA__GAIN8__AMP__FIRST__TAIL.t0 VGND 0.0464f $ **FLOATING
C446 PGA__GAIN8__AMP__FIRST__TAIL.n1 VGND 0.03849f $ **FLOATING
C447 PGA__GAIN8__AMP__FIRST__TAIL.t2 VGND 0.04699f $ **FLOATING
C448 PGA__GAIN8__AMP__FIRST__TAIL.n2 VGND 0.03849f $ **FLOATING
C449 PGA__GAIN8__AMP__FIRST__TAIL.n3 VGND 2.11061f $ **FLOATING
C450 PGA__GAIN8__AMP__FIRST__TAIL.n4 VGND 0.03849f $ **FLOATING
C451 PGA__GAIN8__AMP__FIRST__TAIL.t4 VGND 0.04699f $ **FLOATING
C452 PGA__GAIN8__AMP__FIRST__TAIL.n5 VGND 0.03849f $ **FLOATING
C453 PGA__GAIN8__AMP__FIRST__TAIL.n6 VGND 1.59314f $ **FLOATING
C454 PGA__GAIN8__AMP__FIRST__TAIL.n7 VGND 17.8064f $ **FLOATING
C455 PGA__GAIN8__AMP__FIRST__TAIL.n8 VGND 0.03849f $ **FLOATING
C456 PGA__GAIN8__AMP__FIRST__TAIL.t3 VGND 0.04699f $ **FLOATING
C457 PGA__GAIN8__AMP__FIRST__TAIL.n9 VGND 0.03849f $ **FLOATING
C458 PGA__GAIN8__AMP__FIRST__TAIL.n10 VGND 1.59314f $ **FLOATING
C459 PGA__GAIN8__AMP__FIRST__TAIL.n11 VGND 2.12237f $ **FLOATING
C460 PGA__GAIN8__AMP__FIRST__TAIL.n12 VGND 0.03849f $ **FLOATING
C461 PGA__GAIN8__AMP__FIRST__TAIL.t1 VGND 0.04699f $ **FLOATING
C462 PGA__GAIN8__AMP__FIRST__TAIL.n13 VGND 0.03849f $ **FLOATING
C463 PGA__GAIN8__AMP__FIRST__TAIL.n14 VGND 1.59314f $ **FLOATING
C464 PGA__GAIN8__AMP__FIRST__TAIL.n15 VGND 5.23215f $ **FLOATING
C465 PGA__GAIN8__AMP__FIRST__TAIL.n16 VGND 1.40271f $ **FLOATING
C466 PGA__GAIN8__AMP__FIRST__TAIL.n17 VGND 0.02746f $ **FLOATING
C467 VIN.t1 VGND 1.14239f $ **FLOATING
C468 VIN.t2 VGND 1.14239f $ **FLOATING
C469 VIN.t0 VGND 1.14239f $ **FLOATING
C470 VIN.n0 VGND 18.5136f $ **FLOATING
C471 VIN.n1 VGND 52.6134f $ **FLOATING
C472 VIN.n2 VGND 56.6963f $ **FLOATING
C473 VIN.t3 VGND 1.14239f $ **FLOATING
C474 SAMPLE__T.n0 VGND 0.01268f $ **FLOATING
C475 SAMPLE__T.t5 VGND 0.04586f $ **FLOATING
C476 SAMPLE__T.t4 VGND 0.04765f $ **FLOATING
C477 SAMPLE__T.n1 VGND 8.38568f $ **FLOATING
C478 SAMPLE__T.n2 VGND 0.0111f $ **FLOATING
C479 SAMPLE__T.t2 VGND 0.03399f $ **FLOATING
C480 SAMPLE__T.n3 VGND 0.0111f $ **FLOATING
C481 SAMPLE__T.n4 VGND 1.68336f $ **FLOATING
C482 SAMPLE__T.n5 VGND 4.65568f $ **FLOATING
C483 SAMPLE__T.n6 VGND 0.01268f $ **FLOATING
C484 SAMPLE__T.t3 VGND 0.03083f $ **FLOATING
C485 SAMPLE__T.n7 VGND 0.01268f $ **FLOATING
C486 SAMPLE__T.n8 VGND 2.54403f $ **FLOATING
C487 SAMPLE__T.n9 VGND 0.0111f $ **FLOATING
C488 SAMPLE__T.t1 VGND 0.03399f $ **FLOATING
C489 SAMPLE__T.n10 VGND 0.0111f $ **FLOATING
C490 SAMPLE__T.n11 VGND 1.68336f $ **FLOATING
C491 SAMPLE__T.n12 VGND 41.3248f $ **FLOATING
C492 SAMPLE__T.n13 VGND 2.72797f $ **FLOATING
C493 SAMPLE__T.n14 VGND 1.68335f $ **FLOATING
C494 SAMPLE__T.t0 VGND 0.03083f $ **FLOATING
C495 SAMPLE__T.n15 VGND 0.01268f $ **FLOATING
C496 SAMPLE__MF.n0 VGND 0.01359f $ **FLOATING
C497 SAMPLE__MF.n1 VGND 0.01552f $ **FLOATING
C498 SAMPLE__MF.t1 VGND 0.03775f $ **FLOATING
C499 SAMPLE__MF.n2 VGND 0.01552f $ **FLOATING
C500 SAMPLE__MF.n3 VGND 2.017f $ **FLOATING
C501 SAMPLE__MF.n4 VGND 0.01552f $ **FLOATING
C502 SAMPLE__MF.t4 VGND 0.03775f $ **FLOATING
C503 SAMPLE__MF.n5 VGND 0.01552f $ **FLOATING
C504 SAMPLE__MF.n6 VGND 3.00515f $ **FLOATING
C505 SAMPLE__MF.n7 VGND 0.01359f $ **FLOATING
C506 SAMPLE__MF.t3 VGND 0.04162f $ **FLOATING
C507 SAMPLE__MF.n8 VGND 0.01359f $ **FLOATING
C508 SAMPLE__MF.n9 VGND 1.95516f $ **FLOATING
C509 SAMPLE__MF.n10 VGND 48.7319f $ **FLOATING
C510 SAMPLE__MF.n11 VGND 0.01552f $ **FLOATING
C511 SAMPLE__MF.t5 VGND 0.03775f $ **FLOATING
C512 SAMPLE__MF.n12 VGND 0.01552f $ **FLOATING
C513 SAMPLE__MF.n13 VGND 1.95516f $ **FLOATING
C514 SAMPLE__MF.n14 VGND 3.22868f $ **FLOATING
C515 SAMPLE__MF.n15 VGND 0.01359f $ **FLOATING
C516 SAMPLE__MF.t2 VGND 0.04162f $ **FLOATING
C517 SAMPLE__MF.n16 VGND 0.01359f $ **FLOATING
C518 SAMPLE__MF.n17 VGND 1.95516f $ **FLOATING
C519 SAMPLE__MF.n18 VGND 5.18012f $ **FLOATING
C520 SAMPLE__MF.n19 VGND 7.86013f $ **FLOATING
C521 SAMPLE__MF.n20 VGND 1.95516f $ **FLOATING
C522 SAMPLE__MF.t0 VGND 0.04162f $ **FLOATING
C523 SAMPLE__MF.n21 VGND 0.01359f $ **FLOATING
C524 SAMPLE__CLKB.n0 VGND 0.01267f $ **FLOATING
C525 SAMPLE__CLKB.t5 VGND 0.05234f $ **FLOATING
C526 SAMPLE__CLKB.t3 VGND 0.05439f $ **FLOATING
C527 SAMPLE__CLKB.n1 VGND 7.20406f $ **FLOATING
C528 SAMPLE__CLKB.t2 VGND 0.05439f $ **FLOATING
C529 SAMPLE__CLKB.n2 VGND 5.08812f $ **FLOATING
C530 SAMPLE__CLKB.t4 VGND 0.05234f $ **FLOATING
C531 SAMPLE__CLKB.n3 VGND 4.80309f $ **FLOATING
C532 SAMPLE__CLKB.n4 VGND 0.01447f $ **FLOATING
C533 SAMPLE__CLKB.t1 VGND 0.03519f $ **FLOATING
C534 SAMPLE__CLKB.n5 VGND 0.01447f $ **FLOATING
C535 SAMPLE__CLKB.n6 VGND 1.67493f $ **FLOATING
C536 SAMPLE__CLKB.n7 VGND 41.4097f $ **FLOATING
C537 SAMPLE__CLKB.n8 VGND 2.60852f $ **FLOATING
C538 SAMPLE__CLKB.t0 VGND 0.0388f $ **FLOATING
C539 SAMPLE__CLKB.n9 VGND 0.01267f $ **FLOATING
C540 D.n0 VGND 0.01295f $ **FLOATING
C541 D.n1 VGND 0.01134f $ **FLOATING
C542 D.t3 VGND 0.03473f $ **FLOATING
C543 D.n2 VGND 0.01134f $ **FLOATING
C544 D.n3 VGND 1.50605f $ **FLOATING
C545 D.n4 VGND 0.01295f $ **FLOATING
C546 D.t2 VGND 0.0315f $ **FLOATING
C547 D.n5 VGND 0.01295f $ **FLOATING
C548 D.n6 VGND 2.30652f $ **FLOATING
C549 D.n7 VGND 0.01134f $ **FLOATING
C550 D.t5 VGND 0.03473f $ **FLOATING
C551 D.n8 VGND 0.01134f $ **FLOATING
C552 D.n9 VGND 1.45519f $ **FLOATING
C553 D.n10 VGND 36.8345f $ **FLOATING
C554 D.n11 VGND 0.01295f $ **FLOATING
C555 D.t4 VGND 0.0315f $ **FLOATING
C556 D.n12 VGND 0.01295f $ **FLOATING
C557 D.n13 VGND 1.45519f $ **FLOATING
C558 D.n14 VGND 2.50764f $ **FLOATING
C559 D.n15 VGND 0.01134f $ **FLOATING
C560 D.t1 VGND 0.03473f $ **FLOATING
C561 D.n16 VGND 0.01134f $ **FLOATING
C562 D.n17 VGND 1.45519f $ **FLOATING
C563 D.n18 VGND 3.54658f $ **FLOATING
C564 D.n19 VGND 5.59717f $ **FLOATING
C565 D.n20 VGND 1.45519f $ **FLOATING
C566 D.t0 VGND 0.0315f $ **FLOATING
C567 D.n21 VGND 0.01295f $ **FLOATING
C568 SAMPLE__M.n0 VGND 0.01138f $ **FLOATING
C569 SAMPLE__M.t5 VGND 0.04702f $ **FLOATING
C570 SAMPLE__M.t4 VGND 0.04886f $ **FLOATING
C571 SAMPLE__M.n1 VGND 8.24265f $ **FLOATING
C572 SAMPLE__M.n2 VGND 0.013f $ **FLOATING
C573 SAMPLE__M.t1 VGND 0.03161f $ **FLOATING
C574 SAMPLE__M.n3 VGND 0.013f $ **FLOATING
C575 SAMPLE__M.n4 VGND 2.44335f $ **FLOATING
C576 SAMPLE__M.n5 VGND 0.01138f $ **FLOATING
C577 SAMPLE__M.t2 VGND 0.03485f $ **FLOATING
C578 SAMPLE__M.n6 VGND 0.01138f $ **FLOATING
C579 SAMPLE__M.n7 VGND 1.5931f $ **FLOATING
C580 SAMPLE__M.n8 VGND 38.8634f $ **FLOATING
C581 SAMPLE__M.n9 VGND 0.013f $ **FLOATING
C582 SAMPLE__M.t3 VGND 0.03161f $ **FLOATING
C583 SAMPLE__M.n10 VGND 0.013f $ **FLOATING
C584 SAMPLE__M.n11 VGND 1.5931f $ **FLOATING
C585 SAMPLE__M.n12 VGND 2.65721f $ **FLOATING
C586 SAMPLE__M.n13 VGND 4.6338f $ **FLOATING
C587 SAMPLE__M.n14 VGND 1.5931f $ **FLOATING
C588 SAMPLE__M.t0 VGND 0.03485f $ **FLOATING
C589 SAMPLE__M.n15 VGND 0.01138f $ **FLOATING
C590 CLK.t4 VGND 0.05673f $ **FLOATING
C591 CLK.t3 VGND 0.05459f $ **FLOATING
C592 CLK.n0 VGND 9.60118f $ **FLOATING
C593 CLK.t1 VGND 0.05459f $ **FLOATING
C594 CLK.n1 VGND 4.34499f $ **FLOATING
C595 CLK.t0 VGND 0.05673f $ **FLOATING
C596 CLK.n2 VGND 4.33834f $ **FLOATING
C597 CLK.t2 VGND 0.05459f $ **FLOATING
C598 CLK.n3 VGND 4.34096f $ **FLOATING
C599 CLK.t5 VGND 0.05673f $ **FLOATING
C600 CLK.n4 VGND 30.1974f $ **FLOATING
C601 BIAS_SOURCE_R_VCM_BOTTOM_R0_N0.t1 VGND 7.00899f $ **FLOATING
C602 BIAS_SOURCE_R_VCM_BOTTOM_R0_N0.t0 VGND 8.59101f $ **FLOATING
C603 BIAS_SOURCE__VCM_BUFFER__FIRST__TAIL.n0 VGND 0.04405f $ **FLOATING
C604 BIAS_SOURCE__VCM_BUFFER__FIRST__TAIL.n1 VGND 0.0326f $ **FLOATING
C605 BIAS_SOURCE__VCM_BUFFER__FIRST__TAIL.t2 VGND 0.05312f $ **FLOATING
C606 BIAS_SOURCE__VCM_BUFFER__FIRST__TAIL.n2 VGND 0.03143f $ **FLOATING
C607 BIAS_SOURCE__VCM_BUFFER__FIRST__TAIL.n3 VGND 1.65303f $ **FLOATING
C608 BIAS_SOURCE__VCM_BUFFER__FIRST__TAIL.n4 VGND 0.04405f $ **FLOATING
C609 BIAS_SOURCE__VCM_BUFFER__FIRST__TAIL.t0 VGND 0.05379f $ **FLOATING
C610 BIAS_SOURCE__VCM_BUFFER__FIRST__TAIL.n5 VGND 0.04405f $ **FLOATING
C611 BIAS_SOURCE__VCM_BUFFER__FIRST__TAIL.n6 VGND 4.26534f $ **FLOATING
C612 BIAS_SOURCE__VCM_BUFFER__FIRST__TAIL.n7 VGND 0.04405f $ **FLOATING
C613 BIAS_SOURCE__VCM_BUFFER__FIRST__TAIL.t4 VGND 0.05379f $ **FLOATING
C614 BIAS_SOURCE__VCM_BUFFER__FIRST__TAIL.n8 VGND 0.04405f $ **FLOATING
C615 BIAS_SOURCE__VCM_BUFFER__FIRST__TAIL.n9 VGND 1.8716f $ **FLOATING
C616 BIAS_SOURCE__VCM_BUFFER__FIRST__TAIL.n10 VGND 76.654f $ **FLOATING
C617 BIAS_SOURCE__VCM_BUFFER__FIRST__TAIL.n11 VGND 0.04405f $ **FLOATING
C618 BIAS_SOURCE__VCM_BUFFER__FIRST__TAIL.t3 VGND 0.05379f $ **FLOATING
C619 BIAS_SOURCE__VCM_BUFFER__FIRST__TAIL.n12 VGND 0.04405f $ **FLOATING
C620 BIAS_SOURCE__VCM_BUFFER__FIRST__TAIL.n13 VGND 1.8716f $ **FLOATING
C621 BIAS_SOURCE__VCM_BUFFER__FIRST__TAIL.n14 VGND 2.48071f $ **FLOATING
C622 BIAS_SOURCE__VCM_BUFFER__FIRST__TAIL.n15 VGND 6.09225f $ **FLOATING
C623 BIAS_SOURCE__VCM_BUFFER__FIRST__TAIL.n16 VGND 1.8716f $ **FLOATING
C624 BIAS_SOURCE__VCM_BUFFER__FIRST__TAIL.t1 VGND 0.05379f $ **FLOATING
C625 BIAS_SOURCE__VCM_BUFFER__FIRST__TAIL.n17 VGND 0.04405f $ **FLOATING
C626 CMP.n0 VGND 0.08626f $ **FLOATING
C627 CMP.n1 VGND 0.01249f $ **FLOATING
C628 CMP.t3 VGND 0.03824f $ **FLOATING
C629 CMP.n2 VGND 0.01249f $ **FLOATING
C630 CMP.n3 VGND 1.51304f $ **FLOATING
C631 CMP.n4 VGND 0.01427f $ **FLOATING
C632 CMP.t2 VGND 0.03469f $ **FLOATING
C633 CMP.n5 VGND 0.01427f $ **FLOATING
C634 CMP.n6 VGND 1.45774f $ **FLOATING
C635 CMP.n7 VGND 5.85238f $ **FLOATING
C636 CMP.n8 VGND 0.03048f $ **FLOATING
C637 CMP.t1 VGND 0.06699f $ **FLOATING
C638 CMP.n9 VGND 0.20966f $ **FLOATING
C639 CMP.n10 VGND 0.00943f $ **FLOATING
C640 CMP.n11 VGND 1.72597f $ **FLOATING
C641 CMP.n12 VGND 37.9768f $ **FLOATING
C642 CMP.n13 VGND 2.92126f $ **FLOATING
C643 CMP.t0 VGND 0.13399f $ **FLOATING
C644 CMP.n14 VGND 0.41529f $ **FLOATING
C645 CMP.n15 VGND 0.02573f $ **FLOATING
C646 FILTER__BUFFER1__COMP.t1 VGND 80.129f $ **FLOATING
C647 FILTER__BUFFER1__COMP.t3 VGND 77.7706f $ **FLOATING
C648 FILTER__BUFFER1__COMP.n0 VGND 6.35575f $ **FLOATING
C649 FILTER__BUFFER1__COMP.t2 VGND 77.7706f $ **FLOATING
C650 FILTER__BUFFER1__COMP.n1 VGND 2.2462f $ **FLOATING
C651 FILTER__BUFFER1__COMP.t0 VGND 0.7279f $ **FLOATING
C652 BIAS_SOURCE__VCM_BUFFER__FIRST__MIR.n0 VGND 0.05823f $ **FLOATING
C653 BIAS_SOURCE__VCM_BUFFER__FIRST__MIR.t1 VGND 0.06976f $ **FLOATING
C654 BIAS_SOURCE__VCM_BUFFER__FIRST__MIR.t4 VGND 3.54883f $ **FLOATING
C655 BIAS_SOURCE__VCM_BUFFER__FIRST__MIR.t0 VGND 3.54883f $ **FLOATING
C656 BIAS_SOURCE__VCM_BUFFER__FIRST__MIR.n1 VGND 3.7715f $ **FLOATING
C657 BIAS_SOURCE__VCM_BUFFER__FIRST__MIR.n2 VGND 0.04113f $ **FLOATING
C658 BIAS_SOURCE__VCM_BUFFER__FIRST__MIR.t2 VGND 0.05021f $ **FLOATING
C659 BIAS_SOURCE__VCM_BUFFER__FIRST__MIR.n3 VGND 0.04113f $ **FLOATING
C660 BIAS_SOURCE__VCM_BUFFER__FIRST__MIR.n4 VGND 4.00965f $ **FLOATING
C661 BIAS_SOURCE__VCM_BUFFER__FIRST__MIR.n5 VGND 0.04113f $ **FLOATING
C662 BIAS_SOURCE__VCM_BUFFER__FIRST__MIR.t3 VGND 0.05021f $ **FLOATING
C663 BIAS_SOURCE__VCM_BUFFER__FIRST__MIR.n6 VGND 0.04113f $ **FLOATING
C664 BIAS_SOURCE__VCM_BUFFER__FIRST__MIR.n7 VGND 1.7024f $ **FLOATING
C665 BIAS_SOURCE__VCM_BUFFER__FIRST__MIR.n8 VGND 72.7072f $ **FLOATING
C666 BIAS_SOURCE__VCM_BUFFER__FIRST__MIR.n9 VGND 2.49348f $ **FLOATING
C667 BIAS_SOURCE__VCM_BUFFER__FIRST__MIR.n10 VGND 3.86843f $ **FLOATING
C668 BIAS_SOURCE__VCM_BUFFER__FIRST__MIR.n11 VGND 0.05733f $ **FLOATING
C669 BIAS_SOURCE_R_VCM_TOP_R0_N1.t1 VGND 6.30416f $ **FLOATING
C670 BIAS_SOURCE_R_VCM_TOP_R0_N1.t0 VGND 7.39585f $ **FLOATING
C671 BIAS_SOURCE_R_VCM_TOP_R0_N0.t1 VGND 2.9058f $ **FLOATING
C672 BIAS_SOURCE_R_VCM_TOP_R0_N0.t0 VGND 3.6942f $ **FLOATING
C673 FILTER__BUFFER0__FIRST__TAIL.n0 VGND 0.04115f $ **FLOATING
C674 FILTER__BUFFER0__FIRST__TAIL.n1 VGND 0.03045f $ **FLOATING
C675 FILTER__BUFFER0__FIRST__TAIL.t2 VGND 0.04962f $ **FLOATING
C676 FILTER__BUFFER0__FIRST__TAIL.n2 VGND 0.02936f $ **FLOATING
C677 FILTER__BUFFER0__FIRST__TAIL.n3 VGND 1.36746f $ **FLOATING
C678 FILTER__BUFFER0__FIRST__TAIL.n4 VGND 0.04115f $ **FLOATING
C679 FILTER__BUFFER0__FIRST__TAIL.t3 VGND 0.05025f $ **FLOATING
C680 FILTER__BUFFER0__FIRST__TAIL.n5 VGND 0.04115f $ **FLOATING
C681 FILTER__BUFFER0__FIRST__TAIL.n6 VGND 1.56931f $ **FLOATING
C682 FILTER__BUFFER0__FIRST__TAIL.n7 VGND 5.30391f $ **FLOATING
C683 FILTER__BUFFER0__FIRST__TAIL.n8 VGND 0.04115f $ **FLOATING
C684 FILTER__BUFFER0__FIRST__TAIL.t0 VGND 0.05025f $ **FLOATING
C685 FILTER__BUFFER0__FIRST__TAIL.n9 VGND 0.04115f $ **FLOATING
C686 FILTER__BUFFER0__FIRST__TAIL.n10 VGND 1.56931f $ **FLOATING
C687 FILTER__BUFFER0__FIRST__TAIL.n11 VGND 2.12494f $ **FLOATING
C688 FILTER__BUFFER0__FIRST__TAIL.n12 VGND 0.04115f $ **FLOATING
C689 FILTER__BUFFER0__FIRST__TAIL.t4 VGND 0.05025f $ **FLOATING
C690 FILTER__BUFFER0__FIRST__TAIL.n13 VGND 0.04115f $ **FLOATING
C691 FILTER__BUFFER0__FIRST__TAIL.n14 VGND 2.58756f $ **FLOATING
C692 FILTER__BUFFER0__FIRST__TAIL.n15 VGND 30.9171f $ **FLOATING
C693 FILTER__BUFFER0__FIRST__TAIL.n16 VGND 1.56931f $ **FLOATING
C694 FILTER__BUFFER0__FIRST__TAIL.t1 VGND 0.05025f $ **FLOATING
C695 FILTER__BUFFER0__FIRST__TAIL.n17 VGND 0.04115f $ **FLOATING
C696 FILTER__BUFFER0__FIRST__MIR.n0 VGND 0.0368f $ **FLOATING
C697 FILTER__BUFFER0__FIRST__MIR.t4 VGND 3.17587f $ **FLOATING
C698 FILTER__BUFFER0__FIRST__MIR.t2 VGND 3.17587f $ **FLOATING
C699 FILTER__BUFFER0__FIRST__MIR.n1 VGND 2.89355f $ **FLOATING
C700 FILTER__BUFFER0__FIRST__MIR.n2 VGND 0.0513f $ **FLOATING
C701 FILTER__BUFFER0__FIRST__MIR.t3 VGND 0.06243f $ **FLOATING
C702 FILTER__BUFFER0__FIRST__MIR.n3 VGND 0.05211f $ **FLOATING
C703 FILTER__BUFFER0__FIRST__MIR.n4 VGND 3.30205f $ **FLOATING
C704 FILTER__BUFFER0__FIRST__MIR.n5 VGND 2.05907f $ **FLOATING
C705 FILTER__BUFFER0__FIRST__MIR.n6 VGND 0.0368f $ **FLOATING
C706 FILTER__BUFFER0__FIRST__MIR.t1 VGND 0.04494f $ **FLOATING
C707 FILTER__BUFFER0__FIRST__MIR.n7 VGND 0.0368f $ **FLOATING
C708 FILTER__BUFFER0__FIRST__MIR.n8 VGND 1.36365f $ **FLOATING
C709 FILTER__BUFFER0__FIRST__MIR.n9 VGND 28.6955f $ **FLOATING
C710 FILTER__BUFFER0__FIRST__MIR.n10 VGND 2.31959f $ **FLOATING
C711 FILTER__BUFFER0__FIRST__MIR.t0 VGND 0.04494f $ **FLOATING
C712 FILTER__BUFFER0__FIRST__MIR.n11 VGND 0.0368f $ **FLOATING
C713 PGA__GAIN8__FB.t3 VGND 0.94723f $ **FLOATING
C714 PGA__GAIN8__FB.t1 VGND 2.50749f $ **FLOATING
C715 PGA__GAIN8__FB.t0 VGND 1.7536f $ **FLOATING
C716 PGA__GAIN8__FB.n0 VGND 15.9293f $ **FLOATING
C717 PGA__GAIN8__FB.t2 VGND 0.94723f $ **FLOATING
C718 PGA__GAIN8__FB.n1 VGND 27.682f $ **FLOATING
C719 VCM.t2 VGND 4.03294f $ **FLOATING
C720 VCM.n0 VGND 0.02699f $ **FLOATING
C721 VCM.t3 VGND 0.04398f $ **FLOATING
C722 VCM.n1 VGND 0.02602f $ **FLOATING
C723 VCM.n2 VGND 1.29345f $ **FLOATING
C724 VCM.n3 VGND 15.454f $ **FLOATING
C725 VCM.n4 VGND 0.2326f $ **FLOATING
C726 VCM.t4 VGND 0.55249f $ **FLOATING
C727 VCM.n5 VGND 2.40552f $ **FLOATING
C728 VCM.n6 VGND 0.53996f $ **FLOATING
C729 VCM.n7 VGND 2.64815f $ **FLOATING
C730 VCM.n8 VGND 3.79774f $ **FLOATING
C731 VCM.t6 VGND 0.96753f $ **FLOATING
C732 VCM.n9 VGND 4.2139f $ **FLOATING
C733 VCM.t7 VGND 1.69802f $ **FLOATING
C734 VCM.t1 VGND 6.59685f $ **FLOATING
C735 VCM.t0 VGND 2.05353f $ **FLOATING
C736 VCM.n10 VGND 30.1851f $ **FLOATING
C737 VCM.n11 VGND 32.3323f $ **FLOATING
C738 VCM.n12 VGND 30.0304f $ **FLOATING
C739 VCM.n13 VGND 33.9378f $ **FLOATING
C740 VCM.t5 VGND 0.96753f $ **FLOATING
C741 PGA__SELECTED.n0 VGND 0.06423f $ **FLOATING
C742 PGA__SELECTED.t0 VGND 0.06074f $ **FLOATING
C743 PGA__SELECTED.t4 VGND 1.26222f $ **FLOATING
C744 PGA__SELECTED.t5 VGND 1.26222f $ **FLOATING
C745 PGA__SELECTED.n1 VGND 9.28193f $ **FLOATING
C746 PGA__SELECTED.n2 VGND 0.06633f $ **FLOATING
C747 PGA__SELECTED.t2 VGND 0.08071f $ **FLOATING
C748 PGA__SELECTED.n3 VGND 0.06737f $ **FLOATING
C749 PGA__SELECTED.n4 VGND 4.99106f $ **FLOATING
C750 PGA__SELECTED.n5 VGND 3.19133f $ **FLOATING
C751 PGA__SELECTED.n6 VGND 0.06194f $ **FLOATING
C752 PGA__SELECTED.t3 VGND 0.06074f $ **FLOATING
C753 PGA__SELECTED.n7 VGND 0.06423f $ **FLOATING
C754 PGA__SELECTED.n8 VGND 6.25471f $ **FLOATING
C755 PGA__SELECTED.n9 VGND 0.06633f $ **FLOATING
C756 PGA__SELECTED.t1 VGND 0.08071f $ **FLOATING
C757 PGA__SELECTED.n10 VGND 0.06737f $ **FLOATING
C758 PGA__SELECTED.n11 VGND 4.99106f $ **FLOATING
C759 PGA__SELECTED.n12 VGND 54.7135f $ **FLOATING
C760 PGA__SELECTED.n13 VGND 3.08173f $ **FLOATING
C761 PGA__SELECTED.n14 VGND 5.02036f $ **FLOATING
C762 PGA__SELECTED.n15 VGND 0.06194f $ **FLOATING
C763 FILTER__BUFFER0__COMP.t3 VGND 0.82191f $ **FLOATING
C764 FILTER__BUFFER0__COMP.t1 VGND 90.5319f $ **FLOATING
C765 FILTER__BUFFER0__COMP.t0 VGND 83.9798f $ **FLOATING
C766 FILTER__BUFFER0__COMP.n0 VGND 14.6935f $ **FLOATING
C767 FILTER__BUFFER0__COMP.n1 VGND 2.38353f $ **FLOATING
C768 FILTER__BUFFER0__COMP.t2 VGND 60.3266f $ **FLOATING
C769 FILTER__BUFFER0__COMP.n2 VGND 31.1859f $ **FLOATING
C770 FILTER__BUFFER0__PRE.n0 VGND 0.01452f $ **FLOATING
C771 FILTER__BUFFER0__PRE.t0 VGND 0.01739f $ **FLOATING
C772 FILTER__BUFFER0__PRE.t3 VGND 44.0476f $ **FLOATING
C773 FILTER__BUFFER0__PRE.t6 VGND 44.0476f $ **FLOATING
C774 FILTER__BUFFER0__PRE.n1 VGND 1.69662f $ **FLOATING
C775 FILTER__BUFFER0__PRE.t4 VGND 44.0476f $ **FLOATING
C776 FILTER__BUFFER0__PRE.n2 VGND 1.11304f $ **FLOATING
C777 FILTER__BUFFER0__PRE.t5 VGND 1.68982f $ **FLOATING
C778 FILTER__BUFFER0__PRE.n3 VGND 0.88963f $ **FLOATING
C779 FILTER__BUFFER0__PRE.n4 VGND 0.01025f $ **FLOATING
C780 FILTER__BUFFER0__PRE.t2 VGND 0.01252f $ **FLOATING
C781 FILTER__BUFFER0__PRE.n5 VGND 0.01025f $ **FLOATING
C782 FILTER__BUFFER0__PRE.n6 VGND 1.11196f $ **FLOATING
C783 FILTER__BUFFER0__PRE.n7 VGND 0.01025f $ **FLOATING
C784 FILTER__BUFFER0__PRE.t1 VGND 0.01252f $ **FLOATING
C785 FILTER__BUFFER0__PRE.n8 VGND 0.01025f $ **FLOATING
C786 FILTER__BUFFER0__PRE.n9 VGND 0.41323f $ **FLOATING
C787 FILTER__BUFFER0__PRE.n10 VGND 7.83576f $ **FLOATING
C788 FILTER__BUFFER0__PRE.n11 VGND 0.86538f $ **FLOATING
C789 FILTER__BUFFER0__PRE.n12 VGND 0.95319f $ **FLOATING
C790 FILTER__BUFFER0__PRE.n13 VGND 0.01429f $ **FLOATING
C791 PGA__GAIN2__AMP__PRE.n0 VGND 0.01754f $ **FLOATING
C792 PGA__GAIN2__AMP__PRE.t0 VGND 0.02101f $ **FLOATING
C793 PGA__GAIN2__AMP__PRE.t5 VGND 53.2211f $ **FLOATING
C794 PGA__GAIN2__AMP__PRE.t6 VGND 2.04175f $ **FLOATING
C795 PGA__GAIN2__AMP__PRE.n1 VGND 1.91852f $ **FLOATING
C796 PGA__GAIN2__AMP__PRE.t4 VGND 53.2211f $ **FLOATING
C797 PGA__GAIN2__AMP__PRE.t3 VGND 53.2211f $ **FLOATING
C798 PGA__GAIN2__AMP__PRE.n2 VGND 14.4079f $ **FLOATING
C799 PGA__GAIN2__AMP__PRE.n3 VGND 0.01239f $ **FLOATING
C800 PGA__GAIN2__AMP__PRE.t2 VGND 0.01512f $ **FLOATING
C801 PGA__GAIN2__AMP__PRE.n4 VGND 0.01239f $ **FLOATING
C802 PGA__GAIN2__AMP__PRE.n5 VGND 0.66227f $ **FLOATING
C803 PGA__GAIN2__AMP__PRE.n6 VGND 18.5859f $ **FLOATING
C804 PGA__GAIN2__AMP__PRE.n7 VGND 0.01239f $ **FLOATING
C805 PGA__GAIN2__AMP__PRE.t1 VGND 0.01512f $ **FLOATING
C806 PGA__GAIN2__AMP__PRE.n8 VGND 0.01239f $ **FLOATING
C807 PGA__GAIN2__AMP__PRE.n9 VGND 0.66227f $ **FLOATING
C808 PGA__GAIN2__AMP__PRE.n10 VGND 1.30141f $ **FLOATING
C809 PGA__GAIN2__AMP__PRE.n11 VGND 1.21804f $ **FLOATING
C810 PGA__GAIN2__AMP__PRE.n12 VGND 1.31469f $ **FLOATING
C811 PGA__GAIN2__AMP__PRE.n13 VGND 0.01727f $ **FLOATING
C812 COMPARATOR__PREAMP__TAIL.n0 VGND 0.02752f $ **FLOATING
C813 COMPARATOR__PREAMP__TAIL.t0 VGND 0.04485f $ **FLOATING
C814 COMPARATOR__PREAMP__TAIL.n1 VGND 0.0799f $ **FLOATING
C815 COMPARATOR__PREAMP__TAIL.t1 VGND 0.14085f $ **FLOATING
C816 COMPARATOR__PREAMP__TAIL.n2 VGND 0.48047f $ **FLOATING
C817 COMPARATOR__PREAMP__TAIL.n3 VGND 0.03056f $ **FLOATING
C818 COMPARATOR__PREAMP__TAIL.n4 VGND 2.43262f $ **FLOATING
C819 COMPARATOR__PREAMP__TAIL.n5 VGND 0.02568f $ **FLOATING
C820 COMPARATOR__PREAMP__TAIL.t2 VGND 0.14085f $ **FLOATING
C821 COMPARATOR__PREAMP__TAIL.n6 VGND 0.48047f $ **FLOATING
C822 COMPARATOR__PREAMP__TAIL.n7 VGND 0.08479f $ **FLOATING
C823 COMPARATOR__PREAMP__TAIL.n8 VGND 1.67081f $ **FLOATING
C824 COMPARATOR__PREAMP__TAIL.n9 VGND 29.3529f $ **FLOATING
C825 COMPARATOR__PREAMP__TAIL.n10 VGND 1.43583f $ **FLOATING
C826 COMPARATOR__PREAMP__TAIL.n11 VGND 0.02654f $ **FLOATING
C827 COMPARATOR__PRE.n0 VGND 0.05832f $ **FLOATING
C828 COMPARATOR__PRE.t0 VGND 0.06987f $ **FLOATING
C829 COMPARATOR__PRE.t3 VGND 0.12486f $ **FLOATING
C830 COMPARATOR__PRE.t2 VGND 0.22276f $ **FLOATING
C831 COMPARATOR__PRE.n1 VGND 5.98363f $ **FLOATING
C832 COMPARATOR__PRE.n2 VGND 0.02844f $ **FLOATING
C833 COMPARATOR__PRE.t1 VGND 0.15599f $ **FLOATING
C834 COMPARATOR__PRE.n3 VGND 0.53209f $ **FLOATING
C835 COMPARATOR__PRE.n4 VGND 0.0939f $ **FLOATING
C836 COMPARATOR__PRE.n5 VGND 4.33556f $ **FLOATING
C837 COMPARATOR__PRE.n6 VGND 30.3468f $ **FLOATING
C838 COMPARATOR__PRE.n7 VGND 4.05458f $ **FLOATING
C839 COMPARATOR__PRE.n8 VGND 0.05742f $ **FLOATING
C840 OUT.t5 VGND 1.10497f $ **FLOATING
C841 OUT.t3 VGND 1.93922f $ **FLOATING
C842 OUT.t0 VGND 2.10582f $ **FLOATING
C843 OUT.n0 VGND 12.6794f $ **FLOATING
C844 OUT.n1 VGND 0.03082f $ **FLOATING
C845 OUT.t2 VGND 0.05022f $ **FLOATING
C846 OUT.n2 VGND 0.02972f $ **FLOATING
C847 OUT.n3 VGND 1.24978f $ **FLOATING
C848 OUT.n4 VGND 9.37158f $ **FLOATING
C849 OUT.n5 VGND 0.63517f $ **FLOATING
C850 OUT.t1 VGND 0.63096f $ **FLOATING
C851 OUT.n6 VGND 2.7472f $ **FLOATING
C852 OUT.n7 VGND 0.24714f $ **FLOATING
C853 OUT.n8 VGND 2.79692f $ **FLOATING
C854 OUT.n9 VGND 8.87503f $ **FLOATING
C855 OUT.n10 VGND 57.1173f $ **FLOATING
C856 OUT.n11 VGND 64.2494f $ **FLOATING
C857 OUT.t4 VGND 1.10497f $ **FLOATING
C858 BIAS_SOURCE_R_VCM_BOTTOM_R0_N1.t1 VGND 7.79771f $ **FLOATING
C859 BIAS_SOURCE_R_VCM_BOTTOM_R0_N1.t0 VGND 9.30229f $ **FLOATING
C860 PGA_GAIN8_R_FEEDBACK_R0_N0.t1 VGND 20.2994f $ **FLOATING
C861 PGA_GAIN8_R_FEEDBACK_R0_N0.t0 VGND 25.8006f $ **FLOATING
C862 COMPARATOR__PREAMP__MIR.n0 VGND 0.04946f $ **FLOATING
C863 COMPARATOR__PREAMP__MIR.t1 VGND 0.05926f $ **FLOATING
C864 COMPARATOR__PREAMP__MIR.t3 VGND 3.01458f $ **FLOATING
C865 COMPARATOR__PREAMP__MIR.t0 VGND 3.01458f $ **FLOATING
C866 COMPARATOR__PREAMP__MIR.n1 VGND 3.31575f $ **FLOATING
C867 COMPARATOR__PREAMP__MIR.n2 VGND 0.02412f $ **FLOATING
C868 COMPARATOR__PREAMP__MIR.t2 VGND 0.13229f $ **FLOATING
C869 COMPARATOR__PREAMP__MIR.n3 VGND 0.45127f $ **FLOATING
C870 COMPARATOR__PREAMP__MIR.n4 VGND 0.07964f $ **FLOATING
C871 COMPARATOR__PREAMP__MIR.n5 VGND 2.2871f $ **FLOATING
C872 COMPARATOR__PREAMP__MIR.n6 VGND 24.9911f $ **FLOATING
C873 COMPARATOR__PREAMP__MIR.n7 VGND 3.32415f $ **FLOATING
C874 COMPARATOR__PREAMP__MIR.n8 VGND 0.0487f $ **FLOATING
C875 PGA__OUTPUT_BUFFER__COMP.t3 VGND 1.14278f $ **FLOATING
C876 PGA__OUTPUT_BUFFER__COMP.t1 VGND 87.673f $ **FLOATING
C877 PGA__OUTPUT_BUFFER__COMP.n0 VGND 3.18627f $ **FLOATING
C878 PGA__OUTPUT_BUFFER__COMP.t0 VGND 87.673f $ **FLOATING
C879 PGA__OUTPUT_BUFFER__COMP.n1 VGND 22.9417f $ **FLOATING
C880 PGA__OUTPUT_BUFFER__COMP.t2 VGND 62.5528f $ **FLOATING
C881 PGA__OUTPUT_BUFFER__COMP.n2 VGND 0.14023p $ **FLOATING
C882 PGA__OUTPUT_BUFFER__PRE.n0 VGND 0.01536f $ **FLOATING
C883 PGA__OUTPUT_BUFFER__PRE.t0 VGND 0.0184f $ **FLOATING
C884 PGA__OUTPUT_BUFFER__PRE.t4 VGND 46.6097f $ **FLOATING
C885 PGA__OUTPUT_BUFFER__PRE.t6 VGND 46.6097f $ **FLOATING
C886 PGA__OUTPUT_BUFFER__PRE.n1 VGND 2.09676f $ **FLOATING
C887 PGA__OUTPUT_BUFFER__PRE.t3 VGND 46.6097f $ **FLOATING
C888 PGA__OUTPUT_BUFFER__PRE.n2 VGND 1.32622f $ **FLOATING
C889 PGA__OUTPUT_BUFFER__PRE.t5 VGND 1.78811f $ **FLOATING
C890 PGA__OUTPUT_BUFFER__PRE.n3 VGND 1.20974f $ **FLOATING
C891 PGA__OUTPUT_BUFFER__PRE.n4 VGND 0.01085f $ **FLOATING
C892 PGA__OUTPUT_BUFFER__PRE.t1 VGND 0.01325f $ **FLOATING
C893 PGA__OUTPUT_BUFFER__PRE.n5 VGND 0.01085f $ **FLOATING
C894 PGA__OUTPUT_BUFFER__PRE.n6 VGND 1.54813f $ **FLOATING
C895 PGA__OUTPUT_BUFFER__PRE.n7 VGND 0.01085f $ **FLOATING
C896 PGA__OUTPUT_BUFFER__PRE.t2 VGND 0.01325f $ **FLOATING
C897 PGA__OUTPUT_BUFFER__PRE.n8 VGND 0.01085f $ **FLOATING
C898 PGA__OUTPUT_BUFFER__PRE.n9 VGND 0.61595f $ **FLOATING
C899 PGA__OUTPUT_BUFFER__PRE.n10 VGND 13.5427f $ **FLOATING
C900 PGA__OUTPUT_BUFFER__PRE.n11 VGND 1.10422f $ **FLOATING
C901 PGA__OUTPUT_BUFFER__PRE.n12 VGND 1.18732f $ **FLOATING
C902 PGA__OUTPUT_BUFFER__PRE.n13 VGND 0.01512f $ **FLOATING
C903 PGA__OUTPUT_BUFFER__FIRST__MIR.n0 VGND 0.05373f $ **FLOATING
C904 PGA__OUTPUT_BUFFER__FIRST__MIR.t1 VGND 0.06437f $ **FLOATING
C905 PGA__OUTPUT_BUFFER__FIRST__MIR.t4 VGND 3.27485f $ **FLOATING
C906 PGA__OUTPUT_BUFFER__FIRST__MIR.t0 VGND 3.27485f $ **FLOATING
C907 PGA__OUTPUT_BUFFER__FIRST__MIR.n1 VGND 4.77406f $ **FLOATING
C908 PGA__OUTPUT_BUFFER__FIRST__MIR.n2 VGND 0.03795f $ **FLOATING
C909 PGA__OUTPUT_BUFFER__FIRST__MIR.t2 VGND 0.04634f $ **FLOATING
C910 PGA__OUTPUT_BUFFER__FIRST__MIR.n3 VGND 0.03795f $ **FLOATING
C911 PGA__OUTPUT_BUFFER__FIRST__MIR.n4 VGND 3.23059f $ **FLOATING
C912 PGA__OUTPUT_BUFFER__FIRST__MIR.n5 VGND 0.03795f $ **FLOATING
C913 PGA__OUTPUT_BUFFER__FIRST__MIR.t3 VGND 0.04634f $ **FLOATING
C914 PGA__OUTPUT_BUFFER__FIRST__MIR.n6 VGND 0.03795f $ **FLOATING
C915 PGA__OUTPUT_BUFFER__FIRST__MIR.n7 VGND 2.02898f $ **FLOATING
C916 PGA__OUTPUT_BUFFER__FIRST__MIR.n8 VGND 48.4226f $ **FLOATING
C917 PGA__OUTPUT_BUFFER__FIRST__MIR.n9 VGND 2.78494f $ **FLOATING
C918 PGA__OUTPUT_BUFFER__FIRST__MIR.n10 VGND 4.02779f $ **FLOATING
C919 PGA__OUTPUT_BUFFER__FIRST__MIR.n11 VGND 0.0529f $ **FLOATING
C920 AMPLIFIED.n0 VGND 0.02849f $ **FLOATING
C921 AMPLIFIED.t0 VGND 2.01588f $ **FLOATING
C922 AMPLIFIED.t3 VGND 2.64089f $ **FLOATING
C923 AMPLIFIED.n1 VGND 12.9662f $ **FLOATING
C924 AMPLIFIED.t5 VGND 1.02144f $ **FLOATING
C925 AMPLIFIED.t4 VGND 1.02144f $ **FLOATING
C926 AMPLIFIED.n2 VGND 57.0792f $ **FLOATING
C927 AMPLIFIED.n3 VGND 0.58716f $ **FLOATING
C928 AMPLIFIED.t2 VGND 0.58327f $ **FLOATING
C929 AMPLIFIED.n4 VGND 2.53954f $ **FLOATING
C930 AMPLIFIED.n5 VGND 0.22846f $ **FLOATING
C931 AMPLIFIED.n6 VGND 3.30493f $ **FLOATING
C932 AMPLIFIED.n7 VGND 4.54276f $ **FLOATING
C933 AMPLIFIED.n8 VGND 9.4208f $ **FLOATING
C934 AMPLIFIED.n9 VGND 1.87474f $ **FLOATING
C935 AMPLIFIED.t1 VGND 0.04643f $ **FLOATING
C936 AMPLIFIED.n10 VGND 0.02747f $ **FLOATING
C937 FILTER__BUFFER1__FIRST__TAIL.n0 VGND 0.04604f $ **FLOATING
C938 FILTER__BUFFER1__FIRST__TAIL.n1 VGND 0.04604f $ **FLOATING
C939 FILTER__BUFFER1__FIRST__TAIL.t2 VGND 0.05621f $ **FLOATING
C940 FILTER__BUFFER1__FIRST__TAIL.n2 VGND 0.04604f $ **FLOATING
C941 FILTER__BUFFER1__FIRST__TAIL.n3 VGND 2.22317f $ **FLOATING
C942 FILTER__BUFFER1__FIRST__TAIL.n4 VGND 0.04604f $ **FLOATING
C943 FILTER__BUFFER1__FIRST__TAIL.t4 VGND 0.05621f $ **FLOATING
C944 FILTER__BUFFER1__FIRST__TAIL.n5 VGND 0.04604f $ **FLOATING
C945 FILTER__BUFFER1__FIRST__TAIL.n6 VGND 2.15736f $ **FLOATING
C946 FILTER__BUFFER1__FIRST__TAIL.n7 VGND 5.02407f $ **FLOATING
C947 FILTER__BUFFER1__FIRST__TAIL.n8 VGND 0.03406f $ **FLOATING
C948 FILTER__BUFFER1__FIRST__TAIL.t3 VGND 0.05551f $ **FLOATING
C949 FILTER__BUFFER1__FIRST__TAIL.n9 VGND 0.03284f $ **FLOATING
C950 FILTER__BUFFER1__FIRST__TAIL.n10 VGND 50.8748f $ **FLOATING
C951 FILTER__BUFFER1__FIRST__TAIL.n11 VGND 0.04604f $ **FLOATING
C952 FILTER__BUFFER1__FIRST__TAIL.t1 VGND 0.05621f $ **FLOATING
C953 FILTER__BUFFER1__FIRST__TAIL.n12 VGND 0.04604f $ **FLOATING
C954 FILTER__BUFFER1__FIRST__TAIL.n13 VGND 2.15736f $ **FLOATING
C955 FILTER__BUFFER1__FIRST__TAIL.n14 VGND 88.8262f $ **FLOATING
C956 FILTER__BUFFER1__FIRST__TAIL.n15 VGND 2.80645f $ **FLOATING
C957 FILTER__BUFFER1__FIRST__TAIL.n16 VGND 2.15736f $ **FLOATING
C958 FILTER__BUFFER1__FIRST__TAIL.t0 VGND 0.05621f $ **FLOATING
C959 FILTER__BUFFER1__FIRST__TAIL.n17 VGND 0.04604f $ **FLOATING
C960 FILTER__BUFFER1__PRE.n0 VGND 0.0184f $ **FLOATING
C961 FILTER__BUFFER1__PRE.t0 VGND 0.02204f $ **FLOATING
C962 FILTER__BUFFER1__PRE.t5 VGND 55.8177f $ **FLOATING
C963 FILTER__BUFFER1__PRE.t3 VGND 55.8177f $ **FLOATING
C964 FILTER__BUFFER1__PRE.n1 VGND 2.11318f $ **FLOATING
C965 FILTER__BUFFER1__PRE.t6 VGND 55.8177f $ **FLOATING
C966 FILTER__BUFFER1__PRE.n2 VGND 1.39387f $ **FLOATING
C967 FILTER__BUFFER1__PRE.t4 VGND 2.14136f $ **FLOATING
C968 FILTER__BUFFER1__PRE.n3 VGND 1.08098f $ **FLOATING
C969 FILTER__BUFFER1__PRE.n4 VGND 0.01299f $ **FLOATING
C970 FILTER__BUFFER1__PRE.t1 VGND 0.01586f $ **FLOATING
C971 FILTER__BUFFER1__PRE.n5 VGND 0.01299f $ **FLOATING
C972 FILTER__BUFFER1__PRE.n6 VGND 0.67361f $ **FLOATING
C973 FILTER__BUFFER1__PRE.n7 VGND 0.01299f $ **FLOATING
C974 FILTER__BUFFER1__PRE.t2 VGND 0.01586f $ **FLOATING
C975 FILTER__BUFFER1__PRE.n8 VGND 0.01299f $ **FLOATING
C976 FILTER__BUFFER1__PRE.n9 VGND 0.59457f $ **FLOATING
C977 FILTER__BUFFER1__PRE.n10 VGND 23.3721f $ **FLOATING
C978 FILTER__BUFFER1__PRE.n11 VGND 16.8708f $ **FLOATING
C979 FILTER__BUFFER1__PRE.n12 VGND 1.17969f $ **FLOATING
C980 FILTER__BUFFER1__PRE.n13 VGND 0.01811f $ **FLOATING
C981 FILTER__BUFFER1__FIRST__MIR.n0 VGND 0.04631f $ **FLOATING
C982 FILTER__BUFFER1__FIRST__MIR.t1 VGND 0.05548f $ **FLOATING
C983 FILTER__BUFFER1__FIRST__MIR.t4 VGND 2.82236f $ **FLOATING
C984 FILTER__BUFFER1__FIRST__MIR.t0 VGND 2.82236f $ **FLOATING
C985 FILTER__BUFFER1__FIRST__MIR.n1 VGND 2.46218f $ **FLOATING
C986 FILTER__BUFFER1__FIRST__MIR.n2 VGND 0.03271f $ **FLOATING
C987 FILTER__BUFFER1__FIRST__MIR.t3 VGND 0.03993f $ **FLOATING
C988 FILTER__BUFFER1__FIRST__MIR.n3 VGND 0.03271f $ **FLOATING
C989 FILTER__BUFFER1__FIRST__MIR.n4 VGND 1.47146f $ **FLOATING
C990 FILTER__BUFFER1__FIRST__MIR.n5 VGND 0.03271f $ **FLOATING
C991 FILTER__BUFFER1__FIRST__MIR.t2 VGND 0.03993f $ **FLOATING
C992 FILTER__BUFFER1__FIRST__MIR.n6 VGND 0.03271f $ **FLOATING
C993 FILTER__BUFFER1__FIRST__MIR.n7 VGND 1.42528f $ **FLOATING
C994 FILTER__BUFFER1__FIRST__MIR.n8 VGND 57.6301f $ **FLOATING
C995 FILTER__BUFFER1__FIRST__MIR.n9 VGND 41.5039f $ **FLOATING
C996 FILTER__BUFFER1__FIRST__MIR.n10 VGND 2.89916f $ **FLOATING
C997 FILTER__BUFFER1__FIRST__MIR.n11 VGND 0.04559f $ **FLOATING
C998 BIAS_SOURCE__VCM_RAW.t9 VGND 0.01416f $ **FLOATING
C999 BIAS_SOURCE__VCM_RAW.t11 VGND 0.01416f $ **FLOATING
C1000 BIAS_SOURCE__VCM_RAW.n0 VGND 0.10011f $ **FLOATING
C1001 BIAS_SOURCE__VCM_RAW.t10 VGND 2.29367f $ **FLOATING
C1002 BIAS_SOURCE__VCM_RAW.n1 VGND 0.05632f $ **FLOATING
C1003 BIAS_SOURCE__VCM_RAW.t8 VGND 2.29367f $ **FLOATING
C1004 BIAS_SOURCE__VCM_RAW.n2 VGND 0.06542f $ **FLOATING
C1005 BIAS_SOURCE__VCM_RAW.t2 VGND 2.29367f $ **FLOATING
C1006 BIAS_SOURCE__VCM_RAW.n3 VGND 0.06542f $ **FLOATING
C1007 BIAS_SOURCE__VCM_RAW.t4 VGND 2.29367f $ **FLOATING
C1008 BIAS_SOURCE__VCM_RAW.n4 VGND 0.06542f $ **FLOATING
C1009 BIAS_SOURCE__VCM_RAW.t15 VGND 2.29367f $ **FLOATING
C1010 BIAS_SOURCE__VCM_RAW.n5 VGND 0.06542f $ **FLOATING
C1011 BIAS_SOURCE__VCM_RAW.t6 VGND 2.29367f $ **FLOATING
C1012 BIAS_SOURCE__VCM_RAW.n6 VGND 0.06542f $ **FLOATING
C1013 BIAS_SOURCE__VCM_RAW.t13 VGND 2.29367f $ **FLOATING
C1014 BIAS_SOURCE__VCM_RAW.n7 VGND 0.06542f $ **FLOATING
C1015 BIAS_SOURCE__VCM_RAW.t5 VGND 2.29367f $ **FLOATING
C1016 BIAS_SOURCE__VCM_RAW.n8 VGND 0.06542f $ **FLOATING
C1017 BIAS_SOURCE__VCM_RAW.t3 VGND 2.29367f $ **FLOATING
C1018 BIAS_SOURCE__VCM_RAW.n9 VGND 0.06542f $ **FLOATING
C1019 BIAS_SOURCE__VCM_RAW.t7 VGND 2.29367f $ **FLOATING
C1020 BIAS_SOURCE__VCM_RAW.n10 VGND 0.06542f $ **FLOATING
C1021 BIAS_SOURCE__VCM_RAW.t14 VGND 2.29367f $ **FLOATING
C1022 BIAS_SOURCE__VCM_RAW.n11 VGND 0.06542f $ **FLOATING
C1023 BIAS_SOURCE__VCM_RAW.t0 VGND 0.0468f $ **FLOATING
C1024 BIAS_SOURCE__VCM_RAW.t1 VGND 0.0192f $ **FLOATING
C1025 BIAS_SOURCE__VCM_RAW.n12 VGND 0.21834f $ **FLOATING
C1026 BIAS_SOURCE__VCM_RAW.n13 VGND 0.06759f $ **FLOATING
C1027 BIAS_SOURCE__VCM_RAW.t12 VGND 2.29367f $ **FLOATING
C1028 PGA__V2.n0 VGND 0.03086f $ **FLOATING
C1029 PGA__V2.n1 VGND 0.05814f $ **FLOATING
C1030 PGA__V2.t1 VGND 0.07074f $ **FLOATING
C1031 PGA__V2.n2 VGND 0.05905f $ **FLOATING
C1032 PGA__V2.n3 VGND 4.24447f $ **FLOATING
C1033 PGA__V2.n4 VGND 0.05429f $ **FLOATING
C1034 PGA__V2.t2 VGND 0.05324f $ **FLOATING
C1035 PGA__V2.n5 VGND 0.0563f $ **FLOATING
C1036 PGA__V2.n6 VGND 4.21777f $ **FLOATING
C1037 PGA__V2.n7 VGND 19.1776f $ **FLOATING
C1038 PGA__V2.t5 VGND 2.09165f $ **FLOATING
C1039 PGA__V2.n8 VGND 18.3537f $ **FLOATING
C1040 PGA__V2.t0 VGND 3.36596f $ **FLOATING
C1041 PGA__V2.n9 VGND 55.3037f $ **FLOATING
C1042 PGA__V2.n10 VGND 0.26597f $ **FLOATING
C1043 PGA__V2.t3 VGND 0.63174f $ **FLOATING
C1044 PGA__V2.n11 VGND 2.7506f $ **FLOATING
C1045 PGA__V2.n12 VGND 0.61742f $ **FLOATING
C1046 PGA__V2.n13 VGND 3.25714f $ **FLOATING
C1047 PGA__V2.n14 VGND 69.1308f $ **FLOATING
C1048 PGA__V2.n15 VGND 1.76907f $ **FLOATING
C1049 PGA__V2.t4 VGND 0.05029f $ **FLOATING
C1050 PGA__V2.n16 VGND 0.02975f $ **FLOATING
C1051 PGA__GAIN2__AMP__COMP.t3 VGND 0.10591p $ **FLOATING
C1052 PGA__GAIN2__AMP__COMP.t2 VGND 79.61739f $ **FLOATING
C1053 PGA__GAIN2__AMP__COMP.n0 VGND 24.1019f $ **FLOATING
C1054 PGA__GAIN2__AMP__COMP.t1 VGND 79.61739f $ **FLOATING
C1055 PGA__GAIN2__AMP__COMP.n1 VGND 2.23773f $ **FLOATING
C1056 PGA__GAIN2__AMP__COMP.t0 VGND 0.7113f $ **FLOATING
C1057 FILTER__MID.n0 VGND 0.02882f $ **FLOATING
C1058 FILTER__MID.t0 VGND 1.43616f $ **FLOATING
C1059 FILTER__MID.t3 VGND 2.05029f $ **FLOATING
C1060 FILTER__MID.n1 VGND 11.7005f $ **FLOATING
C1061 FILTER__MID.t4 VGND 1.03305f $ **FLOATING
C1062 FILTER__MID.t5 VGND 1.03305f $ **FLOATING
C1063 FILTER__MID.n2 VGND 32.9208f $ **FLOATING
C1064 FILTER__MID.n3 VGND 0.59383f $ **FLOATING
C1065 FILTER__MID.t2 VGND 0.58989f $ **FLOATING
C1066 FILTER__MID.n4 VGND 2.56838f $ **FLOATING
C1067 FILTER__MID.n5 VGND 0.23105f $ **FLOATING
C1068 FILTER__MID.n6 VGND 2.69971f $ **FLOATING
C1069 FILTER__MID.n7 VGND 3.919f $ **FLOATING
C1070 FILTER__MID.n8 VGND 8.85245f $ **FLOATING
C1071 FILTER__MID.n9 VGND 1.25328f $ **FLOATING
C1072 FILTER__MID.t1 VGND 0.04695f $ **FLOATING
C1073 FILTER__MID.n10 VGND 0.02778f $ **FLOATING
C1074 FILTER__FILTER1.t2 VGND 0.01861f $ **FLOATING
C1075 FILTER__FILTER1.t11 VGND 0.01861f $ **FLOATING
C1076 FILTER__FILTER1.n0 VGND 0.14636f $ **FLOATING
C1077 FILTER__FILTER1.t5 VGND 3.01371f $ **FLOATING
C1078 FILTER__FILTER1.n1 VGND 0.07797f $ **FLOATING
C1079 FILTER__FILTER1.t14 VGND 3.01371f $ **FLOATING
C1080 FILTER__FILTER1.n2 VGND 0.08991f $ **FLOATING
C1081 FILTER__FILTER1.t9 VGND 3.01371f $ **FLOATING
C1082 FILTER__FILTER1.n3 VGND 0.08991f $ **FLOATING
C1083 FILTER__FILTER1.t1 VGND 3.01371f $ **FLOATING
C1084 FILTER__FILTER1.n4 VGND 0.08991f $ **FLOATING
C1085 FILTER__FILTER1.t10 VGND 3.01371f $ **FLOATING
C1086 FILTER__FILTER1.n5 VGND 0.08991f $ **FLOATING
C1087 FILTER__FILTER1.t4 VGND 3.01371f $ **FLOATING
C1088 FILTER__FILTER1.n6 VGND 0.08991f $ **FLOATING
C1089 FILTER__FILTER1.t13 VGND 3.01371f $ **FLOATING
C1090 FILTER__FILTER1.n7 VGND 0.08991f $ **FLOATING
C1091 FILTER__FILTER1.t12 VGND 3.01371f $ **FLOATING
C1092 FILTER__FILTER1.n8 VGND 0.08991f $ **FLOATING
C1093 FILTER__FILTER1.t7 VGND 3.01371f $ **FLOATING
C1094 FILTER__FILTER1.n9 VGND 0.08991f $ **FLOATING
C1095 FILTER__FILTER1.t6 VGND 3.01371f $ **FLOATING
C1096 FILTER__FILTER1.n10 VGND 0.08991f $ **FLOATING
C1097 FILTER__FILTER1.t3 VGND 3.01371f $ **FLOATING
C1098 FILTER__FILTER1.n11 VGND 0.08991f $ **FLOATING
C1099 FILTER__FILTER1.t0 VGND 0.1145f $ **FLOATING
C1100 FILTER__FILTER1.n12 VGND 0.95932f $ **FLOATING
C1101 FILTER__FILTER1.t8 VGND 3.01371f $ **FLOATING
C1102 PGA__V8.n0 VGND 0.05485f $ **FLOATING
C1103 PGA__V8.n1 VGND 0.59074f $ **FLOATING
C1104 PGA__V8.t4 VGND 0.58682f $ **FLOATING
C1105 PGA__V8.n2 VGND 2.55501f $ **FLOATING
C1106 PGA__V8.n3 VGND 0.22985f $ **FLOATING
C1107 PGA__V8.n4 VGND 3.58908f $ **FLOATING
C1108 PGA__V8.n5 VGND 0.02867f $ **FLOATING
C1109 PGA__V8.t3 VGND 0.04671f $ **FLOATING
C1110 PGA__V8.n6 VGND 0.02764f $ **FLOATING
C1111 PGA__V8.n7 VGND 1.544f $ **FLOATING
C1112 PGA__V8.n8 VGND 30.6287f $ **FLOATING
C1113 PGA__V8.t0 VGND 3.21172f $ **FLOATING
C1114 PGA__V8.n9 VGND 9.67878f $ **FLOATING
C1115 PGA__V8.t5 VGND 1.72821f $ **FLOATING
C1116 PGA__V8.n10 VGND 5.42202f $ **FLOATING
C1117 PGA__V8.n11 VGND 0.05043f $ **FLOATING
C1118 PGA__V8.t1 VGND 0.04946f $ **FLOATING
C1119 PGA__V8.n12 VGND 0.05229f $ **FLOATING
C1120 PGA__V8.n13 VGND 4.00257f $ **FLOATING
C1121 PGA__V8.n14 VGND 6.61945f $ **FLOATING
C1122 PGA__V8.n15 VGND 4.02777f $ **FLOATING
C1123 PGA__V8.t2 VGND 0.06571f $ **FLOATING
C1124 PGA__V8.n16 VGND 0.054f $ **FLOATING
C1125 PGA__GAIN8__AMP__COMP.t2 VGND 84.9715f $ **FLOATING
C1126 PGA__GAIN8__AMP__COMP.t3 VGND 80.6019f $ **FLOATING
C1127 PGA__GAIN8__AMP__COMP.n0 VGND 10.8415f $ **FLOATING
C1128 PGA__GAIN8__AMP__COMP.t1 VGND 80.6019f $ **FLOATING
C1129 PGA__GAIN8__AMP__COMP.n1 VGND 2.4598f $ **FLOATING
C1130 PGA__GAIN8__AMP__COMP.t0 VGND 0.82344f $ **FLOATING
C1131 PGA__OUTPUT_BUFFER__FIRST__TAIL.n0 VGND 0.03004f $ **FLOATING
C1132 PGA__OUTPUT_BUFFER__FIRST__TAIL.t0 VGND 0.04896f $ **FLOATING
C1133 PGA__OUTPUT_BUFFER__FIRST__TAIL.n1 VGND 0.0406f $ **FLOATING
C1134 PGA__OUTPUT_BUFFER__FIRST__TAIL.t1 VGND 0.04958f $ **FLOATING
C1135 PGA__OUTPUT_BUFFER__FIRST__TAIL.n2 VGND 0.0406f $ **FLOATING
C1136 PGA__OUTPUT_BUFFER__FIRST__TAIL.n3 VGND 3.46014f $ **FLOATING
C1137 PGA__OUTPUT_BUFFER__FIRST__TAIL.n4 VGND 0.0406f $ **FLOATING
C1138 PGA__OUTPUT_BUFFER__FIRST__TAIL.t4 VGND 0.04958f $ **FLOATING
C1139 PGA__OUTPUT_BUFFER__FIRST__TAIL.n5 VGND 0.0406f $ **FLOATING
C1140 PGA__OUTPUT_BUFFER__FIRST__TAIL.n6 VGND 2.21561f $ **FLOATING
C1141 PGA__OUTPUT_BUFFER__FIRST__TAIL.n7 VGND 50.6435f $ **FLOATING
C1142 PGA__OUTPUT_BUFFER__FIRST__TAIL.n8 VGND 0.0406f $ **FLOATING
C1143 PGA__OUTPUT_BUFFER__FIRST__TAIL.t3 VGND 0.04958f $ **FLOATING
C1144 PGA__OUTPUT_BUFFER__FIRST__TAIL.n9 VGND 0.0406f $ **FLOATING
C1145 PGA__OUTPUT_BUFFER__FIRST__TAIL.n10 VGND 2.21561f $ **FLOATING
C1146 PGA__OUTPUT_BUFFER__FIRST__TAIL.n11 VGND 2.80371f $ **FLOATING
C1147 PGA__OUTPUT_BUFFER__FIRST__TAIL.n12 VGND 0.0406f $ **FLOATING
C1148 PGA__OUTPUT_BUFFER__FIRST__TAIL.t2 VGND 0.04958f $ **FLOATING
C1149 PGA__OUTPUT_BUFFER__FIRST__TAIL.n13 VGND 0.0406f $ **FLOATING
C1150 PGA__OUTPUT_BUFFER__FIRST__TAIL.n14 VGND 2.21561f $ **FLOATING
C1151 PGA__OUTPUT_BUFFER__FIRST__TAIL.n15 VGND 6.65476f $ **FLOATING
C1152 PGA__OUTPUT_BUFFER__FIRST__TAIL.n16 VGND 2.00909f $ **FLOATING
C1153 PGA__OUTPUT_BUFFER__FIRST__TAIL.n17 VGND 0.02897f $ **FLOATING
C1154 BIAS.t11 VGND 0.48407f $ **FLOATING
C1155 BIAS.t4 VGND 0.48407f $ **FLOATING
C1156 BIAS.n0 VGND 18.1527f $ **FLOATING
C1157 BIAS.t5 VGND 0.48407f $ **FLOATING
C1158 BIAS.n1 VGND 9.68105f $ **FLOATING
C1159 BIAS.t10 VGND 0.48407f $ **FLOATING
C1160 BIAS.t12 VGND 0.48407f $ **FLOATING
C1161 BIAS.n2 VGND 23.2257f $ **FLOATING
C1162 BIAS.n3 VGND 21.5254f $ **FLOATING
C1163 BIAS.t7 VGND 0.48407f $ **FLOATING
C1164 BIAS.t3 VGND 0.48407f $ **FLOATING
C1165 BIAS.n4 VGND 18.518f $ **FLOATING
C1166 BIAS.t15 VGND 0.48407f $ **FLOATING
C1167 BIAS.n5 VGND 15.6135f $ **FLOATING
C1168 BIAS.t13 VGND 0.48407f $ **FLOATING
C1169 BIAS.n6 VGND 16.8478f $ **FLOATING
C1170 BIAS.n7 VGND 13.8648f $ **FLOATING
C1171 BIAS.t8 VGND 0.48407f $ **FLOATING
C1172 BIAS.t9 VGND 0.48407f $ **FLOATING
C1173 BIAS.n8 VGND 14.6732f $ **FLOATING
C1174 BIAS.t6 VGND 0.48407f $ **FLOATING
C1175 BIAS.n9 VGND 11.9151f $ **FLOATING
C1176 BIAS.t14 VGND 0.48407f $ **FLOATING
C1177 BIAS.n10 VGND 31.2593f $ **FLOATING
C1178 BIAS.t2 VGND 2.39635f $ **FLOATING
C1179 BIAS.n11 VGND 31.531f $ **FLOATING
C1180 BIAS.t0 VGND 0.48407f $ **FLOATING
C1181 BIAS.n12 VGND 2.51777f $ **FLOATING
C1182 BIAS.n13 VGND 0.02441f $ **FLOATING
C1183 BIAS.t1 VGND 0.04126f $ **FLOATING
C1184 BIAS.n14 VGND 0.02532f $ **FLOATING
C1185 BIAS.n15 VGND 1.43917f $ **FLOATING
C1186 BIAS.n16 VGND 5.34481f $ **FLOATING
C1187 BIAS.n17 VGND 5.61693f $ **FLOATING
C1188 DATA.n0 VGND 0.0142f $ **FLOATING
C1189 DATA.t2 VGND 0.03453f $ **FLOATING
C1190 DATA.n1 VGND 0.0142f $ **FLOATING
C1191 DATA.n2 VGND 1.99106f $ **FLOATING
C1192 DATA.n3 VGND 0.01243f $ **FLOATING
C1193 DATA.t1 VGND 0.03807f $ **FLOATING
C1194 DATA.n4 VGND 0.01243f $ **FLOATING
C1195 DATA.n5 VGND 1.93395f $ **FLOATING
C1196 DATA.n6 VGND 8.46897f $ **FLOATING
C1197 DATA.n7 VGND 0.01243f $ **FLOATING
C1198 DATA.t3 VGND 0.03807f $ **FLOATING
C1199 DATA.n8 VGND 0.01243f $ **FLOATING
C1200 DATA.n9 VGND 1.93395f $ **FLOATING
C1201 DATA.n10 VGND 5.86507f $ **FLOATING
C1202 DATA.n11 VGND 0.0142f $ **FLOATING
C1203 DATA.t0 VGND 0.03453f $ **FLOATING
C1204 DATA.n12 VGND 0.0142f $ **FLOATING
C1205 DATA.n13 VGND 1.93395f $ **FLOATING
C1206 DATA.n14 VGND 31.491f $ **FLOATING
C1207 SAMPLE__TB.n0 VGND 0.008f $ **FLOATING
C1208 SAMPLE__TB.t3 VGND 0.02893f $ **FLOATING
C1209 SAMPLE__TB.t2 VGND 0.03006f $ **FLOATING
C1210 SAMPLE__TB.n1 VGND 4.33551f $ **FLOATING
C1211 SAMPLE__TB.n2 VGND 0.007f $ **FLOATING
C1212 SAMPLE__TB.t1 VGND 0.02144f $ **FLOATING
C1213 SAMPLE__TB.n3 VGND 0.007f $ **FLOATING
C1214 SAMPLE__TB.n4 VGND 1.7348f $ **FLOATING
C1215 SAMPLE__TB.n5 VGND 30.5537f $ **FLOATING
C1216 SAMPLE__TB.n6 VGND 1.11654f $ **FLOATING
C1217 SAMPLE__TB.t0 VGND 0.01945f $ **FLOATING
C1218 SAMPLE__TB.n7 VGND 0.008f $ **FLOATING
C1219 PGA__GAIN8__AMP__PRE.n0 VGND 0.00969f $ **FLOATING
C1220 PGA__GAIN8__AMP__PRE.t6 VGND 41.6516f $ **FLOATING
C1221 PGA__GAIN8__AMP__PRE.t4 VGND 41.6516f $ **FLOATING
C1222 PGA__GAIN8__AMP__PRE.n1 VGND 1.63428f $ **FLOATING
C1223 PGA__GAIN8__AMP__PRE.t5 VGND 41.6516f $ **FLOATING
C1224 PGA__GAIN8__AMP__PRE.n2 VGND 1.06649f $ **FLOATING
C1225 PGA__GAIN8__AMP__PRE.t3 VGND 1.5979f $ **FLOATING
C1226 PGA__GAIN8__AMP__PRE.n3 VGND 0.87511f $ **FLOATING
C1227 PGA__GAIN8__AMP__PRE.n4 VGND 0.01351f $ **FLOATING
C1228 PGA__GAIN8__AMP__PRE.t1 VGND 0.01644f $ **FLOATING
C1229 PGA__GAIN8__AMP__PRE.n5 VGND 0.01373f $ **FLOATING
C1230 PGA__GAIN8__AMP__PRE.n6 VGND 0.92247f $ **FLOATING
C1231 PGA__GAIN8__AMP__PRE.n7 VGND 0.84093f $ **FLOATING
C1232 PGA__GAIN8__AMP__PRE.n8 VGND 0.00969f $ **FLOATING
C1233 PGA__GAIN8__AMP__PRE.t2 VGND 0.01184f $ **FLOATING
C1234 PGA__GAIN8__AMP__PRE.n9 VGND 0.00969f $ **FLOATING
C1235 PGA__GAIN8__AMP__PRE.n10 VGND 0.78558f $ **FLOATING
C1236 PGA__GAIN8__AMP__PRE.n11 VGND 4.76613f $ **FLOATING
C1237 PGA__GAIN8__AMP__PRE.n12 VGND 0.41187f $ **FLOATING
C1238 PGA__GAIN8__AMP__PRE.t0 VGND 0.01184f $ **FLOATING
C1239 PGA__GAIN8__AMP__PRE.n13 VGND 0.00969f $ **FLOATING
C1240 PGA__GAIN8__AMP__FIRST__MIR.n0 VGND 0.03167f $ **FLOATING
C1241 PGA__GAIN8__AMP__FIRST__MIR.t4 VGND 2.73251f $ **FLOATING
C1242 PGA__GAIN8__AMP__FIRST__MIR.t2 VGND 2.73251f $ **FLOATING
C1243 PGA__GAIN8__AMP__FIRST__MIR.n1 VGND 2.80163f $ **FLOATING
C1244 PGA__GAIN8__AMP__FIRST__MIR.n2 VGND 0.04414f $ **FLOATING
C1245 PGA__GAIN8__AMP__FIRST__MIR.t3 VGND 0.05371f $ **FLOATING
C1246 PGA__GAIN8__AMP__FIRST__MIR.n3 VGND 0.04484f $ **FLOATING
C1247 PGA__GAIN8__AMP__FIRST__MIR.n4 VGND 2.94412f $ **FLOATING
C1248 PGA__GAIN8__AMP__FIRST__MIR.n5 VGND 1.88293f $ **FLOATING
C1249 PGA__GAIN8__AMP__FIRST__MIR.n6 VGND 0.03167f $ **FLOATING
C1250 PGA__GAIN8__AMP__FIRST__MIR.t1 VGND 0.03866f $ **FLOATING
C1251 PGA__GAIN8__AMP__FIRST__MIR.n7 VGND 0.03167f $ **FLOATING
C1252 PGA__GAIN8__AMP__FIRST__MIR.n8 VGND 1.73056f $ **FLOATING
C1253 PGA__GAIN8__AMP__FIRST__MIR.n9 VGND 15.5608f $ **FLOATING
C1254 PGA__GAIN8__AMP__FIRST__MIR.n10 VGND 1.27633f $ **FLOATING
C1255 PGA__GAIN8__AMP__FIRST__MIR.t0 VGND 0.03866f $ **FLOATING
C1256 PGA__GAIN8__AMP__FIRST__MIR.n11 VGND 0.03167f $ **FLOATING
C1257 RESET_MUX__SB.n0 VGND 0.01206f $ **FLOATING
C1258 RESET_MUX__SB.t2 VGND 0.05179f $ **FLOATING
C1259 RESET_MUX__SB.t3 VGND 0.04984f $ **FLOATING
C1260 RESET_MUX__SB.n1 VGND 8.10947f $ **FLOATING
C1261 RESET_MUX__SB.n2 VGND 0.01378f $ **FLOATING
C1262 RESET_MUX__SB.t1 VGND 0.03351f $ **FLOATING
C1263 RESET_MUX__SB.n3 VGND 0.01378f $ **FLOATING
C1264 RESET_MUX__SB.n4 VGND 1.50147f $ **FLOATING
C1265 RESET_MUX__SB.n5 VGND 33.7799f $ **FLOATING
C1266 RESET_MUX__SB.n6 VGND 2.28401f $ **FLOATING
C1267 RESET_MUX__SB.t0 VGND 0.03695f $ **FLOATING
C1268 RESET_MUX__SB.n7 VGND 0.01206f $ **FLOATING
C1269 RESET.t3 VGND 0.05069f $ **FLOATING
C1270 RESET.t2 VGND 0.05267f $ **FLOATING
C1271 RESET.n0 VGND 6.58058f $ **FLOATING
C1272 RESET.t1 VGND 0.05069f $ **FLOATING
C1273 RESET.n1 VGND 3.76866f $ **FLOATING
C1274 RESET.t0 VGND 0.05267f $ **FLOATING
C1275 RESET.n2 VGND 21.2978f $ **FLOATING
C1276 FILTER__FILTER0.t8 VGND 0.01615f $ **FLOATING
C1277 FILTER__FILTER0.t6 VGND 0.01615f $ **FLOATING
C1278 FILTER__FILTER0.n0 VGND 0.10657f $ **FLOATING
C1279 FILTER__FILTER0.t9 VGND 2.61602f $ **FLOATING
C1280 FILTER__FILTER0.n1 VGND 0.0628f $ **FLOATING
C1281 FILTER__FILTER0.t2 VGND 2.61602f $ **FLOATING
C1282 FILTER__FILTER0.n2 VGND 0.07317f $ **FLOATING
C1283 FILTER__FILTER0.t4 VGND 2.61602f $ **FLOATING
C1284 FILTER__FILTER0.n3 VGND 0.07317f $ **FLOATING
C1285 FILTER__FILTER0.t14 VGND 2.61602f $ **FLOATING
C1286 FILTER__FILTER0.n4 VGND 0.07317f $ **FLOATING
C1287 FILTER__FILTER0.t10 VGND 2.61602f $ **FLOATING
C1288 FILTER__FILTER0.t11 VGND 2.61602f $ **FLOATING
C1289 FILTER__FILTER0.n5 VGND 0.12166f $ **FLOATING
C1290 FILTER__FILTER0.t7 VGND 2.61602f $ **FLOATING
C1291 FILTER__FILTER0.n6 VGND 0.08496f $ **FLOATING
C1292 FILTER__FILTER0.t3 VGND 2.61602f $ **FLOATING
C1293 FILTER__FILTER0.n7 VGND 0.08496f $ **FLOATING
C1294 FILTER__FILTER0.t5 VGND 2.61602f $ **FLOATING
C1295 FILTER__FILTER0.n8 VGND 0.08496f $ **FLOATING
C1296 FILTER__FILTER0.t1 VGND 2.61602f $ **FLOATING
C1297 FILTER__FILTER0.n9 VGND 0.08496f $ **FLOATING
C1298 FILTER__FILTER0.t13 VGND 2.61602f $ **FLOATING
C1299 FILTER__FILTER0.n10 VGND 0.06996f $ **FLOATING
C1300 FILTER__FILTER0.t0 VGND 0.06347f $ **FLOATING
C1301 FILTER__FILTER0.n11 VGND 0.80125f $ **FLOATING
C1302 FILTER__FILTER0.n12 VGND 0.56421f $ **FLOATING
C1303 FILTER__FILTER0.t12 VGND 2.61602f $ **FLOATING
C1304 BIAS_SOURCE__VCM_BUFFER__COMP.t1 VGND 0.10495p $ **FLOATING
C1305 BIAS_SOURCE__VCM_BUFFER__COMP.t3 VGND 91.62779f $ **FLOATING
C1306 BIAS_SOURCE__VCM_BUFFER__COMP.n0 VGND 29.4052f $ **FLOATING
C1307 BIAS_SOURCE__VCM_BUFFER__COMP.t2 VGND 91.62779f $ **FLOATING
C1308 BIAS_SOURCE__VCM_BUFFER__COMP.n1 VGND 2.83509f $ **FLOATING
C1309 BIAS_SOURCE__VCM_BUFFER__COMP.t0 VGND 0.95579f $ **FLOATING
C1310 BIAS_SOURCE__VCM_BUFFER__PRE.n0 VGND 0.01155f $ **FLOATING
C1311 BIAS_SOURCE__VCM_BUFFER__PRE.t4 VGND 49.6352f $ **FLOATING
C1312 BIAS_SOURCE__VCM_BUFFER__PRE.t3 VGND 49.6352f $ **FLOATING
C1313 BIAS_SOURCE__VCM_BUFFER__PRE.n1 VGND 1.96638f $ **FLOATING
C1314 BIAS_SOURCE__VCM_BUFFER__PRE.t6 VGND 49.6352f $ **FLOATING
C1315 BIAS_SOURCE__VCM_BUFFER__PRE.n2 VGND 1.27989f $ **FLOATING
C1316 BIAS_SOURCE__VCM_BUFFER__PRE.t5 VGND 1.90418f $ **FLOATING
C1317 BIAS_SOURCE__VCM_BUFFER__PRE.n3 VGND 1.06272f $ **FLOATING
C1318 BIAS_SOURCE__VCM_BUFFER__PRE.n4 VGND 0.0161f $ **FLOATING
C1319 BIAS_SOURCE__VCM_BUFFER__PRE.t1 VGND 0.0196f $ **FLOATING
C1320 BIAS_SOURCE__VCM_BUFFER__PRE.n5 VGND 0.01636f $ **FLOATING
C1321 BIAS_SOURCE__VCM_BUFFER__PRE.n6 VGND 1.1119f $ **FLOATING
C1322 BIAS_SOURCE__VCM_BUFFER__PRE.n7 VGND 1.01557f $ **FLOATING
C1323 BIAS_SOURCE__VCM_BUFFER__PRE.n8 VGND 0.01155f $ **FLOATING
C1324 BIAS_SOURCE__VCM_BUFFER__PRE.t2 VGND 0.01411f $ **FLOATING
C1325 BIAS_SOURCE__VCM_BUFFER__PRE.n9 VGND 0.01155f $ **FLOATING
C1326 BIAS_SOURCE__VCM_BUFFER__PRE.n10 VGND 0.50343f $ **FLOATING
C1327 BIAS_SOURCE__VCM_BUFFER__PRE.n11 VGND 19.601f $ **FLOATING
C1328 BIAS_SOURCE__VCM_BUFFER__PRE.n12 VGND 2.25695f $ **FLOATING
C1329 BIAS_SOURCE__VCM_BUFFER__PRE.t0 VGND 0.01411f $ **FLOATING
C1330 BIAS_SOURCE__VCM_BUFFER__PRE.n13 VGND 0.01155f $ **FLOATING
C1331 PGA__GAIN2__AMP__FIRST__MIR.n0 VGND 0.058f $ **FLOATING
C1332 PGA__GAIN2__AMP__FIRST__MIR.t1 VGND 0.06949f $ **FLOATING
C1333 PGA__GAIN2__AMP__FIRST__MIR.t4 VGND 3.53493f $ **FLOATING
C1334 PGA__GAIN2__AMP__FIRST__MIR.t0 VGND 3.53493f $ **FLOATING
C1335 PGA__GAIN2__AMP__FIRST__MIR.n1 VGND 4.65686f $ **FLOATING
C1336 PGA__GAIN2__AMP__FIRST__MIR.n2 VGND 0.04096f $ **FLOATING
C1337 PGA__GAIN2__AMP__FIRST__MIR.t2 VGND 0.05002f $ **FLOATING
C1338 PGA__GAIN2__AMP__FIRST__MIR.n3 VGND 0.04096f $ **FLOATING
C1339 PGA__GAIN2__AMP__FIRST__MIR.n4 VGND 4.60146f $ **FLOATING
C1340 PGA__GAIN2__AMP__FIRST__MIR.n5 VGND 0.04096f $ **FLOATING
C1341 PGA__GAIN2__AMP__FIRST__MIR.t3 VGND 0.05002f $ **FLOATING
C1342 PGA__GAIN2__AMP__FIRST__MIR.n6 VGND 0.04096f $ **FLOATING
C1343 PGA__GAIN2__AMP__FIRST__MIR.n7 VGND 2.00965f $ **FLOATING
C1344 PGA__GAIN2__AMP__FIRST__MIR.n8 VGND 93.9476f $ **FLOATING
C1345 PGA__GAIN2__AMP__FIRST__MIR.n9 VGND 2.81684f $ **FLOATING
C1346 PGA__GAIN2__AMP__FIRST__MIR.n10 VGND 4.1672f $ **FLOATING
C1347 PGA__GAIN2__AMP__FIRST__MIR.n11 VGND 0.0571f $ **FLOATING
C1348 PGA__GAINB.n0 VGND 0.01239f $ **FLOATING
C1349 PGA__GAINB.t3 VGND 0.54589f $ **FLOATING
C1350 PGA__GAINB.t2 VGND 0.54357f $ **FLOATING
C1351 PGA__GAINB.n1 VGND 7.51682f $ **FLOATING
C1352 PGA__GAINB.n2 VGND 0.01415f $ **FLOATING
C1353 PGA__GAINB.t1 VGND 0.03442f $ **FLOATING
C1354 PGA__GAINB.n3 VGND 0.01415f $ **FLOATING
C1355 PGA__GAINB.n4 VGND 1.63814f $ **FLOATING
C1356 PGA__GAINB.n5 VGND 48.868f $ **FLOATING
C1357 PGA__GAINB.n6 VGND 2.75494f $ **FLOATING
C1358 PGA__GAINB.t0 VGND 0.03794f $ **FLOATING
C1359 PGA__GAINB.n7 VGND 0.01239f $ **FLOATING
C1360 GAIN.t3 VGND 0.55467f $ **FLOATING
C1361 GAIN.t2 VGND 0.55703f $ **FLOATING
C1362 GAIN.n0 VGND 5.80274f $ **FLOATING
C1363 GAIN.t0 VGND 0.05224f $ **FLOATING
C1364 GAIN.n1 VGND 3.9516f $ **FLOATING
C1365 GAIN.t1 VGND 0.05428f $ **FLOATING
C1366 GAIN.n2 VGND 31.1024f $ **FLOATING
rmesh_equiv_0 amplified amplified.n0 19.837
rmesh_equiv_1 amplified amplified.n10 4.2590000000000003
rmesh_equiv_10 amplified.n1 amplified.t0 30.876800000000003
rmesh_equiv_100 bias_source__vcm_buffer__first__mir.n8 bias_source__vcm_buffer__first__mir.n9 1.23464
rmesh_equiv_1000 pga__output_buffer__first__tail pga__output_buffer__first__tail.n12 15.6333
rmesh_equiv_1001 pga__output_buffer__first__tail pga__output_buffer__first__tail.n13 15.6333
rmesh_equiv_1002 pga__output_buffer__first__tail pga__output_buffer__first__tail.n17 4.2590000000000003
rmesh_equiv_1003 pga__output_buffer__first__tail pga__output_buffer__first__tail.n2 15.6333
rmesh_equiv_1004 pga__output_buffer__first__tail pga__output_buffer__first__tail.n4 15.6333
rmesh_equiv_1005 pga__output_buffer__first__tail pga__output_buffer__first__tail.n5 15.6333
rmesh_equiv_1006 pga__output_buffer__first__tail pga__output_buffer__first__tail.n8 15.6333
rmesh_equiv_1007 pga__output_buffer__first__tail pga__output_buffer__first__tail.n9 15.6333
rmesh_equiv_1008 pga__output_buffer__first__tail.n0 pga__output_buffer__first__tail.n16 14.189499999999999
rmesh_equiv_1009 pga__output_buffer__first__tail.n0 pga__output_buffer__first__tail.t0 174.91200000000001
rmesh_equiv_101 bias_source__vcm_buffer__first__tail bias_source__vcm_buffer__first__tail.n0 15.6333
rmesh_equiv_1010 pga__output_buffer__first__tail.n1 pga__output_buffer__first__tail.n3 5.2415200000000004
rmesh_equiv_1011 pga__output_buffer__first__tail.n1 pga__output_buffer__first__tail.t1 174.857
rmesh_equiv_1012 pga__output_buffer__first__tail.n10 pga__output_buffer__first__tail.n11 23.637899999999998
rmesh_equiv_1013 pga__output_buffer__first__tail.n10 pga__output_buffer__first__tail.n8 5.2415200000000004
rmesh_equiv_1014 pga__output_buffer__first__tail.n10 pga__output_buffer__first__tail.n9 5.2415200000000004
rmesh_equiv_1015 pga__output_buffer__first__tail.n11 pga__output_buffer__first__tail.n15 0.61541699999999999
rmesh_equiv_1016 pga__output_buffer__first__tail.n11 pga__output_buffer__first__tail.n7 0.61541699999999999
rmesh_equiv_1017 pga__output_buffer__first__tail.n12 pga__output_buffer__first__tail.n14 5.2415200000000004
rmesh_equiv_1018 pga__output_buffer__first__tail.n12 pga__output_buffer__first__tail.t2 174.857
rmesh_equiv_1019 pga__output_buffer__first__tail.n13 pga__output_buffer__first__tail.n14 5.2415200000000004
rmesh_equiv_102 bias_source__vcm_buffer__first__tail bias_source__vcm_buffer__first__tail.n1 19.837
rmesh_equiv_1020 pga__output_buffer__first__tail.n13 pga__output_buffer__first__tail.t2 174.857
rmesh_equiv_1021 pga__output_buffer__first__tail.n14 pga__output_buffer__first__tail.n15 23.637899999999998
rmesh_equiv_1022 pga__output_buffer__first__tail.n15 pga__output_buffer__first__tail.n16 25.311900000000001
rmesh_equiv_1023 pga__output_buffer__first__tail.n16 pga__output_buffer__first__tail.n17 3.0467200000000001
rmesh_equiv_1024 pga__output_buffer__first__tail.n17 pga__output_buffer__first__tail.t0 181.41
rmesh_equiv_1025 pga__output_buffer__first__tail.n2 pga__output_buffer__first__tail.n3 5.2415200000000004
rmesh_equiv_1026 pga__output_buffer__first__tail.n2 pga__output_buffer__first__tail.t1 174.857
rmesh_equiv_1027 pga__output_buffer__first__tail.n3 pga__output_buffer__first__tail.n7 24.252800000000001
rmesh_equiv_1028 pga__output_buffer__first__tail.n4 pga__output_buffer__first__tail.n6 5.2415200000000004
rmesh_equiv_1029 pga__output_buffer__first__tail.n4 pga__output_buffer__first__tail.t4 174.857
rmesh_equiv_103 bias_source__vcm_buffer__first__tail bias_source__vcm_buffer__first__tail.n11 15.6333
rmesh_equiv_1030 pga__output_buffer__first__tail.n5 pga__output_buffer__first__tail.n6 5.2415200000000004
rmesh_equiv_1031 pga__output_buffer__first__tail.n5 pga__output_buffer__first__tail.t4 174.857
rmesh_equiv_1032 pga__output_buffer__first__tail.n6 pga__output_buffer__first__tail.n7 23.637899999999998
rmesh_equiv_1033 pga__output_buffer__first__tail.n8 pga__output_buffer__first__tail.t3 174.857
rmesh_equiv_1034 pga__output_buffer__first__tail.n9 pga__output_buffer__first__tail.t3 174.857
rmesh_equiv_1035 pga__output_buffer__pre pga__output_buffer__pre.n0 22.8553
rmesh_equiv_1036 pga__output_buffer__pre pga__output_buffer__pre.n1 3.8272548433913069
rmesh_equiv_1037 pga__output_buffer__pre pga__output_buffer__pre.n13 4.8770699999999998
rmesh_equiv_1038 pga__output_buffer__pre pga__output_buffer__pre.n2 6.5077999999999996
rmesh_equiv_1039 pga__output_buffer__pre pga__output_buffer__pre.n3 34.299300000000002
rmesh_equiv_104 bias_source__vcm_buffer__first__tail bias_source__vcm_buffer__first__tail.n12 15.6333
rmesh_equiv_1040 pga__output_buffer__pre pga__output_buffer__pre.n4 15.6333
rmesh_equiv_1041 pga__output_buffer__pre pga__output_buffer__pre.n5 15.6333
rmesh_equiv_1042 pga__output_buffer__pre pga__output_buffer__pre.n7 15.6333
rmesh_equiv_1043 pga__output_buffer__pre pga__output_buffer__pre.n8 15.6333
rmesh_equiv_1044 pga__output_buffer__pre pga__output_buffer__pre.t3 0.00141837
rmesh_equiv_1045 pga__output_buffer__pre pga__output_buffer__pre.t4 0.00141837
rmesh_equiv_1046 pga__output_buffer__pre pga__output_buffer__pre.t5 1054.8499999999999
rmesh_equiv_1047 pga__output_buffer__pre pga__output_buffer__pre.t6 0.00141837
rmesh_equiv_1048 pga__output_buffer__pre.n0 pga__output_buffer__pre.n12 11.4361
rmesh_equiv_1049 pga__output_buffer__pre.n0 pga__output_buffer__pre.t0 381.113
rmesh_equiv_105 bias_source__vcm_buffer__first__tail bias_source__vcm_buffer__first__tail.n17 15.6333
rmesh_equiv_1050 pga__output_buffer__pre.n1 pga__output_buffer__pre.n2 2.7844699999999998
rmesh_equiv_1051 pga__output_buffer__pre.n10 pga__output_buffer__pre.n11 1.24326
rmesh_equiv_1052 pga__output_buffer__pre.n10 pga__output_buffer__pre.n6 26.315999999999995
rmesh_equiv_1053 pga__output_buffer__pre.n10 pga__output_buffer__pre.n9 24.4712
rmesh_equiv_1054 pga__output_buffer__pre.n11 pga__output_buffer__pre.n12 24.4712
rmesh_equiv_1055 pga__output_buffer__pre.n11 pga__output_buffer__pre.n3 1.50881
rmesh_equiv_1056 pga__output_buffer__pre.n12 pga__output_buffer__pre.n13 2.4407800000000002
rmesh_equiv_1057 pga__output_buffer__pre.n13 pga__output_buffer__pre.t0 387.11000000000001
rmesh_equiv_1058 pga__output_buffer__pre.n2 pga__output_buffer__pre.n3 2.0861200000000002
rmesh_equiv_1059 pga__output_buffer__pre.n4 pga__output_buffer__pre.n6 5.2415200000000004
rmesh_equiv_106 bias_source__vcm_buffer__first__tail bias_source__vcm_buffer__first__tail.n2 4.2590000000000003
rmesh_equiv_1060 pga__output_buffer__pre.n4 pga__output_buffer__pre.t1 174.857
rmesh_equiv_1061 pga__output_buffer__pre.n5 pga__output_buffer__pre.n6 5.2415200000000004
rmesh_equiv_1062 pga__output_buffer__pre.n5 pga__output_buffer__pre.t1 174.857
rmesh_equiv_1063 pga__output_buffer__pre.n7 pga__output_buffer__pre.n9 5.2415200000000004
rmesh_equiv_1064 pga__output_buffer__pre.n7 pga__output_buffer__pre.t2 174.857
rmesh_equiv_1065 pga__output_buffer__pre.n8 pga__output_buffer__pre.n9 5.2415200000000004
rmesh_equiv_1066 pga__output_buffer__pre.n8 pga__output_buffer__pre.t2 174.857
rmesh_equiv_1067 pga__selected pga__selected.n0 20.370899999999999
rmesh_equiv_1068 pga__selected pga__selected.n1 19.812770036068301
rmesh_equiv_1069 pga__selected pga__selected.n10 22.8553
rmesh_equiv_107 bias_source__vcm_buffer__first__tail bias_source__vcm_buffer__first__tail.n4 15.6333
rmesh_equiv_1070 pga__selected pga__selected.n15 4.39276
rmesh_equiv_1071 pga__selected pga__selected.n2 4.8770699999999998
rmesh_equiv_1072 pga__selected pga__selected.n3 22.8553
rmesh_equiv_1073 pga__selected pga__selected.n6 4.39276
rmesh_equiv_1074 pga__selected pga__selected.n7 20.370899999999999
rmesh_equiv_1075 pga__selected pga__selected.n9 4.8770699999999998
rmesh_equiv_1076 pga__selected pga__selected.t4 212.21199999999999
rmesh_equiv_1077 pga__selected pga__selected.t5 212.21199999999999
rmesh_equiv_1078 pga__selected.n0 pga__selected.n14 13.4665
rmesh_equiv_1079 pga__selected.n0 pga__selected.t0 172.06
rmesh_equiv_108 bias_source__vcm_buffer__first__tail bias_source__vcm_buffer__first__tail.n5 15.6333
rmesh_equiv_1080 pga__selected.n1 pga__selected.n5 0.668292
rmesh_equiv_1081 pga__selected.n10 pga__selected.n11 11.4361
rmesh_equiv_1082 pga__selected.n10 pga__selected.t1 381.113
rmesh_equiv_1083 pga__selected.n11 pga__selected.n12 23.117000000000001
rmesh_equiv_1084 pga__selected.n11 pga__selected.n9 2.4407800000000002
rmesh_equiv_1085 pga__selected.n12 pga__selected.n13 0.55314200000000002
rmesh_equiv_1086 pga__selected.n12 pga__selected.n8 23.669699999999999
rmesh_equiv_1087 pga__selected.n13 pga__selected.n14 23.117000000000001
rmesh_equiv_1088 pga__selected.n13 pga__selected.n5 0.55314200000000002
rmesh_equiv_1089 pga__selected.n14 pga__selected.n15 2.90421
rmesh_equiv_109 bias_source__vcm_buffer__first__tail bias_source__vcm_buffer__first__tail.n7 15.6333
rmesh_equiv_1090 pga__selected.n15 pga__selected.t0 178.41800000000001
rmesh_equiv_1091 pga__selected.n2 pga__selected.n4 2.4407800000000002
rmesh_equiv_1092 pga__selected.n2 pga__selected.t2 387.11000000000001
rmesh_equiv_1093 pga__selected.n3 pga__selected.n4 11.4361
rmesh_equiv_1094 pga__selected.n3 pga__selected.t2 381.113
rmesh_equiv_1095 pga__selected.n4 pga__selected.n5 23.117000000000001
rmesh_equiv_1096 pga__selected.n6 pga__selected.n8 2.90421
rmesh_equiv_1097 pga__selected.n6 pga__selected.t3 178.41800000000001
rmesh_equiv_1098 pga__selected.n7 pga__selected.n8 13.4665
rmesh_equiv_1099 pga__selected.n7 pga__selected.t3 172.06
rmesh_equiv_11 amplified.n1 amplified.t3 37.260399999999997
rmesh_equiv_110 bias_source__vcm_buffer__first__tail bias_source__vcm_buffer__first__tail.n8 15.6333
rmesh_equiv_1100 pga__selected.n9 pga__selected.t1 387.11000000000001
rmesh_equiv_1101 pga__v2 pga__v2.n0 19.837
rmesh_equiv_1102 pga__v2 pga__v2.n1 4.8770699999999998
rmesh_equiv_1103 pga__v2 pga__v2.n10 31.449800000000003
rmesh_equiv_1104 pga__v2 pga__v2.n12 7.21753
rmesh_equiv_1105 pga__v2 pga__v2.n16 4.2590000000000003
rmesh_equiv_1106 pga__v2 pga__v2.n2 22.8553
rmesh_equiv_1107 pga__v2 pga__v2.n4 4.39276
rmesh_equiv_1108 pga__v2 pga__v2.n5 20.370899999999999
rmesh_equiv_1109 pga__v2.n0 pga__v2.n15 14.189499999999999
rmesh_equiv_111 bias_source__vcm_buffer__first__tail.n0 bias_source__vcm_buffer__first__tail.n16 5.2415200000000004
rmesh_equiv_1110 pga__v2.n0 pga__v2.t4 174.91200000000001
rmesh_equiv_1111 pga__v2.n1 pga__v2.n3 2.4407800000000002
rmesh_equiv_1112 pga__v2.n1 pga__v2.t1 387.11000000000001
rmesh_equiv_1113 pga__v2.n10 pga__v2.n11 12.280799999999999
rmesh_equiv_1114 pga__v2.n10 pga__v2.n13 1.2268600000000001
rmesh_equiv_1115 pga__v2.n11 pga__v2.n12 13.671300000000002
rmesh_equiv_1116 pga__v2.n11 pga__v2.t3 0.71462499999999995
rmesh_equiv_1117 pga__v2.n12 pga__v2.n13 0.10989600000000001
rmesh_equiv_1118 pga__v2.n13 pga__v2.n14 22.387899999999998
rmesh_equiv_1119 pga__v2.n14 pga__v2.n15 23.007100000000001
rmesh_equiv_112 bias_source__vcm_buffer__first__tail.n0 bias_source__vcm_buffer__first__tail.t1 174.857
rmesh_equiv_1120 pga__v2.n14 pga__v2.n9 81.815899999999999
rmesh_equiv_1121 pga__v2.n15 pga__v2.n16 3.0467200000000001
rmesh_equiv_1122 pga__v2.n16 pga__v2.t4 181.41
rmesh_equiv_1123 pga__v2.n2 pga__v2.n3 11.4361
rmesh_equiv_1124 pga__v2.n2 pga__v2.t1 381.113
rmesh_equiv_1125 pga__v2.n3 pga__v2.n7 22.003
rmesh_equiv_1126 pga__v2.n4 pga__v2.n6 2.90421
rmesh_equiv_1127 pga__v2.n4 pga__v2.t2 178.41800000000001
rmesh_equiv_1128 pga__v2.n5 pga__v2.n6 13.4665
rmesh_equiv_1129 pga__v2.n5 pga__v2.t2 172.06
rmesh_equiv_113 bias_source__vcm_buffer__first__tail.n1 bias_source__vcm_buffer__first__tail.n3 14.189499999999999
rmesh_equiv_1130 pga__v2.n6 pga__v2.n7 21.450399999999998
rmesh_equiv_1131 pga__v2.n7 pga__v2.n8 18.097799999999999
rmesh_equiv_1132 pga__v2.n8 pga__v2.n9 1.0595699999999999
rmesh_equiv_1133 pga__v2.n8 pga__v2.t5 29.946400000000001
rmesh_equiv_1134 pga__v2.n9 pga__v2.t0 23.2805
rmesh_equiv_1135 pga__v8 pga__v8.n0 22.8553
rmesh_equiv_1136 pga__v8 pga__v8.n1 33.9895
rmesh_equiv_1137 pga__v8 pga__v8.n11 4.39276
rmesh_equiv_1138 pga__v8 pga__v8.n12 20.370899999999999
rmesh_equiv_1139 pga__v8 pga__v8.n16 4.8770699999999998
rmesh_equiv_114 bias_source__vcm_buffer__first__tail.n1 bias_source__vcm_buffer__first__tail.t2 174.91200000000001
rmesh_equiv_1140 pga__v8 pga__v8.n3 6.9688099999999995
rmesh_equiv_1141 pga__v8 pga__v8.n5 19.837
rmesh_equiv_1142 pga__v8 pga__v8.n6 4.2590000000000003
rmesh_equiv_1143 pga__v8.n0 pga__v8.n15 11.4361
rmesh_equiv_1144 pga__v8.n0 pga__v8.t2 381.113
rmesh_equiv_1145 pga__v8.n1 pga__v8.n2 13.2728
rmesh_equiv_1146 pga__v8.n1 pga__v8.n4 0.51338700000000004
rmesh_equiv_1147 pga__v8.n10 pga__v8.n14 3.4205299999999998
rmesh_equiv_1148 pga__v8.n10 pga__v8.n9 1.0595699999999999
rmesh_equiv_1149 pga__v8.n10 pga__v8.t5 27.720700000000004
rmesh_equiv_115 bias_source__vcm_buffer__first__tail.n10 bias_source__vcm_buffer__first__tail.n14 0.61541699999999999
rmesh_equiv_1150 pga__v8.n11 pga__v8.n13 2.90421
rmesh_equiv_1151 pga__v8.n11 pga__v8.t1 178.41800000000001
rmesh_equiv_1152 pga__v8.n12 pga__v8.n13 13.4665
rmesh_equiv_1153 pga__v8.n12 pga__v8.t1 172.06
rmesh_equiv_1154 pga__v8.n13 pga__v8.n14 22.2837
rmesh_equiv_1155 pga__v8.n14 pga__v8.n15 22.836300000000001
rmesh_equiv_1156 pga__v8.n15 pga__v8.n16 2.4407800000000002
rmesh_equiv_1157 pga__v8.n16 pga__v8.t2 387.11000000000001
rmesh_equiv_1158 pga__v8.n2 pga__v8.n3 13.200100000000001
rmesh_equiv_1159 pga__v8.n2 pga__v8.t4 0.71462499999999995
rmesh_equiv_116 bias_source__vcm_buffer__first__tail.n10 bias_source__vcm_buffer__first__tail.n6 19.669499999999999
rmesh_equiv_1160 pga__v8.n3 pga__v8.n4 0.27270899999999998
rmesh_equiv_1161 pga__v8.n4 pga__v8.n8 22.590399999999999
rmesh_equiv_1162 pga__v8.n5 pga__v8.n7 14.189499999999999
rmesh_equiv_1163 pga__v8.n5 pga__v8.t3 174.91200000000001
rmesh_equiv_1164 pga__v8.n6 pga__v8.n7 3.0467200000000001
rmesh_equiv_1165 pga__v8.n6 pga__v8.t3 181.41
rmesh_equiv_1166 pga__v8.n7 pga__v8.n8 21.9712
rmesh_equiv_1167 pga__v8.n8 pga__v8.n9 9.1596299999999999
rmesh_equiv_1168 pga__v8.n9 pga__v8.t0 24.113900000000001
rmesh_equiv_1169 pga_gain8_r_feedback_r0_n0.t0 pga_gain8_r_feedback_r0_n0.t1 62.421399999999998
rmesh_equiv_117 bias_source__vcm_buffer__first__tail.n10 bias_source__vcm_buffer__first__tail.n9 19.054500000000001
rmesh_equiv_1170 reset reset.n0 20.532091937033297
rmesh_equiv_1171 reset reset.n1 40.797600000000003
rmesh_equiv_1172 reset reset.n2 14.412588470319635
rmesh_equiv_1173 reset reset.t0 330.34100000000001
rmesh_equiv_1174 reset reset.t1 315.88
rmesh_equiv_1175 reset reset.t2 330.34100000000001
rmesh_equiv_1176 reset reset.t3 315.88
rmesh_equiv_1177 reset.n0 reset.n1 1.1014699999999999
rmesh_equiv_1178 reset.n1 reset.n2 0.55314200000000002
rmesh_equiv_1179 reset_mux__sb reset_mux__sb.n0 12.8005
rmesh_equiv_118 bias_source__vcm_buffer__first__tail.n11 bias_source__vcm_buffer__first__tail.n13 5.2415200000000004
rmesh_equiv_1180 reset_mux__sb reset_mux__sb.n1 21.009704539620724
rmesh_equiv_1181 reset_mux__sb reset_mux__sb.n2 12.8005
rmesh_equiv_1182 reset_mux__sb reset_mux__sb.n3 12.8005
rmesh_equiv_1183 reset_mux__sb reset_mux__sb.n7 12.8005
rmesh_equiv_1184 reset_mux__sb reset_mux__sb.t2 330.34100000000001
rmesh_equiv_1185 reset_mux__sb reset_mux__sb.t3 315.88
rmesh_equiv_1186 reset_mux__sb.n0 reset_mux__sb.n6 10.151300000000001
rmesh_equiv_1187 reset_mux__sb.n0 reset_mux__sb.t0 700.48400000000004
rmesh_equiv_1188 reset_mux__sb.n1 reset_mux__sb.n5 0.78539999999999988
rmesh_equiv_1189 reset_mux__sb.n2 reset_mux__sb.n4 10.151300000000001
rmesh_equiv_119 bias_source__vcm_buffer__first__tail.n11 bias_source__vcm_buffer__first__tail.t3 174.857
rmesh_equiv_1190 reset_mux__sb.n2 reset_mux__sb.t1 255.34500000000003
rmesh_equiv_1191 reset_mux__sb.n3 reset_mux__sb.n4 10.151300000000001
rmesh_equiv_1192 reset_mux__sb.n3 reset_mux__sb.t1 255.34500000000003
rmesh_equiv_1193 reset_mux__sb.n4 reset_mux__sb.n5 21.867000000000001
rmesh_equiv_1194 reset_mux__sb.n5 reset_mux__sb.n6 22.419699999999999
rmesh_equiv_1195 reset_mux__sb.n6 reset_mux__sb.n7 10.151300000000001
rmesh_equiv_1196 reset_mux__sb.n7 reset_mux__sb.t0 700.48400000000004
rmesh_equiv_1197 sample__clkb sample__clkb.n0 12.8005
rmesh_equiv_1198 sample__clkb sample__clkb.n1 21.157120976270289
rmesh_equiv_1199 sample__clkb sample__clkb.n2 42.031999999999996
rmesh_equiv_12 amplified.n10 amplified.n9 3.0467200000000001
rmesh_equiv_120 bias_source__vcm_buffer__first__tail.n12 bias_source__vcm_buffer__first__tail.n13 5.2415200000000004
rmesh_equiv_1200 sample__clkb sample__clkb.n3 42.047600000000003
rmesh_equiv_1201 sample__clkb sample__clkb.n4 12.8005
rmesh_equiv_1202 sample__clkb sample__clkb.n5 12.8005
rmesh_equiv_1203 sample__clkb sample__clkb.n9 12.8005
rmesh_equiv_1204 sample__clkb sample__clkb.t2 330.34100000000001
rmesh_equiv_1205 sample__clkb sample__clkb.t3 330.34100000000001
rmesh_equiv_1206 sample__clkb sample__clkb.t4 315.88
rmesh_equiv_1207 sample__clkb sample__clkb.t5 315.88
rmesh_equiv_1208 sample__clkb.n0 sample__clkb.n8 10.151300000000001
rmesh_equiv_1209 sample__clkb.n0 sample__clkb.t0 700.48400000000004
rmesh_equiv_121 bias_source__vcm_buffer__first__tail.n12 bias_source__vcm_buffer__first__tail.t3 174.857
rmesh_equiv_1210 sample__clkb.n1 sample__clkb.n2 1.10578
rmesh_equiv_1211 sample__clkb.n2 sample__clkb.n3 1.6584300000000001
rmesh_equiv_1212 sample__clkb.n3 sample__clkb.n7 0.78539999999999988
rmesh_equiv_1213 sample__clkb.n4 sample__clkb.n6 10.151300000000001
rmesh_equiv_1214 sample__clkb.n4 sample__clkb.t1 255.34500000000003
rmesh_equiv_1215 sample__clkb.n5 sample__clkb.n6 10.151300000000001
rmesh_equiv_1216 sample__clkb.n5 sample__clkb.t1 255.34500000000003
rmesh_equiv_1217 sample__clkb.n6 sample__clkb.n7 22.700399999999998
rmesh_equiv_1218 sample__clkb.n7 sample__clkb.n8 23.253
rmesh_equiv_1219 sample__clkb.n8 sample__clkb.n9 10.151300000000001
rmesh_equiv_122 bias_source__vcm_buffer__first__tail.n13 bias_source__vcm_buffer__first__tail.n14 19.054500000000001
rmesh_equiv_1220 sample__clkb.n9 sample__clkb.t0 700.48400000000004
rmesh_equiv_1221 sample__m sample__m.n0 12.8005
rmesh_equiv_1222 sample__m sample__m.n1 21.573789400328391
rmesh_equiv_1223 sample__m sample__m.n10 12.8005
rmesh_equiv_1224 sample__m sample__m.n15 12.8005
rmesh_equiv_1225 sample__m sample__m.n2 12.8005
rmesh_equiv_1226 sample__m sample__m.n3 12.8005
rmesh_equiv_1227 sample__m sample__m.n5 12.8005
rmesh_equiv_1228 sample__m sample__m.n6 12.8005
rmesh_equiv_1229 sample__m sample__m.n9 12.8005
rmesh_equiv_123 bias_source__vcm_buffer__first__tail.n14 bias_source__vcm_buffer__first__tail.n15 0.61541699999999999
rmesh_equiv_1230 sample__m sample__m.t4 330.34100000000001
rmesh_equiv_1231 sample__m sample__m.t5 315.88
rmesh_equiv_1232 sample__m.n0 sample__m.n14 10.151300000000001
rmesh_equiv_1233 sample__m.n0 sample__m.t0 700.48400000000004
rmesh_equiv_1234 sample__m.n1 sample__m.n13 3.0045799999999998
rmesh_equiv_1235 sample__m.n10 sample__m.n11 10.151300000000001
rmesh_equiv_1236 sample__m.n10 sample__m.t3 255.34500000000003
rmesh_equiv_1237 sample__m.n11 sample__m.n12 23.5337
rmesh_equiv_1238 sample__m.n11 sample__m.n9 10.151300000000001
rmesh_equiv_1239 sample__m.n12 sample__m.n13 0.55314200000000002
rmesh_equiv_124 bias_source__vcm_buffer__first__tail.n15 bias_source__vcm_buffer__first__tail.n16 19.054500000000001
rmesh_equiv_1240 sample__m.n12 sample__m.n8 0.55314200000000002
rmesh_equiv_1241 sample__m.n13 sample__m.n14 23.5337
rmesh_equiv_1242 sample__m.n14 sample__m.n15 10.151300000000001
rmesh_equiv_1243 sample__m.n15 sample__m.t0 700.48400000000004
rmesh_equiv_1244 sample__m.n2 sample__m.n4 10.151300000000001
rmesh_equiv_1245 sample__m.n2 sample__m.t1 255.34500000000003
rmesh_equiv_1246 sample__m.n3 sample__m.n4 10.151300000000001
rmesh_equiv_1247 sample__m.n3 sample__m.t1 255.34500000000003
rmesh_equiv_1248 sample__m.n4 sample__m.n8 24.086300000000001
rmesh_equiv_1249 sample__m.n5 sample__m.n7 10.151300000000001
rmesh_equiv_125 bias_source__vcm_buffer__first__tail.n15 bias_source__vcm_buffer__first__tail.n3 20.7285
rmesh_equiv_1250 sample__m.n5 sample__m.t2 700.48400000000004
rmesh_equiv_1251 sample__m.n6 sample__m.n7 10.151300000000001
rmesh_equiv_1252 sample__m.n6 sample__m.t2 700.48400000000004
rmesh_equiv_1253 sample__m.n7 sample__m.n8 23.5337
rmesh_equiv_1254 sample__m.n9 sample__m.t3 255.34500000000003
rmesh_equiv_1255 sample__mb sample__mb.n0 12.8005
rmesh_equiv_1256 sample__mb sample__mb.n1 21.990482450298753
rmesh_equiv_1257 sample__mb sample__mb.n2 12.8005
rmesh_equiv_1258 sample__mb sample__mb.n3 12.8005
rmesh_equiv_1259 sample__mb sample__mb.n7 12.8005
rmesh_equiv_126 bias_source__vcm_buffer__first__tail.n16 bias_source__vcm_buffer__first__tail.n17 5.2415200000000004
rmesh_equiv_1260 sample__mb sample__mb.t2 330.34100000000001
rmesh_equiv_1261 sample__mb sample__mb.t3 315.88
rmesh_equiv_1262 sample__mb.n0 sample__mb.n6 10.151300000000001
rmesh_equiv_1263 sample__mb.n0 sample__mb.t0 700.48400000000004
rmesh_equiv_1264 sample__mb.n1 sample__mb.n5 0.78970799999999997
rmesh_equiv_1265 sample__mb.n2 sample__mb.n4 10.151300000000001
rmesh_equiv_1266 sample__mb.n2 sample__mb.t1 255.34500000000003
rmesh_equiv_1267 sample__mb.n3 sample__mb.n4 10.151300000000001
rmesh_equiv_1268 sample__mb.n3 sample__mb.t1 255.34500000000003
rmesh_equiv_1269 sample__mb.n4 sample__mb.n5 24.367000000000001
rmesh_equiv_127 bias_source__vcm_buffer__first__tail.n17 bias_source__vcm_buffer__first__tail.t1 174.857
rmesh_equiv_1270 sample__mb.n5 sample__mb.n6 24.919699999999995
rmesh_equiv_1271 sample__mb.n6 sample__mb.n7 10.151300000000001
rmesh_equiv_1272 sample__mb.n7 sample__mb.t0 700.48400000000004
rmesh_equiv_1273 sample__mf sample__mf.n0 12.8005
rmesh_equiv_1274 sample__mf sample__mf.n1 12.8005
rmesh_equiv_1275 sample__mf sample__mf.n11 12.8005
rmesh_equiv_1276 sample__mf sample__mf.n12 12.8005
rmesh_equiv_1277 sample__mf sample__mf.n15 12.8005
rmesh_equiv_1278 sample__mf sample__mf.n16 12.8005
rmesh_equiv_1279 sample__mf sample__mf.n2 12.8005
rmesh_equiv_128 bias_source__vcm_buffer__first__tail.n2 bias_source__vcm_buffer__first__tail.n3 3.0467200000000001
rmesh_equiv_1280 sample__mf sample__mf.n21 12.8005
rmesh_equiv_1281 sample__mf sample__mf.n4 12.8005
rmesh_equiv_1282 sample__mf sample__mf.n5 12.8005
rmesh_equiv_1283 sample__mf sample__mf.n7 12.8005
rmesh_equiv_1284 sample__mf sample__mf.n8 12.8005
rmesh_equiv_1285 sample__mf.n0 sample__mf.n20 10.151300000000001
rmesh_equiv_1286 sample__mf.n0 sample__mf.t0 700.48400000000004
rmesh_equiv_1287 sample__mf.n1 sample__mf.n3 10.151300000000001
rmesh_equiv_1288 sample__mf.n1 sample__mf.t1 255.34500000000003
rmesh_equiv_1289 sample__mf.n10 sample__mf.n14 0.55314200000000002
rmesh_equiv_129 bias_source__vcm_buffer__first__tail.n2 bias_source__vcm_buffer__first__tail.t2 181.41
rmesh_equiv_1290 sample__mf.n10 sample__mf.n6 24.503
rmesh_equiv_1291 sample__mf.n10 sample__mf.n9 23.950399999999998
rmesh_equiv_1292 sample__mf.n11 sample__mf.n13 10.151300000000001
rmesh_equiv_1293 sample__mf.n11 sample__mf.t5 255.34500000000003
rmesh_equiv_1294 sample__mf.n12 sample__mf.n13 10.151300000000001
rmesh_equiv_1295 sample__mf.n12 sample__mf.t5 255.34500000000003
rmesh_equiv_1296 sample__mf.n13 sample__mf.n14 23.950399999999998
rmesh_equiv_1297 sample__mf.n14 sample__mf.n18 0.55314200000000002
rmesh_equiv_1298 sample__mf.n15 sample__mf.n17 10.151300000000001
rmesh_equiv_1299 sample__mf.n15 sample__mf.t2 700.48400000000004
rmesh_equiv_13 amplified.n10 amplified.t1 181.41
rmesh_equiv_130 bias_source__vcm_buffer__first__tail.n4 bias_source__vcm_buffer__first__tail.n6 5.2415200000000004
rmesh_equiv_1300 sample__mf.n16 sample__mf.n17 10.151300000000001
rmesh_equiv_1301 sample__mf.n16 sample__mf.t2 700.48400000000004
rmesh_equiv_1302 sample__mf.n17 sample__mf.n18 23.950399999999998
rmesh_equiv_1303 sample__mf.n18 sample__mf.n19 2.5800200000000002
rmesh_equiv_1304 sample__mf.n19 sample__mf.n20 23.950399999999998
rmesh_equiv_1305 sample__mf.n19 sample__mf.n3 24.503
rmesh_equiv_1306 sample__mf.n2 sample__mf.n3 10.151300000000001
rmesh_equiv_1307 sample__mf.n2 sample__mf.t1 255.34500000000003
rmesh_equiv_1308 sample__mf.n20 sample__mf.n21 10.151300000000001
rmesh_equiv_1309 sample__mf.n21 sample__mf.t0 700.48400000000004
rmesh_equiv_131 bias_source__vcm_buffer__first__tail.n4 bias_source__vcm_buffer__first__tail.t0 174.857
rmesh_equiv_1310 sample__mf.n4 sample__mf.n6 10.151300000000001
rmesh_equiv_1311 sample__mf.n4 sample__mf.t4 255.34500000000003
rmesh_equiv_1312 sample__mf.n5 sample__mf.n6 10.151300000000001
rmesh_equiv_1313 sample__mf.n5 sample__mf.t4 255.34500000000003
rmesh_equiv_1314 sample__mf.n7 sample__mf.n9 10.151300000000001
rmesh_equiv_1315 sample__mf.n7 sample__mf.t3 700.48400000000004
rmesh_equiv_1316 sample__mf.n8 sample__mf.n9 10.151300000000001
rmesh_equiv_1317 sample__mf.n8 sample__mf.t3 700.48400000000004
rmesh_equiv_1318 sample__t sample__t.n0 12.8005
rmesh_equiv_1319 sample__t sample__t.n1 22.198815740735526
rmesh_equiv_132 bias_source__vcm_buffer__first__tail.n5 bias_source__vcm_buffer__first__tail.n6 5.2415200000000004
rmesh_equiv_1320 sample__t sample__t.n10 12.8005
rmesh_equiv_1321 sample__t sample__t.n15 12.8005
rmesh_equiv_1322 sample__t sample__t.n2 12.8005
rmesh_equiv_1323 sample__t sample__t.n3 12.8005
rmesh_equiv_1324 sample__t sample__t.n6 12.8005
rmesh_equiv_1325 sample__t sample__t.n7 12.8005
rmesh_equiv_1326 sample__t sample__t.n9 12.8005
rmesh_equiv_1327 sample__t sample__t.t4 330.34100000000001
rmesh_equiv_1328 sample__t sample__t.t5 315.88
rmesh_equiv_1329 sample__t.n0 sample__t.n14 10.151300000000001
rmesh_equiv_133 bias_source__vcm_buffer__first__tail.n5 bias_source__vcm_buffer__first__tail.t0 174.857
rmesh_equiv_1330 sample__t.n0 sample__t.t0 255.34500000000003
rmesh_equiv_1331 sample__t.n1 sample__t.n5 3.0045799999999998
rmesh_equiv_1332 sample__t.n10 sample__t.n11 10.151300000000001
rmesh_equiv_1333 sample__t.n10 sample__t.t1 700.48400000000004
rmesh_equiv_1334 sample__t.n11 sample__t.n12 24.7837
rmesh_equiv_1335 sample__t.n11 sample__t.n9 10.151300000000001
rmesh_equiv_1336 sample__t.n12 sample__t.n13 0.55314200000000002
rmesh_equiv_1337 sample__t.n12 sample__t.n8 25.336300000000001
rmesh_equiv_1338 sample__t.n13 sample__t.n14 24.7837
rmesh_equiv_1339 sample__t.n13 sample__t.n5 0.55314200000000002
rmesh_equiv_134 bias_source__vcm_buffer__first__tail.n7 bias_source__vcm_buffer__first__tail.n9 5.2415200000000004
rmesh_equiv_1340 sample__t.n14 sample__t.n15 10.151300000000001
rmesh_equiv_1341 sample__t.n15 sample__t.t0 255.34500000000003
rmesh_equiv_1342 sample__t.n2 sample__t.n4 10.151300000000001
rmesh_equiv_1343 sample__t.n2 sample__t.t2 700.48400000000004
rmesh_equiv_1344 sample__t.n3 sample__t.n4 10.151300000000001
rmesh_equiv_1345 sample__t.n3 sample__t.t2 700.48400000000004
rmesh_equiv_1346 sample__t.n4 sample__t.n5 24.7837
rmesh_equiv_1347 sample__t.n6 sample__t.n8 10.151300000000001
rmesh_equiv_1348 sample__t.n6 sample__t.t3 255.34500000000003
rmesh_equiv_1349 sample__t.n7 sample__t.n8 10.151300000000001
rmesh_equiv_135 bias_source__vcm_buffer__first__tail.n7 bias_source__vcm_buffer__first__tail.t4 174.857
rmesh_equiv_1350 sample__t.n7 sample__t.t3 255.34500000000003
rmesh_equiv_1351 sample__t.n9 sample__t.t1 700.48400000000004
rmesh_equiv_1352 sample__tb sample__tb.n0 12.8005
rmesh_equiv_1353 sample__tb sample__tb.n1 22.615507806613785
rmesh_equiv_1354 sample__tb sample__tb.n2 12.8005
rmesh_equiv_1355 sample__tb sample__tb.n3 12.8005
rmesh_equiv_1356 sample__tb sample__tb.n7 12.8005
rmesh_equiv_1357 sample__tb sample__tb.t2 330.34100000000001
rmesh_equiv_1358 sample__tb sample__tb.t3 315.88
rmesh_equiv_1359 sample__tb.n0 sample__tb.n6 10.151300000000001
rmesh_equiv_136 bias_source__vcm_buffer__first__tail.n8 bias_source__vcm_buffer__first__tail.n9 5.2415200000000004
rmesh_equiv_1360 sample__tb.n0 sample__tb.t0 255.34500000000003
rmesh_equiv_1361 sample__tb.n1 sample__tb.n5 0.78970799999999997
rmesh_equiv_1362 sample__tb.n2 sample__tb.n4 10.151300000000001
rmesh_equiv_1363 sample__tb.n2 sample__tb.t1 700.48400000000004
rmesh_equiv_1364 sample__tb.n3 sample__tb.n4 10.151300000000001
rmesh_equiv_1365 sample__tb.n3 sample__tb.t1 700.48400000000004
rmesh_equiv_1366 sample__tb.n4 sample__tb.n5 26.169699999999999
rmesh_equiv_1367 sample__tb.n5 sample__tb.n6 25.617000000000001
rmesh_equiv_1368 sample__tb.n6 sample__tb.n7 10.151300000000001
rmesh_equiv_1369 sample__tb.n7 sample__tb.t0 255.34500000000003
rmesh_equiv_137 bias_source__vcm_buffer__first__tail.n8 bias_source__vcm_buffer__first__tail.t4 174.857
rmesh_equiv_1370 vcm vcm.n0 19.837
rmesh_equiv_1371 vcm vcm.n1 4.2590000000000003
rmesh_equiv_1372 vcm vcm.n11 64.874200000000002
rmesh_equiv_1373 vcm vcm.n12 0.020083299999999998
rmesh_equiv_1374 vcm vcm.n13 36.224600000000002
rmesh_equiv_1375 vcm vcm.n4 31.449800000000003
rmesh_equiv_1376 vcm vcm.n6 7.21753
rmesh_equiv_1377 vcm vcm.n9 36.224600000000002
rmesh_equiv_1378 vcm vcm.t5 212.21199999999999
rmesh_equiv_1379 vcm vcm.t6 212.21199999999999
rmesh_equiv_138 bias_source__vcm_buffer__pre bias_source__vcm_buffer__pre.n0 15.6333
rmesh_equiv_1380 vcm vcm.t7 332.71199999999999
rmesh_equiv_1381 vcm.n0 vcm.n2 14.189499999999999
rmesh_equiv_1382 vcm.n0 vcm.t3 174.91200000000001
rmesh_equiv_1383 vcm.n1 vcm.n2 3.0467200000000001
rmesh_equiv_1384 vcm.n1 vcm.t3 181.41
rmesh_equiv_1385 vcm.n10 vcm.n11 11.0457
rmesh_equiv_1386 vcm.n10 vcm.t0 32.456600000000002
rmesh_equiv_1387 vcm.n10 vcm.t1 48.239199999999997
rmesh_equiv_1388 vcm.n11 vcm.n12 6.8897599999999999
rmesh_equiv_1389 vcm.n12 vcm.n13 43.933900000000001
rmesh_equiv_139 bias_source__vcm_buffer__pre bias_source__vcm_buffer__pre.n1 3.1250962059581271
rmesh_equiv_1390 vcm.n13 vcm.n9 0.61541699999999999
rmesh_equiv_1391 vcm.n2 vcm.n3 20.304500000000001
rmesh_equiv_1392 vcm.n3 vcm.n8 0.61972499999999997
rmesh_equiv_1393 vcm.n3 vcm.t2 41.419600000000003
rmesh_equiv_1394 vcm.n4 vcm.n5 12.280799999999999
rmesh_equiv_1395 vcm.n4 vcm.n7 1.2268600000000001
rmesh_equiv_1396 vcm.n5 vcm.n6 13.671300000000002
rmesh_equiv_1397 vcm.n5 vcm.t4 0.71462499999999995
rmesh_equiv_1398 vcm.n6 vcm.n7 0.10989600000000001
rmesh_equiv_1399 vcm.n7 vcm.n8 20.304500000000001
rmesh_equiv_14 amplified.n2 amplified.n7 2.8267699999999998
rmesh_equiv_140 bias_source__vcm_buffer__pre bias_source__vcm_buffer__pre.n13 15.6333
rmesh_equiv_1400 vcm.n8 vcm.n9 2.8267699999999998
rmesh_equiv_1401 vgnd vgnd.n10543 11910.811734895005
rmesh_equiv_1402 vgnd vgnd.n10545 1372.4736188879358
rmesh_equiv_1403 vgnd vgnd.n10555 2424.2850663563163
rmesh_equiv_1404 vgnd vgnd.n10593 244.12207082854019
rmesh_equiv_1405 vgnd vgnd.n10597 3347.2765931704275
rmesh_equiv_1406 vgnd vgnd.n10599 9676.5824806788205
rmesh_equiv_1407 vgnd vgnd.n10601 51.356746910853694
rmesh_equiv_1408 vgnd vgnd.n10608 388.95886446300443
rmesh_equiv_1409 vgnd vgnd.n10716 253.05099374000375
rmesh_equiv_141 bias_source__vcm_buffer__pre bias_source__vcm_buffer__pre.n2 5.1542000000000003
rmesh_equiv_1410 vgnd vgnd.n10781 230.97186701227869
rmesh_equiv_1411 vgnd vgnd.n10978 2424.2850663563163
rmesh_equiv_1412 vgnd vgnd.n11016 244.12207082854019
rmesh_equiv_1413 vgnd vgnd.n11020 3347.2765931704275
rmesh_equiv_1414 vgnd vgnd.n11022 9676.5824806788205
rmesh_equiv_1415 vgnd vgnd.n11024 51.356746910853694
rmesh_equiv_1416 vgnd vgnd.n11031 387.67920667315707
rmesh_equiv_1417 vgnd vgnd.n11038 20480.035509065765
rmesh_equiv_1418 vgnd vgnd.n11043 133.06983814232893
rmesh_equiv_1419 vgnd vgnd.n11077 485.94567652972836
rmesh_equiv_142 bias_source__vcm_buffer__pre bias_source__vcm_buffer__pre.n3 29.299299999999995
rmesh_equiv_1420 vgnd vgnd.n11227 3314.9094506703286
rmesh_equiv_1421 vgnd vgnd.n11273 13563.684554012687
rmesh_equiv_1422 vgnd vgnd.n11321 3166.7028678925558
rmesh_equiv_1423 vgnd vgnd.n114 2.9964241676370178
rmesh_equiv_1424 vgnd vgnd.n11406 684.1257279133805
rmesh_equiv_1425 vgnd vgnd.n11414 16074.375463075085
rmesh_equiv_1426 vgnd vgnd.n11420 21715.230184905846
rmesh_equiv_1427 vgnd vgnd.n11433 1550.0424767517306
rmesh_equiv_1428 vgnd vgnd.n11490 2105.0024982541086
rmesh_equiv_1429 vgnd vgnd.n11501 36122.643006534243
rmesh_equiv_143 bias_source__vcm_buffer__pre bias_source__vcm_buffer__pre.n4 4.8770699999999998
rmesh_equiv_1430 vgnd vgnd.n11543 15981.360674365025
rmesh_equiv_1431 vgnd vgnd.n11545 2776.1157880457085
rmesh_equiv_1432 vgnd vgnd.n11566 24.215335967068803
rmesh_equiv_1433 vgnd vgnd.n11569 7.8844263322480277
rmesh_equiv_1434 vgnd vgnd.n11574 209.117595017403
rmesh_equiv_1435 vgnd vgnd.n11583 530.84228419720648
rmesh_equiv_1436 vgnd vgnd.n11610 577316.57211906265
rmesh_equiv_1437 vgnd vgnd.n1368 281.20496605188441
rmesh_equiv_1438 vgnd vgnd.n1387 1667.6550004847006
rmesh_equiv_1439 vgnd vgnd.n151 231.90089037612287
rmesh_equiv_144 bias_source__vcm_buffer__pre bias_source__vcm_buffer__pre.n5 22.8553
rmesh_equiv_1440 vgnd vgnd.n154 14979.914789584001
rmesh_equiv_1441 vgnd vgnd.n158 158.38150169944592
rmesh_equiv_1442 vgnd vgnd.n1858 11983.955981812896
rmesh_equiv_1443 vgnd vgnd.n1869 17870.514884985176
rmesh_equiv_1444 vgnd vgnd.n1873 2004.1345601353182
rmesh_equiv_1445 vgnd vgnd.n1885 271.71024326050519
rmesh_equiv_1446 vgnd vgnd.n1901 314.23733783216602
rmesh_equiv_1447 vgnd vgnd.n1904 14684.703893909062
rmesh_equiv_1448 vgnd vgnd.n1908 1906.2618614348219
rmesh_equiv_1449 vgnd vgnd.n196 372.89225527389129
rmesh_equiv_145 bias_source__vcm_buffer__pre bias_source__vcm_buffer__pre.n8 15.6333
rmesh_equiv_1450 vgnd vgnd.n197 52.095880594004861
rmesh_equiv_1451 vgnd vgnd.n198 3984.4430461538459
rmesh_equiv_1452 vgnd vgnd.n203 1564.6070951681029
rmesh_equiv_1453 vgnd vgnd.n209 205025.76652236891
rmesh_equiv_1454 vgnd vgnd.n2110 316.64906577239213
rmesh_equiv_1455 vgnd vgnd.n2113 14684.703893909062
rmesh_equiv_1456 vgnd vgnd.n2117 1906.2618614348219
rmesh_equiv_1457 vgnd vgnd.n221 2424.2850663563167
rmesh_equiv_1458 vgnd vgnd.n2382 74.793039414739084
rmesh_equiv_1459 vgnd vgnd.n259 244.12207082854025
rmesh_equiv_146 bias_source__vcm_buffer__pre bias_source__vcm_buffer__pre.n9 15.6333
rmesh_equiv_1460 vgnd vgnd.n263 3347.276593170428
rmesh_equiv_1461 vgnd vgnd.n265 9676.5824806788187
rmesh_equiv_1462 vgnd vgnd.n267 51.356746910853694
rmesh_equiv_1463 vgnd vgnd.n273 388.94397237977188
rmesh_equiv_1464 vgnd vgnd.n2780 225.83646668628234
rmesh_equiv_1465 vgnd vgnd.n3159 45219.115632182329
rmesh_equiv_1466 vgnd vgnd.n3192 169.26347762818747
rmesh_equiv_1467 vgnd vgnd.n3194 8076.9525291074597
rmesh_equiv_1468 vgnd vgnd.n3196 164.35716309672193
rmesh_equiv_1469 vgnd vgnd.n348 1363.6059567639279
rmesh_equiv_147 bias_source__vcm_buffer__pre bias_source__vcm_buffer__pre.t3 0.00141837
rmesh_equiv_1470 vgnd vgnd.n355 6046.6770604692283
rmesh_equiv_1471 vgnd vgnd.n359 2583.2232644871342
rmesh_equiv_1472 vgnd vgnd.n3625 212.10175594861144
rmesh_equiv_1473 vgnd vgnd.n3672 158072.77084128483
rmesh_equiv_1474 vgnd vgnd.n37 15993.916175233886
rmesh_equiv_1475 vgnd vgnd.n3705 169.26347762818747
rmesh_equiv_1476 vgnd vgnd.n3707 8076.9525291074597
rmesh_equiv_1477 vgnd vgnd.n3709 164.35716309672193
rmesh_equiv_1478 vgnd vgnd.n3733 26533.632506894231
rmesh_equiv_1479 vgnd vgnd.n3735 258.96493286833777
rmesh_equiv_148 bias_source__vcm_buffer__pre bias_source__vcm_buffer__pre.t4 0.00141837
rmesh_equiv_1480 vgnd vgnd.n3783 253.70127043856795
rmesh_equiv_1481 vgnd vgnd.n3797 58.025842600764662
rmesh_equiv_1482 vgnd vgnd.n38 23747.312087593458
rmesh_equiv_1483 vgnd vgnd.n3805 13.244859882360373
rmesh_equiv_1484 vgnd vgnd.n41 3897.485424664636
rmesh_equiv_1485 vgnd vgnd.n412 349.58300315943598
rmesh_equiv_1486 vgnd vgnd.n4145 237.15562622736442
rmesh_equiv_1487 vgnd vgnd.n42 1353.4989632434213
rmesh_equiv_1488 vgnd vgnd.n4345 223.50007528945028
rmesh_equiv_1489 vgnd vgnd.n4405 227.63555752640153
rmesh_equiv_149 bias_source__vcm_buffer__pre bias_source__vcm_buffer__pre.t5 1054.8499999999999
rmesh_equiv_1490 vgnd vgnd.n4427 261.88231886447988
rmesh_equiv_1491 vgnd vgnd.n4430 805.06106970719657
rmesh_equiv_1492 vgnd vgnd.n4434 2034.3668572615707
rmesh_equiv_1493 vgnd vgnd.n4439 3176.868127790367
rmesh_equiv_1494 vgnd vgnd.n46 25.487745023861329
rmesh_equiv_1495 vgnd vgnd.n463 620.14494476592904
rmesh_equiv_1496 vgnd vgnd.n465 590.33739327947342
rmesh_equiv_1497 vgnd vgnd.n5263 67873.346519992949
rmesh_equiv_1498 vgnd vgnd.n5313 3.7743924959875099
rmesh_equiv_1499 vgnd vgnd.n5319 775.84175576924781
rmesh_equiv_15 amplified.n3 amplified.n4 13.2728
rmesh_equiv_150 bias_source__vcm_buffer__pre bias_source__vcm_buffer__pre.t6 0.00141837
rmesh_equiv_1500 vgnd vgnd.n5320 1698.6650633953734
rmesh_equiv_1501 vgnd vgnd.n5332 129.62182980459849
rmesh_equiv_1502 vgnd vgnd.n5337 162.08859337652939
rmesh_equiv_1503 vgnd vgnd.n5341 4658.6583799753962
rmesh_equiv_1504 vgnd vgnd.n5342 1615.0118896263216
rmesh_equiv_1505 vgnd vgnd.n5379 122463.20626448846
rmesh_equiv_1506 vgnd vgnd.n5497 11277428.936507735
rmesh_equiv_1507 vgnd vgnd.n55 270.65589405275733
rmesh_equiv_1508 vgnd vgnd.n5570 672.26727420003181
rmesh_equiv_1509 vgnd vgnd.n5675 772.27636298126629
rmesh_equiv_151 bias_source__vcm_buffer__pre.n0 bias_source__vcm_buffer__pre.n12 5.2415200000000004
rmesh_equiv_1510 vgnd vgnd.n5676 1698.6650633953734
rmesh_equiv_1511 vgnd vgnd.n5688 129.62182980459849
rmesh_equiv_1512 vgnd vgnd.n5693 162.08859337652939
rmesh_equiv_1513 vgnd vgnd.n5697 4658.6583799753962
rmesh_equiv_1514 vgnd vgnd.n5698 1615.0118896263216
rmesh_equiv_1515 vgnd vgnd.n57 194.14584602442173
rmesh_equiv_1516 vgnd vgnd.n5746 1964732.7202335945
rmesh_equiv_1517 vgnd vgnd.n5831 5952.9507396008476
rmesh_equiv_1518 vgnd vgnd.n59 1586.2906931874445
rmesh_equiv_1519 vgnd vgnd.n5901 31958.709300370763
rmesh_equiv_152 bias_source__vcm_buffer__pre.n0 bias_source__vcm_buffer__pre.t0 174.857
rmesh_equiv_1520 vgnd vgnd.n5902 1278.0207655857459
rmesh_equiv_1521 vgnd vgnd.n5912 18978.079839775019
rmesh_equiv_1522 vgnd vgnd.n6005 59731.575766799615
rmesh_equiv_1523 vgnd vgnd.n6073 237.21292734080941
rmesh_equiv_1524 vgnd vgnd.n6075 36184.880028528059
rmesh_equiv_1525 vgnd vgnd.n6077 3632.1583219687932
rmesh_equiv_1526 vgnd vgnd.n6100 27393.32981147723
rmesh_equiv_1527 vgnd vgnd.n6145 23296.240301172831
rmesh_equiv_1528 vgnd vgnd.n6147 2338.4255378608336
rmesh_equiv_1529 vgnd vgnd.n6151 247.07193060731458
rmesh_equiv_153 bias_source__vcm_buffer__pre.n1 bias_source__vcm_buffer__pre.n2 2.7844699999999998
rmesh_equiv_1530 vgnd vgnd.n618 39875.685929024279
rmesh_equiv_1531 vgnd vgnd.n63 283.76493063403001
rmesh_equiv_1532 vgnd vgnd.n630 351.29980388985553
rmesh_equiv_1533 vgnd vgnd.n6307 5539.8514353806004
rmesh_equiv_1534 vgnd vgnd.n632 316.94020222228687
rmesh_equiv_1535 vgnd vgnd.n6322 261507.20112436049
rmesh_equiv_1536 vgnd vgnd.n6330 333.17246826178791
rmesh_equiv_1537 vgnd vgnd.n637 263.74111074159458
rmesh_equiv_1538 vgnd vgnd.n6518 232.43725613767077
rmesh_equiv_1539 vgnd vgnd.n6523 197216.42619054904
rmesh_equiv_154 bias_source__vcm_buffer__pre.n10 bias_source__vcm_buffer__pre.n11 19.4712
rmesh_equiv_1540 vgnd vgnd.n6594 1914.0683514571128
rmesh_equiv_1541 vgnd vgnd.n6619 6040.7128853575805
rmesh_equiv_1542 vgnd vgnd.n6866 301.15727275891123
rmesh_equiv_1543 vgnd vgnd.n6870 5120.3647617188844
rmesh_equiv_1544 vgnd vgnd.n6872 198.16426398512502
rmesh_equiv_1545 vgnd vgnd.n6878 1579.4962475964278
rmesh_equiv_1546 vgnd vgnd.n6884 413.42149556080375
rmesh_equiv_1547 vgnd vgnd.n6887 14589.94117494591
rmesh_equiv_1548 vgnd vgnd.n6960 1757.386954814692
rmesh_equiv_1549 vgnd vgnd.n6962 771.74180787910723
rmesh_equiv_155 bias_source__vcm_buffer__pre.n10 bias_source__vcm_buffer__pre.n8 5.2415200000000004
rmesh_equiv_1550 vgnd vgnd.n6964 3979.9722088143185
rmesh_equiv_1551 vgnd vgnd.n6966 895.43709242006503
rmesh_equiv_1552 vgnd vgnd.n6974 129.52247578325546
rmesh_equiv_1553 vgnd vgnd.n6979 161.85398952285396
rmesh_equiv_1554 vgnd vgnd.n6983 1641.9281515017312
rmesh_equiv_1555 vgnd vgnd.n6984 1547.223191994739
rmesh_equiv_1556 vgnd vgnd.n6997 417.60782483126252
rmesh_equiv_1557 vgnd vgnd.n7044 3.7518269350195812
rmesh_equiv_1558 vgnd vgnd.n7088 251.36476204635997
rmesh_equiv_1559 vgnd vgnd.n7097 5.6157904421839513
rmesh_equiv_156 bias_source__vcm_buffer__pre.n10 bias_source__vcm_buffer__pre.n9 5.2415200000000004
rmesh_equiv_1560 vgnd vgnd.n7109 4.4910243596217434
rmesh_equiv_1561 vgnd vgnd.n748 217.7140734769402
rmesh_equiv_1562 vgnd vgnd.n7594 5968.442735042735
rmesh_equiv_1563 vgnd vgnd.n7600 490785317.54776561
rmesh_equiv_1564 vgnd vgnd.n7602 5853.307903010239
rmesh_equiv_1565 vgnd vgnd.n7604 387.31446976814652
rmesh_equiv_1566 vgnd vgnd.n7768 25.526756557320198
rmesh_equiv_1567 vgnd vgnd.n7780 248.03824197155794
rmesh_equiv_1568 vgnd vgnd.n8515 217.68872531152638
rmesh_equiv_1569 vgnd vgnd.n9069 3343.8020382752461
rmesh_equiv_157 bias_source__vcm_buffer__pre.n11 bias_source__vcm_buffer__pre.n12 21.315999999999999
rmesh_equiv_1570 vgnd vgnd.n9278 380.73123407377602
rmesh_equiv_1571 vgnd vgnd.n9286 91863.812379716022
rmesh_equiv_1572 vgnd vgnd.n9288 462.74738250987269
rmesh_equiv_1573 vgnd vgnd.n9313 2252.0649625306792
rmesh_equiv_1574 vgnd vgnd.n9314 51.92378332058675
rmesh_equiv_1575 vgnd vgnd.n9329 317.57520124996717
rmesh_equiv_1576 vgnd vgnd.n9336 2678.8179106616967
rmesh_equiv_1577 vgnd vgnd.n9342 48476126.220963195
rmesh_equiv_1578 vgnd vgnd.n9346 1769.4034345222785
rmesh_equiv_1579 vgnd vgnd.n9348 540.91484454568695
rmesh_equiv_158 bias_source__vcm_buffer__pre.n11 bias_source__vcm_buffer__pre.n7 1.24326
rmesh_equiv_1580 vgnd vgnd.n96 238206.87249082196
rmesh_equiv_1581 vgnd vgnd.n9783 213.25828176083655
rmesh_equiv_1582 vgnd vgnd.t0 104.82546580820797
rmesh_equiv_1583 vgnd vgnd.t10 103.08598799061697
rmesh_equiv_1584 vgnd vgnd.t100 110.08837159092992
rmesh_equiv_1585 vgnd vgnd.t101 184.5678146240144
rmesh_equiv_1586 vgnd vgnd.t102 169.0444036038196
rmesh_equiv_1587 vgnd vgnd.t103 406.22408525241138
rmesh_equiv_1588 vgnd vgnd.t106 168.14975625685631
rmesh_equiv_1589 vgnd vgnd.t107 120.97343198054148
rmesh_equiv_159 bias_source__vcm_buffer__pre.n12 bias_source__vcm_buffer__pre.n13 5.2415200000000004
rmesh_equiv_1590 vgnd vgnd.t109 99.198981769301795
rmesh_equiv_1591 vgnd vgnd.t11 21.478619552199511
rmesh_equiv_1592 vgnd vgnd.t111 141.28443402965442
rmesh_equiv_1593 vgnd vgnd.t112 110.08837295586356
rmesh_equiv_1594 vgnd vgnd.t113 25.084009116657313
rmesh_equiv_1595 vgnd vgnd.t114 135.87345264401603
rmesh_equiv_1596 vgnd vgnd.t115 102.26551264034289
rmesh_equiv_1597 vgnd vgnd.t12 409.78268264960872
rmesh_equiv_1598 vgnd vgnd.t121 162.36426734172466
rmesh_equiv_1599 vgnd vgnd.t123 94.32379561281482
rmesh_equiv_16 amplified.n3 amplified.n6 0.51338700000000004
rmesh_equiv_160 bias_source__vcm_buffer__pre.n13 bias_source__vcm_buffer__pre.t0 174.857
rmesh_equiv_1600 vgnd vgnd.t125 99.011098523967078
rmesh_equiv_1601 vgnd vgnd.t126 52.806611610955699
rmesh_equiv_1602 vgnd vgnd.t129 94.519041864878787
rmesh_equiv_1603 vgnd vgnd.t13 175.56663825338481
rmesh_equiv_1604 vgnd vgnd.t130 135.56141119414829
rmesh_equiv_1605 vgnd vgnd.t131 98.178741619054406
rmesh_equiv_1606 vgnd vgnd.t133 102.94872789214165
rmesh_equiv_1607 vgnd vgnd.t134 18927.04909476859
rmesh_equiv_1608 vgnd vgnd.t135 29.463565817482205
rmesh_equiv_1609 vgnd vgnd.t136 196.43074401837112
rmesh_equiv_161 bias_source__vcm_buffer__pre.n2 bias_source__vcm_buffer__pre.n3 2.0861200000000002
rmesh_equiv_1610 vgnd vgnd.t14 104.88843849383478
rmesh_equiv_1611 vgnd vgnd.t15 101.95861540314445
rmesh_equiv_1612 vgnd vgnd.t16 408.25277712631566
rmesh_equiv_1613 vgnd vgnd.t17 138.64998129599218
rmesh_equiv_1614 vgnd vgnd.t18 601.68966854262703
rmesh_equiv_1615 vgnd vgnd.t19 102.25452259636572
rmesh_equiv_1616 vgnd vgnd.t2 163.23952941851516
rmesh_equiv_1617 vgnd vgnd.t21 112.30818934423772
rmesh_equiv_1618 vgnd vgnd.t23 153.20490848997181
rmesh_equiv_1619 vgnd vgnd.t24 166.45342632704853
rmesh_equiv_162 bias_source__vcm_buffer__pre.n3 bias_source__vcm_buffer__pre.n7 1.50881
rmesh_equiv_1620 vgnd vgnd.t26 119.08086670069304
rmesh_equiv_1621 vgnd vgnd.t27 2307.724524257218
rmesh_equiv_1622 vgnd vgnd.t28 98.106947872539834
rmesh_equiv_1623 vgnd vgnd.t29 115.87437999635515
rmesh_equiv_1624 vgnd vgnd.t3 103.16926335312378
rmesh_equiv_1625 vgnd vgnd.t30 363.09120444099955
rmesh_equiv_1626 vgnd vgnd.t31 140.94702547069093
rmesh_equiv_1627 vgnd vgnd.t34 109.03179977586355
rmesh_equiv_1628 vgnd vgnd.t35 293.4172599846533
rmesh_equiv_1629 vgnd vgnd.t36 103.73830538510349
rmesh_equiv_163 bias_source__vcm_buffer__pre.n4 bias_source__vcm_buffer__pre.n6 2.4407800000000002
rmesh_equiv_1630 vgnd vgnd.t37 363.09120444099949
rmesh_equiv_1631 vgnd vgnd.t38 160.33931995806728
rmesh_equiv_1632 vgnd vgnd.t39 126.53750242342534
rmesh_equiv_1633 vgnd vgnd.t41 155.76996581144962
rmesh_equiv_1634 vgnd vgnd.t43 267.46147518570444
rmesh_equiv_1635 vgnd vgnd.t45 113.31189808363807
rmesh_equiv_1636 vgnd vgnd.t46 97.400221311224328
rmesh_equiv_1637 vgnd vgnd.t49 160.33931995806728
rmesh_equiv_1638 vgnd vgnd.t50 224.75378645257879
rmesh_equiv_1639 vgnd vgnd.t51 151.96574745832518
rmesh_equiv_164 bias_source__vcm_buffer__pre.n4 bias_source__vcm_buffer__pre.t1 387.11000000000001
rmesh_equiv_1640 vgnd vgnd.t52 363.09120444099955
rmesh_equiv_1641 vgnd vgnd.t53 376.63884295590083
rmesh_equiv_1642 vgnd vgnd.t54 154.34299030702047
rmesh_equiv_1643 vgnd vgnd.t55 115.22583831789341
rmesh_equiv_1644 vgnd vgnd.t56 99.207952704373497
rmesh_equiv_1645 vgnd vgnd.t57 363.09120444099949
rmesh_equiv_1646 vgnd vgnd.t58 151.8643093533303
rmesh_equiv_1647 vgnd vgnd.t59 215.96314864816506
rmesh_equiv_1648 vgnd vgnd.t62 2647.6699976148871
rmesh_equiv_1649 vgnd vgnd.t63 210.72562439463846
rmesh_equiv_165 bias_source__vcm_buffer__pre.n5 bias_source__vcm_buffer__pre.n6 11.4361
rmesh_equiv_1650 vgnd vgnd.t64 94.595823816987135
rmesh_equiv_1651 vgnd vgnd.t65 106.33581683278223
rmesh_equiv_1652 vgnd vgnd.t66 103.67296270799081
rmesh_equiv_1653 vgnd vgnd.t68 259.76592017259566
rmesh_equiv_1654 vgnd vgnd.t69 102.94921367100123
rmesh_equiv_1655 vgnd vgnd.t7 164.559272714852
rmesh_equiv_1656 vgnd vgnd.t70 265.80118186970907
rmesh_equiv_1657 vgnd vgnd.t71 155.88601335724644
rmesh_equiv_1658 vgnd vgnd.t74 98.283400524124644
rmesh_equiv_1659 vgnd vgnd.t76 282.58748121081578
rmesh_equiv_166 bias_source__vcm_buffer__pre.n5 bias_source__vcm_buffer__pre.t1 381.113
rmesh_equiv_1660 vgnd vgnd.t77 51.468003545874332
rmesh_equiv_1661 vgnd vgnd.t78 768.07839963640504
rmesh_equiv_1662 vgnd vgnd.t79 135.99538535677098
rmesh_equiv_1663 vgnd vgnd.t81 212.62874520043707
rmesh_equiv_1664 vgnd vgnd.t82 104.6685678458439
rmesh_equiv_1665 vgnd vgnd.t83 253.21788857097832
rmesh_equiv_1666 vgnd vgnd.t84 149.78686170128927
rmesh_equiv_1667 vgnd vgnd.t85 82.507566869678172
rmesh_equiv_1668 vgnd vgnd.t88 163.23952999942915
rmesh_equiv_1669 vgnd vgnd.t9 193.28275267625705
rmesh_equiv_167 bias_source__vcm_buffer__pre.n6 bias_source__vcm_buffer__pre.n7 19.4712
rmesh_equiv_1670 vgnd vgnd.t90 109.05612969370169
rmesh_equiv_1671 vgnd vgnd.t92 101.29617468815557
rmesh_equiv_1672 vgnd vgnd.t93 308.54009094349306
rmesh_equiv_1673 vgnd vgnd.t94 94.262099448823591
rmesh_equiv_1674 vgnd vgnd.t95 169.24812863336376
rmesh_equiv_1675 vgnd vgnd.t96 363.09120444099955
rmesh_equiv_1676 vgnd vgnd.t97 165.31798723924112
rmesh_equiv_1677 vgnd vgnd.t99 102.25452259565392
rmesh_equiv_1678 vgnd.n10543 vgnd.n10545 396.58392808648762
rmesh_equiv_1679 vgnd.n10543 vgnd.n630 63287.115080218304
rmesh_equiv_168 bias_source__vcm_buffer__pre.n8 bias_source__vcm_buffer__pre.t2 174.857
rmesh_equiv_1680 vgnd.n10543 vgnd.n632 377.51748986587711
rmesh_equiv_1681 vgnd.n10543 vgnd.n637 14439.565690563299
rmesh_equiv_1682 vgnd.n10543 vgnd.n748 617397278.82906234
rmesh_equiv_1683 vgnd.n10543 vgnd.t0 7591.3537281454255
rmesh_equiv_1684 vgnd.n10543 vgnd.t34 2424658.1719492329
rmesh_equiv_1685 vgnd.n10543 vgnd.t78 3931.1849147565099
rmesh_equiv_1686 vgnd.n10545 vgnd.n630 16884.940552212654
rmesh_equiv_1687 vgnd.n10545 vgnd.n632 322.51177431299845
rmesh_equiv_1688 vgnd.n10545 vgnd.n637 317.32904011825315
rmesh_equiv_1689 vgnd.n10545 vgnd.n748 252359913.87292454
rmesh_equiv_169 bias_source__vcm_buffer__pre.n9 bias_source__vcm_buffer__pre.t2 174.857
rmesh_equiv_1690 vgnd.n10545 vgnd.t0 3102.9507882623752
rmesh_equiv_1691 vgnd.n10545 vgnd.t34 991074.22145571699
rmesh_equiv_1692 vgnd.n10545 vgnd.t78 734.46858080394043
rmesh_equiv_1693 vgnd.n10555 vgnd.n10558 36870.206915880037
rmesh_equiv_1694 vgnd.n10555 vgnd.n10563 11173.245309151118
rmesh_equiv_1695 vgnd.n10555 vgnd.n10580 14366.402634930102
rmesh_equiv_1696 vgnd.n10555 vgnd.n10584 8745.4253067387654
rmesh_equiv_1697 vgnd.n10555 vgnd.n10589 22049.879582249647
rmesh_equiv_1698 vgnd.n10555 vgnd.n10591 765.53251583084466
rmesh_equiv_1699 vgnd.n10555 vgnd.n10593 376.96929454884679
rmesh_equiv_17 amplified.n4 amplified.n5 13.200100000000001
rmesh_equiv_170 bias_source__vcm_raw bias_source__vcm_raw.n0 17.519693782592512
rmesh_equiv_1700 vgnd.n10555 vgnd.n10597 675.30260888780015
rmesh_equiv_1701 vgnd.n10555 vgnd.n10599 22499.855453217071
rmesh_equiv_1702 vgnd.n10555 vgnd.n10601 98034.100930047382
rmesh_equiv_1703 vgnd.n10555 vgnd.n10608 6485.0408608297357
rmesh_equiv_1704 vgnd.n10555 vgnd.t128 8909.6924593396452
rmesh_equiv_1705 vgnd.n10558 vgnd.n10563 16857.861329605537
rmesh_equiv_1706 vgnd.n10558 vgnd.n10580 5188.2654481749705
rmesh_equiv_1707 vgnd.n10558 vgnd.n10584 773.54943618508287
rmesh_equiv_1708 vgnd.n10558 vgnd.n10589 357.95467880612762
rmesh_equiv_1709 vgnd.n10558 vgnd.n10591 1524.7383058356354
rmesh_equiv_171 bias_source__vcm_raw bias_source__vcm_raw.n1 4.8158000000000003
rmesh_equiv_1710 vgnd.n10558 vgnd.n10593 34447.386852490345
rmesh_equiv_1711 vgnd.n10558 vgnd.n10597 7181.8664804807859
rmesh_equiv_1712 vgnd.n10558 vgnd.n10599 10678.102486853031
rmesh_equiv_1713 vgnd.n10558 vgnd.n10601 22644.642795916465
rmesh_equiv_1714 vgnd.n10558 vgnd.n618 4722.8111619899537
rmesh_equiv_1715 vgnd.n10558 vgnd.t128 979.49592683769617
rmesh_equiv_1716 vgnd.n10563 vgnd.n10580 423.84777783973362
rmesh_equiv_1717 vgnd.n10563 vgnd.n10584 545.56825289647372
rmesh_equiv_1718 vgnd.n10563 vgnd.n10589 7270.5544276860801
rmesh_equiv_1719 vgnd.n10563 vgnd.n10591 16589.717019932497
rmesh_equiv_172 bias_source__vcm_raw bias_source__vcm_raw.n10 4.8158000000000003
rmesh_equiv_1720 vgnd.n10563 vgnd.n10593 1167.3973084086754
rmesh_equiv_1721 vgnd.n10563 vgnd.n618 1293.3480619752336
rmesh_equiv_1722 vgnd.n10563 vgnd.t128 8421.2869173765612
rmesh_equiv_1723 vgnd.n10580 vgnd.n10584 1688.7542589498369
rmesh_equiv_1724 vgnd.n10580 vgnd.n10589 578.08879387674335
rmesh_equiv_1725 vgnd.n10580 vgnd.n10591 21330.826247294695
rmesh_equiv_1726 vgnd.n10580 vgnd.n10593 110.69741612476514
rmesh_equiv_1727 vgnd.n10580 vgnd.n618 418.81095235442848
rmesh_equiv_1728 vgnd.n10580 vgnd.t128 10827.973002634515
rmesh_equiv_1729 vgnd.n10584 vgnd.n10589 1242.4574872579303
rmesh_equiv_173 bias_source__vcm_raw bias_source__vcm_raw.n11 4.8158000000000003
rmesh_equiv_1730 vgnd.n10584 vgnd.n10591 12984.958894523295
rmesh_equiv_1731 vgnd.n10584 vgnd.n10593 2190.3633693131251
rmesh_equiv_1732 vgnd.n10584 vgnd.n618 564.64279412857195
rmesh_equiv_1733 vgnd.n10584 vgnd.t128 192.0378029286808
rmesh_equiv_1734 vgnd.n10589 vgnd.n10591 1360.2943953347958
rmesh_equiv_1735 vgnd.n10589 vgnd.n10597 1660.4328877655012
rmesh_equiv_1736 vgnd.n10589 vgnd.n10599 756.39626287053704
rmesh_equiv_1737 vgnd.n10589 vgnd.n10601 175.54023166265264
rmesh_equiv_1738 vgnd.n10589 vgnd.n618 772.78642150706173
rmesh_equiv_1739 vgnd.n10591 vgnd.n10593 2032.233396872499
rmesh_equiv_174 bias_source__vcm_raw bias_source__vcm_raw.n13 4.8158000000000003
rmesh_equiv_1740 vgnd.n10591 vgnd.n10597 262.70246824174558
rmesh_equiv_1741 vgnd.n10591 vgnd.n10599 6617.8115058109506
rmesh_equiv_1742 vgnd.n10591 vgnd.n10601 14034.139288726758
rmesh_equiv_1743 vgnd.n10591 vgnd.t128 57.955579571446137
rmesh_equiv_1744 vgnd.n10593 vgnd.n10597 1803.4281700240495
rmesh_equiv_1745 vgnd.n10593 vgnd.n10599 23582.568770369326
rmesh_equiv_1746 vgnd.n10593 vgnd.n10601 105218.46212865131
rmesh_equiv_1747 vgnd.n10593 vgnd.n10608 2285.9076179467384
rmesh_equiv_1748 vgnd.n10593 vgnd.t128 3427.697533530898
rmesh_equiv_1749 vgnd.n10597 vgnd.n10599 627.0095784982999
rmesh_equiv_175 bias_source__vcm_raw bias_source__vcm_raw.n2 4.8158000000000003
rmesh_equiv_1750 vgnd.n10597 vgnd.n10601 5719.3005474907086
rmesh_equiv_1751 vgnd.n10597 vgnd.n10608 367.05457163549693
rmesh_equiv_1752 vgnd.n10599 vgnd.n10601 803.60933813001338
rmesh_equiv_1753 vgnd.n10599 vgnd.n10608 1135.9697952690883
rmesh_equiv_1754 vgnd.n10601 vgnd.n10608 878.51314191516508
rmesh_equiv_1755 vgnd.n10608 vgnd.n10716 1277722.005106577
rmesh_equiv_1756 vgnd.n10608 vgnd.n11077 27056287.666966494
rmesh_equiv_1757 vgnd.n10608 vgnd.n618 1644917.4434797037
rmesh_equiv_1758 vgnd.n10608 vgnd.n637 11134.334923039358
rmesh_equiv_1759 vgnd.n10608 vgnd.t13 52327.628760220738
rmesh_equiv_176 bias_source__vcm_raw bias_source__vcm_raw.n3 4.8158000000000003
rmesh_equiv_1760 vgnd.n10608 vgnd.t63 3777988.9844489517
rmesh_equiv_1761 vgnd.n10716 vgnd.n10781 86226.604370099318
rmesh_equiv_1762 vgnd.n10716 vgnd.n11077 40416532.518628001
rmesh_equiv_1763 vgnd.n10716 vgnd.n11543 1581119.8177858698
rmesh_equiv_1764 vgnd.n10716 vgnd.n11545 1581119.8177858698
rmesh_equiv_1765 vgnd.n10716 vgnd.n59 146023.03695637736
rmesh_equiv_1766 vgnd.n10716 vgnd.n618 108625.45301374844
rmesh_equiv_1767 vgnd.n10716 vgnd.n637 16632.407780012716
rmesh_equiv_1768 vgnd.n10716 vgnd.n70 76439.914494614161
rmesh_equiv_1769 vgnd.n10716 vgnd.t13 28.010587498128626
rmesh_equiv_177 bias_source__vcm_raw bias_source__vcm_raw.n4 4.8158000000000003
rmesh_equiv_1770 vgnd.n10716 vgnd.t63 5643539.0000463845
rmesh_equiv_1771 vgnd.n10781 vgnd.n11490 1411827.6638726622
rmesh_equiv_1772 vgnd.n10781 vgnd.n11501 450822.04530408769
rmesh_equiv_1773 vgnd.n10781 vgnd.n11543 4963031600.3991537
rmesh_equiv_1774 vgnd.n10781 vgnd.n11545 4963031600.3991537
rmesh_equiv_1775 vgnd.n10781 vgnd.n59 458356753.64288074
rmesh_equiv_1776 vgnd.n10781 vgnd.n70 239939887.47787473
rmesh_equiv_1777 vgnd.n10781 vgnd.n96 52282028.478392847
rmesh_equiv_1778 vgnd.n10781 vgnd.t107 7573.175463260618
rmesh_equiv_1779 vgnd.n10781 vgnd.t9 73.985093856000987
rmesh_equiv_178 bias_source__vcm_raw bias_source__vcm_raw.n5 4.8158000000000003
rmesh_equiv_1780 vgnd.n10978 vgnd.n10981 36870.206915880037
rmesh_equiv_1781 vgnd.n10978 vgnd.n10986 11173.245309151118
rmesh_equiv_1782 vgnd.n10978 vgnd.n11003 14366.402634930102
rmesh_equiv_1783 vgnd.n10978 vgnd.n11007 8745.4253067387654
rmesh_equiv_1784 vgnd.n10978 vgnd.n11012 22049.879582249647
rmesh_equiv_1785 vgnd.n10978 vgnd.n11014 765.53251583084466
rmesh_equiv_1786 vgnd.n10978 vgnd.n11016 376.96929454884679
rmesh_equiv_1787 vgnd.n10978 vgnd.n11020 675.30260888780015
rmesh_equiv_1788 vgnd.n10978 vgnd.n11022 22499.855453217071
rmesh_equiv_1789 vgnd.n10978 vgnd.n11024 98034.100930047382
rmesh_equiv_179 bias_source__vcm_raw bias_source__vcm_raw.n6 4.8158000000000003
rmesh_equiv_1790 vgnd.n10978 vgnd.n11031 6485.0408608297357
rmesh_equiv_1791 vgnd.n10978 vgnd.t91 8909.6924593396452
rmesh_equiv_1792 vgnd.n10981 vgnd.n10986 16857.861329605537
rmesh_equiv_1793 vgnd.n10981 vgnd.n11003 5188.2654481749705
rmesh_equiv_1794 vgnd.n10981 vgnd.n11007 773.54943618508287
rmesh_equiv_1795 vgnd.n10981 vgnd.n11012 357.95467880612762
rmesh_equiv_1796 vgnd.n10981 vgnd.n11014 1524.7383058356354
rmesh_equiv_1797 vgnd.n10981 vgnd.n11016 34447.386852490345
rmesh_equiv_1798 vgnd.n10981 vgnd.n11020 7181.8664804807859
rmesh_equiv_1799 vgnd.n10981 vgnd.n11022 10678.102486853031
rmesh_equiv_18 amplified.n4 amplified.t2 0.71462499999999995
rmesh_equiv_180 bias_source__vcm_raw bias_source__vcm_raw.n7 4.8158000000000003
rmesh_equiv_1800 vgnd.n10981 vgnd.n11024 22644.642795916465
rmesh_equiv_1801 vgnd.n10981 vgnd.n96 4722.8111619899537
rmesh_equiv_1802 vgnd.n10981 vgnd.t91 979.49592683769617
rmesh_equiv_1803 vgnd.n10986 vgnd.n11003 423.84777783973362
rmesh_equiv_1804 vgnd.n10986 vgnd.n11007 545.56825289647372
rmesh_equiv_1805 vgnd.n10986 vgnd.n11012 7270.5544276860801
rmesh_equiv_1806 vgnd.n10986 vgnd.n11014 16589.717019932497
rmesh_equiv_1807 vgnd.n10986 vgnd.n11016 1167.3973084086754
rmesh_equiv_1808 vgnd.n10986 vgnd.n96 1293.3480619752336
rmesh_equiv_1809 vgnd.n10986 vgnd.t91 8421.2869173765612
rmesh_equiv_181 bias_source__vcm_raw bias_source__vcm_raw.n8 4.8158000000000003
rmesh_equiv_1810 vgnd.n11003 vgnd.n11007 1688.7542589498369
rmesh_equiv_1811 vgnd.n11003 vgnd.n11012 578.08879387674335
rmesh_equiv_1812 vgnd.n11003 vgnd.n11014 21330.826247294695
rmesh_equiv_1813 vgnd.n11003 vgnd.n11016 110.69741612476514
rmesh_equiv_1814 vgnd.n11003 vgnd.n96 418.81095235442848
rmesh_equiv_1815 vgnd.n11003 vgnd.t91 10827.973002634515
rmesh_equiv_1816 vgnd.n11007 vgnd.n11012 1242.4574872579303
rmesh_equiv_1817 vgnd.n11007 vgnd.n11014 12984.958894523295
rmesh_equiv_1818 vgnd.n11007 vgnd.n11016 2190.3633693131251
rmesh_equiv_1819 vgnd.n11007 vgnd.n96 564.64279412857195
rmesh_equiv_182 bias_source__vcm_raw bias_source__vcm_raw.n9 4.8158000000000003
rmesh_equiv_1820 vgnd.n11007 vgnd.t91 192.0378029286808
rmesh_equiv_1821 vgnd.n11012 vgnd.n11014 1360.2943953347958
rmesh_equiv_1822 vgnd.n11012 vgnd.n11020 1660.4328877655012
rmesh_equiv_1823 vgnd.n11012 vgnd.n11022 756.39626287053704
rmesh_equiv_1824 vgnd.n11012 vgnd.n11024 175.54023166265264
rmesh_equiv_1825 vgnd.n11012 vgnd.n96 772.78642150706173
rmesh_equiv_1826 vgnd.n11014 vgnd.n11016 2032.233396872499
rmesh_equiv_1827 vgnd.n11014 vgnd.n11020 262.70246824174558
rmesh_equiv_1828 vgnd.n11014 vgnd.n11022 6617.8115058109506
rmesh_equiv_1829 vgnd.n11014 vgnd.n11024 14034.139288726758
rmesh_equiv_183 bias_source__vcm_raw bias_source__vcm_raw.t10 0.00141837
rmesh_equiv_1830 vgnd.n11014 vgnd.t91 57.955579571446137
rmesh_equiv_1831 vgnd.n11016 vgnd.n11020 1803.4281700240495
rmesh_equiv_1832 vgnd.n11016 vgnd.n11022 23582.568770369326
rmesh_equiv_1833 vgnd.n11016 vgnd.n11024 105218.46212865131
rmesh_equiv_1834 vgnd.n11016 vgnd.n11031 2285.9076179467384
rmesh_equiv_1835 vgnd.n11016 vgnd.t91 3427.697533530898
rmesh_equiv_1836 vgnd.n11020 vgnd.n11022 627.0095784982999
rmesh_equiv_1837 vgnd.n11020 vgnd.n11024 5719.3005474907086
rmesh_equiv_1838 vgnd.n11020 vgnd.n11031 367.05457163549693
rmesh_equiv_1839 vgnd.n11022 vgnd.n11024 803.60933813001338
rmesh_equiv_184 bias_source__vcm_raw bias_source__vcm_raw.t11 212.21199999999999
rmesh_equiv_1840 vgnd.n11022 vgnd.n11031 1135.9697952690883
rmesh_equiv_1841 vgnd.n11024 vgnd.n11031 878.51314191516508
rmesh_equiv_1842 vgnd.n11031 vgnd.n11038 548282.27139649435
rmesh_equiv_1843 vgnd.n11031 vgnd.n11406 9154453.9245641977
rmesh_equiv_1844 vgnd.n11031 vgnd.n359 108740.59536351952
rmesh_equiv_1845 vgnd.n11031 vgnd.n412 109975.47186179359
rmesh_equiv_1846 vgnd.n11031 vgnd.t21 47692.513039758138
rmesh_equiv_1847 vgnd.n11031 vgnd.t43 1209.1230871911489
rmesh_equiv_1848 vgnd.n11038 vgnd.n11043 62990.08611180351
rmesh_equiv_1849 vgnd.n11038 vgnd.n11077 1999452.2008360461
rmesh_equiv_185 bias_source__vcm_raw bias_source__vcm_raw.t12 0.00141837
rmesh_equiv_1850 vgnd.n11038 vgnd.n11406 4071027.7626040848
rmesh_equiv_1851 vgnd.n11038 vgnd.n348 604.1825396298284
rmesh_equiv_1852 vgnd.n11038 vgnd.n355 107530.95067794902
rmesh_equiv_1853 vgnd.n11038 vgnd.n359 356.98124181763524
rmesh_equiv_1854 vgnd.n11038 vgnd.n412 70191.050861836949
rmesh_equiv_1855 vgnd.n11038 vgnd.n55 6025990.2311643269
rmesh_equiv_1856 vgnd.n11038 vgnd.t21 21209.079891945134
rmesh_equiv_1857 vgnd.n11038 vgnd.t43 515.6945908240881
rmesh_equiv_1858 vgnd.n11043 vgnd.n11077 95454.524877080912
rmesh_equiv_1859 vgnd.n11043 vgnd.n348 273.13650613969054
rmesh_equiv_186 bias_source__vcm_raw bias_source__vcm_raw.t13 0.00141837
rmesh_equiv_1860 vgnd.n11043 vgnd.n355 348.93976835934427
rmesh_equiv_1861 vgnd.n11043 vgnd.n359 1170.2585925037934
rmesh_equiv_1862 vgnd.n11043 vgnd.n412 14068.078464590937
rmesh_equiv_1863 vgnd.n11043 vgnd.n55 287682.81341719785
rmesh_equiv_1864 vgnd.n11043 vgnd.t43 7865.1405225721519
rmesh_equiv_1865 vgnd.n11077 vgnd.n348 3516.9250296525943
rmesh_equiv_1866 vgnd.n11077 vgnd.n355 66415.523156964147
rmesh_equiv_1867 vgnd.n11077 vgnd.n359 102473.98856868516
rmesh_equiv_1868 vgnd.n11077 vgnd.n55 279780.47899019334
rmesh_equiv_1869 vgnd.n11077 vgnd.n618 52031552.308837742
rmesh_equiv_187 bias_source__vcm_raw bias_source__vcm_raw.t14 0.00141837
rmesh_equiv_1870 vgnd.n11077 vgnd.n637 220912.78580754041
rmesh_equiv_1871 vgnd.n11077 vgnd.t13 1655212.4021952241
rmesh_equiv_1872 vgnd.n11077 vgnd.t63 226.29685192968714
rmesh_equiv_1873 vgnd.n11227 vgnd.n11273 19009.45298427486
rmesh_equiv_1874 vgnd.n11227 vgnd.n11433 19620.567552182525
rmesh_equiv_1875 vgnd.n11227 vgnd.n11490 4282.5805811895207
rmesh_equiv_1876 vgnd.n11227 vgnd.n196 44545.703452018708
rmesh_equiv_1877 vgnd.n11227 vgnd.n203 4703.1457140027032
rmesh_equiv_1878 vgnd.n11227 vgnd.n209 27508.340747601535
rmesh_equiv_1879 vgnd.n11227 vgnd.n273 51738.167661334555
rmesh_equiv_188 bias_source__vcm_raw bias_source__vcm_raw.t15 0.00141837
rmesh_equiv_1880 vgnd.n11227 vgnd.n5675 63252129.041102804
rmesh_equiv_1881 vgnd.n11227 vgnd.n6073 4711234.7300823461
rmesh_equiv_1882 vgnd.n11227 vgnd.n6100 10310541.249898845
rmesh_equiv_1883 vgnd.n11227 vgnd.n6322 98428369.347366706
rmesh_equiv_1884 vgnd.n11227 vgnd.n6960 26993.677622607298
rmesh_equiv_1885 vgnd.n11227 vgnd.t26 24277.77932828516
rmesh_equiv_1886 vgnd.n11227 vgnd.t35 432.43565839305927
rmesh_equiv_1887 vgnd.n11227 vgnd.t53 131621.30119819875
rmesh_equiv_1888 vgnd.n11227 vgnd.t55 1352.2797425901249
rmesh_equiv_1889 vgnd.n11273 vgnd.n11319 930.57463345244435
rmesh_equiv_189 bias_source__vcm_raw bias_source__vcm_raw.t2 0.00141837
rmesh_equiv_1890 vgnd.n11273 vgnd.n11321 5876.7972130830558
rmesh_equiv_1891 vgnd.n11273 vgnd.n196 65954.617700016694
rmesh_equiv_1892 vgnd.n11273 vgnd.n202 3958.0480375294428
rmesh_equiv_1893 vgnd.n11273 vgnd.n203 477.84300164576456
rmesh_equiv_1894 vgnd.n11273 vgnd.n209 679340.80122982454
rmesh_equiv_1895 vgnd.n11273 vgnd.n273 1277716.0424071949
rmesh_equiv_1896 vgnd.n11273 vgnd.t35 350.13965770323614
rmesh_equiv_1897 vgnd.n11319 vgnd.n11321 2217.543439288896
rmesh_equiv_1898 vgnd.n11319 vgnd.n11406 934.77501706145529
rmesh_equiv_1899 vgnd.n11319 vgnd.n197 2128.2587220066875
rmesh_equiv_19 amplified.n5 amplified.n6 0.27270899999999998
rmesh_equiv_190 bias_source__vcm_raw bias_source__vcm_raw.t3 0.00141837
rmesh_equiv_1900 vgnd.n11319 vgnd.n198 52431.128488110284
rmesh_equiv_1901 vgnd.n11319 vgnd.n202 424.7941411898471
rmesh_equiv_1902 vgnd.n11319 vgnd.n203 80.593074724705744
rmesh_equiv_1903 vgnd.n11319 vgnd.n465 97430.70456795377
rmesh_equiv_1904 vgnd.n11319 vgnd.t134 514.347515048069
rmesh_equiv_1905 vgnd.n11319 vgnd.t35 2792.9659607559197
rmesh_equiv_1906 vgnd.n11321 vgnd.n11414 2809.5306266368502
rmesh_equiv_1907 vgnd.n11321 vgnd.n158 1495.5932919322188
rmesh_equiv_1908 vgnd.n11321 vgnd.n196 1949.563572447486
rmesh_equiv_1909 vgnd.n11321 vgnd.n197 5915.9877715736029
rmesh_equiv_191 bias_source__vcm_raw bias_source__vcm_raw.t4 0.00141837
rmesh_equiv_1910 vgnd.n11321 vgnd.n198 808.02902338216859
rmesh_equiv_1911 vgnd.n11321 vgnd.n202 777.76128597665763
rmesh_equiv_1912 vgnd.n11321 vgnd.n203 27978.392851123463
rmesh_equiv_1913 vgnd.n11321 vgnd.n463 1597.9439219109629
rmesh_equiv_1914 vgnd.n11321 vgnd.t134 10.947487072990056
rmesh_equiv_1915 vgnd.n11321 vgnd.t35 6.2011046774825429
rmesh_equiv_1916 vgnd.n114 vgnd.n11569 84.54036579922122
rmesh_equiv_1917 vgnd.n114 vgnd.n5313 13.514750730358536
rmesh_equiv_1918 vgnd.n114 vgnd.t12 3454.2008497024581
rmesh_equiv_1919 vgnd.n114 vgnd.t135 204.26280075577114
rmesh_equiv_192 bias_source__vcm_raw bias_source__vcm_raw.t5 0.00141837
rmesh_equiv_1920 vgnd.n114 vgnd.t28 4538.958616676221
rmesh_equiv_1921 vgnd.n114 vgnd.t38 779.3526851822196
rmesh_equiv_1922 vgnd.n114 vgnd.t54 1138.9273087217823
rmesh_equiv_1923 vgnd.n114 vgnd.t58 1695.2228377364556
rmesh_equiv_1924 vgnd.n114 vgnd.t74 5306.9267630138829
rmesh_equiv_1925 vgnd.n114 vgnd.t92 1233.7646412823426
rmesh_equiv_1926 vgnd.n11406 vgnd.n11414 57210.249100618486
rmesh_equiv_1927 vgnd.n11406 vgnd.n11420 9462.397127184071
rmesh_equiv_1928 vgnd.n11406 vgnd.n151 727.51949247660059
rmesh_equiv_1929 vgnd.n11406 vgnd.n154 6527.487918085656
rmesh_equiv_193 bias_source__vcm_raw bias_source__vcm_raw.t6 0.00141837
rmesh_equiv_1930 vgnd.n11406 vgnd.n197 800.75798341837651
rmesh_equiv_1931 vgnd.n11406 vgnd.n198 6056.3550932274975
rmesh_equiv_1932 vgnd.n11406 vgnd.n202 4592.8856124941112
rmesh_equiv_1933 vgnd.n11406 vgnd.n359 573205.45116364991
rmesh_equiv_1934 vgnd.n11406 vgnd.n412 1181989.5862917847
rmesh_equiv_1935 vgnd.n11406 vgnd.n465 1383.7734539529877
rmesh_equiv_1936 vgnd.n11406 vgnd.t134 14.75350439783556
rmesh_equiv_1937 vgnd.n11406 vgnd.t21 118.64652396850265
rmesh_equiv_1938 vgnd.n11406 vgnd.t43 34133.0640329284
rmesh_equiv_1939 vgnd.n11414 vgnd.n11420 31082.27385574043
rmesh_equiv_194 bias_source__vcm_raw bias_source__vcm_raw.t7 0.00141837
rmesh_equiv_1940 vgnd.n11414 vgnd.n127 11091.0074718551
rmesh_equiv_1941 vgnd.n11414 vgnd.n151 22025.139825376391
rmesh_equiv_1942 vgnd.n11414 vgnd.n153 6920.5656236561017
rmesh_equiv_1943 vgnd.n11414 vgnd.n154 783.03326503232961
rmesh_equiv_1944 vgnd.n11414 vgnd.n157 1165.0512151299174
rmesh_equiv_1945 vgnd.n11414 vgnd.n158 434.40809767273186
rmesh_equiv_1946 vgnd.n11414 vgnd.n463 27815.106324134667
rmesh_equiv_1947 vgnd.n11414 vgnd.n465 956258.39210954914
rmesh_equiv_1948 vgnd.n11414 vgnd.t134 1128.0973062432392
rmesh_equiv_1949 vgnd.n11414 vgnd.t35 2089.2412640934713
rmesh_equiv_195 bias_source__vcm_raw bias_source__vcm_raw.t8 0.00141837
rmesh_equiv_1950 vgnd.n11420 vgnd.n11424 1171.931184123895
rmesh_equiv_1951 vgnd.n11420 vgnd.n11426 92606.807251221515
rmesh_equiv_1952 vgnd.n11420 vgnd.n121 38861.717063202748
rmesh_equiv_1953 vgnd.n11420 vgnd.n122 116637.02086029359
rmesh_equiv_1954 vgnd.n11420 vgnd.n127 59263.636387082093
rmesh_equiv_1955 vgnd.n11420 vgnd.n146 3365.6465098187396
rmesh_equiv_1956 vgnd.n11420 vgnd.n151 406.90341607511311
rmesh_equiv_1957 vgnd.n11420 vgnd.n153 795.3127157965497
rmesh_equiv_1958 vgnd.n11420 vgnd.n154 730.95004143261065
rmesh_equiv_1959 vgnd.n11420 vgnd.n157 22799.644454521291
rmesh_equiv_196 bias_source__vcm_raw bias_source__vcm_raw.t9 212.21199999999999
rmesh_equiv_1960 vgnd.n11420 vgnd.n158 72023.255321748147
rmesh_equiv_1961 vgnd.n11420 vgnd.n465 158162.16158103105
rmesh_equiv_1962 vgnd.n11420 vgnd.t134 10066.848331487821
rmesh_equiv_1963 vgnd.n11424 vgnd.n11426 911.68069159920583
rmesh_equiv_1964 vgnd.n11424 vgnd.n121 2936.9674663588316
rmesh_equiv_1965 vgnd.n11424 vgnd.n122 5054.0089330676974
rmesh_equiv_1966 vgnd.n11424 vgnd.n127 9405.2905002070729
rmesh_equiv_1967 vgnd.n11424 vgnd.n146 936.95145990650872
rmesh_equiv_1968 vgnd.n11424 vgnd.n151 742.06971981391268
rmesh_equiv_1969 vgnd.n11424 vgnd.n153 1869.2356904405103
rmesh_equiv_197 bias_source__vcm_raw.n0 bias_source__vcm_raw.n1 1.9329800000000001
rmesh_equiv_1970 vgnd.n11424 vgnd.t134 1002.1666615073635
rmesh_equiv_1971 vgnd.n11426 vgnd.n11433 44523.10551433661
rmesh_equiv_1972 vgnd.n11426 vgnd.n121 5208.4524223390526
rmesh_equiv_1973 vgnd.n11426 vgnd.n122 120.61880141963879
rmesh_equiv_1974 vgnd.n11426 vgnd.n123 13578.064848793832
rmesh_equiv_1975 vgnd.n11426 vgnd.n127 917.44486993968064
rmesh_equiv_1976 vgnd.n11426 vgnd.n141 5385.5116749172466
rmesh_equiv_1977 vgnd.n11426 vgnd.n146 3992.4317735516051
rmesh_equiv_1978 vgnd.n11426 vgnd.n151 6527.2384937523311
rmesh_equiv_1979 vgnd.n11426 vgnd.n153 362679.61297572241
rmesh_equiv_198 bias_source__vcm_raw.n1 bias_source__vcm_raw.n2 2.7844699999999998
rmesh_equiv_1980 vgnd.n11426 vgnd.n157 3397.1329463123179
rmesh_equiv_1981 vgnd.n11426 vgnd.t134 213.5694245415385
rmesh_equiv_1982 vgnd.n11433 vgnd.n11490 3898.4904319665711
rmesh_equiv_1983 vgnd.n11433 vgnd.n121 617.15149906763656
rmesh_equiv_1984 vgnd.n11433 vgnd.n122 236.89302408624192
rmesh_equiv_1985 vgnd.n11433 vgnd.n123 401.03099985807438
rmesh_equiv_1986 vgnd.n11433 vgnd.n127 26637.033313631102
rmesh_equiv_1987 vgnd.n11433 vgnd.n141 610.53374213827362
rmesh_equiv_1988 vgnd.n11433 vgnd.n146 540.59360374645917
rmesh_equiv_1989 vgnd.n11433 vgnd.n157 10435.86229210752
rmesh_equiv_199 bias_source__vcm_raw.n10 bias_source__vcm_raw.n11 2.7844699999999998
rmesh_equiv_1990 vgnd.n11433 vgnd.n6960 158767.44822333037
rmesh_equiv_1991 vgnd.n11433 vgnd.t134 168.274
rmesh_equiv_1992 vgnd.n11433 vgnd.t37 17074.10409563034
rmesh_equiv_1993 vgnd.n11433 vgnd.t53 9503.7835816095576
rmesh_equiv_1994 vgnd.n11433 vgnd.t55 7952.9658309748511
rmesh_equiv_1995 vgnd.n11433 vgnd.t96 17074.104095630344
rmesh_equiv_1996 vgnd.n11490 vgnd.n11501 2688632.8187490539
rmesh_equiv_1997 vgnd.n11490 vgnd.n121 160905.91300511512
rmesh_equiv_1998 vgnd.n11490 vgnd.n123 56048.24755853862
rmesh_equiv_1999 vgnd.n11490 vgnd.n141 18264.267523560538
rmesh_equiv_2 amplified amplified.n2 20.764887017375738
rmesh_equiv_20 amplified.n6 amplified.n7 25.304500000000001
rmesh_equiv_200 bias_source__vcm_raw.n10 bias_source__vcm_raw.n9 2.7844699999999998
rmesh_equiv_2000 vgnd.n11490 vgnd.n146 20324.547282442414
rmesh_equiv_2001 vgnd.n11490 vgnd.n6960 10308.493290599539
rmesh_equiv_2002 vgnd.n11490 vgnd.n96 9653.6723408480411
rmesh_equiv_2003 vgnd.n11490 vgnd.t107 2064.6678633962006
rmesh_equiv_2004 vgnd.n11490 vgnd.t53 44733.06518559574
rmesh_equiv_2005 vgnd.n11490 vgnd.t55 516.37218980587272
rmesh_equiv_2006 vgnd.n11490 vgnd.t9 174657.52398848694
rmesh_equiv_2007 vgnd.n11501 vgnd.n11533 17721.778400042578
rmesh_equiv_2008 vgnd.n11501 vgnd.n11539 47827.628585891027
rmesh_equiv_2009 vgnd.n11501 vgnd.n67 627.10614632649992
rmesh_equiv_201 bias_source__vcm_raw.n11 bias_source__vcm_raw.n13 2.7844699999999998
rmesh_equiv_2010 vgnd.n11501 vgnd.n69 28046.070301956253
rmesh_equiv_2011 vgnd.n11501 vgnd.n72 467.58591392796575
rmesh_equiv_2012 vgnd.n11501 vgnd.n96 99563977.385314852
rmesh_equiv_2013 vgnd.n11501 vgnd.t107 14422.077576250154
rmesh_equiv_2014 vgnd.n11501 vgnd.t110 637.80439688011154
rmesh_equiv_2015 vgnd.n11501 vgnd.t9 55771.298584881122
rmesh_equiv_2016 vgnd.n11533 vgnd.n11539 57566.451719680867
rmesh_equiv_2017 vgnd.n11533 vgnd.n11545 11219.026015873642
rmesh_equiv_2018 vgnd.n11533 vgnd.n63 1168.6924795597959
rmesh_equiv_2019 vgnd.n11533 vgnd.n67 17126.650863688341
rmesh_equiv_202 bias_source__vcm_raw.n12 bias_source__vcm_raw.n13 2.98813
rmesh_equiv_2020 vgnd.n11533 vgnd.n69 678.95306945050834
rmesh_equiv_2021 vgnd.n11533 vgnd.n70 6578.8248688852791
rmesh_equiv_2022 vgnd.n11533 vgnd.n72 422.73816571667447
rmesh_equiv_2023 vgnd.n11533 vgnd.t110 635.18250521010441
rmesh_equiv_2024 vgnd.n11539 vgnd.n11543 1246.4325845872922
rmesh_equiv_2025 vgnd.n11539 vgnd.n11545 124560.14542784495
rmesh_equiv_2026 vgnd.n11539 vgnd.n57 1602.6455941866429
rmesh_equiv_2027 vgnd.n11539 vgnd.n63 47920.229032340634
rmesh_equiv_2028 vgnd.n11539 vgnd.n67 441.71430186317968
rmesh_equiv_2029 vgnd.n11539 vgnd.n69 687.80032540751176
rmesh_equiv_203 bias_source__vcm_raw.n12 bias_source__vcm_raw.t0 24.2681
rmesh_equiv_2030 vgnd.n11539 vgnd.n70 758.67640125713854
rmesh_equiv_2031 vgnd.n11539 vgnd.n72 56831.879823806994
rmesh_equiv_2032 vgnd.n11539 vgnd.t110 5218.6101231262792
rmesh_equiv_2033 vgnd.n11543 vgnd.n11545 13334.837511603335
rmesh_equiv_2034 vgnd.n11543 vgnd.n55 9602.3171583840412
rmesh_equiv_2035 vgnd.n11543 vgnd.n57 444.94459142653227
rmesh_equiv_2036 vgnd.n11543 vgnd.n59 662.02541919236796
rmesh_equiv_2037 vgnd.n11543 vgnd.n63 158248.68122339304
rmesh_equiv_2038 vgnd.n11543 vgnd.n67 1602.6455941866429
rmesh_equiv_2039 vgnd.n11543 vgnd.n70 766.87126219231106
rmesh_equiv_204 bias_source__vcm_raw.n12 bias_source__vcm_raw.t1 24.1739
rmesh_equiv_2040 vgnd.n11545 vgnd.n55 6584.0187642440969
rmesh_equiv_2041 vgnd.n11545 vgnd.n57 85270.180829422257
rmesh_equiv_2042 vgnd.n11545 vgnd.n59 634.41199763355758
rmesh_equiv_2043 vgnd.n11545 vgnd.n63 373.33167996316189
rmesh_equiv_2044 vgnd.n11545 vgnd.n69 6900.4511174753943
rmesh_equiv_2045 vgnd.n11545 vgnd.n70 696.16524932873438
rmesh_equiv_2046 vgnd.n11545 vgnd.n72 14425.266827695008
rmesh_equiv_2047 vgnd.n11566 vgnd.n11569 24.624897448532092
rmesh_equiv_2048 vgnd.n11566 vgnd.n3805 138.94118715780485
rmesh_equiv_2049 vgnd.n11566 vgnd.t109 6076.4843641838206
rmesh_equiv_205 bias_source__vcm_raw.n2 bias_source__vcm_raw.n3 2.7844699999999998
rmesh_equiv_2050 vgnd.n11566 vgnd.t11 23.579026268483418
rmesh_equiv_2051 vgnd.n11566 vgnd.t126 11.871529082122571
rmesh_equiv_2052 vgnd.n11566 vgnd.t127 6.07212
rmesh_equiv_2053 vgnd.n11566 vgnd.t56 7211.368143907187
rmesh_equiv_2054 vgnd.n11566 vgnd.t80 11.670382505869254
rmesh_equiv_2055 vgnd.n11566 vgnd.t86 21.74856982583448
rmesh_equiv_2056 vgnd.n11569 vgnd.n7044 967.52614098007314
rmesh_equiv_2057 vgnd.n11569 vgnd.n7109 11080.985479366331
rmesh_equiv_2058 vgnd.n11569 vgnd.t129 15391.92037307067
rmesh_equiv_2059 vgnd.n11569 vgnd.t135 12716.623632089781
rmesh_equiv_206 bias_source__vcm_raw.n3 bias_source__vcm_raw.n4 2.7844699999999998
rmesh_equiv_2060 vgnd.n11569 vgnd.t28 3352.4493164155401
rmesh_equiv_2061 vgnd.n11569 vgnd.t31 95790.9551714431
rmesh_equiv_2062 vgnd.n11569 vgnd.t46 1783013.6053894595
rmesh_equiv_2063 vgnd.n11569 vgnd.t64 17910.263684204187
rmesh_equiv_2064 vgnd.n11569 vgnd.t74 2867.2124203676044
rmesh_equiv_2065 vgnd.n11569 vgnd.t80 53.699746197725489
rmesh_equiv_2066 vgnd.n11569 vgnd.t86 21.841894100838783
rmesh_equiv_2067 vgnd.n11569 vgnd.t92 30653.630101224462
rmesh_equiv_2068 vgnd.n11574 vgnd.n11583 3654.8945636578583
rmesh_equiv_2069 vgnd.n11574 vgnd.n11589 16608.007388429229
rmesh_equiv_207 bias_source__vcm_raw.n4 bias_source__vcm_raw.n5 2.7844699999999998
rmesh_equiv_2070 vgnd.n11574 vgnd.n11610 570.13296849947062
rmesh_equiv_2071 vgnd.n11574 vgnd.n33 843.9042928262088
rmesh_equiv_2072 vgnd.n11574 vgnd.n37 348.90516725421321
rmesh_equiv_2073 vgnd.n11574 vgnd.n38 2841.0965771737801
rmesh_equiv_2074 vgnd.n11574 vgnd.n41 73839.469668311867
rmesh_equiv_2075 vgnd.n11574 vgnd.n42 626.74694085790827
rmesh_equiv_2076 vgnd.n11574 vgnd.n46 109634.74557350874
rmesh_equiv_2077 vgnd.n11574 vgnd.t73 740.91131514743881
rmesh_equiv_2078 vgnd.n11583 vgnd.n11589 13633.870412610149
rmesh_equiv_2079 vgnd.n11583 vgnd.n11610 66642.669254556109
rmesh_equiv_208 bias_source__vcm_raw.n5 bias_source__vcm_raw.n6 2.7844699999999998
rmesh_equiv_2080 vgnd.n11583 vgnd.n33 9850.1738311131649
rmesh_equiv_2081 vgnd.n11583 vgnd.n37 279536.86668784154
rmesh_equiv_2082 vgnd.n11583 vgnd.n38 382.14580502106338
rmesh_equiv_2083 vgnd.n11583 vgnd.n41 380.30457192839327
rmesh_equiv_2084 vgnd.n11583 vgnd.n42 1110.8798702219799
rmesh_equiv_2085 vgnd.n11583 vgnd.n46 1575.2784157474036
rmesh_equiv_2086 vgnd.n11583 vgnd.n7780 106947.38325021951
rmesh_equiv_2087 vgnd.n11583 vgnd.n8515 10709863.863063637
rmesh_equiv_2088 vgnd.n11583 vgnd.n9329 1995137.9503068223
rmesh_equiv_2089 vgnd.n11583 vgnd.t45 33438.29159317899
rmesh_equiv_209 bias_source__vcm_raw.n6 bias_source__vcm_raw.n7 2.7844699999999998
rmesh_equiv_2090 vgnd.n11589 vgnd.n11610 14911.981927520968
rmesh_equiv_2091 vgnd.n11589 vgnd.n33 367.62012403378725
rmesh_equiv_2092 vgnd.n11589 vgnd.n37 4687.8601184874087
rmesh_equiv_2093 vgnd.n11589 vgnd.n38 612.93827472811881
rmesh_equiv_2094 vgnd.n11589 vgnd.n41 7090.15800129952
rmesh_equiv_2095 vgnd.n11589 vgnd.n42 39147.790235289482
rmesh_equiv_2096 vgnd.n11589 vgnd.n46 2312.8447456030422
rmesh_equiv_2097 vgnd.n11589 vgnd.t73 912.80618846930702
rmesh_equiv_2098 vgnd.n11610 vgnd.n33 480.19333154501129
rmesh_equiv_2099 vgnd.n11610 vgnd.n37 9770.0137983757304
rmesh_equiv_21 amplified.n7 amplified.n8 0.61972499999999997
rmesh_equiv_210 bias_source__vcm_raw.n7 bias_source__vcm_raw.n8 2.7844699999999998
rmesh_equiv_2100 vgnd.n11610 vgnd.n38 65000.064638882439
rmesh_equiv_2101 vgnd.n11610 vgnd.n7780 10745.295054566455
rmesh_equiv_2102 vgnd.n11610 vgnd.n8515 14987040.172505699
rmesh_equiv_2103 vgnd.n11610 vgnd.n9329 200456.94713681316
rmesh_equiv_2104 vgnd.n11610 vgnd.t45 46792.473351157802
rmesh_equiv_2105 vgnd.n11610 vgnd.t73 766.70832229868222
rmesh_equiv_2106 vgnd.n121 vgnd.n122 838.33463942189871
rmesh_equiv_2107 vgnd.n121 vgnd.n123 13124.283881746327
rmesh_equiv_2108 vgnd.n121 vgnd.n127 184773.65526602851
rmesh_equiv_2109 vgnd.n121 vgnd.n141 10495.844361120009
rmesh_equiv_211 bias_source__vcm_raw.n8 bias_source__vcm_raw.n9 2.7844699999999998
rmesh_equiv_2110 vgnd.n121 vgnd.n146 380.82806291745061
rmesh_equiv_2111 vgnd.n121 vgnd.n151 2739.1042092632229
rmesh_equiv_2112 vgnd.n121 vgnd.n153 152195.64222551789
rmesh_equiv_2113 vgnd.n121 vgnd.n157 72390.659983101665
rmesh_equiv_2114 vgnd.n122 vgnd.n123 2368.0914308190622
rmesh_equiv_2115 vgnd.n122 vgnd.n127 4206.4381648664348
rmesh_equiv_2116 vgnd.n122 vgnd.n141 2513.7086085304491
rmesh_equiv_2117 vgnd.n122 vgnd.n146 3446.8486557235283
rmesh_equiv_2118 vgnd.n122 vgnd.n151 8220.968576215113
rmesh_equiv_2119 vgnd.n122 vgnd.n153 456790.06586953218
rmesh_equiv_212 bias_source_r_vcm_bottom_r0_n0.t0 bias_source_r_vcm_bottom_r0_n0.t1 46.774799999999999
rmesh_equiv_2120 vgnd.n122 vgnd.n157 2785.0944968569906
rmesh_equiv_2121 vgnd.n123 vgnd.n127 7577.6097309329389
rmesh_equiv_2122 vgnd.n123 vgnd.n141 372.09512305432355
rmesh_equiv_2123 vgnd.n123 vgnd.n146 6485.7619406644244
rmesh_equiv_2124 vgnd.n123 vgnd.n157 1934.8970026106911
rmesh_equiv_2125 vgnd.n127 vgnd.n141 1949.3981057703199
rmesh_equiv_2126 vgnd.n127 vgnd.n153 1544.8759641252734
rmesh_equiv_2127 vgnd.n127 vgnd.n154 7254.8961104397667
rmesh_equiv_2128 vgnd.n127 vgnd.n157 398.76856244030529
rmesh_equiv_2129 vgnd.n127 vgnd.n158 14260.662373284473
rmesh_equiv_213 bias_source_r_vcm_bottom_r0_n1.t0 bias_source_r_vcm_bottom_r0_n1.t1 57.421400000000006
rmesh_equiv_2130 vgnd.n127 vgnd.t134 1002.1666615073635
rmesh_equiv_2131 vgnd.n1368 vgnd.n4145 89635.60795980721
rmesh_equiv_2132 vgnd.n1368 vgnd.n4345 2994800.9289921909
rmesh_equiv_2133 vgnd.n1368 vgnd.n6887 5006.8880126327722
rmesh_equiv_2134 vgnd.n1368 vgnd.n6997 5.9276588076025716
rmesh_equiv_2135 vgnd.n1368 vgnd.n7088 367532094.7149505
rmesh_equiv_2136 vgnd.n1368 vgnd.t18 5800579.5902346019
rmesh_equiv_2137 vgnd.n1368 vgnd.t29 7585379.016329254
rmesh_equiv_2138 vgnd.n1368 vgnd.t50 12.490958404849021
rmesh_equiv_2139 vgnd.n1368 vgnd.t65 73371.46426531105
rmesh_equiv_214 bias_source_r_vcm_top_r0_n0.t0 bias_source_r_vcm_top_r0_n0.t1 45.108199999999997
rmesh_equiv_2140 vgnd.n1368 vgnd.t81 12766.789327555285
rmesh_equiv_2141 vgnd.n1368 vgnd.t83 21.271797179408754
rmesh_equiv_2142 vgnd.n1368 vgnd.t84 5221.6105742083701
rmesh_equiv_2143 vgnd.n1368 vgnd.t97 507079.81418604561
rmesh_equiv_2144 vgnd.n1387 vgnd.n1391 2438.2091797025982
rmesh_equiv_2145 vgnd.n1387 vgnd.n4405 27417.61925680796
rmesh_equiv_2146 vgnd.n1387 vgnd.n6970 11642.396956299146
rmesh_equiv_2147 vgnd.n1387 vgnd.n6974 13566.489998942101
rmesh_equiv_2148 vgnd.n1387 vgnd.n6979 393.29490032802767
rmesh_equiv_2149 vgnd.n1387 vgnd.n6983 817.3644549701728
rmesh_equiv_215 bias_source_r_vcm_top_r0_n1.t0 bias_source_r_vcm_top_r0_n1.t1 55.754800000000003
rmesh_equiv_2150 vgnd.n1387 vgnd.n6984 16938.062150581321
rmesh_equiv_2151 vgnd.n1387 vgnd.t101 27417.61925680796
rmesh_equiv_2152 vgnd.n1387 vgnd.t22 731.82657428630455
rmesh_equiv_2153 vgnd.n1391 vgnd.n4145 2339.8756274751568
rmesh_equiv_2154 vgnd.n1391 vgnd.n6966 3674.0893801657339
rmesh_equiv_2155 vgnd.n1391 vgnd.n6970 428.76531082995859
rmesh_equiv_2156 vgnd.n1391 vgnd.n6974 1199.5498250216015
rmesh_equiv_2157 vgnd.n1391 vgnd.n6979 1130.4581188543425
rmesh_equiv_2158 vgnd.n1391 vgnd.n6983 36081.414354315995
rmesh_equiv_2159 vgnd.n1391 vgnd.n6984 7092.6484531144915
rmesh_equiv_216 clk clk.n0 21.634936154989724
rmesh_equiv_2160 vgnd.n1391 vgnd.t18 21795.290883357324
rmesh_equiv_2161 vgnd.n1391 vgnd.t22 196.85523551452337
rmesh_equiv_2162 vgnd.n141 vgnd.n146 296.8917011581122
rmesh_equiv_2163 vgnd.n141 vgnd.n157 184.42882308705657
rmesh_equiv_2164 vgnd.n146 vgnd.n151 237.22205858643605
rmesh_equiv_2165 vgnd.n146 vgnd.n153 13181.011308194631
rmesh_equiv_2166 vgnd.n151 vgnd.n153 4684.877326068925
rmesh_equiv_2167 vgnd.n151 vgnd.n154 1347.8763268700136
rmesh_equiv_2168 vgnd.n151 vgnd.n465 3892.6125110544317
rmesh_equiv_2169 vgnd.n151 vgnd.t134 3175.1516871885942
rmesh_equiv_217 clk clk.n1 42.464300000000001
rmesh_equiv_2170 vgnd.n153 vgnd.n154 283.52717694511716
rmesh_equiv_2171 vgnd.n153 vgnd.n157 1430.6549683889716
rmesh_equiv_2172 vgnd.n153 vgnd.n158 8898.3665407819972
rmesh_equiv_2173 vgnd.n153 vgnd.t134 62.333799999999997
rmesh_equiv_2174 vgnd.n154 vgnd.n157 1931.9575321529703
rmesh_equiv_2175 vgnd.n154 vgnd.n158 3666.4550783096702
rmesh_equiv_2176 vgnd.n154 vgnd.n465 109105.71443387785
rmesh_equiv_2177 vgnd.n154 vgnd.t134 236.60074086089969
rmesh_equiv_2178 vgnd.n157 vgnd.n158 110.68097909481314
rmesh_equiv_2179 vgnd.n158 vgnd.n463 2780.0682144233851
rmesh_equiv_218 clk clk.n2 42.448700000000002
rmesh_equiv_2180 vgnd.n158 vgnd.t35 1112.1627186340927
rmesh_equiv_2181 vgnd.n1858 vgnd.n1869 1400383.0467665824
rmesh_equiv_2182 vgnd.n1858 vgnd.n1901 449233.00900742091
rmesh_equiv_2183 vgnd.n1858 vgnd.n2110 2045844206.6510308
rmesh_equiv_2184 vgnd.n1858 vgnd.n2780 120937545.91894214
rmesh_equiv_2185 vgnd.n1858 vgnd.n3159 73149.130141181478
rmesh_equiv_2186 vgnd.n1858 vgnd.n3625 1769601.8183117223
rmesh_equiv_2187 vgnd.n1858 vgnd.n3672 52960.537463258588
rmesh_equiv_2188 vgnd.n1858 vgnd.n3735 339452.03506232746
rmesh_equiv_2189 vgnd.n1858 vgnd.n3739 13207.525463215537
rmesh_equiv_219 clk clk.n3 42.464300000000001
rmesh_equiv_2190 vgnd.n1858 vgnd.n3741 296854.58511747979
rmesh_equiv_2191 vgnd.n1858 vgnd.n3743 95817.601028734309
rmesh_equiv_2192 vgnd.n1858 vgnd.n3783 3549.8581505371185
rmesh_equiv_2193 vgnd.n1858 vgnd.t111 17548083704.211533
rmesh_equiv_2194 vgnd.n1858 vgnd.t114 1921415.085090477
rmesh_equiv_2195 vgnd.n1858 vgnd.t130 37379.949717928685
rmesh_equiv_2196 vgnd.n1858 vgnd.t17 22216.567428628048
rmesh_equiv_2197 vgnd.n1858 vgnd.t36 2028.6491296582994
rmesh_equiv_2198 vgnd.n1858 vgnd.t59 349951.30507858394
rmesh_equiv_2199 vgnd.n1858 vgnd.t79 183522537.88864446
rmesh_equiv_22 amplified.n8 amplified.n9 25.304500000000001
rmesh_equiv_220 clk clk.n4 17.951025763932698
rmesh_equiv_2200 vgnd.n1858 vgnd.t90 478335.2614432915
rmesh_equiv_2201 vgnd.n1869 vgnd.n1873 103132.2214947422
rmesh_equiv_2202 vgnd.n1869 vgnd.n1885 80583.867779601904
rmesh_equiv_2203 vgnd.n1869 vgnd.n3733 711.97476945036965
rmesh_equiv_2204 vgnd.n1869 vgnd.n3735 359.81797736838155
rmesh_equiv_2205 vgnd.n1869 vgnd.n3739 566.0209320523785
rmesh_equiv_2206 vgnd.n1869 vgnd.n3741 62377.151330444205
rmesh_equiv_2207 vgnd.n1869 vgnd.n3743 3115.1849318370423
rmesh_equiv_2208 vgnd.n1869 vgnd.n3783 184351.25900422322
rmesh_equiv_2209 vgnd.n1869 vgnd.t93 3795.2969473466724
rmesh_equiv_221 clk clk.t0 330.34100000000001
rmesh_equiv_2210 vgnd.n1873 vgnd.n1885 365.17500036468186
rmesh_equiv_2211 vgnd.n1873 vgnd.n3733 1506.3432133383581
rmesh_equiv_2212 vgnd.n1873 vgnd.n3735 14574.817737370489
rmesh_equiv_2213 vgnd.n1873 vgnd.n3739 6669.2540709112227
rmesh_equiv_2214 vgnd.n1873 vgnd.n3741 10865.948461906346
rmesh_equiv_2215 vgnd.n1873 vgnd.n3743 23043.000557604009
rmesh_equiv_2216 vgnd.n1873 vgnd.t93 425.63331005031102
rmesh_equiv_2217 vgnd.n1885 vgnd.n3733 1300.2583059071117
rmesh_equiv_2218 vgnd.n1885 vgnd.n3735 13749.122016263364
rmesh_equiv_2219 vgnd.n1885 vgnd.n3739 1580.5892846211664
rmesh_equiv_222 clk clk.t1 315.88
rmesh_equiv_2220 vgnd.n1885 vgnd.n3741 759.03854150017764
rmesh_equiv_2221 vgnd.n1885 vgnd.n3743 175.60712961597173
rmesh_equiv_2222 vgnd.n1885 vgnd.t93 966.60452198795224
rmesh_equiv_2223 vgnd.n1901 vgnd.n1904 8518.8704474047481
rmesh_equiv_2224 vgnd.n1901 vgnd.n1908 1105.8560684540639
rmesh_equiv_2225 vgnd.n1901 vgnd.n3625 102437.18403892266
rmesh_equiv_2226 vgnd.n1901 vgnd.n3672 117740.63188599322
rmesh_equiv_2227 vgnd.n1901 vgnd.n3705 2895.8018898371597
rmesh_equiv_2228 vgnd.n1901 vgnd.n3707 369.59779367798893
rmesh_equiv_2229 vgnd.n1901 vgnd.n3709 1540.0362363369115
rmesh_equiv_223 clk clk.t2 315.88
rmesh_equiv_2230 vgnd.n1901 vgnd.t59 20257.641625690085
rmesh_equiv_2231 vgnd.n1904 vgnd.n1908 25511.409503124058
rmesh_equiv_2232 vgnd.n1904 vgnd.n1910 14722.075518278534
rmesh_equiv_2233 vgnd.n1904 vgnd.n3672 5407.105392814633
rmesh_equiv_2234 vgnd.n1904 vgnd.n3697 743.94079028835688
rmesh_equiv_2235 vgnd.n1904 vgnd.n3699 7559.8315777736861
rmesh_equiv_2236 vgnd.n1904 vgnd.n3705 35149.541188472424
rmesh_equiv_2237 vgnd.n1904 vgnd.n3707 697.55506021508097
rmesh_equiv_2238 vgnd.n1904 vgnd.n3709 352.8780814232282
rmesh_equiv_2239 vgnd.n1904 vgnd.t122 3987.4343783077097
rmesh_equiv_224 clk clk.t3 315.88
rmesh_equiv_2240 vgnd.n1908 vgnd.n1910 11825.13468727295
rmesh_equiv_2241 vgnd.n1908 vgnd.n3697 7328.6908875007684
rmesh_equiv_2242 vgnd.n1908 vgnd.n3699 6656.4879854530382
rmesh_equiv_2243 vgnd.n1908 vgnd.n3705 472.41796020972009
rmesh_equiv_2244 vgnd.n1908 vgnd.n3707 641.99811307556843
rmesh_equiv_2245 vgnd.n1908 vgnd.n3709 15821.414558644625
rmesh_equiv_2246 vgnd.n1910 vgnd.n3672 1861.1415946970819
rmesh_equiv_2247 vgnd.n1910 vgnd.n3697 1481.5396722393079
rmesh_equiv_2248 vgnd.n1910 vgnd.n3699 349.98269739429838
rmesh_equiv_2249 vgnd.n1910 vgnd.n3705 6656.4879854530382
rmesh_equiv_225 clk clk.t4 330.34100000000001
rmesh_equiv_2250 vgnd.n1910 vgnd.n3707 7328.6908875007684
rmesh_equiv_2251 vgnd.n1910 vgnd.n3709 4040.4316579407378
rmesh_equiv_2252 vgnd.n1910 vgnd.t122 608.40282688822072
rmesh_equiv_2253 vgnd.n196 vgnd.n197 3984.4430461538459
rmesh_equiv_2254 vgnd.n196 vgnd.n198 1313.0393975116399
rmesh_equiv_2255 vgnd.n196 vgnd.n203 21864.051100633438
rmesh_equiv_2256 vgnd.n196 vgnd.n209 1591929.7572357222
rmesh_equiv_2257 vgnd.n196 vgnd.n273 2994129.2875729236
rmesh_equiv_2258 vgnd.n196 vgnd.t35 389.85271127843322
rmesh_equiv_2259 vgnd.n197 vgnd.n198 455.7221825945316
rmesh_equiv_226 clk clk.t5 330.34100000000001
rmesh_equiv_2260 vgnd.n197 vgnd.n202 22039.515032356187
rmesh_equiv_2261 vgnd.n197 vgnd.n465 83462.237531897015
rmesh_equiv_2262 vgnd.n197 vgnd.t134 440.6064255128324
rmesh_equiv_2263 vgnd.n198 vgnd.n202 101287.56704997702
rmesh_equiv_2264 vgnd.n198 vgnd.n463 196425.2409766496
rmesh_equiv_2265 vgnd.n198 vgnd.n465 631248.08972946357
rmesh_equiv_2266 vgnd.n198 vgnd.t134 790.85927581501949
rmesh_equiv_2267 vgnd.n202 vgnd.n203 18843.567151013071
rmesh_equiv_2268 vgnd.n202 vgnd.n463 196425.2409766496
rmesh_equiv_2269 vgnd.n202 vgnd.n465 478712.06767167995
rmesh_equiv_227 clk.n0 clk.n1 1.10578
rmesh_equiv_2270 vgnd.n202 vgnd.t134 735.25902653595972
rmesh_equiv_2271 vgnd.n202 vgnd.t35 5931.3179513294845
rmesh_equiv_2272 vgnd.n203 vgnd.n209 168076.31341597444
rmesh_equiv_2273 vgnd.n203 vgnd.n273 316120.86542053265
rmesh_equiv_2274 vgnd.n203 vgnd.t35 280.45211390807947
rmesh_equiv_2275 vgnd.n209 vgnd.n224 4722.8111619899537
rmesh_equiv_2276 vgnd.n209 vgnd.n229 1293.3480619752336
rmesh_equiv_2277 vgnd.n209 vgnd.n246 418.81095235442848
rmesh_equiv_2278 vgnd.n209 vgnd.n250 564.64279412857195
rmesh_equiv_2279 vgnd.n209 vgnd.n255 772.78642150706173
rmesh_equiv_228 clk.n1 clk.n2 0.55314200000000002
rmesh_equiv_2280 vgnd.n209 vgnd.n273 46266.962370038687
rmesh_equiv_2281 vgnd.n209 vgnd.t35 15453.952667449355
rmesh_equiv_2282 vgnd.n2110 vgnd.n2113 8518.8704474047481
rmesh_equiv_2283 vgnd.n2110 vgnd.n2117 1105.8560684540639
rmesh_equiv_2284 vgnd.n2110 vgnd.n2780 22361.669117354963
rmesh_equiv_2285 vgnd.n2110 vgnd.n3159 3744948299.2429314
rmesh_equiv_2286 vgnd.n2110 vgnd.n3192 2895.8018898371597
rmesh_equiv_2287 vgnd.n2110 vgnd.n3194 369.59779367798893
rmesh_equiv_2288 vgnd.n2110 vgnd.n3196 1540.0362363369115
rmesh_equiv_2289 vgnd.n2110 vgnd.t36 642186.11504729534
rmesh_equiv_229 clk.n2 clk.n3 1.1014699999999999
rmesh_equiv_2290 vgnd.n2110 vgnd.t90 18213.715739679301
rmesh_equiv_2291 vgnd.n2113 vgnd.n2117 25511.409503124058
rmesh_equiv_2292 vgnd.n2113 vgnd.n2119 14722.075518278534
rmesh_equiv_2293 vgnd.n2113 vgnd.n3159 5407.105392814633
rmesh_equiv_2294 vgnd.n2113 vgnd.n3184 743.94079028835688
rmesh_equiv_2295 vgnd.n2113 vgnd.n3186 7559.8315777736861
rmesh_equiv_2296 vgnd.n2113 vgnd.n3192 35149.541188472424
rmesh_equiv_2297 vgnd.n2113 vgnd.n3194 697.55506021508097
rmesh_equiv_2298 vgnd.n2113 vgnd.n3196 352.8780814232282
rmesh_equiv_2299 vgnd.n2113 vgnd.t124 3987.4343783077097
rmesh_equiv_23 bias bias.n0 20.751522633278569
rmesh_equiv_230 clk.n3 clk.n4 0.55314200000000002
rmesh_equiv_2300 vgnd.n2117 vgnd.n2119 11825.13468727295
rmesh_equiv_2301 vgnd.n2117 vgnd.n3184 7328.6908875007684
rmesh_equiv_2302 vgnd.n2117 vgnd.n3186 6656.4879854530382
rmesh_equiv_2303 vgnd.n2117 vgnd.n3192 472.41796020972009
rmesh_equiv_2304 vgnd.n2117 vgnd.n3194 641.99811307556843
rmesh_equiv_2305 vgnd.n2117 vgnd.n3196 15821.414558644625
rmesh_equiv_2306 vgnd.n2119 vgnd.n3159 1861.1415946970819
rmesh_equiv_2307 vgnd.n2119 vgnd.n3184 1481.5396722393079
rmesh_equiv_2308 vgnd.n2119 vgnd.n3186 349.98269739429838
rmesh_equiv_2309 vgnd.n2119 vgnd.n3192 6656.4879854530382
rmesh_equiv_231 cmp cmp.n0 20.2395
rmesh_equiv_2310 vgnd.n2119 vgnd.n3194 7328.6908875007684
rmesh_equiv_2311 vgnd.n2119 vgnd.n3196 4040.4316579407378
rmesh_equiv_2312 vgnd.n2119 vgnd.t124 608.40282688822072
rmesh_equiv_2313 vgnd.n221 vgnd.n224 36870.206915880037
rmesh_equiv_2314 vgnd.n221 vgnd.n229 11173.245309151118
rmesh_equiv_2315 vgnd.n221 vgnd.n246 14366.402634930102
rmesh_equiv_2316 vgnd.n221 vgnd.n250 8745.4253067387654
rmesh_equiv_2317 vgnd.n221 vgnd.n255 22049.879582249647
rmesh_equiv_2318 vgnd.n221 vgnd.n257 765.53251583084466
rmesh_equiv_2319 vgnd.n221 vgnd.n259 376.96929454884679
rmesh_equiv_232 cmp cmp.n1 12.8005
rmesh_equiv_2320 vgnd.n221 vgnd.n263 675.30260888780015
rmesh_equiv_2321 vgnd.n221 vgnd.n265 22499.855453217071
rmesh_equiv_2322 vgnd.n221 vgnd.n267 98034.100930047367
rmesh_equiv_2323 vgnd.n221 vgnd.n273 6485.0408608297357
rmesh_equiv_2324 vgnd.n221 vgnd.t108 8909.6924593396452
rmesh_equiv_2325 vgnd.n224 vgnd.n229 16857.861329605537
rmesh_equiv_2326 vgnd.n224 vgnd.n246 5188.2654481749705
rmesh_equiv_2327 vgnd.n224 vgnd.n250 773.54943618508287
rmesh_equiv_2328 vgnd.n224 vgnd.n255 357.95467880612762
rmesh_equiv_2329 vgnd.n224 vgnd.n257 1524.7383058356354
rmesh_equiv_233 cmp cmp.n10 5.4168500000000002
rmesh_equiv_2330 vgnd.n224 vgnd.n259 34447.386852490345
rmesh_equiv_2331 vgnd.n224 vgnd.n263 7181.8664804807859
rmesh_equiv_2332 vgnd.n224 vgnd.n265 10678.102486853031
rmesh_equiv_2333 vgnd.n224 vgnd.n267 22644.642795916465
rmesh_equiv_2334 vgnd.n224 vgnd.t108 979.49592683769617
rmesh_equiv_2335 vgnd.n229 vgnd.n246 423.84777783973362
rmesh_equiv_2336 vgnd.n229 vgnd.n250 545.56825289647372
rmesh_equiv_2337 vgnd.n229 vgnd.n255 7270.5544276860801
rmesh_equiv_2338 vgnd.n229 vgnd.n257 16589.717019932497
rmesh_equiv_2339 vgnd.n229 vgnd.n259 1167.3973084086754
rmesh_equiv_234 cmp cmp.n15 17.948799999999999
rmesh_equiv_2340 vgnd.n229 vgnd.t108 8421.2869173765612
rmesh_equiv_2341 vgnd.n2382 vgnd.n7044 48.303063127587968
rmesh_equiv_2342 vgnd.n2382 vgnd.t117 13.295202040736987
rmesh_equiv_2343 vgnd.n2382 vgnd.t136 13.008650445735622
rmesh_equiv_2344 vgnd.n2382 vgnd.t5 54.038390394436348
rmesh_equiv_2345 vgnd.n2382 vgnd.t66 33244.894732359273
rmesh_equiv_2346 vgnd.n2382 vgnd.t75 39.138589654575313
rmesh_equiv_2347 vgnd.n2382 vgnd.t85 21.61258017455366
rmesh_equiv_2348 vgnd.n2382 vgnd.t89 7.3129200000000001
rmesh_equiv_2349 vgnd.n2382 vgnd.t98 23.626779630140962
rmesh_equiv_235 cmp cmp.n2 12.8005
rmesh_equiv_2350 vgnd.n246 vgnd.n250 1688.7542589498369
rmesh_equiv_2351 vgnd.n246 vgnd.n255 578.08879387674335
rmesh_equiv_2352 vgnd.n246 vgnd.n257 21330.826247294695
rmesh_equiv_2353 vgnd.n246 vgnd.n259 110.69741612476514
rmesh_equiv_2354 vgnd.n246 vgnd.t108 10827.973002634515
rmesh_equiv_2355 vgnd.n250 vgnd.n255 1242.4574872579303
rmesh_equiv_2356 vgnd.n250 vgnd.n257 12984.958894523295
rmesh_equiv_2357 vgnd.n250 vgnd.n259 2190.3633693131251
rmesh_equiv_2358 vgnd.n250 vgnd.t108 192.0378029286808
rmesh_equiv_2359 vgnd.n255 vgnd.n257 1360.2943953347958
rmesh_equiv_236 cmp cmp.n4 12.8005
rmesh_equiv_2360 vgnd.n255 vgnd.n263 1660.4328877655012
rmesh_equiv_2361 vgnd.n255 vgnd.n265 756.39626287053704
rmesh_equiv_2362 vgnd.n255 vgnd.n267 175.54023166265264
rmesh_equiv_2363 vgnd.n257 vgnd.n259 2032.233396872499
rmesh_equiv_2364 vgnd.n257 vgnd.n263 262.70246824174558
rmesh_equiv_2365 vgnd.n257 vgnd.n265 6617.8115058109506
rmesh_equiv_2366 vgnd.n257 vgnd.n267 14034.139288726758
rmesh_equiv_2367 vgnd.n257 vgnd.t108 57.955579571446137
rmesh_equiv_2368 vgnd.n259 vgnd.n263 1803.4281700240495
rmesh_equiv_2369 vgnd.n259 vgnd.n265 23582.568770369326
rmesh_equiv_237 cmp cmp.n5 12.8005
rmesh_equiv_2370 vgnd.n259 vgnd.n267 105218.46212865133
rmesh_equiv_2371 vgnd.n259 vgnd.n273 2285.9076179467384
rmesh_equiv_2372 vgnd.n259 vgnd.t108 3427.697533530898
rmesh_equiv_2373 vgnd.n263 vgnd.n265 627.0095784982999
rmesh_equiv_2374 vgnd.n263 vgnd.n267 5719.3005474907086
rmesh_equiv_2375 vgnd.n263 vgnd.n273 367.05457163549693
rmesh_equiv_2376 vgnd.n265 vgnd.n267 803.60933813001327
rmesh_equiv_2377 vgnd.n265 vgnd.n273 1135.9697952690883
rmesh_equiv_2378 vgnd.n267 vgnd.n273 878.51314191516531
rmesh_equiv_2379 vgnd.n273 vgnd.t35 29066.064052174323
rmesh_equiv_238 cmp cmp.n8 31.751799999999999
rmesh_equiv_2380 vgnd.n2780 vgnd.n3159 221377979.53107309
rmesh_equiv_2381 vgnd.n2780 vgnd.n7088 24539304071.743893
rmesh_equiv_2382 vgnd.n2780 vgnd.t19 5599.8240398276557
rmesh_equiv_2383 vgnd.n2780 vgnd.t2 581451445.08922422
rmesh_equiv_2384 vgnd.n2780 vgnd.t36 37962.036661712875
rmesh_equiv_2385 vgnd.n2780 vgnd.t88 17.541744223996297
rmesh_equiv_2386 vgnd.n2780 vgnd.t90 160.68468242447003
rmesh_equiv_2387 vgnd.n2780 vgnd.t99 1787623.5445792289
rmesh_equiv_2388 vgnd.n3159 vgnd.n3184 12305.085349681374
rmesh_equiv_2389 vgnd.n3159 vgnd.n3186 526.22552770447749
rmesh_equiv_239 cmp.n0 cmp.n13 0.71089000000000002
rmesh_equiv_2390 vgnd.n3159 vgnd.n3196 680.81051771011187
rmesh_equiv_2391 vgnd.n3159 vgnd.t124 884.1291348700031
rmesh_equiv_2392 vgnd.n3159 vgnd.t36 3713.4724546356374
rmesh_equiv_2393 vgnd.n3159 vgnd.t90 875599.8223062813
rmesh_equiv_2394 vgnd.n3184 vgnd.n3186 1586.8066286580693
rmesh_equiv_2395 vgnd.n3184 vgnd.n3192 4125.3942666929725
rmesh_equiv_2396 vgnd.n3184 vgnd.n3194 263.01346535148565
rmesh_equiv_2397 vgnd.n3184 vgnd.n3196 2445.7040838288308
rmesh_equiv_2398 vgnd.n3184 vgnd.t124 57.720611180958343
rmesh_equiv_2399 vgnd.n3186 vgnd.n3192 51.600789359185825
rmesh_equiv_24 bias bias.n1 36.328800000000001
rmesh_equiv_240 cmp.n0 cmp.n14 54.441600000000001
rmesh_equiv_2400 vgnd.n3186 vgnd.n3194 4125.3942666929725
rmesh_equiv_2401 vgnd.n3186 vgnd.n3196 1118.8989765236236
rmesh_equiv_2402 vgnd.n3186 vgnd.t124 1922.4930724746139
rmesh_equiv_2403 vgnd.n3192 vgnd.n3194 1703.5636641986459
rmesh_equiv_2404 vgnd.n3192 vgnd.n3196 233783.07302186851
rmesh_equiv_2405 vgnd.n3194 vgnd.n3196 1215.9640626449034
rmesh_equiv_2406 vgnd.n3196 vgnd.t124 1277.3195072841893
rmesh_equiv_2407 vgnd.n33 vgnd.n37 10489.471582247825
rmesh_equiv_2408 vgnd.n33 vgnd.n38 1691.6143495918029
rmesh_equiv_2409 vgnd.n33 vgnd.n41 2665.3401981487264
rmesh_equiv_241 cmp.n1 cmp.n3 10.151300000000001
rmesh_equiv_2410 vgnd.n33 vgnd.n42 28283.424093931364
rmesh_equiv_2411 vgnd.n33 vgnd.n46 212.2718396593917
rmesh_equiv_2412 vgnd.n33 vgnd.t73 624.03104618984105
rmesh_equiv_2413 vgnd.n348 vgnd.n355 201.30240620237484
rmesh_equiv_2414 vgnd.n348 vgnd.n359 279.56878582377965
rmesh_equiv_2415 vgnd.n348 vgnd.n412 5828.5061206858409
rmesh_equiv_2416 vgnd.n348 vgnd.n55 10599.381102265046
rmesh_equiv_2417 vgnd.n348 vgnd.t43 12.627728936088092
rmesh_equiv_2418 vgnd.n355 vgnd.n359 4708.4786480009816
rmesh_equiv_2419 vgnd.n355 vgnd.n412 36711.321150915246
rmesh_equiv_242 cmp.n1 cmp.t3 700.48400000000004
rmesh_equiv_2420 vgnd.n355 vgnd.n55 200164.47183592949
rmesh_equiv_2421 vgnd.n355 vgnd.t43 20524.458997579193
rmesh_equiv_2422 vgnd.n359 vgnd.n412 11656.347680428029
rmesh_equiv_2423 vgnd.n359 vgnd.n55 308838.21769039473
rmesh_equiv_2424 vgnd.n359 vgnd.t21 2986.2631544550864
rmesh_equiv_2425 vgnd.n359 vgnd.t43 349.39064763788673
rmesh_equiv_2426 vgnd.n3625 vgnd.n3672 463800.34475729475
rmesh_equiv_2427 vgnd.n3625 vgnd.t111 1320.1234568524023
rmesh_equiv_2428 vgnd.n3625 vgnd.t114 12043285.53183415
rmesh_equiv_2429 vgnd.n3625 vgnd.t130 2756255456699.3184
rmesh_equiv_243 cmp.n10 cmp.n11 1.7058199999999999
rmesh_equiv_2430 vgnd.n3625 vgnd.t17 1151583873.7214081
rmesh_equiv_2431 vgnd.n3625 vgnd.t59 135.86979794845521
rmesh_equiv_2432 vgnd.n3625 vgnd.t79 126090.59843126145
rmesh_equiv_2433 vgnd.n3672 vgnd.n3697 12305.085349681374
rmesh_equiv_2434 vgnd.n3672 vgnd.n3699 526.22552770447749
rmesh_equiv_2435 vgnd.n3672 vgnd.n3709 680.81051771011187
rmesh_equiv_2436 vgnd.n3672 vgnd.t122 884.1291348700031
rmesh_equiv_2437 vgnd.n3672 vgnd.t59 91719.635385475005
rmesh_equiv_2438 vgnd.n3697 vgnd.n3699 1586.8066286580693
rmesh_equiv_2439 vgnd.n3697 vgnd.n3705 4125.3942666929725
rmesh_equiv_244 cmp.n10 cmp.n9 31.473199999999995
rmesh_equiv_2440 vgnd.n3697 vgnd.n3707 263.01346535148565
rmesh_equiv_2441 vgnd.n3697 vgnd.n3709 2445.7040838288308
rmesh_equiv_2442 vgnd.n3697 vgnd.t122 57.720611180958343
rmesh_equiv_2443 vgnd.n3699 vgnd.n3705 51.600789359185825
rmesh_equiv_2444 vgnd.n3699 vgnd.n3707 4125.3942666929725
rmesh_equiv_2445 vgnd.n3699 vgnd.n3709 1118.8989765236236
rmesh_equiv_2446 vgnd.n3699 vgnd.t122 1922.4930724746139
rmesh_equiv_2447 vgnd.n37 vgnd.n38 707.09020695778656
rmesh_equiv_2448 vgnd.n37 vgnd.n41 5647455.3860492818
rmesh_equiv_2449 vgnd.n37 vgnd.n42 1283.4141570854047
rmesh_equiv_245 cmp.n11 cmp.n12 21.0337
rmesh_equiv_2450 vgnd.n37 vgnd.n46 8385181.2204031227
rmesh_equiv_2451 vgnd.n37 vgnd.t73 890.72457651024035
rmesh_equiv_2452 vgnd.n3705 vgnd.n3707 1703.5636641986459
rmesh_equiv_2453 vgnd.n3705 vgnd.n3709 233783.07302186851
rmesh_equiv_2454 vgnd.n3707 vgnd.n3709 1215.9640626449034
rmesh_equiv_2455 vgnd.n3709 vgnd.t122 1277.3195072841893
rmesh_equiv_2456 vgnd.n3733 vgnd.n3735 1870.6918567985444
rmesh_equiv_2457 vgnd.n3733 vgnd.n3739 33.324593056871187
rmesh_equiv_2458 vgnd.n3733 vgnd.n3741 6139.0761387682605
rmesh_equiv_2459 vgnd.n3733 vgnd.n3743 13018.903539322693
rmesh_equiv_246 cmp.n11 cmp.n8 2.60127
rmesh_equiv_2460 vgnd.n3733 vgnd.t93 8.1653013525713956
rmesh_equiv_2461 vgnd.n3735 vgnd.n3739 766.32253341313321
rmesh_equiv_2462 vgnd.n3735 vgnd.n3741 19794.40469784625
rmesh_equiv_2463 vgnd.n3735 vgnd.n3743 327.13909843901348
rmesh_equiv_2464 vgnd.n3735 vgnd.n3783 44686.637830825195
rmesh_equiv_2465 vgnd.n3735 vgnd.t93 529.817059301379
rmesh_equiv_2466 vgnd.n3739 vgnd.n3741 397.03841874583162
rmesh_equiv_2467 vgnd.n3739 vgnd.n3743 359.63727666695257
rmesh_equiv_2468 vgnd.n3739 vgnd.n3783 1738.6842500671605
rmesh_equiv_2469 vgnd.n3741 vgnd.n3743 711.09178593386321
rmesh_equiv_247 cmp.n12 cmp.n13 21.586300000000001
rmesh_equiv_2470 vgnd.n3741 vgnd.n3783 39078.962455267043
rmesh_equiv_2471 vgnd.n3743 vgnd.n3783 12613.759803217468
rmesh_equiv_2472 vgnd.n3783 vgnd.t10 5726.2356944912026
rmesh_equiv_2473 vgnd.n3783 vgnd.t133 451120406.05896509
rmesh_equiv_2474 vgnd.n3783 vgnd.t69 1610095.8523148592
rmesh_equiv_2475 vgnd.n3783 vgnd.t7 20.36510665297606
rmesh_equiv_2476 vgnd.n3797 vgnd.n3801 27.688187972246837
rmesh_equiv_2477 vgnd.n3797 vgnd.t113 39.250117453848915
rmesh_equiv_2478 vgnd.n3797 vgnd.t132 11.969335185671365
rmesh_equiv_2479 vgnd.n3797 vgnd.t39 11.721371696168703
rmesh_equiv_248 cmp.n12 cmp.n7 1.84212
rmesh_equiv_2480 vgnd.n3797 vgnd.t40 6.07212
rmesh_equiv_2481 vgnd.n3797 vgnd.t6 24.558984288074015
rmesh_equiv_2482 vgnd.n3797 vgnd.t77 22.190853836254252
rmesh_equiv_2483 vgnd.n3797 vgnd.t8 60.379892744414377
rmesh_equiv_2484 vgnd.n38 vgnd.n41 4646.4335415523146
rmesh_equiv_2485 vgnd.n38 vgnd.n42 696.7274992642067
rmesh_equiv_2486 vgnd.n38 vgnd.n46 3741.6002393685017
rmesh_equiv_2487 vgnd.n38 vgnd.t73 397.18279622652159
rmesh_equiv_2488 vgnd.n3801 vgnd.n3805 27.688187972246837
rmesh_equiv_2489 vgnd.n3801 vgnd.t1 6.07212
rmesh_equiv_249 cmp.n13 cmp.n15 2.38164
rmesh_equiv_2490 vgnd.n3801 vgnd.t119 11.969335185671365
rmesh_equiv_2491 vgnd.n3801 vgnd.t132 60.379892744414377
rmesh_equiv_2492 vgnd.n3801 vgnd.t42 60.379892744414377
rmesh_equiv_2493 vgnd.n3801 vgnd.t6 24.558984288074015
rmesh_equiv_2494 vgnd.n3801 vgnd.t72 24.558984288074015
rmesh_equiv_2495 vgnd.n3801 vgnd.t8 11.969335185671365
rmesh_equiv_2496 vgnd.n3805 vgnd.t109 4644.9364478687667
rmesh_equiv_2497 vgnd.n3805 vgnd.t11 123.23863287099692
rmesh_equiv_2498 vgnd.n3805 vgnd.t119 60.379892744414377
rmesh_equiv_2499 vgnd.n3805 vgnd.t120 6.07212
rmesh_equiv_25 bias bias.n10 39.245399999999997
rmesh_equiv_250 cmp.n14 cmp.n15 48.279000000000003
rmesh_equiv_2500 vgnd.n3805 vgnd.t126 302.99035772145152
rmesh_equiv_2501 vgnd.n3805 vgnd.t42 11.969335185671365
rmesh_equiv_2502 vgnd.n3805 vgnd.t56 3537.9359316014707
rmesh_equiv_2503 vgnd.n3805 vgnd.t72 24.558984288074015
rmesh_equiv_2504 vgnd.n41 vgnd.n42 25298.937368925064
rmesh_equiv_2505 vgnd.n41 vgnd.n46 481.01203946033212
rmesh_equiv_2506 vgnd.n412 vgnd.t21 6157.8827335419574
rmesh_equiv_2507 vgnd.n412 vgnd.t43 322.52530150987167
rmesh_equiv_2508 vgnd.n4145 vgnd.n4345 623.39268600494665
rmesh_equiv_2509 vgnd.n4145 vgnd.n6966 6374.3431178390992
rmesh_equiv_251 cmp.n14 cmp.t0 3.5711299999999997
rmesh_equiv_2510 vgnd.n4145 vgnd.n6970 2327.2722064817108
rmesh_equiv_2511 vgnd.n4145 vgnd.n6997 32397.954627165069
rmesh_equiv_2512 vgnd.n4145 vgnd.t18 4.7774683011817087
rmesh_equiv_2513 vgnd.n4145 vgnd.t50 160.30375353748354
rmesh_equiv_2514 vgnd.n42 vgnd.n46 31354.113727497563
rmesh_equiv_2515 vgnd.n4345 vgnd.n4405 234.09061682010426
rmesh_equiv_2516 vgnd.n4345 vgnd.n6966 10735338.12408511
rmesh_equiv_2517 vgnd.n4345 vgnd.n6997 1082442.8686687457
rmesh_equiv_2518 vgnd.n4345 vgnd.t101 4690.9943142670218
rmesh_equiv_2519 vgnd.n4345 vgnd.t18 40.63875883750368
rmesh_equiv_252 cmp.n2 cmp.n3 10.151300000000001
rmesh_equiv_2520 vgnd.n4345 vgnd.t29 213627.57802325825
rmesh_equiv_2521 vgnd.n4345 vgnd.t50 5355.8830128118134
rmesh_equiv_2522 vgnd.n4345 vgnd.t70 477330.77835488552
rmesh_equiv_2523 vgnd.n4405 vgnd.n6966 1178235.8477937323
rmesh_equiv_2524 vgnd.n4405 vgnd.n6974 50717.315618273897
rmesh_equiv_2525 vgnd.n4405 vgnd.n6979 33562.874129377749
rmesh_equiv_2526 vgnd.n4405 vgnd.n6983 761.02156319921312
rmesh_equiv_2527 vgnd.n4405 vgnd.n6984 11063.430806860792
rmesh_equiv_2528 vgnd.n4405 vgnd.t101 10.875812209623595
rmesh_equiv_2529 vgnd.n4405 vgnd.t29 23446.273195592166
rmesh_equiv_253 cmp.n2 cmp.t3 700.48400000000004
rmesh_equiv_2530 vgnd.n4405 vgnd.t70 52388.497484883868
rmesh_equiv_2531 vgnd.n4427 vgnd.n4430 183148.38991834171
rmesh_equiv_2532 vgnd.n4427 vgnd.n4434 1251930.8353895848
rmesh_equiv_2533 vgnd.n4427 vgnd.n5379 171.48089411800566
rmesh_equiv_2534 vgnd.n4427 vgnd.n5497 383.06426433005504
rmesh_equiv_2535 vgnd.n4427 vgnd.n5746 939986740.99126184
rmesh_equiv_2536 vgnd.n4427 vgnd.n6518 36975.038103532315
rmesh_equiv_2537 vgnd.n4427 vgnd.n6523 94354221.220867783
rmesh_equiv_2538 vgnd.n4427 vgnd.n6872 915598.01692997233
rmesh_equiv_2539 vgnd.n4427 vgnd.n6878 21940.543222024095
rmesh_equiv_254 cmp.n3 cmp.n7 21.586300000000001
rmesh_equiv_2540 vgnd.n4427 vgnd.n6884 22005.518146028688
rmesh_equiv_2541 vgnd.n4427 vgnd.n6887 1273.6901892104327
rmesh_equiv_2542 vgnd.n4427 vgnd.t103 57.905722839431519
rmesh_equiv_2543 vgnd.n4430 vgnd.n4434 29188.227065053754
rmesh_equiv_2544 vgnd.n4430 vgnd.n4439 5790.2985455176477
rmesh_equiv_2545 vgnd.n4430 vgnd.n6866 1054.5148799368767
rmesh_equiv_2546 vgnd.n4430 vgnd.n6870 5133.6547280447321
rmesh_equiv_2547 vgnd.n4430 vgnd.n6872 34226.767800276211
rmesh_equiv_2548 vgnd.n4430 vgnd.n6878 515.15584839887742
rmesh_equiv_2549 vgnd.n4430 vgnd.n6884 1180.7967818109598
rmesh_equiv_255 cmp.n4 cmp.n6 10.151300000000001
rmesh_equiv_2550 vgnd.n4430 vgnd.n6887 781833.96339302009
rmesh_equiv_2551 vgnd.n4434 vgnd.n4439 44915.292825717239
rmesh_equiv_2552 vgnd.n4434 vgnd.n4443 11186.003991199468
rmesh_equiv_2553 vgnd.n4434 vgnd.n6860 14382.807569962499
rmesh_equiv_2554 vgnd.n4434 vgnd.n6864 6987.764894317459
rmesh_equiv_2555 vgnd.n4434 vgnd.n6866 50185.92296325112
rmesh_equiv_2556 vgnd.n4434 vgnd.n6870 697.82071961479733
rmesh_equiv_2557 vgnd.n4434 vgnd.n6872 387.18300186677493
rmesh_equiv_2558 vgnd.n4434 vgnd.n6878 639.98150914809048
rmesh_equiv_2559 vgnd.n4434 vgnd.n6884 7760.4642569811867
rmesh_equiv_256 cmp.n4 cmp.t2 255.34500000000003
rmesh_equiv_2560 vgnd.n4434 vgnd.n6887 5344311.5026180753
rmesh_equiv_2561 vgnd.n4439 vgnd.n4443 47219.016999669031
rmesh_equiv_2562 vgnd.n4439 vgnd.n4447 11186.003991199468
rmesh_equiv_2563 vgnd.n4439 vgnd.n6854 14382.807569962499
rmesh_equiv_2564 vgnd.n4439 vgnd.n6858 6987.764894317459
rmesh_equiv_2565 vgnd.n4439 vgnd.n6860 118098.94927850571
rmesh_equiv_2566 vgnd.n4439 vgnd.n6864 698.14904888467424
rmesh_equiv_2567 vgnd.n4439 vgnd.n6866 380.06557269056225
rmesh_equiv_2568 vgnd.n4439 vgnd.n6870 678.16702629370047
rmesh_equiv_2569 vgnd.n4439 vgnd.n6872 37385.342303313126
rmesh_equiv_257 cmp.n5 cmp.n6 10.151300000000001
rmesh_equiv_2570 vgnd.n4439 vgnd.n6878 5585.8038869224793
rmesh_equiv_2571 vgnd.n4439 vgnd.n6884 198248.83799713862
rmesh_equiv_2572 vgnd.n4443 vgnd.n4447 47219.016999669031
rmesh_equiv_2573 vgnd.n4443 vgnd.n4451 11186.003991199468
rmesh_equiv_2574 vgnd.n4443 vgnd.n6848 14382.807569962499
rmesh_equiv_2575 vgnd.n4443 vgnd.n6852 6987.764894317459
rmesh_equiv_2576 vgnd.n4443 vgnd.n6854 118098.94927850571
rmesh_equiv_2577 vgnd.n4443 vgnd.n6858 698.14904888467424
rmesh_equiv_2578 vgnd.n4443 vgnd.n6860 441.63996879204274
rmesh_equiv_2579 vgnd.n4443 vgnd.n6864 688.23728389057908
rmesh_equiv_258 cmp.n5 cmp.t2 255.34500000000003
rmesh_equiv_2580 vgnd.n4443 vgnd.n6866 37385.342303313126
rmesh_equiv_2581 vgnd.n4443 vgnd.n6870 6662.9740996152623
rmesh_equiv_2582 vgnd.n4443 vgnd.n6872 1167.7590376831508
rmesh_equiv_2583 vgnd.n4447 vgnd.n4451 47219.016999669031
rmesh_equiv_2584 vgnd.n4447 vgnd.n4455 11186.003991199468
rmesh_equiv_2585 vgnd.n4447 vgnd.n6842 14382.807569962499
rmesh_equiv_2586 vgnd.n4447 vgnd.n6846 6987.764894317459
rmesh_equiv_2587 vgnd.n4447 vgnd.n6848 118098.94927850571
rmesh_equiv_2588 vgnd.n4447 vgnd.n6852 698.14904888467424
rmesh_equiv_2589 vgnd.n4447 vgnd.n6854 441.63996879204274
rmesh_equiv_259 cmp.n6 cmp.n7 21.0337
rmesh_equiv_2590 vgnd.n4447 vgnd.n6858 688.23728389057908
rmesh_equiv_2591 vgnd.n4447 vgnd.n6860 37385.342303313126
rmesh_equiv_2592 vgnd.n4447 vgnd.n6864 6662.9740996152623
rmesh_equiv_2593 vgnd.n4447 vgnd.n6866 1167.7590376831508
rmesh_equiv_2594 vgnd.n4451 vgnd.n4455 47219.016999669031
rmesh_equiv_2595 vgnd.n4451 vgnd.n4459 11186.003991199468
rmesh_equiv_2596 vgnd.n4451 vgnd.n6836 14382.807569962499
rmesh_equiv_2597 vgnd.n4451 vgnd.n6840 6987.764894317459
rmesh_equiv_2598 vgnd.n4451 vgnd.n6842 118098.94927850571
rmesh_equiv_2599 vgnd.n4451 vgnd.n6846 698.14904888467424
rmesh_equiv_26 bias bias.n12 39.245399999999997
rmesh_equiv_260 cmp.n8 cmp.n9 37.418900000000001
rmesh_equiv_2600 vgnd.n4451 vgnd.n6848 441.63996879204274
rmesh_equiv_2601 vgnd.n4451 vgnd.n6852 688.23728389057908
rmesh_equiv_2602 vgnd.n4451 vgnd.n6854 37385.342303313126
rmesh_equiv_2603 vgnd.n4451 vgnd.n6858 6662.9740996152623
rmesh_equiv_2604 vgnd.n4451 vgnd.n6860 1167.7590376831508
rmesh_equiv_2605 vgnd.n4455 vgnd.n4459 47219.016999669031
rmesh_equiv_2606 vgnd.n4455 vgnd.n4463 11186.003991199468
rmesh_equiv_2607 vgnd.n4455 vgnd.n6830 14382.807569962499
rmesh_equiv_2608 vgnd.n4455 vgnd.n6834 6987.764894317459
rmesh_equiv_2609 vgnd.n4455 vgnd.n6836 118098.94927850571
rmesh_equiv_261 cmp.n9 cmp.t1 4.3505000000000003
rmesh_equiv_2610 vgnd.n4455 vgnd.n6840 698.14904888467424
rmesh_equiv_2611 vgnd.n4455 vgnd.n6842 441.63996879204274
rmesh_equiv_2612 vgnd.n4455 vgnd.n6846 688.23728389057908
rmesh_equiv_2613 vgnd.n4455 vgnd.n6848 37385.342303313126
rmesh_equiv_2614 vgnd.n4455 vgnd.n6852 6662.9740996152623
rmesh_equiv_2615 vgnd.n4455 vgnd.n6854 1167.7590376831508
rmesh_equiv_2616 vgnd.n4459 vgnd.n4463 47219.016999669031
rmesh_equiv_2617 vgnd.n4459 vgnd.n4467 11186.003991199468
rmesh_equiv_2618 vgnd.n4459 vgnd.n6824 14382.807569962499
rmesh_equiv_2619 vgnd.n4459 vgnd.n6828 6987.764894317459
rmesh_equiv_262 comparator__pre comparator__pre.n0 22.8553
rmesh_equiv_2620 vgnd.n4459 vgnd.n6830 118098.94927850571
rmesh_equiv_2621 vgnd.n4459 vgnd.n6834 698.14904888467424
rmesh_equiv_2622 vgnd.n4459 vgnd.n6836 441.63996879204274
rmesh_equiv_2623 vgnd.n4459 vgnd.n6840 688.23728389057908
rmesh_equiv_2624 vgnd.n4459 vgnd.n6842 37385.342303313126
rmesh_equiv_2625 vgnd.n4459 vgnd.n6846 6662.9740996152623
rmesh_equiv_2626 vgnd.n4459 vgnd.n6848 1167.7590376831508
rmesh_equiv_2627 vgnd.n4463 vgnd.n4467 47219.016999669031
rmesh_equiv_2628 vgnd.n4463 vgnd.n4471 11186.003991199468
rmesh_equiv_2629 vgnd.n4463 vgnd.n6818 14382.807569962499
rmesh_equiv_263 comparator__pre comparator__pre.n1 19.646904226928847
rmesh_equiv_2630 vgnd.n4463 vgnd.n6822 6987.764894317459
rmesh_equiv_2631 vgnd.n4463 vgnd.n6824 118098.94927850571
rmesh_equiv_2632 vgnd.n4463 vgnd.n6828 698.14904888467424
rmesh_equiv_2633 vgnd.n4463 vgnd.n6830 441.63996879204274
rmesh_equiv_2634 vgnd.n4463 vgnd.n6834 688.23728389057908
rmesh_equiv_2635 vgnd.n4463 vgnd.n6836 37385.342303313126
rmesh_equiv_2636 vgnd.n4463 vgnd.n6840 6662.9740996152623
rmesh_equiv_2637 vgnd.n4463 vgnd.n6842 1167.7590376831508
rmesh_equiv_2638 vgnd.n4467 vgnd.n4471 47219.016999669031
rmesh_equiv_2639 vgnd.n4467 vgnd.n4475 11186.003991199468
rmesh_equiv_264 comparator__pre comparator__pre.n2 6.3200399999999997
rmesh_equiv_2640 vgnd.n4467 vgnd.n6812 14382.807569962499
rmesh_equiv_2641 vgnd.n4467 vgnd.n6816 6987.764894317459
rmesh_equiv_2642 vgnd.n4467 vgnd.n6818 118098.94927850571
rmesh_equiv_2643 vgnd.n4467 vgnd.n6822 698.14904888467424
rmesh_equiv_2644 vgnd.n4467 vgnd.n6824 441.63996879204274
rmesh_equiv_2645 vgnd.n4467 vgnd.n6828 688.23728389057908
rmesh_equiv_2646 vgnd.n4467 vgnd.n6830 37385.342303313126
rmesh_equiv_2647 vgnd.n4467 vgnd.n6834 6662.9740996152623
rmesh_equiv_2648 vgnd.n4467 vgnd.n6836 1167.7590376831508
rmesh_equiv_2649 vgnd.n4471 vgnd.n4475 47219.016999669031
rmesh_equiv_265 comparator__pre comparator__pre.n4 33.130400000000002
rmesh_equiv_2650 vgnd.n4471 vgnd.n4479 11186.003991199468
rmesh_equiv_2651 vgnd.n4471 vgnd.n6806 14382.807569962499
rmesh_equiv_2652 vgnd.n4471 vgnd.n6810 6987.764894317459
rmesh_equiv_2653 vgnd.n4471 vgnd.n6812 118098.94927850571
rmesh_equiv_2654 vgnd.n4471 vgnd.n6816 698.14904888467424
rmesh_equiv_2655 vgnd.n4471 vgnd.n6818 441.63996879204274
rmesh_equiv_2656 vgnd.n4471 vgnd.n6822 688.23728389057908
rmesh_equiv_2657 vgnd.n4471 vgnd.n6824 37385.342303313126
rmesh_equiv_2658 vgnd.n4471 vgnd.n6828 6662.9740996152623
rmesh_equiv_2659 vgnd.n4471 vgnd.n6830 1167.7590376831508
rmesh_equiv_266 comparator__pre comparator__pre.n8 4.8770699999999998
rmesh_equiv_2660 vgnd.n4475 vgnd.n4479 46546.537565141436
rmesh_equiv_2661 vgnd.n4475 vgnd.n6643 297364.70907389408
rmesh_equiv_2662 vgnd.n4475 vgnd.n6776 105657.56183132071
rmesh_equiv_2663 vgnd.n4475 vgnd.n6804 6261.7241509896712
rmesh_equiv_2664 vgnd.n4475 vgnd.n6806 118098.94927850571
rmesh_equiv_2665 vgnd.n4475 vgnd.n6810 696.09928784735678
rmesh_equiv_2666 vgnd.n4475 vgnd.n6812 422.40110693638479
rmesh_equiv_2667 vgnd.n4475 vgnd.n6816 688.23728389057908
rmesh_equiv_2668 vgnd.n4475 vgnd.n6818 37385.342303313126
rmesh_equiv_2669 vgnd.n4475 vgnd.n6822 6662.9740996152623
rmesh_equiv_267 comparator__pre comparator__pre.t2 1511.24
rmesh_equiv_2670 vgnd.n4475 vgnd.n6824 1167.7590376831508
rmesh_equiv_2671 vgnd.n4475 vgnd.t33 51711.596294297851
rmesh_equiv_2672 vgnd.n4479 vgnd.n6619 59552.447080254962
rmesh_equiv_2673 vgnd.n4479 vgnd.n6643 176910.04602203006
rmesh_equiv_2674 vgnd.n4479 vgnd.n6776 19777.520636619778
rmesh_equiv_2675 vgnd.n4479 vgnd.n6804 735.58452631785804
rmesh_equiv_2676 vgnd.n4479 vgnd.n6806 398.47430848631393
rmesh_equiv_2677 vgnd.n4479 vgnd.n6810 687.99406101710804
rmesh_equiv_2678 vgnd.n4479 vgnd.n6812 25439.935176203042
rmesh_equiv_2679 vgnd.n4479 vgnd.n6816 6662.9740996152623
rmesh_equiv_268 comparator__pre comparator__pre.t3 854.11400000000003
rmesh_equiv_2680 vgnd.n4479 vgnd.n6818 1167.7590376831508
rmesh_equiv_2681 vgnd.n4479 vgnd.t33 17249.501680579968
rmesh_equiv_2682 vgnd.n463 vgnd.n465 394.00000000000006
rmesh_equiv_2683 vgnd.n463 vgnd.t134 826.03154641390984
rmesh_equiv_2684 vgnd.n463 vgnd.t35 5179.0731356571468
rmesh_equiv_2685 vgnd.n465 vgnd.t134 753.81138661799025
rmesh_equiv_2686 vgnd.n5263 vgnd.n5746 383.25868185337953
rmesh_equiv_2687 vgnd.n5263 vgnd.n5831 5747.1198958190289
rmesh_equiv_2688 vgnd.n5263 vgnd.n5901 29790.713202515821
rmesh_equiv_2689 vgnd.n5263 vgnd.n6330 181763.48440716998
rmesh_equiv_269 comparator__pre.n0 comparator__pre.n7 11.4361
rmesh_equiv_2690 vgnd.n5263 vgnd.n6518 55191.106778310335
rmesh_equiv_2691 vgnd.n5263 vgnd.n6523 175.14346394523275
rmesh_equiv_2692 vgnd.n5263 vgnd.n6591 617.34829919306753
rmesh_equiv_2693 vgnd.n5263 vgnd.n6593 28198.038717394935
rmesh_equiv_2694 vgnd.n5263 vgnd.n6594 566.24961758361985
rmesh_equiv_2695 vgnd.n5263 vgnd.t103 577.572
rmesh_equiv_2696 vgnd.n5263 vgnd.t106 6960.6149445624069
rmesh_equiv_2697 vgnd.n5313 vgnd.t12 12325.0353145345
rmesh_equiv_2698 vgnd.n5313 vgnd.t23 1014.5499638955157
rmesh_equiv_2699 vgnd.n5313 vgnd.t49 779.3526851822196
rmesh_equiv_27 bias bias.n13 4.2590000000000003
rmesh_equiv_270 comparator__pre.n0 comparator__pre.t0 381.113
rmesh_equiv_2700 vgnd.n5313 vgnd.t51 1073.9992583841661
rmesh_equiv_2701 vgnd.n5313 vgnd.t54 6288.6248275498428
rmesh_equiv_2702 vgnd.n5313 vgnd.t58 2936.5001304759567
rmesh_equiv_2703 vgnd.n5313 vgnd.t71 908.55231933339428
rmesh_equiv_2704 vgnd.n5319 vgnd.n5320 7783.1514095702214
rmesh_equiv_2705 vgnd.n5319 vgnd.n5332 14397.331250632558
rmesh_equiv_2706 vgnd.n5319 vgnd.n5337 9527.6299755468626
rmesh_equiv_2707 vgnd.n5319 vgnd.n5341 216.03429520440716
rmesh_equiv_2708 vgnd.n5319 vgnd.n5342 3140.6212287275807
rmesh_equiv_2709 vgnd.n5319 vgnd.n5570 1393.3643150695511
rmesh_equiv_271 comparator__pre.n1 comparator__pre.n6 1.4422299999999999
rmesh_equiv_2710 vgnd.n5319 vgnd.n6964 10104.741733566891
rmesh_equiv_2711 vgnd.n5319 vgnd.t29 300.38374159668058
rmesh_equiv_2712 vgnd.n5320 vgnd.n5332 6615.6016323449312
rmesh_equiv_2713 vgnd.n5320 vgnd.n5337 380.14074145740977
rmesh_equiv_2714 vgnd.n5320 vgnd.n5341 843.39876086181027
rmesh_equiv_2715 vgnd.n5320 vgnd.n5342 15574.576010506184
rmesh_equiv_2716 vgnd.n5320 vgnd.n6964 32143.226065954266
rmesh_equiv_2717 vgnd.n5320 vgnd.n6966 42746.383186982559
rmesh_equiv_2718 vgnd.n5320 vgnd.t48 621.37285782708318
rmesh_equiv_2719 vgnd.n5332 vgnd.n5337 298.03941749311815
rmesh_equiv_272 comparator__pre.n2 comparator__pre.n3 13.389300000000002
rmesh_equiv_2720 vgnd.n5332 vgnd.n5341 6017.9703885829576
rmesh_equiv_2721 vgnd.n5332 vgnd.n5342 461.62439617294325
rmesh_equiv_2722 vgnd.n5332 vgnd.n6964 6713.3498769658618
rmesh_equiv_2723 vgnd.n5332 vgnd.n6966 8927.8974587128287
rmesh_equiv_2724 vgnd.n5332 vgnd.t48 700.63374528045654
rmesh_equiv_2725 vgnd.n5337 vgnd.n5341 3495.9149047381347
rmesh_equiv_2726 vgnd.n5337 vgnd.n5342 12938.074745286334
rmesh_equiv_2727 vgnd.n5337 vgnd.n6964 5748.3633123530208
rmesh_equiv_2728 vgnd.n5337 vgnd.n6966 7644.5886403449767
rmesh_equiv_2729 vgnd.n5337 vgnd.t48 852.90293518933709
rmesh_equiv_273 comparator__pre.n2 comparator__pre.n5 0.75515399999999999
rmesh_equiv_2730 vgnd.n5341 vgnd.n5342 529.38799491679856
rmesh_equiv_2731 vgnd.n5341 vgnd.n6964 452647.35043387616
rmesh_equiv_2732 vgnd.n5341 vgnd.n6966 601963.13371025096
rmesh_equiv_2733 vgnd.n5341 vgnd.t48 208.82188887759153
rmesh_equiv_2734 vgnd.n5342 vgnd.n6964 88978.455731660462
rmesh_equiv_2735 vgnd.n5342 vgnd.n6966 118329.97584894425
rmesh_equiv_2736 vgnd.n5342 vgnd.t48 1846.5953724096837
rmesh_equiv_2737 vgnd.n5379 vgnd.n5497 316.68220281656733
rmesh_equiv_2738 vgnd.n5379 vgnd.n5546 1164.6289669103344
rmesh_equiv_2739 vgnd.n5379 vgnd.n5548 773.68380134368101
rmesh_equiv_274 comparator__pre.n3 comparator__pre.n4 14.121399999999998
rmesh_equiv_2740 vgnd.n5379 vgnd.n5746 1489180370915.1609
rmesh_equiv_2741 vgnd.n5379 vgnd.n6518 58577954.939613707
rmesh_equiv_2742 vgnd.n5379 vgnd.n6523 149481315031.02686
rmesh_equiv_2743 vgnd.n5379 vgnd.n6619 26731.214742012573
rmesh_equiv_2744 vgnd.n5379 vgnd.t103 2016.7133665729646
rmesh_equiv_2745 vgnd.n5497 vgnd.n5546 3833.9196348423802
rmesh_equiv_2746 vgnd.n5497 vgnd.n5548 2706.4619384369971
rmesh_equiv_2747 vgnd.n5497 vgnd.n5746 137136094333240.3
rmesh_equiv_2748 vgnd.n5497 vgnd.n6518 5394344507.4490681
rmesh_equiv_2749 vgnd.n5497 vgnd.n6523 13765480743312.566
rmesh_equiv_275 comparator__pre.n3 comparator__pre.t1 1.7404999999999999
rmesh_equiv_2750 vgnd.n5497 vgnd.n6619 87084.653938045289
rmesh_equiv_2751 vgnd.n5497 vgnd.t103 6575.1753526046396
rmesh_equiv_2752 vgnd.n55 vgnd.n57 1210.4005286517502
rmesh_equiv_2753 vgnd.n55 vgnd.n59 218.05909951774984
rmesh_equiv_2754 vgnd.n55 vgnd.n63 1769.127958662945
rmesh_equiv_2755 vgnd.n5546 vgnd.n5548 265.68046169252301
rmesh_equiv_2756 vgnd.n5546 vgnd.n5570 10633.970755344049
rmesh_equiv_2757 vgnd.n5546 vgnd.n6591 28239.642258454183
rmesh_equiv_2758 vgnd.n5546 vgnd.n6593 423807.64842437539
rmesh_equiv_2759 vgnd.n5546 vgnd.n6594 307201.71752260521
rmesh_equiv_276 comparator__pre.n4 comparator__pre.n5 1.13588
rmesh_equiv_2760 vgnd.n5546 vgnd.n6619 36696.390938525554
rmesh_equiv_2761 vgnd.n5546 vgnd.t103 1012.6833346108173
rmesh_equiv_2762 vgnd.n5548 vgnd.n5570 2062.5642158836563
rmesh_equiv_2763 vgnd.n5548 vgnd.n6591 1160.741657778116
rmesh_equiv_2764 vgnd.n5548 vgnd.n6593 17908.330442310857
rmesh_equiv_2765 vgnd.n5548 vgnd.n6594 13609.358388426504
rmesh_equiv_2766 vgnd.n5548 vgnd.n6619 26731.193580671701
rmesh_equiv_2767 vgnd.n5548 vgnd.t103 245.42998347433343
rmesh_equiv_2768 vgnd.n5570 vgnd.n6591 8689.2721274817395
rmesh_equiv_2769 vgnd.n5570 vgnd.n6593 129141.27344424927
rmesh_equiv_277 comparator__pre.n5 comparator__pre.n6 22.162199999999999
rmesh_equiv_2770 vgnd.n5570 vgnd.n6594 92139.771515091386
rmesh_equiv_2771 vgnd.n5570 vgnd.n6962 87871.709754554438
rmesh_equiv_2772 vgnd.n5570 vgnd.n6964 4596.3807883251038
rmesh_equiv_2773 vgnd.n5570 vgnd.t103 385.24299374735125
rmesh_equiv_2774 vgnd.n5570 vgnd.t29 1946.9933568913582
rmesh_equiv_2775 vgnd.n5570 vgnd.t68 658.70223693000514
rmesh_equiv_2776 vgnd.n5675 vgnd.n5676 7783.1514095702214
rmesh_equiv_2777 vgnd.n5675 vgnd.n5688 14397.331250632558
rmesh_equiv_2778 vgnd.n5675 vgnd.n5693 9527.6299755468626
rmesh_equiv_2779 vgnd.n5675 vgnd.n5697 216.03429520440716
rmesh_equiv_278 comparator__pre.n6 comparator__pre.n7 20.304500000000001
rmesh_equiv_2780 vgnd.n5675 vgnd.n5698 3140.6212287275807
rmesh_equiv_2781 vgnd.n5675 vgnd.n6073 345780.83995320799
rmesh_equiv_2782 vgnd.n5675 vgnd.n6100 219.38654333823928
rmesh_equiv_2783 vgnd.n5675 vgnd.n6322 2094.3478323943609
rmesh_equiv_2784 vgnd.n5675 vgnd.n6960 1623.9325318979502
rmesh_equiv_2785 vgnd.n5675 vgnd.t26 25930.065253032109
rmesh_equiv_2786 vgnd.n5676 vgnd.n5688 6535.4387864209566
rmesh_equiv_2787 vgnd.n5676 vgnd.n5693 379.82809349403317
rmesh_equiv_2788 vgnd.n5676 vgnd.n5697 843.37920107241382
rmesh_equiv_2789 vgnd.n5676 vgnd.n5698 15540.717274600238
rmesh_equiv_279 comparator__pre.n7 comparator__pre.n8 2.4407800000000002
rmesh_equiv_2790 vgnd.n5676 vgnd.n6960 48638.46312702517
rmesh_equiv_2791 vgnd.n5676 vgnd.n6962 38971.319884159457
rmesh_equiv_2792 vgnd.n5676 vgnd.t118 619.94341685682843
rmesh_equiv_2793 vgnd.n5688 vgnd.n5693 297.12133474367465
rmesh_equiv_2794 vgnd.n5688 vgnd.n5697 6013.2059181854102
rmesh_equiv_2795 vgnd.n5688 vgnd.n5698 461.48171164718138
rmesh_equiv_2796 vgnd.n5688 vgnd.n6960 10158.501818691957
rmesh_equiv_2797 vgnd.n5688 vgnd.n6962 8139.4476401555903
rmesh_equiv_2798 vgnd.n5688 vgnd.t118 692.01941723509981
rmesh_equiv_2799 vgnd.n5693 vgnd.n5697 3494.0367044677969
rmesh_equiv_28 bias bias.n14 19.837
rmesh_equiv_280 comparator__pre.n8 comparator__pre.t0 387.11000000000001
rmesh_equiv_2800 vgnd.n5693 vgnd.n5698 12808.447926107247
rmesh_equiv_2801 vgnd.n5693 vgnd.n6960 8698.3041601031746
rmesh_equiv_2802 vgnd.n5693 vgnd.n6962 6969.4717324393505
rmesh_equiv_2803 vgnd.n5693 vgnd.t118 838.07134394256843
rmesh_equiv_2804 vgnd.n5697 vgnd.n5698 529.38521098352965
rmesh_equiv_2805 vgnd.n5697 vgnd.n6960 684936.5841017093
rmesh_equiv_2806 vgnd.n5697 vgnd.n6962 548801.93581938487
rmesh_equiv_2807 vgnd.n5697 vgnd.t118 208.81039889112878
rmesh_equiv_2808 vgnd.n5698 vgnd.n6960 134640.35406165844
rmesh_equiv_2809 vgnd.n5698 vgnd.n6962 107879.89525388404
rmesh_equiv_281 comparator__preamp__mir comparator__preamp__mir.n0 22.8553
rmesh_equiv_2810 vgnd.n5698 vgnd.t118 1842.0356723862096
rmesh_equiv_2811 vgnd.n57 vgnd.n59 878.91941406883984
rmesh_equiv_2812 vgnd.n57 vgnd.n63 33902.355122799032
rmesh_equiv_2813 vgnd.n57 vgnd.n67 112.9598387496471
rmesh_equiv_2814 vgnd.n57 vgnd.n70 6276.5027873174149
rmesh_equiv_2815 vgnd.n5746 vgnd.n6518 794.4360470755488
rmesh_equiv_2816 vgnd.n5746 vgnd.n6523 356.9311199229777
rmesh_equiv_2817 vgnd.n5746 vgnd.n6591 1353016.1978012808
rmesh_equiv_2818 vgnd.n5746 vgnd.n6593 61933058.618669577
rmesh_equiv_2819 vgnd.n5746 vgnd.n6594 1500069.2500794707
rmesh_equiv_282 comparator__preamp__mir comparator__preamp__mir.n1 16.331811947371321
rmesh_equiv_2820 vgnd.n5746 vgnd.t103 39855220.635608472
rmesh_equiv_2821 vgnd.n5831 vgnd.n5901 301.79003541129754
rmesh_equiv_2822 vgnd.n5831 vgnd.n5902 261.30718025023072
rmesh_equiv_2823 vgnd.n5831 vgnd.n5912 279990.61022485391
rmesh_equiv_2824 vgnd.n5831 vgnd.n6307 3040.4829187915088
rmesh_equiv_2825 vgnd.n5831 vgnd.n6322 2528.2508533539822
rmesh_equiv_2826 vgnd.n5831 vgnd.n6330 15942.424187748287
rmesh_equiv_2827 vgnd.n5831 vgnd.n6518 4840.855954337082
rmesh_equiv_2828 vgnd.n5831 vgnd.t106 472.63159623291511
rmesh_equiv_2829 vgnd.n59 vgnd.n63 1284.6347682340413
rmesh_equiv_283 comparator__preamp__mir comparator__preamp__mir.n2 6.3200399999999997
rmesh_equiv_2830 vgnd.n59 vgnd.n70 118.09320594094952
rmesh_equiv_2831 vgnd.n5901 vgnd.n5902 192.01124850414777
rmesh_equiv_2832 vgnd.n5901 vgnd.n5912 12816211.012396848
rmesh_equiv_2833 vgnd.n5901 vgnd.n6307 139174.21947912016
rmesh_equiv_2834 vgnd.n5901 vgnd.n6322 115721.21589257404
rmesh_equiv_2835 vgnd.n5901 vgnd.n6330 85585.826304060116
rmesh_equiv_2836 vgnd.n5901 vgnd.n6518 25987.602442141622
rmesh_equiv_2837 vgnd.n5901 vgnd.t106 3187.4066780531216
rmesh_equiv_2838 vgnd.n5902 vgnd.n5912 233834.08584889665
rmesh_equiv_2839 vgnd.n5902 vgnd.n6307 2539.395951899518
rmesh_equiv_284 comparator__preamp__mir comparator__preamp__mir.n4 33.130400000000002
rmesh_equiv_2840 vgnd.n5902 vgnd.n6322 2052.8606368289716
rmesh_equiv_2841 vgnd.n5902 vgnd.n6594 198.61287906301925
rmesh_equiv_2842 vgnd.n5902 vgnd.n6962 28314.955354574362
rmesh_equiv_2843 vgnd.n5902 vgnd.t106 40.715526830872236
rmesh_equiv_2844 vgnd.n5902 vgnd.t76 1258.9822064532914
rmesh_equiv_2845 vgnd.n5912 vgnd.n6005 20409.055475776771
rmesh_equiv_2846 vgnd.n5912 vgnd.n6151 17659.931400449601
rmesh_equiv_2847 vgnd.n5912 vgnd.n6307 302.80860458617792
rmesh_equiv_2848 vgnd.n5912 vgnd.n6322 385.30066511916635
rmesh_equiv_2849 vgnd.n5912 vgnd.n6330 504233.10904477525
rmesh_equiv_285 comparator__preamp__mir comparator__preamp__mir.n8 4.8770699999999998
rmesh_equiv_2850 vgnd.n5912 vgnd.t106 2201.4000521044295
rmesh_equiv_2851 vgnd.n6005 vgnd.n6007 772.43301947758027
rmesh_equiv_2852 vgnd.n6005 vgnd.n6008 301.14024337946671
rmesh_equiv_2853 vgnd.n6005 vgnd.n6075 26048175.731008004
rmesh_equiv_2854 vgnd.n6005 vgnd.n6077 282869.30851462571
rmesh_equiv_2855 vgnd.n6005 vgnd.n6100 75846.16401885658
rmesh_equiv_2856 vgnd.n6005 vgnd.n6145 15432.010171011329
rmesh_equiv_2857 vgnd.n6005 vgnd.n6147 310.35458548311942
rmesh_equiv_2858 vgnd.n6005 vgnd.n6151 1787.9491959551153
rmesh_equiv_2859 vgnd.n6005 vgnd.n6307 6186.3680943409236
rmesh_equiv_286 comparator__preamp__mir comparator__preamp__mir.t0 572.84699999999998
rmesh_equiv_2860 vgnd.n6005 vgnd.n6330 1587005.5672418254
rmesh_equiv_2861 vgnd.n6005 vgnd.t106 6953.2263234012698
rmesh_equiv_2862 vgnd.n6005 vgnd.t16 797.70942513334126
rmesh_equiv_2863 vgnd.n6007 vgnd.n6008 369.22694901819608
rmesh_equiv_2864 vgnd.n6007 vgnd.n6075 3021751.2881529997
rmesh_equiv_2865 vgnd.n6007 vgnd.n6077 32814.608831339501
rmesh_equiv_2866 vgnd.n6007 vgnd.n6100 8798.6293624630162
rmesh_equiv_2867 vgnd.n6007 vgnd.n6145 3191999.0952531174
rmesh_equiv_2868 vgnd.n6007 vgnd.n6147 34664.432620674328
rmesh_equiv_2869 vgnd.n6007 vgnd.n6151 449260.51034169534
rmesh_equiv_287 comparator__preamp__mir comparator__preamp__mir.t3 572.84699999999998
rmesh_equiv_2870 vgnd.n6007 vgnd.t16 830.68990396319168
rmesh_equiv_2871 vgnd.n6008 vgnd.n6075 112668.00954665056
rmesh_equiv_2872 vgnd.n6008 vgnd.n6077 1223.4799308256115
rmesh_equiv_2873 vgnd.n6008 vgnd.n6100 456.15893170433816
rmesh_equiv_2874 vgnd.n6008 vgnd.n6145 105390.94168885866
rmesh_equiv_2875 vgnd.n6008 vgnd.n6147 1144.4538615231697
rmesh_equiv_2876 vgnd.n6008 vgnd.n6151 14833.677430958778
rmesh_equiv_2877 vgnd.n6008 vgnd.t16 719.33174706278646
rmesh_equiv_2878 vgnd.n6073 vgnd.n6075 340.12356689015496
rmesh_equiv_2879 vgnd.n6073 vgnd.n6077 255.46363441475174
rmesh_equiv_288 comparator__preamp__mir.n0 comparator__preamp__mir.n7 11.4361
rmesh_equiv_2880 vgnd.n6073 vgnd.n6100 56364.705312061109
rmesh_equiv_2881 vgnd.n6073 vgnd.n6145 11227289.222699862
rmesh_equiv_2882 vgnd.n6073 vgnd.n6147 1126971.3094248509
rmesh_equiv_2883 vgnd.n6073 vgnd.n6151 37970.962646371561
rmesh_equiv_2884 vgnd.n6073 vgnd.n6322 538079.02981479873
rmesh_equiv_2885 vgnd.n6073 vgnd.n6960 1739995.421063761
rmesh_equiv_2886 vgnd.n6073 vgnd.t16 57.917873941450068
rmesh_equiv_2887 vgnd.n6073 vgnd.t26 348.93863243461811
rmesh_equiv_2888 vgnd.n6075 vgnd.n6077 357.01810926744167
rmesh_equiv_2889 vgnd.n6075 vgnd.n6100 1122.3538493344251
rmesh_equiv_289 comparator__preamp__mir.n0 comparator__preamp__mir.t1 381.113
rmesh_equiv_2890 vgnd.n6075 vgnd.n6145 5220081034.2636366
rmesh_equiv_2891 vgnd.n6075 vgnd.n6147 523980583.54047161
rmesh_equiv_2892 vgnd.n6075 vgnd.n6151 17654439.823488634
rmesh_equiv_2893 vgnd.n6075 vgnd.t16 386425.1230438879
rmesh_equiv_2894 vgnd.n6077 vgnd.n6100 204.18028205243399
rmesh_equiv_2895 vgnd.n6077 vgnd.n6145 523980218.74451524
rmesh_equiv_2896 vgnd.n6077 vgnd.n6147 52596015.077023573
rmesh_equiv_2897 vgnd.n6077 vgnd.n6151 1772113.7238683451
rmesh_equiv_2898 vgnd.n6077 vgnd.t16 7906.3425138218818
rmesh_equiv_2899 vgnd.n6100 vgnd.n6322 341.39340516911398
rmesh_equiv_29 bias bias.n17 0.020083299999999998
rmesh_equiv_290 comparator__preamp__mir.n1 comparator__preamp__mir.n6 0.27035799999999999
rmesh_equiv_2900 vgnd.n6100 vgnd.n6960 1103.9697309521248
rmesh_equiv_2901 vgnd.n6100 vgnd.t16 559.33691072064642
rmesh_equiv_2902 vgnd.n6100 vgnd.t26 4226.7827416563905
rmesh_equiv_2903 vgnd.n6145 vgnd.n6147 357.15092569707861
rmesh_equiv_2904 vgnd.n6145 vgnd.n6151 266.52483240118977
rmesh_equiv_2905 vgnd.n6145 vgnd.t16 472856.81126904907
rmesh_equiv_2906 vgnd.n6147 vgnd.n6151 180.61891073707645
rmesh_equiv_2907 vgnd.n6147 vgnd.t16 47464.363609845561
rmesh_equiv_2908 vgnd.n6151 vgnd.n6307 5155.221334496604
rmesh_equiv_2909 vgnd.n6151 vgnd.n6330 47512.771566297546
rmesh_equiv_291 comparator__preamp__mir.n2 comparator__preamp__mir.n3 13.389300000000002
rmesh_equiv_2910 vgnd.n6151 vgnd.t106 381.14910359938943
rmesh_equiv_2911 vgnd.n6151 vgnd.t16 57.943824069926592
rmesh_equiv_2912 vgnd.n618 vgnd.n637 21412.27714249814
rmesh_equiv_2913 vgnd.n618 vgnd.t13 4448.6299496267256
rmesh_equiv_2914 vgnd.n618 vgnd.t63 7265395.5297263432
rmesh_equiv_2915 vgnd.n63 vgnd.n69 1865.625628606045
rmesh_equiv_2916 vgnd.n63 vgnd.n70 1393.8807576849292
rmesh_equiv_2917 vgnd.n63 vgnd.n72 110.70646407053155
rmesh_equiv_2918 vgnd.n630 vgnd.n632 374.98945171125263
rmesh_equiv_2919 vgnd.n630 vgnd.n637 6875.4189529390596
rmesh_equiv_292 comparator__preamp__mir.n2 comparator__preamp__mir.n5 0.75515399999999999
rmesh_equiv_2920 vgnd.n630 vgnd.n748 1182775127.7317681
rmesh_equiv_2921 vgnd.n630 vgnd.t0 14543.090297536286
rmesh_equiv_2922 vgnd.n630 vgnd.t34 4645024.3261067886
rmesh_equiv_2923 vgnd.n630 vgnd.t78 1346.8819135683632
rmesh_equiv_2924 vgnd.n6307 vgnd.n6322 225.37031509396948
rmesh_equiv_2925 vgnd.n6307 vgnd.n6330 147192.61017499008
rmesh_equiv_2926 vgnd.n6307 vgnd.t106 492.46712605627499
rmesh_equiv_2927 vgnd.n632 vgnd.n637 21439.456672536875
rmesh_equiv_2928 vgnd.n632 vgnd.n748 10494647.840542126
rmesh_equiv_2929 vgnd.n632 vgnd.t0 129.03941552993226
rmesh_equiv_293 comparator__preamp__mir.n3 comparator__preamp__mir.n4 14.121399999999998
rmesh_equiv_2930 vgnd.n632 vgnd.t34 41214.845806511912
rmesh_equiv_2931 vgnd.n632 vgnd.t78 5.0508655398044926
rmesh_equiv_2932 vgnd.n6322 vgnd.n6960 10538.917190941342
rmesh_equiv_2933 vgnd.n6322 vgnd.t106 40.708337719897379
rmesh_equiv_2934 vgnd.n6322 vgnd.t26 40350.484301773409
rmesh_equiv_2935 vgnd.n6330 vgnd.n6518 5523.5258261508579
rmesh_equiv_2936 vgnd.n6330 vgnd.t106 318.64093049369387
rmesh_equiv_2937 vgnd.n637 vgnd.t13 681.16104772611845
rmesh_equiv_2938 vgnd.n637 vgnd.t63 30847.028298113626
rmesh_equiv_2939 vgnd.n637 vgnd.t78 18.137556477559979
rmesh_equiv_294 comparator__preamp__mir.n3 comparator__preamp__mir.t2 1.7404999999999999
rmesh_equiv_2940 vgnd.n6518 vgnd.n6523 238.4543703235756
rmesh_equiv_2941 vgnd.n6518 vgnd.t103 57.905281284029854
rmesh_equiv_2942 vgnd.n6518 vgnd.t106 392.44346996613598
rmesh_equiv_2943 vgnd.n6523 vgnd.n6591 14692.595505890262
rmesh_equiv_2944 vgnd.n6523 vgnd.n6593 672539.90026616387
rmesh_equiv_2945 vgnd.n6523 vgnd.n6594 16289.465536769065
rmesh_equiv_2946 vgnd.n6523 vgnd.t103 4000597.179374103
rmesh_equiv_2947 vgnd.n6591 vgnd.n6593 351.40781264633995
rmesh_equiv_2948 vgnd.n6591 vgnd.n6594 257.01042453533478
rmesh_equiv_2949 vgnd.n6591 vgnd.t103 491.7752149220193
rmesh_equiv_295 comparator__preamp__mir.n4 comparator__preamp__mir.n5 1.13588
rmesh_equiv_2950 vgnd.n6593 vgnd.n6594 187.82760703755619
rmesh_equiv_2951 vgnd.n6593 vgnd.t103 3719.2282012422102
rmesh_equiv_2952 vgnd.n6594 vgnd.n6962 42406.791326486993
rmesh_equiv_2953 vgnd.n6594 vgnd.t103 41.596607422491807
rmesh_equiv_2954 vgnd.n6594 vgnd.t76 1885.554649274758
rmesh_equiv_2955 vgnd.n6619 vgnd.n6643 21305.6528786134
rmesh_equiv_2956 vgnd.n6619 vgnd.n6776 2444.2121839074703
rmesh_equiv_2957 vgnd.n6619 vgnd.n6804 58.323004755724597
rmesh_equiv_2958 vgnd.n6619 vgnd.n6806 3497.9848397735364
rmesh_equiv_2959 vgnd.n6619 vgnd.t103 62615.319858635659
rmesh_equiv_296 comparator__preamp__mir.n5 comparator__preamp__mir.n6 19.6738
rmesh_equiv_2960 vgnd.n6619 vgnd.t30 17074.104095630344
rmesh_equiv_2961 vgnd.n6619 vgnd.t33 278.46917326315935
rmesh_equiv_2962 vgnd.n6643 vgnd.n6776 414.94890605689096
rmesh_equiv_2963 vgnd.n6643 vgnd.n6804 42441.300947797623
rmesh_equiv_2964 vgnd.n6643 vgnd.n6806 7762.9346350236683
rmesh_equiv_2965 vgnd.n6643 vgnd.n6810 177126.1083276734
rmesh_equiv_2966 vgnd.n6643 vgnd.n6812 4716.8093569849243
rmesh_equiv_2967 vgnd.n6643 vgnd.t33 456.64165640921323
rmesh_equiv_2968 vgnd.n67 vgnd.n69 1185.7931410388053
rmesh_equiv_2969 vgnd.n67 vgnd.n70 6276.5027873174149
rmesh_equiv_297 comparator__preamp__mir.n6 comparator__preamp__mir.n7 19.054500000000001
rmesh_equiv_2970 vgnd.n67 vgnd.n72 1411.316577695012
rmesh_equiv_2971 vgnd.n67 vgnd.t110 454.68374587869602
rmesh_equiv_2972 vgnd.n6776 vgnd.n6804 11155.041913803541
rmesh_equiv_2973 vgnd.n6776 vgnd.n6806 818.58975762121111
rmesh_equiv_2974 vgnd.n6776 vgnd.n6810 62935.217836901487
rmesh_equiv_2975 vgnd.n6776 vgnd.n6812 1675.2699445376415
rmesh_equiv_2976 vgnd.n6776 vgnd.t33 429.88746144751229
rmesh_equiv_2977 vgnd.n6804 vgnd.n6806 1521.8371023443931
rmesh_equiv_2978 vgnd.n6804 vgnd.n6810 152.41135331134313
rmesh_equiv_2979 vgnd.n6804 vgnd.n6812 886.55748949884435
rmesh_equiv_298 comparator__preamp__mir.n7 comparator__preamp__mir.n8 2.4407800000000002
rmesh_equiv_2980 vgnd.n6804 vgnd.t33 6398.1511201088188
rmesh_equiv_2981 vgnd.n6806 vgnd.n6810 3609.0812621729187
rmesh_equiv_2982 vgnd.n6806 vgnd.n6816 8567.1589598757546
rmesh_equiv_2983 vgnd.n6806 vgnd.n6818 110.6999450030161
rmesh_equiv_2984 vgnd.n6806 vgnd.t33 1073.054496698617
rmesh_equiv_2985 vgnd.n6810 vgnd.n6812 1128.8678827646211
rmesh_equiv_2986 vgnd.n6810 vgnd.n6816 153.06121073592419
rmesh_equiv_2987 vgnd.n6810 vgnd.n6818 1882.1531099845897
rmesh_equiv_2988 vgnd.n6810 vgnd.t33 30802.154820411517
rmesh_equiv_2989 vgnd.n6812 vgnd.n6816 3609.0812621729187
rmesh_equiv_299 comparator__preamp__mir.n8 comparator__preamp__mir.t1 387.11000000000001
rmesh_equiv_2990 vgnd.n6812 vgnd.n6822 8567.1589598757546
rmesh_equiv_2991 vgnd.n6812 vgnd.n6824 110.6999450030161
rmesh_equiv_2992 vgnd.n6812 vgnd.t33 913.01419446918726
rmesh_equiv_2993 vgnd.n6816 vgnd.n6818 1403.1048880495202
rmesh_equiv_2994 vgnd.n6816 vgnd.n6822 153.06121073592419
rmesh_equiv_2995 vgnd.n6816 vgnd.n6824 1882.1531099845897
rmesh_equiv_2996 vgnd.n6818 vgnd.n6822 3609.0812621729187
rmesh_equiv_2997 vgnd.n6818 vgnd.n6828 8567.1589598757546
rmesh_equiv_2998 vgnd.n6818 vgnd.n6830 110.6999450030161
rmesh_equiv_2999 vgnd.n6822 vgnd.n6824 1403.1048880495202
rmesh_equiv_3 amplified amplified.n3 33.9895
rmesh_equiv_30 bias bias.n2 17.426825582072382
rmesh_equiv_300 comparator__preamp__tail comparator__preamp__tail.n0 19.837
rmesh_equiv_3000 vgnd.n6822 vgnd.n6828 153.06121073592419
rmesh_equiv_3001 vgnd.n6822 vgnd.n6830 1882.1531099845897
rmesh_equiv_3002 vgnd.n6824 vgnd.n6828 3609.0812621729187
rmesh_equiv_3003 vgnd.n6824 vgnd.n6834 8567.1589598757546
rmesh_equiv_3004 vgnd.n6824 vgnd.n6836 110.6999450030161
rmesh_equiv_3005 vgnd.n6828 vgnd.n6830 1403.1048880495202
rmesh_equiv_3006 vgnd.n6828 vgnd.n6834 153.06121073592419
rmesh_equiv_3007 vgnd.n6828 vgnd.n6836 1882.1531099845897
rmesh_equiv_3008 vgnd.n6830 vgnd.n6834 3609.0812621729187
rmesh_equiv_3009 vgnd.n6830 vgnd.n6840 8567.1589598757546
rmesh_equiv_301 comparator__preamp__tail comparator__preamp__tail.n1 7.0733300000000003
rmesh_equiv_3010 vgnd.n6830 vgnd.n6842 110.6999450030161
rmesh_equiv_3011 vgnd.n6834 vgnd.n6836 1403.1048880495202
rmesh_equiv_3012 vgnd.n6834 vgnd.n6840 153.06121073592419
rmesh_equiv_3013 vgnd.n6834 vgnd.n6842 1882.1531099845897
rmesh_equiv_3014 vgnd.n6836 vgnd.n6840 3609.0812621729187
rmesh_equiv_3015 vgnd.n6836 vgnd.n6846 8567.1589598757546
rmesh_equiv_3016 vgnd.n6836 vgnd.n6848 110.6999450030161
rmesh_equiv_3017 vgnd.n6840 vgnd.n6842 1403.1048880495202
rmesh_equiv_3018 vgnd.n6840 vgnd.n6846 153.06121073592419
rmesh_equiv_3019 vgnd.n6840 vgnd.n6848 1882.1531099845897
rmesh_equiv_302 comparator__preamp__tail comparator__preamp__tail.n11 4.2590000000000003
rmesh_equiv_3020 vgnd.n6842 vgnd.n6846 3609.0812621729187
rmesh_equiv_3021 vgnd.n6842 vgnd.n6852 8567.1589598757546
rmesh_equiv_3022 vgnd.n6842 vgnd.n6854 110.6999450030161
rmesh_equiv_3023 vgnd.n6846 vgnd.n6848 1403.1048880495202
rmesh_equiv_3024 vgnd.n6846 vgnd.n6852 153.06121073592419
rmesh_equiv_3025 vgnd.n6846 vgnd.n6854 1882.1531099845897
rmesh_equiv_3026 vgnd.n6848 vgnd.n6852 3609.0812621729187
rmesh_equiv_3027 vgnd.n6848 vgnd.n6858 8567.1589598757546
rmesh_equiv_3028 vgnd.n6848 vgnd.n6860 110.6999450030161
rmesh_equiv_3029 vgnd.n6852 vgnd.n6854 1403.1048880495202
rmesh_equiv_303 comparator__preamp__tail comparator__preamp__tail.n3 26.391300000000001
rmesh_equiv_3030 vgnd.n6852 vgnd.n6858 153.06121073592419
rmesh_equiv_3031 vgnd.n6852 vgnd.n6860 1882.1531099845897
rmesh_equiv_3032 vgnd.n6854 vgnd.n6858 3609.0812621729187
rmesh_equiv_3033 vgnd.n6854 vgnd.n6864 8567.1589598757546
rmesh_equiv_3034 vgnd.n6854 vgnd.n6866 110.6999450030161
rmesh_equiv_3035 vgnd.n6858 vgnd.n6860 1403.1048880495202
rmesh_equiv_3036 vgnd.n6858 vgnd.n6864 153.06121073592419
rmesh_equiv_3037 vgnd.n6858 vgnd.n6866 1882.1531099845897
rmesh_equiv_3038 vgnd.n6860 vgnd.n6864 3609.0812621729187
rmesh_equiv_3039 vgnd.n6860 vgnd.n6870 8567.1589598757546
rmesh_equiv_304 comparator__preamp__tail comparator__preamp__tail.n5 6.3200399999999997
rmesh_equiv_3040 vgnd.n6860 vgnd.n6872 110.6999450030161
rmesh_equiv_3041 vgnd.n6864 vgnd.n6866 1403.1048880495202
rmesh_equiv_3042 vgnd.n6864 vgnd.n6870 153.06121073592419
rmesh_equiv_3043 vgnd.n6864 vgnd.n6872 1882.1531099845897
rmesh_equiv_3044 vgnd.n6866 vgnd.n6870 1981.4596666628888
rmesh_equiv_3045 vgnd.n6866 vgnd.n6878 2369.4912303103133
rmesh_equiv_3046 vgnd.n6866 vgnd.n6884 18793.376677038192
rmesh_equiv_3047 vgnd.n6870 vgnd.n6872 1403.1048880495202
rmesh_equiv_3048 vgnd.n6870 vgnd.n6878 152.64167680984821
rmesh_equiv_3049 vgnd.n6870 vgnd.n6884 319530.53236689098
rmesh_equiv_305 comparator__preamp__tail comparator__preamp__tail.n7 33.130400000000002
rmesh_equiv_3050 vgnd.n6872 vgnd.n6878 1767.8733663500602
rmesh_equiv_3051 vgnd.n6872 vgnd.n6884 4060.292683055171
rmesh_equiv_3052 vgnd.n6872 vgnd.n6887 3908555.3892683177
rmesh_equiv_3053 vgnd.n6878 vgnd.n6884 443.37357052476523
rmesh_equiv_3054 vgnd.n6878 vgnd.n6887 93661.002829012927
rmesh_equiv_3055 vgnd.n6884 vgnd.n6887 93938.371373603019
rmesh_equiv_3056 vgnd.n6887 vgnd.n6997 8401.3817366598178
rmesh_equiv_3057 vgnd.n6887 vgnd.n7088 5161364.193446924
rmesh_equiv_3058 vgnd.n6887 vgnd.t29 4705.3900000000003
rmesh_equiv_3059 vgnd.n6887 vgnd.t65 1030.3776293971159
rmesh_equiv_306 comparator__preamp__tail.n0 comparator__preamp__tail.n10 14.189499999999999
rmesh_equiv_3060 vgnd.n6887 vgnd.t81 98009.592908737555
rmesh_equiv_3061 vgnd.n69 vgnd.n70 114.68822956933883
rmesh_equiv_3062 vgnd.n69 vgnd.n72 3363.4930645832424
rmesh_equiv_3063 vgnd.n69 vgnd.t110 113.65010820264291
rmesh_equiv_3064 vgnd.n6960 vgnd.n6962 8311.4910877656057
rmesh_equiv_3065 vgnd.n6960 vgnd.t118 5075.7099764421982
rmesh_equiv_3066 vgnd.n6960 vgnd.t26 130482.05566932491
rmesh_equiv_3067 vgnd.n6960 vgnd.t52 17074.104095630344
rmesh_equiv_3068 vgnd.n6960 vgnd.t53 348261.21382144047
rmesh_equiv_3069 vgnd.n6960 vgnd.t55 579.09388999283283
rmesh_equiv_307 comparator__preamp__tail.n0 comparator__preamp__tail.t0 174.91200000000001
rmesh_equiv_3070 vgnd.n6960 vgnd.t57 17074.10409563034
rmesh_equiv_3071 vgnd.n6962 vgnd.n6964 5357.9272175417445
rmesh_equiv_3072 vgnd.n6962 vgnd.t118 4066.8866656940068
rmesh_equiv_3073 vgnd.n6962 vgnd.t68 3422.7839105167454
rmesh_equiv_3074 vgnd.n6962 vgnd.t76 584.92535584918085
rmesh_equiv_3075 vgnd.n6964 vgnd.n6966 5492.7339353116167
rmesh_equiv_3076 vgnd.n6964 vgnd.t29 14119.684863161981
rmesh_equiv_3077 vgnd.n6964 vgnd.t48 3354.3348767397515
rmesh_equiv_3078 vgnd.n6964 vgnd.t68 2573.7690257770064
rmesh_equiv_3079 vgnd.n6966 vgnd.n6970 3654.2993987316599
rmesh_equiv_308 comparator__preamp__tail.n1 comparator__preamp__tail.n2 14.985300000000001
rmesh_equiv_3080 vgnd.n6966 vgnd.t101 70743.116460420148
rmesh_equiv_3081 vgnd.n6966 vgnd.t18 59375.233799731126
rmesh_equiv_3082 vgnd.n6966 vgnd.t29 38852.907776851047
rmesh_equiv_3083 vgnd.n6966 vgnd.t48 4460.8367462670403
rmesh_equiv_3084 vgnd.n6966 vgnd.t70 582.26917267348097
rmesh_equiv_3085 vgnd.n6970 vgnd.n6974 886.15467440809641
rmesh_equiv_3086 vgnd.n6970 vgnd.n6979 727.59491236523218
rmesh_equiv_3087 vgnd.n6970 vgnd.n6983 142981.72789564708
rmesh_equiv_3088 vgnd.n6970 vgnd.n6984 28106.412936703277
rmesh_equiv_3089 vgnd.n6970 vgnd.t18 21677.893521099239
rmesh_equiv_309 comparator__preamp__tail.n1 comparator__preamp__tail.n4 0.24337299999999998
rmesh_equiv_3090 vgnd.n6970 vgnd.t22 10706.407540296175
rmesh_equiv_3091 vgnd.n6974 vgnd.n6979 346.31551916013473
rmesh_equiv_3092 vgnd.n6974 vgnd.n6983 5499.091020359815
rmesh_equiv_3093 vgnd.n6974 vgnd.n6984 467.42675373824159
rmesh_equiv_3094 vgnd.n6974 vgnd.t101 50717.315618273897
rmesh_equiv_3095 vgnd.n6974 vgnd.t22 1417.4895261903011
rmesh_equiv_3096 vgnd.n6979 vgnd.n6983 3207.1951596696331
rmesh_equiv_3097 vgnd.n6979 vgnd.n6984 21220.67521295623
rmesh_equiv_3098 vgnd.n6979 vgnd.t101 33562.874129377749
rmesh_equiv_3099 vgnd.n6979 vgnd.t22 2745.5079922933419
rmesh_equiv_31 bias bias.n4 20.552661570267531
rmesh_equiv_310 comparator__preamp__tail.n10 comparator__preamp__tail.n11 3.0467200000000001
rmesh_equiv_3100 vgnd.n6983 vgnd.n6984 503.56188776217317
rmesh_equiv_3101 vgnd.n6983 vgnd.t101 761.02156319921312
rmesh_equiv_3102 vgnd.n6983 vgnd.t22 209.55258849607134
rmesh_equiv_3103 vgnd.n6984 vgnd.t101 11063.430806860792
rmesh_equiv_3104 vgnd.n6984 vgnd.t22 2190.1450739222014
rmesh_equiv_3105 vgnd.n6997 vgnd.n7088 5448817.46189065
rmesh_equiv_3106 vgnd.n6997 vgnd.t18 2096565.4013296501
rmesh_equiv_3107 vgnd.n6997 vgnd.t50 1590.2740247316397
rmesh_equiv_3108 vgnd.n6997 vgnd.t65 1087.7627326761192
rmesh_equiv_3109 vgnd.n6997 vgnd.t81 19271.565025887918
rmesh_equiv_311 comparator__preamp__tail.n10 comparator__preamp__tail.n9 21.145199999999999
rmesh_equiv_3110 vgnd.n70 vgnd.n72 8458.9610552708637
rmesh_equiv_3111 vgnd.n7044 vgnd.n7109 751439.01518246788
rmesh_equiv_3112 vgnd.n7044 vgnd.t129 14368.757619367647
rmesh_equiv_3113 vgnd.n7044 vgnd.t136 126.859487229886
rmesh_equiv_3114 vgnd.n7044 vgnd.t31 2449.8334623639853
rmesh_equiv_3115 vgnd.n7044 vgnd.t46 120912168.88476741
rmesh_equiv_3116 vgnd.n7044 vgnd.t64 11515.502324840298
rmesh_equiv_3117 vgnd.n7044 vgnd.t66 992.66980991806929
rmesh_equiv_3118 vgnd.n7044 vgnd.t82 855.1407315829199
rmesh_equiv_3119 vgnd.n7044 vgnd.t85 53.28528218929921
rmesh_equiv_312 comparator__preamp__tail.n11 comparator__preamp__tail.t0 181.41
rmesh_equiv_3120 vgnd.n7088 vgnd.t19 1787623.5541101706
rmesh_equiv_3121 vgnd.n7088 vgnd.t2 17.541744317522319
rmesh_equiv_3122 vgnd.n7088 vgnd.t65 1244.9892079910244
rmesh_equiv_3123 vgnd.n7088 vgnd.t81 63565303.662328623
rmesh_equiv_3124 vgnd.n7088 vgnd.t88 581451448.25727952
rmesh_equiv_3125 vgnd.n7088 vgnd.t99 5599.824069683822
rmesh_equiv_3126 vgnd.n7097 vgnd.n7101 25.665476823798841
rmesh_equiv_3127 vgnd.n7097 vgnd.t123 8993.2892879319606
rmesh_equiv_3128 vgnd.n7097 vgnd.t125 1617.1477115016944
rmesh_equiv_3129 vgnd.n7097 vgnd.t131 1881.3032210520398
rmesh_equiv_313 comparator__preamp__tail.n2 comparator__preamp__tail.n3 11.248699999999999
rmesh_equiv_3130 vgnd.n7097 vgnd.t47 12.90461767455867
rmesh_equiv_3131 vgnd.n7097 vgnd.t60 62.207260213136607
rmesh_equiv_3132 vgnd.n7097 vgnd.t61 6.74892
rmesh_equiv_3133 vgnd.n7097 vgnd.t87 25.784536874536961
rmesh_equiv_3134 vgnd.n7097 vgnd.t94 9672.0066196504431
rmesh_equiv_3135 vgnd.n7101 vgnd.n7105 25.665476823798841
rmesh_equiv_3136 vgnd.n7101 vgnd.t104 25.784536874536961
rmesh_equiv_3137 vgnd.n7101 vgnd.t105 62.207260213136607
rmesh_equiv_3138 vgnd.n7101 vgnd.t116 6.74892
rmesh_equiv_3139 vgnd.n7101 vgnd.t44 12.90461767455867
rmesh_equiv_314 comparator__preamp__tail.n2 comparator__preamp__tail.t1 1.7404999999999999
rmesh_equiv_3140 vgnd.n7101 vgnd.t47 62.207260213136607
rmesh_equiv_3141 vgnd.n7101 vgnd.t60 12.90461767455867
rmesh_equiv_3142 vgnd.n7101 vgnd.t87 25.784536874536961
rmesh_equiv_3143 vgnd.n7105 vgnd.n7109 25.672335866906209
rmesh_equiv_3144 vgnd.n7105 vgnd.t104 25.784536874536961
rmesh_equiv_3145 vgnd.n7105 vgnd.t105 12.90461767455867
rmesh_equiv_3146 vgnd.n7105 vgnd.t20 62.189043541842949
rmesh_equiv_3147 vgnd.n7105 vgnd.t32 25.782970151756253
rmesh_equiv_3148 vgnd.n7105 vgnd.t4 6.74892
rmesh_equiv_3149 vgnd.n7105 vgnd.t44 62.207260213136607
rmesh_equiv_315 comparator__preamp__tail.n3 comparator__preamp__tail.n4 3.1501399999999999
rmesh_equiv_3150 vgnd.n7105 vgnd.t67 12.904455006251116
rmesh_equiv_3151 vgnd.n7109 vgnd.t129 11954291.462544993
rmesh_equiv_3152 vgnd.n7109 vgnd.t20 12.908066405689658
rmesh_equiv_3153 vgnd.n7109 vgnd.t25 39.479199999999999
rmesh_equiv_3154 vgnd.n7109 vgnd.t31 74397019.334798142
rmesh_equiv_3155 vgnd.n7109 vgnd.t32 25.791427736185089
rmesh_equiv_3156 vgnd.n7109 vgnd.t46 2192.5484099761902
rmesh_equiv_3157 vgnd.n7109 vgnd.t64 13910188.401611261
rmesh_equiv_3158 vgnd.n7109 vgnd.t67 62.223884968730374
rmesh_equiv_3159 vgnd.n72 vgnd.t110 455.61231007659239
rmesh_equiv_316 comparator__preamp__tail.n4 comparator__preamp__tail.n9 20.086099999999998
rmesh_equiv_3160 vgnd.n748 vgnd.n9783 7617142651235.0527
rmesh_equiv_3161 vgnd.n748 vgnd.t0 33181.046039542627
rmesh_equiv_3162 vgnd.n748 vgnd.t115 5655.7366447609666
rmesh_equiv_3163 vgnd.n748 vgnd.t121 17.541484955385094
rmesh_equiv_3164 vgnd.n748 vgnd.t15 1472907.250141033
rmesh_equiv_3165 vgnd.n748 vgnd.t24 217133081447.03265
rmesh_equiv_3166 vgnd.n748 vgnd.t3 382308080.60020006
rmesh_equiv_3167 vgnd.n748 vgnd.t34 103.92786531043541
rmesh_equiv_3168 vgnd.n7594 vgnd.n7600 43076933866.142448
rmesh_equiv_3169 vgnd.n7594 vgnd.n7602 1783.2168918198217
rmesh_equiv_317 comparator__preamp__tail.n5 comparator__preamp__tail.n6 13.389300000000002
rmesh_equiv_3170 vgnd.n7594 vgnd.n7604 4019.7716882168161
rmesh_equiv_3171 vgnd.n7594 vgnd.n7768 447.54978542517313
rmesh_equiv_3172 vgnd.n7594 vgnd.n9342 468604110.82727748
rmesh_equiv_3173 vgnd.n7594 vgnd.n9346 584.99996677715012
rmesh_equiv_3174 vgnd.n7594 vgnd.n9348 1526.3331025957209
rmesh_equiv_3175 vgnd.n7594 vgnd.t62 5968.442178090957
rmesh_equiv_3176 vgnd.n7600 vgnd.n7602 5118.747199005953
rmesh_equiv_3177 vgnd.n7600 vgnd.n7604 500156.52029880276
rmesh_equiv_3178 vgnd.n7600 vgnd.n7768 3766999528.9574976
rmesh_equiv_3179 vgnd.n7600 vgnd.n9069 699.58676378183679
rmesh_equiv_318 comparator__preamp__tail.n5 comparator__preamp__tail.n8 0.75515399999999999
rmesh_equiv_3180 vgnd.n7600 vgnd.n9329 2258.8404564474886
rmesh_equiv_3181 vgnd.n7600 vgnd.n9336 1465.7497780103745
rmesh_equiv_3182 vgnd.n7600 vgnd.n9342 354.46240993826751
rmesh_equiv_3183 vgnd.n7600 vgnd.n9346 12825.304958689383
rmesh_equiv_3184 vgnd.n7600 vgnd.n9348 19764.85262685499
rmesh_equiv_3185 vgnd.n7600 vgnd.t27 3623.3446593911845
rmesh_equiv_3186 vgnd.n7600 vgnd.t62 1757.1793885606248
rmesh_equiv_3187 vgnd.n7602 vgnd.n7604 5968.4427350427359
rmesh_equiv_3188 vgnd.n7602 vgnd.n7768 2647.6658026470873
rmesh_equiv_3189 vgnd.n7602 vgnd.n9278 649.48877929188166
rmesh_equiv_319 comparator__preamp__tail.n6 comparator__preamp__tail.n7 14.121399999999998
rmesh_equiv_3190 vgnd.n7602 vgnd.n9280 2276.1186774843281
rmesh_equiv_3191 vgnd.n7602 vgnd.n9282 5791.4233769785797
rmesh_equiv_3192 vgnd.n7602 vgnd.n9286 1390.4100260111372
rmesh_equiv_3193 vgnd.n7602 vgnd.n9288 10323.368995292376
rmesh_equiv_3194 vgnd.n7602 vgnd.n9342 1533.1244549705668
rmesh_equiv_3195 vgnd.n7602 vgnd.n9346 5.0614230660983264
rmesh_equiv_3196 vgnd.n7602 vgnd.n9348 7543.3235267709169
rmesh_equiv_3197 vgnd.n7602 vgnd.t62 5.0601197039029486
rmesh_equiv_3198 vgnd.n7604 vgnd.n7768 5968.4427350427359
rmesh_equiv_3199 vgnd.n7604 vgnd.n9069 699.58676378183679
rmesh_equiv_32 bias bias.n5 40.495399999999997
rmesh_equiv_320 comparator__preamp__tail.n6 comparator__preamp__tail.t2 1.7404999999999999
rmesh_equiv_3200 vgnd.n7604 vgnd.n9329 2258.8404564474886
rmesh_equiv_3201 vgnd.n7604 vgnd.n9336 1465.7497780103745
rmesh_equiv_3202 vgnd.n7604 vgnd.n9342 490785317.54776579
rmesh_equiv_3203 vgnd.n7604 vgnd.t27 3623.3446593911845
rmesh_equiv_3204 vgnd.n7604 vgnd.t62 1783.2170582226763
rmesh_equiv_3205 vgnd.n7768 vgnd.n9342 40978577.310984872
rmesh_equiv_3206 vgnd.n7768 vgnd.n9346 900794249.97358966
rmesh_equiv_3207 vgnd.n7768 vgnd.n9348 285.51521355308319
rmesh_equiv_3208 vgnd.n7768 vgnd.t62 8861.7600710820498
rmesh_equiv_3209 vgnd.n7780 vgnd.n8515 3502684.0268522077
rmesh_equiv_321 comparator__preamp__tail.n7 comparator__preamp__tail.n8 1.13588
rmesh_equiv_3210 vgnd.n7780 vgnd.n9329 81.673103213623634
rmesh_equiv_3211 vgnd.n7780 vgnd.t102 23.974678605234676
rmesh_equiv_3212 vgnd.n7780 vgnd.t14 4987.1568651954876
rmesh_equiv_3213 vgnd.n7780 vgnd.t45 12473.808556303515
rmesh_equiv_3214 vgnd.n7780 vgnd.t95 1067457.670315854
rmesh_equiv_3215 vgnd.n8515 vgnd.n9329 74531817.319207504
rmesh_equiv_3216 vgnd.n8515 vgnd.t102 1071803.0823810531
rmesh_equiv_3217 vgnd.n8515 vgnd.t14 5005.780256468016
rmesh_equiv_3218 vgnd.n8515 vgnd.t45 139.262396336775
rmesh_equiv_3219 vgnd.n8515 vgnd.t95 23.978718597359226
rmesh_equiv_322 comparator__preamp__tail.n8 comparator__preamp__tail.n9 19.4712
rmesh_equiv_3220 vgnd.n9069 vgnd.n9278 5940.2059399182508
rmesh_equiv_3221 vgnd.n9069 vgnd.n9280 1732.2950718608442
rmesh_equiv_3222 vgnd.n9069 vgnd.n9282 1871.887733806946
rmesh_equiv_3223 vgnd.n9069 vgnd.n9313 1772.8808843845275
rmesh_equiv_3224 vgnd.n9069 vgnd.n9314 5048.4773966684816
rmesh_equiv_3225 vgnd.n9069 vgnd.n9329 16543.473695270492
rmesh_equiv_3226 vgnd.n9069 vgnd.n9336 4.2351251890700619
rmesh_equiv_3227 vgnd.n9069 vgnd.t27 5.0646812623022788
rmesh_equiv_3228 vgnd.n9278 vgnd.n9280 1627432.4490860575
rmesh_equiv_3229 vgnd.n9278 vgnd.n9282 4140887.0386791984
rmesh_equiv_323 d d.n0 12.8005
rmesh_equiv_3230 vgnd.n9278 vgnd.n9286 394507.86014357395
rmesh_equiv_3231 vgnd.n9278 vgnd.n9288 4666.7661371975319
rmesh_equiv_3232 vgnd.n9278 vgnd.n9313 4000.7540860304121
rmesh_equiv_3233 vgnd.n9278 vgnd.n9314 12140.364430545695
rmesh_equiv_3234 vgnd.n9278 vgnd.n9346 1613.1462316147652
rmesh_equiv_3235 vgnd.n9278 vgnd.n9348 4528.5532317027901
rmesh_equiv_3236 vgnd.n9278 vgnd.t27 1782.4607127274287
rmesh_equiv_3237 vgnd.n9278 vgnd.t62 3622.4827429130123
rmesh_equiv_3238 vgnd.n9280 vgnd.n9282 410.14472932285395
rmesh_equiv_3239 vgnd.n9280 vgnd.n9286 1200.5952626641006
rmesh_equiv_324 d d.n1 12.8005
rmesh_equiv_3240 vgnd.n9280 vgnd.n9288 2546.4048448066474
rmesh_equiv_3241 vgnd.n9280 vgnd.n9313 1115498.496840405
rmesh_equiv_3242 vgnd.n9280 vgnd.n9314 54317.556209131493
rmesh_equiv_3243 vgnd.n9280 vgnd.n9329 11142.100232370209
rmesh_equiv_3244 vgnd.n9280 vgnd.n9336 4964.2909396055275
rmesh_equiv_3245 vgnd.n9280 vgnd.t27 585
rmesh_equiv_3246 vgnd.n9280 vgnd.t62 11788.619912733528
rmesh_equiv_3247 vgnd.n9282 vgnd.n9286 947.04231206380928
rmesh_equiv_3248 vgnd.n9282 vgnd.n9288 179.49517443424796
rmesh_equiv_3249 vgnd.n9282 vgnd.n9313 17897.831480802059
rmesh_equiv_325 d d.n11 12.8005
rmesh_equiv_3250 vgnd.n9282 vgnd.n9314 599.50033320969544
rmesh_equiv_3251 vgnd.n9282 vgnd.n9329 433.1881106199346
rmesh_equiv_3252 vgnd.n9282 vgnd.n9336 1736.4077717522155
rmesh_equiv_3253 vgnd.n9282 vgnd.t62 29995.311589103294
rmesh_equiv_3254 vgnd.n9286 vgnd.n9288 798.37662453972166
rmesh_equiv_3255 vgnd.n9286 vgnd.n9346 667.40376855180762
rmesh_equiv_3256 vgnd.n9286 vgnd.n9348 3365.0708092799391
rmesh_equiv_3257 vgnd.n9286 vgnd.t62 11689.553294063402
rmesh_equiv_3258 vgnd.n9288 vgnd.n9346 1261.394160781754
rmesh_equiv_3259 vgnd.n9288 vgnd.n9348 315.98455031543239
rmesh_equiv_326 d d.n12 12.8005
rmesh_equiv_3260 vgnd.n9288 vgnd.t62 61758.679722950976
rmesh_equiv_3261 vgnd.n9313 vgnd.n9314 454.49467652000533
rmesh_equiv_3262 vgnd.n9313 vgnd.n9329 1689.3505915115595
rmesh_equiv_3263 vgnd.n9313 vgnd.n9336 646.04576866432103
rmesh_equiv_3264 vgnd.n9313 vgnd.t27 5940.2059399182517
rmesh_equiv_3265 vgnd.n9314 vgnd.n9329 400.86577480081377
rmesh_equiv_3266 vgnd.n9314 vgnd.n9336 26641.800823904421
rmesh_equiv_3267 vgnd.n9314 vgnd.t27 18025.667999668098
rmesh_equiv_3268 vgnd.n9329 vgnd.n9336 8.7490242350503937
rmesh_equiv_3269 vgnd.n9329 vgnd.n9342 317.6103331259992
rmesh_equiv_327 d d.n15 12.8005
rmesh_equiv_3270 vgnd.n9329 vgnd.t45 232702.92436530479
rmesh_equiv_3271 vgnd.n9336 vgnd.n9342 2678.8179106616967
rmesh_equiv_3272 vgnd.n9342 vgnd.n9346 1578.2209744022443
rmesh_equiv_3273 vgnd.n9342 vgnd.n9348 301.43774816059573
rmesh_equiv_3274 vgnd.n9342 vgnd.t62 1855.7869786667427
rmesh_equiv_3275 vgnd.n9346 vgnd.n9348 8.8170652428270024
rmesh_equiv_3276 vgnd.n9346 vgnd.t62 19042.6482254652
rmesh_equiv_3277 vgnd.n9348 vgnd.n9783 5664293.771292856
rmesh_equiv_3278 vgnd.n9348 vgnd.t100 104.98062656698077
rmesh_equiv_3279 vgnd.n9348 vgnd.t112 27429.353722888569
rmesh_equiv_328 d d.n16 12.8005
rmesh_equiv_3280 vgnd.n9348 vgnd.t62 29346.291336827846
rmesh_equiv_3281 vgnd.n96 vgnd.t107 76457.649042240766
rmesh_equiv_3282 vgnd.n96 vgnd.t9 6467821.7298023226
rmesh_equiv_3283 vgnd.n9783 vgnd.t100 27429.353376433199
rmesh_equiv_3284 vgnd.n9783 vgnd.t112 104.98062524137288
rmesh_equiv_3285 vgnd.n9783 vgnd.t115 686961888.0542537
rmesh_equiv_3286 vgnd.n9783 vgnd.t121 180485909999.49115
rmesh_equiv_3287 vgnd.n9783 vgnd.t15 2637771.022569993
rmesh_equiv_3288 vgnd.n9783 vgnd.t24 18.19039700770012
rmesh_equiv_3289 vgnd.n9783 vgnd.t3 9390.5707110211752
rmesh_equiv_329 d d.n2 12.8005
rmesh_equiv_3290 vgnd.t0 vgnd.t34 130.30944125018655
rmesh_equiv_3291 vgnd.t10 vgnd.t133 43299.127853892314
rmesh_equiv_3292 vgnd.t10 vgnd.t69 154.53911024652334
rmesh_equiv_3293 vgnd.t10 vgnd.t7 157.90946016145165
rmesh_equiv_3294 vgnd.t100 vgnd.t112 132.82669764858761
rmesh_equiv_3295 vgnd.t101 vgnd.t29 1407.7507812586746
rmesh_equiv_3296 vgnd.t101 vgnd.t70 3145.4870310552456
rmesh_equiv_3297 vgnd.t102 vgnd.t14 188.12730929416014
rmesh_equiv_3298 vgnd.t102 vgnd.t95 40267.018810538772
rmesh_equiv_3299 vgnd.t104 vgnd.t105 62.495834612439701
rmesh_equiv_33 bias bias.n6 40.495399999999997
rmesh_equiv_330 d d.n21 12.8005
rmesh_equiv_3300 vgnd.t104 vgnd.t44 62.495834612439701
rmesh_equiv_3301 vgnd.t105 vgnd.t44 150.77620609941638
rmesh_equiv_3302 vgnd.t107 vgnd.t9 936.87927286765637
rmesh_equiv_3303 vgnd.t109 vgnd.t11 5389.7454097140753
rmesh_equiv_3304 vgnd.t109 vgnd.t126 13251.046783570253
rmesh_equiv_3305 vgnd.t109 vgnd.t56 241082.91728204518
rmesh_equiv_3306 vgnd.t11 vgnd.t126 51.419005047776963
rmesh_equiv_3307 vgnd.t11 vgnd.t56 6396.369351409111
rmesh_equiv_3308 vgnd.t111 vgnd.t114 222499.4043170285
rmesh_equiv_3309 vgnd.t111 vgnd.t130 50921751845.881836
rmesh_equiv_331 d d.n4 12.8005
rmesh_equiv_3310 vgnd.t111 vgnd.t17 21275483.774491813
rmesh_equiv_3311 vgnd.t111 vgnd.t79 2329.52070818009
rmesh_equiv_3312 vgnd.t113 vgnd.t39 85.593101449778629
rmesh_equiv_3313 vgnd.t113 vgnd.t77 34.81423265474578
rmesh_equiv_3314 vgnd.t114 vgnd.t130 5575641.4093482578
rmesh_equiv_3315 vgnd.t114 vgnd.t17 2329.5441346165503
rmesh_equiv_3316 vgnd.t114 vgnd.t79 2326.9580911089806
rmesh_equiv_3317 vgnd.t115 vgnd.t121 134.01098309241212
rmesh_equiv_3318 vgnd.t115 vgnd.t15 132.83605044755507
rmesh_equiv_3319 vgnd.t115 vgnd.t24 19582428.532529347
rmesh_equiv_332 d d.n5 12.8005
rmesh_equiv_3320 vgnd.t115 vgnd.t3 34478.95003317653
rmesh_equiv_3321 vgnd.t117 vgnd.t5 141.92231407890247
rmesh_equiv_3322 vgnd.t117 vgnd.t75 102.79061187828815
rmesh_equiv_3323 vgnd.t117 vgnd.t98 62.051575090717613
rmesh_equiv_3324 vgnd.t119 vgnd.t42 131.67100178174425
rmesh_equiv_3325 vgnd.t119 vgnd.t72 53.556008746835126
rmesh_equiv_3326 vgnd.t12 vgnd.t54 1607293.6642469892
rmesh_equiv_3327 vgnd.t12 vgnd.t58 1545990.877521195
rmesh_equiv_3328 vgnd.t121 vgnd.t15 34900.095424030027
rmesh_equiv_3329 vgnd.t121 vgnd.t24 5144903225.5693779
rmesh_equiv_333 d d.n7 12.8005
rmesh_equiv_3330 vgnd.t121 vgnd.t3 9058675.2784652077
rmesh_equiv_3331 vgnd.t123 vgnd.t125 1503567.9186314465
rmesh_equiv_3332 vgnd.t123 vgnd.t131 1085448.9344407569
rmesh_equiv_3333 vgnd.t123 vgnd.t94 175100.1053105965
rmesh_equiv_3334 vgnd.t125 vgnd.t131 314530.87717167323
rmesh_equiv_3335 vgnd.t125 vgnd.t94 1617041.1510738241
rmesh_equiv_3336 vgnd.t126 vgnd.t56 15725.898549448084
rmesh_equiv_3337 vgnd.t129 vgnd.t31 1422594.1384818102
rmesh_equiv_3338 vgnd.t129 vgnd.t46 1923535082.7052681
rmesh_equiv_3339 vgnd.t129 vgnd.t64 265985.82392472308
rmesh_equiv_334 d d.n8 12.8005
rmesh_equiv_3340 vgnd.t13 vgnd.t63 231124.62062013408
rmesh_equiv_3341 vgnd.t130 vgnd.t17 64468.950145045514
rmesh_equiv_3342 vgnd.t130 vgnd.t79 532553257.09719145
rmesh_equiv_3343 vgnd.t131 vgnd.t94 1167367.0159027746
rmesh_equiv_3344 vgnd.t132 vgnd.t6 53.556008746835126
rmesh_equiv_3345 vgnd.t132 vgnd.t8 131.67100178174425
rmesh_equiv_3346 vgnd.t133 vgnd.t69 153.99141176183778
rmesh_equiv_3347 vgnd.t133 vgnd.t7 12440315.695897255
rmesh_equiv_3348 vgnd.t135 vgnd.t28 682753.47361265006
rmesh_equiv_3349 vgnd.t135 vgnd.t74 798271.80365635175
rmesh_equiv_335 d.n0 d.n20 10.151300000000001
rmesh_equiv_3350 vgnd.t135 vgnd.t92 185583.7793632109
rmesh_equiv_3351 vgnd.t136 vgnd.t66 87311.860277239393
rmesh_equiv_3352 vgnd.t136 vgnd.t85 56.76163500059149
rmesh_equiv_3353 vgnd.t14 vgnd.t95 188.06425458380863
rmesh_equiv_3354 vgnd.t15 vgnd.t24 75191.889729076691
rmesh_equiv_3355 vgnd.t15 vgnd.t3 132.39100577144259
rmesh_equiv_3356 vgnd.t17 vgnd.t79 222504.68158904029
rmesh_equiv_3357 vgnd.t18 vgnd.t50 10373.719799217222
rmesh_equiv_3358 vgnd.t19 vgnd.t2 42357.203601781985
rmesh_equiv_3359 vgnd.t19 vgnd.t88 132.68615069214266
rmesh_equiv_336 d.n0 d.t0 255.34500000000003
rmesh_equiv_3360 vgnd.t19 vgnd.t99 130.22365853689206
rmesh_equiv_3361 vgnd.t2 vgnd.t88 13777317.557579426
rmesh_equiv_3362 vgnd.t2 vgnd.t99 132.68615067663117
rmesh_equiv_3363 vgnd.t20 vgnd.t32 62.477533435495779
rmesh_equiv_3364 vgnd.t20 vgnd.t67 150.73205304435481
rmesh_equiv_3365 vgnd.t21 vgnd.t43 177.82509092204907
rmesh_equiv_3366 vgnd.t23 vgnd.t51 366154.55127179477
rmesh_equiv_3367 vgnd.t23 vgnd.t71 712976.5266389891
rmesh_equiv_3368 vgnd.t24 vgnd.t3 267.68614536839135
rmesh_equiv_3369 vgnd.t27 vgnd.t62 0.81817799999999985
rmesh_equiv_337 d.n1 d.n3 10.151300000000001
rmesh_equiv_3370 vgnd.t28 vgnd.t74 210446.25050696335
rmesh_equiv_3371 vgnd.t28 vgnd.t92 1645788.4605183487
rmesh_equiv_3372 vgnd.t29 vgnd.t41 1629.2748110341452
rmesh_equiv_3373 vgnd.t29 vgnd.t70 1727.5365243379701
rmesh_equiv_3374 vgnd.t29 vgnd.t83 25617533.976827547
rmesh_equiv_3375 vgnd.t29 vgnd.t84 65622.675138781153
rmesh_equiv_3376 vgnd.t29 vgnd.t97 693.11043513485845
rmesh_equiv_3377 vgnd.t31 vgnd.t46 11971037947.967194
rmesh_equiv_3378 vgnd.t31 vgnd.t64 1140104.5617827335
rmesh_equiv_3379 vgnd.t32 vgnd.t67 62.492037233868849
rmesh_equiv_338 d.n1 d.t3 700.48400000000004
rmesh_equiv_3380 vgnd.t36 vgnd.t90 150.14841415478165
rmesh_equiv_3381 vgnd.t39 vgnd.t77 48.391804327644465
rmesh_equiv_3382 vgnd.t42 vgnd.t72 53.556008746835126
rmesh_equiv_3383 vgnd.t46 vgnd.t64 2238253557.843472
rmesh_equiv_3384 vgnd.t47 vgnd.t60 150.77620609941638
rmesh_equiv_3385 vgnd.t47 vgnd.t87 62.495834612439701
rmesh_equiv_3386 vgnd.t5 vgnd.t75 30.403108469234414
rmesh_equiv_3387 vgnd.t5 vgnd.t98 59.612179741422615
rmesh_equiv_3388 vgnd.t51 vgnd.t71 754754.60855119885
rmesh_equiv_3389 vgnd.t53 vgnd.t55 17445.071800106831
rmesh_equiv_339 d.n10 d.n14 0.55314200000000002
rmesh_equiv_3390 vgnd.t54 vgnd.t58 788813.69241030433
rmesh_equiv_3391 vgnd.t6 vgnd.t8 53.556008746835126
rmesh_equiv_3392 vgnd.t60 vgnd.t87 62.495834612439701
rmesh_equiv_3393 vgnd.t65 vgnd.t81 12689.720090408404
rmesh_equiv_3394 vgnd.t66 vgnd.t85 36673.939134836175
rmesh_equiv_3395 vgnd.t69 vgnd.t7 44400.786207914331
rmesh_equiv_3396 vgnd.t74 vgnd.t92 1924247.2921641255
rmesh_equiv_3397 vgnd.t75 vgnd.t98 43.175539172879233
rmesh_equiv_3398 vgnd.t80 vgnd.t86 47.427311413247786
rmesh_equiv_3399 vgnd.t83 vgnd.t84 17634.555374304407
rmesh_equiv_34 bias bias.n8 19.927515343292864
rmesh_equiv_340 d.n10 d.n6 22.836300000000001
rmesh_equiv_3400 vgnd.t83 vgnd.t97 1712522.7811174896
rmesh_equiv_3401 vgnd.t84 vgnd.t97 4386.8518427530598
rmesh_equiv_3402 vgnd.t88 vgnd.t99 42357.203606733638
rmesh_equiv_3403 vin vin.n0 17.311221566658009
rmesh_equiv_3404 vin vin.n1 0.020083299999999998
rmesh_equiv_3405 vin vin.n2 18.978949170096076
rmesh_equiv_3406 vin vin.t0 212.21199999999999
rmesh_equiv_3407 vin vin.t1 212.21199999999999
rmesh_equiv_3408 vin vin.t2 212.21199999999999
rmesh_equiv_3409 vin vin.t3 212.21199999999999
rmesh_equiv_341 d.n10 d.n9 22.2837
rmesh_equiv_3410 vin.n0 vin.n1 18.187899999999999
rmesh_equiv_3411 vin.n1 vin.n2 57.572499999999998
rmesh_equiv_342 d.n11 d.n13 10.151300000000001
rmesh_equiv_343 d.n11 d.t4 255.34500000000003
rmesh_equiv_344 d.n12 d.n13 10.151300000000001
rmesh_equiv_345 d.n12 d.t4 255.34500000000003
rmesh_equiv_346 d.n13 d.n14 22.2837
rmesh_equiv_347 d.n14 d.n18 0.55314200000000002
rmesh_equiv_348 d.n15 d.n17 10.151300000000001
rmesh_equiv_349 d.n15 d.t1 700.48400000000004
rmesh_equiv_35 bias bias.n9 39.245399999999997
rmesh_equiv_350 d.n16 d.n17 10.151300000000001
rmesh_equiv_351 d.n16 d.t1 700.48400000000004
rmesh_equiv_352 d.n17 d.n18 22.2837
rmesh_equiv_353 d.n18 d.n19 1.84643
rmesh_equiv_354 d.n19 d.n20 22.2837
rmesh_equiv_355 d.n19 d.n3 22.836300000000001
rmesh_equiv_356 d.n2 d.n3 10.151300000000001
rmesh_equiv_357 d.n2 d.t3 700.48400000000004
rmesh_equiv_358 d.n20 d.n21 10.151300000000001
rmesh_equiv_359 d.n21 d.t0 255.34500000000003
rmesh_equiv_36 bias bias.t0 139.911
rmesh_equiv_360 d.n4 d.n6 10.151300000000001
rmesh_equiv_361 d.n4 d.t2 255.34500000000003
rmesh_equiv_362 d.n5 d.n6 10.151300000000001
rmesh_equiv_363 d.n5 d.t2 255.34500000000003
rmesh_equiv_364 d.n7 d.n9 10.151300000000001
rmesh_equiv_365 d.n7 d.t5 700.48400000000004
rmesh_equiv_366 d.n8 d.n9 10.151300000000001
rmesh_equiv_367 d.n8 d.t5 700.48400000000004
rmesh_equiv_368 data data.n0 12.8005
rmesh_equiv_369 data data.n1 12.8005
rmesh_equiv_37 bias bias.t10 139.911
rmesh_equiv_370 data data.n11 12.8005
rmesh_equiv_371 data data.n12 12.8005
rmesh_equiv_372 data data.n14 34.627099999999999
rmesh_equiv_373 data data.n3 12.8005
rmesh_equiv_374 data data.n4 12.8005
rmesh_equiv_375 data data.n7 12.8005
rmesh_equiv_376 data data.n8 12.8005
rmesh_equiv_377 data.n0 data.n2 10.151300000000001
rmesh_equiv_378 data.n0 data.t2 255.34500000000003
rmesh_equiv_379 data.n1 data.n2 10.151300000000001
rmesh_equiv_38 bias bias.t11 139.911
rmesh_equiv_380 data.n1 data.t2 255.34500000000003
rmesh_equiv_381 data.n10 data.n14 0.55314200000000002
rmesh_equiv_382 data.n10 data.n6 3.6852999999999994
rmesh_equiv_383 data.n10 data.n9 25.200399999999995
rmesh_equiv_384 data.n11 data.n13 10.151300000000001
rmesh_equiv_385 data.n11 data.t0 255.34500000000003
rmesh_equiv_386 data.n12 data.n13 10.151300000000001
rmesh_equiv_387 data.n12 data.t0 255.34500000000003
rmesh_equiv_388 data.n13 data.n14 25.200399999999995
rmesh_equiv_389 data.n2 data.n6 25.753
rmesh_equiv_39 bias bias.t12 139.911
rmesh_equiv_390 data.n3 data.n5 10.151300000000001
rmesh_equiv_391 data.n3 data.t1 700.48400000000004
rmesh_equiv_392 data.n4 data.n5 10.151300000000001
rmesh_equiv_393 data.n4 data.t1 700.48400000000004
rmesh_equiv_394 data.n5 data.n6 25.200399999999995
rmesh_equiv_395 data.n7 data.n9 10.151300000000001
rmesh_equiv_396 data.n7 data.t3 700.48400000000004
rmesh_equiv_397 data.n8 data.n9 10.151300000000001
rmesh_equiv_398 data.n8 data.t3 700.48400000000004
rmesh_equiv_399 filter__buffer0__comp.n0 filter__buffer0__comp.n1 2.7844699999999998
rmesh_equiv_4 amplified amplified.n5 6.9688099999999995
rmesh_equiv_40 bias bias.t13 139.911
rmesh_equiv_400 filter__buffer0__comp.n0 filter__buffer0__comp.t0 5.2825199999999999
rmesh_equiv_401 filter__buffer0__comp.n0 filter__buffer0__comp.t1 8.0664800000000003
rmesh_equiv_402 filter__buffer0__comp.n1 filter__buffer0__comp.n2 5.2745199999999999
rmesh_equiv_403 filter__buffer0__comp.n1 filter__buffer0__comp.t3 28.493299999999998
rmesh_equiv_404 filter__buffer0__comp.n2 filter__buffer0__comp.t2 0.025939499999999997
rmesh_equiv_405 filter__buffer0__first__mir filter__buffer0__first__mir.n0 15.6333
rmesh_equiv_406 filter__buffer0__first__mir filter__buffer0__first__mir.n1 15.290036090016596
rmesh_equiv_407 filter__buffer0__first__mir filter__buffer0__first__mir.n11 15.6333
rmesh_equiv_408 filter__buffer0__first__mir filter__buffer0__first__mir.n2 4.8770699999999998
rmesh_equiv_409 filter__buffer0__first__mir filter__buffer0__first__mir.n3 22.8553
rmesh_equiv_41 bias bias.t14 139.911
rmesh_equiv_410 filter__buffer0__first__mir filter__buffer0__first__mir.n6 15.6333
rmesh_equiv_411 filter__buffer0__first__mir filter__buffer0__first__mir.n7 15.6333
rmesh_equiv_412 filter__buffer0__first__mir filter__buffer0__first__mir.t2 572.84699999999998
rmesh_equiv_413 filter__buffer0__first__mir filter__buffer0__first__mir.t4 572.84699999999998
rmesh_equiv_414 filter__buffer0__first__mir.n0 filter__buffer0__first__mir.n10 5.2415200000000004
rmesh_equiv_415 filter__buffer0__first__mir.n0 filter__buffer0__first__mir.t0 174.857
rmesh_equiv_416 filter__buffer0__first__mir.n1 filter__buffer0__first__mir.n5 0.27035799999999999
rmesh_equiv_417 filter__buffer0__first__mir.n10 filter__buffer0__first__mir.n11 5.2415200000000004
rmesh_equiv_418 filter__buffer0__first__mir.n10 filter__buffer0__first__mir.n9 17.586099999999998
rmesh_equiv_419 filter__buffer0__first__mir.n11 filter__buffer0__first__mir.t0 174.857
rmesh_equiv_42 bias bias.t15 139.911
rmesh_equiv_420 filter__buffer0__first__mir.n2 filter__buffer0__first__mir.n4 2.4407800000000002
rmesh_equiv_421 filter__buffer0__first__mir.n2 filter__buffer0__first__mir.t3 387.11000000000001
rmesh_equiv_422 filter__buffer0__first__mir.n3 filter__buffer0__first__mir.n4 11.4361
rmesh_equiv_423 filter__buffer0__first__mir.n3 filter__buffer0__first__mir.t3 381.113
rmesh_equiv_424 filter__buffer0__first__mir.n4 filter__buffer0__first__mir.n5 16.9712
rmesh_equiv_425 filter__buffer0__first__mir.n5 filter__buffer0__first__mir.n9 1.23464
rmesh_equiv_426 filter__buffer0__first__mir.n6 filter__buffer0__first__mir.n8 5.2415200000000004
rmesh_equiv_427 filter__buffer0__first__mir.n6 filter__buffer0__first__mir.t1 174.857
rmesh_equiv_428 filter__buffer0__first__mir.n7 filter__buffer0__first__mir.n8 5.2415200000000004
rmesh_equiv_429 filter__buffer0__first__mir.n7 filter__buffer0__first__mir.t1 174.857
rmesh_equiv_43 bias bias.t3 139.911
rmesh_equiv_430 filter__buffer0__first__mir.n8 filter__buffer0__first__mir.n9 16.9712
rmesh_equiv_431 filter__buffer0__first__tail filter__buffer0__first__tail.n0 15.6333
rmesh_equiv_432 filter__buffer0__first__tail filter__buffer0__first__tail.n1 19.837
rmesh_equiv_433 filter__buffer0__first__tail filter__buffer0__first__tail.n12 15.6333
rmesh_equiv_434 filter__buffer0__first__tail filter__buffer0__first__tail.n13 15.6333
rmesh_equiv_435 filter__buffer0__first__tail filter__buffer0__first__tail.n17 15.6333
rmesh_equiv_436 filter__buffer0__first__tail filter__buffer0__first__tail.n2 4.2590000000000003
rmesh_equiv_437 filter__buffer0__first__tail filter__buffer0__first__tail.n4 15.6333
rmesh_equiv_438 filter__buffer0__first__tail filter__buffer0__first__tail.n5 15.6333
rmesh_equiv_439 filter__buffer0__first__tail filter__buffer0__first__tail.n8 15.6333
rmesh_equiv_44 bias bias.t4 139.911
rmesh_equiv_440 filter__buffer0__first__tail filter__buffer0__first__tail.n9 15.6333
rmesh_equiv_441 filter__buffer0__first__tail.n0 filter__buffer0__first__tail.n16 5.2415200000000004
rmesh_equiv_442 filter__buffer0__first__tail.n0 filter__buffer0__first__tail.t1 174.857
rmesh_equiv_443 filter__buffer0__first__tail.n1 filter__buffer0__first__tail.n3 14.189499999999999
rmesh_equiv_444 filter__buffer0__first__tail.n1 filter__buffer0__first__tail.t2 174.91200000000001
rmesh_equiv_445 filter__buffer0__first__tail.n10 filter__buffer0__first__tail.n11 17.387899999999998
rmesh_equiv_446 filter__buffer0__first__tail.n10 filter__buffer0__first__tail.n8 5.2415200000000004
rmesh_equiv_447 filter__buffer0__first__tail.n10 filter__buffer0__first__tail.n9 5.2415200000000004
rmesh_equiv_448 filter__buffer0__first__tail.n11 filter__buffer0__first__tail.n15 0.61541699999999999
rmesh_equiv_449 filter__buffer0__first__tail.n11 filter__buffer0__first__tail.n7 0.61541699999999999
rmesh_equiv_45 bias bias.t5 139.911
rmesh_equiv_450 filter__buffer0__first__tail.n12 filter__buffer0__first__tail.n14 5.2415200000000004
rmesh_equiv_451 filter__buffer0__first__tail.n12 filter__buffer0__first__tail.t4 174.857
rmesh_equiv_452 filter__buffer0__first__tail.n13 filter__buffer0__first__tail.n14 5.2415200000000004
rmesh_equiv_453 filter__buffer0__first__tail.n13 filter__buffer0__first__tail.t4 174.857
rmesh_equiv_454 filter__buffer0__first__tail.n14 filter__buffer0__first__tail.n15 18.002800000000001
rmesh_equiv_455 filter__buffer0__first__tail.n15 filter__buffer0__first__tail.n16 17.387899999999998
rmesh_equiv_456 filter__buffer0__first__tail.n16 filter__buffer0__first__tail.n17 5.2415200000000004
rmesh_equiv_457 filter__buffer0__first__tail.n17 filter__buffer0__first__tail.t1 174.857
rmesh_equiv_458 filter__buffer0__first__tail.n2 filter__buffer0__first__tail.n3 3.0467200000000001
rmesh_equiv_459 filter__buffer0__first__tail.n2 filter__buffer0__first__tail.t2 181.41
rmesh_equiv_46 bias bias.t6 139.911
rmesh_equiv_460 filter__buffer0__first__tail.n3 filter__buffer0__first__tail.n7 19.061900000000001
rmesh_equiv_461 filter__buffer0__first__tail.n4 filter__buffer0__first__tail.n6 5.2415200000000004
rmesh_equiv_462 filter__buffer0__first__tail.n4 filter__buffer0__first__tail.t3 174.857
rmesh_equiv_463 filter__buffer0__first__tail.n5 filter__buffer0__first__tail.n6 5.2415200000000004
rmesh_equiv_464 filter__buffer0__first__tail.n5 filter__buffer0__first__tail.t3 174.857
rmesh_equiv_465 filter__buffer0__first__tail.n6 filter__buffer0__first__tail.n7 17.387899999999998
rmesh_equiv_466 filter__buffer0__first__tail.n8 filter__buffer0__first__tail.t0 174.857
rmesh_equiv_467 filter__buffer0__first__tail.n9 filter__buffer0__first__tail.t0 174.857
rmesh_equiv_468 filter__buffer0__pre filter__buffer0__pre.n0 22.8553
rmesh_equiv_469 filter__buffer0__pre filter__buffer0__pre.n1 2.9478286027947167
rmesh_equiv_47 bias bias.t7 139.911
rmesh_equiv_470 filter__buffer0__pre filter__buffer0__pre.n13 4.8770699999999998
rmesh_equiv_471 filter__buffer0__pre filter__buffer0__pre.n2 4.8158000000000003
rmesh_equiv_472 filter__buffer0__pre filter__buffer0__pre.n3 28.049299999999999
rmesh_equiv_473 filter__buffer0__pre filter__buffer0__pre.n4 15.6333
rmesh_equiv_474 filter__buffer0__pre filter__buffer0__pre.n5 15.6333
rmesh_equiv_475 filter__buffer0__pre filter__buffer0__pre.n7 15.6333
rmesh_equiv_476 filter__buffer0__pre filter__buffer0__pre.n8 15.6333
rmesh_equiv_477 filter__buffer0__pre filter__buffer0__pre.t3 0.00141837
rmesh_equiv_478 filter__buffer0__pre filter__buffer0__pre.t4 0.00141837
rmesh_equiv_479 filter__buffer0__pre filter__buffer0__pre.t5 1054.8499999999999
rmesh_equiv_48 bias bias.t8 139.911
rmesh_equiv_480 filter__buffer0__pre filter__buffer0__pre.t6 0.00141837
rmesh_equiv_481 filter__buffer0__pre.n0 filter__buffer0__pre.n12 11.4361
rmesh_equiv_482 filter__buffer0__pre.n0 filter__buffer0__pre.t0 381.113
rmesh_equiv_483 filter__buffer0__pre.n1 filter__buffer0__pre.n2 2.7844699999999998
rmesh_equiv_484 filter__buffer0__pre.n10 filter__buffer0__pre.n11 1.24326
rmesh_equiv_485 filter__buffer0__pre.n10 filter__buffer0__pre.n6 20.065999999999999
rmesh_equiv_486 filter__buffer0__pre.n10 filter__buffer0__pre.n9 18.2212
rmesh_equiv_487 filter__buffer0__pre.n11 filter__buffer0__pre.n12 18.2212
rmesh_equiv_488 filter__buffer0__pre.n11 filter__buffer0__pre.n3 1.50881
rmesh_equiv_489 filter__buffer0__pre.n12 filter__buffer0__pre.n13 2.4407800000000002
rmesh_equiv_49 bias bias.t9 139.911
rmesh_equiv_490 filter__buffer0__pre.n13 filter__buffer0__pre.t0 387.11000000000001
rmesh_equiv_491 filter__buffer0__pre.n2 filter__buffer0__pre.n3 2.0861200000000002
rmesh_equiv_492 filter__buffer0__pre.n4 filter__buffer0__pre.n6 5.2415200000000004
rmesh_equiv_493 filter__buffer0__pre.n4 filter__buffer0__pre.t2 174.857
rmesh_equiv_494 filter__buffer0__pre.n5 filter__buffer0__pre.n6 5.2415200000000004
rmesh_equiv_495 filter__buffer0__pre.n5 filter__buffer0__pre.t2 174.857
rmesh_equiv_496 filter__buffer0__pre.n7 filter__buffer0__pre.n9 5.2415200000000004
rmesh_equiv_497 filter__buffer0__pre.n7 filter__buffer0__pre.t1 174.857
rmesh_equiv_498 filter__buffer0__pre.n8 filter__buffer0__pre.n9 5.2415200000000004
rmesh_equiv_499 filter__buffer0__pre.n8 filter__buffer0__pre.t1 174.857
rmesh_equiv_5 amplified amplified.t4 212.21199999999999
rmesh_equiv_50 bias.n0 bias.n1 1.23895
rmesh_equiv_500 filter__buffer1__comp.n0 filter__buffer1__comp.n1 2.7844699999999998
rmesh_equiv_501 filter__buffer1__comp.n0 filter__buffer1__comp.t1 7.8408800000000003
rmesh_equiv_502 filter__buffer1__comp.n0 filter__buffer1__comp.t3 5.0569199999999999
rmesh_equiv_503 filter__buffer1__comp.n1 filter__buffer1__comp.t0 27.6599
rmesh_equiv_504 filter__buffer1__comp.n1 filter__buffer1__comp.t2 5.0569199999999999
rmesh_equiv_505 filter__buffer1__first__mir filter__buffer1__first__mir.n0 22.8553
rmesh_equiv_506 filter__buffer1__first__mir filter__buffer1__first__mir.n1 15.081688627820172
rmesh_equiv_507 filter__buffer1__first__mir filter__buffer1__first__mir.n11 4.8770699999999998
rmesh_equiv_508 filter__buffer1__first__mir filter__buffer1__first__mir.n2 15.6333
rmesh_equiv_509 filter__buffer1__first__mir filter__buffer1__first__mir.n3 15.6333
rmesh_equiv_51 bias.n1 bias.n3 21.1051
rmesh_equiv_510 filter__buffer1__first__mir filter__buffer1__first__mir.n5 15.6333
rmesh_equiv_511 filter__buffer1__first__mir filter__buffer1__first__mir.n6 15.6333
rmesh_equiv_512 filter__buffer1__first__mir filter__buffer1__first__mir.t0 572.84699999999998
rmesh_equiv_513 filter__buffer1__first__mir filter__buffer1__first__mir.t4 572.84699999999998
rmesh_equiv_514 filter__buffer1__first__mir.n0 filter__buffer1__first__mir.n10 11.4361
rmesh_equiv_515 filter__buffer1__first__mir.n0 filter__buffer1__first__mir.t1 381.113
rmesh_equiv_516 filter__buffer1__first__mir.n1 filter__buffer1__first__mir.n9 0.27035799999999999
rmesh_equiv_517 filter__buffer1__first__mir.n10 filter__buffer1__first__mir.n11 2.4407800000000002
rmesh_equiv_518 filter__buffer1__first__mir.n10 filter__buffer1__first__mir.n9 16.554500000000001
rmesh_equiv_519 filter__buffer1__first__mir.n11 filter__buffer1__first__mir.t1 387.11000000000001
rmesh_equiv_52 bias.n10 bias.n11 41.557099999999998
rmesh_equiv_520 filter__buffer1__first__mir.n2 filter__buffer1__first__mir.n4 5.2415200000000004
rmesh_equiv_521 filter__buffer1__first__mir.n2 filter__buffer1__first__mir.t3 174.857
rmesh_equiv_522 filter__buffer1__first__mir.n3 filter__buffer1__first__mir.n4 5.2415200000000004
rmesh_equiv_523 filter__buffer1__first__mir.n3 filter__buffer1__first__mir.t3 174.857
rmesh_equiv_524 filter__buffer1__first__mir.n4 filter__buffer1__first__mir.n8 20.086099999999998
rmesh_equiv_525 filter__buffer1__first__mir.n5 filter__buffer1__first__mir.n7 5.2415200000000004
rmesh_equiv_526 filter__buffer1__first__mir.n5 filter__buffer1__first__mir.t2 174.857
rmesh_equiv_527 filter__buffer1__first__mir.n6 filter__buffer1__first__mir.n7 5.2415200000000004
rmesh_equiv_528 filter__buffer1__first__mir.n6 filter__buffer1__first__mir.t2 174.857
rmesh_equiv_529 filter__buffer1__first__mir.n7 filter__buffer1__first__mir.n8 19.4712
rmesh_equiv_53 bias.n10 bias.n9 1.23895
rmesh_equiv_530 filter__buffer1__first__mir.n8 filter__buffer1__first__mir.n9 87.834599999999995
rmesh_equiv_531 filter__buffer1__first__tail filter__buffer1__first__tail.n0 15.6333
rmesh_equiv_532 filter__buffer1__first__tail filter__buffer1__first__tail.n1 15.6333
rmesh_equiv_533 filter__buffer1__first__tail filter__buffer1__first__tail.n11 15.6333
rmesh_equiv_534 filter__buffer1__first__tail filter__buffer1__first__tail.n12 15.6333
rmesh_equiv_535 filter__buffer1__first__tail filter__buffer1__first__tail.n17 15.6333
rmesh_equiv_536 filter__buffer1__first__tail filter__buffer1__first__tail.n2 15.6333
rmesh_equiv_537 filter__buffer1__first__tail filter__buffer1__first__tail.n4 15.6333
rmesh_equiv_538 filter__buffer1__first__tail filter__buffer1__first__tail.n5 15.6333
rmesh_equiv_539 filter__buffer1__first__tail filter__buffer1__first__tail.n8 19.837
rmesh_equiv_54 bias.n11 bias.n12 0.53786699999999998
rmesh_equiv_540 filter__buffer1__first__tail filter__buffer1__first__tail.n9 4.2590000000000003
rmesh_equiv_541 filter__buffer1__first__tail.n0 filter__buffer1__first__tail.n16 5.2415200000000004
rmesh_equiv_542 filter__buffer1__first__tail.n0 filter__buffer1__first__tail.t0 174.857
rmesh_equiv_543 filter__buffer1__first__tail.n1 filter__buffer1__first__tail.n3 5.2415200000000004
rmesh_equiv_544 filter__buffer1__first__tail.n1 filter__buffer1__first__tail.t2 174.857
rmesh_equiv_545 filter__buffer1__first__tail.n10 filter__buffer1__first__tail.n14 105.114
rmesh_equiv_546 filter__buffer1__first__tail.n10 filter__buffer1__first__tail.n8 14.189499999999999
rmesh_equiv_547 filter__buffer1__first__tail.n10 filter__buffer1__first__tail.n9 3.0467200000000001
rmesh_equiv_548 filter__buffer1__first__tail.n11 filter__buffer1__first__tail.n13 5.2415200000000004
rmesh_equiv_549 filter__buffer1__first__tail.n11 filter__buffer1__first__tail.t1 174.857
rmesh_equiv_55 bias.n11 bias.t2 37.821199999999997
rmesh_equiv_550 filter__buffer1__first__tail.n12 filter__buffer1__first__tail.n13 5.2415200000000004
rmesh_equiv_551 filter__buffer1__first__tail.n12 filter__buffer1__first__tail.t1 174.857
rmesh_equiv_552 filter__buffer1__first__tail.n13 filter__buffer1__first__tail.n14 20.7212
rmesh_equiv_553 filter__buffer1__first__tail.n14 filter__buffer1__first__tail.n15 0.61541699999999999
rmesh_equiv_554 filter__buffer1__first__tail.n15 filter__buffer1__first__tail.n16 20.7212
rmesh_equiv_555 filter__buffer1__first__tail.n15 filter__buffer1__first__tail.n7 0.61541699999999999
rmesh_equiv_556 filter__buffer1__first__tail.n16 filter__buffer1__first__tail.n17 5.2415200000000004
rmesh_equiv_557 filter__buffer1__first__tail.n17 filter__buffer1__first__tail.t0 174.857
rmesh_equiv_558 filter__buffer1__first__tail.n2 filter__buffer1__first__tail.n3 5.2415200000000004
rmesh_equiv_559 filter__buffer1__first__tail.n2 filter__buffer1__first__tail.t2 174.857
rmesh_equiv_56 bias.n12 bias.n16 0.27035799999999999
rmesh_equiv_560 filter__buffer1__first__tail.n3 filter__buffer1__first__tail.n7 21.336099999999998
rmesh_equiv_561 filter__buffer1__first__tail.n4 filter__buffer1__first__tail.n6 5.2415200000000004
rmesh_equiv_562 filter__buffer1__first__tail.n4 filter__buffer1__first__tail.t4 174.857
rmesh_equiv_563 filter__buffer1__first__tail.n5 filter__buffer1__first__tail.n6 5.2415200000000004
rmesh_equiv_564 filter__buffer1__first__tail.n5 filter__buffer1__first__tail.t4 174.857
rmesh_equiv_565 filter__buffer1__first__tail.n6 filter__buffer1__first__tail.n7 20.7212
rmesh_equiv_566 filter__buffer1__first__tail.n8 filter__buffer1__first__tail.t3 174.91200000000001
rmesh_equiv_567 filter__buffer1__first__tail.n9 filter__buffer1__first__tail.t3 181.41
rmesh_equiv_568 filter__buffer1__pre filter__buffer1__pre.n0 22.8553
rmesh_equiv_569 filter__buffer1__pre filter__buffer1__pre.n1 2.8291431252961923
rmesh_equiv_57 bias.n13 bias.n15 3.0467200000000001
rmesh_equiv_570 filter__buffer1__pre filter__buffer1__pre.n13 4.8770699999999998
rmesh_equiv_571 filter__buffer1__pre filter__buffer1__pre.n2 4.5902000000000003
rmesh_equiv_572 filter__buffer1__pre filter__buffer1__pre.n3 27.215900000000005
rmesh_equiv_573 filter__buffer1__pre filter__buffer1__pre.n4 15.6333
rmesh_equiv_574 filter__buffer1__pre filter__buffer1__pre.n5 15.6333
rmesh_equiv_575 filter__buffer1__pre filter__buffer1__pre.n7 15.6333
rmesh_equiv_576 filter__buffer1__pre filter__buffer1__pre.n8 15.6333
rmesh_equiv_577 filter__buffer1__pre filter__buffer1__pre.t3 0.00141837
rmesh_equiv_578 filter__buffer1__pre filter__buffer1__pre.t4 1054.8499999999999
rmesh_equiv_579 filter__buffer1__pre filter__buffer1__pre.t5 0.00141837
rmesh_equiv_58 bias.n13 bias.t1 181.41
rmesh_equiv_580 filter__buffer1__pre filter__buffer1__pre.t6 0.00141837
rmesh_equiv_581 filter__buffer1__pre.n0 filter__buffer1__pre.n12 11.4361
rmesh_equiv_582 filter__buffer1__pre.n0 filter__buffer1__pre.t0 381.113
rmesh_equiv_583 filter__buffer1__pre.n1 filter__buffer1__pre.n2 2.7844699999999998
rmesh_equiv_584 filter__buffer1__pre.n10 filter__buffer1__pre.n11 87.279200000000003
rmesh_equiv_585 filter__buffer1__pre.n10 filter__buffer1__pre.n6 22.1493
rmesh_equiv_586 filter__buffer1__pre.n10 filter__buffer1__pre.n9 20.304500000000001
rmesh_equiv_587 filter__buffer1__pre.n11 filter__buffer1__pre.n12 17.387899999999998
rmesh_equiv_588 filter__buffer1__pre.n11 filter__buffer1__pre.n3 1.50881
rmesh_equiv_589 filter__buffer1__pre.n12 filter__buffer1__pre.n13 2.4407800000000002
rmesh_equiv_59 bias.n14 bias.n15 14.189499999999999
rmesh_equiv_590 filter__buffer1__pre.n13 filter__buffer1__pre.t0 387.11000000000001
rmesh_equiv_591 filter__buffer1__pre.n2 filter__buffer1__pre.n3 2.0861200000000002
rmesh_equiv_592 filter__buffer1__pre.n4 filter__buffer1__pre.n6 5.2415200000000004
rmesh_equiv_593 filter__buffer1__pre.n4 filter__buffer1__pre.t1 174.857
rmesh_equiv_594 filter__buffer1__pre.n5 filter__buffer1__pre.n6 5.2415200000000004
rmesh_equiv_595 filter__buffer1__pre.n5 filter__buffer1__pre.t1 174.857
rmesh_equiv_596 filter__buffer1__pre.n7 filter__buffer1__pre.n9 5.2415200000000004
rmesh_equiv_597 filter__buffer1__pre.n7 filter__buffer1__pre.t2 174.857
rmesh_equiv_598 filter__buffer1__pre.n8 filter__buffer1__pre.n9 5.2415200000000004
rmesh_equiv_599 filter__buffer1__pre.n8 filter__buffer1__pre.t2 174.857
rmesh_equiv_6 amplified amplified.t5 212.21199999999999
rmesh_equiv_60 bias.n14 bias.t1 174.91200000000001
rmesh_equiv_600 filter__filter0 filter__filter0.n0 16.685762003173938
rmesh_equiv_601 filter__filter0 filter__filter0.n1 4.3646000000000003
rmesh_equiv_602 filter__filter0 filter__filter0.n10 6.8461999999999987
rmesh_equiv_603 filter__filter0 filter__filter0.n12 4.3646000000000003
rmesh_equiv_604 filter__filter0 filter__filter0.n2 4.3646000000000003
rmesh_equiv_605 filter__filter0 filter__filter0.n3 4.3646000000000003
rmesh_equiv_606 filter__filter0 filter__filter0.n4 4.3646000000000003
rmesh_equiv_607 filter__filter0 filter__filter0.n5 4.0014924315246621
rmesh_equiv_608 filter__filter0 filter__filter0.n6 6.8461999999999987
rmesh_equiv_609 filter__filter0 filter__filter0.n7 6.8461999999999987
rmesh_equiv_61 bias.n15 bias.n16 22.804500000000001
rmesh_equiv_610 filter__filter0 filter__filter0.n8 6.8461999999999987
rmesh_equiv_611 filter__filter0 filter__filter0.n9 6.8461999999999987
rmesh_equiv_612 filter__filter0 filter__filter0.t1 0.00141837
rmesh_equiv_613 filter__filter0 filter__filter0.t10 0.00141837
rmesh_equiv_614 filter__filter0 filter__filter0.t11 0.00141837
rmesh_equiv_615 filter__filter0 filter__filter0.t12 0.00141837
rmesh_equiv_616 filter__filter0 filter__filter0.t13 0.00141837
rmesh_equiv_617 filter__filter0 filter__filter0.t14 0.00141837
rmesh_equiv_618 filter__filter0 filter__filter0.t2 0.00141837
rmesh_equiv_619 filter__filter0 filter__filter0.t3 0.00141837
rmesh_equiv_62 bias.n16 bias.n17 12.6989
rmesh_equiv_620 filter__filter0 filter__filter0.t4 0.00141837
rmesh_equiv_621 filter__filter0 filter__filter0.t5 0.00141837
rmesh_equiv_622 filter__filter0 filter__filter0.t6 212.21199999999999
rmesh_equiv_623 filter__filter0 filter__filter0.t7 0.00141837
rmesh_equiv_624 filter__filter0 filter__filter0.t8 212.21199999999999
rmesh_equiv_625 filter__filter0 filter__filter0.t9 0.00141837
rmesh_equiv_626 filter__filter0.n0 filter__filter0.n1 1.9329800000000001
rmesh_equiv_627 filter__filter0.n1 filter__filter0.n2 2.7844699999999998
rmesh_equiv_628 filter__filter0.n10 filter__filter0.n11 1.55307
rmesh_equiv_629 filter__filter0.n10 filter__filter0.n9 2.7844699999999998
rmesh_equiv_63 bias.n17 bias.n7 7.3409599999999999
rmesh_equiv_630 filter__filter0.n11 filter__filter0.n12 66.441400000000002
rmesh_equiv_631 filter__filter0.n11 filter__filter0.t0 32.148600000000002
rmesh_equiv_632 filter__filter0.n12 filter__filter0.n4 2.7844699999999998
rmesh_equiv_633 filter__filter0.n2 filter__filter0.n3 2.7844699999999998
rmesh_equiv_634 filter__filter0.n3 filter__filter0.n4 2.7844699999999998
rmesh_equiv_635 filter__filter0.n5 filter__filter0.n6 2.7844699999999998
rmesh_equiv_636 filter__filter0.n6 filter__filter0.n7 2.7844699999999998
rmesh_equiv_637 filter__filter0.n7 filter__filter0.n8 2.7844699999999998
rmesh_equiv_638 filter__filter0.n8 filter__filter0.n9 2.7844699999999998
rmesh_equiv_639 filter__filter1 filter__filter1.n0 18.978949170096076
rmesh_equiv_64 bias.n2 bias.n3 30.595300000000005
rmesh_equiv_640 filter__filter1 filter__filter1.n1 5.6054000000000004
rmesh_equiv_641 filter__filter1 filter__filter1.n10 5.6054000000000004
rmesh_equiv_642 filter__filter1 filter__filter1.n11 5.6054000000000004
rmesh_equiv_643 filter__filter1 filter__filter1.n12 5.6054000000000004
rmesh_equiv_644 filter__filter1 filter__filter1.n2 5.6054000000000004
rmesh_equiv_645 filter__filter1 filter__filter1.n3 5.6054000000000004
rmesh_equiv_646 filter__filter1 filter__filter1.n4 5.6054000000000004
rmesh_equiv_647 filter__filter1 filter__filter1.n5 5.6054000000000004
rmesh_equiv_648 filter__filter1 filter__filter1.n6 5.6054000000000004
rmesh_equiv_649 filter__filter1 filter__filter1.n7 5.6054000000000004
rmesh_equiv_65 bias.n3 bias.n7 5.8745599999999998
rmesh_equiv_650 filter__filter1 filter__filter1.n8 5.6054000000000004
rmesh_equiv_651 filter__filter1 filter__filter1.n9 5.6054000000000004
rmesh_equiv_652 filter__filter1 filter__filter1.t1 0.00141837
rmesh_equiv_653 filter__filter1 filter__filter1.t10 0.00141837
rmesh_equiv_654 filter__filter1 filter__filter1.t11 212.21199999999999
rmesh_equiv_655 filter__filter1 filter__filter1.t12 0.00141837
rmesh_equiv_656 filter__filter1 filter__filter1.t13 0.00141837
rmesh_equiv_657 filter__filter1 filter__filter1.t14 0.00141837
rmesh_equiv_658 filter__filter1 filter__filter1.t2 212.21199999999999
rmesh_equiv_659 filter__filter1 filter__filter1.t3 0.00141837
rmesh_equiv_66 bias.n4 bias.n5 18.484000000000002
rmesh_equiv_660 filter__filter1 filter__filter1.t4 0.00141837
rmesh_equiv_661 filter__filter1 filter__filter1.t5 0.00141837
rmesh_equiv_662 filter__filter1 filter__filter1.t6 0.00141837
rmesh_equiv_663 filter__filter1 filter__filter1.t7 0.00141837
rmesh_equiv_664 filter__filter1 filter__filter1.t8 0.00141837
rmesh_equiv_665 filter__filter1 filter__filter1.t9 0.00141837
rmesh_equiv_666 filter__filter1.n0 filter__filter1.n1 1.9329800000000001
rmesh_equiv_667 filter__filter1.n1 filter__filter1.n2 2.7844699999999998
rmesh_equiv_668 filter__filter1.n10 filter__filter1.n11 2.7844699999999998
rmesh_equiv_669 filter__filter1.n10 filter__filter1.n9 2.7844699999999998
rmesh_equiv_67 bias.n5 bias.n6 1.23895
rmesh_equiv_670 filter__filter1.n11 filter__filter1.n12 2.7844699999999998
rmesh_equiv_671 filter__filter1.n12 filter__filter1.t0 29.117799999999999
rmesh_equiv_672 filter__filter1.n2 filter__filter1.n3 2.7844699999999998
rmesh_equiv_673 filter__filter1.n3 filter__filter1.n4 2.7844699999999998
rmesh_equiv_674 filter__filter1.n4 filter__filter1.n5 2.7844699999999998
rmesh_equiv_675 filter__filter1.n5 filter__filter1.n6 2.7844699999999998
rmesh_equiv_676 filter__filter1.n6 filter__filter1.n7 2.7844699999999998
rmesh_equiv_677 filter__filter1.n7 filter__filter1.n8 2.7844699999999998
rmesh_equiv_678 filter__filter1.n8 filter__filter1.n9 2.7844699999999998
rmesh_equiv_679 filter__mid filter__mid.n0 19.837
rmesh_equiv_68 bias.n6 bias.n7 24.114000000000001
rmesh_equiv_680 filter__mid filter__mid.n10 4.2590000000000003
rmesh_equiv_681 filter__mid filter__mid.n2 17.639685430693511
rmesh_equiv_682 filter__mid filter__mid.n3 33.9895
rmesh_equiv_683 filter__mid filter__mid.n5 6.9688099999999995
rmesh_equiv_684 filter__mid filter__mid.t4 212.21199999999999
rmesh_equiv_685 filter__mid filter__mid.t5 212.21199999999999
rmesh_equiv_686 filter__mid.n0 filter__mid.n9 14.189499999999999
rmesh_equiv_687 filter__mid.n0 filter__mid.t1 174.91200000000001
rmesh_equiv_688 filter__mid.n1 filter__mid.n8 9.1596299999999999
rmesh_equiv_689 filter__mid.n1 filter__mid.t0 24.626799999999999
rmesh_equiv_69 bias.n8 bias.n9 13.297599999999999
rmesh_equiv_690 filter__mid.n1 filter__mid.t3 31.010400000000001
rmesh_equiv_691 filter__mid.n10 filter__mid.n9 3.0467200000000001
rmesh_equiv_692 filter__mid.n10 filter__mid.t1 181.41
rmesh_equiv_693 filter__mid.n2 filter__mid.n7 2.8267699999999998
rmesh_equiv_694 filter__mid.n3 filter__mid.n4 13.2728
rmesh_equiv_695 filter__mid.n3 filter__mid.n6 0.51338700000000004
rmesh_equiv_696 filter__mid.n4 filter__mid.n5 13.200100000000001
rmesh_equiv_697 filter__mid.n4 filter__mid.t2 0.71462499999999995
rmesh_equiv_698 filter__mid.n5 filter__mid.n6 0.27270899999999998
rmesh_equiv_699 filter__mid.n6 filter__mid.n7 19.054500000000001
rmesh_equiv_7 amplified.n0 amplified.n9 14.189499999999999
rmesh_equiv_70 bias_source__vcm_buffer__comp.n0 bias_source__vcm_buffer__comp.n1 2.7844699999999998
rmesh_equiv_700 filter__mid.n7 filter__mid.n8 0.61972499999999997
rmesh_equiv_701 filter__mid.n8 filter__mid.n9 19.054500000000001
rmesh_equiv_702 gain gain.n0 19.060666055669149
rmesh_equiv_703 gain gain.n1 41.214300000000001
rmesh_equiv_704 gain gain.n2 18.268400361111787
rmesh_equiv_705 gain gain.t0 315.88
rmesh_equiv_706 gain gain.t1 330.34100000000001
rmesh_equiv_707 gain gain.t2 3439.2399999999998
rmesh_equiv_708 gain gain.t3 3424.7800000000002
rmesh_equiv_709 gain.n0 gain.n1 1.1014699999999999
rmesh_equiv_71 bias_source__vcm_buffer__comp.n0 bias_source__vcm_buffer__comp.t1 8.4048800000000004
rmesh_equiv_710 gain.n1 gain.n2 0.55314200000000002
rmesh_equiv_711 out out.n0 33.974299999999999
rmesh_equiv_712 out out.n1 19.837
rmesh_equiv_713 out out.n10 0.020083299999999998
rmesh_equiv_714 out out.n11 18.05639091509439
rmesh_equiv_715 out out.n2 4.2590000000000003
rmesh_equiv_716 out out.n5 33.9895
rmesh_equiv_717 out out.n7 6.9688099999999995
rmesh_equiv_718 out out.t3 332.71199999999999
rmesh_equiv_719 out out.t4 212.21199999999999
rmesh_equiv_72 bias_source__vcm_buffer__comp.n0 bias_source__vcm_buffer__comp.t3 5.6209199999999999
rmesh_equiv_720 out out.t5 212.21199999999999
rmesh_equiv_721 out.n0 out.n4 9.1596299999999999
rmesh_equiv_722 out.n0 out.t0 30.177099999999999
rmesh_equiv_723 out.n1 out.n3 14.189499999999999
rmesh_equiv_724 out.n1 out.t2 174.91200000000001
rmesh_equiv_725 out.n10 out.n11 71.981200000000001
rmesh_equiv_726 out.n10 out.n9 16.350200000000001
rmesh_equiv_727 out.n2 out.n3 3.0467200000000001
rmesh_equiv_728 out.n2 out.t2 181.41
rmesh_equiv_729 out.n3 out.n4 18.2212
rmesh_equiv_73 bias_source__vcm_buffer__comp.n1 bias_source__vcm_buffer__comp.t0 29.743300000000001
rmesh_equiv_730 out.n4 out.n9 0.61972499999999997
rmesh_equiv_731 out.n5 out.n6 13.2728
rmesh_equiv_732 out.n5 out.n8 0.51338700000000004
rmesh_equiv_733 out.n6 out.n7 13.200100000000001
rmesh_equiv_734 out.n6 out.t1 0.71462499999999995
rmesh_equiv_735 out.n7 out.n8 0.27270899999999998
rmesh_equiv_736 out.n8 out.n9 18.2212
rmesh_equiv_737 pga__gain2__amp__comp.n0 pga__gain2__amp__comp.n1 2.7844699999999998
rmesh_equiv_738 pga__gain2__amp__comp.n0 pga__gain2__amp__comp.t2 4.8313199999999998
rmesh_equiv_739 pga__gain2__amp__comp.n0 pga__gain2__amp__comp.t3 91.679599999999994
rmesh_equiv_74 bias_source__vcm_buffer__comp.n1 bias_source__vcm_buffer__comp.t2 5.6209199999999999
rmesh_equiv_740 pga__gain2__amp__comp.n1 pga__gain2__amp__comp.t0 26.826599999999999
rmesh_equiv_741 pga__gain2__amp__comp.n1 pga__gain2__amp__comp.t1 4.8313199999999998
rmesh_equiv_742 pga__gain2__amp__first__mir pga__gain2__amp__first__mir.n0 22.8553
rmesh_equiv_743 pga__gain2__amp__first__mir pga__gain2__amp__first__mir.n1 17.581917733303762
rmesh_equiv_744 pga__gain2__amp__first__mir pga__gain2__amp__first__mir.n11 4.8770699999999998
rmesh_equiv_745 pga__gain2__amp__first__mir pga__gain2__amp__first__mir.n2 15.6333
rmesh_equiv_746 pga__gain2__amp__first__mir pga__gain2__amp__first__mir.n3 15.6333
rmesh_equiv_747 pga__gain2__amp__first__mir pga__gain2__amp__first__mir.n5 15.6333
rmesh_equiv_748 pga__gain2__amp__first__mir pga__gain2__amp__first__mir.n6 15.6333
rmesh_equiv_749 pga__gain2__amp__first__mir pga__gain2__amp__first__mir.t0 572.84699999999998
rmesh_equiv_75 bias_source__vcm_buffer__first__mir bias_source__vcm_buffer__first__mir.n0 22.8553
rmesh_equiv_750 pga__gain2__amp__first__mir pga__gain2__amp__first__mir.t4 572.84699999999998
rmesh_equiv_751 pga__gain2__amp__first__mir.n0 pga__gain2__amp__first__mir.n10 11.4361
rmesh_equiv_752 pga__gain2__amp__first__mir.n0 pga__gain2__amp__first__mir.t1 381.113
rmesh_equiv_753 pga__gain2__amp__first__mir.n1 pga__gain2__amp__first__mir.n9 0.27035799999999999
rmesh_equiv_754 pga__gain2__amp__first__mir.n10 pga__gain2__amp__first__mir.n11 2.4407800000000002
rmesh_equiv_755 pga__gain2__amp__first__mir.n10 pga__gain2__amp__first__mir.n9 21.554500000000001
rmesh_equiv_756 pga__gain2__amp__first__mir.n11 pga__gain2__amp__first__mir.t1 387.11000000000001
rmesh_equiv_757 pga__gain2__amp__first__mir.n2 pga__gain2__amp__first__mir.n4 5.2415200000000004
rmesh_equiv_758 pga__gain2__amp__first__mir.n2 pga__gain2__amp__first__mir.t2 174.857
rmesh_equiv_759 pga__gain2__amp__first__mir.n3 pga__gain2__amp__first__mir.n4 5.2415200000000004
rmesh_equiv_76 bias_source__vcm_buffer__first__mir bias_source__vcm_buffer__first__mir.n1 16.123468205997217
rmesh_equiv_760 pga__gain2__amp__first__mir.n3 pga__gain2__amp__first__mir.t2 174.857
rmesh_equiv_761 pga__gain2__amp__first__mir.n4 pga__gain2__amp__first__mir.n8 22.169499999999999
rmesh_equiv_762 pga__gain2__amp__first__mir.n5 pga__gain2__amp__first__mir.n7 5.2415200000000004
rmesh_equiv_763 pga__gain2__amp__first__mir.n5 pga__gain2__amp__first__mir.t3 174.857
rmesh_equiv_764 pga__gain2__amp__first__mir.n6 pga__gain2__amp__first__mir.n7 5.2415200000000004
rmesh_equiv_765 pga__gain2__amp__first__mir.n6 pga__gain2__amp__first__mir.t3 174.857
rmesh_equiv_766 pga__gain2__amp__first__mir.n7 pga__gain2__amp__first__mir.n8 21.554500000000001
rmesh_equiv_767 pga__gain2__amp__first__mir.n8 pga__gain2__amp__first__mir.n9 1.23464
rmesh_equiv_768 pga__gain2__amp__first__tail pga__gain2__amp__first__tail.n0 19.837
rmesh_equiv_769 pga__gain2__amp__first__tail pga__gain2__amp__first__tail.n1 15.6333
rmesh_equiv_77 bias_source__vcm_buffer__first__mir bias_source__vcm_buffer__first__mir.n11 4.8770699999999998
rmesh_equiv_770 pga__gain2__amp__first__tail pga__gain2__amp__first__tail.n12 15.6333
rmesh_equiv_771 pga__gain2__amp__first__tail pga__gain2__amp__first__tail.n13 15.6333
rmesh_equiv_772 pga__gain2__amp__first__tail pga__gain2__amp__first__tail.n17 4.2590000000000003
rmesh_equiv_773 pga__gain2__amp__first__tail pga__gain2__amp__first__tail.n2 15.6333
rmesh_equiv_774 pga__gain2__amp__first__tail pga__gain2__amp__first__tail.n4 15.6333
rmesh_equiv_775 pga__gain2__amp__first__tail pga__gain2__amp__first__tail.n5 15.6333
rmesh_equiv_776 pga__gain2__amp__first__tail pga__gain2__amp__first__tail.n8 15.6333
rmesh_equiv_777 pga__gain2__amp__first__tail pga__gain2__amp__first__tail.n9 15.6333
rmesh_equiv_778 pga__gain2__amp__first__tail.n0 pga__gain2__amp__first__tail.n16 14.189499999999999
rmesh_equiv_779 pga__gain2__amp__first__tail.n0 pga__gain2__amp__first__tail.t0 174.91200000000001
rmesh_equiv_78 bias_source__vcm_buffer__first__mir bias_source__vcm_buffer__first__mir.n2 15.6333
rmesh_equiv_780 pga__gain2__amp__first__tail.n1 pga__gain2__amp__first__tail.n3 5.2415200000000004
rmesh_equiv_781 pga__gain2__amp__first__tail.n1 pga__gain2__amp__first__tail.t3 174.857
rmesh_equiv_782 pga__gain2__amp__first__tail.n10 pga__gain2__amp__first__tail.n11 21.9712
rmesh_equiv_783 pga__gain2__amp__first__tail.n10 pga__gain2__amp__first__tail.n8 5.2415200000000004
rmesh_equiv_784 pga__gain2__amp__first__tail.n10 pga__gain2__amp__first__tail.n9 5.2415200000000004
rmesh_equiv_785 pga__gain2__amp__first__tail.n11 pga__gain2__amp__first__tail.n15 0.61541699999999999
rmesh_equiv_786 pga__gain2__amp__first__tail.n11 pga__gain2__amp__first__tail.n7 0.61541699999999999
rmesh_equiv_787 pga__gain2__amp__first__tail.n12 pga__gain2__amp__first__tail.n14 5.2415200000000004
rmesh_equiv_788 pga__gain2__amp__first__tail.n12 pga__gain2__amp__first__tail.t4 174.857
rmesh_equiv_789 pga__gain2__amp__first__tail.n13 pga__gain2__amp__first__tail.n14 5.2415200000000004
rmesh_equiv_79 bias_source__vcm_buffer__first__mir bias_source__vcm_buffer__first__mir.n3 15.6333
rmesh_equiv_790 pga__gain2__amp__first__tail.n13 pga__gain2__amp__first__tail.t4 174.857
rmesh_equiv_791 pga__gain2__amp__first__tail.n14 pga__gain2__amp__first__tail.n15 21.9712
rmesh_equiv_792 pga__gain2__amp__first__tail.n15 pga__gain2__amp__first__tail.n16 23.645199999999999
rmesh_equiv_793 pga__gain2__amp__first__tail.n16 pga__gain2__amp__first__tail.n17 3.0467200000000001
rmesh_equiv_794 pga__gain2__amp__first__tail.n17 pga__gain2__amp__first__tail.t0 181.41
rmesh_equiv_795 pga__gain2__amp__first__tail.n2 pga__gain2__amp__first__tail.n3 5.2415200000000004
rmesh_equiv_796 pga__gain2__amp__first__tail.n2 pga__gain2__amp__first__tail.t3 174.857
rmesh_equiv_797 pga__gain2__amp__first__tail.n3 pga__gain2__amp__first__tail.n7 22.586099999999998
rmesh_equiv_798 pga__gain2__amp__first__tail.n4 pga__gain2__amp__first__tail.n6 5.2415200000000004
rmesh_equiv_799 pga__gain2__amp__first__tail.n4 pga__gain2__amp__first__tail.t2 174.857
rmesh_equiv_8 amplified.n0 amplified.t1 174.91200000000001
rmesh_equiv_80 bias_source__vcm_buffer__first__mir bias_source__vcm_buffer__first__mir.n5 15.6333
rmesh_equiv_800 pga__gain2__amp__first__tail.n5 pga__gain2__amp__first__tail.n6 5.2415200000000004
rmesh_equiv_801 pga__gain2__amp__first__tail.n5 pga__gain2__amp__first__tail.t2 174.857
rmesh_equiv_802 pga__gain2__amp__first__tail.n6 pga__gain2__amp__first__tail.n7 21.9712
rmesh_equiv_803 pga__gain2__amp__first__tail.n8 pga__gain2__amp__first__tail.t1 174.857
rmesh_equiv_804 pga__gain2__amp__first__tail.n9 pga__gain2__amp__first__tail.t1 174.857
rmesh_equiv_805 pga__gain2__amp__pre pga__gain2__amp__pre.n0 22.8553
rmesh_equiv_806 pga__gain2__amp__pre pga__gain2__amp__pre.n1 6.6051903754158472
rmesh_equiv_807 pga__gain2__amp__pre pga__gain2__amp__pre.n13 4.8770699999999998
rmesh_equiv_808 pga__gain2__amp__pre pga__gain2__amp__pre.n2 2.7099963452289857
rmesh_equiv_809 pga__gain2__amp__pre pga__gain2__amp__pre.n3 15.6333
rmesh_equiv_81 bias_source__vcm_buffer__first__mir bias_source__vcm_buffer__first__mir.n6 15.6333
rmesh_equiv_810 pga__gain2__amp__pre pga__gain2__amp__pre.n4 15.6333
rmesh_equiv_811 pga__gain2__amp__pre pga__gain2__amp__pre.n7 15.6333
rmesh_equiv_812 pga__gain2__amp__pre pga__gain2__amp__pre.n8 15.6333
rmesh_equiv_813 pga__gain2__amp__pre pga__gain2__amp__pre.t3 0.00141837
rmesh_equiv_814 pga__gain2__amp__pre pga__gain2__amp__pre.t4 0.00141837
rmesh_equiv_815 pga__gain2__amp__pre pga__gain2__amp__pre.t5 0.00141837
rmesh_equiv_816 pga__gain2__amp__pre pga__gain2__amp__pre.t6 1054.8499999999999
rmesh_equiv_817 pga__gain2__amp__pre.n0 pga__gain2__amp__pre.n12 11.4361
rmesh_equiv_818 pga__gain2__amp__pre.n0 pga__gain2__amp__pre.t0 381.113
rmesh_equiv_819 pga__gain2__amp__pre.n1 pga__gain2__amp__pre.n11 1.50881
rmesh_equiv_82 bias_source__vcm_buffer__first__mir bias_source__vcm_buffer__first__mir.t0 572.84699999999998
rmesh_equiv_820 pga__gain2__amp__pre.n10 pga__gain2__amp__pre.n11 1.24326
rmesh_equiv_821 pga__gain2__amp__pre.n10 pga__gain2__amp__pre.n6 1.8452500000000001
rmesh_equiv_822 pga__gain2__amp__pre.n10 pga__gain2__amp__pre.n9 23.2212
rmesh_equiv_823 pga__gain2__amp__pre.n11 pga__gain2__amp__pre.n12 23.2212
rmesh_equiv_824 pga__gain2__amp__pre.n12 pga__gain2__amp__pre.n13 2.4407800000000002
rmesh_equiv_825 pga__gain2__amp__pre.n13 pga__gain2__amp__pre.t0 387.11000000000001
rmesh_equiv_826 pga__gain2__amp__pre.n2 pga__gain2__amp__pre.n6 75.050600000000003
rmesh_equiv_827 pga__gain2__amp__pre.n3 pga__gain2__amp__pre.n5 5.2415200000000004
rmesh_equiv_828 pga__gain2__amp__pre.n3 pga__gain2__amp__pre.t2 174.857
rmesh_equiv_829 pga__gain2__amp__pre.n4 pga__gain2__amp__pre.n5 5.2415200000000004
rmesh_equiv_83 bias_source__vcm_buffer__first__mir bias_source__vcm_buffer__first__mir.t4 572.84699999999998
rmesh_equiv_830 pga__gain2__amp__pre.n4 pga__gain2__amp__pre.t2 174.857
rmesh_equiv_831 pga__gain2__amp__pre.n5 pga__gain2__amp__pre.n6 23.2212
rmesh_equiv_832 pga__gain2__amp__pre.n7 pga__gain2__amp__pre.n9 5.2415200000000004
rmesh_equiv_833 pga__gain2__amp__pre.n7 pga__gain2__amp__pre.t1 174.857
rmesh_equiv_834 pga__gain2__amp__pre.n8 pga__gain2__amp__pre.n9 5.2415200000000004
rmesh_equiv_835 pga__gain2__amp__pre.n8 pga__gain2__amp__pre.t1 174.857
rmesh_equiv_836 pga__gain2__fb pga__gain2__fb.n1 18.473095856558071
rmesh_equiv_837 pga__gain2__fb pga__gain2__fb.t2 212.21199999999999
rmesh_equiv_838 pga__gain2__fb pga__gain2__fb.t3 212.21199999999999
rmesh_equiv_839 pga__gain2__fb.n0 pga__gain2__fb.n1 81.630200000000002
rmesh_equiv_84 bias_source__vcm_buffer__first__mir.n0 bias_source__vcm_buffer__first__mir.n10 11.4361
rmesh_equiv_840 pga__gain2__fb.n0 pga__gain2__fb.t0 26.196400000000001
rmesh_equiv_841 pga__gain2__fb.n0 pga__gain2__fb.t1 30.7682
rmesh_equiv_842 pga__gain8__amp__comp.n0 pga__gain8__amp__comp.n1 2.7844699999999998
rmesh_equiv_843 pga__gain8__amp__comp.n0 pga__gain8__amp__comp.t2 8.2920800000000003
rmesh_equiv_844 pga__gain8__amp__comp.n0 pga__gain8__amp__comp.t3 5.5081199999999999
rmesh_equiv_845 pga__gain8__amp__comp.n1 pga__gain8__amp__comp.t0 29.326600000000003
rmesh_equiv_846 pga__gain8__amp__comp.n1 pga__gain8__amp__comp.t1 5.5081199999999999
rmesh_equiv_847 pga__gain8__amp__first__mir pga__gain8__amp__first__mir.n0 15.6333
rmesh_equiv_848 pga__gain8__amp__first__mir pga__gain8__amp__first__mir.n1 15.9150984819332
rmesh_equiv_849 pga__gain8__amp__first__mir pga__gain8__amp__first__mir.n11 15.6333
rmesh_equiv_85 bias_source__vcm_buffer__first__mir.n0 bias_source__vcm_buffer__first__mir.t1 381.113
rmesh_equiv_850 pga__gain8__amp__first__mir pga__gain8__amp__first__mir.n2 4.8770699999999998
rmesh_equiv_851 pga__gain8__amp__first__mir pga__gain8__amp__first__mir.n3 22.8553
rmesh_equiv_852 pga__gain8__amp__first__mir pga__gain8__amp__first__mir.n6 15.6333
rmesh_equiv_853 pga__gain8__amp__first__mir pga__gain8__amp__first__mir.n7 15.6333
rmesh_equiv_854 pga__gain8__amp__first__mir pga__gain8__amp__first__mir.t2 572.84699999999998
rmesh_equiv_855 pga__gain8__amp__first__mir pga__gain8__amp__first__mir.t4 572.84699999999998
rmesh_equiv_856 pga__gain8__amp__first__mir.n0 pga__gain8__amp__first__mir.n10 5.2415200000000004
rmesh_equiv_857 pga__gain8__amp__first__mir.n0 pga__gain8__amp__first__mir.t0 174.857
rmesh_equiv_858 pga__gain8__amp__first__mir.n1 pga__gain8__amp__first__mir.n5 0.27035799999999999
rmesh_equiv_859 pga__gain8__amp__first__mir.n10 pga__gain8__amp__first__mir.n11 5.2415200000000004
rmesh_equiv_86 bias_source__vcm_buffer__first__mir.n1 bias_source__vcm_buffer__first__mir.n9 0.27035799999999999
rmesh_equiv_860 pga__gain8__amp__first__mir.n10 pga__gain8__amp__first__mir.n9 18.2212
rmesh_equiv_861 pga__gain8__amp__first__mir.n11 pga__gain8__amp__first__mir.t0 174.857
rmesh_equiv_862 pga__gain8__amp__first__mir.n2 pga__gain8__amp__first__mir.n4 2.4407800000000002
rmesh_equiv_863 pga__gain8__amp__first__mir.n2 pga__gain8__amp__first__mir.t3 387.11000000000001
rmesh_equiv_864 pga__gain8__amp__first__mir.n3 pga__gain8__amp__first__mir.n4 11.4361
rmesh_equiv_865 pga__gain8__amp__first__mir.n3 pga__gain8__amp__first__mir.t3 381.113
rmesh_equiv_866 pga__gain8__amp__first__mir.n4 pga__gain8__amp__first__mir.n5 18.2212
rmesh_equiv_867 pga__gain8__amp__first__mir.n5 pga__gain8__amp__first__mir.n9 1.23464
rmesh_equiv_868 pga__gain8__amp__first__mir.n6 pga__gain8__amp__first__mir.n8 5.2415200000000004
rmesh_equiv_869 pga__gain8__amp__first__mir.n6 pga__gain8__amp__first__mir.t1 174.857
rmesh_equiv_87 bias_source__vcm_buffer__first__mir.n10 bias_source__vcm_buffer__first__mir.n11 2.4407800000000002
rmesh_equiv_870 pga__gain8__amp__first__mir.n7 pga__gain8__amp__first__mir.n8 5.2415200000000004
rmesh_equiv_871 pga__gain8__amp__first__mir.n7 pga__gain8__amp__first__mir.t1 174.857
rmesh_equiv_872 pga__gain8__amp__first__mir.n8 pga__gain8__amp__first__mir.n9 18.836099999999998
rmesh_equiv_873 pga__gain8__amp__first__tail pga__gain8__amp__first__tail.n0 19.837
rmesh_equiv_874 pga__gain8__amp__first__tail pga__gain8__amp__first__tail.n1 15.6333
rmesh_equiv_875 pga__gain8__amp__first__tail pga__gain8__amp__first__tail.n12 15.6333
rmesh_equiv_876 pga__gain8__amp__first__tail pga__gain8__amp__first__tail.n13 15.6333
rmesh_equiv_877 pga__gain8__amp__first__tail pga__gain8__amp__first__tail.n17 4.2590000000000003
rmesh_equiv_878 pga__gain8__amp__first__tail pga__gain8__amp__first__tail.n2 15.6333
rmesh_equiv_879 pga__gain8__amp__first__tail pga__gain8__amp__first__tail.n4 15.6333
rmesh_equiv_88 bias_source__vcm_buffer__first__mir.n10 bias_source__vcm_buffer__first__mir.n9 18.637899999999998
rmesh_equiv_880 pga__gain8__amp__first__tail pga__gain8__amp__first__tail.n5 15.6333
rmesh_equiv_881 pga__gain8__amp__first__tail pga__gain8__amp__first__tail.n8 15.6333
rmesh_equiv_882 pga__gain8__amp__first__tail pga__gain8__amp__first__tail.n9 15.6333
rmesh_equiv_883 pga__gain8__amp__first__tail.n0 pga__gain8__amp__first__tail.n16 14.189499999999999
rmesh_equiv_884 pga__gain8__amp__first__tail.n0 pga__gain8__amp__first__tail.t0 174.91200000000001
rmesh_equiv_885 pga__gain8__amp__first__tail.n1 pga__gain8__amp__first__tail.n3 5.2415200000000004
rmesh_equiv_886 pga__gain8__amp__first__tail.n1 pga__gain8__amp__first__tail.t2 174.857
rmesh_equiv_887 pga__gain8__amp__first__tail.n10 pga__gain8__amp__first__tail.n11 18.637899999999998
rmesh_equiv_888 pga__gain8__amp__first__tail.n10 pga__gain8__amp__first__tail.n8 5.2415200000000004
rmesh_equiv_889 pga__gain8__amp__first__tail.n10 pga__gain8__amp__first__tail.n9 5.2415200000000004
rmesh_equiv_89 bias_source__vcm_buffer__first__mir.n11 bias_source__vcm_buffer__first__mir.t1 387.11000000000001
rmesh_equiv_890 pga__gain8__amp__first__tail.n11 pga__gain8__amp__first__tail.n15 0.61541699999999999
rmesh_equiv_891 pga__gain8__amp__first__tail.n11 pga__gain8__amp__first__tail.n7 0.61541699999999999
rmesh_equiv_892 pga__gain8__amp__first__tail.n12 pga__gain8__amp__first__tail.n14 5.2415200000000004
rmesh_equiv_893 pga__gain8__amp__first__tail.n12 pga__gain8__amp__first__tail.t1 174.857
rmesh_equiv_894 pga__gain8__amp__first__tail.n13 pga__gain8__amp__first__tail.n14 5.2415200000000004
rmesh_equiv_895 pga__gain8__amp__first__tail.n13 pga__gain8__amp__first__tail.t1 174.857
rmesh_equiv_896 pga__gain8__amp__first__tail.n14 pga__gain8__amp__first__tail.n15 18.637899999999998
rmesh_equiv_897 pga__gain8__amp__first__tail.n15 pga__gain8__amp__first__tail.n16 20.311900000000001
rmesh_equiv_898 pga__gain8__amp__first__tail.n16 pga__gain8__amp__first__tail.n17 3.0467200000000001
rmesh_equiv_899 pga__gain8__amp__first__tail.n17 pga__gain8__amp__first__tail.t0 181.41
rmesh_equiv_9 amplified.n1 amplified.n8 9.1596299999999999
rmesh_equiv_90 bias_source__vcm_buffer__first__mir.n2 bias_source__vcm_buffer__first__mir.n4 5.2415200000000004
rmesh_equiv_900 pga__gain8__amp__first__tail.n2 pga__gain8__amp__first__tail.n3 5.2415200000000004
rmesh_equiv_901 pga__gain8__amp__first__tail.n2 pga__gain8__amp__first__tail.t2 174.857
rmesh_equiv_902 pga__gain8__amp__first__tail.n3 pga__gain8__amp__first__tail.n7 19.252800000000001
rmesh_equiv_903 pga__gain8__amp__first__tail.n4 pga__gain8__amp__first__tail.n6 5.2415200000000004
rmesh_equiv_904 pga__gain8__amp__first__tail.n4 pga__gain8__amp__first__tail.t4 174.857
rmesh_equiv_905 pga__gain8__amp__first__tail.n5 pga__gain8__amp__first__tail.n6 5.2415200000000004
rmesh_equiv_906 pga__gain8__amp__first__tail.n5 pga__gain8__amp__first__tail.t4 174.857
rmesh_equiv_907 pga__gain8__amp__first__tail.n6 pga__gain8__amp__first__tail.n7 18.637899999999998
rmesh_equiv_908 pga__gain8__amp__first__tail.n8 pga__gain8__amp__first__tail.t3 174.857
rmesh_equiv_909 pga__gain8__amp__first__tail.n9 pga__gain8__amp__first__tail.t3 174.857
rmesh_equiv_91 bias_source__vcm_buffer__first__mir.n2 bias_source__vcm_buffer__first__mir.t2 174.857
rmesh_equiv_910 pga__gain8__amp__pre pga__gain8__amp__pre.n0 15.6333
rmesh_equiv_911 pga__gain8__amp__pre pga__gain8__amp__pre.n1 3.066101307321107
rmesh_equiv_912 pga__gain8__amp__pre pga__gain8__amp__pre.n13 15.6333
rmesh_equiv_913 pga__gain8__amp__pre pga__gain8__amp__pre.n2 5.0414000000000003
rmesh_equiv_914 pga__gain8__amp__pre pga__gain8__amp__pre.n3 28.882600000000004
rmesh_equiv_915 pga__gain8__amp__pre pga__gain8__amp__pre.n4 4.8770699999999998
rmesh_equiv_916 pga__gain8__amp__pre pga__gain8__amp__pre.n5 22.8553
rmesh_equiv_917 pga__gain8__amp__pre pga__gain8__amp__pre.n8 15.6333
rmesh_equiv_918 pga__gain8__amp__pre pga__gain8__amp__pre.n9 15.6333
rmesh_equiv_919 pga__gain8__amp__pre pga__gain8__amp__pre.t3 1054.8499999999999
rmesh_equiv_92 bias_source__vcm_buffer__first__mir.n3 bias_source__vcm_buffer__first__mir.n4 5.2415200000000004
rmesh_equiv_920 pga__gain8__amp__pre pga__gain8__amp__pre.t4 0.00141837
rmesh_equiv_921 pga__gain8__amp__pre pga__gain8__amp__pre.t5 0.00141837
rmesh_equiv_922 pga__gain8__amp__pre pga__gain8__amp__pre.t6 0.00141837
rmesh_equiv_923 pga__gain8__amp__pre.n0 pga__gain8__amp__pre.n12 5.2415200000000004
rmesh_equiv_924 pga__gain8__amp__pre.n0 pga__gain8__amp__pre.t0 174.857
rmesh_equiv_925 pga__gain8__amp__pre.n1 pga__gain8__amp__pre.n2 2.7844699999999998
rmesh_equiv_926 pga__gain8__amp__pre.n10 pga__gain8__amp__pre.n11 20.8993
rmesh_equiv_927 pga__gain8__amp__pre.n10 pga__gain8__amp__pre.n8 5.2415200000000004
rmesh_equiv_928 pga__gain8__amp__pre.n10 pga__gain8__amp__pre.n9 5.2415200000000004
rmesh_equiv_929 pga__gain8__amp__pre.n11 pga__gain8__amp__pre.n12 19.054500000000001
rmesh_equiv_93 bias_source__vcm_buffer__first__mir.n3 bias_source__vcm_buffer__first__mir.t2 174.857
rmesh_equiv_930 pga__gain8__amp__pre.n11 pga__gain8__amp__pre.n7 1.24326
rmesh_equiv_931 pga__gain8__amp__pre.n12 pga__gain8__amp__pre.n13 5.2415200000000004
rmesh_equiv_932 pga__gain8__amp__pre.n13 pga__gain8__amp__pre.t0 174.857
rmesh_equiv_933 pga__gain8__amp__pre.n2 pga__gain8__amp__pre.n3 2.0861200000000002
rmesh_equiv_934 pga__gain8__amp__pre.n3 pga__gain8__amp__pre.n7 1.50881
rmesh_equiv_935 pga__gain8__amp__pre.n4 pga__gain8__amp__pre.n6 2.4407800000000002
rmesh_equiv_936 pga__gain8__amp__pre.n4 pga__gain8__amp__pre.t1 387.11000000000001
rmesh_equiv_937 pga__gain8__amp__pre.n5 pga__gain8__amp__pre.n6 11.4361
rmesh_equiv_938 pga__gain8__amp__pre.n5 pga__gain8__amp__pre.t1 381.113
rmesh_equiv_939 pga__gain8__amp__pre.n6 pga__gain8__amp__pre.n7 19.054500000000001
rmesh_equiv_94 bias_source__vcm_buffer__first__mir.n4 bias_source__vcm_buffer__first__mir.n8 19.252800000000001
rmesh_equiv_940 pga__gain8__amp__pre.n8 pga__gain8__amp__pre.t2 174.857
rmesh_equiv_941 pga__gain8__amp__pre.n9 pga__gain8__amp__pre.t2 174.857
rmesh_equiv_942 pga__gain8__fb pga__gain8__fb.n1 18.473095856558071
rmesh_equiv_943 pga__gain8__fb pga__gain8__fb.t2 212.21199999999999
rmesh_equiv_944 pga__gain8__fb pga__gain8__fb.t3 212.21199999999999
rmesh_equiv_945 pga__gain8__fb.n0 pga__gain8__fb.n1 13.040699999999999
rmesh_equiv_946 pga__gain8__fb.n0 pga__gain8__fb.t0 29.529800000000002
rmesh_equiv_947 pga__gain8__fb.n0 pga__gain8__fb.t1 37.784100000000002
rmesh_equiv_948 pga__gainb pga__gainb.n0 12.8005
rmesh_equiv_949 pga__gainb pga__gainb.n1 19.746167787286065
rmesh_equiv_95 bias_source__vcm_buffer__first__mir.n5 bias_source__vcm_buffer__first__mir.n7 5.2415200000000004
rmesh_equiv_950 pga__gainb pga__gainb.n2 12.8005
rmesh_equiv_951 pga__gainb pga__gainb.n3 12.8005
rmesh_equiv_952 pga__gainb pga__gainb.n7 12.8005
rmesh_equiv_953 pga__gainb pga__gainb.t2 3424.7800000000002
rmesh_equiv_954 pga__gainb pga__gainb.t3 3439.2399999999998
rmesh_equiv_955 pga__gainb.n0 pga__gainb.n6 10.151300000000001
rmesh_equiv_956 pga__gainb.n0 pga__gainb.t0 700.48400000000004
rmesh_equiv_957 pga__gainb.n1 pga__gainb.n5 0.78539999999999988
rmesh_equiv_958 pga__gainb.n2 pga__gainb.n4 10.151300000000001
rmesh_equiv_959 pga__gainb.n2 pga__gainb.t1 255.34500000000003
rmesh_equiv_96 bias_source__vcm_buffer__first__mir.n5 bias_source__vcm_buffer__first__mir.t3 174.857
rmesh_equiv_960 pga__gainb.n3 pga__gainb.n4 10.151300000000001
rmesh_equiv_961 pga__gainb.n3 pga__gainb.t1 255.34500000000003
rmesh_equiv_962 pga__gainb.n4 pga__gainb.n5 22.700399999999998
rmesh_equiv_963 pga__gainb.n5 pga__gainb.n6 23.253
rmesh_equiv_964 pga__gainb.n6 pga__gainb.n7 10.151300000000001
rmesh_equiv_965 pga__gainb.n7 pga__gainb.t0 700.48400000000004
rmesh_equiv_966 pga__output_buffer__comp.n0 pga__output_buffer__comp.n1 2.7844699999999998
rmesh_equiv_967 pga__output_buffer__comp.n0 pga__output_buffer__comp.t1 6.9745200000000001
rmesh_equiv_968 pga__output_buffer__comp.n0 pga__output_buffer__comp.t3 34.743299999999998
rmesh_equiv_969 pga__output_buffer__comp.n1 pga__output_buffer__comp.n2 9.7504799999999996
rmesh_equiv_97 bias_source__vcm_buffer__first__mir.n6 bias_source__vcm_buffer__first__mir.n7 5.2415200000000004
rmesh_equiv_970 pga__output_buffer__comp.n1 pga__output_buffer__comp.t0 6.9745200000000001
rmesh_equiv_971 pga__output_buffer__comp.n2 pga__output_buffer__comp.t2 0.025939499999999997
rmesh_equiv_972 pga__output_buffer__first__mir pga__output_buffer__first__mir.n0 22.8553
rmesh_equiv_973 pga__output_buffer__first__mir pga__output_buffer__first__mir.n1 18.415305702049103
rmesh_equiv_974 pga__output_buffer__first__mir pga__output_buffer__first__mir.n11 4.8770699999999998
rmesh_equiv_975 pga__output_buffer__first__mir pga__output_buffer__first__mir.n2 15.6333
rmesh_equiv_976 pga__output_buffer__first__mir pga__output_buffer__first__mir.n3 15.6333
rmesh_equiv_977 pga__output_buffer__first__mir pga__output_buffer__first__mir.n5 15.6333
rmesh_equiv_978 pga__output_buffer__first__mir pga__output_buffer__first__mir.n6 15.6333
rmesh_equiv_979 pga__output_buffer__first__mir pga__output_buffer__first__mir.t0 572.84699999999998
rmesh_equiv_98 bias_source__vcm_buffer__first__mir.n6 bias_source__vcm_buffer__first__mir.t3 174.857
rmesh_equiv_980 pga__output_buffer__first__mir pga__output_buffer__first__mir.t4 572.84699999999998
rmesh_equiv_981 pga__output_buffer__first__mir.n0 pga__output_buffer__first__mir.n10 11.4361
rmesh_equiv_982 pga__output_buffer__first__mir.n0 pga__output_buffer__first__mir.t1 381.113
rmesh_equiv_983 pga__output_buffer__first__mir.n1 pga__output_buffer__first__mir.n9 0.27035799999999999
rmesh_equiv_984 pga__output_buffer__first__mir.n10 pga__output_buffer__first__mir.n11 2.4407800000000002
rmesh_equiv_985 pga__output_buffer__first__mir.n10 pga__output_buffer__first__mir.n9 23.2212
rmesh_equiv_986 pga__output_buffer__first__mir.n11 pga__output_buffer__first__mir.t1 387.11000000000001
rmesh_equiv_987 pga__output_buffer__first__mir.n2 pga__output_buffer__first__mir.n4 5.2415200000000004
rmesh_equiv_988 pga__output_buffer__first__mir.n2 pga__output_buffer__first__mir.t2 174.857
rmesh_equiv_989 pga__output_buffer__first__mir.n3 pga__output_buffer__first__mir.n4 5.2415200000000004
rmesh_equiv_99 bias_source__vcm_buffer__first__mir.n7 bias_source__vcm_buffer__first__mir.n8 18.637899999999998
rmesh_equiv_990 pga__output_buffer__first__mir.n3 pga__output_buffer__first__mir.t2 174.857
rmesh_equiv_991 pga__output_buffer__first__mir.n4 pga__output_buffer__first__mir.n8 23.836099999999998
rmesh_equiv_992 pga__output_buffer__first__mir.n5 pga__output_buffer__first__mir.n7 5.2415200000000004
rmesh_equiv_993 pga__output_buffer__first__mir.n5 pga__output_buffer__first__mir.t3 174.857
rmesh_equiv_994 pga__output_buffer__first__mir.n6 pga__output_buffer__first__mir.n7 5.2415200000000004
rmesh_equiv_995 pga__output_buffer__first__mir.n6 pga__output_buffer__first__mir.t3 174.857
rmesh_equiv_996 pga__output_buffer__first__mir.n7 pga__output_buffer__first__mir.n8 23.2212
rmesh_equiv_997 pga__output_buffer__first__mir.n8 pga__output_buffer__first__mir.n9 1.23464
rmesh_equiv_998 pga__output_buffer__first__tail pga__output_buffer__first__tail.n0 19.837
rmesh_equiv_999 pga__output_buffer__first__tail pga__output_buffer__first__tail.n1 15.6333
.ends

Resistor analog SoC soc_sensor_afe
.include "/workspace/.runtime/eda/runs/407d981857554744ab8f82a8df639657/supported-tt.spice"
.options method=gear maxord=2
.include "/workspace/.runtime/eda/runs/407d981857554744ab8f82a8df639657/current-probe.spice"
.temp 27.0
VGND VGND 0 0
VDD VPWR VGND 1.8
VIN VIN VGND DC 0.9 AC 1 SIN(0.9 0.025 5000)
VGAIN GAIN VGND PULSE(0 1.8 100u 2n 2n 1 2)
VCLK CLK VGND PULSE(0 1.8 250n 2n 2n 498n 1u)
VRESET RESET VGND PWL(0 1.8 5u 1.8 5.002u 0)
CLOAD OUT VGND 50f
.nodeset v(VCM)=0.9 v(OUT)=0.9
XU VIN GAIN CLK RESET OUT DATA VCM BIAS VPWR VGND soc_sensor_afe
.control
save v(OUT) i(VDD) v(VIN) v(GAIN) v(CLK) v(RESET) v(DATA) v(VCM) v(BIAS) i(v.xu.vregister_cf_1cdfa349d923dfb6) i(v.xu.vregister_cf_010ee9fd4a343b34) i(v.xu.vregister_cf_86c2e59fe1a1137f) i(v.xu.vregister_cf_e65e9d2831f61968) i(v.xu.vregister_cf_53b1d46c0d721a2a) i(v.xu.vregister_cf_10874caec9dc87ee) i(v.xu.vregister_cf_fda8c84343d7ad8c) i(v.xu.vregister_cf_24a7912a68e04950) i(v.xu.vregister_cf_a4f143fea9f2cfff) i(v.xu.vregister_cf_eca2d4119abf5ea4) i(v.xu.vregister_cf_642c575fea9eb7d4) i(v.xu.vregister_cf_9d1744eca2d64648) i(v.xu.vregister_cf_e3102478511b8837) i(v.xu.vregister_cf_18f5662f0d50ee36) i(v.xu.vregister_cf_334141ce685e7c2f) i(v.xu.vregister_cf_c53c0b2565f53ef4) i(v.xu.vregister_cf_98a25b8d46859b10) i(v.xu.vregister_cf_f71c900296670c23) i(v.xu.vregister_cf_fd24172a709ce84c) i(v.xu.vregister_cf_f860d621dc4e1a72) i(v.xu.vregister_cf_dd39e4456990685c) i(v.xu.vregister_cf_0e13bf8b496f9c68) i(v.xu.vregister_cf_26348b89100366b7) i(v.xu.vregister_cf_fd6e518dd7979607) i(v.xu.vregister_cf_7c0362d20f1bb9aa) i(v.xu.vregister_cf_541e2876687f09d3) i(v.xu.vregister_cf_817bc62e2d936bbc) i(v.xu.vregister_cf_47a0232f04d50307) i(v.xu.vregister_cf_f20522ccfb4fbffd) i(v.xu.vregister_cf_7ae7ea44db9db16e) i(v.xu.vregister_cf_cb520d6f20b8f9af) i(v.xu.vregister_cf_0a9ac7a772237125) i(v.xu.vregister_cf_582c5051c2480a75) i(v.xu.vregister_cf_016483cc89710033) i(v.xu.vregister_cf_29a31ddf48631d60) i(v.xu.vregister_cf_5326ce4d2652e940) i(v.xu.vregister_cf_22bb0e87a0a6d1b9) i(v.xu.vregister_cf_1430bc036b43c326) i(v.xu.vregister_cf_3cdc7892dc0fa716) i(v.xu.vregister_cf_b1fc834ad3f93740) i(v.xu.vregister_cf_1dc446d71701f632) i(v.xu.vregister_cf_15874693ba242ef8) i(v.xu.vregister_cf_ace589ac47ba651a) i(v.xu.vregister_cf_26f7654ef79c34f3) i(v.xu.vregister_cf_5371070aa36cbaad) i(v.xu.vregister_cf_94c7081f2afce902) i(v.xu.vregister_cf_be166804ba66477a) i(v.xu.vregister_cf_cd0a0b04a035807c) i(v.xu.vregister_cf_da2ae6e5b0bf46f2) i(v.xu.vregister_cf_bf6517cd56f83693) i(v.xu.vregister_cf_d4a491a2376a04cc) i(v.xu.vregister_cf_84c0a17c2c5e80c4) i(v.xu.vregister_cf_d9dbc7ed25faccea) i(v.xu.vregister_cf_33dcc485d4a44380) i(v.xu.vregister_cf_47c0aa59d6a62f8c) i(v.xu.vregister_cf_104eea0b14c55918) i(VGND) i(VIN) i(VGAIN) i(VCLK) i(VRESET) v(VGND) v(XU.BIAS_SOURCE__VCM_BUFFER__FIRST__MIR) v(XU.BIAS_SOURCE__VCM_BUFFER__FIRST__TAIL) v(XU.BIAS_SOURCE__VCM_BUFFER__PRE) v(XU.BIAS_SOURCE__VCM_RAW) v(VPWR) v(XU.CMP) v(XU.COMPARATOR__PRE) v(XU.COMPARATOR__PREAMP__MIR) v(XU.COMPARATOR__PREAMP__TAIL) v(XU.FILTER__BUFFER0__FIRST__MIR) v(XU.FILTER__BUFFER0__FIRST__TAIL) v(XU.FILTER__MID) v(XU.FILTER__BUFFER0__PRE) v(XU.FILTER__FILTER0) v(XU.FILTER__BUFFER1__FIRST__MIR) v(XU.FILTER__BUFFER1__FIRST__TAIL) v(XU.FILTER__BUFFER1__PRE) v(XU.FILTER__FILTER1) v(XU.PGA__GAIN2__AMP__FIRST__MIR) v(XU.PGA__GAIN2__AMP__FIRST__TAIL) v(XU.PGA__GAIN2__FB) v(XU.PGA__GAIN2__AMP__PRE) v(XU.PGA__V2) v(XU.PGA__GAIN8__AMP__FIRST__MIR) v(XU.PGA__GAIN8__AMP__FIRST__TAIL) v(XU.PGA__GAIN8__FB) v(XU.PGA__GAIN8__AMP__PRE) v(XU.PGA__V8) v(XU.PGA__GAINB) v(XU.PGA__SELECTED)
set num_threads=1
set numdgt=17
set wr_singlescale
set wr_vecnames
set noaskquit
tran 2e-08 0.0002
let mos_wave_0 = v(OUT)
let mos_wave_1 = -i(VDD)
let mos_wave_2 = v(VIN)
let mos_wave_3 = v(GAIN)
let mos_wave_4 = v(CLK)
let mos_wave_5 = v(RESET)
let mos_wave_6 = v(DATA)
let mos_wave_7 = v(VCM)
let mos_wave_8 = v(BIAS)
wrdata waveform.dat mos_wave_0 mos_wave_1 mos_wave_2 mos_wave_3 mos_wave_4 mos_wave_5 mos_wave_6 mos_wave_7 mos_wave_8
write waveform.raw all
let register_flow_0 = i(v.xu.vregister_cf_1cdfa349d923dfb6)
let register_flow_1 = i(v.xu.vregister_cf_010ee9fd4a343b34)
let register_flow_2 = i(v.xu.vregister_cf_86c2e59fe1a1137f)
let register_flow_3 = i(v.xu.vregister_cf_e65e9d2831f61968)
let register_flow_4 = i(v.xu.vregister_cf_53b1d46c0d721a2a)
let register_flow_5 = i(v.xu.vregister_cf_10874caec9dc87ee)
let register_flow_6 = i(v.xu.vregister_cf_fda8c84343d7ad8c)
let register_flow_7 = i(v.xu.vregister_cf_24a7912a68e04950)
let register_flow_8 = i(v.xu.vregister_cf_a4f143fea9f2cfff)
let register_flow_9 = i(v.xu.vregister_cf_eca2d4119abf5ea4)
let register_flow_10 = i(v.xu.vregister_cf_642c575fea9eb7d4)
let register_flow_11 = i(v.xu.vregister_cf_9d1744eca2d64648)
let register_flow_12 = i(v.xu.vregister_cf_e3102478511b8837)
let register_flow_13 = i(v.xu.vregister_cf_18f5662f0d50ee36)
let register_flow_14 = i(v.xu.vregister_cf_334141ce685e7c2f)
let register_flow_15 = i(v.xu.vregister_cf_c53c0b2565f53ef4)
let register_flow_16 = i(v.xu.vregister_cf_98a25b8d46859b10)
let register_flow_17 = i(v.xu.vregister_cf_f71c900296670c23)
let register_flow_18 = i(v.xu.vregister_cf_fd24172a709ce84c)
let register_flow_19 = i(v.xu.vregister_cf_f860d621dc4e1a72)
let register_flow_20 = i(v.xu.vregister_cf_dd39e4456990685c)
let register_flow_21 = i(v.xu.vregister_cf_0e13bf8b496f9c68)
let register_flow_22 = i(v.xu.vregister_cf_26348b89100366b7)
let register_flow_23 = i(v.xu.vregister_cf_fd6e518dd7979607)
let register_flow_24 = i(v.xu.vregister_cf_7c0362d20f1bb9aa)
let register_flow_25 = i(v.xu.vregister_cf_541e2876687f09d3)
let register_flow_26 = i(v.xu.vregister_cf_817bc62e2d936bbc)
let register_flow_27 = i(v.xu.vregister_cf_47a0232f04d50307)
let register_flow_28 = i(v.xu.vregister_cf_f20522ccfb4fbffd)
let register_flow_29 = i(v.xu.vregister_cf_7ae7ea44db9db16e)
let register_flow_30 = i(v.xu.vregister_cf_cb520d6f20b8f9af)
let register_flow_31 = i(v.xu.vregister_cf_0a9ac7a772237125)
let register_flow_32 = i(v.xu.vregister_cf_582c5051c2480a75)
let register_flow_33 = i(v.xu.vregister_cf_016483cc89710033)
let register_flow_34 = i(v.xu.vregister_cf_29a31ddf48631d60)
let register_flow_35 = i(v.xu.vregister_cf_5326ce4d2652e940)
let register_flow_36 = i(v.xu.vregister_cf_22bb0e87a0a6d1b9)
let register_flow_37 = i(v.xu.vregister_cf_1430bc036b43c326)
let register_flow_38 = i(v.xu.vregister_cf_3cdc7892dc0fa716)
let register_flow_39 = i(v.xu.vregister_cf_b1fc834ad3f93740)
let register_flow_40 = i(v.xu.vregister_cf_1dc446d71701f632)
let register_flow_41 = i(v.xu.vregister_cf_15874693ba242ef8)
let register_flow_42 = i(v.xu.vregister_cf_ace589ac47ba651a)
let register_flow_43 = i(v.xu.vregister_cf_26f7654ef79c34f3)
let register_flow_44 = i(v.xu.vregister_cf_5371070aa36cbaad)
let register_flow_45 = i(v.xu.vregister_cf_94c7081f2afce902)
let register_flow_46 = i(v.xu.vregister_cf_be166804ba66477a)
let register_flow_47 = i(v.xu.vregister_cf_cd0a0b04a035807c)
let register_flow_48 = i(v.xu.vregister_cf_da2ae6e5b0bf46f2)
let register_flow_49 = i(v.xu.vregister_cf_bf6517cd56f83693)
let register_flow_50 = i(v.xu.vregister_cf_d4a491a2376a04cc)
let register_flow_51 = i(v.xu.vregister_cf_84c0a17c2c5e80c4)
let register_flow_52 = i(v.xu.vregister_cf_d9dbc7ed25faccea)
let register_flow_53 = i(v.xu.vregister_cf_33dcc485d4a44380)
let register_flow_54 = i(v.xu.vregister_cf_47c0aa59d6a62f8c)
let register_flow_55 = i(v.xu.vregister_cf_104eea0b14c55918)
let register_flow_56 = i(VGND)
let register_flow_57 = i(VDD)
let register_flow_58 = i(VIN)
let register_flow_59 = i(VGAIN)
let register_flow_60 = i(VCLK)
let register_flow_61 = i(VRESET)
wrdata current-flow.dat register_flow_0 register_flow_1 register_flow_2 register_flow_3 register_flow_4 register_flow_5 register_flow_6 register_flow_7 register_flow_8 register_flow_9 register_flow_10 register_flow_11 register_flow_12 register_flow_13 register_flow_14 register_flow_15 register_flow_16 register_flow_17 register_flow_18 register_flow_19 register_flow_20 register_flow_21 register_flow_22 register_flow_23 register_flow_24 register_flow_25 register_flow_26 register_flow_27 register_flow_28 register_flow_29 register_flow_30 register_flow_31 register_flow_32 register_flow_33 register_flow_34 register_flow_35 register_flow_36 register_flow_37 register_flow_38 register_flow_39 register_flow_40 register_flow_41 register_flow_42 register_flow_43 register_flow_44 register_flow_45 register_flow_46 register_flow_47 register_flow_48 register_flow_49 register_flow_50 register_flow_51 register_flow_52 register_flow_53 register_flow_54 register_flow_55 register_flow_56 register_flow_57 register_flow_58 register_flow_59 register_flow_60 register_flow_61
let register_voltage_0 = v(BIAS)
let register_voltage_1 = v(VGND)
let register_voltage_2 = v(XU.BIAS_SOURCE__VCM_BUFFER__FIRST__MIR)
let register_voltage_3 = v(XU.BIAS_SOURCE__VCM_BUFFER__FIRST__TAIL)
let register_voltage_4 = v(VCM)
let register_voltage_5 = v(XU.BIAS_SOURCE__VCM_BUFFER__PRE)
let register_voltage_6 = v(XU.BIAS_SOURCE__VCM_RAW)
let register_voltage_7 = v(VPWR)
let register_voltage_8 = v(XU.CMP)
let register_voltage_9 = v(XU.COMPARATOR__PRE)
let register_voltage_10 = v(XU.COMPARATOR__PREAMP__MIR)
let register_voltage_11 = v(XU.COMPARATOR__PREAMP__TAIL)
let register_voltage_12 = v(OUT)
let register_voltage_13 = v(XU.FILTER__BUFFER0__FIRST__MIR)
let register_voltage_14 = v(XU.FILTER__BUFFER0__FIRST__TAIL)
let register_voltage_15 = v(XU.FILTER__MID)
let register_voltage_16 = v(XU.FILTER__BUFFER0__PRE)
let register_voltage_17 = v(XU.FILTER__FILTER0)
let register_voltage_18 = v(XU.FILTER__BUFFER1__FIRST__MIR)
let register_voltage_19 = v(XU.FILTER__BUFFER1__FIRST__TAIL)
let register_voltage_20 = v(XU.FILTER__BUFFER1__PRE)
let register_voltage_21 = v(XU.FILTER__FILTER1)
let register_voltage_22 = v(XU.PGA__GAIN2__AMP__FIRST__MIR)
let register_voltage_23 = v(XU.PGA__GAIN2__AMP__FIRST__TAIL)
let register_voltage_24 = v(XU.PGA__GAIN2__FB)
let register_voltage_25 = v(XU.PGA__GAIN2__AMP__PRE)
let register_voltage_26 = v(VIN)
let register_voltage_27 = v(XU.PGA__V2)
let register_voltage_28 = v(XU.PGA__GAIN8__AMP__FIRST__MIR)
let register_voltage_29 = v(XU.PGA__GAIN8__AMP__FIRST__TAIL)
let register_voltage_30 = v(XU.PGA__GAIN8__FB)
let register_voltage_31 = v(XU.PGA__GAIN8__AMP__PRE)
let register_voltage_32 = v(XU.PGA__V8)
let register_voltage_33 = v(XU.PGA__GAINB)
let register_voltage_34 = v(GAIN)
let register_voltage_35 = v(XU.PGA__SELECTED)
let register_voltage_36 = 0*register_flow_0
let register_voltage_37 = v(CLK)
let register_voltage_38 = v(RESET)
wrdata node-voltages.dat register_voltage_0 register_voltage_1 register_voltage_2 register_voltage_3 register_voltage_4 register_voltage_5 register_voltage_6 register_voltage_7 register_voltage_8 register_voltage_9 register_voltage_10 register_voltage_11 register_voltage_12 register_voltage_13 register_voltage_14 register_voltage_15 register_voltage_16 register_voltage_17 register_voltage_18 register_voltage_19 register_voltage_20 register_voltage_21 register_voltage_22 register_voltage_23 register_voltage_24 register_voltage_25 register_voltage_26 register_voltage_27 register_voltage_28 register_voltage_29 register_voltage_30 register_voltage_31 register_voltage_32 register_voltage_33 register_voltage_34 register_voltage_35 register_voltage_36 register_voltage_37 register_voltage_38
quit
.endc
.end

* NGSPICE file created from soc_sensor_afe.ext - technology: sky130A

.subckt soc_sensor_afe VIN VGND VCM RESET OUT VPWR DATA GAIN CLK BIAS
X0 VGND GAIN PGA__GAINB VGND sky130_fd_pr__nfet_01v8 ad=0.1885 pd=1.88 as=0.1885 ps=1.88 w=0.65 l=0.15
X1 VPWR PGA__GAIN2__AMP__FIRST__MIR PGA__GAIN2__AMP__FIRST__MIR VPWR sky130_fd_pr__pfet_01v8_hvt ad=5.8 pd=40.58 as=5.8 ps=40.58 w=20 l=1
X2 BIAS_SOURCE__VCM_BUFFER__PRE BIAS_SOURCE__VCM_BUFFER__COMP sky130_fd_pr__cap_mim_m3_1 l=28.68 w=28.68
X3 FILTER__FILTER0 VGND sky130_fd_pr__cap_mim_m3_1 l=28.68 w=28.68
X4 VPWR RESET RESET_MUX__SB VPWR sky130_fd_pr__pfet_01v8_hvt ad=0.1885 pd=1.88 as=0.1885 ps=1.88 w=0.65 l=0.15
X5 VPWR PGA__GAIN8__AMP__FIRST__MIR PGA__GAIN8__AMP__PRE VPWR sky130_fd_pr__pfet_01v8_hvt ad=5.8 pd=40.58 as=5.8 ps=40.58 w=20 l=1
X6 VPWR SAMPLE__TB DATA VPWR sky130_fd_pr__pfet_01v8_hvt ad=0.1885 pd=1.88 as=0.1885 ps=1.88 w=0.65 l=0.15
X7 VGND BIAS PGA__OUTPUT_BUFFER__FIRST__TAIL VGND sky130_fd_pr__nfet_01v8 ad=0.58 pd=4.58 as=0.58 ps=4.58 w=2 l=1
X8 PGA__GAIN8__AMP__COMP PGA__V8 VGND sky130_fd_pr__res_xhigh_po_1p41 l=3.36
X9 FILTER__FILTER1 VGND sky130_fd_pr__cap_mim_m3_1 l=28.68 w=28.68
X10 FILTER__MID FILTER__FILTER1 VGND sky130_fd_pr__res_xhigh_po_1p41 l=28.04
X11 PGA__GAIN2__AMP__COMP PGA__V2 VGND sky130_fd_pr__res_xhigh_po_1p41 l=3.36
X12 BIAS_SOURCE__VCM_RAW VGND sky130_fd_pr__cap_mim_m3_1 l=28.68 w=28.68
X13 VPWR FILTER__BUFFER1__FIRST__MIR FILTER__BUFFER1__FIRST__MIR VPWR sky130_fd_pr__pfet_01v8_hvt ad=5.8 pd=40.58 as=5.8 ps=40.58 w=20 l=1
X14 FILTER__BUFFER1__FIRST__TAIL FILTER__FILTER1 FILTER__BUFFER1__PRE VGND sky130_fd_pr__nfet_01v8 ad=1.45 pd=10.58 as=1.45 ps=10.58 w=5 l=1
X15 PGA__OUTPUT_BUFFER__FIRST__TAIL AMPLIFIED PGA__OUTPUT_BUFFER__FIRST__MIR VGND sky130_fd_pr__nfet_01v8 ad=1.45 pd=10.58 as=1.45 ps=10.58 w=5 l=1
X16 PGA__OUTPUT_BUFFER__PRE PGA__OUTPUT_BUFFER__COMP sky130_fd_pr__cap_mim_m3_1 l=28.68 w=28.68
X17 FILTER__FILTER1 VGND sky130_fd_pr__cap_mim_m3_1 l=28.68 w=28.68
X18 VPWR COMPARATOR__PREAMP__MIR COMPARATOR__PREAMP__MIR VPWR sky130_fd_pr__pfet_01v8_hvt ad=5.8 pd=40.58 as=5.8 ps=40.58 w=20 l=1
X19 PGA__V8 PGA_GAIN8_R_FEEDBACK_R0_N0 VGND sky130_fd_pr__res_xhigh_po_1p41 l=24.51
X20 FILTER__FILTER0 VGND sky130_fd_pr__cap_mim_m3_1 l=28.68 w=28.68
X21 BIAS_SOURCE_R_VCM_BOTTOM_R0_N1 VGND VGND sky130_fd_pr__res_xhigh_po_1p41 l=23.34
X22 COMPARATOR__PREAMP__TAIL OUT COMPARATOR__PRE VGND sky130_fd_pr__nfet_01v8 ad=2.9 pd=20.58 as=2.9 ps=20.58 w=10 l=1
X23 PGA__GAIN2__AMP__PRE PGA__GAIN2__AMP__COMP sky130_fd_pr__cap_mim_m3_1 l=28.68 w=28.68
X24 VGND BIAS OUT VGND sky130_fd_pr__nfet_01v8 ad=0.58 pd=4.58 as=0.58 ps=4.58 w=2 l=1
X25 FILTER__FILTER0 VGND sky130_fd_pr__cap_mim_m3_1 l=28.68 w=28.68
X26 FILTER__FILTER1 VGND sky130_fd_pr__cap_mim_m3_1 l=28.68 w=28.68
X27 FILTER__BUFFER0__PRE FILTER__BUFFER0__COMP sky130_fd_pr__cap_mim_m3_1 l=28.68 w=28.68
X28 PGA__OUTPUT_BUFFER__COMP AMPLIFIED VGND sky130_fd_pr__res_xhigh_po_1p41 l=3.36
X29 PGA__OUTPUT_BUFFER__FIRST__TAIL PGA__SELECTED PGA__OUTPUT_BUFFER__PRE VGND sky130_fd_pr__nfet_01v8 ad=1.45 pd=10.58 as=1.45 ps=10.58 w=5 l=1
X30 VPWR PGA__GAIN8__AMP__PRE PGA__V8 VPWR sky130_fd_pr__pfet_01v8_hvt ad=11.6 pd=80.58 as=11.6 ps=80.58 w=40 l=1
X31 BIAS_SOURCE__VCM_RAW VGND sky130_fd_pr__cap_mim_m3_1 l=28.68 w=28.68
X32 VGND RESET RESET_MUX__SB VGND sky130_fd_pr__nfet_01v8 ad=0.1885 pd=1.88 as=0.1885 ps=1.88 w=0.65 l=0.15
X33 FILTER__FILTER1 VGND sky130_fd_pr__cap_mim_m3_1 l=28.68 w=28.68
X34 VGND SAMPLE__TB DATA VGND sky130_fd_pr__nfet_01v8 ad=0.1885 pd=1.88 as=0.1885 ps=1.88 w=0.65 l=0.15
X35 PGA__GAIN2__AMP__PRE PGA__GAIN2__AMP__COMP sky130_fd_pr__cap_mim_m3_1 l=28.68 w=28.68
X36 BIAS_SOURCE__VCM_BUFFER__COMP VCM VGND sky130_fd_pr__res_xhigh_po_1p41 l=3.36
X37 PGA_GAIN8_R_FEEDBACK_R0_N0 PGA__GAIN8__FB VGND sky130_fd_pr__res_xhigh_po_1p41 l=24.51
X38 FILTER__FILTER1 VGND sky130_fd_pr__cap_mim_m3_1 l=28.68 w=28.68
X39 FILTER__BUFFER0__FIRST__TAIL FILTER__MID FILTER__BUFFER0__FIRST__MIR VGND sky130_fd_pr__nfet_01v8 ad=1.45 pd=10.58 as=1.45 ps=10.58 w=5 l=1
X40 PGA__GAIN8__AMP__PRE PGA__GAIN8__AMP__COMP sky130_fd_pr__cap_mim_m3_1 l=28.68 w=28.68
X41 BIAS_SOURCE_R_VCM_TOP_R0_N0 BIAS_SOURCE_R_VCM_TOP_R0_N1 VGND sky130_fd_pr__res_xhigh_po_1p41 l=23.34
X42 FILTER__BUFFER0__COMP FILTER__MID VGND sky130_fd_pr__res_xhigh_po_1p41 l=3.36
X43 BIAS_SOURCE__VCM_RAW VGND sky130_fd_pr__cap_mim_m3_1 l=28.68 w=28.68
X44 FILTER__FILTER1 VGND sky130_fd_pr__cap_mim_m3_1 l=28.68 w=28.68
X45 VPWR PGA__GAIN8__AMP__FIRST__MIR PGA__GAIN8__AMP__FIRST__MIR VPWR sky130_fd_pr__pfet_01v8_hvt ad=5.8 pd=40.58 as=5.8 ps=40.58 w=20 l=1
X46 VGND BIAS FILTER__BUFFER1__FIRST__TAIL VGND sky130_fd_pr__nfet_01v8 ad=0.58 pd=4.58 as=0.58 ps=4.58 w=2 l=1
X47 FILTER__BUFFER0__FIRST__TAIL FILTER__MID FILTER__BUFFER0__FIRST__MIR VGND sky130_fd_pr__nfet_01v8 ad=1.45 pd=10.58 as=1.45 ps=10.58 w=5 l=1
X48 BIAS_SOURCE__VCM_RAW VGND sky130_fd_pr__cap_mim_m3_1 l=28.68 w=28.68
X49 VPWR BIAS_SOURCE__VCM_BUFFER__FIRST__MIR BIAS_SOURCE__VCM_BUFFER__PRE VPWR sky130_fd_pr__pfet_01v8_hvt ad=5.8 pd=40.58 as=5.8 ps=40.58 w=20 l=1
X50 FILTER__BUFFER1__PRE FILTER__BUFFER1__COMP sky130_fd_pr__cap_mim_m3_1 l=28.68 w=28.68
X51 VGND BIAS VCM VGND sky130_fd_pr__nfet_01v8 ad=0.58 pd=4.58 as=0.58 ps=4.58 w=2 l=1
X52 VPWR COMPARATOR__PRE CMP VPWR sky130_fd_pr__pfet_01v8_hvt ad=2.32 pd=16.58 as=2.32 ps=16.58 w=8 l=0.15
X53 VPWR GAIN PGA__GAINB VPWR sky130_fd_pr__pfet_01v8_hvt ad=0.1885 pd=1.88 as=0.1885 ps=1.88 w=0.65 l=0.15
X54 BIAS_SOURCE__VCM_BUFFER__FIRST__TAIL VCM BIAS_SOURCE__VCM_BUFFER__FIRST__MIR VGND sky130_fd_pr__nfet_01v8 ad=1.45 pd=10.58 as=1.45 ps=10.58 w=5 l=1
X55 VPWR PGA__OUTPUT_BUFFER__FIRST__MIR PGA__OUTPUT_BUFFER__PRE VPWR sky130_fd_pr__pfet_01v8_hvt ad=5.8 pd=40.58 as=5.8 ps=40.58 w=20 l=1
X56 BIAS_SOURCE__VCM_RAW BIAS_SOURCE_R_VCM_BOTTOM_R0_N0 VGND sky130_fd_pr__res_xhigh_po_1p41 l=23.34
X57 FILTER__FILTER1 VGND sky130_fd_pr__cap_mim_m3_1 l=28.68 w=28.68
X58 D CLK SAMPLE__M VPWR sky130_fd_pr__pfet_01v8_hvt ad=0.1885 pd=1.88 as=0.1885 ps=1.88 w=0.65 l=0.15
X59 FILTER__FILTER0 VGND sky130_fd_pr__cap_mim_m3_1 l=28.68 w=28.68
X60 BIAS_SOURCE__VCM_RAW VGND sky130_fd_pr__cap_mim_m3_1 l=28.68 w=28.68
X61 FILTER__FILTER0 VGND sky130_fd_pr__cap_mim_m3_1 l=28.68 w=28.68
X62 SAMPLE__MF SAMPLE__CLKB SAMPLE__M VPWR sky130_fd_pr__pfet_01v8_hvt ad=0.1885 pd=1.88 as=0.1885 ps=1.88 w=0.65 l=0.15
X63 FILTER__BUFFER0__PRE FILTER__BUFFER0__COMP sky130_fd_pr__cap_mim_m3_1 l=28.68 w=28.68
X64 PGA__GAIN2__AMP__PRE PGA__GAIN2__AMP__COMP sky130_fd_pr__cap_mim_m3_1 l=28.68 w=28.68
X65 VPWR FILTER__BUFFER1__PRE OUT VPWR sky130_fd_pr__pfet_01v8_hvt ad=11.6 pd=80.58 as=11.6 ps=80.58 w=40 l=1
X66 VPWR FILTER__BUFFER0__PRE FILTER__MID VPWR sky130_fd_pr__pfet_01v8_hvt ad=11.6 pd=80.58 as=11.6 ps=80.58 w=40 l=1
X67 VPWR BIAS VGND sky130_fd_pr__res_xhigh_po_1p41 l=20.99
X68 SAMPLE__MF SAMPLE__CLKB SAMPLE__T VPWR sky130_fd_pr__pfet_01v8_hvt ad=0.1885 pd=1.88 as=0.1885 ps=1.88 w=0.65 l=0.15
X69 PGA__GAIN8__AMP__FIRST__TAIL VIN PGA__GAIN8__AMP__PRE VGND sky130_fd_pr__nfet_01v8 ad=1.45 pd=10.58 as=1.45 ps=10.58 w=5 l=1
X70 BIAS_SOURCE__VCM_RAW VGND sky130_fd_pr__cap_mim_m3_1 l=28.68 w=28.68
X71 FILTER__FILTER1 VGND sky130_fd_pr__cap_mim_m3_1 l=28.68 w=28.68
X72 VGND BIAS AMPLIFIED VGND sky130_fd_pr__nfet_01v8 ad=0.58 pd=4.58 as=0.58 ps=4.58 w=2 l=1
X73 D SAMPLE__CLKB SAMPLE__M VGND sky130_fd_pr__nfet_01v8 ad=0.1885 pd=1.88 as=0.1885 ps=1.88 w=0.65 l=0.15
X74 BIAS_SOURCE__VCM_RAW VGND sky130_fd_pr__cap_mim_m3_1 l=28.68 w=28.68
X75 PGA__OUTPUT_BUFFER__PRE PGA__OUTPUT_BUFFER__COMP sky130_fd_pr__cap_mim_m3_1 l=28.68 w=28.68
X76 FILTER__BUFFER0__FIRST__TAIL FILTER__FILTER0 FILTER__BUFFER0__PRE VGND sky130_fd_pr__nfet_01v8 ad=1.45 pd=10.58 as=1.45 ps=10.58 w=5 l=1
X77 VGND BIAS PGA__V2 VGND sky130_fd_pr__nfet_01v8 ad=0.58 pd=4.58 as=0.58 ps=4.58 w=2 l=1
X78 SAMPLE__MF CLK SAMPLE__M VGND sky130_fd_pr__nfet_01v8 ad=0.1885 pd=1.88 as=0.1885 ps=1.88 w=0.65 l=0.15
X79 FILTER__FILTER0 VGND sky130_fd_pr__cap_mim_m3_1 l=28.68 w=28.68
X80 PGA__GAIN8__AMP__PRE PGA__GAIN8__AMP__COMP sky130_fd_pr__cap_mim_m3_1 l=28.68 w=28.68
X81 VPWR FILTER__BUFFER1__FIRST__MIR FILTER__BUFFER1__PRE VPWR sky130_fd_pr__pfet_01v8_hvt ad=5.8 pd=40.58 as=5.8 ps=40.58 w=20 l=1
X82 FILTER__BUFFER0__FIRST__TAIL FILTER__FILTER0 FILTER__BUFFER0__PRE VGND sky130_fd_pr__nfet_01v8 ad=1.45 pd=10.58 as=1.45 ps=10.58 w=5 l=1
X83 FILTER__BUFFER1__FIRST__TAIL OUT FILTER__BUFFER1__FIRST__MIR VGND sky130_fd_pr__nfet_01v8 ad=1.45 pd=10.58 as=1.45 ps=10.58 w=5 l=1
X84 PGA__GAIN2__AMP__FIRST__TAIL PGA__GAIN2__FB PGA__GAIN2__AMP__FIRST__MIR VGND sky130_fd_pr__nfet_01v8 ad=1.45 pd=10.58 as=1.45 ps=10.58 w=5 l=1
X85 PGA__GAIN8__AMP__FIRST__TAIL PGA__GAIN8__FB PGA__GAIN8__AMP__FIRST__MIR VGND sky130_fd_pr__nfet_01v8 ad=1.45 pd=10.58 as=1.45 ps=10.58 w=5 l=1
X86 VGND CLK SAMPLE__CLKB VGND sky130_fd_pr__nfet_01v8 ad=0.1885 pd=1.88 as=0.1885 ps=1.88 w=0.65 l=0.15
X87 VPWR SAMPLE__M SAMPLE__MB VPWR sky130_fd_pr__pfet_01v8_hvt ad=0.1885 pd=1.88 as=0.1885 ps=1.88 w=0.65 l=0.15
X88 VPWR FILTER__BUFFER0__FIRST__MIR FILTER__BUFFER0__FIRST__MIR VPWR sky130_fd_pr__pfet_01v8_hvt ad=5.8 pd=40.58 as=5.8 ps=40.58 w=20 l=1
X89 BIAS_SOURCE__VCM_BUFFER__FIRST__TAIL BIAS_SOURCE__VCM_RAW BIAS_SOURCE__VCM_BUFFER__PRE VGND sky130_fd_pr__nfet_01v8 ad=1.45 pd=10.58 as=1.45 ps=10.58 w=5 l=1
X90 BIAS_SOURCE__VCM_BUFFER__PRE BIAS_SOURCE__VCM_BUFFER__COMP sky130_fd_pr__cap_mim_m3_1 l=28.68 w=28.68
X91 VPWR SAMPLE__MB SAMPLE__MF VPWR sky130_fd_pr__pfet_01v8_hvt ad=0.1885 pd=1.88 as=0.1885 ps=1.88 w=0.65 l=0.15
X92 VGND BIAS PGA__GAIN2__AMP__FIRST__TAIL VGND sky130_fd_pr__nfet_01v8 ad=0.58 pd=4.58 as=0.58 ps=4.58 w=2 l=1
X93 BIAS_SOURCE__VCM_RAW VGND sky130_fd_pr__cap_mim_m3_1 l=28.68 w=28.68
X94 VPWR PGA__OUTPUT_BUFFER__PRE AMPLIFIED VPWR sky130_fd_pr__pfet_01v8_hvt ad=11.6 pd=80.58 as=11.6 ps=80.58 w=40 l=1
X95 FILTER__FILTER0 VGND sky130_fd_pr__cap_mim_m3_1 l=28.68 w=28.68
X96 VPWR SAMPLE__T SAMPLE__TB VPWR sky130_fd_pr__pfet_01v8_hvt ad=0.1885 pd=1.88 as=0.1885 ps=1.88 w=0.65 l=0.15
X97 PGA__OUTPUT_BUFFER__FIRST__TAIL AMPLIFIED PGA__OUTPUT_BUFFER__FIRST__MIR VGND sky130_fd_pr__nfet_01v8 ad=1.45 pd=10.58 as=1.45 ps=10.58 w=5 l=1
X98 PGA__SELECTED GAIN PGA__V2 VPWR sky130_fd_pr__pfet_01v8_hvt ad=5.8 pd=40.58 as=5.8 ps=40.58 w=20 l=0.15
X99 VPWR FILTER__BUFFER0__FIRST__MIR FILTER__BUFFER0__PRE VPWR sky130_fd_pr__pfet_01v8_hvt ad=5.8 pd=40.58 as=5.8 ps=40.58 w=20 l=1
X100 FILTER__FILTER1 VGND sky130_fd_pr__cap_mim_m3_1 l=28.68 w=28.68
X101 VPWR BIAS_SOURCE__VCM_BUFFER__PRE VCM VPWR sky130_fd_pr__pfet_01v8_hvt ad=11.6 pd=80.58 as=11.6 ps=80.58 w=40 l=1
X102 BIAS_SOURCE_R_VCM_BOTTOM_R0_N0 BIAS_SOURCE_R_VCM_BOTTOM_R0_N1 VGND sky130_fd_pr__res_xhigh_po_1p41 l=23.34
X103 VGND SAMPLE__M SAMPLE__MB VGND sky130_fd_pr__nfet_01v8 ad=0.1885 pd=1.88 as=0.1885 ps=1.88 w=0.65 l=0.15
X104 SAMPLE__MF CLK SAMPLE__T VGND sky130_fd_pr__nfet_01v8 ad=0.1885 pd=1.88 as=0.1885 ps=1.88 w=0.65 l=0.15
X105 VPWR PGA__OUTPUT_BUFFER__FIRST__MIR PGA__OUTPUT_BUFFER__FIRST__MIR VPWR sky130_fd_pr__pfet_01v8_hvt ad=5.8 pd=40.58 as=5.8 ps=40.58 w=20 l=1
X106 PGA__SELECTED PGA__GAINB PGA__V2 VGND sky130_fd_pr__nfet_01v8 ad=5.8 pd=40.58 as=5.8 ps=40.58 w=20 l=0.15
X107 DATA SAMPLE__CLKB SAMPLE__T VGND sky130_fd_pr__nfet_01v8 ad=0.1885 pd=1.88 as=0.1885 ps=1.88 w=0.65 l=0.15
X108 CMP RESET D VPWR sky130_fd_pr__pfet_01v8_hvt ad=0.1885 pd=1.88 as=0.1885 ps=1.88 w=0.65 l=0.15
X109 VGND BIAS FILTER__MID VGND sky130_fd_pr__nfet_01v8 ad=0.58 pd=4.58 as=0.58 ps=4.58 w=2 l=1
X110 FILTER__BUFFER1__FIRST__TAIL FILTER__FILTER1 FILTER__BUFFER1__PRE VGND sky130_fd_pr__nfet_01v8 ad=1.45 pd=10.58 as=1.45 ps=10.58 w=5 l=1
X111 BIAS_SOURCE__VCM_BUFFER__FIRST__TAIL BIAS_SOURCE__VCM_RAW BIAS_SOURCE__VCM_BUFFER__PRE VGND sky130_fd_pr__nfet_01v8 ad=1.45 pd=10.58 as=1.45 ps=10.58 w=5 l=1
X112 PGA__GAIN8__AMP__PRE PGA__GAIN8__AMP__COMP sky130_fd_pr__cap_mim_m3_1 l=28.68 w=28.68
X113 VGND RESET_MUX__SB D VPWR sky130_fd_pr__pfet_01v8_hvt ad=0.1885 pd=1.88 as=0.1885 ps=1.88 w=0.65 l=0.15
X114 PGA__GAIN8__FB VCM VGND sky130_fd_pr__res_xhigh_po_1p41 l=6.89
X115 PGA__GAIN2__FB VCM VGND sky130_fd_pr__res_xhigh_po_1p41 l=6.89
X116 FILTER__FILTER1 VGND sky130_fd_pr__cap_mim_m3_1 l=28.68 w=28.68
X117 PGA__SELECTED PGA__GAINB PGA__V8 VPWR sky130_fd_pr__pfet_01v8_hvt ad=5.8 pd=40.58 as=5.8 ps=40.58 w=20 l=0.15
X118 BIAS_SOURCE__VCM_BUFFER__FIRST__TAIL VCM BIAS_SOURCE__VCM_BUFFER__FIRST__MIR VGND sky130_fd_pr__nfet_01v8 ad=1.45 pd=10.58 as=1.45 ps=10.58 w=5 l=1
X119 VPWR BIAS_SOURCE_R_VCM_TOP_R0_N0 VGND sky130_fd_pr__res_xhigh_po_1p41 l=23.34
X120 VGND BIAS COMPARATOR__PREAMP__TAIL VGND sky130_fd_pr__nfet_01v8 ad=0.58 pd=4.58 as=0.58 ps=4.58 w=2 l=1
X121 VPWR PGA__GAIN2__AMP__PRE PGA__V2 VPWR sky130_fd_pr__pfet_01v8_hvt ad=11.6 pd=80.58 as=11.6 ps=80.58 w=40 l=1
X122 VPWR PGA__GAIN2__AMP__FIRST__MIR PGA__GAIN2__AMP__PRE VPWR sky130_fd_pr__pfet_01v8_hvt ad=5.8 pd=40.58 as=5.8 ps=40.58 w=20 l=1
X123 PGA__GAIN8__AMP__FIRST__TAIL PGA__GAIN8__FB PGA__GAIN8__AMP__FIRST__MIR VGND sky130_fd_pr__nfet_01v8 ad=1.45 pd=10.58 as=1.45 ps=10.58 w=5 l=1
X124 FILTER__BUFFER1__PRE FILTER__BUFFER1__COMP sky130_fd_pr__cap_mim_m3_1 l=28.68 w=28.68
X125 VGND SAMPLE__MB SAMPLE__MF VGND sky130_fd_pr__nfet_01v8 ad=0.1885 pd=1.88 as=0.1885 ps=1.88 w=0.65 l=0.15
X126 FILTER__FILTER0 VGND sky130_fd_pr__cap_mim_m3_1 l=28.68 w=28.68
X127 VPWR BIAS_SOURCE__VCM_BUFFER__FIRST__MIR BIAS_SOURCE__VCM_BUFFER__FIRST__MIR VPWR sky130_fd_pr__pfet_01v8_hvt ad=5.8 pd=40.58 as=5.8 ps=40.58 w=20 l=1
X128 COMPARATOR__PREAMP__TAIL VCM COMPARATOR__PREAMP__MIR VGND sky130_fd_pr__nfet_01v8 ad=2.9 pd=20.58 as=2.9 ps=20.58 w=10 l=1
X129 PGA__GAIN2__AMP__FIRST__TAIL VIN PGA__GAIN2__AMP__PRE VGND sky130_fd_pr__nfet_01v8 ad=1.45 pd=10.58 as=1.45 ps=10.58 w=5 l=1
X130 PGA__V2 PGA__GAIN2__FB VGND sky130_fd_pr__res_xhigh_po_1p41 l=6.89
X131 VGND SAMPLE__T SAMPLE__TB VGND sky130_fd_pr__nfet_01v8 ad=0.1885 pd=1.88 as=0.1885 ps=1.88 w=0.65 l=0.15
X132 BIAS_SOURCE_R_VCM_TOP_R0_N1 BIAS_SOURCE__VCM_RAW VGND sky130_fd_pr__res_xhigh_po_1p41 l=23.34
X133 AMPLIFIED FILTER__FILTER0 VGND sky130_fd_pr__res_xhigh_po_1p41 l=28.04
X134 VGND BIAS FILTER__BUFFER0__FIRST__TAIL VGND sky130_fd_pr__nfet_01v8 ad=0.58 pd=4.58 as=0.58 ps=4.58 w=2 l=1
X135 PGA__GAIN8__AMP__FIRST__TAIL VIN PGA__GAIN8__AMP__PRE VGND sky130_fd_pr__nfet_01v8 ad=1.45 pd=10.58 as=1.45 ps=10.58 w=5 l=1
X136 BIAS_SOURCE__VCM_RAW VGND sky130_fd_pr__cap_mim_m3_1 l=28.68 w=28.68
X137 PGA__SELECTED GAIN PGA__V8 VGND sky130_fd_pr__nfet_01v8 ad=5.8 pd=40.58 as=5.8 ps=40.58 w=20 l=0.15
X138 PGA__GAIN2__AMP__FIRST__TAIL VIN PGA__GAIN2__AMP__PRE VGND sky130_fd_pr__nfet_01v8 ad=1.45 pd=10.58 as=1.45 ps=10.58 w=5 l=1
X139 FILTER__FILTER1 VGND sky130_fd_pr__cap_mim_m3_1 l=28.68 w=28.68
X140 FILTER__BUFFER0__PRE FILTER__BUFFER0__COMP sky130_fd_pr__cap_mim_m3_1 l=28.68 w=28.68
X141 VGND BIAS PGA__GAIN8__AMP__FIRST__TAIL VGND sky130_fd_pr__nfet_01v8 ad=0.58 pd=4.58 as=0.58 ps=4.58 w=2 l=1
X142 VGND BIAS BIAS_SOURCE__VCM_BUFFER__FIRST__TAIL VGND sky130_fd_pr__nfet_01v8 ad=0.58 pd=4.58 as=0.58 ps=4.58 w=2 l=1
X143 PGA__GAIN2__AMP__FIRST__TAIL PGA__GAIN2__FB PGA__GAIN2__AMP__FIRST__MIR VGND sky130_fd_pr__nfet_01v8 ad=1.45 pd=10.58 as=1.45 ps=10.58 w=5 l=1
X144 CMP RESET_MUX__SB D VGND sky130_fd_pr__nfet_01v8 ad=0.1885 pd=1.88 as=0.1885 ps=1.88 w=0.65 l=0.15
X145 FILTER__FILTER1 VGND sky130_fd_pr__cap_mim_m3_1 l=28.68 w=28.68
X146 PGA__OUTPUT_BUFFER__FIRST__TAIL PGA__SELECTED PGA__OUTPUT_BUFFER__PRE VGND sky130_fd_pr__nfet_01v8 ad=1.45 pd=10.58 as=1.45 ps=10.58 w=5 l=1
X147 VGND RESET D VGND sky130_fd_pr__nfet_01v8 ad=0.1885 pd=1.88 as=0.1885 ps=1.88 w=0.65 l=0.15
X148 BIAS_SOURCE__VCM_RAW VGND sky130_fd_pr__cap_mim_m3_1 l=28.68 w=28.68
X149 FILTER__FILTER0 VGND sky130_fd_pr__cap_mim_m3_1 l=28.68 w=28.68
X150 FILTER__BUFFER1__COMP OUT VGND sky130_fd_pr__res_xhigh_po_1p41 l=3.36
X151 VPWR COMPARATOR__PREAMP__MIR COMPARATOR__PRE VPWR sky130_fd_pr__pfet_01v8_hvt ad=5.8 pd=40.58 as=5.8 ps=40.58 w=20 l=1
X152 DATA CLK SAMPLE__T VPWR sky130_fd_pr__pfet_01v8_hvt ad=0.1885 pd=1.88 as=0.1885 ps=1.88 w=0.65 l=0.15
X153 BIAS_SOURCE__VCM_BUFFER__PRE BIAS_SOURCE__VCM_BUFFER__COMP sky130_fd_pr__cap_mim_m3_1 l=28.68 w=28.68
X154 BIAS_SOURCE__VCM_RAW VGND sky130_fd_pr__cap_mim_m3_1 l=28.68 w=28.68
X155 VGND COMPARATOR__PRE CMP VGND sky130_fd_pr__nfet_01v8 ad=1.16 pd=8.58 as=1.16 ps=8.58 w=4 l=0.15
X156 VGND BIAS PGA__V8 VGND sky130_fd_pr__nfet_01v8 ad=0.58 pd=4.58 as=0.58 ps=4.58 w=2 l=1
X157 FILTER__FILTER0 VGND sky130_fd_pr__cap_mim_m3_1 l=28.68 w=28.68
X158 BIAS_SOURCE__VCM_RAW VGND sky130_fd_pr__cap_mim_m3_1 l=28.68 w=28.68
X159 VGND BIAS BIAS VGND sky130_fd_pr__nfet_01v8 ad=0.58 pd=4.58 as=0.58 ps=4.58 w=2 l=1
X160 FILTER__FILTER0 VGND sky130_fd_pr__cap_mim_m3_1 l=28.68 w=28.68
X161 FILTER__BUFFER1__PRE FILTER__BUFFER1__COMP sky130_fd_pr__cap_mim_m3_1 l=28.68 w=28.68
X162 FILTER__BUFFER1__FIRST__TAIL OUT FILTER__BUFFER1__FIRST__MIR VGND sky130_fd_pr__nfet_01v8 ad=1.45 pd=10.58 as=1.45 ps=10.58 w=5 l=1
X163 PGA__OUTPUT_BUFFER__PRE PGA__OUTPUT_BUFFER__COMP sky130_fd_pr__cap_mim_m3_1 l=28.68 w=28.68
X164 VPWR CLK SAMPLE__CLKB VPWR sky130_fd_pr__pfet_01v8_hvt ad=0.1885 pd=1.88 as=0.1885 ps=1.88 w=0.65 l=0.15
X165 FILTER__FILTER0 VGND sky130_fd_pr__cap_mim_m3_1 l=28.68 w=28.68
.ends

.subckt soc_sensor_afe VIN GAIN CLK RESET OUT DATA VCM BIAS VPWR VGND
XBIAS_SOURCE_C_VCM_P0 BIAS_SOURCE__VCM_RAW VGND sky130_fd_pr__cap_mim_m3_1 w=28.68 l=28.68
XBIAS_SOURCE_C_VCM_P1 BIAS_SOURCE__VCM_RAW VGND sky130_fd_pr__cap_mim_m3_1 w=28.68 l=28.68
XBIAS_SOURCE_C_VCM_P10 BIAS_SOURCE__VCM_RAW VGND sky130_fd_pr__cap_mim_m3_1 w=28.68 l=28.68
XBIAS_SOURCE_C_VCM_P11 BIAS_SOURCE__VCM_RAW VGND sky130_fd_pr__cap_mim_m3_1 w=28.68 l=28.68
XBIAS_SOURCE_C_VCM_P2 BIAS_SOURCE__VCM_RAW VGND sky130_fd_pr__cap_mim_m3_1 w=28.68 l=28.68
XBIAS_SOURCE_C_VCM_P3 BIAS_SOURCE__VCM_RAW VGND sky130_fd_pr__cap_mim_m3_1 w=28.68 l=28.68
XBIAS_SOURCE_C_VCM_P4 BIAS_SOURCE__VCM_RAW VGND sky130_fd_pr__cap_mim_m3_1 w=28.68 l=28.68
XBIAS_SOURCE_C_VCM_P5 BIAS_SOURCE__VCM_RAW VGND sky130_fd_pr__cap_mim_m3_1 w=28.68 l=28.68
XBIAS_SOURCE_C_VCM_P6 BIAS_SOURCE__VCM_RAW VGND sky130_fd_pr__cap_mim_m3_1 w=28.68 l=28.68
XBIAS_SOURCE_C_VCM_P7 BIAS_SOURCE__VCM_RAW VGND sky130_fd_pr__cap_mim_m3_1 w=28.68 l=28.68
XBIAS_SOURCE_C_VCM_P8 BIAS_SOURCE__VCM_RAW VGND sky130_fd_pr__cap_mim_m3_1 w=28.68 l=28.68
XBIAS_SOURCE_C_VCM_P9 BIAS_SOURCE__VCM_RAW VGND sky130_fd_pr__cap_mim_m3_1 w=28.68 l=28.68
XBIAS_SOURCE_N_DIODE BIAS BIAS VGND VGND sky130_fd_pr__nfet_01v8 w=2 l=1 nf=1 m=1
XBIAS_SOURCE_R_BIAS_P0 VPWR BIAS VGND sky130_fd_pr__res_xhigh_po_1p41 l=20.985
XBIAS_SOURCE_R_VCM_BOTTOM_P0 BIAS_SOURCE__VCM_RAW BIAS_SOURCE_R_VCM_BOTTOM_R0_N0 VGND sky130_fd_pr__res_xhigh_po_1p41 l=23.335
XBIAS_SOURCE_R_VCM_BOTTOM_P1 BIAS_SOURCE_R_VCM_BOTTOM_R0_N0 BIAS_SOURCE_R_VCM_BOTTOM_R0_N1 VGND sky130_fd_pr__res_xhigh_po_1p41 l=23.335
XBIAS_SOURCE_R_VCM_BOTTOM_P2 BIAS_SOURCE_R_VCM_BOTTOM_R0_N1 VGND VGND sky130_fd_pr__res_xhigh_po_1p41 l=23.335
XBIAS_SOURCE_R_VCM_TOP_P0 VPWR BIAS_SOURCE_R_VCM_TOP_R0_N0 VGND sky130_fd_pr__res_xhigh_po_1p41 l=23.335
XBIAS_SOURCE_R_VCM_TOP_P1 BIAS_SOURCE_R_VCM_TOP_R0_N0 BIAS_SOURCE_R_VCM_TOP_R0_N1 VGND sky130_fd_pr__res_xhigh_po_1p41 l=23.335
XBIAS_SOURCE_R_VCM_TOP_P2 BIAS_SOURCE_R_VCM_TOP_R0_N1 BIAS_SOURCE__VCM_RAW VGND sky130_fd_pr__res_xhigh_po_1p41 l=23.335
XBIAS_SOURCE_VCM_BUFFER_C_MILLER_P0 BIAS_SOURCE__VCM_BUFFER__PRE BIAS_SOURCE__VCM_BUFFER__COMP sky130_fd_pr__cap_mim_m3_1 w=28.68 l=28.68
XBIAS_SOURCE_VCM_BUFFER_C_MILLER_P1 BIAS_SOURCE__VCM_BUFFER__PRE BIAS_SOURCE__VCM_BUFFER__COMP sky130_fd_pr__cap_mim_m3_1 w=28.68 l=28.68
XBIAS_SOURCE_VCM_BUFFER_C_MILLER_P2 BIAS_SOURCE__VCM_BUFFER__PRE BIAS_SOURCE__VCM_BUFFER__COMP sky130_fd_pr__cap_mim_m3_1 w=28.68 l=28.68
XBIAS_SOURCE_VCM_BUFFER_FIRST_N_INN0 BIAS_SOURCE__VCM_BUFFER__FIRST__MIR VCM BIAS_SOURCE__VCM_BUFFER__FIRST__TAIL VGND sky130_fd_pr__nfet_01v8 w=5 l=1 nf=1 m=1
XBIAS_SOURCE_VCM_BUFFER_FIRST_N_INN1 BIAS_SOURCE__VCM_BUFFER__FIRST__MIR VCM BIAS_SOURCE__VCM_BUFFER__FIRST__TAIL VGND sky130_fd_pr__nfet_01v8 w=5 l=1 nf=1 m=1
XBIAS_SOURCE_VCM_BUFFER_FIRST_N_INP0 BIAS_SOURCE__VCM_BUFFER__PRE BIAS_SOURCE__VCM_RAW BIAS_SOURCE__VCM_BUFFER__FIRST__TAIL VGND sky130_fd_pr__nfet_01v8 w=5 l=1 nf=1 m=1
XBIAS_SOURCE_VCM_BUFFER_FIRST_N_INP1 BIAS_SOURCE__VCM_BUFFER__PRE BIAS_SOURCE__VCM_RAW BIAS_SOURCE__VCM_BUFFER__FIRST__TAIL VGND sky130_fd_pr__nfet_01v8 w=5 l=1 nf=1 m=1
XBIAS_SOURCE_VCM_BUFFER_FIRST_N_TAIL BIAS_SOURCE__VCM_BUFFER__FIRST__TAIL BIAS VGND VGND sky130_fd_pr__nfet_01v8 w=2 l=1 nf=1 m=1
XBIAS_SOURCE_VCM_BUFFER_FIRST_P_DIODE BIAS_SOURCE__VCM_BUFFER__FIRST__MIR BIAS_SOURCE__VCM_BUFFER__FIRST__MIR VPWR VPWR sky130_fd_pr__pfet_01v8_hvt w=20 l=1 nf=1 m=1
XBIAS_SOURCE_VCM_BUFFER_FIRST_P_MIRROR BIAS_SOURCE__VCM_BUFFER__PRE BIAS_SOURCE__VCM_BUFFER__FIRST__MIR VPWR VPWR sky130_fd_pr__pfet_01v8_hvt w=20 l=1 nf=1 m=1
XBIAS_SOURCE_VCM_BUFFER_N_SECOND VCM BIAS VGND VGND sky130_fd_pr__nfet_01v8 w=2 l=1 nf=1 m=1
XBIAS_SOURCE_VCM_BUFFER_P_SECOND VCM BIAS_SOURCE__VCM_BUFFER__PRE VPWR VPWR sky130_fd_pr__pfet_01v8_hvt w=40 l=1 nf=1 m=1
XBIAS_SOURCE_VCM_BUFFER_R_ZERO_P0 BIAS_SOURCE__VCM_BUFFER__COMP VCM VGND sky130_fd_pr__res_xhigh_po_1p41 l=3.36
XCOMPARATOR_N_OUT CMP COMPARATOR__PRE VGND VGND sky130_fd_pr__nfet_01v8 w=4 l=0.15 nf=1 m=1
XCOMPARATOR_PREAMP_N_INN COMPARATOR__PREAMP__MIR VCM COMPARATOR__PREAMP__TAIL VGND sky130_fd_pr__nfet_01v8 w=10 l=1 nf=1 m=1
XCOMPARATOR_PREAMP_N_INP COMPARATOR__PRE OUT COMPARATOR__PREAMP__TAIL VGND sky130_fd_pr__nfet_01v8 w=10 l=1 nf=1 m=1
XCOMPARATOR_PREAMP_N_TAIL COMPARATOR__PREAMP__TAIL BIAS VGND VGND sky130_fd_pr__nfet_01v8 w=2 l=1 nf=1 m=1
XCOMPARATOR_PREAMP_P_DIODE COMPARATOR__PREAMP__MIR COMPARATOR__PREAMP__MIR VPWR VPWR sky130_fd_pr__pfet_01v8_hvt w=20 l=1 nf=1 m=1
XCOMPARATOR_PREAMP_P_MIRROR COMPARATOR__PRE COMPARATOR__PREAMP__MIR VPWR VPWR sky130_fd_pr__pfet_01v8_hvt w=20 l=1 nf=1 m=1
XCOMPARATOR_P_OUT CMP COMPARATOR__PRE VPWR VPWR sky130_fd_pr__pfet_01v8_hvt w=8 l=0.15 nf=1 m=1
XFILTER_BUFFER0_C_MILLER_P0 FILTER__BUFFER0__PRE FILTER__BUFFER0__COMP sky130_fd_pr__cap_mim_m3_1 w=28.68 l=28.68
XFILTER_BUFFER0_C_MILLER_P1 FILTER__BUFFER0__PRE FILTER__BUFFER0__COMP sky130_fd_pr__cap_mim_m3_1 w=28.68 l=28.68
XFILTER_BUFFER0_C_MILLER_P2 FILTER__BUFFER0__PRE FILTER__BUFFER0__COMP sky130_fd_pr__cap_mim_m3_1 w=28.68 l=28.68
XFILTER_BUFFER0_FIRST_N_INN0 FILTER__BUFFER0__FIRST__MIR FILTER__MID FILTER__BUFFER0__FIRST__TAIL VGND sky130_fd_pr__nfet_01v8 w=5 l=1 nf=1 m=1
XFILTER_BUFFER0_FIRST_N_INN1 FILTER__BUFFER0__FIRST__MIR FILTER__MID FILTER__BUFFER0__FIRST__TAIL VGND sky130_fd_pr__nfet_01v8 w=5 l=1 nf=1 m=1
XFILTER_BUFFER0_FIRST_N_INP0 FILTER__BUFFER0__PRE FILTER__FILTER0 FILTER__BUFFER0__FIRST__TAIL VGND sky130_fd_pr__nfet_01v8 w=5 l=1 nf=1 m=1
XFILTER_BUFFER0_FIRST_N_INP1 FILTER__BUFFER0__PRE FILTER__FILTER0 FILTER__BUFFER0__FIRST__TAIL VGND sky130_fd_pr__nfet_01v8 w=5 l=1 nf=1 m=1
XFILTER_BUFFER0_FIRST_N_TAIL FILTER__BUFFER0__FIRST__TAIL BIAS VGND VGND sky130_fd_pr__nfet_01v8 w=2 l=1 nf=1 m=1
XFILTER_BUFFER0_FIRST_P_DIODE FILTER__BUFFER0__FIRST__MIR FILTER__BUFFER0__FIRST__MIR VPWR VPWR sky130_fd_pr__pfet_01v8_hvt w=20 l=1 nf=1 m=1
XFILTER_BUFFER0_FIRST_P_MIRROR FILTER__BUFFER0__PRE FILTER__BUFFER0__FIRST__MIR VPWR VPWR sky130_fd_pr__pfet_01v8_hvt w=20 l=1 nf=1 m=1
XFILTER_BUFFER0_N_SECOND FILTER__MID BIAS VGND VGND sky130_fd_pr__nfet_01v8 w=2 l=1 nf=1 m=1
XFILTER_BUFFER0_P_SECOND FILTER__MID FILTER__BUFFER0__PRE VPWR VPWR sky130_fd_pr__pfet_01v8_hvt w=40 l=1 nf=1 m=1
XFILTER_BUFFER0_R_ZERO_P0 FILTER__BUFFER0__COMP FILTER__MID VGND sky130_fd_pr__res_xhigh_po_1p41 l=3.36
XFILTER_BUFFER1_C_MILLER_P0 FILTER__BUFFER1__PRE FILTER__BUFFER1__COMP sky130_fd_pr__cap_mim_m3_1 w=28.68 l=28.68
XFILTER_BUFFER1_C_MILLER_P1 FILTER__BUFFER1__PRE FILTER__BUFFER1__COMP sky130_fd_pr__cap_mim_m3_1 w=28.68 l=28.68
XFILTER_BUFFER1_C_MILLER_P2 FILTER__BUFFER1__PRE FILTER__BUFFER1__COMP sky130_fd_pr__cap_mim_m3_1 w=28.68 l=28.68
XFILTER_BUFFER1_FIRST_N_INN0 FILTER__BUFFER1__FIRST__MIR OUT FILTER__BUFFER1__FIRST__TAIL VGND sky130_fd_pr__nfet_01v8 w=5 l=1 nf=1 m=1
XFILTER_BUFFER1_FIRST_N_INN1 FILTER__BUFFER1__FIRST__MIR OUT FILTER__BUFFER1__FIRST__TAIL VGND sky130_fd_pr__nfet_01v8 w=5 l=1 nf=1 m=1
XFILTER_BUFFER1_FIRST_N_INP0 FILTER__BUFFER1__PRE FILTER__FILTER1 FILTER__BUFFER1__FIRST__TAIL VGND sky130_fd_pr__nfet_01v8 w=5 l=1 nf=1 m=1
XFILTER_BUFFER1_FIRST_N_INP1 FILTER__BUFFER1__PRE FILTER__FILTER1 FILTER__BUFFER1__FIRST__TAIL VGND sky130_fd_pr__nfet_01v8 w=5 l=1 nf=1 m=1
XFILTER_BUFFER1_FIRST_N_TAIL FILTER__BUFFER1__FIRST__TAIL BIAS VGND VGND sky130_fd_pr__nfet_01v8 w=2 l=1 nf=1 m=1
XFILTER_BUFFER1_FIRST_P_DIODE FILTER__BUFFER1__FIRST__MIR FILTER__BUFFER1__FIRST__MIR VPWR VPWR sky130_fd_pr__pfet_01v8_hvt w=20 l=1 nf=1 m=1
XFILTER_BUFFER1_FIRST_P_MIRROR FILTER__BUFFER1__PRE FILTER__BUFFER1__FIRST__MIR VPWR VPWR sky130_fd_pr__pfet_01v8_hvt w=20 l=1 nf=1 m=1
XFILTER_BUFFER1_N_SECOND OUT BIAS VGND VGND sky130_fd_pr__nfet_01v8 w=2 l=1 nf=1 m=1
XFILTER_BUFFER1_P_SECOND OUT FILTER__BUFFER1__PRE VPWR VPWR sky130_fd_pr__pfet_01v8_hvt w=40 l=1 nf=1 m=1
XFILTER_BUFFER1_R_ZERO_P0 FILTER__BUFFER1__COMP OUT VGND sky130_fd_pr__res_xhigh_po_1p41 l=3.36
XFILTER_C_POLE0_P0 FILTER__FILTER0 VGND sky130_fd_pr__cap_mim_m3_1 w=28.68 l=28.68
XFILTER_C_POLE0_P1 FILTER__FILTER0 VGND sky130_fd_pr__cap_mim_m3_1 w=28.68 l=28.68
XFILTER_C_POLE0_P10 FILTER__FILTER0 VGND sky130_fd_pr__cap_mim_m3_1 w=28.68 l=28.68
XFILTER_C_POLE0_P11 FILTER__FILTER0 VGND sky130_fd_pr__cap_mim_m3_1 w=28.68 l=28.68
XFILTER_C_POLE0_P2 FILTER__FILTER0 VGND sky130_fd_pr__cap_mim_m3_1 w=28.68 l=28.68
XFILTER_C_POLE0_P3 FILTER__FILTER0 VGND sky130_fd_pr__cap_mim_m3_1 w=28.68 l=28.68
XFILTER_C_POLE0_P4 FILTER__FILTER0 VGND sky130_fd_pr__cap_mim_m3_1 w=28.68 l=28.68
XFILTER_C_POLE0_P5 FILTER__FILTER0 VGND sky130_fd_pr__cap_mim_m3_1 w=28.68 l=28.68
XFILTER_C_POLE0_P6 FILTER__FILTER0 VGND sky130_fd_pr__cap_mim_m3_1 w=28.68 l=28.68
XFILTER_C_POLE0_P7 FILTER__FILTER0 VGND sky130_fd_pr__cap_mim_m3_1 w=28.68 l=28.68
XFILTER_C_POLE0_P8 FILTER__FILTER0 VGND sky130_fd_pr__cap_mim_m3_1 w=28.68 l=28.68
XFILTER_C_POLE0_P9 FILTER__FILTER0 VGND sky130_fd_pr__cap_mim_m3_1 w=28.68 l=28.68
XFILTER_C_POLE1_P0 FILTER__FILTER1 VGND sky130_fd_pr__cap_mim_m3_1 w=28.68 l=28.68
XFILTER_C_POLE1_P1 FILTER__FILTER1 VGND sky130_fd_pr__cap_mim_m3_1 w=28.68 l=28.68
XFILTER_C_POLE1_P10 FILTER__FILTER1 VGND sky130_fd_pr__cap_mim_m3_1 w=28.68 l=28.68
XFILTER_C_POLE1_P11 FILTER__FILTER1 VGND sky130_fd_pr__cap_mim_m3_1 w=28.68 l=28.68
XFILTER_C_POLE1_P2 FILTER__FILTER1 VGND sky130_fd_pr__cap_mim_m3_1 w=28.68 l=28.68
XFILTER_C_POLE1_P3 FILTER__FILTER1 VGND sky130_fd_pr__cap_mim_m3_1 w=28.68 l=28.68
XFILTER_C_POLE1_P4 FILTER__FILTER1 VGND sky130_fd_pr__cap_mim_m3_1 w=28.68 l=28.68
XFILTER_C_POLE1_P5 FILTER__FILTER1 VGND sky130_fd_pr__cap_mim_m3_1 w=28.68 l=28.68
XFILTER_C_POLE1_P6 FILTER__FILTER1 VGND sky130_fd_pr__cap_mim_m3_1 w=28.68 l=28.68
XFILTER_C_POLE1_P7 FILTER__FILTER1 VGND sky130_fd_pr__cap_mim_m3_1 w=28.68 l=28.68
XFILTER_C_POLE1_P8 FILTER__FILTER1 VGND sky130_fd_pr__cap_mim_m3_1 w=28.68 l=28.68
XFILTER_C_POLE1_P9 FILTER__FILTER1 VGND sky130_fd_pr__cap_mim_m3_1 w=28.68 l=28.68
XFILTER_R_POLE0_P0 AMPLIFIED FILTER__FILTER0 VGND sky130_fd_pr__res_xhigh_po_1p41 l=28.035
XFILTER_R_POLE1_P0 FILTER__MID FILTER__FILTER1 VGND sky130_fd_pr__res_xhigh_po_1p41 l=28.035
XPGA_GAIN2_AMP_C_MILLER_P0 PGA__GAIN2__AMP__PRE PGA__GAIN2__AMP__COMP sky130_fd_pr__cap_mim_m3_1 w=28.68 l=28.68
XPGA_GAIN2_AMP_C_MILLER_P1 PGA__GAIN2__AMP__PRE PGA__GAIN2__AMP__COMP sky130_fd_pr__cap_mim_m3_1 w=28.68 l=28.68
XPGA_GAIN2_AMP_C_MILLER_P2 PGA__GAIN2__AMP__PRE PGA__GAIN2__AMP__COMP sky130_fd_pr__cap_mim_m3_1 w=28.68 l=28.68
XPGA_GAIN2_AMP_FIRST_N_INN0 PGA__GAIN2__AMP__FIRST__MIR PGA__GAIN2__FB PGA__GAIN2__AMP__FIRST__TAIL VGND sky130_fd_pr__nfet_01v8 w=5 l=1 nf=1 m=1
XPGA_GAIN2_AMP_FIRST_N_INN1 PGA__GAIN2__AMP__FIRST__MIR PGA__GAIN2__FB PGA__GAIN2__AMP__FIRST__TAIL VGND sky130_fd_pr__nfet_01v8 w=5 l=1 nf=1 m=1
XPGA_GAIN2_AMP_FIRST_N_INP0 PGA__GAIN2__AMP__PRE VIN PGA__GAIN2__AMP__FIRST__TAIL VGND sky130_fd_pr__nfet_01v8 w=5 l=1 nf=1 m=1
XPGA_GAIN2_AMP_FIRST_N_INP1 PGA__GAIN2__AMP__PRE VIN PGA__GAIN2__AMP__FIRST__TAIL VGND sky130_fd_pr__nfet_01v8 w=5 l=1 nf=1 m=1
XPGA_GAIN2_AMP_FIRST_N_TAIL PGA__GAIN2__AMP__FIRST__TAIL BIAS VGND VGND sky130_fd_pr__nfet_01v8 w=2 l=1 nf=1 m=1
XPGA_GAIN2_AMP_FIRST_P_DIODE PGA__GAIN2__AMP__FIRST__MIR PGA__GAIN2__AMP__FIRST__MIR VPWR VPWR sky130_fd_pr__pfet_01v8_hvt w=20 l=1 nf=1 m=1
XPGA_GAIN2_AMP_FIRST_P_MIRROR PGA__GAIN2__AMP__PRE PGA__GAIN2__AMP__FIRST__MIR VPWR VPWR sky130_fd_pr__pfet_01v8_hvt w=20 l=1 nf=1 m=1
XPGA_GAIN2_AMP_N_SECOND PGA__V2 BIAS VGND VGND sky130_fd_pr__nfet_01v8 w=2 l=1 nf=1 m=1
XPGA_GAIN2_AMP_P_SECOND PGA__V2 PGA__GAIN2__AMP__PRE VPWR VPWR sky130_fd_pr__pfet_01v8_hvt w=40 l=1 nf=1 m=1
XPGA_GAIN2_AMP_R_ZERO_P0 PGA__GAIN2__AMP__COMP PGA__V2 VGND sky130_fd_pr__res_xhigh_po_1p41 l=3.36
XPGA_GAIN2_R_FEEDBACK_P0 PGA__V2 PGA__GAIN2__FB VGND sky130_fd_pr__res_xhigh_po_1p41 l=6.885
XPGA_GAIN2_R_GROUND_P0 PGA__GAIN2__FB VCM VGND sky130_fd_pr__res_xhigh_po_1p41 l=6.885
XPGA_GAIN8_AMP_C_MILLER_P0 PGA__GAIN8__AMP__PRE PGA__GAIN8__AMP__COMP sky130_fd_pr__cap_mim_m3_1 w=28.68 l=28.68
XPGA_GAIN8_AMP_C_MILLER_P1 PGA__GAIN8__AMP__PRE PGA__GAIN8__AMP__COMP sky130_fd_pr__cap_mim_m3_1 w=28.68 l=28.68
XPGA_GAIN8_AMP_C_MILLER_P2 PGA__GAIN8__AMP__PRE PGA__GAIN8__AMP__COMP sky130_fd_pr__cap_mim_m3_1 w=28.68 l=28.68
XPGA_GAIN8_AMP_FIRST_N_INN0 PGA__GAIN8__AMP__FIRST__MIR PGA__GAIN8__FB PGA__GAIN8__AMP__FIRST__TAIL VGND sky130_fd_pr__nfet_01v8 w=5 l=1 nf=1 m=1
XPGA_GAIN8_AMP_FIRST_N_INN1 PGA__GAIN8__AMP__FIRST__MIR PGA__GAIN8__FB PGA__GAIN8__AMP__FIRST__TAIL VGND sky130_fd_pr__nfet_01v8 w=5 l=1 nf=1 m=1
XPGA_GAIN8_AMP_FIRST_N_INP0 PGA__GAIN8__AMP__PRE VIN PGA__GAIN8__AMP__FIRST__TAIL VGND sky130_fd_pr__nfet_01v8 w=5 l=1 nf=1 m=1
XPGA_GAIN8_AMP_FIRST_N_INP1 PGA__GAIN8__AMP__PRE VIN PGA__GAIN8__AMP__FIRST__TAIL VGND sky130_fd_pr__nfet_01v8 w=5 l=1 nf=1 m=1
XPGA_GAIN8_AMP_FIRST_N_TAIL PGA__GAIN8__AMP__FIRST__TAIL BIAS VGND VGND sky130_fd_pr__nfet_01v8 w=2 l=1 nf=1 m=1
XPGA_GAIN8_AMP_FIRST_P_DIODE PGA__GAIN8__AMP__FIRST__MIR PGA__GAIN8__AMP__FIRST__MIR VPWR VPWR sky130_fd_pr__pfet_01v8_hvt w=20 l=1 nf=1 m=1
XPGA_GAIN8_AMP_FIRST_P_MIRROR PGA__GAIN8__AMP__PRE PGA__GAIN8__AMP__FIRST__MIR VPWR VPWR sky130_fd_pr__pfet_01v8_hvt w=20 l=1 nf=1 m=1
XPGA_GAIN8_AMP_N_SECOND PGA__V8 BIAS VGND VGND sky130_fd_pr__nfet_01v8 w=2 l=1 nf=1 m=1
XPGA_GAIN8_AMP_P_SECOND PGA__V8 PGA__GAIN8__AMP__PRE VPWR VPWR sky130_fd_pr__pfet_01v8_hvt w=40 l=1 nf=1 m=1
XPGA_GAIN8_AMP_R_ZERO_P0 PGA__GAIN8__AMP__COMP PGA__V8 VGND sky130_fd_pr__res_xhigh_po_1p41 l=3.36
XPGA_GAIN8_R_FEEDBACK_P0 PGA__V8 PGA_GAIN8_R_FEEDBACK_R0_N0 VGND sky130_fd_pr__res_xhigh_po_1p41 l=24.51
XPGA_GAIN8_R_FEEDBACK_P1 PGA_GAIN8_R_FEEDBACK_R0_N0 PGA__GAIN8__FB VGND sky130_fd_pr__res_xhigh_po_1p41 l=24.51
XPGA_GAIN8_R_GROUND_P0 PGA__GAIN8__FB VCM VGND sky130_fd_pr__res_xhigh_po_1p41 l=6.885
XPGA_GAIN_INVERTER_MN PGA__GAINB GAIN VGND VGND sky130_fd_pr__nfet_01v8 w=0.65 l=0.15 nf=1 m=1
XPGA_GAIN_INVERTER_MP PGA__GAINB GAIN VPWR VPWR sky130_fd_pr__pfet_01v8_hvt w=0.65 l=0.15 nf=1 m=1
XPGA_N_HIGH PGA__V8 GAIN PGA__SELECTED VGND sky130_fd_pr__nfet_01v8 w=20 l=0.15 nf=1 m=1
XPGA_N_LOW PGA__V2 PGA__GAINB PGA__SELECTED VGND sky130_fd_pr__nfet_01v8 w=20 l=0.15 nf=1 m=1
XPGA_OUTPUT_BUFFER_C_MILLER_P0 PGA__OUTPUT_BUFFER__PRE PGA__OUTPUT_BUFFER__COMP sky130_fd_pr__cap_mim_m3_1 w=28.68 l=28.68
XPGA_OUTPUT_BUFFER_C_MILLER_P1 PGA__OUTPUT_BUFFER__PRE PGA__OUTPUT_BUFFER__COMP sky130_fd_pr__cap_mim_m3_1 w=28.68 l=28.68
XPGA_OUTPUT_BUFFER_C_MILLER_P2 PGA__OUTPUT_BUFFER__PRE PGA__OUTPUT_BUFFER__COMP sky130_fd_pr__cap_mim_m3_1 w=28.68 l=28.68
XPGA_OUTPUT_BUFFER_FIRST_N_INN0 PGA__OUTPUT_BUFFER__FIRST__MIR AMPLIFIED PGA__OUTPUT_BUFFER__FIRST__TAIL VGND sky130_fd_pr__nfet_01v8 w=5 l=1 nf=1 m=1
XPGA_OUTPUT_BUFFER_FIRST_N_INN1 PGA__OUTPUT_BUFFER__FIRST__MIR AMPLIFIED PGA__OUTPUT_BUFFER__FIRST__TAIL VGND sky130_fd_pr__nfet_01v8 w=5 l=1 nf=1 m=1
XPGA_OUTPUT_BUFFER_FIRST_N_INP0 PGA__OUTPUT_BUFFER__PRE PGA__SELECTED PGA__OUTPUT_BUFFER__FIRST__TAIL VGND sky130_fd_pr__nfet_01v8 w=5 l=1 nf=1 m=1
XPGA_OUTPUT_BUFFER_FIRST_N_INP1 PGA__OUTPUT_BUFFER__PRE PGA__SELECTED PGA__OUTPUT_BUFFER__FIRST__TAIL VGND sky130_fd_pr__nfet_01v8 w=5 l=1 nf=1 m=1
XPGA_OUTPUT_BUFFER_FIRST_N_TAIL PGA__OUTPUT_BUFFER__FIRST__TAIL BIAS VGND VGND sky130_fd_pr__nfet_01v8 w=2 l=1 nf=1 m=1
XPGA_OUTPUT_BUFFER_FIRST_P_DIODE PGA__OUTPUT_BUFFER__FIRST__MIR PGA__OUTPUT_BUFFER__FIRST__MIR VPWR VPWR sky130_fd_pr__pfet_01v8_hvt w=20 l=1 nf=1 m=1
XPGA_OUTPUT_BUFFER_FIRST_P_MIRROR PGA__OUTPUT_BUFFER__PRE PGA__OUTPUT_BUFFER__FIRST__MIR VPWR VPWR sky130_fd_pr__pfet_01v8_hvt w=20 l=1 nf=1 m=1
XPGA_OUTPUT_BUFFER_N_SECOND AMPLIFIED BIAS VGND VGND sky130_fd_pr__nfet_01v8 w=2 l=1 nf=1 m=1
XPGA_OUTPUT_BUFFER_P_SECOND AMPLIFIED PGA__OUTPUT_BUFFER__PRE VPWR VPWR sky130_fd_pr__pfet_01v8_hvt w=40 l=1 nf=1 m=1
XPGA_OUTPUT_BUFFER_R_ZERO_P0 PGA__OUTPUT_BUFFER__COMP AMPLIFIED VGND sky130_fd_pr__res_xhigh_po_1p41 l=3.36
XPGA_P_HIGH PGA__V8 PGA__GAINB PGA__SELECTED VPWR sky130_fd_pr__pfet_01v8_hvt w=20 l=0.15 nf=1 m=1
XPGA_P_LOW PGA__V2 GAIN PGA__SELECTED VPWR sky130_fd_pr__pfet_01v8_hvt w=20 l=0.15 nf=1 m=1
XRESET_MUX_IS_MN RESET_MUX__SB RESET VGND VGND sky130_fd_pr__nfet_01v8 w=0.65 l=0.15 nf=1 m=1
XRESET_MUX_IS_MP RESET_MUX__SB RESET VPWR VPWR sky130_fd_pr__pfet_01v8_hvt w=0.65 l=0.15 nf=1 m=1
XRESET_MUX_MNA D RESET_MUX__SB CMP VGND sky130_fd_pr__nfet_01v8 w=0.65 l=0.15 nf=1 m=1
XRESET_MUX_MNB D RESET VGND VGND sky130_fd_pr__nfet_01v8 w=0.65 l=0.15 nf=1 m=1
XRESET_MUX_MPA D RESET CMP VPWR sky130_fd_pr__pfet_01v8_hvt w=0.65 l=0.15 nf=1 m=1
XRESET_MUX_MPB D RESET_MUX__SB VGND VPWR sky130_fd_pr__pfet_01v8_hvt w=0.65 l=0.15 nf=1 m=1
XSAMPLE_ICLK_MN SAMPLE__CLKB CLK VGND VGND sky130_fd_pr__nfet_01v8 w=0.65 l=0.15 nf=1 m=1
XSAMPLE_ICLK_MP SAMPLE__CLKB CLK VPWR VPWR sky130_fd_pr__pfet_01v8_hvt w=0.65 l=0.15 nf=1 m=1
XSAMPLE_M1_MN SAMPLE__MB SAMPLE__M VGND VGND sky130_fd_pr__nfet_01v8 w=0.65 l=0.15 nf=1 m=1
XSAMPLE_M1_MP SAMPLE__MB SAMPLE__M VPWR VPWR sky130_fd_pr__pfet_01v8_hvt w=0.65 l=0.15 nf=1 m=1
XSAMPLE_M2_MN SAMPLE__MF SAMPLE__MB VGND VGND sky130_fd_pr__nfet_01v8 w=0.65 l=0.15 nf=1 m=1
XSAMPLE_M2_MP SAMPLE__MF SAMPLE__MB VPWR VPWR sky130_fd_pr__pfet_01v8_hvt w=0.65 l=0.15 nf=1 m=1
XSAMPLE_MNIN SAMPLE__M SAMPLE__CLKB D VGND sky130_fd_pr__nfet_01v8 w=0.65 l=0.15 nf=1 m=1
XSAMPLE_MNMF SAMPLE__M CLK SAMPLE__MF VGND sky130_fd_pr__nfet_01v8 w=0.65 l=0.15 nf=1 m=1
XSAMPLE_MNOUT SAMPLE__T CLK SAMPLE__MF VGND sky130_fd_pr__nfet_01v8 w=0.65 l=0.15 nf=1 m=1
XSAMPLE_MNSF SAMPLE__T SAMPLE__CLKB DATA VGND sky130_fd_pr__nfet_01v8 w=0.65 l=0.15 nf=1 m=1
XSAMPLE_MPIN SAMPLE__M CLK D VPWR sky130_fd_pr__pfet_01v8_hvt w=0.65 l=0.15 nf=1 m=1
XSAMPLE_MPMF SAMPLE__M SAMPLE__CLKB SAMPLE__MF VPWR sky130_fd_pr__pfet_01v8_hvt w=0.65 l=0.15 nf=1 m=1
XSAMPLE_MPOUT SAMPLE__T SAMPLE__CLKB SAMPLE__MF VPWR sky130_fd_pr__pfet_01v8_hvt w=0.65 l=0.15 nf=1 m=1
XSAMPLE_MPSF SAMPLE__T CLK DATA VPWR sky130_fd_pr__pfet_01v8_hvt w=0.65 l=0.15 nf=1 m=1
XSAMPLE_S1_MN SAMPLE__TB SAMPLE__T VGND VGND sky130_fd_pr__nfet_01v8 w=0.65 l=0.15 nf=1 m=1
XSAMPLE_S1_MP SAMPLE__TB SAMPLE__T VPWR VPWR sky130_fd_pr__pfet_01v8_hvt w=0.65 l=0.15 nf=1 m=1
XSAMPLE_S2_MN DATA SAMPLE__TB VGND VGND sky130_fd_pr__nfet_01v8 w=0.65 l=0.15 nf=1 m=1
XSAMPLE_S2_MP DATA SAMPLE__TB VPWR VPWR sky130_fd_pr__pfet_01v8_hvt w=0.65 l=0.15 nf=1 m=1
.ends soc_sensor_afe

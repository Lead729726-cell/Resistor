* NGSPICE file created from soc_pga.ext - technology: sky130A

.subckt soc_pga VPWR VCM OUT GAIN VIN VGND BIAS
X0 GAIN8__AMP__FIRST__TAIL GAIN8__FB GAIN8__AMP__FIRST__MIR VGND sky130_fd_pr__nfet_01v8 ad=1.45 pd=10.58 as=1.45 ps=10.58 w=5 l=1
X1 VPWR OUTPUT_BUFFER__FIRST__MIR OUTPUT_BUFFER__PRE VPWR sky130_fd_pr__pfet_01v8_hvt ad=5.8 pd=40.58 as=5.8 ps=40.58 w=20 l=1
X2 GAIN2__AMP__FIRST__TAIL VIN GAIN2__AMP__PRE VGND sky130_fd_pr__nfet_01v8 ad=1.45 pd=10.58 as=1.45 ps=10.58 w=5 l=1
X3 VPWR GAIN2__AMP__PRE V2 VPWR sky130_fd_pr__pfet_01v8_hvt ad=11.6 pd=80.58 as=11.6 ps=80.58 w=40 l=1
X4 GAIN8__AMP__FIRST__TAIL VIN GAIN8__AMP__PRE VGND sky130_fd_pr__nfet_01v8 ad=1.45 pd=10.58 as=1.45 ps=10.58 w=5 l=1
X5 OUTPUT_BUFFER__PRE OUTPUT_BUFFER__COMP sky130_fd_pr__cap_mim_m3_1 l=28.68 w=28.68
X6 GAIN8__AMP__COMP V8 VGND sky130_fd_pr__res_xhigh_po_1p41 l=3.36
X7 GAIN8__FB VCM VGND sky130_fd_pr__res_xhigh_po_1p41 l=6.89
X8 SELECTED GAIN V2 VPWR sky130_fd_pr__pfet_01v8_hvt ad=5.8 pd=40.58 as=5.8 ps=40.58 w=20 l=0.15
X9 GAIN2__AMP__FIRST__TAIL GAIN2__FB GAIN2__AMP__FIRST__MIR VGND sky130_fd_pr__nfet_01v8 ad=1.45 pd=10.58 as=1.45 ps=10.58 w=5 l=1
X10 V8 GAIN8_R_FEEDBACK_R0_N0 VGND sky130_fd_pr__res_xhigh_po_1p41 l=24.51
X11 VPWR OUTPUT_BUFFER__PRE OUT VPWR sky130_fd_pr__pfet_01v8_hvt ad=11.6 pd=80.58 as=11.6 ps=80.58 w=40 l=1
X12 VPWR GAIN8__AMP__FIRST__MIR GAIN8__AMP__PRE VPWR sky130_fd_pr__pfet_01v8_hvt ad=5.8 pd=40.58 as=5.8 ps=40.58 w=20 l=1
X13 SELECTED GAINB V8 VPWR sky130_fd_pr__pfet_01v8_hvt ad=5.8 pd=40.58 as=5.8 ps=40.58 w=20 l=0.15
X14 OUTPUT_BUFFER__FIRST__TAIL SELECTED OUTPUT_BUFFER__PRE VGND sky130_fd_pr__nfet_01v8 ad=1.45 pd=10.58 as=1.45 ps=10.58 w=5 l=1
X15 OUTPUT_BUFFER__FIRST__TAIL SELECTED OUTPUT_BUFFER__PRE VGND sky130_fd_pr__nfet_01v8 ad=1.45 pd=10.58 as=1.45 ps=10.58 w=5 l=1
X16 OUTPUT_BUFFER__FIRST__TAIL OUT OUTPUT_BUFFER__FIRST__MIR VGND sky130_fd_pr__nfet_01v8 ad=1.45 pd=10.58 as=1.45 ps=10.58 w=5 l=1
X17 GAIN2__AMP__PRE GAIN2__AMP__COMP sky130_fd_pr__cap_mim_m3_1 l=28.68 w=28.68
X18 VPWR GAIN8__AMP__PRE V8 VPWR sky130_fd_pr__pfet_01v8_hvt ad=11.6 pd=80.58 as=11.6 ps=80.58 w=40 l=1
X19 V2 GAIN2__FB VGND sky130_fd_pr__res_xhigh_po_1p41 l=6.89
X20 VPWR GAIN GAINB VPWR sky130_fd_pr__pfet_01v8_hvt ad=0.1885 pd=1.88 as=0.1885 ps=1.88 w=0.65 l=0.15
X21 VPWR GAIN2__AMP__FIRST__MIR GAIN2__AMP__FIRST__MIR VPWR sky130_fd_pr__pfet_01v8_hvt ad=5.8 pd=40.58 as=5.8 ps=40.58 w=20 l=1
X22 GAIN8__AMP__FIRST__TAIL VIN GAIN8__AMP__PRE VGND sky130_fd_pr__nfet_01v8 ad=1.45 pd=10.58 as=1.45 ps=10.58 w=5 l=1
X23 GAIN8__AMP__PRE GAIN8__AMP__COMP sky130_fd_pr__cap_mim_m3_1 l=28.68 w=28.68
X24 OUTPUT_BUFFER__PRE OUTPUT_BUFFER__COMP sky130_fd_pr__cap_mim_m3_1 l=28.68 w=28.68
X25 VPWR OUTPUT_BUFFER__FIRST__MIR OUTPUT_BUFFER__FIRST__MIR VPWR sky130_fd_pr__pfet_01v8_hvt ad=5.8 pd=40.58 as=5.8 ps=40.58 w=20 l=1
X26 VGND BIAS OUTPUT_BUFFER__FIRST__TAIL VGND sky130_fd_pr__nfet_01v8 ad=0.58 pd=4.58 as=0.58 ps=4.58 w=2 l=1
X27 SELECTED GAINB V2 VGND sky130_fd_pr__nfet_01v8 ad=5.8 pd=40.58 as=5.8 ps=40.58 w=20 l=0.15
X28 GAIN2__FB VCM VGND sky130_fd_pr__res_xhigh_po_1p41 l=6.89
X29 VPWR GAIN8__AMP__FIRST__MIR GAIN8__AMP__FIRST__MIR VPWR sky130_fd_pr__pfet_01v8_hvt ad=5.8 pd=40.58 as=5.8 ps=40.58 w=20 l=1
X30 GAIN8_R_FEEDBACK_R0_N0 GAIN8__FB VGND sky130_fd_pr__res_xhigh_po_1p41 l=24.51
X31 VPWR GAIN2__AMP__FIRST__MIR GAIN2__AMP__PRE VPWR sky130_fd_pr__pfet_01v8_hvt ad=5.8 pd=40.58 as=5.8 ps=40.58 w=20 l=1
X32 SELECTED GAIN V8 VGND sky130_fd_pr__nfet_01v8 ad=5.8 pd=40.58 as=5.8 ps=40.58 w=20 l=0.15
X33 GAIN8__AMP__FIRST__TAIL GAIN8__FB GAIN8__AMP__FIRST__MIR VGND sky130_fd_pr__nfet_01v8 ad=1.45 pd=10.58 as=1.45 ps=10.58 w=5 l=1
X34 VGND BIAS GAIN2__AMP__FIRST__TAIL VGND sky130_fd_pr__nfet_01v8 ad=0.58 pd=4.58 as=0.58 ps=4.58 w=2 l=1
X35 VGND BIAS V8 VGND sky130_fd_pr__nfet_01v8 ad=0.58 pd=4.58 as=0.58 ps=4.58 w=2 l=1
X36 GAIN8__AMP__PRE GAIN8__AMP__COMP sky130_fd_pr__cap_mim_m3_1 l=28.68 w=28.68
X37 GAIN2__AMP__FIRST__TAIL GAIN2__FB GAIN2__AMP__FIRST__MIR VGND sky130_fd_pr__nfet_01v8 ad=1.45 pd=10.58 as=1.45 ps=10.58 w=5 l=1
X38 VGND BIAS V2 VGND sky130_fd_pr__nfet_01v8 ad=0.58 pd=4.58 as=0.58 ps=4.58 w=2 l=1
X39 GAIN2__AMP__PRE GAIN2__AMP__COMP sky130_fd_pr__cap_mim_m3_1 l=28.68 w=28.68
X40 GAIN2__AMP__PRE GAIN2__AMP__COMP sky130_fd_pr__cap_mim_m3_1 l=28.68 w=28.68
X41 GAIN2__AMP__FIRST__TAIL VIN GAIN2__AMP__PRE VGND sky130_fd_pr__nfet_01v8 ad=1.45 pd=10.58 as=1.45 ps=10.58 w=5 l=1
X42 GAIN2__AMP__COMP V2 VGND sky130_fd_pr__res_xhigh_po_1p41 l=3.36
X43 GAIN8__AMP__PRE GAIN8__AMP__COMP sky130_fd_pr__cap_mim_m3_1 l=28.68 w=28.68
X44 VGND BIAS GAIN8__AMP__FIRST__TAIL VGND sky130_fd_pr__nfet_01v8 ad=0.58 pd=4.58 as=0.58 ps=4.58 w=2 l=1
X45 VGND GAIN GAINB VGND sky130_fd_pr__nfet_01v8 ad=0.1885 pd=1.88 as=0.1885 ps=1.88 w=0.65 l=0.15
X46 OUTPUT_BUFFER__FIRST__TAIL OUT OUTPUT_BUFFER__FIRST__MIR VGND sky130_fd_pr__nfet_01v8 ad=1.45 pd=10.58 as=1.45 ps=10.58 w=5 l=1
X47 VGND BIAS OUT VGND sky130_fd_pr__nfet_01v8 ad=0.58 pd=4.58 as=0.58 ps=4.58 w=2 l=1
X48 OUTPUT_BUFFER__COMP OUT VGND sky130_fd_pr__res_xhigh_po_1p41 l=3.36
X49 OUTPUT_BUFFER__PRE OUTPUT_BUFFER__COMP sky130_fd_pr__cap_mim_m3_1 l=28.68 w=28.68
.ends

.subckt soc_pga VIN GAIN VCM BIAS OUT VPWR VGND
XGAIN2_AMP_C_MILLER_P0 GAIN2__AMP__PRE GAIN2__AMP__COMP sky130_fd_pr__cap_mim_m3_1 w=28.68 l=28.68
XGAIN2_AMP_C_MILLER_P1 GAIN2__AMP__PRE GAIN2__AMP__COMP sky130_fd_pr__cap_mim_m3_1 w=28.68 l=28.68
XGAIN2_AMP_C_MILLER_P2 GAIN2__AMP__PRE GAIN2__AMP__COMP sky130_fd_pr__cap_mim_m3_1 w=28.68 l=28.68
XGAIN2_AMP_FIRST_N_INN0 GAIN2__AMP__FIRST__MIR GAIN2__FB GAIN2__AMP__FIRST__TAIL VGND sky130_fd_pr__nfet_01v8 w=5 l=1 nf=1 m=1
XGAIN2_AMP_FIRST_N_INN1 GAIN2__AMP__FIRST__MIR GAIN2__FB GAIN2__AMP__FIRST__TAIL VGND sky130_fd_pr__nfet_01v8 w=5 l=1 nf=1 m=1
XGAIN2_AMP_FIRST_N_INP0 GAIN2__AMP__PRE VIN GAIN2__AMP__FIRST__TAIL VGND sky130_fd_pr__nfet_01v8 w=5 l=1 nf=1 m=1
XGAIN2_AMP_FIRST_N_INP1 GAIN2__AMP__PRE VIN GAIN2__AMP__FIRST__TAIL VGND sky130_fd_pr__nfet_01v8 w=5 l=1 nf=1 m=1
XGAIN2_AMP_FIRST_N_TAIL GAIN2__AMP__FIRST__TAIL BIAS VGND VGND sky130_fd_pr__nfet_01v8 w=2 l=1 nf=1 m=1
XGAIN2_AMP_FIRST_P_DIODE GAIN2__AMP__FIRST__MIR GAIN2__AMP__FIRST__MIR VPWR VPWR sky130_fd_pr__pfet_01v8_hvt w=20 l=1 nf=1 m=1
XGAIN2_AMP_FIRST_P_MIRROR GAIN2__AMP__PRE GAIN2__AMP__FIRST__MIR VPWR VPWR sky130_fd_pr__pfet_01v8_hvt w=20 l=1 nf=1 m=1
XGAIN2_AMP_N_SECOND V2 BIAS VGND VGND sky130_fd_pr__nfet_01v8 w=2 l=1 nf=1 m=1
XGAIN2_AMP_P_SECOND V2 GAIN2__AMP__PRE VPWR VPWR sky130_fd_pr__pfet_01v8_hvt w=40 l=1 nf=1 m=1
XGAIN2_AMP_R_ZERO_P0 GAIN2__AMP__COMP V2 VGND sky130_fd_pr__res_xhigh_po_1p41 l=3.36
XGAIN2_R_FEEDBACK_P0 V2 GAIN2__FB VGND sky130_fd_pr__res_xhigh_po_1p41 l=6.885
XGAIN2_R_GROUND_P0 GAIN2__FB VCM VGND sky130_fd_pr__res_xhigh_po_1p41 l=6.885
XGAIN8_AMP_C_MILLER_P0 GAIN8__AMP__PRE GAIN8__AMP__COMP sky130_fd_pr__cap_mim_m3_1 w=28.68 l=28.68
XGAIN8_AMP_C_MILLER_P1 GAIN8__AMP__PRE GAIN8__AMP__COMP sky130_fd_pr__cap_mim_m3_1 w=28.68 l=28.68
XGAIN8_AMP_C_MILLER_P2 GAIN8__AMP__PRE GAIN8__AMP__COMP sky130_fd_pr__cap_mim_m3_1 w=28.68 l=28.68
XGAIN8_AMP_FIRST_N_INN0 GAIN8__AMP__FIRST__MIR GAIN8__FB GAIN8__AMP__FIRST__TAIL VGND sky130_fd_pr__nfet_01v8 w=5 l=1 nf=1 m=1
XGAIN8_AMP_FIRST_N_INN1 GAIN8__AMP__FIRST__MIR GAIN8__FB GAIN8__AMP__FIRST__TAIL VGND sky130_fd_pr__nfet_01v8 w=5 l=1 nf=1 m=1
XGAIN8_AMP_FIRST_N_INP0 GAIN8__AMP__PRE VIN GAIN8__AMP__FIRST__TAIL VGND sky130_fd_pr__nfet_01v8 w=5 l=1 nf=1 m=1
XGAIN8_AMP_FIRST_N_INP1 GAIN8__AMP__PRE VIN GAIN8__AMP__FIRST__TAIL VGND sky130_fd_pr__nfet_01v8 w=5 l=1 nf=1 m=1
XGAIN8_AMP_FIRST_N_TAIL GAIN8__AMP__FIRST__TAIL BIAS VGND VGND sky130_fd_pr__nfet_01v8 w=2 l=1 nf=1 m=1
XGAIN8_AMP_FIRST_P_DIODE GAIN8__AMP__FIRST__MIR GAIN8__AMP__FIRST__MIR VPWR VPWR sky130_fd_pr__pfet_01v8_hvt w=20 l=1 nf=1 m=1
XGAIN8_AMP_FIRST_P_MIRROR GAIN8__AMP__PRE GAIN8__AMP__FIRST__MIR VPWR VPWR sky130_fd_pr__pfet_01v8_hvt w=20 l=1 nf=1 m=1
XGAIN8_AMP_N_SECOND V8 BIAS VGND VGND sky130_fd_pr__nfet_01v8 w=2 l=1 nf=1 m=1
XGAIN8_AMP_P_SECOND V8 GAIN8__AMP__PRE VPWR VPWR sky130_fd_pr__pfet_01v8_hvt w=40 l=1 nf=1 m=1
XGAIN8_AMP_R_ZERO_P0 GAIN8__AMP__COMP V8 VGND sky130_fd_pr__res_xhigh_po_1p41 l=3.36
XGAIN8_R_FEEDBACK_P0 V8 GAIN8_R_FEEDBACK_R0_N0 VGND sky130_fd_pr__res_xhigh_po_1p41 l=24.51
XGAIN8_R_FEEDBACK_P1 GAIN8_R_FEEDBACK_R0_N0 GAIN8__FB VGND sky130_fd_pr__res_xhigh_po_1p41 l=24.51
XGAIN8_R_GROUND_P0 GAIN8__FB VCM VGND sky130_fd_pr__res_xhigh_po_1p41 l=6.885
XGAIN_INVERTER_MN GAINB GAIN VGND VGND sky130_fd_pr__nfet_01v8 w=0.65 l=0.15 nf=1 m=1
XGAIN_INVERTER_MP GAINB GAIN VPWR VPWR sky130_fd_pr__pfet_01v8_hvt w=0.65 l=0.15 nf=1 m=1
XN_HIGH V8 GAIN SELECTED VGND sky130_fd_pr__nfet_01v8 w=20 l=0.15 nf=1 m=1
XN_LOW V2 GAINB SELECTED VGND sky130_fd_pr__nfet_01v8 w=20 l=0.15 nf=1 m=1
XOUTPUT_BUFFER_C_MILLER_P0 OUTPUT_BUFFER__PRE OUTPUT_BUFFER__COMP sky130_fd_pr__cap_mim_m3_1 w=28.68 l=28.68
XOUTPUT_BUFFER_C_MILLER_P1 OUTPUT_BUFFER__PRE OUTPUT_BUFFER__COMP sky130_fd_pr__cap_mim_m3_1 w=28.68 l=28.68
XOUTPUT_BUFFER_C_MILLER_P2 OUTPUT_BUFFER__PRE OUTPUT_BUFFER__COMP sky130_fd_pr__cap_mim_m3_1 w=28.68 l=28.68
XOUTPUT_BUFFER_FIRST_N_INN0 OUTPUT_BUFFER__FIRST__MIR OUT OUTPUT_BUFFER__FIRST__TAIL VGND sky130_fd_pr__nfet_01v8 w=5 l=1 nf=1 m=1
XOUTPUT_BUFFER_FIRST_N_INN1 OUTPUT_BUFFER__FIRST__MIR OUT OUTPUT_BUFFER__FIRST__TAIL VGND sky130_fd_pr__nfet_01v8 w=5 l=1 nf=1 m=1
XOUTPUT_BUFFER_FIRST_N_INP0 OUTPUT_BUFFER__PRE SELECTED OUTPUT_BUFFER__FIRST__TAIL VGND sky130_fd_pr__nfet_01v8 w=5 l=1 nf=1 m=1
XOUTPUT_BUFFER_FIRST_N_INP1 OUTPUT_BUFFER__PRE SELECTED OUTPUT_BUFFER__FIRST__TAIL VGND sky130_fd_pr__nfet_01v8 w=5 l=1 nf=1 m=1
XOUTPUT_BUFFER_FIRST_N_TAIL OUTPUT_BUFFER__FIRST__TAIL BIAS VGND VGND sky130_fd_pr__nfet_01v8 w=2 l=1 nf=1 m=1
XOUTPUT_BUFFER_FIRST_P_DIODE OUTPUT_BUFFER__FIRST__MIR OUTPUT_BUFFER__FIRST__MIR VPWR VPWR sky130_fd_pr__pfet_01v8_hvt w=20 l=1 nf=1 m=1
XOUTPUT_BUFFER_FIRST_P_MIRROR OUTPUT_BUFFER__PRE OUTPUT_BUFFER__FIRST__MIR VPWR VPWR sky130_fd_pr__pfet_01v8_hvt w=20 l=1 nf=1 m=1
XOUTPUT_BUFFER_N_SECOND OUT BIAS VGND VGND sky130_fd_pr__nfet_01v8 w=2 l=1 nf=1 m=1
XOUTPUT_BUFFER_P_SECOND OUT OUTPUT_BUFFER__PRE VPWR VPWR sky130_fd_pr__pfet_01v8_hvt w=40 l=1 nf=1 m=1
XOUTPUT_BUFFER_R_ZERO_P0 OUTPUT_BUFFER__COMP OUT VGND sky130_fd_pr__res_xhigh_po_1p41 l=3.36
XP_HIGH V8 GAINB SELECTED VPWR sky130_fd_pr__pfet_01v8_hvt w=20 l=0.15 nf=1 m=1
XP_LOW V2 GAIN SELECTED VPWR sky130_fd_pr__pfet_01v8_hvt w=20 l=0.15 nf=1 m=1
.ends soc_pga

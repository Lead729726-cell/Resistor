Resistor analog SoC soc_pga
.include "/workspace/.runtime/eda/runs/35f3831865354726a5bc9a33484be47c/supported-tt.spice"
.options method=gear maxord=2
.include "/workspace/.runtime/eda/runs/35f3831865354726a5bc9a33484be47c/current-probe.spice"
.temp 27.0
VGND VGND 0 0
VDD VPWR VGND 1.8
VBIAS BIAS VGND 0.9
VCM VCM VGND 0.9
VIN VIN VGND DC 0.9 AC 1 SIN(0.9 0.025 5000)
VGAIN GAIN VGND PULSE(0 1.8 100u 2n 2n 1 2)
CLOAD OUT VGND 50f
XU VIN GAIN VCM BIAS OUT VPWR VGND soc_pga
.control
save v(OUT) i(VDD) v(VIN) v(GAIN) i(v.xu.vregister_cf_5a0386e397d1e31e) i(v.xu.vregister_cf_6aa7e3689d3542a3) i(v.xu.vregister_cf_b464c2df17e14bac) i(v.xu.vregister_cf_e0e87bb62d246415) i(v.xu.vregister_cf_f5996600cbff2511) i(v.xu.vregister_cf_2461cb00b6e67796) i(v.xu.vregister_cf_dfe39be444870253) i(v.xu.vregister_cf_179a6c27383a4e12) i(v.xu.vregister_cf_476e48061b5d9c89) i(v.xu.vregister_cf_8e6d2826a9d8f8e3) i(v.xu.vregister_cf_d088cf9d3f35b51f) i(v.xu.vregister_cf_db7cfb28e1b0755f) i(v.xu.vregister_cf_5340d9fe38977e91) i(v.xu.vregister_cf_81ac28cdafee6a1e) i(v.xu.vregister_cf_dd917807efc0b7ac) i(v.xu.vregister_cf_48ce06a2d14dad44) i(v.xu.vregister_cf_7c8949e745a2290f) i(v.xu.vregister_cf_51d40da40a955f41) i(v.xu.vregister_cf_e7e336b00d51fca7) i(v.xu.vregister_cf_2dfb2478aad30aab) i(v.xu.vregister_cf_396c97f6815217b7) i(v.xu.vregister_cf_58a90f8abcf17bdb) i(v.xu.vregister_cf_68991393cdbd0b08) i(v.xu.vregister_cf_35f8bfb165fb7d8d) i(v.xu.vregister_cf_39488953a65d8e4d) i(v.xu.vregister_cf_a46538b02eae5d7c) i(v.xu.vregister_cf_5e703f515ec7c644) i(v.xu.vregister_cf_0406410a902a199e) i(v.xu.vregister_cf_224db6c6240cfa9e) i(v.xu.vregister_cf_e8aef782d19e6bae) i(v.xu.vregister_cf_838dac3cd6064ad0) i(v.xu.vregister_cf_59c8c4c927c8fe6a) i(v.xu.vregister_cf_58071531a6efd575) i(VGND) i(VBIAS) i(VCM) i(VIN) i(VGAIN) v(XU.GAIN2__AMP__FIRST__MIR) v(XU.GAIN2__AMP__FIRST__TAIL) v(XU.GAIN2__FB) v(VGND) v(XU.GAIN2__AMP__PRE) v(BIAS) v(VPWR) v(XU.V2) v(XU.GAIN8__AMP__FIRST__MIR) v(XU.GAIN8__AMP__FIRST__TAIL) v(XU.GAIN8__FB) v(XU.GAIN8__AMP__PRE) v(XU.V8) v(XU.GAINB) v(XU.SELECTED) v(XU.OUTPUT_BUFFER__FIRST__MIR) v(XU.OUTPUT_BUFFER__FIRST__TAIL) v(XU.OUTPUT_BUFFER__PRE) v(VCM)
set num_threads=1
set numdgt=17
set wr_singlescale
set wr_vecnames
set noaskquit
tran 2e-08 0.0002
let mos_wave_0 = v(OUT)
let mos_wave_1 = -i(VDD)
let mos_wave_2 = v(VIN)
let mos_wave_3 = v(GAIN)
wrdata waveform.dat mos_wave_0 mos_wave_1 mos_wave_2 mos_wave_3
write waveform.raw all
let register_flow_0 = i(v.xu.vregister_cf_5a0386e397d1e31e)
let register_flow_1 = i(v.xu.vregister_cf_6aa7e3689d3542a3)
let register_flow_2 = i(v.xu.vregister_cf_b464c2df17e14bac)
let register_flow_3 = i(v.xu.vregister_cf_e0e87bb62d246415)
let register_flow_4 = i(v.xu.vregister_cf_f5996600cbff2511)
let register_flow_5 = i(v.xu.vregister_cf_2461cb00b6e67796)
let register_flow_6 = i(v.xu.vregister_cf_dfe39be444870253)
let register_flow_7 = i(v.xu.vregister_cf_179a6c27383a4e12)
let register_flow_8 = i(v.xu.vregister_cf_476e48061b5d9c89)
let register_flow_9 = i(v.xu.vregister_cf_8e6d2826a9d8f8e3)
let register_flow_10 = i(v.xu.vregister_cf_d088cf9d3f35b51f)
let register_flow_11 = i(v.xu.vregister_cf_db7cfb28e1b0755f)
let register_flow_12 = i(v.xu.vregister_cf_5340d9fe38977e91)
let register_flow_13 = i(v.xu.vregister_cf_81ac28cdafee6a1e)
let register_flow_14 = i(v.xu.vregister_cf_dd917807efc0b7ac)
let register_flow_15 = i(v.xu.vregister_cf_48ce06a2d14dad44)
let register_flow_16 = i(v.xu.vregister_cf_7c8949e745a2290f)
let register_flow_17 = i(v.xu.vregister_cf_51d40da40a955f41)
let register_flow_18 = i(v.xu.vregister_cf_e7e336b00d51fca7)
let register_flow_19 = i(v.xu.vregister_cf_2dfb2478aad30aab)
let register_flow_20 = i(v.xu.vregister_cf_396c97f6815217b7)
let register_flow_21 = i(v.xu.vregister_cf_58a90f8abcf17bdb)
let register_flow_22 = i(v.xu.vregister_cf_68991393cdbd0b08)
let register_flow_23 = i(v.xu.vregister_cf_35f8bfb165fb7d8d)
let register_flow_24 = i(v.xu.vregister_cf_39488953a65d8e4d)
let register_flow_25 = i(v.xu.vregister_cf_a46538b02eae5d7c)
let register_flow_26 = i(v.xu.vregister_cf_5e703f515ec7c644)
let register_flow_27 = i(v.xu.vregister_cf_0406410a902a199e)
let register_flow_28 = i(v.xu.vregister_cf_224db6c6240cfa9e)
let register_flow_29 = i(v.xu.vregister_cf_e8aef782d19e6bae)
let register_flow_30 = i(v.xu.vregister_cf_838dac3cd6064ad0)
let register_flow_31 = i(v.xu.vregister_cf_59c8c4c927c8fe6a)
let register_flow_32 = i(v.xu.vregister_cf_58071531a6efd575)
let register_flow_33 = i(VGND)
let register_flow_34 = i(VDD)
let register_flow_35 = i(VBIAS)
let register_flow_36 = i(VCM)
let register_flow_37 = i(VIN)
let register_flow_38 = i(VGAIN)
wrdata current-flow.dat register_flow_0 register_flow_1 register_flow_2 register_flow_3 register_flow_4 register_flow_5 register_flow_6 register_flow_7 register_flow_8 register_flow_9 register_flow_10 register_flow_11 register_flow_12 register_flow_13 register_flow_14 register_flow_15 register_flow_16 register_flow_17 register_flow_18 register_flow_19 register_flow_20 register_flow_21 register_flow_22 register_flow_23 register_flow_24 register_flow_25 register_flow_26 register_flow_27 register_flow_28 register_flow_29 register_flow_30 register_flow_31 register_flow_32 register_flow_33 register_flow_34 register_flow_35 register_flow_36 register_flow_37 register_flow_38
let register_voltage_0 = v(XU.GAIN2__AMP__FIRST__MIR)
let register_voltage_1 = v(XU.GAIN2__AMP__FIRST__TAIL)
let register_voltage_2 = v(XU.GAIN2__FB)
let register_voltage_3 = v(VGND)
let register_voltage_4 = v(XU.GAIN2__AMP__PRE)
let register_voltage_5 = v(VIN)
let register_voltage_6 = v(BIAS)
let register_voltage_7 = v(VPWR)
let register_voltage_8 = v(XU.V2)
let register_voltage_9 = v(XU.GAIN8__AMP__FIRST__MIR)
let register_voltage_10 = v(XU.GAIN8__AMP__FIRST__TAIL)
let register_voltage_11 = v(XU.GAIN8__FB)
let register_voltage_12 = v(XU.GAIN8__AMP__PRE)
let register_voltage_13 = v(XU.V8)
let register_voltage_14 = v(XU.GAINB)
let register_voltage_15 = v(GAIN)
let register_voltage_16 = v(XU.SELECTED)
let register_voltage_17 = v(XU.OUTPUT_BUFFER__FIRST__MIR)
let register_voltage_18 = v(XU.OUTPUT_BUFFER__FIRST__TAIL)
let register_voltage_19 = v(OUT)
let register_voltage_20 = v(XU.OUTPUT_BUFFER__PRE)
let register_voltage_21 = 0*register_flow_0
let register_voltage_22 = v(VCM)
wrdata node-voltages.dat register_voltage_0 register_voltage_1 register_voltage_2 register_voltage_3 register_voltage_4 register_voltage_5 register_voltage_6 register_voltage_7 register_voltage_8 register_voltage_9 register_voltage_10 register_voltage_11 register_voltage_12 register_voltage_13 register_voltage_14 register_voltage_15 register_voltage_16 register_voltage_17 register_voltage_18 register_voltage_19 register_voltage_20 register_voltage_21 register_voltage_22
quit
.endc
.end

.subckt soc_pga VIN GAIN VCM BIAS OUT VPWR VGND
XGAIN2_AMP_C_MILLER_P0 GAIN2__AMP__PRE GAIN2__AMP__COMP sky130_fd_pr__cap_mim_m3_1 w=28.68 l=28.68
XGAIN2_AMP_C_MILLER_P1 GAIN2__AMP__PRE GAIN2__AMP__COMP sky130_fd_pr__cap_mim_m3_1 w=28.68 l=28.68
XGAIN2_AMP_C_MILLER_P2 GAIN2__AMP__PRE GAIN2__AMP__COMP sky130_fd_pr__cap_mim_m3_1 w=28.68 l=28.68
XGAIN2_AMP_FIRST_N_INN0 register_cf_node_5a0386e397d1e31e GAIN2__FB register_cf_node_5a0386e397d1e31e_source VGND sky130_fd_pr__nfet_01v8 w=5 l=1 nf=1 m=1
Vregister_cf_5a0386e397d1e31e GAIN2__AMP__FIRST__MIR register_cf_node_5a0386e397d1e31e 0
Vregister_cf_5a0386e397d1e31e_source GAIN2__AMP__FIRST__TAIL register_cf_node_5a0386e397d1e31e_source 0
XGAIN2_AMP_FIRST_N_INN1 register_cf_node_6aa7e3689d3542a3 GAIN2__FB register_cf_node_6aa7e3689d3542a3_source VGND sky130_fd_pr__nfet_01v8 w=5 l=1 nf=1 m=1
Vregister_cf_6aa7e3689d3542a3 GAIN2__AMP__FIRST__MIR register_cf_node_6aa7e3689d3542a3 0
Vregister_cf_6aa7e3689d3542a3_source GAIN2__AMP__FIRST__TAIL register_cf_node_6aa7e3689d3542a3_source 0
XGAIN2_AMP_FIRST_N_INP0 register_cf_node_b464c2df17e14bac VIN register_cf_node_b464c2df17e14bac_source VGND sky130_fd_pr__nfet_01v8 w=5 l=1 nf=1 m=1
Vregister_cf_b464c2df17e14bac GAIN2__AMP__PRE register_cf_node_b464c2df17e14bac 0
Vregister_cf_b464c2df17e14bac_source GAIN2__AMP__FIRST__TAIL register_cf_node_b464c2df17e14bac_source 0
XGAIN2_AMP_FIRST_N_INP1 register_cf_node_e0e87bb62d246415 VIN register_cf_node_e0e87bb62d246415_source VGND sky130_fd_pr__nfet_01v8 w=5 l=1 nf=1 m=1
Vregister_cf_e0e87bb62d246415 GAIN2__AMP__PRE register_cf_node_e0e87bb62d246415 0
Vregister_cf_e0e87bb62d246415_source GAIN2__AMP__FIRST__TAIL register_cf_node_e0e87bb62d246415_source 0
XGAIN2_AMP_FIRST_N_TAIL register_cf_node_f5996600cbff2511 BIAS register_cf_node_f5996600cbff2511_source VGND sky130_fd_pr__nfet_01v8 w=2 l=1 nf=1 m=1
Vregister_cf_f5996600cbff2511 GAIN2__AMP__FIRST__TAIL register_cf_node_f5996600cbff2511 0
Vregister_cf_f5996600cbff2511_source VGND register_cf_node_f5996600cbff2511_source 0
XGAIN2_AMP_FIRST_P_DIODE register_cf_node_2461cb00b6e67796 GAIN2__AMP__FIRST__MIR register_cf_node_2461cb00b6e67796_source VPWR sky130_fd_pr__pfet_01v8_hvt w=20 l=1 nf=1 m=1
Vregister_cf_2461cb00b6e67796 GAIN2__AMP__FIRST__MIR register_cf_node_2461cb00b6e67796 0
Vregister_cf_2461cb00b6e67796_source VPWR register_cf_node_2461cb00b6e67796_source 0
XGAIN2_AMP_FIRST_P_MIRROR register_cf_node_dfe39be444870253 GAIN2__AMP__FIRST__MIR register_cf_node_dfe39be444870253_source VPWR sky130_fd_pr__pfet_01v8_hvt w=20 l=1 nf=1 m=1
Vregister_cf_dfe39be444870253 GAIN2__AMP__PRE register_cf_node_dfe39be444870253 0
Vregister_cf_dfe39be444870253_source VPWR register_cf_node_dfe39be444870253_source 0
XGAIN2_AMP_N_SECOND register_cf_node_179a6c27383a4e12 BIAS register_cf_node_179a6c27383a4e12_source VGND sky130_fd_pr__nfet_01v8 w=2 l=1 nf=1 m=1
Vregister_cf_179a6c27383a4e12 V2 register_cf_node_179a6c27383a4e12 0
Vregister_cf_179a6c27383a4e12_source VGND register_cf_node_179a6c27383a4e12_source 0
XGAIN2_AMP_P_SECOND register_cf_node_476e48061b5d9c89 GAIN2__AMP__PRE register_cf_node_476e48061b5d9c89_source VPWR sky130_fd_pr__pfet_01v8_hvt w=40 l=1 nf=1 m=1
Vregister_cf_476e48061b5d9c89 V2 register_cf_node_476e48061b5d9c89 0
Vregister_cf_476e48061b5d9c89_source VPWR register_cf_node_476e48061b5d9c89_source 0
XGAIN2_AMP_R_ZERO_P0 GAIN2__AMP__COMP V2 VGND sky130_fd_pr__res_xhigh_po_1p41 l=3.36
XGAIN2_R_FEEDBACK_P0 V2 GAIN2__FB VGND sky130_fd_pr__res_xhigh_po_1p41 l=6.885
XGAIN2_R_GROUND_P0 GAIN2__FB VCM VGND sky130_fd_pr__res_xhigh_po_1p41 l=6.885
XGAIN8_AMP_C_MILLER_P0 GAIN8__AMP__PRE GAIN8__AMP__COMP sky130_fd_pr__cap_mim_m3_1 w=28.68 l=28.68
XGAIN8_AMP_C_MILLER_P1 GAIN8__AMP__PRE GAIN8__AMP__COMP sky130_fd_pr__cap_mim_m3_1 w=28.68 l=28.68
XGAIN8_AMP_C_MILLER_P2 GAIN8__AMP__PRE GAIN8__AMP__COMP sky130_fd_pr__cap_mim_m3_1 w=28.68 l=28.68
XGAIN8_AMP_FIRST_N_INN0 register_cf_node_8e6d2826a9d8f8e3 GAIN8__FB register_cf_node_8e6d2826a9d8f8e3_source VGND sky130_fd_pr__nfet_01v8 w=5 l=1 nf=1 m=1
Vregister_cf_8e6d2826a9d8f8e3 GAIN8__AMP__FIRST__MIR register_cf_node_8e6d2826a9d8f8e3 0
Vregister_cf_8e6d2826a9d8f8e3_source GAIN8__AMP__FIRST__TAIL register_cf_node_8e6d2826a9d8f8e3_source 0
XGAIN8_AMP_FIRST_N_INN1 register_cf_node_d088cf9d3f35b51f GAIN8__FB register_cf_node_d088cf9d3f35b51f_source VGND sky130_fd_pr__nfet_01v8 w=5 l=1 nf=1 m=1
Vregister_cf_d088cf9d3f35b51f GAIN8__AMP__FIRST__MIR register_cf_node_d088cf9d3f35b51f 0
Vregister_cf_d088cf9d3f35b51f_source GAIN8__AMP__FIRST__TAIL register_cf_node_d088cf9d3f35b51f_source 0
XGAIN8_AMP_FIRST_N_INP0 register_cf_node_db7cfb28e1b0755f VIN register_cf_node_db7cfb28e1b0755f_source VGND sky130_fd_pr__nfet_01v8 w=5 l=1 nf=1 m=1
Vregister_cf_db7cfb28e1b0755f GAIN8__AMP__PRE register_cf_node_db7cfb28e1b0755f 0
Vregister_cf_db7cfb28e1b0755f_source GAIN8__AMP__FIRST__TAIL register_cf_node_db7cfb28e1b0755f_source 0
XGAIN8_AMP_FIRST_N_INP1 register_cf_node_5340d9fe38977e91 VIN register_cf_node_5340d9fe38977e91_source VGND sky130_fd_pr__nfet_01v8 w=5 l=1 nf=1 m=1
Vregister_cf_5340d9fe38977e91 GAIN8__AMP__PRE register_cf_node_5340d9fe38977e91 0
Vregister_cf_5340d9fe38977e91_source GAIN8__AMP__FIRST__TAIL register_cf_node_5340d9fe38977e91_source 0
XGAIN8_AMP_FIRST_N_TAIL register_cf_node_81ac28cdafee6a1e BIAS register_cf_node_81ac28cdafee6a1e_source VGND sky130_fd_pr__nfet_01v8 w=2 l=1 nf=1 m=1
Vregister_cf_81ac28cdafee6a1e GAIN8__AMP__FIRST__TAIL register_cf_node_81ac28cdafee6a1e 0
Vregister_cf_81ac28cdafee6a1e_source VGND register_cf_node_81ac28cdafee6a1e_source 0
XGAIN8_AMP_FIRST_P_DIODE register_cf_node_dd917807efc0b7ac GAIN8__AMP__FIRST__MIR register_cf_node_dd917807efc0b7ac_source VPWR sky130_fd_pr__pfet_01v8_hvt w=20 l=1 nf=1 m=1
Vregister_cf_dd917807efc0b7ac GAIN8__AMP__FIRST__MIR register_cf_node_dd917807efc0b7ac 0
Vregister_cf_dd917807efc0b7ac_source VPWR register_cf_node_dd917807efc0b7ac_source 0
XGAIN8_AMP_FIRST_P_MIRROR register_cf_node_48ce06a2d14dad44 GAIN8__AMP__FIRST__MIR register_cf_node_48ce06a2d14dad44_source VPWR sky130_fd_pr__pfet_01v8_hvt w=20 l=1 nf=1 m=1
Vregister_cf_48ce06a2d14dad44 GAIN8__AMP__PRE register_cf_node_48ce06a2d14dad44 0
Vregister_cf_48ce06a2d14dad44_source VPWR register_cf_node_48ce06a2d14dad44_source 0
XGAIN8_AMP_N_SECOND register_cf_node_7c8949e745a2290f BIAS register_cf_node_7c8949e745a2290f_source VGND sky130_fd_pr__nfet_01v8 w=2 l=1 nf=1 m=1
Vregister_cf_7c8949e745a2290f V8 register_cf_node_7c8949e745a2290f 0
Vregister_cf_7c8949e745a2290f_source VGND register_cf_node_7c8949e745a2290f_source 0
XGAIN8_AMP_P_SECOND register_cf_node_51d40da40a955f41 GAIN8__AMP__PRE register_cf_node_51d40da40a955f41_source VPWR sky130_fd_pr__pfet_01v8_hvt w=40 l=1 nf=1 m=1
Vregister_cf_51d40da40a955f41 V8 register_cf_node_51d40da40a955f41 0
Vregister_cf_51d40da40a955f41_source VPWR register_cf_node_51d40da40a955f41_source 0
XGAIN8_AMP_R_ZERO_P0 GAIN8__AMP__COMP V8 VGND sky130_fd_pr__res_xhigh_po_1p41 l=3.36
XGAIN8_R_FEEDBACK_P0 V8 GAIN8_R_FEEDBACK_R0_N0 VGND sky130_fd_pr__res_xhigh_po_1p41 l=24.51
XGAIN8_R_FEEDBACK_P1 GAIN8_R_FEEDBACK_R0_N0 GAIN8__FB VGND sky130_fd_pr__res_xhigh_po_1p41 l=24.51
XGAIN8_R_GROUND_P0 GAIN8__FB VCM VGND sky130_fd_pr__res_xhigh_po_1p41 l=6.885
XGAIN_INVERTER_MN register_cf_node_e7e336b00d51fca7 GAIN register_cf_node_e7e336b00d51fca7_source VGND sky130_fd_pr__nfet_01v8 w=0.65 l=0.15 nf=1 m=1
Vregister_cf_e7e336b00d51fca7 GAINB register_cf_node_e7e336b00d51fca7 0
Vregister_cf_e7e336b00d51fca7_source VGND register_cf_node_e7e336b00d51fca7_source 0
XGAIN_INVERTER_MP register_cf_node_2dfb2478aad30aab GAIN register_cf_node_2dfb2478aad30aab_source VPWR sky130_fd_pr__pfet_01v8_hvt w=0.65 l=0.15 nf=1 m=1
Vregister_cf_2dfb2478aad30aab GAINB register_cf_node_2dfb2478aad30aab 0
Vregister_cf_2dfb2478aad30aab_source VPWR register_cf_node_2dfb2478aad30aab_source 0
XN_HIGH register_cf_node_396c97f6815217b7 GAIN register_cf_node_396c97f6815217b7_source VGND sky130_fd_pr__nfet_01v8 w=20 l=0.15 nf=1 m=1
Vregister_cf_396c97f6815217b7 V8 register_cf_node_396c97f6815217b7 0
Vregister_cf_396c97f6815217b7_source SELECTED register_cf_node_396c97f6815217b7_source 0
XN_LOW register_cf_node_58a90f8abcf17bdb GAINB register_cf_node_58a90f8abcf17bdb_source VGND sky130_fd_pr__nfet_01v8 w=20 l=0.15 nf=1 m=1
Vregister_cf_58a90f8abcf17bdb V2 register_cf_node_58a90f8abcf17bdb 0
Vregister_cf_58a90f8abcf17bdb_source SELECTED register_cf_node_58a90f8abcf17bdb_source 0
XOUTPUT_BUFFER_C_MILLER_P0 OUTPUT_BUFFER__PRE OUTPUT_BUFFER__COMP sky130_fd_pr__cap_mim_m3_1 w=28.68 l=28.68
XOUTPUT_BUFFER_C_MILLER_P1 OUTPUT_BUFFER__PRE OUTPUT_BUFFER__COMP sky130_fd_pr__cap_mim_m3_1 w=28.68 l=28.68
XOUTPUT_BUFFER_C_MILLER_P2 OUTPUT_BUFFER__PRE OUTPUT_BUFFER__COMP sky130_fd_pr__cap_mim_m3_1 w=28.68 l=28.68
XOUTPUT_BUFFER_FIRST_N_INN0 register_cf_node_68991393cdbd0b08 OUT register_cf_node_68991393cdbd0b08_source VGND sky130_fd_pr__nfet_01v8 w=5 l=1 nf=1 m=1
Vregister_cf_68991393cdbd0b08 OUTPUT_BUFFER__FIRST__MIR register_cf_node_68991393cdbd0b08 0
Vregister_cf_68991393cdbd0b08_source OUTPUT_BUFFER__FIRST__TAIL register_cf_node_68991393cdbd0b08_source 0
XOUTPUT_BUFFER_FIRST_N_INN1 register_cf_node_35f8bfb165fb7d8d OUT register_cf_node_35f8bfb165fb7d8d_source VGND sky130_fd_pr__nfet_01v8 w=5 l=1 nf=1 m=1
Vregister_cf_35f8bfb165fb7d8d OUTPUT_BUFFER__FIRST__MIR register_cf_node_35f8bfb165fb7d8d 0
Vregister_cf_35f8bfb165fb7d8d_source OUTPUT_BUFFER__FIRST__TAIL register_cf_node_35f8bfb165fb7d8d_source 0
XOUTPUT_BUFFER_FIRST_N_INP0 register_cf_node_39488953a65d8e4d SELECTED register_cf_node_39488953a65d8e4d_source VGND sky130_fd_pr__nfet_01v8 w=5 l=1 nf=1 m=1
Vregister_cf_39488953a65d8e4d OUTPUT_BUFFER__PRE register_cf_node_39488953a65d8e4d 0
Vregister_cf_39488953a65d8e4d_source OUTPUT_BUFFER__FIRST__TAIL register_cf_node_39488953a65d8e4d_source 0
XOUTPUT_BUFFER_FIRST_N_INP1 register_cf_node_a46538b02eae5d7c SELECTED register_cf_node_a46538b02eae5d7c_source VGND sky130_fd_pr__nfet_01v8 w=5 l=1 nf=1 m=1
Vregister_cf_a46538b02eae5d7c OUTPUT_BUFFER__PRE register_cf_node_a46538b02eae5d7c 0
Vregister_cf_a46538b02eae5d7c_source OUTPUT_BUFFER__FIRST__TAIL register_cf_node_a46538b02eae5d7c_source 0
XOUTPUT_BUFFER_FIRST_N_TAIL register_cf_node_5e703f515ec7c644 BIAS register_cf_node_5e703f515ec7c644_source VGND sky130_fd_pr__nfet_01v8 w=2 l=1 nf=1 m=1
Vregister_cf_5e703f515ec7c644 OUTPUT_BUFFER__FIRST__TAIL register_cf_node_5e703f515ec7c644 0
Vregister_cf_5e703f515ec7c644_source VGND register_cf_node_5e703f515ec7c644_source 0
XOUTPUT_BUFFER_FIRST_P_DIODE register_cf_node_0406410a902a199e OUTPUT_BUFFER__FIRST__MIR register_cf_node_0406410a902a199e_source VPWR sky130_fd_pr__pfet_01v8_hvt w=20 l=1 nf=1 m=1
Vregister_cf_0406410a902a199e OUTPUT_BUFFER__FIRST__MIR register_cf_node_0406410a902a199e 0
Vregister_cf_0406410a902a199e_source VPWR register_cf_node_0406410a902a199e_source 0
XOUTPUT_BUFFER_FIRST_P_MIRROR register_cf_node_224db6c6240cfa9e OUTPUT_BUFFER__FIRST__MIR register_cf_node_224db6c6240cfa9e_source VPWR sky130_fd_pr__pfet_01v8_hvt w=20 l=1 nf=1 m=1
Vregister_cf_224db6c6240cfa9e OUTPUT_BUFFER__PRE register_cf_node_224db6c6240cfa9e 0
Vregister_cf_224db6c6240cfa9e_source VPWR register_cf_node_224db6c6240cfa9e_source 0
XOUTPUT_BUFFER_N_SECOND register_cf_node_e8aef782d19e6bae BIAS register_cf_node_e8aef782d19e6bae_source VGND sky130_fd_pr__nfet_01v8 w=2 l=1 nf=1 m=1
Vregister_cf_e8aef782d19e6bae OUT register_cf_node_e8aef782d19e6bae 0
Vregister_cf_e8aef782d19e6bae_source VGND register_cf_node_e8aef782d19e6bae_source 0
XOUTPUT_BUFFER_P_SECOND register_cf_node_838dac3cd6064ad0 OUTPUT_BUFFER__PRE register_cf_node_838dac3cd6064ad0_source VPWR sky130_fd_pr__pfet_01v8_hvt w=40 l=1 nf=1 m=1
Vregister_cf_838dac3cd6064ad0 OUT register_cf_node_838dac3cd6064ad0 0
Vregister_cf_838dac3cd6064ad0_source VPWR register_cf_node_838dac3cd6064ad0_source 0
XOUTPUT_BUFFER_R_ZERO_P0 OUTPUT_BUFFER__COMP OUT VGND sky130_fd_pr__res_xhigh_po_1p41 l=3.36
XP_HIGH register_cf_node_59c8c4c927c8fe6a GAINB register_cf_node_59c8c4c927c8fe6a_source VPWR sky130_fd_pr__pfet_01v8_hvt w=20 l=0.15 nf=1 m=1
Vregister_cf_59c8c4c927c8fe6a V8 register_cf_node_59c8c4c927c8fe6a 0
Vregister_cf_59c8c4c927c8fe6a_source SELECTED register_cf_node_59c8c4c927c8fe6a_source 0
XP_LOW register_cf_node_58071531a6efd575 GAIN register_cf_node_58071531a6efd575_source VPWR sky130_fd_pr__pfet_01v8_hvt w=20 l=0.15 nf=1 m=1
Vregister_cf_58071531a6efd575 V2 register_cf_node_58071531a6efd575 0
Vregister_cf_58071531a6efd575_source SELECTED register_cf_node_58071531a6efd575_source 0
.ends soc_pga

.subckt soc_bias BIAS VCM VPWR VGND
XC_VCM_P0 VCM_RAW VGND sky130_fd_pr__cap_mim_m3_1 w=28.68 l=28.68
XC_VCM_P1 VCM_RAW VGND sky130_fd_pr__cap_mim_m3_1 w=28.68 l=28.68
XC_VCM_P10 VCM_RAW VGND sky130_fd_pr__cap_mim_m3_1 w=28.68 l=28.68
XC_VCM_P11 VCM_RAW VGND sky130_fd_pr__cap_mim_m3_1 w=28.68 l=28.68
XC_VCM_P2 VCM_RAW VGND sky130_fd_pr__cap_mim_m3_1 w=28.68 l=28.68
XC_VCM_P3 VCM_RAW VGND sky130_fd_pr__cap_mim_m3_1 w=28.68 l=28.68
XC_VCM_P4 VCM_RAW VGND sky130_fd_pr__cap_mim_m3_1 w=28.68 l=28.68
XC_VCM_P5 VCM_RAW VGND sky130_fd_pr__cap_mim_m3_1 w=28.68 l=28.68
XC_VCM_P6 VCM_RAW VGND sky130_fd_pr__cap_mim_m3_1 w=28.68 l=28.68
XC_VCM_P7 VCM_RAW VGND sky130_fd_pr__cap_mim_m3_1 w=28.68 l=28.68
XC_VCM_P8 VCM_RAW VGND sky130_fd_pr__cap_mim_m3_1 w=28.68 l=28.68
XC_VCM_P9 VCM_RAW VGND sky130_fd_pr__cap_mim_m3_1 w=28.68 l=28.68
XN_DIODE BIAS BIAS VGND VGND sky130_fd_pr__nfet_01v8 w=2 l=1 nf=1 m=1
XR_BIAS_P0 VPWR BIAS VGND sky130_fd_pr__res_xhigh_po_1p41 l=20.985
XR_VCM_BOTTOM_P0 VCM_RAW R_VCM_BOTTOM_R0_N0 VGND sky130_fd_pr__res_xhigh_po_1p41 l=23.335
XR_VCM_BOTTOM_P1 R_VCM_BOTTOM_R0_N0 R_VCM_BOTTOM_R0_N1 VGND sky130_fd_pr__res_xhigh_po_1p41 l=23.335
XR_VCM_BOTTOM_P2 R_VCM_BOTTOM_R0_N1 VGND VGND sky130_fd_pr__res_xhigh_po_1p41 l=23.335
XR_VCM_TOP_P0 VPWR R_VCM_TOP_R0_N0 VGND sky130_fd_pr__res_xhigh_po_1p41 l=23.335
XR_VCM_TOP_P1 R_VCM_TOP_R0_N0 R_VCM_TOP_R0_N1 VGND sky130_fd_pr__res_xhigh_po_1p41 l=23.335
XR_VCM_TOP_P2 R_VCM_TOP_R0_N1 VCM_RAW VGND sky130_fd_pr__res_xhigh_po_1p41 l=23.335
XVCM_BUFFER_C_MILLER_P0 VCM_BUFFER__PRE VCM_BUFFER__COMP sky130_fd_pr__cap_mim_m3_1 w=28.68 l=28.68
XVCM_BUFFER_C_MILLER_P1 VCM_BUFFER__PRE VCM_BUFFER__COMP sky130_fd_pr__cap_mim_m3_1 w=28.68 l=28.68
XVCM_BUFFER_C_MILLER_P2 VCM_BUFFER__PRE VCM_BUFFER__COMP sky130_fd_pr__cap_mim_m3_1 w=28.68 l=28.68
XVCM_BUFFER_FIRST_N_INN0 VCM_BUFFER__FIRST__MIR VCM VCM_BUFFER__FIRST__TAIL VGND sky130_fd_pr__nfet_01v8 w=5 l=1 nf=1 m=1
XVCM_BUFFER_FIRST_N_INN1 VCM_BUFFER__FIRST__MIR VCM VCM_BUFFER__FIRST__TAIL VGND sky130_fd_pr__nfet_01v8 w=5 l=1 nf=1 m=1
XVCM_BUFFER_FIRST_N_INP0 VCM_BUFFER__PRE VCM_RAW VCM_BUFFER__FIRST__TAIL VGND sky130_fd_pr__nfet_01v8 w=5 l=1 nf=1 m=1
XVCM_BUFFER_FIRST_N_INP1 VCM_BUFFER__PRE VCM_RAW VCM_BUFFER__FIRST__TAIL VGND sky130_fd_pr__nfet_01v8 w=5 l=1 nf=1 m=1
XVCM_BUFFER_FIRST_N_TAIL VCM_BUFFER__FIRST__TAIL BIAS VGND VGND sky130_fd_pr__nfet_01v8 w=2 l=1 nf=1 m=1
XVCM_BUFFER_FIRST_P_DIODE VCM_BUFFER__FIRST__MIR VCM_BUFFER__FIRST__MIR VPWR VPWR sky130_fd_pr__pfet_01v8_hvt w=20 l=1 nf=1 m=1
XVCM_BUFFER_FIRST_P_MIRROR VCM_BUFFER__PRE VCM_BUFFER__FIRST__MIR VPWR VPWR sky130_fd_pr__pfet_01v8_hvt w=20 l=1 nf=1 m=1
XVCM_BUFFER_N_SECOND VCM BIAS VGND VGND sky130_fd_pr__nfet_01v8 w=2 l=1 nf=1 m=1
XVCM_BUFFER_P_SECOND VCM VCM_BUFFER__PRE VPWR VPWR sky130_fd_pr__pfet_01v8_hvt w=40 l=1 nf=1 m=1
XVCM_BUFFER_R_ZERO_P0 VCM_BUFFER__COMP VCM VGND sky130_fd_pr__res_xhigh_po_1p41 l=3.36
.ends soc_bias

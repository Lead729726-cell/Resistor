.subckt SOC_OTA_FIRST INP INN BIAS OUT VPWR VGND
XN_INN0 MIR INN TAIL VGND sky130_fd_pr__nfet_01v8 w=5 l=1 nf=1 m=1
XN_INN1 MIR INN TAIL VGND sky130_fd_pr__nfet_01v8 w=5 l=1 nf=1 m=1
XN_INP0 OUT INP TAIL VGND sky130_fd_pr__nfet_01v8 w=5 l=1 nf=1 m=1
XN_INP1 OUT INP TAIL VGND sky130_fd_pr__nfet_01v8 w=5 l=1 nf=1 m=1
XN_TAIL TAIL BIAS VGND VGND sky130_fd_pr__nfet_01v8 w=2 l=1 nf=1 m=1
XP_DIODE MIR MIR VPWR VPWR sky130_fd_pr__pfet_01v8_hvt w=20 l=1 nf=1 m=1
XP_MIRROR OUT MIR VPWR VPWR sky130_fd_pr__pfet_01v8_hvt w=20 l=1 nf=1 m=1
.ends SOC_OTA_FIRST
.subckt SOC_OTA INP INN BIAS OUT VPWR VGND
CC_MILLER PRE COMP 8e-12
XFIRST INP INN BIAS PRE VPWR VGND SOC_OTA_FIRST
XN_SECOND OUT BIAS VGND VGND sky130_fd_pr__nfet_01v8 w=2 l=1 nf=1 m=1
XP_SECOND OUT PRE VPWR VPWR sky130_fd_pr__pfet_01v8_hvt w=40 l=1 nf=1 m=1
RR_ZERO COMP OUT 5000
.ends SOC_OTA
.subckt SOC_BIAS BIAS VCM VPWR VGND
CC_VCM VCM_RAW VGND 2e-11
XN_DIODE BIAS BIAS VGND VGND sky130_fd_pr__nfet_01v8 w=2 l=1 nf=1 m=1
RR_BIAS VPWR BIAS 40000
RR_VCM_BOTTOM VCM_RAW VGND 100000
RR_VCM_TOP VPWR VCM_RAW 100000
XVCM_BUFFER VCM_RAW VCM BIAS VCM VPWR VGND SOC_OTA
.ends SOC_BIAS
.subckt DUET_GAIN VIN VCM BIAS OUT VPWR VGND
XAMP VIN FB BIAS OUT VPWR VGND SOC_OTA
RR_FEEDBACK OUT FB 300000
RR_GROUND FB VCM 100000
.ends DUET_GAIN
.subckt DUET_SLOW VIN BIAS OUT VPWR VGND
XBUFFER FILTERED OUT BIAS OUT VPWR VGND SOC_OTA
CC_POLE FILTERED VGND 1e-10
RR_POLE VIN FILTERED 318309.886184
.ends DUET_SLOW
.subckt DUET_FAST VIN BIAS OUT VPWR VGND
XBUFFER FILTERED OUT BIAS OUT VPWR VGND SOC_OTA
CC_POLE FILTERED VGND 1e-10
RR_POLE VIN FILTERED 15915.4943092
.ends DUET_FAST
.subckt sensor_afe_dualband VIN PRE_OUT SLOW FAST VCM BIAS VPWR VGND
XBIAS_SOURCE BIAS VCM VPWR VGND SOC_BIAS
XFAST_PATH PRE_OUT BIAS FAST VPWR VGND DUET_FAST
XPREAMP VIN VCM BIAS PRE_OUT VPWR VGND DUET_GAIN
XSLOW_PATH PRE_OUT BIAS SLOW VPWR VGND DUET_SLOW
.ends sensor_afe_dualband

.subckt INV A Y VPWR VGND
XMN Y A VGND VGND sky130_fd_pr__nfet_01v8 w=0.65 l=0.15 nf=1 m=1
XMP Y A VPWR VPWR sky130_fd_pr__pfet_01v8_hvt w=0.65 l=0.15 nf=1 m=1
.ends INV
.subckt NAND2 A0 A1 Y VPWR VGND
XMN0 Y A0 N1 VGND sky130_fd_pr__nfet_01v8 w=0.65 l=0.15 nf=1 m=1
XMN1 N1 A1 VGND VGND sky130_fd_pr__nfet_01v8 w=0.65 l=0.15 nf=1 m=1
XMP0 Y A0 VPWR VPWR sky130_fd_pr__pfet_01v8_hvt w=0.65 l=0.15 nf=1 m=1
XMP1 Y A1 VPWR VPWR sky130_fd_pr__pfet_01v8_hvt w=0.65 l=0.15 nf=1 m=1
.ends NAND2
.subckt AND2 A B Y VPWR VGND
XI1 N Y VPWR VGND INV
XN1 A B N VPWR VGND NAND2
.ends AND2
.subckt XOR2 A B Y VPWR VGND
XN1 A B N1 VPWR VGND NAND2
XN2 A N1 N2 VPWR VGND NAND2
XN3 B N1 N3 VPWR VGND NAND2
XN4 N2 N3 Y VPWR VGND NAND2
.ends XOR2
.subckt OR2 A B Y VPWR VGND
XG NA NB Y VPWR VGND NAND2
XIA A NA VPWR VGND INV
XIB B NB VPWR VGND INV
.ends OR2
.subckt BUF A Y VPWR VGND
XI0 A N VPWR VGND INV
XI1 N Y VPWR VGND INV
.ends BUF
.subckt c_alu a_0 a_1 a_2 a_3 a_4 a_5 a_6 a_7 a_8 a_9 a_10 a_11 a_12 a_13 a_14 a_15 a_16 a_17 a_18 a_19 a_20 a_21 a_22 a_23 a_24 a_25 a_26 a_27 a_28 a_29 a_30 a_31 b_0 b_1 b_2 b_3 b_4 b_5 b_6 b_7 b_8 b_9 b_10 b_11 b_12 b_13 b_14 b_15 b_16 b_17 b_18 b_19 b_20 b_21 b_22 b_23 b_24 b_25 b_26 b_27 b_28 b_29 b_30 b_31 sel_0 sel_1 sel_2 sel_3 sel_4 sel_5 sel_6 sel_7 sel_8 sel_9 sel_10 sel_11 sel_12 sel_13 sel_14 sel_15 sel_16 sel_17 sel_18 sel_19 sel_20 sel_21 sel_22 sel_23 sel_24 sel_25 sel_26 sel_27 sel_28 sel_29 sel_30 sel_31 result_0 result_1 result_2 result_3 result_4 result_5 result_6 result_7 result_8 result_9 result_10 result_11 result_12 result_13 result_14 result_15 result_16 result_17 result_18 result_19 result_20 result_21 result_22 result_23 result_24 result_25 result_26 result_27 result_28 result_29 result_30 result_31 VPWR VGND
XG0 b_2 N_102 VPWR VGND INV
XG1 b_3 N_103 VPWR VGND INV
XG10 N_107 N_110 N_111 VPWR VGND OR2
XG11 sel_12 sel_13 N_112 VPWR VGND OR2
XG12 sel_14 sel_15 N_113 VPWR VGND OR2
XG13 N_112 N_113 N_114 VPWR VGND OR2
XG14 sel_8 sel_9 N_115 VPWR VGND OR2
XG15 sel_10 sel_11 N_116 VPWR VGND OR2
XG16 N_115 N_116 N_117 VPWR VGND OR2
XG17 N_114 N_117 N_118 VPWR VGND OR2
XG18 N_111 N_118 N_119 VPWR VGND OR2
XG19 N_119 N_120 VPWR VGND INV
XG2 b_0 a_0 N_104 VPWR VGND AND2
XG20 sel_20 sel_21 N_121 VPWR VGND OR2
XG21 sel_22 sel_23 N_122 VPWR VGND OR2
XG22 N_121 N_122 N_123 VPWR VGND OR2
XG23 sel_18 sel_19 N_124 VPWR VGND OR2
XG24 sel_16 sel_17 N_125 VPWR VGND OR2
XG25 N_124 N_125 N_126 VPWR VGND OR2
XG26 N_123 N_126 N_127 VPWR VGND OR2
XG27 sel_28 sel_29 N_128 VPWR VGND OR2
XG28 sel_30 sel_31 N_129 VPWR VGND OR2
XG29 N_128 N_129 N_130 VPWR VGND OR2
XG3 b_0 a_0 N_98 VPWR VGND XOR2
XG30 sel_24 sel_25 N_131 VPWR VGND OR2
XG31 sel_26 sel_27 N_132 VPWR VGND OR2
XG32 N_131 N_132 N_133 VPWR VGND OR2
XG33 N_130 N_133 N_134 VPWR VGND OR2
XG34 N_127 N_134 N_135 VPWR VGND OR2
XG35 N_135 N_136 VPWR VGND INV
XG36 N_120 N_136 N_137 VPWR VGND AND2
XG37 N_119 N_135 N_138 VPWR VGND OR2
XG38 N_104 N_137 N_139 VPWR VGND AND2
XG39 b_1 a_1 N_140 VPWR VGND AND2
XG4 sel_4 sel_5 N_105 VPWR VGND OR2
XG40 b_1 a_1 N_141 VPWR VGND XOR2
XG41 N_139 N_141 N_99 VPWR VGND XOR2
XG42 N_104 N_141 N_142 VPWR VGND AND2
XG43 N_140 N_142 N_143 VPWR VGND OR2
XG44 N_143 N_144 VPWR VGND INV
XG45 N_137 N_143 N_145 VPWR VGND AND2
XG46 b_2 a_2 N_146 VPWR VGND AND2
XG47 N_146 N_147 VPWR VGND INV
XG48 b_2 a_2 N_148 VPWR VGND XOR2
XG49 N_102 a_2 N_149 VPWR VGND XOR2
XG5 sel_6 sel_7 N_106 VPWR VGND OR2
XG50 N_145 N_148 N_150 VPWR VGND OR2
XG51 N_144 N_149 N_151 VPWR VGND OR2
XG52 N_138 N_151 N_152 VPWR VGND OR2
XG53 N_150 N_152 N_100 VPWR VGND AND2
XG54 N_147 N_151 N_153 VPWR VGND AND2
XG55 N_138 N_153 N_154 VPWR VGND OR2
XG56 N_103 a_3 N_155 VPWR VGND XOR2
XG57 N_154 N_155 N_101 VPWR VGND XOR2
XG6 N_105 N_106 N_107 VPWR VGND OR2
XG7 sel_2 sel_3 N_108 VPWR VGND OR2
XG8 sel_0 sel_1 N_109 VPWR VGND OR2
XG9 N_108 N_109 N_110 VPWR VGND OR2
XOUT_result_0 N_98 result_0 VPWR VGND BUF
XOUT_result_1 N_99 result_1 VPWR VGND BUF
XOUT_result_10 VGND result_10 VPWR VGND BUF
XOUT_result_11 VGND result_11 VPWR VGND BUF
XOUT_result_12 VGND result_12 VPWR VGND BUF
XOUT_result_13 VGND result_13 VPWR VGND BUF
XOUT_result_14 VGND result_14 VPWR VGND BUF
XOUT_result_15 VGND result_15 VPWR VGND BUF
XOUT_result_16 VGND result_16 VPWR VGND BUF
XOUT_result_17 VGND result_17 VPWR VGND BUF
XOUT_result_18 VGND result_18 VPWR VGND BUF
XOUT_result_19 VGND result_19 VPWR VGND BUF
XOUT_result_2 N_100 result_2 VPWR VGND BUF
XOUT_result_20 VGND result_20 VPWR VGND BUF
XOUT_result_21 VGND result_21 VPWR VGND BUF
XOUT_result_22 VGND result_22 VPWR VGND BUF
XOUT_result_23 VGND result_23 VPWR VGND BUF
XOUT_result_24 VGND result_24 VPWR VGND BUF
XOUT_result_25 VGND result_25 VPWR VGND BUF
XOUT_result_26 VGND result_26 VPWR VGND BUF
XOUT_result_27 VGND result_27 VPWR VGND BUF
XOUT_result_28 VGND result_28 VPWR VGND BUF
XOUT_result_29 VGND result_29 VPWR VGND BUF
XOUT_result_3 N_101 result_3 VPWR VGND BUF
XOUT_result_30 VGND result_30 VPWR VGND BUF
XOUT_result_31 VGND result_31 VPWR VGND BUF
XOUT_result_4 VGND result_4 VPWR VGND BUF
XOUT_result_5 VGND result_5 VPWR VGND BUF
XOUT_result_6 VGND result_6 VPWR VGND BUF
XOUT_result_7 VGND result_7 VPWR VGND BUF
XOUT_result_8 VGND result_8 VPWR VGND BUF
XOUT_result_9 VGND result_9 VPWR VGND BUF
.ends c_alu

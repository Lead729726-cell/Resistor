.subckt logic_inv a y VPWR VGND ANALOG_OUT
VHDLDRV_a a VGND DC 0 PWL(0 0 5e-08 0 5.1e-08 1.8 1e-07 1.8 1.01e-07 0 1.5e-07 0 1.51e-07 1.8 2e-07 1.8 2.01e-07 0 2.5e-07 0 2.51e-07 1.8 3e-07 1.8 3.01e-07 0 3.5e-07 0 3.51e-07 1.8 4.5e-07 1.8)
RHDLDRV_RC_R y ANALOG_OUT 1000
VHDLDRV_VDD VPWR 0 1.8
XG0_MN N_3 a VGND VGND sky130_fd_pr__nfet_01v8 w=0.65 l=0.15 nf=1 m=1
XG0_MP N_3 a VPWR VPWR sky130_fd_pr__pfet_01v8_hvt w=0.65 l=0.15 nf=1 m=1
XOUT_y_0_I0_MN OUT_y_0__N N_3 VGND VGND sky130_fd_pr__nfet_01v8 w=0.65 l=0.15 nf=1 m=1
XOUT_y_0_I0_MP OUT_y_0__N N_3 VPWR VPWR sky130_fd_pr__pfet_01v8_hvt w=0.65 l=0.15 nf=1 m=1
XOUT_y_0_I1_MN y OUT_y_0__N VGND VGND sky130_fd_pr__nfet_01v8 w=0.65 l=0.15 nf=1 m=1
XOUT_y_0_I1_MP y OUT_y_0__N VPWR VPWR sky130_fd_pr__pfet_01v8_hvt w=0.65 l=0.15 nf=1 m=1
CHDLDRV_RC_C ANALOG_OUT VGND 1e-12
VHDLDRV_GND VGND 0 0
.ends logic_inv

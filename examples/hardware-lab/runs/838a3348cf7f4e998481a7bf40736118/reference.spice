.subckt NAND2 A0 A1 Y VPWR VGND
XMN0 Y A0 N1 VGND sky130_fd_pr__nfet_01v8 w=0.65 l=0.15 nf=1 m=1
XMN1 N1 A1 VGND VGND sky130_fd_pr__nfet_01v8 w=0.65 l=0.15 nf=1 m=1
XMP0 Y A0 VPWR VPWR sky130_fd_pr__pfet_01v8_hvt w=0.65 l=0.15 nf=1 m=1
XMP1 Y A1 VPWR VPWR sky130_fd_pr__pfet_01v8_hvt w=0.65 l=0.15 nf=1 m=1
.ends NAND2
.subckt INV A Y VPWR VGND
XMN Y A VGND VGND sky130_fd_pr__nfet_01v8 w=0.65 l=0.15 nf=1 m=1
XMP Y A VPWR VPWR sky130_fd_pr__pfet_01v8_hvt w=0.65 l=0.15 nf=1 m=1
.ends INV
.subckt AND2 A B Y VPWR VGND
XI1 N Y VPWR VGND INV
XN1 A B N VPWR VGND NAND2
.ends AND2
.subckt XOR2 A B Y VPWR VGND
XN1 A B N1 VPWR VGND NAND2
XN2 A N1 N2 VPWR VGND NAND2
XN3 B N1 N3 VPWR VGND NAND2
XN4 N2 N3 Y VPWR VGND NAND2
.ends XOR2
.subckt OR2 A B Y VPWR VGND
XG NA NB Y VPWR VGND NAND2
XIA A NA VPWR VGND INV
XIB B NB VPWR VGND INV
.ends OR2
.subckt BUF A Y VPWR VGND
XI0 A N VPWR VGND INV
XI1 N Y VPWR VGND INV
.ends BUF
.subckt vhdl_adder a_0 a_1 a_2 a_3 b_0 b_1 b_2 b_3 sum_0 sum_1 sum_2 sum_3 sum_4 VPWR VGND
XG0 b_3 a_3 N_15 VPWR VGND AND2
XG1 b_2 a_2 N_16 VPWR VGND AND2
XG10 b_3 a_3 N_25 VPWR VGND XOR2
XG11 N_24 N_25 N_26 VPWR VGND AND2
XG12 N_15 N_26 N_14 VPWR VGND OR2
XG13 N_18 N_19 N_11 VPWR VGND XOR2
XG14 N_21 N_22 N_12 VPWR VGND XOR2
XG15 N_24 N_25 N_13 VPWR VGND XOR2
XG16 b_0 a_0 N_10 VPWR VGND XOR2
XG2 b_1 a_1 N_17 VPWR VGND AND2
XG3 b_0 a_0 N_18 VPWR VGND AND2
XG4 b_1 a_1 N_19 VPWR VGND XOR2
XG5 N_18 N_19 N_20 VPWR VGND AND2
XG6 N_17 N_20 N_21 VPWR VGND OR2
XG7 b_2 a_2 N_22 VPWR VGND XOR2
XG8 N_21 N_22 N_23 VPWR VGND AND2
XG9 N_16 N_23 N_24 VPWR VGND OR2
XOUT_sum_0 N_10 sum_0 VPWR VGND BUF
XOUT_sum_1 N_11 sum_1 VPWR VGND BUF
XOUT_sum_2 N_12 sum_2 VPWR VGND BUF
XOUT_sum_3 N_13 sum_3 VPWR VGND BUF
XOUT_sum_4 N_14 sum_4 VPWR VGND BUF
.ends vhdl_adder

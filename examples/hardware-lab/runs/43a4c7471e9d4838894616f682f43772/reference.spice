.subckt INV A Y VPWR VGND
XMN Y A VGND VGND sky130_fd_pr__nfet_01v8 w=0.65 l=0.15 nf=1 m=1
XMP Y A VPWR VPWR sky130_fd_pr__pfet_01v8_hvt w=0.65 l=0.15 nf=1 m=1
.ends INV
.subckt BUF A Y VPWR VGND
XI0 A N VPWR VGND INV
XI1 N Y VPWR VGND INV
.ends BUF
.subckt logic_inv a y VPWR VGND
XG0 a N_3 VPWR VGND INV
XOUT_y_0 N_3 y VPWR VGND BUF
.ends logic_inv

.subckt INV A Y VPWR VGND
XMN Y A VGND VGND sky130_fd_pr__nfet_01v8 w=0.65 l=0.15 nf=1 m=1
XMP Y A VPWR VPWR sky130_fd_pr__pfet_01v8_hvt w=0.65 l=0.15 nf=1 m=1
.ends INV
.subckt NAND4 A0 A1 A2 A3 Y VPWR VGND
XMN0 Y A0 N1 VGND sky130_fd_pr__nfet_01v8 w=0.65 l=0.15 nf=1 m=1
XMN1 N1 A1 N2 VGND sky130_fd_pr__nfet_01v8 w=0.65 l=0.15 nf=1 m=1
XMN2 N2 A2 N3 VGND sky130_fd_pr__nfet_01v8 w=0.65 l=0.15 nf=1 m=1
XMN3 N3 A3 VGND VGND sky130_fd_pr__nfet_01v8 w=0.65 l=0.15 nf=1 m=1
XMP0 Y A0 VPWR VPWR sky130_fd_pr__pfet_01v8_hvt w=0.65 l=0.15 nf=1 m=1
XMP1 Y A1 VPWR VPWR sky130_fd_pr__pfet_01v8_hvt w=0.65 l=0.15 nf=1 m=1
XMP2 Y A2 VPWR VPWR sky130_fd_pr__pfet_01v8_hvt w=0.65 l=0.15 nf=1 m=1
XMP3 Y A3 VPWR VPWR sky130_fd_pr__pfet_01v8_hvt w=0.65 l=0.15 nf=1 m=1
.ends NAND4
.subckt NAND13 A0 A1 A2 A3 A4 A5 A6 A7 A8 A9 A10 A11 A12 Y VPWR VGND
XMN0 Y A0 N1 VGND sky130_fd_pr__nfet_01v8 w=0.65 l=0.15 nf=1 m=1
XMN1 N1 A1 N2 VGND sky130_fd_pr__nfet_01v8 w=0.65 l=0.15 nf=1 m=1
XMN10 N10 A10 N11 VGND sky130_fd_pr__nfet_01v8 w=0.65 l=0.15 nf=1 m=1
XMN11 N11 A11 N12 VGND sky130_fd_pr__nfet_01v8 w=0.65 l=0.15 nf=1 m=1
XMN12 N12 A12 VGND VGND sky130_fd_pr__nfet_01v8 w=0.65 l=0.15 nf=1 m=1
XMN2 N2 A2 N3 VGND sky130_fd_pr__nfet_01v8 w=0.65 l=0.15 nf=1 m=1
XMN3 N3 A3 N4 VGND sky130_fd_pr__nfet_01v8 w=0.65 l=0.15 nf=1 m=1
XMN4 N4 A4 N5 VGND sky130_fd_pr__nfet_01v8 w=0.65 l=0.15 nf=1 m=1
XMN5 N5 A5 N6 VGND sky130_fd_pr__nfet_01v8 w=0.65 l=0.15 nf=1 m=1
XMN6 N6 A6 N7 VGND sky130_fd_pr__nfet_01v8 w=0.65 l=0.15 nf=1 m=1
XMN7 N7 A7 N8 VGND sky130_fd_pr__nfet_01v8 w=0.65 l=0.15 nf=1 m=1
XMN8 N8 A8 N9 VGND sky130_fd_pr__nfet_01v8 w=0.65 l=0.15 nf=1 m=1
XMN9 N9 A9 N10 VGND sky130_fd_pr__nfet_01v8 w=0.65 l=0.15 nf=1 m=1
XMP0 Y A0 VPWR VPWR sky130_fd_pr__pfet_01v8_hvt w=0.65 l=0.15 nf=1 m=1
XMP1 Y A1 VPWR VPWR sky130_fd_pr__pfet_01v8_hvt w=0.65 l=0.15 nf=1 m=1
XMP10 Y A10 VPWR VPWR sky130_fd_pr__pfet_01v8_hvt w=0.65 l=0.15 nf=1 m=1
XMP11 Y A11 VPWR VPWR sky130_fd_pr__pfet_01v8_hvt w=0.65 l=0.15 nf=1 m=1
XMP12 Y A12 VPWR VPWR sky130_fd_pr__pfet_01v8_hvt w=0.65 l=0.15 nf=1 m=1
XMP2 Y A2 VPWR VPWR sky130_fd_pr__pfet_01v8_hvt w=0.65 l=0.15 nf=1 m=1
XMP3 Y A3 VPWR VPWR sky130_fd_pr__pfet_01v8_hvt w=0.65 l=0.15 nf=1 m=1
XMP4 Y A4 VPWR VPWR sky130_fd_pr__pfet_01v8_hvt w=0.65 l=0.15 nf=1 m=1
XMP5 Y A5 VPWR VPWR sky130_fd_pr__pfet_01v8_hvt w=0.65 l=0.15 nf=1 m=1
XMP6 Y A6 VPWR VPWR sky130_fd_pr__pfet_01v8_hvt w=0.65 l=0.15 nf=1 m=1
XMP7 Y A7 VPWR VPWR sky130_fd_pr__pfet_01v8_hvt w=0.65 l=0.15 nf=1 m=1
XMP8 Y A8 VPWR VPWR sky130_fd_pr__pfet_01v8_hvt w=0.65 l=0.15 nf=1 m=1
XMP9 Y A9 VPWR VPWR sky130_fd_pr__pfet_01v8_hvt w=0.65 l=0.15 nf=1 m=1
.ends NAND13
.subckt NAND9 A0 A1 A2 A3 A4 A5 A6 A7 A8 Y VPWR VGND
XMN0 Y A0 N1 VGND sky130_fd_pr__nfet_01v8 w=0.65 l=0.15 nf=1 m=1
XMN1 N1 A1 N2 VGND sky130_fd_pr__nfet_01v8 w=0.65 l=0.15 nf=1 m=1
XMN2 N2 A2 N3 VGND sky130_fd_pr__nfet_01v8 w=0.65 l=0.15 nf=1 m=1
XMN3 N3 A3 N4 VGND sky130_fd_pr__nfet_01v8 w=0.65 l=0.15 nf=1 m=1
XMN4 N4 A4 N5 VGND sky130_fd_pr__nfet_01v8 w=0.65 l=0.15 nf=1 m=1
XMN5 N5 A5 N6 VGND sky130_fd_pr__nfet_01v8 w=0.65 l=0.15 nf=1 m=1
XMN6 N6 A6 N7 VGND sky130_fd_pr__nfet_01v8 w=0.65 l=0.15 nf=1 m=1
XMN7 N7 A7 N8 VGND sky130_fd_pr__nfet_01v8 w=0.65 l=0.15 nf=1 m=1
XMN8 N8 A8 VGND VGND sky130_fd_pr__nfet_01v8 w=0.65 l=0.15 nf=1 m=1
XMP0 Y A0 VPWR VPWR sky130_fd_pr__pfet_01v8_hvt w=0.65 l=0.15 nf=1 m=1
XMP1 Y A1 VPWR VPWR sky130_fd_pr__pfet_01v8_hvt w=0.65 l=0.15 nf=1 m=1
XMP2 Y A2 VPWR VPWR sky130_fd_pr__pfet_01v8_hvt w=0.65 l=0.15 nf=1 m=1
XMP3 Y A3 VPWR VPWR sky130_fd_pr__pfet_01v8_hvt w=0.65 l=0.15 nf=1 m=1
XMP4 Y A4 VPWR VPWR sky130_fd_pr__pfet_01v8_hvt w=0.65 l=0.15 nf=1 m=1
XMP5 Y A5 VPWR VPWR sky130_fd_pr__pfet_01v8_hvt w=0.65 l=0.15 nf=1 m=1
XMP6 Y A6 VPWR VPWR sky130_fd_pr__pfet_01v8_hvt w=0.65 l=0.15 nf=1 m=1
XMP7 Y A7 VPWR VPWR sky130_fd_pr__pfet_01v8_hvt w=0.65 l=0.15 nf=1 m=1
XMP8 Y A8 VPWR VPWR sky130_fd_pr__pfet_01v8_hvt w=0.65 l=0.15 nf=1 m=1
.ends NAND9
.subckt NAND8 A0 A1 A2 A3 A4 A5 A6 A7 Y VPWR VGND
XMN0 Y A0 N1 VGND sky130_fd_pr__nfet_01v8 w=0.65 l=0.15 nf=1 m=1
XMN1 N1 A1 N2 VGND sky130_fd_pr__nfet_01v8 w=0.65 l=0.15 nf=1 m=1
XMN2 N2 A2 N3 VGND sky130_fd_pr__nfet_01v8 w=0.65 l=0.15 nf=1 m=1
XMN3 N3 A3 N4 VGND sky130_fd_pr__nfet_01v8 w=0.65 l=0.15 nf=1 m=1
XMN4 N4 A4 N5 VGND sky130_fd_pr__nfet_01v8 w=0.65 l=0.15 nf=1 m=1
XMN5 N5 A5 N6 VGND sky130_fd_pr__nfet_01v8 w=0.65 l=0.15 nf=1 m=1
XMN6 N6 A6 N7 VGND sky130_fd_pr__nfet_01v8 w=0.65 l=0.15 nf=1 m=1
XMN7 N7 A7 VGND VGND sky130_fd_pr__nfet_01v8 w=0.65 l=0.15 nf=1 m=1
XMP0 Y A0 VPWR VPWR sky130_fd_pr__pfet_01v8_hvt w=0.65 l=0.15 nf=1 m=1
XMP1 Y A1 VPWR VPWR sky130_fd_pr__pfet_01v8_hvt w=0.65 l=0.15 nf=1 m=1
XMP2 Y A2 VPWR VPWR sky130_fd_pr__pfet_01v8_hvt w=0.65 l=0.15 nf=1 m=1
XMP3 Y A3 VPWR VPWR sky130_fd_pr__pfet_01v8_hvt w=0.65 l=0.15 nf=1 m=1
XMP4 Y A4 VPWR VPWR sky130_fd_pr__pfet_01v8_hvt w=0.65 l=0.15 nf=1 m=1
XMP5 Y A5 VPWR VPWR sky130_fd_pr__pfet_01v8_hvt w=0.65 l=0.15 nf=1 m=1
XMP6 Y A6 VPWR VPWR sky130_fd_pr__pfet_01v8_hvt w=0.65 l=0.15 nf=1 m=1
XMP7 Y A7 VPWR VPWR sky130_fd_pr__pfet_01v8_hvt w=0.65 l=0.15 nf=1 m=1
.ends NAND8
.subckt NAND10 A0 A1 A2 A3 A4 A5 A6 A7 A8 A9 Y VPWR VGND
XMN0 Y A0 N1 VGND sky130_fd_pr__nfet_01v8 w=0.65 l=0.15 nf=1 m=1
XMN1 N1 A1 N2 VGND sky130_fd_pr__nfet_01v8 w=0.65 l=0.15 nf=1 m=1
XMN2 N2 A2 N3 VGND sky130_fd_pr__nfet_01v8 w=0.65 l=0.15 nf=1 m=1
XMN3 N3 A3 N4 VGND sky130_fd_pr__nfet_01v8 w=0.65 l=0.15 nf=1 m=1
XMN4 N4 A4 N5 VGND sky130_fd_pr__nfet_01v8 w=0.65 l=0.15 nf=1 m=1
XMN5 N5 A5 N6 VGND sky130_fd_pr__nfet_01v8 w=0.65 l=0.15 nf=1 m=1
XMN6 N6 A6 N7 VGND sky130_fd_pr__nfet_01v8 w=0.65 l=0.15 nf=1 m=1
XMN7 N7 A7 N8 VGND sky130_fd_pr__nfet_01v8 w=0.65 l=0.15 nf=1 m=1
XMN8 N8 A8 N9 VGND sky130_fd_pr__nfet_01v8 w=0.65 l=0.15 nf=1 m=1
XMN9 N9 A9 VGND VGND sky130_fd_pr__nfet_01v8 w=0.65 l=0.15 nf=1 m=1
XMP0 Y A0 VPWR VPWR sky130_fd_pr__pfet_01v8_hvt w=0.65 l=0.15 nf=1 m=1
XMP1 Y A1 VPWR VPWR sky130_fd_pr__pfet_01v8_hvt w=0.65 l=0.15 nf=1 m=1
XMP2 Y A2 VPWR VPWR sky130_fd_pr__pfet_01v8_hvt w=0.65 l=0.15 nf=1 m=1
XMP3 Y A3 VPWR VPWR sky130_fd_pr__pfet_01v8_hvt w=0.65 l=0.15 nf=1 m=1
XMP4 Y A4 VPWR VPWR sky130_fd_pr__pfet_01v8_hvt w=0.65 l=0.15 nf=1 m=1
XMP5 Y A5 VPWR VPWR sky130_fd_pr__pfet_01v8_hvt w=0.65 l=0.15 nf=1 m=1
XMP6 Y A6 VPWR VPWR sky130_fd_pr__pfet_01v8_hvt w=0.65 l=0.15 nf=1 m=1
XMP7 Y A7 VPWR VPWR sky130_fd_pr__pfet_01v8_hvt w=0.65 l=0.15 nf=1 m=1
XMP8 Y A8 VPWR VPWR sky130_fd_pr__pfet_01v8_hvt w=0.65 l=0.15 nf=1 m=1
XMP9 Y A9 VPWR VPWR sky130_fd_pr__pfet_01v8_hvt w=0.65 l=0.15 nf=1 m=1
.ends NAND10
.subckt NAND7 A0 A1 A2 A3 A4 A5 A6 Y VPWR VGND
XMN0 Y A0 N1 VGND sky130_fd_pr__nfet_01v8 w=0.65 l=0.15 nf=1 m=1
XMN1 N1 A1 N2 VGND sky130_fd_pr__nfet_01v8 w=0.65 l=0.15 nf=1 m=1
XMN2 N2 A2 N3 VGND sky130_fd_pr__nfet_01v8 w=0.65 l=0.15 nf=1 m=1
XMN3 N3 A3 N4 VGND sky130_fd_pr__nfet_01v8 w=0.65 l=0.15 nf=1 m=1
XMN4 N4 A4 N5 VGND sky130_fd_pr__nfet_01v8 w=0.65 l=0.15 nf=1 m=1
XMN5 N5 A5 N6 VGND sky130_fd_pr__nfet_01v8 w=0.65 l=0.15 nf=1 m=1
XMN6 N6 A6 VGND VGND sky130_fd_pr__nfet_01v8 w=0.65 l=0.15 nf=1 m=1
XMP0 Y A0 VPWR VPWR sky130_fd_pr__pfet_01v8_hvt w=0.65 l=0.15 nf=1 m=1
XMP1 Y A1 VPWR VPWR sky130_fd_pr__pfet_01v8_hvt w=0.65 l=0.15 nf=1 m=1
XMP2 Y A2 VPWR VPWR sky130_fd_pr__pfet_01v8_hvt w=0.65 l=0.15 nf=1 m=1
XMP3 Y A3 VPWR VPWR sky130_fd_pr__pfet_01v8_hvt w=0.65 l=0.15 nf=1 m=1
XMP4 Y A4 VPWR VPWR sky130_fd_pr__pfet_01v8_hvt w=0.65 l=0.15 nf=1 m=1
XMP5 Y A5 VPWR VPWR sky130_fd_pr__pfet_01v8_hvt w=0.65 l=0.15 nf=1 m=1
XMP6 Y A6 VPWR VPWR sky130_fd_pr__pfet_01v8_hvt w=0.65 l=0.15 nf=1 m=1
.ends NAND7
.subckt NAND6 A0 A1 A2 A3 A4 A5 Y VPWR VGND
XMN0 Y A0 N1 VGND sky130_fd_pr__nfet_01v8 w=0.65 l=0.15 nf=1 m=1
XMN1 N1 A1 N2 VGND sky130_fd_pr__nfet_01v8 w=0.65 l=0.15 nf=1 m=1
XMN2 N2 A2 N3 VGND sky130_fd_pr__nfet_01v8 w=0.65 l=0.15 nf=1 m=1
XMN3 N3 A3 N4 VGND sky130_fd_pr__nfet_01v8 w=0.65 l=0.15 nf=1 m=1
XMN4 N4 A4 N5 VGND sky130_fd_pr__nfet_01v8 w=0.65 l=0.15 nf=1 m=1
XMN5 N5 A5 VGND VGND sky130_fd_pr__nfet_01v8 w=0.65 l=0.15 nf=1 m=1
XMP0 Y A0 VPWR VPWR sky130_fd_pr__pfet_01v8_hvt w=0.65 l=0.15 nf=1 m=1
XMP1 Y A1 VPWR VPWR sky130_fd_pr__pfet_01v8_hvt w=0.65 l=0.15 nf=1 m=1
XMP2 Y A2 VPWR VPWR sky130_fd_pr__pfet_01v8_hvt w=0.65 l=0.15 nf=1 m=1
XMP3 Y A3 VPWR VPWR sky130_fd_pr__pfet_01v8_hvt w=0.65 l=0.15 nf=1 m=1
XMP4 Y A4 VPWR VPWR sky130_fd_pr__pfet_01v8_hvt w=0.65 l=0.15 nf=1 m=1
XMP5 Y A5 VPWR VPWR sky130_fd_pr__pfet_01v8_hvt w=0.65 l=0.15 nf=1 m=1
.ends NAND6
.subckt ROM16 P0 P1 P2 P3 I0 I1 I2 I3 I4 I5 I6 I7 I8 I9 I10 I11 I12 I13 I14 I15 O0 O1 VPWR VGND
XDEC0 PB0 PB1 PB2 PB3 D0 VPWR VGND NAND4
XDEC1 P0 PB1 PB2 PB3 D1 VPWR VGND NAND4
XDEC10 PB0 P1 PB2 P3 D10 VPWR VGND NAND4
XDEC11 P0 P1 PB2 P3 D11 VPWR VGND NAND4
XDEC12 PB0 PB1 P2 P3 D12 VPWR VGND NAND4
XDEC13 P0 PB1 P2 P3 D13 VPWR VGND NAND4
XDEC14 PB0 P1 P2 P3 D14 VPWR VGND NAND4
XDEC15 P0 P1 P2 P3 D15 VPWR VGND NAND4
XDEC2 PB0 P1 PB2 PB3 D2 VPWR VGND NAND4
XDEC3 P0 P1 PB2 PB3 D3 VPWR VGND NAND4
XDEC4 PB0 PB1 P2 PB3 D4 VPWR VGND NAND4
XDEC5 P0 PB1 P2 PB3 D5 VPWR VGND NAND4
XDEC6 PB0 P1 P2 PB3 D6 VPWR VGND NAND4
XDEC7 P0 P1 P2 PB3 D7 VPWR VGND NAND4
XDEC8 PB0 PB1 PB2 P3 D8 VPWR VGND NAND4
XDEC9 P0 PB1 PB2 P3 D9 VPWR VGND NAND4
XIP0 P0 PB0 VPWR VGND INV
XIP1 P1 PB1 VPWR VGND INV
XIP2 P2 PB2 VPWR VGND INV
XIP3 P3 PB3 VPWR VGND INV
XROM0 D1 D2 D3 D4 D5 D6 D7 D8 D9 D10 D12 D13 D14 I0 VPWR VGND NAND13
XROM1 D2 D3 D5 D7 D9 D11 D12 D13 D14 I1 VPWR VGND NAND9
XROM10 D2 D3 D5 D7 D11 D12 D13 D14 I10 VPWR VGND NAND8
XROM11 D2 D3 D5 D7 D10 D12 D13 I11 VPWR VGND NAND7
XROM12 D0 D1 D2 D3 D5 D7 D11 D12 D14 I12 VPWR VGND NAND9
XROM13 D3 D5 D7 D10 D12 D14 I13 VPWR VGND NAND6
XROM14 D2 D3 D5 D7 D11 D12 D14 I14 VPWR VGND NAND7
XROM15 D2 D3 D4 D5 D10 D12 D14 D15 I15 VPWR VGND NAND8
XROM16 D1 D2 D3 D6 D7 D8 D10 D12 D14 O0 VPWR VGND NAND9
XROM17 D3 D4 D9 D10 D12 D13 O1 VPWR VGND NAND6
XROM2 D0 D3 D5 D7 D9 D10 D12 D13 I2 VPWR VGND NAND8
XROM3 D2 D3 D5 D7 D9 D11 D12 D13 D14 I3 VPWR VGND NAND9
XROM4 D0 D1 D2 D3 D5 D7 D9 D10 D12 D14 I4 VPWR VGND NAND10
XROM5 D0 D2 D3 D5 D7 D9 D11 D12 D14 I5 VPWR VGND NAND9
XROM6 D3 D5 D7 D9 D10 D12 D14 I6 VPWR VGND NAND7
XROM7 D2 D3 D5 D7 D9 D11 D12 D14 I7 VPWR VGND NAND8
XROM8 D1 D3 D5 D7 D11 D12 D13 D14 I8 VPWR VGND NAND8
XROM9 D0 D3 D5 D7 D10 D12 D13 I9 VPWR VGND NAND7
.ends ROM16
.subckt NAND2 A0 A1 Y VPWR VGND
XMN0 Y A0 N1 VGND sky130_fd_pr__nfet_01v8 w=0.65 l=0.15 nf=1 m=1
XMN1 N1 A1 VGND VGND sky130_fd_pr__nfet_01v8 w=0.65 l=0.15 nf=1 m=1
XMP0 Y A0 VPWR VPWR sky130_fd_pr__pfet_01v8_hvt w=0.65 l=0.15 nf=1 m=1
XMP1 Y A1 VPWR VPWR sky130_fd_pr__pfet_01v8_hvt w=0.65 l=0.15 nf=1 m=1
.ends NAND2
.subckt FA A B CIN SUM COUT VPWR VGND
XN1 A B N1 VPWR VGND NAND2
XN2 A N1 N2 VPWR VGND NAND2
XN3 B N1 N3 VPWR VGND NAND2
XN4 N2 N3 P VPWR VGND NAND2
XN5 P CIN N5 VPWR VGND NAND2
XN6 P N5 N6 VPWR VGND NAND2
XN7 CIN N5 N7 VPWR VGND NAND2
XN8 N6 N7 SUM VPWR VGND NAND2
XN9 N1 N5 COUT VPWR VGND NAND2
.ends FA
.subckt ADD16 A0 A1 A2 A3 A4 A5 A6 A7 A8 A9 A10 A11 A12 A13 A14 A15 B0 B1 B2 B3 B4 B5 B6 B7 B8 B9 B10 B11 B12 B13 B14 B15 CIN S0 S1 S2 S3 S4 S5 S6 S7 S8 S9 S10 S11 S12 S13 S14 S15 COUT VPWR VGND
XBIT0 A0 B0 CIN S0 C1 VPWR VGND FA
XBIT1 A1 B1 C1 S1 C2 VPWR VGND FA
XBIT10 A10 B10 C10 S10 C11 VPWR VGND FA
XBIT11 A11 B11 C11 S11 C12 VPWR VGND FA
XBIT12 A12 B12 C12 S12 C13 VPWR VGND FA
XBIT13 A13 B13 C13 S13 C14 VPWR VGND FA
XBIT14 A14 B14 C14 S14 C15 VPWR VGND FA
XBIT15 A15 B15 C15 S15 COUT VPWR VGND FA
XBIT2 A2 B2 C2 S2 C3 VPWR VGND FA
XBIT3 A3 B3 C3 S3 C4 VPWR VGND FA
XBIT4 A4 B4 C4 S4 C5 VPWR VGND FA
XBIT5 A5 B5 C5 S5 C6 VPWR VGND FA
XBIT6 A6 B6 C6 S6 C7 VPWR VGND FA
XBIT7 A7 B7 C7 S7 C8 VPWR VGND FA
XBIT8 A8 B8 C8 S8 C9 VPWR VGND FA
XBIT9 A9 B9 C9 S9 C10 VPWR VGND FA
.ends ADD16
.subckt AND2 A B Y VPWR VGND
XI1 N Y VPWR VGND INV
XN1 A B N VPWR VGND NAND2
.ends AND2
.subckt XOR2 A B Y VPWR VGND
XN1 A B N1 VPWR VGND NAND2
XN2 A N1 N2 VPWR VGND NAND2
XN3 B N1 N3 VPWR VGND NAND2
XN4 N2 N3 Y VPWR VGND NAND2
.ends XOR2
.subckt MUX2 A B S Y VPWR VGND
XIS S SB VPWR VGND INV
XMNA Y SB A VGND sky130_fd_pr__nfet_01v8 w=0.65 l=0.15 nf=1 m=1
XMNB Y S B VGND sky130_fd_pr__nfet_01v8 w=0.65 l=0.15 nf=1 m=1
XMPA Y S A VPWR sky130_fd_pr__pfet_01v8_hvt w=0.65 l=0.15 nf=1 m=1
XMPB Y SB B VPWR sky130_fd_pr__pfet_01v8_hvt w=0.65 l=0.15 nf=1 m=1
.ends MUX2
.subckt DFF D CLK Q VPWR VGND
XICLK CLK CLKB VPWR VGND INV
XM1 M MB VPWR VGND INV
XM2 MB MF VPWR VGND INV
XMNIN M CLKB D VGND sky130_fd_pr__nfet_01v8 w=0.65 l=0.15 nf=1 m=1
XMNMF M CLK MF VGND sky130_fd_pr__nfet_01v8 w=0.65 l=0.15 nf=1 m=1
XMNOUT T CLK MF VGND sky130_fd_pr__nfet_01v8 w=0.65 l=0.15 nf=1 m=1
XMNSF T CLKB Q VGND sky130_fd_pr__nfet_01v8 w=0.65 l=0.15 nf=1 m=1
XMPIN M CLK D VPWR sky130_fd_pr__pfet_01v8_hvt w=0.65 l=0.15 nf=1 m=1
XMPMF M CLKB MF VPWR sky130_fd_pr__pfet_01v8_hvt w=0.65 l=0.15 nf=1 m=1
XMPOUT T CLKB MF VPWR sky130_fd_pr__pfet_01v8_hvt w=0.65 l=0.15 nf=1 m=1
XMPSF T CLK Q VPWR sky130_fd_pr__pfet_01v8_hvt w=0.65 l=0.15 nf=1 m=1
XS1 T TB VPWR VGND INV
XS2 TB Q VPWR VGND INV
.ends DFF
.subckt NAND3 A0 A1 A2 Y VPWR VGND
XMN0 Y A0 N1 VGND sky130_fd_pr__nfet_01v8 w=0.65 l=0.15 nf=1 m=1
XMN1 N1 A1 N2 VGND sky130_fd_pr__nfet_01v8 w=0.65 l=0.15 nf=1 m=1
XMN2 N2 A2 VGND VGND sky130_fd_pr__nfet_01v8 w=0.65 l=0.15 nf=1 m=1
XMP0 Y A0 VPWR VPWR sky130_fd_pr__pfet_01v8_hvt w=0.65 l=0.15 nf=1 m=1
XMP1 Y A1 VPWR VPWR sky130_fd_pr__pfet_01v8_hvt w=0.65 l=0.15 nf=1 m=1
XMP2 Y A2 VPWR VPWR sky130_fd_pr__pfet_01v8_hvt w=0.65 l=0.15 nf=1 m=1
.ends NAND3
.subckt cpu16 CLK RESET ACC0 ACC1 ACC2 ACC3 ACC4 ACC5 ACC6 ACC7 ACC8 ACC9 ACC10 ACC11 ACC12 ACC13 ACC14 ACC15 PC0 PC1 PC2 PC3 CARRY ZERO VPWR VGND
XACC_REG0 NEXT_ACC0 CLK ACC0 VPWR VGND DFF
XACC_REG1 NEXT_ACC1 CLK ACC1 VPWR VGND DFF
XACC_REG10 NEXT_ACC10 CLK ACC10 VPWR VGND DFF
XACC_REG11 NEXT_ACC11 CLK ACC11 VPWR VGND DFF
XACC_REG12 NEXT_ACC12 CLK ACC12 VPWR VGND DFF
XACC_REG13 NEXT_ACC13 CLK ACC13 VPWR VGND DFF
XACC_REG14 NEXT_ACC14 CLK ACC14 VPWR VGND DFF
XACC_REG15 NEXT_ACC15 CLK ACC15 VPWR VGND DFF
XACC_REG2 NEXT_ACC2 CLK ACC2 VPWR VGND DFF
XACC_REG3 NEXT_ACC3 CLK ACC3 VPWR VGND DFF
XACC_REG4 NEXT_ACC4 CLK ACC4 VPWR VGND DFF
XACC_REG5 NEXT_ACC5 CLK ACC5 VPWR VGND DFF
XACC_REG6 NEXT_ACC6 CLK ACC6 VPWR VGND DFF
XACC_REG7 NEXT_ACC7 CLK ACC7 VPWR VGND DFF
XACC_REG8 NEXT_ACC8 CLK ACC8 VPWR VGND DFF
XACC_REG9 NEXT_ACC9 CLK ACC9 VPWR VGND DFF
XADD_ENABLE OP0 OP1B IS_ADD VPWR VGND AND2
XALU_ADD ACC0 ACC1 ACC2 ACC3 ACC4 ACC5 ACC6 ACC7 ACC8 ACC9 ACC10 ACC11 ACC12 ACC13 ACC14 ACC15 IMM0 IMM1 IMM2 IMM3 IMM4 IMM5 IMM6 IMM7 IMM8 IMM9 IMM10 IMM11 IMM12 IMM13 IMM14 IMM15 VGND ADD0 ADD1 ADD2 ADD3 ADD4 ADD5 ADD6 ADD7 ADD8 ADD9 ADD10 ADD11 ADD12 ADD13 ADD14 ADD15 ADD_CARRY VPWR VGND ADD16
XALU_AND0 ACC0 IMM0 AND0 VPWR VGND AND2
XALU_AND1 ACC1 IMM1 AND1 VPWR VGND AND2
XALU_AND10 ACC10 IMM10 AND10 VPWR VGND AND2
XALU_AND11 ACC11 IMM11 AND11 VPWR VGND AND2
XALU_AND12 ACC12 IMM12 AND12 VPWR VGND AND2
XALU_AND13 ACC13 IMM13 AND13 VPWR VGND AND2
XALU_AND14 ACC14 IMM14 AND14 VPWR VGND AND2
XALU_AND15 ACC15 IMM15 AND15 VPWR VGND AND2
XALU_AND2 ACC2 IMM2 AND2 VPWR VGND AND2
XALU_AND3 ACC3 IMM3 AND3 VPWR VGND AND2
XALU_AND4 ACC4 IMM4 AND4 VPWR VGND AND2
XALU_AND5 ACC5 IMM5 AND5 VPWR VGND AND2
XALU_AND6 ACC6 IMM6 AND6 VPWR VGND AND2
XALU_AND7 ACC7 IMM7 AND7 VPWR VGND AND2
XALU_AND8 ACC8 IMM8 AND8 VPWR VGND AND2
XALU_AND9 ACC9 IMM9 AND9 VPWR VGND AND2
XALU_XOR0 ACC0 IMM0 XOR0 VPWR VGND XOR2
XALU_XOR1 ACC1 IMM1 XOR1 VPWR VGND XOR2
XALU_XOR10 ACC10 IMM10 XOR10 VPWR VGND XOR2
XALU_XOR11 ACC11 IMM11 XOR11 VPWR VGND XOR2
XALU_XOR12 ACC12 IMM12 XOR12 VPWR VGND XOR2
XALU_XOR13 ACC13 IMM13 XOR13 VPWR VGND XOR2
XALU_XOR14 ACC14 IMM14 XOR14 VPWR VGND XOR2
XALU_XOR15 ACC15 IMM15 XOR15 VPWR VGND XOR2
XALU_XOR2 ACC2 IMM2 XOR2 VPWR VGND XOR2
XALU_XOR3 ACC3 IMM3 XOR3 VPWR VGND XOR2
XALU_XOR4 ACC4 IMM4 XOR4 VPWR VGND XOR2
XALU_XOR5 ACC5 IMM5 XOR5 VPWR VGND XOR2
XALU_XOR6 ACC6 IMM6 XOR6 VPWR VGND XOR2
XALU_XOR7 ACC7 IMM7 XOR7 VPWR VGND XOR2
XALU_XOR8 ACC8 IMM8 XOR8 VPWR VGND XOR2
XALU_XOR9 ACC9 IMM9 XOR9 VPWR VGND XOR2
XCARRY_REG CD CLK CARRY VPWR VGND DFF
XCARRY_RESET CV RESETB CD VPWR VGND AND2
XCARRY_VALUE ADD_CARRY IS_ADD CV VPWR VGND AND2
XHIGH0 AND0 XOR0 OP0 H0 VPWR VGND MUX2
XHIGH1 AND1 XOR1 OP0 H1 VPWR VGND MUX2
XHIGH10 AND10 XOR10 OP0 H10 VPWR VGND MUX2
XHIGH11 AND11 XOR11 OP0 H11 VPWR VGND MUX2
XHIGH12 AND12 XOR12 OP0 H12 VPWR VGND MUX2
XHIGH13 AND13 XOR13 OP0 H13 VPWR VGND MUX2
XHIGH14 AND14 XOR14 OP0 H14 VPWR VGND MUX2
XHIGH15 AND15 XOR15 OP0 H15 VPWR VGND MUX2
XHIGH2 AND2 XOR2 OP0 H2 VPWR VGND MUX2
XHIGH3 AND3 XOR3 OP0 H3 VPWR VGND MUX2
XHIGH4 AND4 XOR4 OP0 H4 VPWR VGND MUX2
XHIGH5 AND5 XOR5 OP0 H5 VPWR VGND MUX2
XHIGH6 AND6 XOR6 OP0 H6 VPWR VGND MUX2
XHIGH7 AND7 XOR7 OP0 H7 VPWR VGND MUX2
XHIGH8 AND8 XOR8 OP0 H8 VPWR VGND MUX2
XHIGH9 AND9 XOR9 OP0 H9 VPWR VGND MUX2
XIOP1 OP1 OP1B VPWR VGND INV
XIR RESET RESETB VPWR VGND INV
XLOW0 IMM0 ADD0 OP0 L0 VPWR VGND MUX2
XLOW1 IMM1 ADD1 OP0 L1 VPWR VGND MUX2
XLOW10 IMM10 ADD10 OP0 L10 VPWR VGND MUX2
XLOW11 IMM11 ADD11 OP0 L11 VPWR VGND MUX2
XLOW12 IMM12 ADD12 OP0 L12 VPWR VGND MUX2
XLOW13 IMM13 ADD13 OP0 L13 VPWR VGND MUX2
XLOW14 IMM14 ADD14 OP0 L14 VPWR VGND MUX2
XLOW15 IMM15 ADD15 OP0 L15 VPWR VGND MUX2
XLOW2 IMM2 ADD2 OP0 L2 VPWR VGND MUX2
XLOW3 IMM3 ADD3 OP0 L3 VPWR VGND MUX2
XLOW4 IMM4 ADD4 OP0 L4 VPWR VGND MUX2
XLOW5 IMM5 ADD5 OP0 L5 VPWR VGND MUX2
XLOW6 IMM6 ADD6 OP0 L6 VPWR VGND MUX2
XLOW7 IMM7 ADD7 OP0 L7 VPWR VGND MUX2
XLOW8 IMM8 ADD8 OP0 L8 VPWR VGND MUX2
XLOW9 IMM9 ADD9 OP0 L9 VPWR VGND MUX2
XPCC2 PC0 PC1 PC_CB2 VPWR VGND NAND2
XPCC3 PC0 PC1 PC2 PC_CB3 VPWR VGND NAND3
XPCCI2 PC_CB2 PC_C2 VPWR VGND INV
XPCCI3 PC_CB3 PC_C3 VPWR VGND INV
XPC_PLUS0 PC0 PC_NEXT0 VPWR VGND INV
XPC_PLUS1 PC1 PC0 PC_NEXT1 VPWR VGND XOR2
XPC_PLUS2 PC2 PC_C2 PC_NEXT2 VPWR VGND XOR2
XPC_PLUS3 PC3 PC_C3 PC_NEXT3 VPWR VGND XOR2
XPC_REG0 PC_D0 CLK PC0 VPWR VGND DFF
XPC_REG1 PC_D1 CLK PC1 VPWR VGND DFF
XPC_REG2 PC_D2 CLK PC2 VPWR VGND DFF
XPC_REG3 PC_D3 CLK PC3 VPWR VGND DFF
XRESET_ACC0 RES0 RESETB NEXT_ACC0 VPWR VGND AND2
XRESET_ACC1 RES1 RESETB NEXT_ACC1 VPWR VGND AND2
XRESET_ACC10 RES10 RESETB NEXT_ACC10 VPWR VGND AND2
XRESET_ACC11 RES11 RESETB NEXT_ACC11 VPWR VGND AND2
XRESET_ACC12 RES12 RESETB NEXT_ACC12 VPWR VGND AND2
XRESET_ACC13 RES13 RESETB NEXT_ACC13 VPWR VGND AND2
XRESET_ACC14 RES14 RESETB NEXT_ACC14 VPWR VGND AND2
XRESET_ACC15 RES15 RESETB NEXT_ACC15 VPWR VGND AND2
XRESET_ACC2 RES2 RESETB NEXT_ACC2 VPWR VGND AND2
XRESET_ACC3 RES3 RESETB NEXT_ACC3 VPWR VGND AND2
XRESET_ACC4 RES4 RESETB NEXT_ACC4 VPWR VGND AND2
XRESET_ACC5 RES5 RESETB NEXT_ACC5 VPWR VGND AND2
XRESET_ACC6 RES6 RESETB NEXT_ACC6 VPWR VGND AND2
XRESET_ACC7 RES7 RESETB NEXT_ACC7 VPWR VGND AND2
XRESET_ACC8 RES8 RESETB NEXT_ACC8 VPWR VGND AND2
XRESET_ACC9 RES9 RESETB NEXT_ACC9 VPWR VGND AND2
XRESET_PC0 PC_NEXT0 RESETB PC_D0 VPWR VGND AND2
XRESET_PC1 PC_NEXT1 RESETB PC_D1 VPWR VGND AND2
XRESET_PC2 PC_NEXT2 RESETB PC_D2 VPWR VGND AND2
XRESET_PC3 PC_NEXT3 RESETB PC_D3 VPWR VGND AND2
XRESULT0 L0 H0 OP1 RES0 VPWR VGND MUX2
XRESULT1 L1 H1 OP1 RES1 VPWR VGND MUX2
XRESULT10 L10 H10 OP1 RES10 VPWR VGND MUX2
XRESULT11 L11 H11 OP1 RES11 VPWR VGND MUX2
XRESULT12 L12 H12 OP1 RES12 VPWR VGND MUX2
XRESULT13 L13 H13 OP1 RES13 VPWR VGND MUX2
XRESULT14 L14 H14 OP1 RES14 VPWR VGND MUX2
XRESULT15 L15 H15 OP1 RES15 VPWR VGND MUX2
XRESULT2 L2 H2 OP1 RES2 VPWR VGND MUX2
XRESULT3 L3 H3 OP1 RES3 VPWR VGND MUX2
XRESULT4 L4 H4 OP1 RES4 VPWR VGND MUX2
XRESULT5 L5 H5 OP1 RES5 VPWR VGND MUX2
XRESULT6 L6 H6 OP1 RES6 VPWR VGND MUX2
XRESULT7 L7 H7 OP1 RES7 VPWR VGND MUX2
XRESULT8 L8 H8 OP1 RES8 VPWR VGND MUX2
XRESULT9 L9 H9 OP1 RES9 VPWR VGND MUX2
XROM PC0 PC1 PC2 PC3 IMM0 IMM1 IMM2 IMM3 IMM4 IMM5 IMM6 IMM7 IMM8 IMM9 IMM10 IMM11 IMM12 IMM13 IMM14 IMM15 OP0 OP1 VPWR VGND ROM16
XZERO_TREE_0_0 ACC_B0 ACC_B1 ZL0_0 VPWR VGND AND2
XZERO_TREE_0_1 ACC_B2 ACC_B3 ZL0_1 VPWR VGND AND2
XZERO_TREE_0_2 ACC_B4 ACC_B5 ZL0_2 VPWR VGND AND2
XZERO_TREE_0_3 ACC_B6 ACC_B7 ZL0_3 VPWR VGND AND2
XZERO_TREE_0_4 ACC_B8 ACC_B9 ZL0_4 VPWR VGND AND2
XZERO_TREE_0_5 ACC_B10 ACC_B11 ZL0_5 VPWR VGND AND2
XZERO_TREE_0_6 ACC_B12 ACC_B13 ZL0_6 VPWR VGND AND2
XZERO_TREE_0_7 ACC_B14 ACC_B15 ZL0_7 VPWR VGND AND2
XZERO_TREE_1_0 ZL0_0 ZL0_1 ZL1_0 VPWR VGND AND2
XZERO_TREE_1_1 ZL0_2 ZL0_3 ZL1_1 VPWR VGND AND2
XZERO_TREE_1_2 ZL0_4 ZL0_5 ZL1_2 VPWR VGND AND2
XZERO_TREE_1_3 ZL0_6 ZL0_7 ZL1_3 VPWR VGND AND2
XZERO_TREE_2_0 ZL1_0 ZL1_1 ZL2_0 VPWR VGND AND2
XZERO_TREE_2_1 ZL1_2 ZL1_3 ZL2_1 VPWR VGND AND2
XZERO_TREE_3_0 ZL2_0 ZL2_1 ZERO VPWR VGND AND2
XZI0 ACC0 ACC_B0 VPWR VGND INV
XZI1 ACC1 ACC_B1 VPWR VGND INV
XZI10 ACC10 ACC_B10 VPWR VGND INV
XZI11 ACC11 ACC_B11 VPWR VGND INV
XZI12 ACC12 ACC_B12 VPWR VGND INV
XZI13 ACC13 ACC_B13 VPWR VGND INV
XZI14 ACC14 ACC_B14 VPWR VGND INV
XZI15 ACC15 ACC_B15 VPWR VGND INV
XZI2 ACC2 ACC_B2 VPWR VGND INV
XZI3 ACC3 ACC_B3 VPWR VGND INV
XZI4 ACC4 ACC_B4 VPWR VGND INV
XZI5 ACC5 ACC_B5 VPWR VGND INV
XZI6 ACC6 ACC_B6 VPWR VGND INV
XZI7 ACC7 ACC_B7 VPWR VGND INV
XZI8 ACC8 ACC_B8 VPWR VGND INV
XZI9 ACC9 ACC_B9 VPWR VGND INV
.ends cpu16

Resistor actual SKY130 chip reference chip_sc_dcdc
.options method=gear maxord=2
.include "./supported-tt.spice"
.option scale=1e-6
.include "./current-probe.spice"
.temp 27.0
VGND VGND 0 0
VDD VPWR VGND 1.8
VPHI1 PHI1 VGND PULSE(0 1.8 1e-07 100p 100p 75n 200n)
VPHI1B PHI1B VGND PULSE(1.8 0 1e-07 100p 100p 75n 200n)
VPHI2 PHI2 VGND PULSE(0 1.8 2e-07 100p 100p 75n 200n)
VPHI2B PHI2B VGND PULSE(1.8 0 2e-07 100p 100p 75n 200n)
CFLY xu.FLYTOP xu.FLYBOTTOM 1e-09
COUT OUT VGND 1e-09
RLOAD OUT VGND 50000
XU PHI1 PHI1B PHI2 PHI2B OUT VPWR VGND chip_sc_dcdc
.control
save all i(v.xu.vregister_cf_3c1ae243e0461cec) i(v.xu.vregister_cf_4b2cc0664d4f8ee5) i(v.xu.vregister_cf_26022b929921ff94) i(v.xu.vregister_cf_81887fac5d22173f) i(v.xu.vregister_cf_b74705dc0e0122c5) i(v.xu.vregister_cf_a491c787bfff7a6c) i(v.xu.vregister_cf_16333635d80f45c8) i(v.xu.vregister_cf_2c801747b661ae05) i(VGND) i(VDD) i(VPHI1) i(VPHI1B) i(VPHI2) i(VPHI2B) v(OUT) v(XU.FLYBOTTOM) v(PHI1) v(VGND) v(PHI2) v(VPWR) v(XU.FLYTOP) v(PHI1B) v(PHI2B)
set num_threads=1
set numdgt=17
set noaskquit
set wr_singlescale
set wr_vecnames
tran 2e-09 2e-05 uic
let mos_wave_0 = v(OUT)
let mos_wave_1 = -i(VDD)
let mos_wave_2 = v(xu.FLYTOP)
let mos_wave_3 = v(xu.FLYBOTTOM)
let mos_wave_4 = v(PHI1)
let mos_wave_5 = v(PHI2)
wrdata waveform.dat mos_wave_0 mos_wave_1 mos_wave_2 mos_wave_3 mos_wave_4 mos_wave_5
write waveform.raw all
let register_flow_0 = i(v.xu.vregister_cf_3c1ae243e0461cec)
let register_flow_1 = i(v.xu.vregister_cf_4b2cc0664d4f8ee5)
let register_flow_2 = i(v.xu.vregister_cf_26022b929921ff94)
let register_flow_3 = i(v.xu.vregister_cf_81887fac5d22173f)
let register_flow_4 = i(v.xu.vregister_cf_b74705dc0e0122c5)
let register_flow_5 = i(v.xu.vregister_cf_a491c787bfff7a6c)
let register_flow_6 = i(v.xu.vregister_cf_16333635d80f45c8)
let register_flow_7 = i(v.xu.vregister_cf_2c801747b661ae05)
let register_flow_8 = i(VGND)
let register_flow_9 = i(VDD)
let register_flow_10 = i(VPHI1)
let register_flow_11 = i(VPHI1B)
let register_flow_12 = i(VPHI2)
let register_flow_13 = i(VPHI2B)
wrdata current-flow.dat register_flow_0 register_flow_1 register_flow_2 register_flow_3 register_flow_4 register_flow_5 register_flow_6 register_flow_7 register_flow_8 register_flow_9 register_flow_10 register_flow_11 register_flow_12 register_flow_13
let register_voltage_0 = v(OUT)
let register_voltage_1 = v(XU.FLYBOTTOM)
let register_voltage_2 = v(PHI1)
let register_voltage_3 = v(VGND)
let register_voltage_4 = v(PHI2)
let register_voltage_5 = v(VPWR)
let register_voltage_6 = v(XU.FLYTOP)
let register_voltage_7 = v(PHI1B)
let register_voltage_8 = v(PHI2B)
let register_voltage_9 = 0*register_flow_0
wrdata node-voltages.dat register_voltage_0 register_voltage_1 register_voltage_2 register_voltage_3 register_voltage_4 register_voltage_5 register_voltage_6 register_voltage_7 register_voltage_8 register_voltage_9
quit
.endc
.end

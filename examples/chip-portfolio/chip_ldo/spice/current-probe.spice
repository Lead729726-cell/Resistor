.subckt ERROR_AMP INP INN BIAS OUT VPWR VGND
XN_INN register_cf_node_d8ead78856ae83b4 INN register_cf_node_d8ead78856ae83b4_source VGND sky130_fd_pr__nfet_01v8 w=10 l=1 nf=1 m=1
Vregister_cf_d8ead78856ae83b4 MIR register_cf_node_d8ead78856ae83b4 0
Vregister_cf_d8ead78856ae83b4_source TAIL register_cf_node_d8ead78856ae83b4_source 0
XN_INP register_cf_node_564fc5b316a1f30c INP register_cf_node_564fc5b316a1f30c_source VGND sky130_fd_pr__nfet_01v8 w=10 l=1 nf=1 m=1
Vregister_cf_564fc5b316a1f30c OUT register_cf_node_564fc5b316a1f30c 0
Vregister_cf_564fc5b316a1f30c_source TAIL register_cf_node_564fc5b316a1f30c_source 0
XN_TAIL register_cf_node_fd920b51ee0d75cc BIAS register_cf_node_fd920b51ee0d75cc_source VGND sky130_fd_pr__nfet_01v8 w=2 l=1 nf=1 m=1
Vregister_cf_fd920b51ee0d75cc TAIL register_cf_node_fd920b51ee0d75cc 0
Vregister_cf_fd920b51ee0d75cc_source VGND register_cf_node_fd920b51ee0d75cc_source 0
XP_DIODE register_cf_node_414c5c4f93294a3c MIR register_cf_node_414c5c4f93294a3c_source VPWR sky130_fd_pr__pfet_01v8_hvt w=20 l=1 nf=1 m=1
Vregister_cf_414c5c4f93294a3c MIR register_cf_node_414c5c4f93294a3c 0
Vregister_cf_414c5c4f93294a3c_source VPWR register_cf_node_414c5c4f93294a3c_source 0
XP_MIRROR register_cf_node_8ab1dde3ba915385 MIR register_cf_node_8ab1dde3ba915385_source VPWR sky130_fd_pr__pfet_01v8_hvt w=20 l=1 nf=1 m=1
Vregister_cf_8ab1dde3ba915385 OUT register_cf_node_8ab1dde3ba915385 0
Vregister_cf_8ab1dde3ba915385_source VPWR register_cf_node_8ab1dde3ba915385_source 0
.ends ERROR_AMP
.subckt chip_ldo VREF BIAS OUT VPWR VGND
CC_COMP register_cf_node_97cfcadfe94bd0df COMP 2e-11
Vregister_cf_97cfcadfe94bd0df GATE register_cf_node_97cfcadfe94bd0df 0
XERROR_AMP VREF FB BIAS GATE VPWR VGND ERROR_AMP
XPASS0 register_cf_node_d969221a365d2a95 GATE register_cf_node_d969221a365d2a95_source VPWR sky130_fd_pr__pfet_01v8_hvt w=20 l=0.15 nf=1 m=1
Vregister_cf_d969221a365d2a95 OUT register_cf_node_d969221a365d2a95 0
Vregister_cf_d969221a365d2a95_source VPWR register_cf_node_d969221a365d2a95_source 0
XPASS1 register_cf_node_6bad8ec437fcbab1 GATE register_cf_node_6bad8ec437fcbab1_source VPWR sky130_fd_pr__pfet_01v8_hvt w=20 l=0.15 nf=1 m=1
Vregister_cf_6bad8ec437fcbab1 OUT register_cf_node_6bad8ec437fcbab1 0
Vregister_cf_6bad8ec437fcbab1_source VPWR register_cf_node_6bad8ec437fcbab1_source 0
XPASS2 register_cf_node_d33fcf75d0929dfd GATE register_cf_node_d33fcf75d0929dfd_source VPWR sky130_fd_pr__pfet_01v8_hvt w=20 l=0.15 nf=1 m=1
Vregister_cf_d33fcf75d0929dfd OUT register_cf_node_d33fcf75d0929dfd 0
Vregister_cf_d33fcf75d0929dfd_source VPWR register_cf_node_d33fcf75d0929dfd_source 0
XPASS3 register_cf_node_6ce00279bd0a7baa GATE register_cf_node_6ce00279bd0a7baa_source VPWR sky130_fd_pr__pfet_01v8_hvt w=20 l=0.15 nf=1 m=1
Vregister_cf_6ce00279bd0a7baa OUT register_cf_node_6ce00279bd0a7baa 0
Vregister_cf_6ce00279bd0a7baa_source VPWR register_cf_node_6ce00279bd0a7baa_source 0
XPASS4 register_cf_node_83563f53a4988147 GATE register_cf_node_83563f53a4988147_source VPWR sky130_fd_pr__pfet_01v8_hvt w=20 l=0.15 nf=1 m=1
Vregister_cf_83563f53a4988147 OUT register_cf_node_83563f53a4988147 0
Vregister_cf_83563f53a4988147_source VPWR register_cf_node_83563f53a4988147_source 0
RR_FB_BOTTOM register_cf_node_2aa8a0dc15b1e421 VGND 200000
Vregister_cf_2aa8a0dc15b1e421 FB register_cf_node_2aa8a0dc15b1e421 0
RR_FB_TOP register_cf_node_7bdb8e3328c94d5e FB 200000
Vregister_cf_7bdb8e3328c94d5e OUT register_cf_node_7bdb8e3328c94d5e 0
RR_ZERO register_cf_node_88c8327248b6c0d9 OUT 1000
Vregister_cf_88c8327248b6c0d9 COMP register_cf_node_88c8327248b6c0d9 0
.ends chip_ldo

.subckt INV A Y VPWR VGND
XMN Y A VGND VGND sky130_fd_pr__nfet_01v8 w=0.65 l=0.15 nf=1 m=1
XMP Y A VPWR VPWR sky130_fd_pr__pfet_01v8_hvt w=0.65 l=0.15 nf=1 m=1
.ends INV
.subckt NAND4 A0 A1 A2 A3 Y VPWR VGND
XMN0 Y A0 N1 VGND sky130_fd_pr__nfet_01v8 w=0.65 l=0.15 nf=1 m=1
XMN1 N1 A1 N2 VGND sky130_fd_pr__nfet_01v8 w=0.65 l=0.15 nf=1 m=1
XMN2 N2 A2 N3 VGND sky130_fd_pr__nfet_01v8 w=0.65 l=0.15 nf=1 m=1
XMN3 N3 A3 VGND VGND sky130_fd_pr__nfet_01v8 w=0.65 l=0.15 nf=1 m=1
XMP0 Y A0 VPWR VPWR sky130_fd_pr__pfet_01v8_hvt w=0.65 l=0.15 nf=1 m=1
XMP1 Y A1 VPWR VPWR sky130_fd_pr__pfet_01v8_hvt w=0.65 l=0.15 nf=1 m=1
XMP2 Y A2 VPWR VPWR sky130_fd_pr__pfet_01v8_hvt w=0.65 l=0.15 nf=1 m=1
XMP3 Y A3 VPWR VPWR sky130_fd_pr__pfet_01v8_hvt w=0.65 l=0.15 nf=1 m=1
.ends NAND4
.subckt NAND11 A0 A1 A2 A3 A4 A5 A6 A7 A8 A9 A10 Y VPWR VGND
XMN0 Y A0 N1 VGND sky130_fd_pr__nfet_01v8 w=0.65 l=0.15 nf=1 m=1
XMN1 N1 A1 N2 VGND sky130_fd_pr__nfet_01v8 w=0.65 l=0.15 nf=1 m=1
XMN10 N10 A10 VGND VGND sky130_fd_pr__nfet_01v8 w=0.65 l=0.15 nf=1 m=1
XMN2 N2 A2 N3 VGND sky130_fd_pr__nfet_01v8 w=0.65 l=0.15 nf=1 m=1
XMN3 N3 A3 N4 VGND sky130_fd_pr__nfet_01v8 w=0.65 l=0.15 nf=1 m=1
XMN4 N4 A4 N5 VGND sky130_fd_pr__nfet_01v8 w=0.65 l=0.15 nf=1 m=1
XMN5 N5 A5 N6 VGND sky130_fd_pr__nfet_01v8 w=0.65 l=0.15 nf=1 m=1
XMN6 N6 A6 N7 VGND sky130_fd_pr__nfet_01v8 w=0.65 l=0.15 nf=1 m=1
XMN7 N7 A7 N8 VGND sky130_fd_pr__nfet_01v8 w=0.65 l=0.15 nf=1 m=1
XMN8 N8 A8 N9 VGND sky130_fd_pr__nfet_01v8 w=0.65 l=0.15 nf=1 m=1
XMN9 N9 A9 N10 VGND sky130_fd_pr__nfet_01v8 w=0.65 l=0.15 nf=1 m=1
XMP0 Y A0 VPWR VPWR sky130_fd_pr__pfet_01v8_hvt w=0.65 l=0.15 nf=1 m=1
XMP1 Y A1 VPWR VPWR sky130_fd_pr__pfet_01v8_hvt w=0.65 l=0.15 nf=1 m=1
XMP10 Y A10 VPWR VPWR sky130_fd_pr__pfet_01v8_hvt w=0.65 l=0.15 nf=1 m=1
XMP2 Y A2 VPWR VPWR sky130_fd_pr__pfet_01v8_hvt w=0.65 l=0.15 nf=1 m=1
XMP3 Y A3 VPWR VPWR sky130_fd_pr__pfet_01v8_hvt w=0.65 l=0.15 nf=1 m=1
XMP4 Y A4 VPWR VPWR sky130_fd_pr__pfet_01v8_hvt w=0.65 l=0.15 nf=1 m=1
XMP5 Y A5 VPWR VPWR sky130_fd_pr__pfet_01v8_hvt w=0.65 l=0.15 nf=1 m=1
XMP6 Y A6 VPWR VPWR sky130_fd_pr__pfet_01v8_hvt w=0.65 l=0.15 nf=1 m=1
XMP7 Y A7 VPWR VPWR sky130_fd_pr__pfet_01v8_hvt w=0.65 l=0.15 nf=1 m=1
XMP8 Y A8 VPWR VPWR sky130_fd_pr__pfet_01v8_hvt w=0.65 l=0.15 nf=1 m=1
XMP9 Y A9 VPWR VPWR sky130_fd_pr__pfet_01v8_hvt w=0.65 l=0.15 nf=1 m=1
.ends NAND11
.subckt NAND9 A0 A1 A2 A3 A4 A5 A6 A7 A8 Y VPWR VGND
XMN0 Y A0 N1 VGND sky130_fd_pr__nfet_01v8 w=0.65 l=0.15 nf=1 m=1
XMN1 N1 A1 N2 VGND sky130_fd_pr__nfet_01v8 w=0.65 l=0.15 nf=1 m=1
XMN2 N2 A2 N3 VGND sky130_fd_pr__nfet_01v8 w=0.65 l=0.15 nf=1 m=1
XMN3 N3 A3 N4 VGND sky130_fd_pr__nfet_01v8 w=0.65 l=0.15 nf=1 m=1
XMN4 N4 A4 N5 VGND sky130_fd_pr__nfet_01v8 w=0.65 l=0.15 nf=1 m=1
XMN5 N5 A5 N6 VGND sky130_fd_pr__nfet_01v8 w=0.65 l=0.15 nf=1 m=1
XMN6 N6 A6 N7 VGND sky130_fd_pr__nfet_01v8 w=0.65 l=0.15 nf=1 m=1
XMN7 N7 A7 N8 VGND sky130_fd_pr__nfet_01v8 w=0.65 l=0.15 nf=1 m=1
XMN8 N8 A8 VGND VGND sky130_fd_pr__nfet_01v8 w=0.65 l=0.15 nf=1 m=1
XMP0 Y A0 VPWR VPWR sky130_fd_pr__pfet_01v8_hvt w=0.65 l=0.15 nf=1 m=1
XMP1 Y A1 VPWR VPWR sky130_fd_pr__pfet_01v8_hvt w=0.65 l=0.15 nf=1 m=1
XMP2 Y A2 VPWR VPWR sky130_fd_pr__pfet_01v8_hvt w=0.65 l=0.15 nf=1 m=1
XMP3 Y A3 VPWR VPWR sky130_fd_pr__pfet_01v8_hvt w=0.65 l=0.15 nf=1 m=1
XMP4 Y A4 VPWR VPWR sky130_fd_pr__pfet_01v8_hvt w=0.65 l=0.15 nf=1 m=1
XMP5 Y A5 VPWR VPWR sky130_fd_pr__pfet_01v8_hvt w=0.65 l=0.15 nf=1 m=1
XMP6 Y A6 VPWR VPWR sky130_fd_pr__pfet_01v8_hvt w=0.65 l=0.15 nf=1 m=1
XMP7 Y A7 VPWR VPWR sky130_fd_pr__pfet_01v8_hvt w=0.65 l=0.15 nf=1 m=1
XMP8 Y A8 VPWR VPWR sky130_fd_pr__pfet_01v8_hvt w=0.65 l=0.15 nf=1 m=1
.ends NAND9
.subckt NAND8 A0 A1 A2 A3 A4 A5 A6 A7 Y VPWR VGND
XMN0 Y A0 N1 VGND sky130_fd_pr__nfet_01v8 w=0.65 l=0.15 nf=1 m=1
XMN1 N1 A1 N2 VGND sky130_fd_pr__nfet_01v8 w=0.65 l=0.15 nf=1 m=1
XMN2 N2 A2 N3 VGND sky130_fd_pr__nfet_01v8 w=0.65 l=0.15 nf=1 m=1
XMN3 N3 A3 N4 VGND sky130_fd_pr__nfet_01v8 w=0.65 l=0.15 nf=1 m=1
XMN4 N4 A4 N5 VGND sky130_fd_pr__nfet_01v8 w=0.65 l=0.15 nf=1 m=1
XMN5 N5 A5 N6 VGND sky130_fd_pr__nfet_01v8 w=0.65 l=0.15 nf=1 m=1
XMN6 N6 A6 N7 VGND sky130_fd_pr__nfet_01v8 w=0.65 l=0.15 nf=1 m=1
XMN7 N7 A7 VGND VGND sky130_fd_pr__nfet_01v8 w=0.65 l=0.15 nf=1 m=1
XMP0 Y A0 VPWR VPWR sky130_fd_pr__pfet_01v8_hvt w=0.65 l=0.15 nf=1 m=1
XMP1 Y A1 VPWR VPWR sky130_fd_pr__pfet_01v8_hvt w=0.65 l=0.15 nf=1 m=1
XMP2 Y A2 VPWR VPWR sky130_fd_pr__pfet_01v8_hvt w=0.65 l=0.15 nf=1 m=1
XMP3 Y A3 VPWR VPWR sky130_fd_pr__pfet_01v8_hvt w=0.65 l=0.15 nf=1 m=1
XMP4 Y A4 VPWR VPWR sky130_fd_pr__pfet_01v8_hvt w=0.65 l=0.15 nf=1 m=1
XMP5 Y A5 VPWR VPWR sky130_fd_pr__pfet_01v8_hvt w=0.65 l=0.15 nf=1 m=1
XMP6 Y A6 VPWR VPWR sky130_fd_pr__pfet_01v8_hvt w=0.65 l=0.15 nf=1 m=1
XMP7 Y A7 VPWR VPWR sky130_fd_pr__pfet_01v8_hvt w=0.65 l=0.15 nf=1 m=1
.ends NAND8
.subckt NAND7 A0 A1 A2 A3 A4 A5 A6 Y VPWR VGND
XMN0 Y A0 N1 VGND sky130_fd_pr__nfet_01v8 w=0.65 l=0.15 nf=1 m=1
XMN1 N1 A1 N2 VGND sky130_fd_pr__nfet_01v8 w=0.65 l=0.15 nf=1 m=1
XMN2 N2 A2 N3 VGND sky130_fd_pr__nfet_01v8 w=0.65 l=0.15 nf=1 m=1
XMN3 N3 A3 N4 VGND sky130_fd_pr__nfet_01v8 w=0.65 l=0.15 nf=1 m=1
XMN4 N4 A4 N5 VGND sky130_fd_pr__nfet_01v8 w=0.65 l=0.15 nf=1 m=1
XMN5 N5 A5 N6 VGND sky130_fd_pr__nfet_01v8 w=0.65 l=0.15 nf=1 m=1
XMN6 N6 A6 VGND VGND sky130_fd_pr__nfet_01v8 w=0.65 l=0.15 nf=1 m=1
XMP0 Y A0 VPWR VPWR sky130_fd_pr__pfet_01v8_hvt w=0.65 l=0.15 nf=1 m=1
XMP1 Y A1 VPWR VPWR sky130_fd_pr__pfet_01v8_hvt w=0.65 l=0.15 nf=1 m=1
XMP2 Y A2 VPWR VPWR sky130_fd_pr__pfet_01v8_hvt w=0.65 l=0.15 nf=1 m=1
XMP3 Y A3 VPWR VPWR sky130_fd_pr__pfet_01v8_hvt w=0.65 l=0.15 nf=1 m=1
XMP4 Y A4 VPWR VPWR sky130_fd_pr__pfet_01v8_hvt w=0.65 l=0.15 nf=1 m=1
XMP5 Y A5 VPWR VPWR sky130_fd_pr__pfet_01v8_hvt w=0.65 l=0.15 nf=1 m=1
XMP6 Y A6 VPWR VPWR sky130_fd_pr__pfet_01v8_hvt w=0.65 l=0.15 nf=1 m=1
.ends NAND7
.subckt ROM16 P0 P1 P2 P3 I0 I1 I2 I3 O0 O1 VPWR VGND
XDEC0 PB0 PB1 PB2 PB3 D0 VPWR VGND NAND4
XDEC1 P0 PB1 PB2 PB3 D1 VPWR VGND NAND4
XDEC10 PB0 P1 PB2 P3 D10 VPWR VGND NAND4
XDEC11 P0 P1 PB2 P3 D11 VPWR VGND NAND4
XDEC12 PB0 PB1 P2 P3 D12 VPWR VGND NAND4
XDEC13 P0 PB1 P2 P3 D13 VPWR VGND NAND4
XDEC14 PB0 P1 P2 P3 D14 VPWR VGND NAND4
XDEC15 P0 P1 P2 P3 D15 VPWR VGND NAND4
XDEC2 PB0 P1 PB2 PB3 D2 VPWR VGND NAND4
XDEC3 P0 P1 PB2 PB3 D3 VPWR VGND NAND4
XDEC4 PB0 PB1 P2 PB3 D4 VPWR VGND NAND4
XDEC5 P0 PB1 P2 PB3 D5 VPWR VGND NAND4
XDEC6 PB0 P1 P2 PB3 D6 VPWR VGND NAND4
XDEC7 P0 P1 P2 PB3 D7 VPWR VGND NAND4
XDEC8 PB0 PB1 PB2 P3 D8 VPWR VGND NAND4
XDEC9 P0 PB1 PB2 P3 D9 VPWR VGND NAND4
XIP0 P0 PB0 VPWR VGND INV
XIP1 P1 PB1 VPWR VGND INV
XIP2 P2 PB2 VPWR VGND INV
XIP3 P3 PB3 VPWR VGND INV
XROM0 D0 D1 D2 D4 D5 D6 D7 D9 D11 D13 D15 I0 VPWR VGND NAND11
XROM1 D3 D4 D5 D7 D8 D9 D11 D14 D15 I1 VPWR VGND NAND9
XROM2 D1 D4 D5 D7 D8 D9 D11 D13 D15 I2 VPWR VGND NAND9
XROM3 D2 D3 D5 D7 D9 D12 D14 D15 I3 VPWR VGND NAND8
XROM4 D0 D1 D2 D3 D6 D7 D9 D11 D12 D13 D15 O0 VPWR VGND NAND11
XROM5 D3 D4 D8 D9 D13 D14 D15 O1 VPWR VGND NAND7
.ends ROM16
.subckt NAND2 A0 A1 Y VPWR VGND
XMN0 Y A0 N1 VGND sky130_fd_pr__nfet_01v8 w=0.65 l=0.15 nf=1 m=1
XMN1 N1 A1 VGND VGND sky130_fd_pr__nfet_01v8 w=0.65 l=0.15 nf=1 m=1
XMP0 Y A0 VPWR VPWR sky130_fd_pr__pfet_01v8_hvt w=0.65 l=0.15 nf=1 m=1
XMP1 Y A1 VPWR VPWR sky130_fd_pr__pfet_01v8_hvt w=0.65 l=0.15 nf=1 m=1
.ends NAND2
.subckt FA A B CIN SUM COUT VPWR VGND
XN1 A B N1 VPWR VGND NAND2
XN2 A N1 N2 VPWR VGND NAND2
XN3 B N1 N3 VPWR VGND NAND2
XN4 N2 N3 P VPWR VGND NAND2
XN5 P CIN N5 VPWR VGND NAND2
XN6 P N5 N6 VPWR VGND NAND2
XN7 CIN N5 N7 VPWR VGND NAND2
XN8 N6 N7 SUM VPWR VGND NAND2
XN9 N1 N5 COUT VPWR VGND NAND2
.ends FA
.subckt ADD4 A0 A1 A2 A3 B0 B1 B2 B3 CIN S0 S1 S2 S3 COUT VPWR VGND
XBIT0 A0 B0 CIN S0 C1 VPWR VGND FA
XBIT1 A1 B1 C1 S1 C2 VPWR VGND FA
XBIT2 A2 B2 C2 S2 C3 VPWR VGND FA
XBIT3 A3 B3 C3 S3 COUT VPWR VGND FA
.ends ADD4
.subckt AND2 A B Y VPWR VGND
XI1 N Y VPWR VGND INV
XN1 A B N VPWR VGND NAND2
.ends AND2
.subckt XOR2 A B Y VPWR VGND
XN1 A B N1 VPWR VGND NAND2
XN2 A N1 N2 VPWR VGND NAND2
XN3 B N1 N3 VPWR VGND NAND2
XN4 N2 N3 Y VPWR VGND NAND2
.ends XOR2
.subckt MUX2 A B S Y VPWR VGND
XIS S SB VPWR VGND INV
XMNA Y SB A VGND sky130_fd_pr__nfet_01v8 w=0.65 l=0.15 nf=1 m=1
XMNB Y S B VGND sky130_fd_pr__nfet_01v8 w=0.65 l=0.15 nf=1 m=1
XMPA Y S A VPWR sky130_fd_pr__pfet_01v8_hvt w=0.65 l=0.15 nf=1 m=1
XMPB Y SB B VPWR sky130_fd_pr__pfet_01v8_hvt w=0.65 l=0.15 nf=1 m=1
.ends MUX2
.subckt DFF D CLK Q VPWR VGND
XICLK CLK CLKB VPWR VGND INV
XM1 M MB VPWR VGND INV
XM2 MB MF VPWR VGND INV
XMNIN M CLKB D VGND sky130_fd_pr__nfet_01v8 w=0.65 l=0.15 nf=1 m=1
XMNMF M CLK MF VGND sky130_fd_pr__nfet_01v8 w=0.65 l=0.15 nf=1 m=1
XMNOUT T CLK MF VGND sky130_fd_pr__nfet_01v8 w=0.65 l=0.15 nf=1 m=1
XMNSF T CLKB Q VGND sky130_fd_pr__nfet_01v8 w=0.65 l=0.15 nf=1 m=1
XMPIN M CLK D VPWR sky130_fd_pr__pfet_01v8_hvt w=0.65 l=0.15 nf=1 m=1
XMPMF M CLKB MF VPWR sky130_fd_pr__pfet_01v8_hvt w=0.65 l=0.15 nf=1 m=1
XMPOUT T CLKB MF VPWR sky130_fd_pr__pfet_01v8_hvt w=0.65 l=0.15 nf=1 m=1
XMPSF T CLK Q VPWR sky130_fd_pr__pfet_01v8_hvt w=0.65 l=0.15 nf=1 m=1
XS1 T TB VPWR VGND INV
XS2 TB Q VPWR VGND INV
.ends DFF
.subckt NAND3 A0 A1 A2 Y VPWR VGND
XMN0 Y A0 N1 VGND sky130_fd_pr__nfet_01v8 w=0.65 l=0.15 nf=1 m=1
XMN1 N1 A1 N2 VGND sky130_fd_pr__nfet_01v8 w=0.65 l=0.15 nf=1 m=1
XMN2 N2 A2 VGND VGND sky130_fd_pr__nfet_01v8 w=0.65 l=0.15 nf=1 m=1
XMP0 Y A0 VPWR VPWR sky130_fd_pr__pfet_01v8_hvt w=0.65 l=0.15 nf=1 m=1
XMP1 Y A1 VPWR VPWR sky130_fd_pr__pfet_01v8_hvt w=0.65 l=0.15 nf=1 m=1
XMP2 Y A2 VPWR VPWR sky130_fd_pr__pfet_01v8_hvt w=0.65 l=0.15 nf=1 m=1
.ends NAND3
.subckt cpu4 CLK RESET ACC0 ACC1 ACC2 ACC3 PC0 PC1 PC2 PC3 CARRY ZERO VPWR VGND
XACC_REG0 NEXT_ACC0 CLK ACC0 VPWR VGND DFF
XACC_REG1 NEXT_ACC1 CLK ACC1 VPWR VGND DFF
XACC_REG2 NEXT_ACC2 CLK ACC2 VPWR VGND DFF
XACC_REG3 NEXT_ACC3 CLK ACC3 VPWR VGND DFF
XADD_ENABLE OP0 OP1B IS_ADD VPWR VGND AND2
XALU_ADD ACC0 ACC1 ACC2 ACC3 IMM0 IMM1 IMM2 IMM3 VGND ADD0 ADD1 ADD2 ADD3 ADD_CARRY VPWR VGND ADD4
XALU_AND0 ACC0 IMM0 AND0 VPWR VGND AND2
XALU_AND1 ACC1 IMM1 AND1 VPWR VGND AND2
XALU_AND2 ACC2 IMM2 AND2 VPWR VGND AND2
XALU_AND3 ACC3 IMM3 AND3 VPWR VGND AND2
XALU_XOR0 ACC0 IMM0 XOR0 VPWR VGND XOR2
XALU_XOR1 ACC1 IMM1 XOR1 VPWR VGND XOR2
XALU_XOR2 ACC2 IMM2 XOR2 VPWR VGND XOR2
XALU_XOR3 ACC3 IMM3 XOR3 VPWR VGND XOR2
XCARRY_REG CD CLK CARRY VPWR VGND DFF
XCARRY_RESET CV RESETB CD VPWR VGND AND2
XCARRY_VALUE ADD_CARRY IS_ADD CV VPWR VGND AND2
XHIGH0 AND0 XOR0 OP0 H0 VPWR VGND MUX2
XHIGH1 AND1 XOR1 OP0 H1 VPWR VGND MUX2
XHIGH2 AND2 XOR2 OP0 H2 VPWR VGND MUX2
XHIGH3 AND3 XOR3 OP0 H3 VPWR VGND MUX2
XIOP1 OP1 OP1B VPWR VGND INV
XIR RESET RESETB VPWR VGND INV
XLOW0 IMM0 ADD0 OP0 L0 VPWR VGND MUX2
XLOW1 IMM1 ADD1 OP0 L1 VPWR VGND MUX2
XLOW2 IMM2 ADD2 OP0 L2 VPWR VGND MUX2
XLOW3 IMM3 ADD3 OP0 L3 VPWR VGND MUX2
XPCC2 PC0 PC1 PC_CB2 VPWR VGND NAND2
XPCC3 PC0 PC1 PC2 PC_CB3 VPWR VGND NAND3
XPCCI2 PC_CB2 PC_C2 VPWR VGND INV
XPCCI3 PC_CB3 PC_C3 VPWR VGND INV
XPC_PLUS0 PC0 PC_NEXT0 VPWR VGND INV
XPC_PLUS1 PC1 PC0 PC_NEXT1 VPWR VGND XOR2
XPC_PLUS2 PC2 PC_C2 PC_NEXT2 VPWR VGND XOR2
XPC_PLUS3 PC3 PC_C3 PC_NEXT3 VPWR VGND XOR2
XPC_REG0 PC_D0 CLK PC0 VPWR VGND DFF
XPC_REG1 PC_D1 CLK PC1 VPWR VGND DFF
XPC_REG2 PC_D2 CLK PC2 VPWR VGND DFF
XPC_REG3 PC_D3 CLK PC3 VPWR VGND DFF
XRESET_ACC0 RES0 RESETB NEXT_ACC0 VPWR VGND AND2
XRESET_ACC1 RES1 RESETB NEXT_ACC1 VPWR VGND AND2
XRESET_ACC2 RES2 RESETB NEXT_ACC2 VPWR VGND AND2
XRESET_ACC3 RES3 RESETB NEXT_ACC3 VPWR VGND AND2
XRESET_PC0 PC_NEXT0 RESETB PC_D0 VPWR VGND AND2
XRESET_PC1 PC_NEXT1 RESETB PC_D1 VPWR VGND AND2
XRESET_PC2 PC_NEXT2 RESETB PC_D2 VPWR VGND AND2
XRESET_PC3 PC_NEXT3 RESETB PC_D3 VPWR VGND AND2
XRESULT0 L0 H0 OP1 RES0 VPWR VGND MUX2
XRESULT1 L1 H1 OP1 RES1 VPWR VGND MUX2
XRESULT2 L2 H2 OP1 RES2 VPWR VGND MUX2
XRESULT3 L3 H3 OP1 RES3 VPWR VGND MUX2
XROM PC0 PC1 PC2 PC3 IMM0 IMM1 IMM2 IMM3 OP0 OP1 VPWR VGND ROM16
XZI ZERO_B ZERO VPWR VGND INV
XZI0 ACC0 ACC_B0 VPWR VGND INV
XZI1 ACC1 ACC_B1 VPWR VGND INV
XZI2 ACC2 ACC_B2 VPWR VGND INV
XZI3 ACC3 ACC_B3 VPWR VGND INV
XZN ACC_B0 ACC_B1 ACC_B2 ACC_B3 ZERO_B VPWR VGND NAND4
.ends cpu4

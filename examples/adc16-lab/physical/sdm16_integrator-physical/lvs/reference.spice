.subckt sdm16_integrator VIN SIGNAL BITSTREAM VCM BIAS OUT RESET RESETB VPWR VGND
XAMP_C_MILLER_P0 AMP__PRE AMP__COMP sky130_fd_pr__cap_mim_m3_1 w=15.625 l=15.625
XAMP_FIRST_N_INN AMP__FIRST__MIR SUM AMP__FIRST__TAIL VGND sky130_fd_pr__nfet_01v8 w=10 l=1 nf=1 m=1
XAMP_FIRST_N_INP AMP__PRE TRACK_REF AMP__FIRST__TAIL VGND sky130_fd_pr__nfet_01v8 w=10 l=1 nf=1 m=1
XAMP_FIRST_N_TAIL AMP__FIRST__TAIL BIAS VGND VGND sky130_fd_pr__nfet_01v8 w=2 l=1 nf=1 m=1
XAMP_FIRST_P_DIODE AMP__FIRST__MIR AMP__FIRST__MIR VPWR VPWR sky130_fd_pr__pfet_01v8_hvt w=20 l=1 nf=1 m=1
XAMP_FIRST_P_MIRROR AMP__PRE AMP__FIRST__MIR VPWR VPWR sky130_fd_pr__pfet_01v8_hvt w=20 l=1 nf=1 m=1
XAMP_N_SECOND OUT BIAS VGND VGND sky130_fd_pr__nfet_01v8 w=10 l=1 nf=1 m=1
XAMP_P_SECOND OUT AMP__PRE VPWR VPWR sky130_fd_pr__pfet_01v8_hvt w=20 l=1 nf=1 m=1
XAMP_R_ZERO_P0 AMP__COMP OUT VGND sky130_fd_pr__res_xhigh_po_1p41 l=0.54
XC_INT_P0 OUT SUM sky130_fd_pr__cap_mim_m3_1 w=25.63 l=25.63
XC_INT_P1 OUT SUM sky130_fd_pr__cap_mim_m3_1 w=25.63 l=25.63
XC_INT_P2 OUT SUM sky130_fd_pr__cap_mim_m3_1 w=25.63 l=25.63
XRESET_SWITCH_N_RESET0 SUM RESET VCM VGND sky130_fd_pr__nfet_01v8 w=2 l=0.15 nf=1 m=1
XRESET_SWITCH_N_RESET1 OUT RESET VCM VGND sky130_fd_pr__nfet_01v8 w=2 l=0.15 nf=1 m=1
XRESET_SWITCH_P_RESET0 SUM RESETB VCM VPWR sky130_fd_pr__pfet_01v8_hvt w=4 l=0.15 nf=1 m=1
XRESET_SWITCH_P_RESET1 OUT RESETB VCM VPWR sky130_fd_pr__pfet_01v8_hvt w=4 l=0.15 nf=1 m=1
XR_FEEDBACK_P0 BITSTREAM R_FEEDBACK_R0_N0 VGND sky130_fd_pr__res_xhigh_po_1p41 l=29.21
XR_FEEDBACK_P1 R_FEEDBACK_R0_N0 R_FEEDBACK_R0_N1 VGND sky130_fd_pr__res_xhigh_po_1p41 l=29.21
XR_FEEDBACK_P2 R_FEEDBACK_R0_N1 R_FEEDBACK_R0_N2 VGND sky130_fd_pr__res_xhigh_po_1p41 l=29.21
XR_FEEDBACK_P3 R_FEEDBACK_R0_N2 R_FEEDBACK_R0_N3 VGND sky130_fd_pr__res_xhigh_po_1p41 l=29.21
XR_FEEDBACK_P4 R_FEEDBACK_R0_N3 R_FEEDBACK_R0_N4 VGND sky130_fd_pr__res_xhigh_po_1p41 l=29.21
XR_FEEDBACK_P5 R_FEEDBACK_R0_N4 SUM VGND sky130_fd_pr__res_xhigh_po_1p41 l=29.21
XR_INPUT_P0 VIN R_INPUT_R0_N0 VGND sky130_fd_pr__res_xhigh_po_1p41 l=29.21
XR_INPUT_P1 R_INPUT_R0_N0 R_INPUT_R0_N1 VGND sky130_fd_pr__res_xhigh_po_1p41 l=29.21
XR_INPUT_P10 R_INPUT_R0_N9 R_INPUT_R0_N10 VGND sky130_fd_pr__res_xhigh_po_1p41 l=29.21
XR_INPUT_P11 R_INPUT_R0_N10 SUM VGND sky130_fd_pr__res_xhigh_po_1p41 l=29.21
XR_INPUT_P2 R_INPUT_R0_N1 R_INPUT_R0_N2 VGND sky130_fd_pr__res_xhigh_po_1p41 l=29.21
XR_INPUT_P3 R_INPUT_R0_N2 R_INPUT_R0_N3 VGND sky130_fd_pr__res_xhigh_po_1p41 l=29.21
XR_INPUT_P4 R_INPUT_R0_N3 R_INPUT_R0_N4 VGND sky130_fd_pr__res_xhigh_po_1p41 l=29.21
XR_INPUT_P5 R_INPUT_R0_N4 R_INPUT_R0_N5 VGND sky130_fd_pr__res_xhigh_po_1p41 l=29.21
XR_INPUT_P6 R_INPUT_R0_N5 R_INPUT_R0_N6 VGND sky130_fd_pr__res_xhigh_po_1p41 l=29.21
XR_INPUT_P7 R_INPUT_R0_N6 R_INPUT_R0_N7 VGND sky130_fd_pr__res_xhigh_po_1p41 l=29.21
XR_INPUT_P8 R_INPUT_R0_N7 R_INPUT_R0_N8 VGND sky130_fd_pr__res_xhigh_po_1p41 l=29.21
XR_INPUT_P9 R_INPUT_R0_N8 R_INPUT_R0_N9 VGND sky130_fd_pr__res_xhigh_po_1p41 l=29.21
XR_REF_CM_P0 VCM R_REF_CM_R0_N0 VGND sky130_fd_pr__res_xhigh_po_1p41 l=28.035
XR_REF_CM_P1 R_REF_CM_R0_N0 R_REF_CM_R0_N1 VGND sky130_fd_pr__res_xhigh_po_1p41 l=28.035
XR_REF_CM_P2 R_REF_CM_R0_N1 R_REF_CM_R0_N2 VGND sky130_fd_pr__res_xhigh_po_1p41 l=28.035
XR_REF_CM_P3 R_REF_CM_R0_N2 R_REF_CM_R0_N3 VGND sky130_fd_pr__res_xhigh_po_1p41 l=28.035
XR_REF_CM_P4 R_REF_CM_R0_N3 TRACK_REF VGND sky130_fd_pr__res_xhigh_po_1p41 l=28.035
XR_REF_SIGNAL_P0 SIGNAL R_REF_SIGNAL_R0_N0 VGND sky130_fd_pr__res_xhigh_po_1p41 l=23.335
XR_REF_SIGNAL_P1 R_REF_SIGNAL_R0_N0 R_REF_SIGNAL_R0_N1 VGND sky130_fd_pr__res_xhigh_po_1p41 l=23.335
XR_REF_SIGNAL_P2 R_REF_SIGNAL_R0_N1 TRACK_REF VGND sky130_fd_pr__res_xhigh_po_1p41 l=23.335
.ends sdm16_integrator

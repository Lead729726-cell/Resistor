.subckt sar16_analog VINP VINN VREF VCM SAMPLE EVAL TOPP TOPN COMP COMPN B0 B1 B2 B3 B4 B5 B6 B7 B8 B9 B10 B11 B12 B13 B14 B15 VPWR VGND
XCOMPARE_BIAS_DIODE COMPARE__BIAS COMPARE__BIAS VGND VGND sky130_fd_pr__nfet_01v8 w=4 l=1 nf=1 m=1
XCOMPARE_BIAS_RES_P0 VPWR COMPARE_BIAS_RES_R0_N0 VGND sky130_fd_pr__res_xhigh_po_1p41 l=23.335
XCOMPARE_BIAS_RES_P1 COMPARE_BIAS_RES_R0_N0 COMPARE_BIAS_RES_R0_N1 VGND sky130_fd_pr__res_xhigh_po_1p41 l=23.335
XCOMPARE_BIAS_RES_P2 COMPARE_BIAS_RES_R0_N1 COMPARE__BIAS VGND sky130_fd_pr__res_xhigh_po_1p41 l=23.335
XCOMPARE_LATCH_BUF0_OUTN_MN COMPARE__LATCH__OUTN_B COMPARE__LATCH__QP VGND VGND sky130_fd_pr__nfet_01v8 w=0.65 l=0.15 nf=1 m=1
XCOMPARE_LATCH_BUF0_OUTN_MP COMPARE__LATCH__OUTN_B COMPARE__LATCH__QP VPWR VPWR sky130_fd_pr__pfet_01v8_hvt w=0.65 l=0.15 nf=1 m=1
XCOMPARE_LATCH_BUF0_OUTP_MN COMPARE__LATCH__OUTP_B COMPARE__LATCH__QN VGND VGND sky130_fd_pr__nfet_01v8 w=0.65 l=0.15 nf=1 m=1
XCOMPARE_LATCH_BUF0_OUTP_MP COMPARE__LATCH__OUTP_B COMPARE__LATCH__QN VPWR VPWR sky130_fd_pr__pfet_01v8_hvt w=0.65 l=0.15 nf=1 m=1
XCOMPARE_LATCH_BUF1_OUTN_MN COMPN COMPARE__LATCH__OUTN_B VGND VGND sky130_fd_pr__nfet_01v8 w=0.65 l=0.15 nf=1 m=1
XCOMPARE_LATCH_BUF1_OUTN_MP COMPN COMPARE__LATCH__OUTN_B VPWR VPWR sky130_fd_pr__pfet_01v8_hvt w=0.65 l=0.15 nf=1 m=1
XCOMPARE_LATCH_BUF1_OUTP_MN COMP COMPARE__LATCH__OUTP_B VGND VGND sky130_fd_pr__nfet_01v8 w=0.65 l=0.15 nf=1 m=1
XCOMPARE_LATCH_BUF1_OUTP_MP COMP COMPARE__LATCH__OUTP_B VPWR VPWR sky130_fd_pr__pfet_01v8_hvt w=0.65 l=0.15 nf=1 m=1
XCOMPARE_LATCH_INPUT0 COMPARE__LATCH__FN COMPARE__PRE1P COMPARE__LATCH__TAIL VGND sky130_fd_pr__nfet_01v8 w=10 l=0.5 nf=1 m=1
XCOMPARE_LATCH_INPUT1 COMPARE__LATCH__FP COMPARE__PRE1N COMPARE__LATCH__TAIL VGND sky130_fd_pr__nfet_01v8 w=10 l=0.5 nf=1 m=1
XCOMPARE_LATCH_INPUT2 COMPARE__LATCH__FP COMPARE__PRE1N COMPARE__LATCH__TAIL VGND sky130_fd_pr__nfet_01v8 w=10 l=0.5 nf=1 m=1
XCOMPARE_LATCH_INPUT3 COMPARE__LATCH__FN COMPARE__PRE1P COMPARE__LATCH__TAIL VGND sky130_fd_pr__nfet_01v8 w=10 l=0.5 nf=1 m=1
XCOMPARE_LATCH_LN_QN COMPARE__LATCH__QN COMPARE__LATCH__QP COMPARE__LATCH__FP VGND sky130_fd_pr__nfet_01v8 w=8 l=0.15 nf=1 m=1
XCOMPARE_LATCH_LN_QP COMPARE__LATCH__QP COMPARE__LATCH__QN COMPARE__LATCH__FN VGND sky130_fd_pr__nfet_01v8 w=8 l=0.15 nf=1 m=1
XCOMPARE_LATCH_LP_QN COMPARE__LATCH__QN COMPARE__LATCH__QP VPWR VPWR sky130_fd_pr__pfet_01v8_hvt w=4 l=0.15 nf=1 m=1
XCOMPARE_LATCH_LP_QP COMPARE__LATCH__QP COMPARE__LATCH__QN VPWR VPWR sky130_fd_pr__pfet_01v8_hvt w=4 l=0.15 nf=1 m=1
XCOMPARE_LATCH_PRE_FN COMPARE__LATCH__FN EVAL VPWR VPWR sky130_fd_pr__pfet_01v8_hvt w=2 l=0.15 nf=1 m=1
XCOMPARE_LATCH_PRE_FP COMPARE__LATCH__FP EVAL VPWR VPWR sky130_fd_pr__pfet_01v8_hvt w=2 l=0.15 nf=1 m=1
XCOMPARE_LATCH_RESET_QN COMPARE__LATCH__QN EVAL VPWR VPWR sky130_fd_pr__pfet_01v8_hvt w=4 l=0.15 nf=1 m=1
XCOMPARE_LATCH_RESET_QP COMPARE__LATCH__QP EVAL VPWR VPWR sky130_fd_pr__pfet_01v8_hvt w=4 l=0.15 nf=1 m=1
XCOMPARE_LATCH_TAIL COMPARE__LATCH__TAIL EVAL VGND VGND sky130_fd_pr__nfet_01v8 w=20 l=0.15 nf=1 m=1
XCOMPARE_LOAD_PRE1N_P0 COMPARE__PRE1N VGND sky130_fd_pr__cap_mim_m3_1 w=15.625 l=15.625
XCOMPARE_LOAD_PRE1P_P0 COMPARE__PRE1P VGND sky130_fd_pr__cap_mim_m3_1 w=15.625 l=15.625
XCOMPARE_PRE0_INPUT0 COMPARE__PRE0N TOPN COMPARE__PRE0__TAIL VGND sky130_fd_pr__nfet_01v8 w=10 l=1 nf=1 m=1
XCOMPARE_PRE0_INPUT1 COMPARE__PRE0P TOPP COMPARE__PRE0__TAIL VGND sky130_fd_pr__nfet_01v8 w=10 l=1 nf=1 m=1
XCOMPARE_PRE0_INPUT2 COMPARE__PRE0P TOPP COMPARE__PRE0__TAIL VGND sky130_fd_pr__nfet_01v8 w=10 l=1 nf=1 m=1
XCOMPARE_PRE0_INPUT3 COMPARE__PRE0N TOPN COMPARE__PRE0__TAIL VGND sky130_fd_pr__nfet_01v8 w=10 l=1 nf=1 m=1
XCOMPARE_PRE0_LOAD_OUTN_P0 VPWR COMPARE_PRE0_LOAD_OUTN_R0_N0 VGND sky130_fd_pr__res_xhigh_po_1p41 l=23.335
XCOMPARE_PRE0_LOAD_OUTN_P1 COMPARE_PRE0_LOAD_OUTN_R0_N0 COMPARE_PRE0_LOAD_OUTN_R0_N1 VGND sky130_fd_pr__res_xhigh_po_1p41 l=23.335
XCOMPARE_PRE0_LOAD_OUTN_P2 COMPARE_PRE0_LOAD_OUTN_R0_N1 COMPARE__PRE0N VGND sky130_fd_pr__res_xhigh_po_1p41 l=23.335
XCOMPARE_PRE0_LOAD_OUTP_P0 VPWR COMPARE_PRE0_LOAD_OUTP_R0_N0 VGND sky130_fd_pr__res_xhigh_po_1p41 l=23.335
XCOMPARE_PRE0_LOAD_OUTP_P1 COMPARE_PRE0_LOAD_OUTP_R0_N0 COMPARE_PRE0_LOAD_OUTP_R0_N1 VGND sky130_fd_pr__res_xhigh_po_1p41 l=23.335
XCOMPARE_PRE0_LOAD_OUTP_P2 COMPARE_PRE0_LOAD_OUTP_R0_N1 COMPARE__PRE0P VGND sky130_fd_pr__res_xhigh_po_1p41 l=23.335
XCOMPARE_PRE0_TAIL COMPARE__PRE0__TAIL COMPARE__BIAS VGND VGND sky130_fd_pr__nfet_01v8 w=4 l=1 nf=1 m=1
XCOMPARE_PRE1_INPUT0 COMPARE__PRE1N COMPARE__PRE0P COMPARE__PRE1__TAIL VGND sky130_fd_pr__nfet_01v8 w=10 l=1 nf=1 m=1
XCOMPARE_PRE1_INPUT1 COMPARE__PRE1P COMPARE__PRE0N COMPARE__PRE1__TAIL VGND sky130_fd_pr__nfet_01v8 w=10 l=1 nf=1 m=1
XCOMPARE_PRE1_INPUT2 COMPARE__PRE1P COMPARE__PRE0N COMPARE__PRE1__TAIL VGND sky130_fd_pr__nfet_01v8 w=10 l=1 nf=1 m=1
XCOMPARE_PRE1_INPUT3 COMPARE__PRE1N COMPARE__PRE0P COMPARE__PRE1__TAIL VGND sky130_fd_pr__nfet_01v8 w=10 l=1 nf=1 m=1
XCOMPARE_PRE1_LOAD_OUTN_P0 VPWR COMPARE_PRE1_LOAD_OUTN_R0_N0 VGND sky130_fd_pr__res_xhigh_po_1p41 l=23.335
XCOMPARE_PRE1_LOAD_OUTN_P1 COMPARE_PRE1_LOAD_OUTN_R0_N0 COMPARE_PRE1_LOAD_OUTN_R0_N1 VGND sky130_fd_pr__res_xhigh_po_1p41 l=23.335
XCOMPARE_PRE1_LOAD_OUTN_P2 COMPARE_PRE1_LOAD_OUTN_R0_N1 COMPARE__PRE1N VGND sky130_fd_pr__res_xhigh_po_1p41 l=23.335
XCOMPARE_PRE1_LOAD_OUTP_P0 VPWR COMPARE_PRE1_LOAD_OUTP_R0_N0 VGND sky130_fd_pr__res_xhigh_po_1p41 l=23.335
XCOMPARE_PRE1_LOAD_OUTP_P1 COMPARE_PRE1_LOAD_OUTP_R0_N0 COMPARE_PRE1_LOAD_OUTP_R0_N1 VGND sky130_fd_pr__res_xhigh_po_1p41 l=23.335
XCOMPARE_PRE1_LOAD_OUTP_P2 COMPARE_PRE1_LOAD_OUTP_R0_N1 COMPARE__PRE1P VGND sky130_fd_pr__res_xhigh_po_1p41 l=23.335
XCOMPARE_PRE1_TAIL COMPARE__PRE1__TAIL COMPARE__BIAS VGND VGND sky130_fd_pr__nfet_01v8 w=4 l=1 nf=1 m=1
XDAC_BRIDGE_0N_C_BRIDGE_P0 TOPN DAC__BANK1N sky130_fd_pr__cap_mim_m3_1 w=22.905 l=22.905
XDAC_BRIDGE_0N_C_BRIDGE_P1 TOPN DAC__BANK1N sky130_fd_pr__cap_mim_m3_1 w=22.905 l=22.905
XDAC_BRIDGE_0P_C_BRIDGE_P0 TOPP DAC__BANK1P sky130_fd_pr__cap_mim_m3_1 w=22.905 l=22.905
XDAC_BRIDGE_0P_C_BRIDGE_P1 TOPP DAC__BANK1P sky130_fd_pr__cap_mim_m3_1 w=22.905 l=22.905
XDAC_BRIDGE_1N_C_BRIDGE_P0 DAC__BANK1N DAC__BANK2N sky130_fd_pr__cap_mim_m3_1 w=22.905 l=22.905
XDAC_BRIDGE_1N_C_BRIDGE_P1 DAC__BANK1N DAC__BANK2N sky130_fd_pr__cap_mim_m3_1 w=22.905 l=22.905
XDAC_BRIDGE_1P_C_BRIDGE_P0 DAC__BANK1P DAC__BANK2P sky130_fd_pr__cap_mim_m3_1 w=22.905 l=22.905
XDAC_BRIDGE_1P_C_BRIDGE_P1 DAC__BANK1P DAC__BANK2P sky130_fd_pr__cap_mim_m3_1 w=22.905 l=22.905
XDAC_BRIDGE_2N_C_BRIDGE_P0 DAC__BANK2N DAC__BANK3N sky130_fd_pr__cap_mim_m3_1 w=22.905 l=22.905
XDAC_BRIDGE_2N_C_BRIDGE_P1 DAC__BANK2N DAC__BANK3N sky130_fd_pr__cap_mim_m3_1 w=22.905 l=22.905
XDAC_BRIDGE_2P_C_BRIDGE_P0 DAC__BANK2P DAC__BANK3P sky130_fd_pr__cap_mim_m3_1 w=22.905 l=22.905
XDAC_BRIDGE_2P_C_BRIDGE_P1 DAC__BANK2P DAC__BANK3P sky130_fd_pr__cap_mim_m3_1 w=22.905 l=22.905
XDAC_HIN_ACQUIRE_N VINN SAMPLE DAC__HIN VGND sky130_fd_pr__nfet_01v8 w=8 l=0.15 nf=1 m=1
XDAC_HIN_ACQUIRE_P VINN DAC__SAMPLEB DAC__HIN VPWR sky130_fd_pr__pfet_01v8_hvt w=12 l=0.15 nf=1 m=1
XDAC_HIN_CONVERT_N VREF DAC__SAMPLEB DAC__HIN VGND sky130_fd_pr__nfet_01v8 w=8 l=0.15 nf=1 m=1
XDAC_HIN_CONVERT_P VREF SAMPLE DAC__HIN VPWR sky130_fd_pr__pfet_01v8_hvt w=12 l=0.15 nf=1 m=1
XDAC_HIP_ACQUIRE_N VINP SAMPLE DAC__HIP VGND sky130_fd_pr__nfet_01v8 w=8 l=0.15 nf=1 m=1
XDAC_HIP_ACQUIRE_P VINP DAC__SAMPLEB DAC__HIP VPWR sky130_fd_pr__pfet_01v8_hvt w=12 l=0.15 nf=1 m=1
XDAC_HIP_CONVERT_N VREF DAC__SAMPLEB DAC__HIP VGND sky130_fd_pr__nfet_01v8 w=8 l=0.15 nf=1 m=1
XDAC_HIP_CONVERT_P VREF SAMPLE DAC__HIP VPWR sky130_fd_pr__pfet_01v8_hvt w=12 l=0.15 nf=1 m=1
XDAC_LON_ACQUIRE_N VINN SAMPLE DAC__LON VGND sky130_fd_pr__nfet_01v8 w=8 l=0.15 nf=1 m=1
XDAC_LON_ACQUIRE_P VINN DAC__SAMPLEB DAC__LON VPWR sky130_fd_pr__pfet_01v8_hvt w=12 l=0.15 nf=1 m=1
XDAC_LON_CONVERT_N VGND DAC__SAMPLEB DAC__LON VGND sky130_fd_pr__nfet_01v8 w=8 l=0.15 nf=1 m=1
XDAC_LON_CONVERT_P VGND SAMPLE DAC__LON VPWR sky130_fd_pr__pfet_01v8_hvt w=12 l=0.15 nf=1 m=1
XDAC_LOP_ACQUIRE_N VINP SAMPLE DAC__LOP VGND sky130_fd_pr__nfet_01v8 w=8 l=0.15 nf=1 m=1
XDAC_LOP_ACQUIRE_P VINP DAC__SAMPLEB DAC__LOP VPWR sky130_fd_pr__pfet_01v8_hvt w=12 l=0.15 nf=1 m=1
XDAC_LOP_CONVERT_N VGND DAC__SAMPLEB DAC__LOP VGND sky130_fd_pr__nfet_01v8 w=8 l=0.15 nf=1 m=1
XDAC_LOP_CONVERT_P VGND SAMPLE DAC__LOP VPWR sky130_fd_pr__pfet_01v8_hvt w=12 l=0.15 nf=1 m=1
XDAC_N_BANK0_B0_SW_HIGH_N DAC__LON B12 DAC__N_BANK0_B0 VGND sky130_fd_pr__nfet_01v8 w=8 l=0.15 nf=1 m=1
XDAC_N_BANK0_B0_SW_HIGH_P DAC__LON DAC__N_BANK0_B0_SW__BITB DAC__N_BANK0_B0 VPWR sky130_fd_pr__pfet_01v8_hvt w=12 l=0.15 nf=1 m=1
XDAC_N_BANK0_B0_SW_INV_MN DAC__N_BANK0_B0_SW__BITB B12 VGND VGND sky130_fd_pr__nfet_01v8 w=0.65 l=0.15 nf=1 m=1
XDAC_N_BANK0_B0_SW_INV_MP DAC__N_BANK0_B0_SW__BITB B12 VPWR VPWR sky130_fd_pr__pfet_01v8_hvt w=0.65 l=0.15 nf=1 m=1
XDAC_N_BANK0_B0_SW_LOW_N DAC__HIN DAC__N_BANK0_B0_SW__BITB DAC__N_BANK0_B0 VGND sky130_fd_pr__nfet_01v8 w=8 l=0.15 nf=1 m=1
XDAC_N_BANK0_B0_SW_LOW_P DAC__HIN B12 DAC__N_BANK0_B0 VPWR sky130_fd_pr__pfet_01v8_hvt w=12 l=0.15 nf=1 m=1
XDAC_N_BANK0_B0_U0_C_UNIT_P0 TOPN DAC__N_BANK0_B0 sky130_fd_pr__cap_mim_m3_1 w=22.17 l=22.17
XDAC_N_BANK0_B0_U1_C_UNIT_P0 TOPN DAC__N_BANK0_B0 sky130_fd_pr__cap_mim_m3_1 w=22.17 l=22.17
XDAC_N_BANK0_B1_SW_HIGH_N DAC__LON B13 DAC__N_BANK0_B1 VGND sky130_fd_pr__nfet_01v8 w=8 l=0.15 nf=1 m=1
XDAC_N_BANK0_B1_SW_HIGH_P DAC__LON DAC__N_BANK0_B1_SW__BITB DAC__N_BANK0_B1 VPWR sky130_fd_pr__pfet_01v8_hvt w=12 l=0.15 nf=1 m=1
XDAC_N_BANK0_B1_SW_INV_MN DAC__N_BANK0_B1_SW__BITB B13 VGND VGND sky130_fd_pr__nfet_01v8 w=0.65 l=0.15 nf=1 m=1
XDAC_N_BANK0_B1_SW_INV_MP DAC__N_BANK0_B1_SW__BITB B13 VPWR VPWR sky130_fd_pr__pfet_01v8_hvt w=0.65 l=0.15 nf=1 m=1
XDAC_N_BANK0_B1_SW_LOW_N DAC__HIN DAC__N_BANK0_B1_SW__BITB DAC__N_BANK0_B1 VGND sky130_fd_pr__nfet_01v8 w=8 l=0.15 nf=1 m=1
XDAC_N_BANK0_B1_SW_LOW_P DAC__HIN B13 DAC__N_BANK0_B1 VPWR sky130_fd_pr__pfet_01v8_hvt w=12 l=0.15 nf=1 m=1
XDAC_N_BANK0_B1_U0_C_UNIT_P0 TOPN DAC__N_BANK0_B1 sky130_fd_pr__cap_mim_m3_1 w=22.17 l=22.17
XDAC_N_BANK0_B1_U1_C_UNIT_P0 TOPN DAC__N_BANK0_B1 sky130_fd_pr__cap_mim_m3_1 w=22.17 l=22.17
XDAC_N_BANK0_B1_U2_C_UNIT_P0 TOPN DAC__N_BANK0_B1 sky130_fd_pr__cap_mim_m3_1 w=22.17 l=22.17
XDAC_N_BANK0_B1_U3_C_UNIT_P0 TOPN DAC__N_BANK0_B1 sky130_fd_pr__cap_mim_m3_1 w=22.17 l=22.17
XDAC_N_BANK0_B2_SW_HIGH_N DAC__LON B14 DAC__N_BANK0_B2 VGND sky130_fd_pr__nfet_01v8 w=8 l=0.15 nf=1 m=1
XDAC_N_BANK0_B2_SW_HIGH_P DAC__LON DAC__N_BANK0_B2_SW__BITB DAC__N_BANK0_B2 VPWR sky130_fd_pr__pfet_01v8_hvt w=12 l=0.15 nf=1 m=1
XDAC_N_BANK0_B2_SW_INV_MN DAC__N_BANK0_B2_SW__BITB B14 VGND VGND sky130_fd_pr__nfet_01v8 w=0.65 l=0.15 nf=1 m=1
XDAC_N_BANK0_B2_SW_INV_MP DAC__N_BANK0_B2_SW__BITB B14 VPWR VPWR sky130_fd_pr__pfet_01v8_hvt w=0.65 l=0.15 nf=1 m=1
XDAC_N_BANK0_B2_SW_LOW_N DAC__HIN DAC__N_BANK0_B2_SW__BITB DAC__N_BANK0_B2 VGND sky130_fd_pr__nfet_01v8 w=8 l=0.15 nf=1 m=1
XDAC_N_BANK0_B2_SW_LOW_P DAC__HIN B14 DAC__N_BANK0_B2 VPWR sky130_fd_pr__pfet_01v8_hvt w=12 l=0.15 nf=1 m=1
XDAC_N_BANK0_B2_U0_C_UNIT_P0 TOPN DAC__N_BANK0_B2 sky130_fd_pr__cap_mim_m3_1 w=22.17 l=22.17
XDAC_N_BANK0_B2_U1_C_UNIT_P0 TOPN DAC__N_BANK0_B2 sky130_fd_pr__cap_mim_m3_1 w=22.17 l=22.17
XDAC_N_BANK0_B2_U2_C_UNIT_P0 TOPN DAC__N_BANK0_B2 sky130_fd_pr__cap_mim_m3_1 w=22.17 l=22.17
XDAC_N_BANK0_B2_U3_C_UNIT_P0 TOPN DAC__N_BANK0_B2 sky130_fd_pr__cap_mim_m3_1 w=22.17 l=22.17
XDAC_N_BANK0_B2_U4_C_UNIT_P0 TOPN DAC__N_BANK0_B2 sky130_fd_pr__cap_mim_m3_1 w=22.17 l=22.17
XDAC_N_BANK0_B2_U5_C_UNIT_P0 TOPN DAC__N_BANK0_B2 sky130_fd_pr__cap_mim_m3_1 w=22.17 l=22.17
XDAC_N_BANK0_B2_U6_C_UNIT_P0 TOPN DAC__N_BANK0_B2 sky130_fd_pr__cap_mim_m3_1 w=22.17 l=22.17
XDAC_N_BANK0_B2_U7_C_UNIT_P0 TOPN DAC__N_BANK0_B2 sky130_fd_pr__cap_mim_m3_1 w=22.17 l=22.17
XDAC_N_BANK0_B3_SW_HIGH_N DAC__LON B15 DAC__N_BANK0_B3 VGND sky130_fd_pr__nfet_01v8 w=8 l=0.15 nf=1 m=1
XDAC_N_BANK0_B3_SW_HIGH_P DAC__LON DAC__N_BANK0_B3_SW__BITB DAC__N_BANK0_B3 VPWR sky130_fd_pr__pfet_01v8_hvt w=12 l=0.15 nf=1 m=1
XDAC_N_BANK0_B3_SW_INV_MN DAC__N_BANK0_B3_SW__BITB B15 VGND VGND sky130_fd_pr__nfet_01v8 w=0.65 l=0.15 nf=1 m=1
XDAC_N_BANK0_B3_SW_INV_MP DAC__N_BANK0_B3_SW__BITB B15 VPWR VPWR sky130_fd_pr__pfet_01v8_hvt w=0.65 l=0.15 nf=1 m=1
XDAC_N_BANK0_B3_SW_LOW_N DAC__HIN DAC__N_BANK0_B3_SW__BITB DAC__N_BANK0_B3 VGND sky130_fd_pr__nfet_01v8 w=8 l=0.15 nf=1 m=1
XDAC_N_BANK0_B3_SW_LOW_P DAC__HIN B15 DAC__N_BANK0_B3 VPWR sky130_fd_pr__pfet_01v8_hvt w=12 l=0.15 nf=1 m=1
XDAC_N_BANK0_B3_U0_C_UNIT_P0 TOPN DAC__N_BANK0_B3 sky130_fd_pr__cap_mim_m3_1 w=22.17 l=22.17
XDAC_N_BANK0_B3_U1_C_UNIT_P0 TOPN DAC__N_BANK0_B3 sky130_fd_pr__cap_mim_m3_1 w=22.17 l=22.17
XDAC_N_BANK0_B3_U10_C_UNIT_P0 TOPN DAC__N_BANK0_B3 sky130_fd_pr__cap_mim_m3_1 w=22.17 l=22.17
XDAC_N_BANK0_B3_U11_C_UNIT_P0 TOPN DAC__N_BANK0_B3 sky130_fd_pr__cap_mim_m3_1 w=22.17 l=22.17
XDAC_N_BANK0_B3_U12_C_UNIT_P0 TOPN DAC__N_BANK0_B3 sky130_fd_pr__cap_mim_m3_1 w=22.17 l=22.17
XDAC_N_BANK0_B3_U13_C_UNIT_P0 TOPN DAC__N_BANK0_B3 sky130_fd_pr__cap_mim_m3_1 w=22.17 l=22.17
XDAC_N_BANK0_B3_U14_C_UNIT_P0 TOPN DAC__N_BANK0_B3 sky130_fd_pr__cap_mim_m3_1 w=22.17 l=22.17
XDAC_N_BANK0_B3_U15_C_UNIT_P0 TOPN DAC__N_BANK0_B3 sky130_fd_pr__cap_mim_m3_1 w=22.17 l=22.17
XDAC_N_BANK0_B3_U2_C_UNIT_P0 TOPN DAC__N_BANK0_B3 sky130_fd_pr__cap_mim_m3_1 w=22.17 l=22.17
XDAC_N_BANK0_B3_U3_C_UNIT_P0 TOPN DAC__N_BANK0_B3 sky130_fd_pr__cap_mim_m3_1 w=22.17 l=22.17
XDAC_N_BANK0_B3_U4_C_UNIT_P0 TOPN DAC__N_BANK0_B3 sky130_fd_pr__cap_mim_m3_1 w=22.17 l=22.17
XDAC_N_BANK0_B3_U5_C_UNIT_P0 TOPN DAC__N_BANK0_B3 sky130_fd_pr__cap_mim_m3_1 w=22.17 l=22.17
XDAC_N_BANK0_B3_U6_C_UNIT_P0 TOPN DAC__N_BANK0_B3 sky130_fd_pr__cap_mim_m3_1 w=22.17 l=22.17
XDAC_N_BANK0_B3_U7_C_UNIT_P0 TOPN DAC__N_BANK0_B3 sky130_fd_pr__cap_mim_m3_1 w=22.17 l=22.17
XDAC_N_BANK0_B3_U8_C_UNIT_P0 TOPN DAC__N_BANK0_B3 sky130_fd_pr__cap_mim_m3_1 w=22.17 l=22.17
XDAC_N_BANK0_B3_U9_C_UNIT_P0 TOPN DAC__N_BANK0_B3 sky130_fd_pr__cap_mim_m3_1 w=22.17 l=22.17
XDAC_N_BANK1_B0_SW_HIGH_N DAC__LON B8 DAC__N_BANK1_B0 VGND sky130_fd_pr__nfet_01v8 w=8 l=0.15 nf=1 m=1
XDAC_N_BANK1_B0_SW_HIGH_P DAC__LON DAC__N_BANK1_B0_SW__BITB DAC__N_BANK1_B0 VPWR sky130_fd_pr__pfet_01v8_hvt w=12 l=0.15 nf=1 m=1
XDAC_N_BANK1_B0_SW_INV_MN DAC__N_BANK1_B0_SW__BITB B8 VGND VGND sky130_fd_pr__nfet_01v8 w=0.65 l=0.15 nf=1 m=1
XDAC_N_BANK1_B0_SW_INV_MP DAC__N_BANK1_B0_SW__BITB B8 VPWR VPWR sky130_fd_pr__pfet_01v8_hvt w=0.65 l=0.15 nf=1 m=1
XDAC_N_BANK1_B0_SW_LOW_N DAC__HIN DAC__N_BANK1_B0_SW__BITB DAC__N_BANK1_B0 VGND sky130_fd_pr__nfet_01v8 w=8 l=0.15 nf=1 m=1
XDAC_N_BANK1_B0_SW_LOW_P DAC__HIN B8 DAC__N_BANK1_B0 VPWR sky130_fd_pr__pfet_01v8_hvt w=12 l=0.15 nf=1 m=1
XDAC_N_BANK1_B0_U0_C_UNIT_P0 DAC__BANK1N DAC__N_BANK1_B0 sky130_fd_pr__cap_mim_m3_1 w=22.17 l=22.17
XDAC_N_BANK1_B0_U1_C_UNIT_P0 DAC__BANK1N DAC__N_BANK1_B0 sky130_fd_pr__cap_mim_m3_1 w=22.17 l=22.17
XDAC_N_BANK1_B1_SW_HIGH_N DAC__LON B9 DAC__N_BANK1_B1 VGND sky130_fd_pr__nfet_01v8 w=8 l=0.15 nf=1 m=1
XDAC_N_BANK1_B1_SW_HIGH_P DAC__LON DAC__N_BANK1_B1_SW__BITB DAC__N_BANK1_B1 VPWR sky130_fd_pr__pfet_01v8_hvt w=12 l=0.15 nf=1 m=1
XDAC_N_BANK1_B1_SW_INV_MN DAC__N_BANK1_B1_SW__BITB B9 VGND VGND sky130_fd_pr__nfet_01v8 w=0.65 l=0.15 nf=1 m=1
XDAC_N_BANK1_B1_SW_INV_MP DAC__N_BANK1_B1_SW__BITB B9 VPWR VPWR sky130_fd_pr__pfet_01v8_hvt w=0.65 l=0.15 nf=1 m=1
XDAC_N_BANK1_B1_SW_LOW_N DAC__HIN DAC__N_BANK1_B1_SW__BITB DAC__N_BANK1_B1 VGND sky130_fd_pr__nfet_01v8 w=8 l=0.15 nf=1 m=1
XDAC_N_BANK1_B1_SW_LOW_P DAC__HIN B9 DAC__N_BANK1_B1 VPWR sky130_fd_pr__pfet_01v8_hvt w=12 l=0.15 nf=1 m=1
XDAC_N_BANK1_B1_U0_C_UNIT_P0 DAC__BANK1N DAC__N_BANK1_B1 sky130_fd_pr__cap_mim_m3_1 w=22.17 l=22.17
XDAC_N_BANK1_B1_U1_C_UNIT_P0 DAC__BANK1N DAC__N_BANK1_B1 sky130_fd_pr__cap_mim_m3_1 w=22.17 l=22.17
XDAC_N_BANK1_B1_U2_C_UNIT_P0 DAC__BANK1N DAC__N_BANK1_B1 sky130_fd_pr__cap_mim_m3_1 w=22.17 l=22.17
XDAC_N_BANK1_B1_U3_C_UNIT_P0 DAC__BANK1N DAC__N_BANK1_B1 sky130_fd_pr__cap_mim_m3_1 w=22.17 l=22.17
XDAC_N_BANK1_B2_SW_HIGH_N DAC__LON B10 DAC__N_BANK1_B2 VGND sky130_fd_pr__nfet_01v8 w=8 l=0.15 nf=1 m=1
XDAC_N_BANK1_B2_SW_HIGH_P DAC__LON DAC__N_BANK1_B2_SW__BITB DAC__N_BANK1_B2 VPWR sky130_fd_pr__pfet_01v8_hvt w=12 l=0.15 nf=1 m=1
XDAC_N_BANK1_B2_SW_INV_MN DAC__N_BANK1_B2_SW__BITB B10 VGND VGND sky130_fd_pr__nfet_01v8 w=0.65 l=0.15 nf=1 m=1
XDAC_N_BANK1_B2_SW_INV_MP DAC__N_BANK1_B2_SW__BITB B10 VPWR VPWR sky130_fd_pr__pfet_01v8_hvt w=0.65 l=0.15 nf=1 m=1
XDAC_N_BANK1_B2_SW_LOW_N DAC__HIN DAC__N_BANK1_B2_SW__BITB DAC__N_BANK1_B2 VGND sky130_fd_pr__nfet_01v8 w=8 l=0.15 nf=1 m=1
XDAC_N_BANK1_B2_SW_LOW_P DAC__HIN B10 DAC__N_BANK1_B2 VPWR sky130_fd_pr__pfet_01v8_hvt w=12 l=0.15 nf=1 m=1
XDAC_N_BANK1_B2_U0_C_UNIT_P0 DAC__BANK1N DAC__N_BANK1_B2 sky130_fd_pr__cap_mim_m3_1 w=22.17 l=22.17
XDAC_N_BANK1_B2_U1_C_UNIT_P0 DAC__BANK1N DAC__N_BANK1_B2 sky130_fd_pr__cap_mim_m3_1 w=22.17 l=22.17
XDAC_N_BANK1_B2_U2_C_UNIT_P0 DAC__BANK1N DAC__N_BANK1_B2 sky130_fd_pr__cap_mim_m3_1 w=22.17 l=22.17
XDAC_N_BANK1_B2_U3_C_UNIT_P0 DAC__BANK1N DAC__N_BANK1_B2 sky130_fd_pr__cap_mim_m3_1 w=22.17 l=22.17
XDAC_N_BANK1_B2_U4_C_UNIT_P0 DAC__BANK1N DAC__N_BANK1_B2 sky130_fd_pr__cap_mim_m3_1 w=22.17 l=22.17
XDAC_N_BANK1_B2_U5_C_UNIT_P0 DAC__BANK1N DAC__N_BANK1_B2 sky130_fd_pr__cap_mim_m3_1 w=22.17 l=22.17
XDAC_N_BANK1_B2_U6_C_UNIT_P0 DAC__BANK1N DAC__N_BANK1_B2 sky130_fd_pr__cap_mim_m3_1 w=22.17 l=22.17
XDAC_N_BANK1_B2_U7_C_UNIT_P0 DAC__BANK1N DAC__N_BANK1_B2 sky130_fd_pr__cap_mim_m3_1 w=22.17 l=22.17
XDAC_N_BANK1_B3_SW_HIGH_N DAC__LON B11 DAC__N_BANK1_B3 VGND sky130_fd_pr__nfet_01v8 w=8 l=0.15 nf=1 m=1
XDAC_N_BANK1_B3_SW_HIGH_P DAC__LON DAC__N_BANK1_B3_SW__BITB DAC__N_BANK1_B3 VPWR sky130_fd_pr__pfet_01v8_hvt w=12 l=0.15 nf=1 m=1
XDAC_N_BANK1_B3_SW_INV_MN DAC__N_BANK1_B3_SW__BITB B11 VGND VGND sky130_fd_pr__nfet_01v8 w=0.65 l=0.15 nf=1 m=1
XDAC_N_BANK1_B3_SW_INV_MP DAC__N_BANK1_B3_SW__BITB B11 VPWR VPWR sky130_fd_pr__pfet_01v8_hvt w=0.65 l=0.15 nf=1 m=1
XDAC_N_BANK1_B3_SW_LOW_N DAC__HIN DAC__N_BANK1_B3_SW__BITB DAC__N_BANK1_B3 VGND sky130_fd_pr__nfet_01v8 w=8 l=0.15 nf=1 m=1
XDAC_N_BANK1_B3_SW_LOW_P DAC__HIN B11 DAC__N_BANK1_B3 VPWR sky130_fd_pr__pfet_01v8_hvt w=12 l=0.15 nf=1 m=1
XDAC_N_BANK1_B3_U0_C_UNIT_P0 DAC__BANK1N DAC__N_BANK1_B3 sky130_fd_pr__cap_mim_m3_1 w=22.17 l=22.17
XDAC_N_BANK1_B3_U1_C_UNIT_P0 DAC__BANK1N DAC__N_BANK1_B3 sky130_fd_pr__cap_mim_m3_1 w=22.17 l=22.17
XDAC_N_BANK1_B3_U10_C_UNIT_P0 DAC__BANK1N DAC__N_BANK1_B3 sky130_fd_pr__cap_mim_m3_1 w=22.17 l=22.17
XDAC_N_BANK1_B3_U11_C_UNIT_P0 DAC__BANK1N DAC__N_BANK1_B3 sky130_fd_pr__cap_mim_m3_1 w=22.17 l=22.17
XDAC_N_BANK1_B3_U12_C_UNIT_P0 DAC__BANK1N DAC__N_BANK1_B3 sky130_fd_pr__cap_mim_m3_1 w=22.17 l=22.17
XDAC_N_BANK1_B3_U13_C_UNIT_P0 DAC__BANK1N DAC__N_BANK1_B3 sky130_fd_pr__cap_mim_m3_1 w=22.17 l=22.17
XDAC_N_BANK1_B3_U14_C_UNIT_P0 DAC__BANK1N DAC__N_BANK1_B3 sky130_fd_pr__cap_mim_m3_1 w=22.17 l=22.17
XDAC_N_BANK1_B3_U15_C_UNIT_P0 DAC__BANK1N DAC__N_BANK1_B3 sky130_fd_pr__cap_mim_m3_1 w=22.17 l=22.17
XDAC_N_BANK1_B3_U2_C_UNIT_P0 DAC__BANK1N DAC__N_BANK1_B3 sky130_fd_pr__cap_mim_m3_1 w=22.17 l=22.17
XDAC_N_BANK1_B3_U3_C_UNIT_P0 DAC__BANK1N DAC__N_BANK1_B3 sky130_fd_pr__cap_mim_m3_1 w=22.17 l=22.17
XDAC_N_BANK1_B3_U4_C_UNIT_P0 DAC__BANK1N DAC__N_BANK1_B3 sky130_fd_pr__cap_mim_m3_1 w=22.17 l=22.17
XDAC_N_BANK1_B3_U5_C_UNIT_P0 DAC__BANK1N DAC__N_BANK1_B3 sky130_fd_pr__cap_mim_m3_1 w=22.17 l=22.17
XDAC_N_BANK1_B3_U6_C_UNIT_P0 DAC__BANK1N DAC__N_BANK1_B3 sky130_fd_pr__cap_mim_m3_1 w=22.17 l=22.17
XDAC_N_BANK1_B3_U7_C_UNIT_P0 DAC__BANK1N DAC__N_BANK1_B3 sky130_fd_pr__cap_mim_m3_1 w=22.17 l=22.17
XDAC_N_BANK1_B3_U8_C_UNIT_P0 DAC__BANK1N DAC__N_BANK1_B3 sky130_fd_pr__cap_mim_m3_1 w=22.17 l=22.17
XDAC_N_BANK1_B3_U9_C_UNIT_P0 DAC__BANK1N DAC__N_BANK1_B3 sky130_fd_pr__cap_mim_m3_1 w=22.17 l=22.17
XDAC_N_BANK2_B0_SW_HIGH_N DAC__LON B4 DAC__N_BANK2_B0 VGND sky130_fd_pr__nfet_01v8 w=8 l=0.15 nf=1 m=1
XDAC_N_BANK2_B0_SW_HIGH_P DAC__LON DAC__N_BANK2_B0_SW__BITB DAC__N_BANK2_B0 VPWR sky130_fd_pr__pfet_01v8_hvt w=12 l=0.15 nf=1 m=1
XDAC_N_BANK2_B0_SW_INV_MN DAC__N_BANK2_B0_SW__BITB B4 VGND VGND sky130_fd_pr__nfet_01v8 w=0.65 l=0.15 nf=1 m=1
XDAC_N_BANK2_B0_SW_INV_MP DAC__N_BANK2_B0_SW__BITB B4 VPWR VPWR sky130_fd_pr__pfet_01v8_hvt w=0.65 l=0.15 nf=1 m=1
XDAC_N_BANK2_B0_SW_LOW_N DAC__HIN DAC__N_BANK2_B0_SW__BITB DAC__N_BANK2_B0 VGND sky130_fd_pr__nfet_01v8 w=8 l=0.15 nf=1 m=1
XDAC_N_BANK2_B0_SW_LOW_P DAC__HIN B4 DAC__N_BANK2_B0 VPWR sky130_fd_pr__pfet_01v8_hvt w=12 l=0.15 nf=1 m=1
XDAC_N_BANK2_B0_U0_C_UNIT_P0 DAC__BANK2N DAC__N_BANK2_B0 sky130_fd_pr__cap_mim_m3_1 w=22.17 l=22.17
XDAC_N_BANK2_B0_U1_C_UNIT_P0 DAC__BANK2N DAC__N_BANK2_B0 sky130_fd_pr__cap_mim_m3_1 w=22.17 l=22.17
XDAC_N_BANK2_B1_SW_HIGH_N DAC__LON B5 DAC__N_BANK2_B1 VGND sky130_fd_pr__nfet_01v8 w=8 l=0.15 nf=1 m=1
XDAC_N_BANK2_B1_SW_HIGH_P DAC__LON DAC__N_BANK2_B1_SW__BITB DAC__N_BANK2_B1 VPWR sky130_fd_pr__pfet_01v8_hvt w=12 l=0.15 nf=1 m=1
XDAC_N_BANK2_B1_SW_INV_MN DAC__N_BANK2_B1_SW__BITB B5 VGND VGND sky130_fd_pr__nfet_01v8 w=0.65 l=0.15 nf=1 m=1
XDAC_N_BANK2_B1_SW_INV_MP DAC__N_BANK2_B1_SW__BITB B5 VPWR VPWR sky130_fd_pr__pfet_01v8_hvt w=0.65 l=0.15 nf=1 m=1
XDAC_N_BANK2_B1_SW_LOW_N DAC__HIN DAC__N_BANK2_B1_SW__BITB DAC__N_BANK2_B1 VGND sky130_fd_pr__nfet_01v8 w=8 l=0.15 nf=1 m=1
XDAC_N_BANK2_B1_SW_LOW_P DAC__HIN B5 DAC__N_BANK2_B1 VPWR sky130_fd_pr__pfet_01v8_hvt w=12 l=0.15 nf=1 m=1
XDAC_N_BANK2_B1_U0_C_UNIT_P0 DAC__BANK2N DAC__N_BANK2_B1 sky130_fd_pr__cap_mim_m3_1 w=22.17 l=22.17
XDAC_N_BANK2_B1_U1_C_UNIT_P0 DAC__BANK2N DAC__N_BANK2_B1 sky130_fd_pr__cap_mim_m3_1 w=22.17 l=22.17
XDAC_N_BANK2_B1_U2_C_UNIT_P0 DAC__BANK2N DAC__N_BANK2_B1 sky130_fd_pr__cap_mim_m3_1 w=22.17 l=22.17
XDAC_N_BANK2_B1_U3_C_UNIT_P0 DAC__BANK2N DAC__N_BANK2_B1 sky130_fd_pr__cap_mim_m3_1 w=22.17 l=22.17
XDAC_N_BANK2_B2_SW_HIGH_N DAC__LON B6 DAC__N_BANK2_B2 VGND sky130_fd_pr__nfet_01v8 w=8 l=0.15 nf=1 m=1
XDAC_N_BANK2_B2_SW_HIGH_P DAC__LON DAC__N_BANK2_B2_SW__BITB DAC__N_BANK2_B2 VPWR sky130_fd_pr__pfet_01v8_hvt w=12 l=0.15 nf=1 m=1
XDAC_N_BANK2_B2_SW_INV_MN DAC__N_BANK2_B2_SW__BITB B6 VGND VGND sky130_fd_pr__nfet_01v8 w=0.65 l=0.15 nf=1 m=1
XDAC_N_BANK2_B2_SW_INV_MP DAC__N_BANK2_B2_SW__BITB B6 VPWR VPWR sky130_fd_pr__pfet_01v8_hvt w=0.65 l=0.15 nf=1 m=1
XDAC_N_BANK2_B2_SW_LOW_N DAC__HIN DAC__N_BANK2_B2_SW__BITB DAC__N_BANK2_B2 VGND sky130_fd_pr__nfet_01v8 w=8 l=0.15 nf=1 m=1
XDAC_N_BANK2_B2_SW_LOW_P DAC__HIN B6 DAC__N_BANK2_B2 VPWR sky130_fd_pr__pfet_01v8_hvt w=12 l=0.15 nf=1 m=1
XDAC_N_BANK2_B2_U0_C_UNIT_P0 DAC__BANK2N DAC__N_BANK2_B2 sky130_fd_pr__cap_mim_m3_1 w=22.17 l=22.17
XDAC_N_BANK2_B2_U1_C_UNIT_P0 DAC__BANK2N DAC__N_BANK2_B2 sky130_fd_pr__cap_mim_m3_1 w=22.17 l=22.17
XDAC_N_BANK2_B2_U2_C_UNIT_P0 DAC__BANK2N DAC__N_BANK2_B2 sky130_fd_pr__cap_mim_m3_1 w=22.17 l=22.17
XDAC_N_BANK2_B2_U3_C_UNIT_P0 DAC__BANK2N DAC__N_BANK2_B2 sky130_fd_pr__cap_mim_m3_1 w=22.17 l=22.17
XDAC_N_BANK2_B2_U4_C_UNIT_P0 DAC__BANK2N DAC__N_BANK2_B2 sky130_fd_pr__cap_mim_m3_1 w=22.17 l=22.17
XDAC_N_BANK2_B2_U5_C_UNIT_P0 DAC__BANK2N DAC__N_BANK2_B2 sky130_fd_pr__cap_mim_m3_1 w=22.17 l=22.17
XDAC_N_BANK2_B2_U6_C_UNIT_P0 DAC__BANK2N DAC__N_BANK2_B2 sky130_fd_pr__cap_mim_m3_1 w=22.17 l=22.17
XDAC_N_BANK2_B2_U7_C_UNIT_P0 DAC__BANK2N DAC__N_BANK2_B2 sky130_fd_pr__cap_mim_m3_1 w=22.17 l=22.17
XDAC_N_BANK2_B3_SW_HIGH_N DAC__LON B7 DAC__N_BANK2_B3 VGND sky130_fd_pr__nfet_01v8 w=8 l=0.15 nf=1 m=1
XDAC_N_BANK2_B3_SW_HIGH_P DAC__LON DAC__N_BANK2_B3_SW__BITB DAC__N_BANK2_B3 VPWR sky130_fd_pr__pfet_01v8_hvt w=12 l=0.15 nf=1 m=1
XDAC_N_BANK2_B3_SW_INV_MN DAC__N_BANK2_B3_SW__BITB B7 VGND VGND sky130_fd_pr__nfet_01v8 w=0.65 l=0.15 nf=1 m=1
XDAC_N_BANK2_B3_SW_INV_MP DAC__N_BANK2_B3_SW__BITB B7 VPWR VPWR sky130_fd_pr__pfet_01v8_hvt w=0.65 l=0.15 nf=1 m=1
XDAC_N_BANK2_B3_SW_LOW_N DAC__HIN DAC__N_BANK2_B3_SW__BITB DAC__N_BANK2_B3 VGND sky130_fd_pr__nfet_01v8 w=8 l=0.15 nf=1 m=1
XDAC_N_BANK2_B3_SW_LOW_P DAC__HIN B7 DAC__N_BANK2_B3 VPWR sky130_fd_pr__pfet_01v8_hvt w=12 l=0.15 nf=1 m=1
XDAC_N_BANK2_B3_U0_C_UNIT_P0 DAC__BANK2N DAC__N_BANK2_B3 sky130_fd_pr__cap_mim_m3_1 w=22.17 l=22.17
XDAC_N_BANK2_B3_U1_C_UNIT_P0 DAC__BANK2N DAC__N_BANK2_B3 sky130_fd_pr__cap_mim_m3_1 w=22.17 l=22.17
XDAC_N_BANK2_B3_U10_C_UNIT_P0 DAC__BANK2N DAC__N_BANK2_B3 sky130_fd_pr__cap_mim_m3_1 w=22.17 l=22.17
XDAC_N_BANK2_B3_U11_C_UNIT_P0 DAC__BANK2N DAC__N_BANK2_B3 sky130_fd_pr__cap_mim_m3_1 w=22.17 l=22.17
XDAC_N_BANK2_B3_U12_C_UNIT_P0 DAC__BANK2N DAC__N_BANK2_B3 sky130_fd_pr__cap_mim_m3_1 w=22.17 l=22.17
XDAC_N_BANK2_B3_U13_C_UNIT_P0 DAC__BANK2N DAC__N_BANK2_B3 sky130_fd_pr__cap_mim_m3_1 w=22.17 l=22.17
XDAC_N_BANK2_B3_U14_C_UNIT_P0 DAC__BANK2N DAC__N_BANK2_B3 sky130_fd_pr__cap_mim_m3_1 w=22.17 l=22.17
XDAC_N_BANK2_B3_U15_C_UNIT_P0 DAC__BANK2N DAC__N_BANK2_B3 sky130_fd_pr__cap_mim_m3_1 w=22.17 l=22.17
XDAC_N_BANK2_B3_U2_C_UNIT_P0 DAC__BANK2N DAC__N_BANK2_B3 sky130_fd_pr__cap_mim_m3_1 w=22.17 l=22.17
XDAC_N_BANK2_B3_U3_C_UNIT_P0 DAC__BANK2N DAC__N_BANK2_B3 sky130_fd_pr__cap_mim_m3_1 w=22.17 l=22.17
XDAC_N_BANK2_B3_U4_C_UNIT_P0 DAC__BANK2N DAC__N_BANK2_B3 sky130_fd_pr__cap_mim_m3_1 w=22.17 l=22.17
XDAC_N_BANK2_B3_U5_C_UNIT_P0 DAC__BANK2N DAC__N_BANK2_B3 sky130_fd_pr__cap_mim_m3_1 w=22.17 l=22.17
XDAC_N_BANK2_B3_U6_C_UNIT_P0 DAC__BANK2N DAC__N_BANK2_B3 sky130_fd_pr__cap_mim_m3_1 w=22.17 l=22.17
XDAC_N_BANK2_B3_U7_C_UNIT_P0 DAC__BANK2N DAC__N_BANK2_B3 sky130_fd_pr__cap_mim_m3_1 w=22.17 l=22.17
XDAC_N_BANK2_B3_U8_C_UNIT_P0 DAC__BANK2N DAC__N_BANK2_B3 sky130_fd_pr__cap_mim_m3_1 w=22.17 l=22.17
XDAC_N_BANK2_B3_U9_C_UNIT_P0 DAC__BANK2N DAC__N_BANK2_B3 sky130_fd_pr__cap_mim_m3_1 w=22.17 l=22.17
XDAC_N_BANK3_B0_SW_HIGH_N DAC__LON B0 DAC__N_BANK3_B0 VGND sky130_fd_pr__nfet_01v8 w=8 l=0.15 nf=1 m=1
XDAC_N_BANK3_B0_SW_HIGH_P DAC__LON DAC__N_BANK3_B0_SW__BITB DAC__N_BANK3_B0 VPWR sky130_fd_pr__pfet_01v8_hvt w=12 l=0.15 nf=1 m=1
XDAC_N_BANK3_B0_SW_INV_MN DAC__N_BANK3_B0_SW__BITB B0 VGND VGND sky130_fd_pr__nfet_01v8 w=0.65 l=0.15 nf=1 m=1
XDAC_N_BANK3_B0_SW_INV_MP DAC__N_BANK3_B0_SW__BITB B0 VPWR VPWR sky130_fd_pr__pfet_01v8_hvt w=0.65 l=0.15 nf=1 m=1
XDAC_N_BANK3_B0_SW_LOW_N DAC__HIN DAC__N_BANK3_B0_SW__BITB DAC__N_BANK3_B0 VGND sky130_fd_pr__nfet_01v8 w=8 l=0.15 nf=1 m=1
XDAC_N_BANK3_B0_SW_LOW_P DAC__HIN B0 DAC__N_BANK3_B0 VPWR sky130_fd_pr__pfet_01v8_hvt w=12 l=0.15 nf=1 m=1
XDAC_N_BANK3_B0_U0_C_UNIT_P0 DAC__BANK3N DAC__N_BANK3_B0 sky130_fd_pr__cap_mim_m3_1 w=22.17 l=22.17
XDAC_N_BANK3_B0_U1_C_UNIT_P0 DAC__BANK3N DAC__N_BANK3_B0 sky130_fd_pr__cap_mim_m3_1 w=22.17 l=22.17
XDAC_N_BANK3_B1_SW_HIGH_N DAC__LON B1 DAC__N_BANK3_B1 VGND sky130_fd_pr__nfet_01v8 w=8 l=0.15 nf=1 m=1
XDAC_N_BANK3_B1_SW_HIGH_P DAC__LON DAC__N_BANK3_B1_SW__BITB DAC__N_BANK3_B1 VPWR sky130_fd_pr__pfet_01v8_hvt w=12 l=0.15 nf=1 m=1
XDAC_N_BANK3_B1_SW_INV_MN DAC__N_BANK3_B1_SW__BITB B1 VGND VGND sky130_fd_pr__nfet_01v8 w=0.65 l=0.15 nf=1 m=1
XDAC_N_BANK3_B1_SW_INV_MP DAC__N_BANK3_B1_SW__BITB B1 VPWR VPWR sky130_fd_pr__pfet_01v8_hvt w=0.65 l=0.15 nf=1 m=1
XDAC_N_BANK3_B1_SW_LOW_N DAC__HIN DAC__N_BANK3_B1_SW__BITB DAC__N_BANK3_B1 VGND sky130_fd_pr__nfet_01v8 w=8 l=0.15 nf=1 m=1
XDAC_N_BANK3_B1_SW_LOW_P DAC__HIN B1 DAC__N_BANK3_B1 VPWR sky130_fd_pr__pfet_01v8_hvt w=12 l=0.15 nf=1 m=1
XDAC_N_BANK3_B1_U0_C_UNIT_P0 DAC__BANK3N DAC__N_BANK3_B1 sky130_fd_pr__cap_mim_m3_1 w=22.17 l=22.17
XDAC_N_BANK3_B1_U1_C_UNIT_P0 DAC__BANK3N DAC__N_BANK3_B1 sky130_fd_pr__cap_mim_m3_1 w=22.17 l=22.17
XDAC_N_BANK3_B1_U2_C_UNIT_P0 DAC__BANK3N DAC__N_BANK3_B1 sky130_fd_pr__cap_mim_m3_1 w=22.17 l=22.17
XDAC_N_BANK3_B1_U3_C_UNIT_P0 DAC__BANK3N DAC__N_BANK3_B1 sky130_fd_pr__cap_mim_m3_1 w=22.17 l=22.17
XDAC_N_BANK3_B2_SW_HIGH_N DAC__LON B2 DAC__N_BANK3_B2 VGND sky130_fd_pr__nfet_01v8 w=8 l=0.15 nf=1 m=1
XDAC_N_BANK3_B2_SW_HIGH_P DAC__LON DAC__N_BANK3_B2_SW__BITB DAC__N_BANK3_B2 VPWR sky130_fd_pr__pfet_01v8_hvt w=12 l=0.15 nf=1 m=1
XDAC_N_BANK3_B2_SW_INV_MN DAC__N_BANK3_B2_SW__BITB B2 VGND VGND sky130_fd_pr__nfet_01v8 w=0.65 l=0.15 nf=1 m=1
XDAC_N_BANK3_B2_SW_INV_MP DAC__N_BANK3_B2_SW__BITB B2 VPWR VPWR sky130_fd_pr__pfet_01v8_hvt w=0.65 l=0.15 nf=1 m=1
XDAC_N_BANK3_B2_SW_LOW_N DAC__HIN DAC__N_BANK3_B2_SW__BITB DAC__N_BANK3_B2 VGND sky130_fd_pr__nfet_01v8 w=8 l=0.15 nf=1 m=1
XDAC_N_BANK3_B2_SW_LOW_P DAC__HIN B2 DAC__N_BANK3_B2 VPWR sky130_fd_pr__pfet_01v8_hvt w=12 l=0.15 nf=1 m=1
XDAC_N_BANK3_B2_U0_C_UNIT_P0 DAC__BANK3N DAC__N_BANK3_B2 sky130_fd_pr__cap_mim_m3_1 w=22.17 l=22.17
XDAC_N_BANK3_B2_U1_C_UNIT_P0 DAC__BANK3N DAC__N_BANK3_B2 sky130_fd_pr__cap_mim_m3_1 w=22.17 l=22.17
XDAC_N_BANK3_B2_U2_C_UNIT_P0 DAC__BANK3N DAC__N_BANK3_B2 sky130_fd_pr__cap_mim_m3_1 w=22.17 l=22.17
XDAC_N_BANK3_B2_U3_C_UNIT_P0 DAC__BANK3N DAC__N_BANK3_B2 sky130_fd_pr__cap_mim_m3_1 w=22.17 l=22.17
XDAC_N_BANK3_B2_U4_C_UNIT_P0 DAC__BANK3N DAC__N_BANK3_B2 sky130_fd_pr__cap_mim_m3_1 w=22.17 l=22.17
XDAC_N_BANK3_B2_U5_C_UNIT_P0 DAC__BANK3N DAC__N_BANK3_B2 sky130_fd_pr__cap_mim_m3_1 w=22.17 l=22.17
XDAC_N_BANK3_B2_U6_C_UNIT_P0 DAC__BANK3N DAC__N_BANK3_B2 sky130_fd_pr__cap_mim_m3_1 w=22.17 l=22.17
XDAC_N_BANK3_B2_U7_C_UNIT_P0 DAC__BANK3N DAC__N_BANK3_B2 sky130_fd_pr__cap_mim_m3_1 w=22.17 l=22.17
XDAC_N_BANK3_B3_SW_HIGH_N DAC__LON B3 DAC__N_BANK3_B3 VGND sky130_fd_pr__nfet_01v8 w=8 l=0.15 nf=1 m=1
XDAC_N_BANK3_B3_SW_HIGH_P DAC__LON DAC__N_BANK3_B3_SW__BITB DAC__N_BANK3_B3 VPWR sky130_fd_pr__pfet_01v8_hvt w=12 l=0.15 nf=1 m=1
XDAC_N_BANK3_B3_SW_INV_MN DAC__N_BANK3_B3_SW__BITB B3 VGND VGND sky130_fd_pr__nfet_01v8 w=0.65 l=0.15 nf=1 m=1
XDAC_N_BANK3_B3_SW_INV_MP DAC__N_BANK3_B3_SW__BITB B3 VPWR VPWR sky130_fd_pr__pfet_01v8_hvt w=0.65 l=0.15 nf=1 m=1
XDAC_N_BANK3_B3_SW_LOW_N DAC__HIN DAC__N_BANK3_B3_SW__BITB DAC__N_BANK3_B3 VGND sky130_fd_pr__nfet_01v8 w=8 l=0.15 nf=1 m=1
XDAC_N_BANK3_B3_SW_LOW_P DAC__HIN B3 DAC__N_BANK3_B3 VPWR sky130_fd_pr__pfet_01v8_hvt w=12 l=0.15 nf=1 m=1
XDAC_N_BANK3_B3_U0_C_UNIT_P0 DAC__BANK3N DAC__N_BANK3_B3 sky130_fd_pr__cap_mim_m3_1 w=22.17 l=22.17
XDAC_N_BANK3_B3_U1_C_UNIT_P0 DAC__BANK3N DAC__N_BANK3_B3 sky130_fd_pr__cap_mim_m3_1 w=22.17 l=22.17
XDAC_N_BANK3_B3_U10_C_UNIT_P0 DAC__BANK3N DAC__N_BANK3_B3 sky130_fd_pr__cap_mim_m3_1 w=22.17 l=22.17
XDAC_N_BANK3_B3_U11_C_UNIT_P0 DAC__BANK3N DAC__N_BANK3_B3 sky130_fd_pr__cap_mim_m3_1 w=22.17 l=22.17
XDAC_N_BANK3_B3_U12_C_UNIT_P0 DAC__BANK3N DAC__N_BANK3_B3 sky130_fd_pr__cap_mim_m3_1 w=22.17 l=22.17
XDAC_N_BANK3_B3_U13_C_UNIT_P0 DAC__BANK3N DAC__N_BANK3_B3 sky130_fd_pr__cap_mim_m3_1 w=22.17 l=22.17
XDAC_N_BANK3_B3_U14_C_UNIT_P0 DAC__BANK3N DAC__N_BANK3_B3 sky130_fd_pr__cap_mim_m3_1 w=22.17 l=22.17
XDAC_N_BANK3_B3_U15_C_UNIT_P0 DAC__BANK3N DAC__N_BANK3_B3 sky130_fd_pr__cap_mim_m3_1 w=22.17 l=22.17
XDAC_N_BANK3_B3_U2_C_UNIT_P0 DAC__BANK3N DAC__N_BANK3_B3 sky130_fd_pr__cap_mim_m3_1 w=22.17 l=22.17
XDAC_N_BANK3_B3_U3_C_UNIT_P0 DAC__BANK3N DAC__N_BANK3_B3 sky130_fd_pr__cap_mim_m3_1 w=22.17 l=22.17
XDAC_N_BANK3_B3_U4_C_UNIT_P0 DAC__BANK3N DAC__N_BANK3_B3 sky130_fd_pr__cap_mim_m3_1 w=22.17 l=22.17
XDAC_N_BANK3_B3_U5_C_UNIT_P0 DAC__BANK3N DAC__N_BANK3_B3 sky130_fd_pr__cap_mim_m3_1 w=22.17 l=22.17
XDAC_N_BANK3_B3_U6_C_UNIT_P0 DAC__BANK3N DAC__N_BANK3_B3 sky130_fd_pr__cap_mim_m3_1 w=22.17 l=22.17
XDAC_N_BANK3_B3_U7_C_UNIT_P0 DAC__BANK3N DAC__N_BANK3_B3 sky130_fd_pr__cap_mim_m3_1 w=22.17 l=22.17
XDAC_N_BANK3_B3_U8_C_UNIT_P0 DAC__BANK3N DAC__N_BANK3_B3 sky130_fd_pr__cap_mim_m3_1 w=22.17 l=22.17
XDAC_N_BANK3_B3_U9_C_UNIT_P0 DAC__BANK3N DAC__N_BANK3_B3 sky130_fd_pr__cap_mim_m3_1 w=22.17 l=22.17
XDAC_N_BANK3_DUMMY_U0_C_UNIT_P0 DAC__BANK3N DAC__HIN sky130_fd_pr__cap_mim_m3_1 w=22.17 l=22.17
XDAC_N_BANK3_DUMMY_U1_C_UNIT_P0 DAC__BANK3N DAC__HIN sky130_fd_pr__cap_mim_m3_1 w=22.17 l=22.17
XDAC_P_BANK0_B0_SW_HIGH_N DAC__HIP B12 DAC__P_BANK0_B0 VGND sky130_fd_pr__nfet_01v8 w=8 l=0.15 nf=1 m=1
XDAC_P_BANK0_B0_SW_HIGH_P DAC__HIP DAC__P_BANK0_B0_SW__BITB DAC__P_BANK0_B0 VPWR sky130_fd_pr__pfet_01v8_hvt w=12 l=0.15 nf=1 m=1
XDAC_P_BANK0_B0_SW_INV_MN DAC__P_BANK0_B0_SW__BITB B12 VGND VGND sky130_fd_pr__nfet_01v8 w=0.65 l=0.15 nf=1 m=1
XDAC_P_BANK0_B0_SW_INV_MP DAC__P_BANK0_B0_SW__BITB B12 VPWR VPWR sky130_fd_pr__pfet_01v8_hvt w=0.65 l=0.15 nf=1 m=1
XDAC_P_BANK0_B0_SW_LOW_N DAC__LOP DAC__P_BANK0_B0_SW__BITB DAC__P_BANK0_B0 VGND sky130_fd_pr__nfet_01v8 w=8 l=0.15 nf=1 m=1
XDAC_P_BANK0_B0_SW_LOW_P DAC__LOP B12 DAC__P_BANK0_B0 VPWR sky130_fd_pr__pfet_01v8_hvt w=12 l=0.15 nf=1 m=1
XDAC_P_BANK0_B0_U0_C_UNIT_P0 TOPP DAC__P_BANK0_B0 sky130_fd_pr__cap_mim_m3_1 w=22.17 l=22.17
XDAC_P_BANK0_B0_U1_C_UNIT_P0 TOPP DAC__P_BANK0_B0 sky130_fd_pr__cap_mim_m3_1 w=22.17 l=22.17
XDAC_P_BANK0_B1_SW_HIGH_N DAC__HIP B13 DAC__P_BANK0_B1 VGND sky130_fd_pr__nfet_01v8 w=8 l=0.15 nf=1 m=1
XDAC_P_BANK0_B1_SW_HIGH_P DAC__HIP DAC__P_BANK0_B1_SW__BITB DAC__P_BANK0_B1 VPWR sky130_fd_pr__pfet_01v8_hvt w=12 l=0.15 nf=1 m=1
XDAC_P_BANK0_B1_SW_INV_MN DAC__P_BANK0_B1_SW__BITB B13 VGND VGND sky130_fd_pr__nfet_01v8 w=0.65 l=0.15 nf=1 m=1
XDAC_P_BANK0_B1_SW_INV_MP DAC__P_BANK0_B1_SW__BITB B13 VPWR VPWR sky130_fd_pr__pfet_01v8_hvt w=0.65 l=0.15 nf=1 m=1
XDAC_P_BANK0_B1_SW_LOW_N DAC__LOP DAC__P_BANK0_B1_SW__BITB DAC__P_BANK0_B1 VGND sky130_fd_pr__nfet_01v8 w=8 l=0.15 nf=1 m=1
XDAC_P_BANK0_B1_SW_LOW_P DAC__LOP B13 DAC__P_BANK0_B1 VPWR sky130_fd_pr__pfet_01v8_hvt w=12 l=0.15 nf=1 m=1
XDAC_P_BANK0_B1_U0_C_UNIT_P0 TOPP DAC__P_BANK0_B1 sky130_fd_pr__cap_mim_m3_1 w=22.17 l=22.17
XDAC_P_BANK0_B1_U1_C_UNIT_P0 TOPP DAC__P_BANK0_B1 sky130_fd_pr__cap_mim_m3_1 w=22.17 l=22.17
XDAC_P_BANK0_B1_U2_C_UNIT_P0 TOPP DAC__P_BANK0_B1 sky130_fd_pr__cap_mim_m3_1 w=22.17 l=22.17
XDAC_P_BANK0_B1_U3_C_UNIT_P0 TOPP DAC__P_BANK0_B1 sky130_fd_pr__cap_mim_m3_1 w=22.17 l=22.17
XDAC_P_BANK0_B2_SW_HIGH_N DAC__HIP B14 DAC__P_BANK0_B2 VGND sky130_fd_pr__nfet_01v8 w=8 l=0.15 nf=1 m=1
XDAC_P_BANK0_B2_SW_HIGH_P DAC__HIP DAC__P_BANK0_B2_SW__BITB DAC__P_BANK0_B2 VPWR sky130_fd_pr__pfet_01v8_hvt w=12 l=0.15 nf=1 m=1
XDAC_P_BANK0_B2_SW_INV_MN DAC__P_BANK0_B2_SW__BITB B14 VGND VGND sky130_fd_pr__nfet_01v8 w=0.65 l=0.15 nf=1 m=1
XDAC_P_BANK0_B2_SW_INV_MP DAC__P_BANK0_B2_SW__BITB B14 VPWR VPWR sky130_fd_pr__pfet_01v8_hvt w=0.65 l=0.15 nf=1 m=1
XDAC_P_BANK0_B2_SW_LOW_N DAC__LOP DAC__P_BANK0_B2_SW__BITB DAC__P_BANK0_B2 VGND sky130_fd_pr__nfet_01v8 w=8 l=0.15 nf=1 m=1
XDAC_P_BANK0_B2_SW_LOW_P DAC__LOP B14 DAC__P_BANK0_B2 VPWR sky130_fd_pr__pfet_01v8_hvt w=12 l=0.15 nf=1 m=1
XDAC_P_BANK0_B2_U0_C_UNIT_P0 TOPP DAC__P_BANK0_B2 sky130_fd_pr__cap_mim_m3_1 w=22.17 l=22.17
XDAC_P_BANK0_B2_U1_C_UNIT_P0 TOPP DAC__P_BANK0_B2 sky130_fd_pr__cap_mim_m3_1 w=22.17 l=22.17
XDAC_P_BANK0_B2_U2_C_UNIT_P0 TOPP DAC__P_BANK0_B2 sky130_fd_pr__cap_mim_m3_1 w=22.17 l=22.17
XDAC_P_BANK0_B2_U3_C_UNIT_P0 TOPP DAC__P_BANK0_B2 sky130_fd_pr__cap_mim_m3_1 w=22.17 l=22.17
XDAC_P_BANK0_B2_U4_C_UNIT_P0 TOPP DAC__P_BANK0_B2 sky130_fd_pr__cap_mim_m3_1 w=22.17 l=22.17
XDAC_P_BANK0_B2_U5_C_UNIT_P0 TOPP DAC__P_BANK0_B2 sky130_fd_pr__cap_mim_m3_1 w=22.17 l=22.17
XDAC_P_BANK0_B2_U6_C_UNIT_P0 TOPP DAC__P_BANK0_B2 sky130_fd_pr__cap_mim_m3_1 w=22.17 l=22.17
XDAC_P_BANK0_B2_U7_C_UNIT_P0 TOPP DAC__P_BANK0_B2 sky130_fd_pr__cap_mim_m3_1 w=22.17 l=22.17
XDAC_P_BANK0_B3_SW_HIGH_N DAC__HIP B15 DAC__P_BANK0_B3 VGND sky130_fd_pr__nfet_01v8 w=8 l=0.15 nf=1 m=1
XDAC_P_BANK0_B3_SW_HIGH_P DAC__HIP DAC__P_BANK0_B3_SW__BITB DAC__P_BANK0_B3 VPWR sky130_fd_pr__pfet_01v8_hvt w=12 l=0.15 nf=1 m=1
XDAC_P_BANK0_B3_SW_INV_MN DAC__P_BANK0_B3_SW__BITB B15 VGND VGND sky130_fd_pr__nfet_01v8 w=0.65 l=0.15 nf=1 m=1
XDAC_P_BANK0_B3_SW_INV_MP DAC__P_BANK0_B3_SW__BITB B15 VPWR VPWR sky130_fd_pr__pfet_01v8_hvt w=0.65 l=0.15 nf=1 m=1
XDAC_P_BANK0_B3_SW_LOW_N DAC__LOP DAC__P_BANK0_B3_SW__BITB DAC__P_BANK0_B3 VGND sky130_fd_pr__nfet_01v8 w=8 l=0.15 nf=1 m=1
XDAC_P_BANK0_B3_SW_LOW_P DAC__LOP B15 DAC__P_BANK0_B3 VPWR sky130_fd_pr__pfet_01v8_hvt w=12 l=0.15 nf=1 m=1
XDAC_P_BANK0_B3_U0_C_UNIT_P0 TOPP DAC__P_BANK0_B3 sky130_fd_pr__cap_mim_m3_1 w=22.17 l=22.17
XDAC_P_BANK0_B3_U1_C_UNIT_P0 TOPP DAC__P_BANK0_B3 sky130_fd_pr__cap_mim_m3_1 w=22.17 l=22.17
XDAC_P_BANK0_B3_U10_C_UNIT_P0 TOPP DAC__P_BANK0_B3 sky130_fd_pr__cap_mim_m3_1 w=22.17 l=22.17
XDAC_P_BANK0_B3_U11_C_UNIT_P0 TOPP DAC__P_BANK0_B3 sky130_fd_pr__cap_mim_m3_1 w=22.17 l=22.17
XDAC_P_BANK0_B3_U12_C_UNIT_P0 TOPP DAC__P_BANK0_B3 sky130_fd_pr__cap_mim_m3_1 w=22.17 l=22.17
XDAC_P_BANK0_B3_U13_C_UNIT_P0 TOPP DAC__P_BANK0_B3 sky130_fd_pr__cap_mim_m3_1 w=22.17 l=22.17
XDAC_P_BANK0_B3_U14_C_UNIT_P0 TOPP DAC__P_BANK0_B3 sky130_fd_pr__cap_mim_m3_1 w=22.17 l=22.17
XDAC_P_BANK0_B3_U15_C_UNIT_P0 TOPP DAC__P_BANK0_B3 sky130_fd_pr__cap_mim_m3_1 w=22.17 l=22.17
XDAC_P_BANK0_B3_U2_C_UNIT_P0 TOPP DAC__P_BANK0_B3 sky130_fd_pr__cap_mim_m3_1 w=22.17 l=22.17
XDAC_P_BANK0_B3_U3_C_UNIT_P0 TOPP DAC__P_BANK0_B3 sky130_fd_pr__cap_mim_m3_1 w=22.17 l=22.17
XDAC_P_BANK0_B3_U4_C_UNIT_P0 TOPP DAC__P_BANK0_B3 sky130_fd_pr__cap_mim_m3_1 w=22.17 l=22.17
XDAC_P_BANK0_B3_U5_C_UNIT_P0 TOPP DAC__P_BANK0_B3 sky130_fd_pr__cap_mim_m3_1 w=22.17 l=22.17
XDAC_P_BANK0_B3_U6_C_UNIT_P0 TOPP DAC__P_BANK0_B3 sky130_fd_pr__cap_mim_m3_1 w=22.17 l=22.17
XDAC_P_BANK0_B3_U7_C_UNIT_P0 TOPP DAC__P_BANK0_B3 sky130_fd_pr__cap_mim_m3_1 w=22.17 l=22.17
XDAC_P_BANK0_B3_U8_C_UNIT_P0 TOPP DAC__P_BANK0_B3 sky130_fd_pr__cap_mim_m3_1 w=22.17 l=22.17
XDAC_P_BANK0_B3_U9_C_UNIT_P0 TOPP DAC__P_BANK0_B3 sky130_fd_pr__cap_mim_m3_1 w=22.17 l=22.17
XDAC_P_BANK1_B0_SW_HIGH_N DAC__HIP B8 DAC__P_BANK1_B0 VGND sky130_fd_pr__nfet_01v8 w=8 l=0.15 nf=1 m=1
XDAC_P_BANK1_B0_SW_HIGH_P DAC__HIP DAC__P_BANK1_B0_SW__BITB DAC__P_BANK1_B0 VPWR sky130_fd_pr__pfet_01v8_hvt w=12 l=0.15 nf=1 m=1
XDAC_P_BANK1_B0_SW_INV_MN DAC__P_BANK1_B0_SW__BITB B8 VGND VGND sky130_fd_pr__nfet_01v8 w=0.65 l=0.15 nf=1 m=1
XDAC_P_BANK1_B0_SW_INV_MP DAC__P_BANK1_B0_SW__BITB B8 VPWR VPWR sky130_fd_pr__pfet_01v8_hvt w=0.65 l=0.15 nf=1 m=1
XDAC_P_BANK1_B0_SW_LOW_N DAC__LOP DAC__P_BANK1_B0_SW__BITB DAC__P_BANK1_B0 VGND sky130_fd_pr__nfet_01v8 w=8 l=0.15 nf=1 m=1
XDAC_P_BANK1_B0_SW_LOW_P DAC__LOP B8 DAC__P_BANK1_B0 VPWR sky130_fd_pr__pfet_01v8_hvt w=12 l=0.15 nf=1 m=1
XDAC_P_BANK1_B0_U0_C_UNIT_P0 DAC__BANK1P DAC__P_BANK1_B0 sky130_fd_pr__cap_mim_m3_1 w=22.17 l=22.17
XDAC_P_BANK1_B0_U1_C_UNIT_P0 DAC__BANK1P DAC__P_BANK1_B0 sky130_fd_pr__cap_mim_m3_1 w=22.17 l=22.17
XDAC_P_BANK1_B1_SW_HIGH_N DAC__HIP B9 DAC__P_BANK1_B1 VGND sky130_fd_pr__nfet_01v8 w=8 l=0.15 nf=1 m=1
XDAC_P_BANK1_B1_SW_HIGH_P DAC__HIP DAC__P_BANK1_B1_SW__BITB DAC__P_BANK1_B1 VPWR sky130_fd_pr__pfet_01v8_hvt w=12 l=0.15 nf=1 m=1
XDAC_P_BANK1_B1_SW_INV_MN DAC__P_BANK1_B1_SW__BITB B9 VGND VGND sky130_fd_pr__nfet_01v8 w=0.65 l=0.15 nf=1 m=1
XDAC_P_BANK1_B1_SW_INV_MP DAC__P_BANK1_B1_SW__BITB B9 VPWR VPWR sky130_fd_pr__pfet_01v8_hvt w=0.65 l=0.15 nf=1 m=1
XDAC_P_BANK1_B1_SW_LOW_N DAC__LOP DAC__P_BANK1_B1_SW__BITB DAC__P_BANK1_B1 VGND sky130_fd_pr__nfet_01v8 w=8 l=0.15 nf=1 m=1
XDAC_P_BANK1_B1_SW_LOW_P DAC__LOP B9 DAC__P_BANK1_B1 VPWR sky130_fd_pr__pfet_01v8_hvt w=12 l=0.15 nf=1 m=1
XDAC_P_BANK1_B1_U0_C_UNIT_P0 DAC__BANK1P DAC__P_BANK1_B1 sky130_fd_pr__cap_mim_m3_1 w=22.17 l=22.17
XDAC_P_BANK1_B1_U1_C_UNIT_P0 DAC__BANK1P DAC__P_BANK1_B1 sky130_fd_pr__cap_mim_m3_1 w=22.17 l=22.17
XDAC_P_BANK1_B1_U2_C_UNIT_P0 DAC__BANK1P DAC__P_BANK1_B1 sky130_fd_pr__cap_mim_m3_1 w=22.17 l=22.17
XDAC_P_BANK1_B1_U3_C_UNIT_P0 DAC__BANK1P DAC__P_BANK1_B1 sky130_fd_pr__cap_mim_m3_1 w=22.17 l=22.17
XDAC_P_BANK1_B2_SW_HIGH_N DAC__HIP B10 DAC__P_BANK1_B2 VGND sky130_fd_pr__nfet_01v8 w=8 l=0.15 nf=1 m=1
XDAC_P_BANK1_B2_SW_HIGH_P DAC__HIP DAC__P_BANK1_B2_SW__BITB DAC__P_BANK1_B2 VPWR sky130_fd_pr__pfet_01v8_hvt w=12 l=0.15 nf=1 m=1
XDAC_P_BANK1_B2_SW_INV_MN DAC__P_BANK1_B2_SW__BITB B10 VGND VGND sky130_fd_pr__nfet_01v8 w=0.65 l=0.15 nf=1 m=1
XDAC_P_BANK1_B2_SW_INV_MP DAC__P_BANK1_B2_SW__BITB B10 VPWR VPWR sky130_fd_pr__pfet_01v8_hvt w=0.65 l=0.15 nf=1 m=1
XDAC_P_BANK1_B2_SW_LOW_N DAC__LOP DAC__P_BANK1_B2_SW__BITB DAC__P_BANK1_B2 VGND sky130_fd_pr__nfet_01v8 w=8 l=0.15 nf=1 m=1
XDAC_P_BANK1_B2_SW_LOW_P DAC__LOP B10 DAC__P_BANK1_B2 VPWR sky130_fd_pr__pfet_01v8_hvt w=12 l=0.15 nf=1 m=1
XDAC_P_BANK1_B2_U0_C_UNIT_P0 DAC__BANK1P DAC__P_BANK1_B2 sky130_fd_pr__cap_mim_m3_1 w=22.17 l=22.17
XDAC_P_BANK1_B2_U1_C_UNIT_P0 DAC__BANK1P DAC__P_BANK1_B2 sky130_fd_pr__cap_mim_m3_1 w=22.17 l=22.17
XDAC_P_BANK1_B2_U2_C_UNIT_P0 DAC__BANK1P DAC__P_BANK1_B2 sky130_fd_pr__cap_mim_m3_1 w=22.17 l=22.17
XDAC_P_BANK1_B2_U3_C_UNIT_P0 DAC__BANK1P DAC__P_BANK1_B2 sky130_fd_pr__cap_mim_m3_1 w=22.17 l=22.17
XDAC_P_BANK1_B2_U4_C_UNIT_P0 DAC__BANK1P DAC__P_BANK1_B2 sky130_fd_pr__cap_mim_m3_1 w=22.17 l=22.17
XDAC_P_BANK1_B2_U5_C_UNIT_P0 DAC__BANK1P DAC__P_BANK1_B2 sky130_fd_pr__cap_mim_m3_1 w=22.17 l=22.17
XDAC_P_BANK1_B2_U6_C_UNIT_P0 DAC__BANK1P DAC__P_BANK1_B2 sky130_fd_pr__cap_mim_m3_1 w=22.17 l=22.17
XDAC_P_BANK1_B2_U7_C_UNIT_P0 DAC__BANK1P DAC__P_BANK1_B2 sky130_fd_pr__cap_mim_m3_1 w=22.17 l=22.17
XDAC_P_BANK1_B3_SW_HIGH_N DAC__HIP B11 DAC__P_BANK1_B3 VGND sky130_fd_pr__nfet_01v8 w=8 l=0.15 nf=1 m=1
XDAC_P_BANK1_B3_SW_HIGH_P DAC__HIP DAC__P_BANK1_B3_SW__BITB DAC__P_BANK1_B3 VPWR sky130_fd_pr__pfet_01v8_hvt w=12 l=0.15 nf=1 m=1
XDAC_P_BANK1_B3_SW_INV_MN DAC__P_BANK1_B3_SW__BITB B11 VGND VGND sky130_fd_pr__nfet_01v8 w=0.65 l=0.15 nf=1 m=1
XDAC_P_BANK1_B3_SW_INV_MP DAC__P_BANK1_B3_SW__BITB B11 VPWR VPWR sky130_fd_pr__pfet_01v8_hvt w=0.65 l=0.15 nf=1 m=1
XDAC_P_BANK1_B3_SW_LOW_N DAC__LOP DAC__P_BANK1_B3_SW__BITB DAC__P_BANK1_B3 VGND sky130_fd_pr__nfet_01v8 w=8 l=0.15 nf=1 m=1
XDAC_P_BANK1_B3_SW_LOW_P DAC__LOP B11 DAC__P_BANK1_B3 VPWR sky130_fd_pr__pfet_01v8_hvt w=12 l=0.15 nf=1 m=1
XDAC_P_BANK1_B3_U0_C_UNIT_P0 DAC__BANK1P DAC__P_BANK1_B3 sky130_fd_pr__cap_mim_m3_1 w=22.17 l=22.17
XDAC_P_BANK1_B3_U1_C_UNIT_P0 DAC__BANK1P DAC__P_BANK1_B3 sky130_fd_pr__cap_mim_m3_1 w=22.17 l=22.17
XDAC_P_BANK1_B3_U10_C_UNIT_P0 DAC__BANK1P DAC__P_BANK1_B3 sky130_fd_pr__cap_mim_m3_1 w=22.17 l=22.17
XDAC_P_BANK1_B3_U11_C_UNIT_P0 DAC__BANK1P DAC__P_BANK1_B3 sky130_fd_pr__cap_mim_m3_1 w=22.17 l=22.17
XDAC_P_BANK1_B3_U12_C_UNIT_P0 DAC__BANK1P DAC__P_BANK1_B3 sky130_fd_pr__cap_mim_m3_1 w=22.17 l=22.17
XDAC_P_BANK1_B3_U13_C_UNIT_P0 DAC__BANK1P DAC__P_BANK1_B3 sky130_fd_pr__cap_mim_m3_1 w=22.17 l=22.17
XDAC_P_BANK1_B3_U14_C_UNIT_P0 DAC__BANK1P DAC__P_BANK1_B3 sky130_fd_pr__cap_mim_m3_1 w=22.17 l=22.17
XDAC_P_BANK1_B3_U15_C_UNIT_P0 DAC__BANK1P DAC__P_BANK1_B3 sky130_fd_pr__cap_mim_m3_1 w=22.17 l=22.17
XDAC_P_BANK1_B3_U2_C_UNIT_P0 DAC__BANK1P DAC__P_BANK1_B3 sky130_fd_pr__cap_mim_m3_1 w=22.17 l=22.17
XDAC_P_BANK1_B3_U3_C_UNIT_P0 DAC__BANK1P DAC__P_BANK1_B3 sky130_fd_pr__cap_mim_m3_1 w=22.17 l=22.17
XDAC_P_BANK1_B3_U4_C_UNIT_P0 DAC__BANK1P DAC__P_BANK1_B3 sky130_fd_pr__cap_mim_m3_1 w=22.17 l=22.17
XDAC_P_BANK1_B3_U5_C_UNIT_P0 DAC__BANK1P DAC__P_BANK1_B3 sky130_fd_pr__cap_mim_m3_1 w=22.17 l=22.17
XDAC_P_BANK1_B3_U6_C_UNIT_P0 DAC__BANK1P DAC__P_BANK1_B3 sky130_fd_pr__cap_mim_m3_1 w=22.17 l=22.17
XDAC_P_BANK1_B3_U7_C_UNIT_P0 DAC__BANK1P DAC__P_BANK1_B3 sky130_fd_pr__cap_mim_m3_1 w=22.17 l=22.17
XDAC_P_BANK1_B3_U8_C_UNIT_P0 DAC__BANK1P DAC__P_BANK1_B3 sky130_fd_pr__cap_mim_m3_1 w=22.17 l=22.17
XDAC_P_BANK1_B3_U9_C_UNIT_P0 DAC__BANK1P DAC__P_BANK1_B3 sky130_fd_pr__cap_mim_m3_1 w=22.17 l=22.17
XDAC_P_BANK2_B0_SW_HIGH_N DAC__HIP B4 DAC__P_BANK2_B0 VGND sky130_fd_pr__nfet_01v8 w=8 l=0.15 nf=1 m=1
XDAC_P_BANK2_B0_SW_HIGH_P DAC__HIP DAC__P_BANK2_B0_SW__BITB DAC__P_BANK2_B0 VPWR sky130_fd_pr__pfet_01v8_hvt w=12 l=0.15 nf=1 m=1
XDAC_P_BANK2_B0_SW_INV_MN DAC__P_BANK2_B0_SW__BITB B4 VGND VGND sky130_fd_pr__nfet_01v8 w=0.65 l=0.15 nf=1 m=1
XDAC_P_BANK2_B0_SW_INV_MP DAC__P_BANK2_B0_SW__BITB B4 VPWR VPWR sky130_fd_pr__pfet_01v8_hvt w=0.65 l=0.15 nf=1 m=1
XDAC_P_BANK2_B0_SW_LOW_N DAC__LOP DAC__P_BANK2_B0_SW__BITB DAC__P_BANK2_B0 VGND sky130_fd_pr__nfet_01v8 w=8 l=0.15 nf=1 m=1
XDAC_P_BANK2_B0_SW_LOW_P DAC__LOP B4 DAC__P_BANK2_B0 VPWR sky130_fd_pr__pfet_01v8_hvt w=12 l=0.15 nf=1 m=1
XDAC_P_BANK2_B0_U0_C_UNIT_P0 DAC__BANK2P DAC__P_BANK2_B0 sky130_fd_pr__cap_mim_m3_1 w=22.17 l=22.17
XDAC_P_BANK2_B0_U1_C_UNIT_P0 DAC__BANK2P DAC__P_BANK2_B0 sky130_fd_pr__cap_mim_m3_1 w=22.17 l=22.17
XDAC_P_BANK2_B1_SW_HIGH_N DAC__HIP B5 DAC__P_BANK2_B1 VGND sky130_fd_pr__nfet_01v8 w=8 l=0.15 nf=1 m=1
XDAC_P_BANK2_B1_SW_HIGH_P DAC__HIP DAC__P_BANK2_B1_SW__BITB DAC__P_BANK2_B1 VPWR sky130_fd_pr__pfet_01v8_hvt w=12 l=0.15 nf=1 m=1
XDAC_P_BANK2_B1_SW_INV_MN DAC__P_BANK2_B1_SW__BITB B5 VGND VGND sky130_fd_pr__nfet_01v8 w=0.65 l=0.15 nf=1 m=1
XDAC_P_BANK2_B1_SW_INV_MP DAC__P_BANK2_B1_SW__BITB B5 VPWR VPWR sky130_fd_pr__pfet_01v8_hvt w=0.65 l=0.15 nf=1 m=1
XDAC_P_BANK2_B1_SW_LOW_N DAC__LOP DAC__P_BANK2_B1_SW__BITB DAC__P_BANK2_B1 VGND sky130_fd_pr__nfet_01v8 w=8 l=0.15 nf=1 m=1
XDAC_P_BANK2_B1_SW_LOW_P DAC__LOP B5 DAC__P_BANK2_B1 VPWR sky130_fd_pr__pfet_01v8_hvt w=12 l=0.15 nf=1 m=1
XDAC_P_BANK2_B1_U0_C_UNIT_P0 DAC__BANK2P DAC__P_BANK2_B1 sky130_fd_pr__cap_mim_m3_1 w=22.17 l=22.17
XDAC_P_BANK2_B1_U1_C_UNIT_P0 DAC__BANK2P DAC__P_BANK2_B1 sky130_fd_pr__cap_mim_m3_1 w=22.17 l=22.17
XDAC_P_BANK2_B1_U2_C_UNIT_P0 DAC__BANK2P DAC__P_BANK2_B1 sky130_fd_pr__cap_mim_m3_1 w=22.17 l=22.17
XDAC_P_BANK2_B1_U3_C_UNIT_P0 DAC__BANK2P DAC__P_BANK2_B1 sky130_fd_pr__cap_mim_m3_1 w=22.17 l=22.17
XDAC_P_BANK2_B2_SW_HIGH_N DAC__HIP B6 DAC__P_BANK2_B2 VGND sky130_fd_pr__nfet_01v8 w=8 l=0.15 nf=1 m=1
XDAC_P_BANK2_B2_SW_HIGH_P DAC__HIP DAC__P_BANK2_B2_SW__BITB DAC__P_BANK2_B2 VPWR sky130_fd_pr__pfet_01v8_hvt w=12 l=0.15 nf=1 m=1
XDAC_P_BANK2_B2_SW_INV_MN DAC__P_BANK2_B2_SW__BITB B6 VGND VGND sky130_fd_pr__nfet_01v8 w=0.65 l=0.15 nf=1 m=1
XDAC_P_BANK2_B2_SW_INV_MP DAC__P_BANK2_B2_SW__BITB B6 VPWR VPWR sky130_fd_pr__pfet_01v8_hvt w=0.65 l=0.15 nf=1 m=1
XDAC_P_BANK2_B2_SW_LOW_N DAC__LOP DAC__P_BANK2_B2_SW__BITB DAC__P_BANK2_B2 VGND sky130_fd_pr__nfet_01v8 w=8 l=0.15 nf=1 m=1
XDAC_P_BANK2_B2_SW_LOW_P DAC__LOP B6 DAC__P_BANK2_B2 VPWR sky130_fd_pr__pfet_01v8_hvt w=12 l=0.15 nf=1 m=1
XDAC_P_BANK2_B2_U0_C_UNIT_P0 DAC__BANK2P DAC__P_BANK2_B2 sky130_fd_pr__cap_mim_m3_1 w=22.17 l=22.17
XDAC_P_BANK2_B2_U1_C_UNIT_P0 DAC__BANK2P DAC__P_BANK2_B2 sky130_fd_pr__cap_mim_m3_1 w=22.17 l=22.17
XDAC_P_BANK2_B2_U2_C_UNIT_P0 DAC__BANK2P DAC__P_BANK2_B2 sky130_fd_pr__cap_mim_m3_1 w=22.17 l=22.17
XDAC_P_BANK2_B2_U3_C_UNIT_P0 DAC__BANK2P DAC__P_BANK2_B2 sky130_fd_pr__cap_mim_m3_1 w=22.17 l=22.17
XDAC_P_BANK2_B2_U4_C_UNIT_P0 DAC__BANK2P DAC__P_BANK2_B2 sky130_fd_pr__cap_mim_m3_1 w=22.17 l=22.17
XDAC_P_BANK2_B2_U5_C_UNIT_P0 DAC__BANK2P DAC__P_BANK2_B2 sky130_fd_pr__cap_mim_m3_1 w=22.17 l=22.17
XDAC_P_BANK2_B2_U6_C_UNIT_P0 DAC__BANK2P DAC__P_BANK2_B2 sky130_fd_pr__cap_mim_m3_1 w=22.17 l=22.17
XDAC_P_BANK2_B2_U7_C_UNIT_P0 DAC__BANK2P DAC__P_BANK2_B2 sky130_fd_pr__cap_mim_m3_1 w=22.17 l=22.17
XDAC_P_BANK2_B3_SW_HIGH_N DAC__HIP B7 DAC__P_BANK2_B3 VGND sky130_fd_pr__nfet_01v8 w=8 l=0.15 nf=1 m=1
XDAC_P_BANK2_B3_SW_HIGH_P DAC__HIP DAC__P_BANK2_B3_SW__BITB DAC__P_BANK2_B3 VPWR sky130_fd_pr__pfet_01v8_hvt w=12 l=0.15 nf=1 m=1
XDAC_P_BANK2_B3_SW_INV_MN DAC__P_BANK2_B3_SW__BITB B7 VGND VGND sky130_fd_pr__nfet_01v8 w=0.65 l=0.15 nf=1 m=1
XDAC_P_BANK2_B3_SW_INV_MP DAC__P_BANK2_B3_SW__BITB B7 VPWR VPWR sky130_fd_pr__pfet_01v8_hvt w=0.65 l=0.15 nf=1 m=1
XDAC_P_BANK2_B3_SW_LOW_N DAC__LOP DAC__P_BANK2_B3_SW__BITB DAC__P_BANK2_B3 VGND sky130_fd_pr__nfet_01v8 w=8 l=0.15 nf=1 m=1
XDAC_P_BANK2_B3_SW_LOW_P DAC__LOP B7 DAC__P_BANK2_B3 VPWR sky130_fd_pr__pfet_01v8_hvt w=12 l=0.15 nf=1 m=1
XDAC_P_BANK2_B3_U0_C_UNIT_P0 DAC__BANK2P DAC__P_BANK2_B3 sky130_fd_pr__cap_mim_m3_1 w=22.17 l=22.17
XDAC_P_BANK2_B3_U1_C_UNIT_P0 DAC__BANK2P DAC__P_BANK2_B3 sky130_fd_pr__cap_mim_m3_1 w=22.17 l=22.17
XDAC_P_BANK2_B3_U10_C_UNIT_P0 DAC__BANK2P DAC__P_BANK2_B3 sky130_fd_pr__cap_mim_m3_1 w=22.17 l=22.17
XDAC_P_BANK2_B3_U11_C_UNIT_P0 DAC__BANK2P DAC__P_BANK2_B3 sky130_fd_pr__cap_mim_m3_1 w=22.17 l=22.17
XDAC_P_BANK2_B3_U12_C_UNIT_P0 DAC__BANK2P DAC__P_BANK2_B3 sky130_fd_pr__cap_mim_m3_1 w=22.17 l=22.17
XDAC_P_BANK2_B3_U13_C_UNIT_P0 DAC__BANK2P DAC__P_BANK2_B3 sky130_fd_pr__cap_mim_m3_1 w=22.17 l=22.17
XDAC_P_BANK2_B3_U14_C_UNIT_P0 DAC__BANK2P DAC__P_BANK2_B3 sky130_fd_pr__cap_mim_m3_1 w=22.17 l=22.17
XDAC_P_BANK2_B3_U15_C_UNIT_P0 DAC__BANK2P DAC__P_BANK2_B3 sky130_fd_pr__cap_mim_m3_1 w=22.17 l=22.17
XDAC_P_BANK2_B3_U2_C_UNIT_P0 DAC__BANK2P DAC__P_BANK2_B3 sky130_fd_pr__cap_mim_m3_1 w=22.17 l=22.17
XDAC_P_BANK2_B3_U3_C_UNIT_P0 DAC__BANK2P DAC__P_BANK2_B3 sky130_fd_pr__cap_mim_m3_1 w=22.17 l=22.17
XDAC_P_BANK2_B3_U4_C_UNIT_P0 DAC__BANK2P DAC__P_BANK2_B3 sky130_fd_pr__cap_mim_m3_1 w=22.17 l=22.17
XDAC_P_BANK2_B3_U5_C_UNIT_P0 DAC__BANK2P DAC__P_BANK2_B3 sky130_fd_pr__cap_mim_m3_1 w=22.17 l=22.17
XDAC_P_BANK2_B3_U6_C_UNIT_P0 DAC__BANK2P DAC__P_BANK2_B3 sky130_fd_pr__cap_mim_m3_1 w=22.17 l=22.17
XDAC_P_BANK2_B3_U7_C_UNIT_P0 DAC__BANK2P DAC__P_BANK2_B3 sky130_fd_pr__cap_mim_m3_1 w=22.17 l=22.17
XDAC_P_BANK2_B3_U8_C_UNIT_P0 DAC__BANK2P DAC__P_BANK2_B3 sky130_fd_pr__cap_mim_m3_1 w=22.17 l=22.17
XDAC_P_BANK2_B3_U9_C_UNIT_P0 DAC__BANK2P DAC__P_BANK2_B3 sky130_fd_pr__cap_mim_m3_1 w=22.17 l=22.17
XDAC_P_BANK3_B0_SW_HIGH_N DAC__HIP B0 DAC__P_BANK3_B0 VGND sky130_fd_pr__nfet_01v8 w=8 l=0.15 nf=1 m=1
XDAC_P_BANK3_B0_SW_HIGH_P DAC__HIP DAC__P_BANK3_B0_SW__BITB DAC__P_BANK3_B0 VPWR sky130_fd_pr__pfet_01v8_hvt w=12 l=0.15 nf=1 m=1
XDAC_P_BANK3_B0_SW_INV_MN DAC__P_BANK3_B0_SW__BITB B0 VGND VGND sky130_fd_pr__nfet_01v8 w=0.65 l=0.15 nf=1 m=1
XDAC_P_BANK3_B0_SW_INV_MP DAC__P_BANK3_B0_SW__BITB B0 VPWR VPWR sky130_fd_pr__pfet_01v8_hvt w=0.65 l=0.15 nf=1 m=1
XDAC_P_BANK3_B0_SW_LOW_N DAC__LOP DAC__P_BANK3_B0_SW__BITB DAC__P_BANK3_B0 VGND sky130_fd_pr__nfet_01v8 w=8 l=0.15 nf=1 m=1
XDAC_P_BANK3_B0_SW_LOW_P DAC__LOP B0 DAC__P_BANK3_B0 VPWR sky130_fd_pr__pfet_01v8_hvt w=12 l=0.15 nf=1 m=1
XDAC_P_BANK3_B0_U0_C_UNIT_P0 DAC__BANK3P DAC__P_BANK3_B0 sky130_fd_pr__cap_mim_m3_1 w=22.17 l=22.17
XDAC_P_BANK3_B0_U1_C_UNIT_P0 DAC__BANK3P DAC__P_BANK3_B0 sky130_fd_pr__cap_mim_m3_1 w=22.17 l=22.17
XDAC_P_BANK3_B1_SW_HIGH_N DAC__HIP B1 DAC__P_BANK3_B1 VGND sky130_fd_pr__nfet_01v8 w=8 l=0.15 nf=1 m=1
XDAC_P_BANK3_B1_SW_HIGH_P DAC__HIP DAC__P_BANK3_B1_SW__BITB DAC__P_BANK3_B1 VPWR sky130_fd_pr__pfet_01v8_hvt w=12 l=0.15 nf=1 m=1
XDAC_P_BANK3_B1_SW_INV_MN DAC__P_BANK3_B1_SW__BITB B1 VGND VGND sky130_fd_pr__nfet_01v8 w=0.65 l=0.15 nf=1 m=1
XDAC_P_BANK3_B1_SW_INV_MP DAC__P_BANK3_B1_SW__BITB B1 VPWR VPWR sky130_fd_pr__pfet_01v8_hvt w=0.65 l=0.15 nf=1 m=1
XDAC_P_BANK3_B1_SW_LOW_N DAC__LOP DAC__P_BANK3_B1_SW__BITB DAC__P_BANK3_B1 VGND sky130_fd_pr__nfet_01v8 w=8 l=0.15 nf=1 m=1
XDAC_P_BANK3_B1_SW_LOW_P DAC__LOP B1 DAC__P_BANK3_B1 VPWR sky130_fd_pr__pfet_01v8_hvt w=12 l=0.15 nf=1 m=1
XDAC_P_BANK3_B1_U0_C_UNIT_P0 DAC__BANK3P DAC__P_BANK3_B1 sky130_fd_pr__cap_mim_m3_1 w=22.17 l=22.17
XDAC_P_BANK3_B1_U1_C_UNIT_P0 DAC__BANK3P DAC__P_BANK3_B1 sky130_fd_pr__cap_mim_m3_1 w=22.17 l=22.17
XDAC_P_BANK3_B1_U2_C_UNIT_P0 DAC__BANK3P DAC__P_BANK3_B1 sky130_fd_pr__cap_mim_m3_1 w=22.17 l=22.17
XDAC_P_BANK3_B1_U3_C_UNIT_P0 DAC__BANK3P DAC__P_BANK3_B1 sky130_fd_pr__cap_mim_m3_1 w=22.17 l=22.17
XDAC_P_BANK3_B2_SW_HIGH_N DAC__HIP B2 DAC__P_BANK3_B2 VGND sky130_fd_pr__nfet_01v8 w=8 l=0.15 nf=1 m=1
XDAC_P_BANK3_B2_SW_HIGH_P DAC__HIP DAC__P_BANK3_B2_SW__BITB DAC__P_BANK3_B2 VPWR sky130_fd_pr__pfet_01v8_hvt w=12 l=0.15 nf=1 m=1
XDAC_P_BANK3_B2_SW_INV_MN DAC__P_BANK3_B2_SW__BITB B2 VGND VGND sky130_fd_pr__nfet_01v8 w=0.65 l=0.15 nf=1 m=1
XDAC_P_BANK3_B2_SW_INV_MP DAC__P_BANK3_B2_SW__BITB B2 VPWR VPWR sky130_fd_pr__pfet_01v8_hvt w=0.65 l=0.15 nf=1 m=1
XDAC_P_BANK3_B2_SW_LOW_N DAC__LOP DAC__P_BANK3_B2_SW__BITB DAC__P_BANK3_B2 VGND sky130_fd_pr__nfet_01v8 w=8 l=0.15 nf=1 m=1
XDAC_P_BANK3_B2_SW_LOW_P DAC__LOP B2 DAC__P_BANK3_B2 VPWR sky130_fd_pr__pfet_01v8_hvt w=12 l=0.15 nf=1 m=1
XDAC_P_BANK3_B2_U0_C_UNIT_P0 DAC__BANK3P DAC__P_BANK3_B2 sky130_fd_pr__cap_mim_m3_1 w=22.17 l=22.17
XDAC_P_BANK3_B2_U1_C_UNIT_P0 DAC__BANK3P DAC__P_BANK3_B2 sky130_fd_pr__cap_mim_m3_1 w=22.17 l=22.17
XDAC_P_BANK3_B2_U2_C_UNIT_P0 DAC__BANK3P DAC__P_BANK3_B2 sky130_fd_pr__cap_mim_m3_1 w=22.17 l=22.17
XDAC_P_BANK3_B2_U3_C_UNIT_P0 DAC__BANK3P DAC__P_BANK3_B2 sky130_fd_pr__cap_mim_m3_1 w=22.17 l=22.17
XDAC_P_BANK3_B2_U4_C_UNIT_P0 DAC__BANK3P DAC__P_BANK3_B2 sky130_fd_pr__cap_mim_m3_1 w=22.17 l=22.17
XDAC_P_BANK3_B2_U5_C_UNIT_P0 DAC__BANK3P DAC__P_BANK3_B2 sky130_fd_pr__cap_mim_m3_1 w=22.17 l=22.17
XDAC_P_BANK3_B2_U6_C_UNIT_P0 DAC__BANK3P DAC__P_BANK3_B2 sky130_fd_pr__cap_mim_m3_1 w=22.17 l=22.17
XDAC_P_BANK3_B2_U7_C_UNIT_P0 DAC__BANK3P DAC__P_BANK3_B2 sky130_fd_pr__cap_mim_m3_1 w=22.17 l=22.17
XDAC_P_BANK3_B3_SW_HIGH_N DAC__HIP B3 DAC__P_BANK3_B3 VGND sky130_fd_pr__nfet_01v8 w=8 l=0.15 nf=1 m=1
XDAC_P_BANK3_B3_SW_HIGH_P DAC__HIP DAC__P_BANK3_B3_SW__BITB DAC__P_BANK3_B3 VPWR sky130_fd_pr__pfet_01v8_hvt w=12 l=0.15 nf=1 m=1
XDAC_P_BANK3_B3_SW_INV_MN DAC__P_BANK3_B3_SW__BITB B3 VGND VGND sky130_fd_pr__nfet_01v8 w=0.65 l=0.15 nf=1 m=1
XDAC_P_BANK3_B3_SW_INV_MP DAC__P_BANK3_B3_SW__BITB B3 VPWR VPWR sky130_fd_pr__pfet_01v8_hvt w=0.65 l=0.15 nf=1 m=1
XDAC_P_BANK3_B3_SW_LOW_N DAC__LOP DAC__P_BANK3_B3_SW__BITB DAC__P_BANK3_B3 VGND sky130_fd_pr__nfet_01v8 w=8 l=0.15 nf=1 m=1
XDAC_P_BANK3_B3_SW_LOW_P DAC__LOP B3 DAC__P_BANK3_B3 VPWR sky130_fd_pr__pfet_01v8_hvt w=12 l=0.15 nf=1 m=1
XDAC_P_BANK3_B3_U0_C_UNIT_P0 DAC__BANK3P DAC__P_BANK3_B3 sky130_fd_pr__cap_mim_m3_1 w=22.17 l=22.17
XDAC_P_BANK3_B3_U1_C_UNIT_P0 DAC__BANK3P DAC__P_BANK3_B3 sky130_fd_pr__cap_mim_m3_1 w=22.17 l=22.17
XDAC_P_BANK3_B3_U10_C_UNIT_P0 DAC__BANK3P DAC__P_BANK3_B3 sky130_fd_pr__cap_mim_m3_1 w=22.17 l=22.17
XDAC_P_BANK3_B3_U11_C_UNIT_P0 DAC__BANK3P DAC__P_BANK3_B3 sky130_fd_pr__cap_mim_m3_1 w=22.17 l=22.17
XDAC_P_BANK3_B3_U12_C_UNIT_P0 DAC__BANK3P DAC__P_BANK3_B3 sky130_fd_pr__cap_mim_m3_1 w=22.17 l=22.17
XDAC_P_BANK3_B3_U13_C_UNIT_P0 DAC__BANK3P DAC__P_BANK3_B3 sky130_fd_pr__cap_mim_m3_1 w=22.17 l=22.17
XDAC_P_BANK3_B3_U14_C_UNIT_P0 DAC__BANK3P DAC__P_BANK3_B3 sky130_fd_pr__cap_mim_m3_1 w=22.17 l=22.17
XDAC_P_BANK3_B3_U15_C_UNIT_P0 DAC__BANK3P DAC__P_BANK3_B3 sky130_fd_pr__cap_mim_m3_1 w=22.17 l=22.17
XDAC_P_BANK3_B3_U2_C_UNIT_P0 DAC__BANK3P DAC__P_BANK3_B3 sky130_fd_pr__cap_mim_m3_1 w=22.17 l=22.17
XDAC_P_BANK3_B3_U3_C_UNIT_P0 DAC__BANK3P DAC__P_BANK3_B3 sky130_fd_pr__cap_mim_m3_1 w=22.17 l=22.17
XDAC_P_BANK3_B3_U4_C_UNIT_P0 DAC__BANK3P DAC__P_BANK3_B3 sky130_fd_pr__cap_mim_m3_1 w=22.17 l=22.17
XDAC_P_BANK3_B3_U5_C_UNIT_P0 DAC__BANK3P DAC__P_BANK3_B3 sky130_fd_pr__cap_mim_m3_1 w=22.17 l=22.17
XDAC_P_BANK3_B3_U6_C_UNIT_P0 DAC__BANK3P DAC__P_BANK3_B3 sky130_fd_pr__cap_mim_m3_1 w=22.17 l=22.17
XDAC_P_BANK3_B3_U7_C_UNIT_P0 DAC__BANK3P DAC__P_BANK3_B3 sky130_fd_pr__cap_mim_m3_1 w=22.17 l=22.17
XDAC_P_BANK3_B3_U8_C_UNIT_P0 DAC__BANK3P DAC__P_BANK3_B3 sky130_fd_pr__cap_mim_m3_1 w=22.17 l=22.17
XDAC_P_BANK3_B3_U9_C_UNIT_P0 DAC__BANK3P DAC__P_BANK3_B3 sky130_fd_pr__cap_mim_m3_1 w=22.17 l=22.17
XDAC_P_BANK3_DUMMY_U0_C_UNIT_P0 DAC__BANK3P DAC__LOP sky130_fd_pr__cap_mim_m3_1 w=22.17 l=22.17
XDAC_P_BANK3_DUMMY_U1_C_UNIT_P0 DAC__BANK3P DAC__LOP sky130_fd_pr__cap_mim_m3_1 w=22.17 l=22.17
XDAC_RESET_0N_N VCM SAMPLE TOPN VGND sky130_fd_pr__nfet_01v8 w=8 l=0.15 nf=1 m=1
XDAC_RESET_0N_P VCM DAC__SAMPLEB TOPN VPWR sky130_fd_pr__pfet_01v8_hvt w=12 l=0.15 nf=1 m=1
XDAC_RESET_0P_N VCM SAMPLE TOPP VGND sky130_fd_pr__nfet_01v8 w=8 l=0.15 nf=1 m=1
XDAC_RESET_0P_P VCM DAC__SAMPLEB TOPP VPWR sky130_fd_pr__pfet_01v8_hvt w=12 l=0.15 nf=1 m=1
XDAC_RESET_1N_N VCM SAMPLE DAC__BANK1N VGND sky130_fd_pr__nfet_01v8 w=8 l=0.15 nf=1 m=1
XDAC_RESET_1N_P VCM DAC__SAMPLEB DAC__BANK1N VPWR sky130_fd_pr__pfet_01v8_hvt w=12 l=0.15 nf=1 m=1
XDAC_RESET_1P_N VCM SAMPLE DAC__BANK1P VGND sky130_fd_pr__nfet_01v8 w=8 l=0.15 nf=1 m=1
XDAC_RESET_1P_P VCM DAC__SAMPLEB DAC__BANK1P VPWR sky130_fd_pr__pfet_01v8_hvt w=12 l=0.15 nf=1 m=1
XDAC_RESET_2N_N VCM SAMPLE DAC__BANK2N VGND sky130_fd_pr__nfet_01v8 w=8 l=0.15 nf=1 m=1
XDAC_RESET_2N_P VCM DAC__SAMPLEB DAC__BANK2N VPWR sky130_fd_pr__pfet_01v8_hvt w=12 l=0.15 nf=1 m=1
XDAC_RESET_2P_N VCM SAMPLE DAC__BANK2P VGND sky130_fd_pr__nfet_01v8 w=8 l=0.15 nf=1 m=1
XDAC_RESET_2P_P VCM DAC__SAMPLEB DAC__BANK2P VPWR sky130_fd_pr__pfet_01v8_hvt w=12 l=0.15 nf=1 m=1
XDAC_RESET_3N_N VCM SAMPLE DAC__BANK3N VGND sky130_fd_pr__nfet_01v8 w=8 l=0.15 nf=1 m=1
XDAC_RESET_3N_P VCM DAC__SAMPLEB DAC__BANK3N VPWR sky130_fd_pr__pfet_01v8_hvt w=12 l=0.15 nf=1 m=1
XDAC_RESET_3P_N VCM SAMPLE DAC__BANK3P VGND sky130_fd_pr__nfet_01v8 w=8 l=0.15 nf=1 m=1
XDAC_RESET_3P_P VCM DAC__SAMPLEB DAC__BANK3P VPWR sky130_fd_pr__pfet_01v8_hvt w=12 l=0.15 nf=1 m=1
XDAC_SAMPLE_INV_MN DAC__SAMPLEB SAMPLE VGND VGND sky130_fd_pr__nfet_01v8 w=0.65 l=0.15 nf=1 m=1
XDAC_SAMPLE_INV_MP DAC__SAMPLEB SAMPLE VPWR VPWR sky130_fd_pr__pfet_01v8_hvt w=0.65 l=0.15 nf=1 m=1
.ends sar16_analog

* NGSPICE file created from pipeline16_stage.ext - technology: sky130A

.subckt pipeline16_stage VINP VINN VGND BIAS LOW HIGH HOLD OUTN VPWR OUTP REFN THN
+ REFP RESET THP SAMPLE VCM
X0 VPWR LATCH_LOW__SAMPLE__MB LATCH_LOW__SAMPLE__MF VPWR sky130_fd_pr__pfet_01v8_hvt ad=0.1885 pd=1.88 as=0.1885 ps=1.88 w=0.65 l=0.15
X1 VPWR LOW DAC0_P__SB VPWR sky130_fd_pr__pfet_01v8_hvt ad=0.1885 pd=1.88 as=0.1885 ps=1.88 w=0.65 l=0.15
X2 SUBADC_R_P1_R0_N1 SUBADC_R_P1_R0_N2 VGND sky130_fd_pr__res_xhigh_po_1p41 l=29.21
X3 SUBADC_R_P0_R0_N17 SUBADC_R_P0_R0_N18 VGND sky130_fd_pr__res_xhigh_po_1p41 l=29.21
X4 VPWR LATCH_HIGH__SAMPLE__T LATCH_HIGH__SAMPLE__TB VPWR sky130_fd_pr__pfet_01v8_hvt ad=0.1885 pd=1.88 as=0.1885 ps=1.88 w=0.65 l=0.15
X5 LATCH_LOW__SAMPLE__MF LATCH_LOW__SAMPLE__CLKB LATCH_LOW__SAMPLE__T VPWR sky130_fd_pr__pfet_01v8_hvt ad=0.1885 pd=1.88 as=0.1885 ps=1.88 w=0.65 l=0.15
X6 MDAC_P__AMP__FIRST__TAIL MDAC_P__SUM MDAC_P__AMP__FIRST__MIR VGND sky130_fd_pr__nfet_01v8 ad=2.9 pd=20.58 as=2.9 ps=20.58 w=10 l=1
X7 REFP DAC0_N__SB DAC0_N VGND sky130_fd_pr__nfet_01v8 ad=0.1885 pd=1.88 as=0.1885 ps=1.88 w=0.65 l=0.15
X8 SUBADC_R_HIGH0_R0_N1 SUBADC_R_HIGH0_R0_N2 VGND sky130_fd_pr__res_xhigh_po_1p41 l=29.21
X9 SUBADC_R_P0_R0_N2 SUBADC_R_P0_R0_N3 VGND sky130_fd_pr__res_xhigh_po_1p41 l=29.21
X10 SUBADC_R_HIGH0_R0_N17 SUBADC_R_HIGH0_R0_N18 VGND sky130_fd_pr__res_xhigh_po_1p41 l=29.21
X11 SUBADC_R_HIGH0_R0_N9 SUBADC_R_HIGH0_R0_N10 VGND sky130_fd_pr__res_xhigh_po_1p41 l=29.21
X12 VPWR SUBADC__LOW__PREAMP__MIR SUBADC__LOW__PRE VPWR sky130_fd_pr__pfet_01v8_hvt ad=5.8 pd=40.58 as=5.8 ps=40.58 w=20 l=1
X13 VCM LOW DAC0_P VGND sky130_fd_pr__nfet_01v8 ad=0.1885 pd=1.88 as=0.1885 ps=1.88 w=0.65 l=0.15
X14 SUBADC_R_HIGH1_R0_N20 SUBADC_R_HIGH1_R0_N21 VGND sky130_fd_pr__res_xhigh_po_1p41 l=29.21
X15 SUBADC_R_P0_R0_N15 SUBADC_R_P0_R0_N16 VGND sky130_fd_pr__res_xhigh_po_1p41 l=29.21
X16 LATCH_LOW__SAMPLE__MF HOLD LATCH_LOW__SAMPLE__M VGND sky130_fd_pr__nfet_01v8 ad=0.1885 pd=1.88 as=0.1885 ps=1.88 w=0.65 l=0.15
X17 SUBADC_R_HIGH1_R0_N2 SUBADC_R_HIGH1_R0_N3 VGND sky130_fd_pr__res_xhigh_po_1p41 l=29.21
X18 SUBADC_R_P1_R0_N15 SUBADC_R_P1_R0_N16 VGND sky130_fd_pr__res_xhigh_po_1p41 l=29.21
X19 VGND BIAS OUTP VGND sky130_fd_pr__nfet_01v8 ad=2.9 pd=20.58 as=2.9 ps=20.58 w=10 l=1
X20 OUTN SAMPLE VCM VGND sky130_fd_pr__nfet_01v8 ad=2.32 pd=16.58 as=2.32 ps=16.58 w=8 l=0.15
X21 VGND LATCH_HIGH__SAMPLE__MB LATCH_HIGH__SAMPLE__MF VGND sky130_fd_pr__nfet_01v8 ad=0.1885 pd=1.88 as=0.1885 ps=1.88 w=0.65 l=0.15
X22 LATCH_LOW__SAMPLE__MF HOLD LATCH_LOW__SAMPLE__T VGND sky130_fd_pr__nfet_01v8 ad=0.1885 pd=1.88 as=0.1885 ps=1.88 w=0.65 l=0.15
X23 SUBADC_R_P1_R0_N3 SUBADC_R_P1_R0_N4 VGND sky130_fd_pr__res_xhigh_po_1p41 l=29.21
X24 LATCH_HIGH__SAMPLE__MF HOLD LATCH_HIGH__SAMPLE__T VGND sky130_fd_pr__nfet_01v8 ad=0.1885 pd=1.88 as=0.1885 ps=1.88 w=0.65 l=0.15
X25 DAC0_P DAC1_P__SB DAC_P VGND sky130_fd_pr__nfet_01v8 ad=0.1885 pd=1.88 as=0.1885 ps=1.88 w=0.65 l=0.15
X26 VPWR SUBADC__HIGH__PREAMP__MIR SUBADC__HIGH__PREAMP__MIR VPWR sky130_fd_pr__pfet_01v8_hvt ad=5.8 pd=40.58 as=5.8 ps=40.58 w=20 l=1
X27 SUBADC_R_HIGH0_R0_N11 SUBADC_R_HIGH0_R0_N12 VGND sky130_fd_pr__res_xhigh_po_1p41 l=29.21
X28 MDAC_N__AMP__COMP OUTN VGND sky130_fd_pr__res_xhigh_po_1p41 l=0.54
X29 VGND LATCH_HIGH__SAMPLE__T LATCH_HIGH__SAMPLE__TB VGND sky130_fd_pr__nfet_01v8 ad=0.1885 pd=1.88 as=0.1885 ps=1.88 w=0.65 l=0.15
X30 LOW LATCH_LOW__SAMPLE__CLKB LATCH_LOW__SAMPLE__T VGND sky130_fd_pr__nfet_01v8 ad=0.1885 pd=1.88 as=0.1885 ps=1.88 w=0.65 l=0.15
X31 SUBADC_R_HIGH1_R0_N13 SUBADC_R_HIGH1_R0_N14 VGND sky130_fd_pr__res_xhigh_po_1p41 l=29.21
X32 VGND LOW DAC0_N__SB VGND sky130_fd_pr__nfet_01v8 ad=0.1885 pd=1.88 as=0.1885 ps=1.88 w=0.65 l=0.15
X33 VPWR LATCH_HIGH__SAMPLE__TB HIGH VPWR sky130_fd_pr__pfet_01v8_hvt ad=0.1885 pd=1.88 as=0.1885 ps=1.88 w=0.65 l=0.15
X34 VCM LOW DAC0_N VGND sky130_fd_pr__nfet_01v8 ad=0.1885 pd=1.88 as=0.1885 ps=1.88 w=0.65 l=0.15
X35 HIGH HOLD LATCH_HIGH__SAMPLE__T VPWR sky130_fd_pr__pfet_01v8_hvt ad=0.1885 pd=1.88 as=0.1885 ps=1.88 w=0.65 l=0.15
X36 SUBADC_R_P1_R0_N7 SUBADC_R_P1_R0_N8 VGND sky130_fd_pr__res_xhigh_po_1p41 l=29.21
X37 SUBADC_R_LOW1_R0_N15 SUBADC_R_LOW1_R0_N16 VGND sky130_fd_pr__res_xhigh_po_1p41 l=29.21
X38 SUBADC_R_P0_R0_N11 SUBADC_R_P0_R0_N12 VGND sky130_fd_pr__res_xhigh_po_1p41 l=29.21
X39 VPWR LATCH_LOW__SAMPLE__T LATCH_LOW__SAMPLE__TB VPWR sky130_fd_pr__pfet_01v8_hvt ad=0.1885 pd=1.88 as=0.1885 ps=1.88 w=0.65 l=0.15
X40 SUBADC_R_HIGH1_R0_N12 SUBADC_R_HIGH1_R0_N13 VGND sky130_fd_pr__res_xhigh_po_1p41 l=29.21
X41 SUBADC_R_HIGH1_R0_N15 SUBADC_R_HIGH1_R0_N16 VGND sky130_fd_pr__res_xhigh_po_1p41 l=29.21
X42 VPWR RESET LATCH_LOW__RESET_DATA__SB VPWR sky130_fd_pr__pfet_01v8_hvt ad=0.1885 pd=1.88 as=0.1885 ps=1.88 w=0.65 l=0.15
X43 SUBADC_R_P0_R0_N19 SUBADC_R_P0_R0_N20 VGND sky130_fd_pr__res_xhigh_po_1p41 l=29.21
X44 VPWR RESET LATCH_HIGH__RESET_DATA__SB VPWR sky130_fd_pr__pfet_01v8_hvt ad=0.1885 pd=1.88 as=0.1885 ps=1.88 w=0.65 l=0.15
X45 VPWR SUBADC__HIGH__PREAMP__MIR SUBADC__HIGH__PRE VPWR sky130_fd_pr__pfet_01v8_hvt ad=5.8 pd=40.58 as=5.8 ps=40.58 w=20 l=1
X46 SUBADC_R_HIGH0_R0_N3 SUBADC_R_HIGH0_R0_N4 VGND sky130_fd_pr__res_xhigh_po_1p41 l=29.21
X47 SUBADC_R_P1_R0_N19 SUBADC_R_P1_R0_N20 VGND sky130_fd_pr__res_xhigh_po_1p41 l=29.21
X48 VGND SAMPLE SAMPLEB VGND sky130_fd_pr__nfet_01v8 ad=0.1885 pd=1.88 as=0.1885 ps=1.88 w=0.65 l=0.15
X49 VCM SUBADC_R_P1_R0_N0 VGND sky130_fd_pr__res_xhigh_po_1p41 l=29.21
X50 SUBADC_R_P0_R0_N1 SUBADC_R_P0_R0_N2 VGND sky130_fd_pr__res_xhigh_po_1p41 l=29.21
X51 SUBADC_R_LOW1_R0_N17 SUBADC_R_LOW1_R0_N18 VGND sky130_fd_pr__res_xhigh_po_1p41 l=29.21
X52 VGND BIAS SUBADC__LOW__PREAMP__TAIL VGND sky130_fd_pr__nfet_01v8 ad=0.58 pd=4.58 as=0.58 ps=4.58 w=2 l=1
X53 SUBADC_R_HIGH1_R0_N6 SUBADC_R_HIGH1_R0_N7 VGND sky130_fd_pr__res_xhigh_po_1p41 l=29.21
X54 SUBADC_R_HIGH1_R0_N11 SUBADC_R_HIGH1_R0_N12 VGND sky130_fd_pr__res_xhigh_po_1p41 l=29.21
X55 SUBADC_R_HIGH1_R0_N14 SUBADC_R_HIGH1_R0_N15 VGND sky130_fd_pr__res_xhigh_po_1p41 l=29.21
X56 MDAC_P__AMP__FIRST__TAIL VCM MDAC_P__AMP__PRE VGND sky130_fd_pr__nfet_01v8 ad=2.9 pd=20.58 as=2.9 ps=20.58 w=10 l=1
X57 DAC0_N DAC1_N__SB DAC_N VGND sky130_fd_pr__nfet_01v8 ad=0.1885 pd=1.88 as=0.1885 ps=1.88 w=0.65 l=0.15
X58 HIGH LATCH_HIGH__SAMPLE__CLKB LATCH_HIGH__SAMPLE__T VGND sky130_fd_pr__nfet_01v8 ad=0.1885 pd=1.88 as=0.1885 ps=1.88 w=0.65 l=0.15
X59 SUBADC_R_P1_R0_N17 SUBADC_R_P1_R0_N18 VGND sky130_fd_pr__res_xhigh_po_1p41 l=29.21
X60 SUBADC_R_P1_R0_N9 SUBADC_R_P1_R0_N10 VGND sky130_fd_pr__res_xhigh_po_1p41 l=29.21
X61 MDAC_N__SUM SAMPLEB VCM VPWR sky130_fd_pr__pfet_01v8_hvt ad=3.48 pd=24.58 as=3.48 ps=24.58 w=12 l=0.15
X62 VGND LATCH_LOW__SAMPLE__MB LATCH_LOW__SAMPLE__MF VGND sky130_fd_pr__nfet_01v8 ad=0.1885 pd=1.88 as=0.1885 ps=1.88 w=0.65 l=0.15
X63 VGND LOW DAC0_P__SB VGND sky130_fd_pr__nfet_01v8 ad=0.1885 pd=1.88 as=0.1885 ps=1.88 w=0.65 l=0.15
X64 SUBADC_R_LOW0_R0_N15 SUBADC_R_LOW0_R0_N16 VGND sky130_fd_pr__res_xhigh_po_1p41 l=29.21
X65 SUBADC_R_HIGH0_R0_N15 SUBADC_R_HIGH0_R0_N16 VGND sky130_fd_pr__res_xhigh_po_1p41 l=29.21
X66 MDAC_N__BOTTOM SAMPLE VINN VGND sky130_fd_pr__nfet_01v8 ad=2.32 pd=16.58 as=2.32 ps=16.58 w=8 l=0.15
X67 SUBADC_R_LOW1_R0_N16 SUBADC_R_LOW1_R0_N17 VGND sky130_fd_pr__res_xhigh_po_1p41 l=29.21
X68 SUBADC_R_HIGH0_R0_N22 SUBADC__AVG_HIGH VGND sky130_fd_pr__res_xhigh_po_1p41 l=29.21
X69 SUBADC_R_P0_R0_N21 SUBADC_R_P0_R0_N22 VGND sky130_fd_pr__res_xhigh_po_1p41 l=29.21
X70 SUBADC_R_P0_R0_N13 SUBADC_R_P0_R0_N14 VGND sky130_fd_pr__res_xhigh_po_1p41 l=29.21
X71 VGND LATCH_HIGH__SAMPLE__TB HIGH VGND sky130_fd_pr__nfet_01v8 ad=0.1885 pd=1.88 as=0.1885 ps=1.88 w=0.65 l=0.15
X72 LO_RAW RESET LATCH_LOW__DATA VPWR sky130_fd_pr__pfet_01v8_hvt ad=0.1885 pd=1.88 as=0.1885 ps=1.88 w=0.65 l=0.15
X73 VGND HOLD LATCH_LOW__SAMPLE__CLKB VGND sky130_fd_pr__nfet_01v8 ad=0.1885 pd=1.88 as=0.1885 ps=1.88 w=0.65 l=0.15
X74 VPWR LATCH_LOW__SAMPLE__M LATCH_LOW__SAMPLE__MB VPWR sky130_fd_pr__pfet_01v8_hvt ad=0.1885 pd=1.88 as=0.1885 ps=1.88 w=0.65 l=0.15
X75 MDAC_P__AMP__PRE MDAC_P__AMP__COMP sky130_fd_pr__cap_mim_m3_1 l=15.63 w=15.63
X76 SUBADC_R_P1_R0_N13 SUBADC_R_P1_R0_N14 VGND sky130_fd_pr__res_xhigh_po_1p41 l=29.21
X77 VGND LATCH_LOW__SAMPLE__T LATCH_LOW__SAMPLE__TB VGND sky130_fd_pr__nfet_01v8 ad=0.1885 pd=1.88 as=0.1885 ps=1.88 w=0.65 l=0.15
X78 SUBADC_R_LOW0_R0_N14 SUBADC_R_LOW0_R0_N15 VGND sky130_fd_pr__res_xhigh_po_1p41 l=29.21
X79 SUBADC_R_HIGH0_R0_N5 SUBADC_R_HIGH0_R0_N6 VGND sky130_fd_pr__res_xhigh_po_1p41 l=29.21
X80 DAC0_P HIGH DAC_P VPWR sky130_fd_pr__pfet_01v8_hvt ad=0.1885 pd=1.88 as=0.1885 ps=1.88 w=0.65 l=0.15
X81 SUBADC_R_HIGH1_R0_N22 SUBADC__AVG_HIGH VGND sky130_fd_pr__res_xhigh_po_1p41 l=29.21
X82 VGND RESET LATCH_HIGH__RESET_DATA__SB VGND sky130_fd_pr__nfet_01v8 ad=0.1885 pd=1.88 as=0.1885 ps=1.88 w=0.65 l=0.15
X83 VGND LATCH_LOW__RESET_DATA__SB LATCH_LOW__DATA VPWR sky130_fd_pr__pfet_01v8_hvt ad=0.1885 pd=1.88 as=0.1885 ps=1.88 w=0.65 l=0.15
X84 SUBADC_R_HIGH1_R0_N0 SUBADC_R_HIGH1_R0_N1 VGND sky130_fd_pr__res_xhigh_po_1p41 l=29.21
X85 SUBADC_R_P0_R0_N3 SUBADC_R_P0_R0_N4 VGND sky130_fd_pr__res_xhigh_po_1p41 l=29.21
X86 LATCH_LOW__DATA LATCH_LOW__SAMPLE__CLKB LATCH_LOW__SAMPLE__M VGND sky130_fd_pr__nfet_01v8 ad=0.1885 pd=1.88 as=0.1885 ps=1.88 w=0.65 l=0.15
X87 SUBADC_R_HIGH1_R0_N7 SUBADC_R_HIGH1_R0_N8 VGND sky130_fd_pr__res_xhigh_po_1p41 l=29.21
X88 SUBADC_R_HIGH0_R0_N18 SUBADC_R_HIGH0_R0_N19 VGND sky130_fd_pr__res_xhigh_po_1p41 l=29.21
X89 SUBADC_R_P1_R0_N11 SUBADC_R_P1_R0_N12 VGND sky130_fd_pr__res_xhigh_po_1p41 l=29.21
X90 SUBADC_R_LOW0_R0_N16 SUBADC_R_LOW0_R0_N17 VGND sky130_fd_pr__res_xhigh_po_1p41 l=29.21
X91 LO_RAW LATCH_LOW__RESET_DATA__SB LATCH_LOW__DATA VGND sky130_fd_pr__nfet_01v8 ad=0.1885 pd=1.88 as=0.1885 ps=1.88 w=0.65 l=0.15
X92 THP SUBADC_R_HIGH1_R0_N0 VGND sky130_fd_pr__res_xhigh_po_1p41 l=29.21
X93 SUBADC_R_LOW0_R0_N0 SUBADC_R_LOW0_R0_N1 VGND sky130_fd_pr__res_xhigh_po_1p41 l=29.21
X94 VINN SUBADC_R_HIGH0_R0_N0 VGND sky130_fd_pr__res_xhigh_po_1p41 l=29.21
X95 SUBADC_R_P1_R0_N5 SUBADC_R_P1_R0_N6 VGND sky130_fd_pr__res_xhigh_po_1p41 l=29.21
X96 SUBADC_R_LOW1_R0_N1 SUBADC_R_LOW1_R0_N2 VGND sky130_fd_pr__res_xhigh_po_1p41 l=29.21
X97 SUBADC_R_LOW0_R0_N3 SUBADC_R_LOW0_R0_N4 VGND sky130_fd_pr__res_xhigh_po_1p41 l=29.21
X98 VGND RESET LATCH_LOW__DATA VGND sky130_fd_pr__nfet_01v8 ad=0.1885 pd=1.88 as=0.1885 ps=1.88 w=0.65 l=0.15
X99 MDAC_N__AMP__FIRST__TAIL VCM MDAC_N__AMP__PRE VGND sky130_fd_pr__nfet_01v8 ad=2.9 pd=20.58 as=2.9 ps=20.58 w=10 l=1
X100 SUBADC_R_HIGH1_R0_N18 SUBADC_R_HIGH1_R0_N19 VGND sky130_fd_pr__res_xhigh_po_1p41 l=29.21
X101 VGND BIAS MDAC_N__AMP__FIRST__TAIL VGND sky130_fd_pr__nfet_01v8 ad=0.58 pd=4.58 as=0.58 ps=4.58 w=2 l=1
X102 SUBADC_R_LOW1_R0_N0 SUBADC_R_LOW1_R0_N1 VGND sky130_fd_pr__res_xhigh_po_1p41 l=29.21
X103 VGND LATCH_HIGH__RESET_DATA__SB LATCH_HIGH__DATA VPWR sky130_fd_pr__pfet_01v8_hvt ad=0.1885 pd=1.88 as=0.1885 ps=1.88 w=0.65 l=0.15
X104 VINN SUBADC_R_LOW0_R0_N0 VGND sky130_fd_pr__res_xhigh_po_1p41 l=29.21
X105 SUBADC_R_LOW0_R0_N2 SUBADC_R_LOW0_R0_N3 VGND sky130_fd_pr__res_xhigh_po_1p41 l=29.21
X106 MDAC_N__SUM MDAC_N__BOTTOM sky130_fd_pr__cap_mim_m3_1 l=22.17 w=22.17
X107 SUBADC_R_LOW1_R0_N3 SUBADC_R_LOW1_R0_N4 VGND sky130_fd_pr__res_xhigh_po_1p41 l=29.21
X108 SUBADC_R_HIGH1_R0_N10 SUBADC_R_HIGH1_R0_N11 VGND sky130_fd_pr__res_xhigh_po_1p41 l=29.21
X109 VGND BIAS SUBADC__HIGH__PREAMP__TAIL VGND sky130_fd_pr__nfet_01v8 ad=0.58 pd=4.58 as=0.58 ps=4.58 w=2 l=1
X110 SUBADC_R_LOW0_R0_N9 SUBADC_R_LOW0_R0_N10 VGND sky130_fd_pr__res_xhigh_po_1p41 l=29.21
X111 SUBADC_R_LOW1_R0_N10 SUBADC_R_LOW1_R0_N11 VGND sky130_fd_pr__res_xhigh_po_1p41 l=29.21
X112 SUBADC_R_LOW1_R0_N20 SUBADC_R_LOW1_R0_N21 VGND sky130_fd_pr__res_xhigh_po_1p41 l=29.21
X113 SUBADC_R_HIGH1_R0_N17 SUBADC_R_HIGH1_R0_N18 VGND sky130_fd_pr__res_xhigh_po_1p41 l=29.21
X114 MDAC_N__SUM OUTN sky130_fd_pr__cap_mim_m3_1 l=22.17 w=22.17
X115 VINP SUBADC_R_P0_R0_N0 VGND sky130_fd_pr__res_xhigh_po_1p41 l=29.21
X116 SUBADC_R_P0_R0_N7 SUBADC_R_P0_R0_N8 VGND sky130_fd_pr__res_xhigh_po_1p41 l=29.21
X117 VPWR MDAC_P__AMP__FIRST__MIR MDAC_P__AMP__PRE VPWR sky130_fd_pr__pfet_01v8_hvt ad=5.8 pd=40.58 as=5.8 ps=40.58 w=20 l=1
X118 VGND SUBADC__LOW__PRE LO_RAW VGND sky130_fd_pr__nfet_01v8 ad=1.16 pd=8.58 as=1.16 ps=8.58 w=4 l=0.15
X119 VPWR HIGH DAC1_P__SB VPWR sky130_fd_pr__pfet_01v8_hvt ad=0.1885 pd=1.88 as=0.1885 ps=1.88 w=0.65 l=0.15
X120 SUBADC_R_LOW1_R0_N2 SUBADC_R_LOW1_R0_N3 VGND sky130_fd_pr__res_xhigh_po_1p41 l=29.21
X121 SUBADC_R_LOW0_R0_N1 SUBADC_R_LOW0_R0_N2 VGND sky130_fd_pr__res_xhigh_po_1p41 l=29.21
X122 SUBADC_R_P0_R0_N20 SUBADC_R_P0_R0_N21 VGND sky130_fd_pr__res_xhigh_po_1p41 l=29.21
X123 SUBADC_R_LOW1_R0_N22 SUBADC__AVG_LOW VGND sky130_fd_pr__res_xhigh_po_1p41 l=29.21
X124 SUBADC_R_HIGH1_R0_N16 SUBADC_R_HIGH1_R0_N17 VGND sky130_fd_pr__res_xhigh_po_1p41 l=29.21
X125 SUBADC_R_HIGH1_R0_N19 SUBADC_R_HIGH1_R0_N20 VGND sky130_fd_pr__res_xhigh_po_1p41 l=29.21
X126 SUBADC_R_P1_R0_N20 SUBADC_R_P1_R0_N21 VGND sky130_fd_pr__res_xhigh_po_1p41 l=29.21
X127 VPWR MDAC_P__AMP__FIRST__MIR MDAC_P__AMP__FIRST__MIR VPWR sky130_fd_pr__pfet_01v8_hvt ad=5.8 pd=40.58 as=5.8 ps=40.58 w=20 l=1
X128 LATCH_HIGH__DATA HOLD LATCH_HIGH__SAMPLE__M VPWR sky130_fd_pr__pfet_01v8_hvt ad=0.1885 pd=1.88 as=0.1885 ps=1.88 w=0.65 l=0.15
X129 VGND RESET LATCH_HIGH__DATA VGND sky130_fd_pr__nfet_01v8 ad=0.1885 pd=1.88 as=0.1885 ps=1.88 w=0.65 l=0.15
X130 SUBADC_R_LOW0_R0_N13 SUBADC_R_LOW0_R0_N14 VGND sky130_fd_pr__res_xhigh_po_1p41 l=29.21
X131 SUBADC_R_LOW1_R0_N4 SUBADC_R_LOW1_R0_N5 VGND sky130_fd_pr__res_xhigh_po_1p41 l=29.21
X132 VGND LATCH_LOW__SAMPLE__M LATCH_LOW__SAMPLE__MB VGND sky130_fd_pr__nfet_01v8 ad=0.1885 pd=1.88 as=0.1885 ps=1.88 w=0.65 l=0.15
X133 SUBADC_R_LOW0_R0_N20 SUBADC_R_LOW0_R0_N21 VGND sky130_fd_pr__res_xhigh_po_1p41 l=29.21
X134 SUBADC_R_LOW1_R0_N21 SUBADC_R_LOW1_R0_N22 VGND sky130_fd_pr__res_xhigh_po_1p41 l=29.21
X135 SUBADC_R_HIGH1_R0_N3 SUBADC_R_HIGH1_R0_N4 VGND sky130_fd_pr__res_xhigh_po_1p41 l=29.21
X136 SUBADC_R_P0_R0_N9 SUBADC_R_P0_R0_N10 VGND sky130_fd_pr__res_xhigh_po_1p41 l=29.21
X137 MDAC_P__AMP__COMP OUTP VGND sky130_fd_pr__res_xhigh_po_1p41 l=0.54
X138 SUBADC_R_HIGH0_R0_N16 SUBADC_R_HIGH0_R0_N17 VGND sky130_fd_pr__res_xhigh_po_1p41 l=29.21
X139 SUBADC_R_LOW0_R0_N12 SUBADC_R_LOW0_R0_N13 VGND sky130_fd_pr__res_xhigh_po_1p41 l=29.21
X140 SUBADC_R_LOW1_R0_N13 SUBADC_R_LOW1_R0_N14 VGND sky130_fd_pr__res_xhigh_po_1p41 l=29.21
X141 SUBADC_R_LOW0_R0_N19 SUBADC_R_LOW0_R0_N20 VGND sky130_fd_pr__res_xhigh_po_1p41 l=29.21
X142 LOW HOLD LATCH_LOW__SAMPLE__T VPWR sky130_fd_pr__pfet_01v8_hvt ad=0.1885 pd=1.88 as=0.1885 ps=1.88 w=0.65 l=0.15
X143 SUBADC_R_LOW0_R0_N22 SUBADC__AVG_LOW VGND sky130_fd_pr__res_xhigh_po_1p41 l=29.21
X144 SUBADC_R_HIGH1_R0_N5 SUBADC_R_HIGH1_R0_N6 VGND sky130_fd_pr__res_xhigh_po_1p41 l=29.21
X145 VPWR HIGH DAC1_N__SB VPWR sky130_fd_pr__pfet_01v8_hvt ad=0.1885 pd=1.88 as=0.1885 ps=1.88 w=0.65 l=0.15
X146 LATCH_HIGH__DATA LATCH_HIGH__SAMPLE__CLKB LATCH_HIGH__SAMPLE__M VGND sky130_fd_pr__nfet_01v8 ad=0.1885 pd=1.88 as=0.1885 ps=1.88 w=0.65 l=0.15
X147 VGND HIGH DAC1_P__SB VGND sky130_fd_pr__nfet_01v8 ad=0.1885 pd=1.88 as=0.1885 ps=1.88 w=0.65 l=0.15
X148 SUBADC_R_HIGH0_R0_N6 SUBADC_R_HIGH0_R0_N7 VGND sky130_fd_pr__res_xhigh_po_1p41 l=29.21
X149 SUBADC_R_LOW1_R0_N12 SUBADC_R_LOW1_R0_N13 VGND sky130_fd_pr__res_xhigh_po_1p41 l=29.21
X150 SUBADC_R_LOW0_R0_N11 SUBADC_R_LOW0_R0_N12 VGND sky130_fd_pr__res_xhigh_po_1p41 l=29.21
X151 MDAC_N__AMP__FIRST__TAIL MDAC_N__SUM MDAC_N__AMP__FIRST__MIR VGND sky130_fd_pr__nfet_01v8 ad=2.9 pd=20.58 as=2.9 ps=20.58 w=10 l=1
X152 SUBADC_R_LOW0_R0_N21 SUBADC_R_LOW0_R0_N22 VGND sky130_fd_pr__res_xhigh_po_1p41 l=29.21
X153 SUBADC_R_HIGH1_R0_N4 SUBADC_R_HIGH1_R0_N5 VGND sky130_fd_pr__res_xhigh_po_1p41 l=29.21
X154 SUBADC_R_HIGH0_R0_N8 SUBADC_R_HIGH0_R0_N9 VGND sky130_fd_pr__res_xhigh_po_1p41 l=29.21
X155 SUBADC_R_LOW1_R0_N14 SUBADC_R_LOW1_R0_N15 VGND sky130_fd_pr__res_xhigh_po_1p41 l=29.21
X156 SUBADC_R_LOW0_R0_N5 SUBADC_R_LOW0_R0_N6 VGND sky130_fd_pr__res_xhigh_po_1p41 l=29.21
X157 SUBADC_R_LOW1_R0_N6 SUBADC_R_LOW1_R0_N7 VGND sky130_fd_pr__res_xhigh_po_1p41 l=29.21
X158 VGND SUBADC__HIGH__PRE HI_RAW VGND sky130_fd_pr__nfet_01v8 ad=1.16 pd=8.58 as=1.16 ps=8.58 w=4 l=0.15
X159 SUBADC_R_LOW0_R0_N8 SUBADC_R_LOW0_R0_N9 VGND sky130_fd_pr__res_xhigh_po_1p41 l=29.21
X160 SUBADC_R_P0_R0_N6 SUBADC_R_P0_R0_N7 VGND sky130_fd_pr__res_xhigh_po_1p41 l=29.21
X161 VGND BIAS OUTN VGND sky130_fd_pr__nfet_01v8 ad=2.9 pd=20.58 as=2.9 ps=20.58 w=10 l=1
X162 VPWR LATCH_HIGH__SAMPLE__M LATCH_HIGH__SAMPLE__MB VPWR sky130_fd_pr__pfet_01v8_hvt ad=0.1885 pd=1.88 as=0.1885 ps=1.88 w=0.65 l=0.15
X163 DAC0_N HIGH DAC_N VPWR sky130_fd_pr__pfet_01v8_hvt ad=0.1885 pd=1.88 as=0.1885 ps=1.88 w=0.65 l=0.15
X164 HI_RAW RESET LATCH_HIGH__DATA VPWR sky130_fd_pr__pfet_01v8_hvt ad=0.1885 pd=1.88 as=0.1885 ps=1.88 w=0.65 l=0.15
X165 SUBADC_R_P1_R0_N6 SUBADC_R_P1_R0_N7 VGND sky130_fd_pr__res_xhigh_po_1p41 l=29.21
X166 MDAC_P__SUM SAMPLE VCM VGND sky130_fd_pr__nfet_01v8 ad=2.32 pd=16.58 as=2.32 ps=16.58 w=8 l=0.15
X167 VPWR SUBADC__HIGH__PRE HI_RAW VPWR sky130_fd_pr__pfet_01v8_hvt ad=2.32 pd=16.58 as=2.32 ps=16.58 w=8 l=0.15
X168 SUBADC_R_HIGH0_R0_N20 SUBADC_R_HIGH0_R0_N21 VGND sky130_fd_pr__res_xhigh_po_1p41 l=29.21
X169 SUBADC_R_LOW1_R0_N5 SUBADC_R_LOW1_R0_N6 VGND sky130_fd_pr__res_xhigh_po_1p41 l=29.21
X170 SUBADC_R_LOW0_R0_N4 SUBADC_R_LOW0_R0_N5 VGND sky130_fd_pr__res_xhigh_po_1p41 l=29.21
X171 SUBADC_R_LOW0_R0_N7 SUBADC_R_LOW0_R0_N8 VGND sky130_fd_pr__res_xhigh_po_1p41 l=29.21
X172 SUBADC_R_LOW1_R0_N8 SUBADC_R_LOW1_R0_N9 VGND sky130_fd_pr__res_xhigh_po_1p41 l=29.21
X173 SUBADC_R_P1_R0_N2 SUBADC_R_P1_R0_N3 VGND sky130_fd_pr__res_xhigh_po_1p41 l=29.21
X174 SUBADC_R_P0_R0_N18 SUBADC_R_P0_R0_N19 VGND sky130_fd_pr__res_xhigh_po_1p41 l=29.21
X175 MDAC_P__BOTTOM SAMPLE DAC_P VPWR sky130_fd_pr__pfet_01v8_hvt ad=3.48 pd=24.58 as=3.48 ps=24.58 w=12 l=0.15
X176 REFP LOW DAC0_N VPWR sky130_fd_pr__pfet_01v8_hvt ad=0.1885 pd=1.88 as=0.1885 ps=1.88 w=0.65 l=0.15
X177 VGND HIGH DAC1_N__SB VGND sky130_fd_pr__nfet_01v8 ad=0.1885 pd=1.88 as=0.1885 ps=1.88 w=0.65 l=0.15
X178 REFN DAC1_N__SB DAC_N VPWR sky130_fd_pr__pfet_01v8_hvt ad=0.1885 pd=1.88 as=0.1885 ps=1.88 w=0.65 l=0.15
X179 OUTP SAMPLE VCM VGND sky130_fd_pr__nfet_01v8 ad=2.32 pd=16.58 as=2.32 ps=16.58 w=8 l=0.15
X180 SUBADC_R_HIGH0_R0_N2 SUBADC_R_HIGH0_R0_N3 VGND sky130_fd_pr__res_xhigh_po_1p41 l=29.21
X181 SUBADC_R_P1_R0_N18 SUBADC_R_P1_R0_N19 VGND sky130_fd_pr__res_xhigh_po_1p41 l=29.21
X182 VPWR LATCH_LOW__SAMPLE__TB LOW VPWR sky130_fd_pr__pfet_01v8_hvt ad=0.1885 pd=1.88 as=0.1885 ps=1.88 w=0.65 l=0.15
X183 SUBADC_R_HIGH0_R0_N10 SUBADC_R_HIGH0_R0_N11 VGND sky130_fd_pr__res_xhigh_po_1p41 l=29.21
X184 SUBADC_R_P0_R0_N0 SUBADC_R_P0_R0_N1 VGND sky130_fd_pr__res_xhigh_po_1p41 l=29.21
X185 SUBADC_R_LOW0_R0_N6 SUBADC_R_LOW0_R0_N7 VGND sky130_fd_pr__res_xhigh_po_1p41 l=29.21
X186 SUBADC_R_P0_R0_N8 SUBADC_R_P0_R0_N9 VGND sky130_fd_pr__res_xhigh_po_1p41 l=29.21
X187 SUBADC_R_LOW1_R0_N7 SUBADC_R_LOW1_R0_N8 VGND sky130_fd_pr__res_xhigh_po_1p41 l=29.21
X188 SUBADC_R_P0_R0_N16 SUBADC_R_P0_R0_N17 VGND sky130_fd_pr__res_xhigh_po_1p41 l=29.21
X189 LATCH_HIGH__SAMPLE__MF HOLD LATCH_HIGH__SAMPLE__M VGND sky130_fd_pr__nfet_01v8 ad=0.1885 pd=1.88 as=0.1885 ps=1.88 w=0.65 l=0.15
X190 SUBADC_R_P1_R0_N16 SUBADC_R_P1_R0_N17 VGND sky130_fd_pr__res_xhigh_po_1p41 l=29.21
X191 SUBADC_R_P1_R0_N8 SUBADC_R_P1_R0_N9 VGND sky130_fd_pr__res_xhigh_po_1p41 l=29.21
X192 VPWR SAMPLE SAMPLEB VPWR sky130_fd_pr__pfet_01v8_hvt ad=0.1885 pd=1.88 as=0.1885 ps=1.88 w=0.65 l=0.15
X193 SUBADC_R_HIGH0_R0_N14 SUBADC_R_HIGH0_R0_N15 VGND sky130_fd_pr__res_xhigh_po_1p41 l=29.21
X194 THN SUBADC_R_LOW1_R0_N0 VGND sky130_fd_pr__res_xhigh_po_1p41 l=29.21
X195 SUBADC_R_LOW0_R0_N18 SUBADC_R_LOW0_R0_N19 VGND sky130_fd_pr__res_xhigh_po_1p41 l=29.21
X196 SUBADC_R_P0_R0_N12 SUBADC_R_P0_R0_N13 VGND sky130_fd_pr__res_xhigh_po_1p41 l=29.21
X197 VPWR MDAC_N__AMP__FIRST__MIR MDAC_N__AMP__FIRST__MIR VPWR sky130_fd_pr__pfet_01v8_hvt ad=5.8 pd=40.58 as=5.8 ps=40.58 w=20 l=1
X198 SUBADC_R_LOW1_R0_N9 SUBADC_R_LOW1_R0_N10 VGND sky130_fd_pr__res_xhigh_po_1p41 l=29.21
X199 REFN HIGH DAC_N VGND sky130_fd_pr__nfet_01v8 ad=0.1885 pd=1.88 as=0.1885 ps=1.88 w=0.65 l=0.15
X200 SUBADC_R_P1_R0_N4 SUBADC_R_P1_R0_N5 VGND sky130_fd_pr__res_xhigh_po_1p41 l=29.21
X201 SUBADC_R_HIGH0_R0_N4 SUBADC_R_HIGH0_R0_N5 VGND sky130_fd_pr__res_xhigh_po_1p41 l=29.21
X202 SUBADC_R_LOW0_R0_N17 SUBADC_R_LOW0_R0_N18 VGND sky130_fd_pr__res_xhigh_po_1p41 l=29.21
X203 SUBADC_R_HIGH0_R0_N12 SUBADC_R_HIGH0_R0_N13 VGND sky130_fd_pr__res_xhigh_po_1p41 l=29.21
X204 VGND BIAS MDAC_P__AMP__FIRST__TAIL VGND sky130_fd_pr__nfet_01v8 ad=0.58 pd=4.58 as=0.58 ps=4.58 w=2 l=1
X205 VPWR MDAC_P__AMP__PRE OUTP VPWR sky130_fd_pr__pfet_01v8_hvt ad=5.8 pd=40.58 as=5.8 ps=40.58 w=20 l=1
X206 MDAC_N__BOTTOM SAMPLEB DAC_N VGND sky130_fd_pr__nfet_01v8 ad=2.32 pd=16.58 as=2.32 ps=16.58 w=8 l=0.15
X207 VGND RESET LATCH_LOW__RESET_DATA__SB VGND sky130_fd_pr__nfet_01v8 ad=0.1885 pd=1.88 as=0.1885 ps=1.88 w=0.65 l=0.15
X208 VPWR HOLD LATCH_LOW__SAMPLE__CLKB VPWR sky130_fd_pr__pfet_01v8_hvt ad=0.1885 pd=1.88 as=0.1885 ps=1.88 w=0.65 l=0.15
X209 SUBADC_R_P0_R0_N10 SUBADC_R_P0_R0_N11 VGND sky130_fd_pr__res_xhigh_po_1p41 l=29.21
X210 SUBADC__HIGH__PREAMP__TAIL SUBADC__AVG_HIGH SUBADC__HIGH__PREAMP__MIR VGND sky130_fd_pr__nfet_01v8 ad=2.9 pd=20.58 as=2.9 ps=20.58 w=10 l=1
X211 MDAC_P__SUM OUTP sky130_fd_pr__cap_mim_m3_1 l=22.17 w=22.17
X212 SUBADC_R_P1_R0_N10 SUBADC_R_P1_R0_N11 VGND sky130_fd_pr__res_xhigh_po_1p41 l=29.21
X213 MDAC_N__BOTTOM SAMPLEB VINN VPWR sky130_fd_pr__pfet_01v8_hvt ad=3.48 pd=24.58 as=3.48 ps=24.58 w=12 l=0.15
X214 MDAC_N__SUM SAMPLE VCM VGND sky130_fd_pr__nfet_01v8 ad=2.32 pd=16.58 as=2.32 ps=16.58 w=8 l=0.15
X215 VGND LATCH_LOW__SAMPLE__TB LOW VGND sky130_fd_pr__nfet_01v8 ad=0.1885 pd=1.88 as=0.1885 ps=1.88 w=0.65 l=0.15
X216 REFN DAC0_P__SB DAC0_P VGND sky130_fd_pr__nfet_01v8 ad=0.1885 pd=1.88 as=0.1885 ps=1.88 w=0.65 l=0.15
X217 MDAC_P__SUM MDAC_P__BOTTOM sky130_fd_pr__cap_mim_m3_1 l=22.17 w=22.17
X218 SUBADC_R_P0_R0_N22 SUBADC__AVG_P VGND sky130_fd_pr__res_xhigh_po_1p41 l=29.21
X219 SUBADC_R_P0_R0_N4 SUBADC_R_P0_R0_N5 VGND sky130_fd_pr__res_xhigh_po_1p41 l=29.21
X220 MDAC_P__SUM SAMPLEB VCM VPWR sky130_fd_pr__pfet_01v8_hvt ad=3.48 pd=24.58 as=3.48 ps=24.58 w=12 l=0.15
X221 VPWR MDAC_N__AMP__FIRST__MIR MDAC_N__AMP__PRE VPWR sky130_fd_pr__pfet_01v8_hvt ad=5.8 pd=40.58 as=5.8 ps=40.58 w=20 l=1
X222 SUBADC__LOW__PREAMP__TAIL SUBADC__AVG_P SUBADC__LOW__PRE VGND sky130_fd_pr__nfet_01v8 ad=2.9 pd=20.58 as=2.9 ps=20.58 w=10 l=1
X223 MDAC_N__SUM MDAC_N__BOTTOM sky130_fd_pr__cap_mim_m3_1 l=22.17 w=22.17
X224 SUBADC_R_P1_R0_N12 SUBADC_R_P1_R0_N13 VGND sky130_fd_pr__res_xhigh_po_1p41 l=29.21
X225 SUBADC_R_LOW0_R0_N10 SUBADC_R_LOW0_R0_N11 VGND sky130_fd_pr__res_xhigh_po_1p41 l=29.21
X226 SUBADC_R_LOW1_R0_N11 SUBADC_R_LOW1_R0_N12 VGND sky130_fd_pr__res_xhigh_po_1p41 l=29.21
X227 OUTP SAMPLEB VCM VPWR sky130_fd_pr__pfet_01v8_hvt ad=3.48 pd=24.58 as=3.48 ps=24.58 w=12 l=0.15
X228 VGND LATCH_HIGH__SAMPLE__M LATCH_HIGH__SAMPLE__MB VGND sky130_fd_pr__nfet_01v8 ad=0.1885 pd=1.88 as=0.1885 ps=1.88 w=0.65 l=0.15
X229 SUBADC_R_P1_R0_N0 SUBADC_R_P1_R0_N1 VGND sky130_fd_pr__res_xhigh_po_1p41 l=29.21
X230 MDAC_P__BOTTOM SAMPLEB DAC_P VGND sky130_fd_pr__nfet_01v8 ad=2.32 pd=16.58 as=2.32 ps=16.58 w=8 l=0.15
X231 VPWR HOLD LATCH_HIGH__SAMPLE__CLKB VPWR sky130_fd_pr__pfet_01v8_hvt ad=0.1885 pd=1.88 as=0.1885 ps=1.88 w=0.65 l=0.15
X232 SUBADC_R_HIGH0_R0_N0 SUBADC_R_HIGH0_R0_N1 VGND sky130_fd_pr__res_xhigh_po_1p41 l=29.21
X233 MDAC_P__BOTTOM SAMPLEB VINP VPWR sky130_fd_pr__pfet_01v8_hvt ad=3.48 pd=24.58 as=3.48 ps=24.58 w=12 l=0.15
X234 SUBADC_R_HIGH0_R0_N13 SUBADC_R_HIGH0_R0_N14 VGND sky130_fd_pr__res_xhigh_po_1p41 l=29.21
X235 SUBADC_R_P0_R0_N14 SUBADC_R_P0_R0_N15 VGND sky130_fd_pr__res_xhigh_po_1p41 l=29.21
X236 SUBADC_R_HIGH0_R0_N21 SUBADC_R_HIGH0_R0_N22 VGND sky130_fd_pr__res_xhigh_po_1p41 l=29.21
X237 SUBADC_R_P1_R0_N22 SUBADC__AVG_P VGND sky130_fd_pr__res_xhigh_po_1p41 l=29.21
X238 SUBADC_R_P1_R0_N14 SUBADC_R_P1_R0_N15 VGND sky130_fd_pr__res_xhigh_po_1p41 l=29.21
X239 REFN LOW DAC0_P VPWR sky130_fd_pr__pfet_01v8_hvt ad=0.1885 pd=1.88 as=0.1885 ps=1.88 w=0.65 l=0.15
X240 REFP DAC1_P__SB DAC_P VPWR sky130_fd_pr__pfet_01v8_hvt ad=0.1885 pd=1.88 as=0.1885 ps=1.88 w=0.65 l=0.15
X241 LATCH_LOW__DATA HOLD LATCH_LOW__SAMPLE__M VPWR sky130_fd_pr__pfet_01v8_hvt ad=0.1885 pd=1.88 as=0.1885 ps=1.88 w=0.65 l=0.15
X242 MDAC_N__BOTTOM SAMPLE DAC_N VPWR sky130_fd_pr__pfet_01v8_hvt ad=3.48 pd=24.58 as=3.48 ps=24.58 w=12 l=0.15
X243 VCM DAC0_P__SB DAC0_P VPWR sky130_fd_pr__pfet_01v8_hvt ad=0.1885 pd=1.88 as=0.1885 ps=1.88 w=0.65 l=0.15
X244 SUBADC_R_HIGH1_R0_N21 SUBADC_R_HIGH1_R0_N22 VGND sky130_fd_pr__res_xhigh_po_1p41 l=29.21
X245 VPWR LATCH_HIGH__SAMPLE__MB LATCH_HIGH__SAMPLE__MF VPWR sky130_fd_pr__pfet_01v8_hvt ad=0.1885 pd=1.88 as=0.1885 ps=1.88 w=0.65 l=0.15
X246 LATCH_LOW__SAMPLE__MF LATCH_LOW__SAMPLE__CLKB LATCH_LOW__SAMPLE__M VPWR sky130_fd_pr__pfet_01v8_hvt ad=0.1885 pd=1.88 as=0.1885 ps=1.88 w=0.65 l=0.15
X247 SUBADC__HIGH__PREAMP__TAIL SUBADC__AVG_P SUBADC__HIGH__PRE VGND sky130_fd_pr__nfet_01v8 ad=2.9 pd=20.58 as=2.9 ps=20.58 w=10 l=1
X248 HI_RAW LATCH_HIGH__RESET_DATA__SB LATCH_HIGH__DATA VGND sky130_fd_pr__nfet_01v8 ad=0.1885 pd=1.88 as=0.1885 ps=1.88 w=0.65 l=0.15
X249 LATCH_HIGH__SAMPLE__MF LATCH_HIGH__SAMPLE__CLKB LATCH_HIGH__SAMPLE__M VPWR sky130_fd_pr__pfet_01v8_hvt ad=0.1885 pd=1.88 as=0.1885 ps=1.88 w=0.65 l=0.15
X250 SUBADC__LOW__PREAMP__TAIL SUBADC__AVG_LOW SUBADC__LOW__PREAMP__MIR VGND sky130_fd_pr__nfet_01v8 ad=2.9 pd=20.58 as=2.9 ps=20.58 w=10 l=1
X251 REFP HIGH DAC_P VGND sky130_fd_pr__nfet_01v8 ad=0.1885 pd=1.88 as=0.1885 ps=1.88 w=0.65 l=0.15
X252 SUBADC_R_HIGH1_R0_N8 SUBADC_R_HIGH1_R0_N9 VGND sky130_fd_pr__res_xhigh_po_1p41 l=29.21
X253 SUBADC_R_LOW1_R0_N18 SUBADC_R_LOW1_R0_N19 VGND sky130_fd_pr__res_xhigh_po_1p41 l=29.21
X254 VPWR LOW DAC0_N__SB VPWR sky130_fd_pr__pfet_01v8_hvt ad=0.1885 pd=1.88 as=0.1885 ps=1.88 w=0.65 l=0.15
X255 MDAC_N__AMP__PRE MDAC_N__AMP__COMP sky130_fd_pr__cap_mim_m3_1 l=15.63 w=15.63
X256 VPWR SUBADC__LOW__PRE LO_RAW VPWR sky130_fd_pr__pfet_01v8_hvt ad=2.32 pd=16.58 as=2.32 ps=16.58 w=8 l=0.15
X257 VPWR MDAC_N__AMP__PRE OUTN VPWR sky130_fd_pr__pfet_01v8_hvt ad=5.8 pd=40.58 as=5.8 ps=40.58 w=20 l=1
X258 SUBADC_R_HIGH0_R0_N7 SUBADC_R_HIGH0_R0_N8 VGND sky130_fd_pr__res_xhigh_po_1p41 l=29.21
X259 VCM DAC0_N__SB DAC0_N VPWR sky130_fd_pr__pfet_01v8_hvt ad=0.1885 pd=1.88 as=0.1885 ps=1.88 w=0.65 l=0.15
X260 VPWR SUBADC__LOW__PREAMP__MIR SUBADC__LOW__PREAMP__MIR VPWR sky130_fd_pr__pfet_01v8_hvt ad=5.8 pd=40.58 as=5.8 ps=40.58 w=20 l=1
X261 SUBADC_R_P0_R0_N5 SUBADC_R_P0_R0_N6 VGND sky130_fd_pr__res_xhigh_po_1p41 l=29.21
X262 SUBADC_R_HIGH1_R0_N1 SUBADC_R_HIGH1_R0_N2 VGND sky130_fd_pr__res_xhigh_po_1p41 l=29.21
X263 SUBADC_R_HIGH1_R0_N9 SUBADC_R_HIGH1_R0_N10 VGND sky130_fd_pr__res_xhigh_po_1p41 l=29.21
X264 MDAC_P__SUM MDAC_P__BOTTOM sky130_fd_pr__cap_mim_m3_1 l=22.17 w=22.17
X265 SUBADC_R_LOW1_R0_N19 SUBADC_R_LOW1_R0_N20 VGND sky130_fd_pr__res_xhigh_po_1p41 l=29.21
X266 MDAC_P__BOTTOM SAMPLE VINP VGND sky130_fd_pr__nfet_01v8 ad=2.32 pd=16.58 as=2.32 ps=16.58 w=8 l=0.15
X267 VGND HOLD LATCH_HIGH__SAMPLE__CLKB VGND sky130_fd_pr__nfet_01v8 ad=0.1885 pd=1.88 as=0.1885 ps=1.88 w=0.65 l=0.15
X268 SUBADC_R_HIGH0_R0_N19 SUBADC_R_HIGH0_R0_N20 VGND sky130_fd_pr__res_xhigh_po_1p41 l=29.21
X269 SUBADC_R_P1_R0_N21 SUBADC_R_P1_R0_N22 VGND sky130_fd_pr__res_xhigh_po_1p41 l=29.21
X270 OUTN SAMPLEB VCM VPWR sky130_fd_pr__pfet_01v8_hvt ad=3.48 pd=24.58 as=3.48 ps=24.58 w=12 l=0.15
X271 LATCH_HIGH__SAMPLE__MF LATCH_HIGH__SAMPLE__CLKB LATCH_HIGH__SAMPLE__T VPWR sky130_fd_pr__pfet_01v8_hvt ad=0.1885 pd=1.88 as=0.1885 ps=1.88 w=0.65 l=0.15
.ends

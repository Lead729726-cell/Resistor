.subckt pipeline16_stage VINP VINN OUTP OUTN VCM REFP REFN THP THN BIAS SAMPLE HOLD RESET HIGH LOW VPWR VGND
XDAC0_N_IS_MN DAC0_N__SB LOW VGND VGND sky130_fd_pr__nfet_01v8 w=0.65 l=0.15 nf=1 m=1
XDAC0_N_IS_MP DAC0_N__SB LOW VPWR VPWR sky130_fd_pr__pfet_01v8_hvt w=0.65 l=0.15 nf=1 m=1
XDAC0_N_MNA DAC0_N DAC0_N__SB REFP VGND sky130_fd_pr__nfet_01v8 w=0.65 l=0.15 nf=1 m=1
XDAC0_N_MNB DAC0_N LOW VCM VGND sky130_fd_pr__nfet_01v8 w=0.65 l=0.15 nf=1 m=1
XDAC0_N_MPA DAC0_N LOW REFP VPWR sky130_fd_pr__pfet_01v8_hvt w=0.65 l=0.15 nf=1 m=1
XDAC0_N_MPB DAC0_N DAC0_N__SB VCM VPWR sky130_fd_pr__pfet_01v8_hvt w=0.65 l=0.15 nf=1 m=1
XDAC0_P_IS_MN DAC0_P__SB LOW VGND VGND sky130_fd_pr__nfet_01v8 w=0.65 l=0.15 nf=1 m=1
XDAC0_P_IS_MP DAC0_P__SB LOW VPWR VPWR sky130_fd_pr__pfet_01v8_hvt w=0.65 l=0.15 nf=1 m=1
XDAC0_P_MNA DAC0_P DAC0_P__SB REFN VGND sky130_fd_pr__nfet_01v8 w=0.65 l=0.15 nf=1 m=1
XDAC0_P_MNB DAC0_P LOW VCM VGND sky130_fd_pr__nfet_01v8 w=0.65 l=0.15 nf=1 m=1
XDAC0_P_MPA DAC0_P LOW REFN VPWR sky130_fd_pr__pfet_01v8_hvt w=0.65 l=0.15 nf=1 m=1
XDAC0_P_MPB DAC0_P DAC0_P__SB VCM VPWR sky130_fd_pr__pfet_01v8_hvt w=0.65 l=0.15 nf=1 m=1
XDAC1_N_IS_MN DAC1_N__SB HIGH VGND VGND sky130_fd_pr__nfet_01v8 w=0.65 l=0.15 nf=1 m=1
XDAC1_N_IS_MP DAC1_N__SB HIGH VPWR VPWR sky130_fd_pr__pfet_01v8_hvt w=0.65 l=0.15 nf=1 m=1
XDAC1_N_MNA DAC_N DAC1_N__SB DAC0_N VGND sky130_fd_pr__nfet_01v8 w=0.65 l=0.15 nf=1 m=1
XDAC1_N_MNB DAC_N HIGH REFN VGND sky130_fd_pr__nfet_01v8 w=0.65 l=0.15 nf=1 m=1
XDAC1_N_MPA DAC_N HIGH DAC0_N VPWR sky130_fd_pr__pfet_01v8_hvt w=0.65 l=0.15 nf=1 m=1
XDAC1_N_MPB DAC_N DAC1_N__SB REFN VPWR sky130_fd_pr__pfet_01v8_hvt w=0.65 l=0.15 nf=1 m=1
XDAC1_P_IS_MN DAC1_P__SB HIGH VGND VGND sky130_fd_pr__nfet_01v8 w=0.65 l=0.15 nf=1 m=1
XDAC1_P_IS_MP DAC1_P__SB HIGH VPWR VPWR sky130_fd_pr__pfet_01v8_hvt w=0.65 l=0.15 nf=1 m=1
XDAC1_P_MNA DAC_P DAC1_P__SB DAC0_P VGND sky130_fd_pr__nfet_01v8 w=0.65 l=0.15 nf=1 m=1
XDAC1_P_MNB DAC_P HIGH REFP VGND sky130_fd_pr__nfet_01v8 w=0.65 l=0.15 nf=1 m=1
XDAC1_P_MPA DAC_P HIGH DAC0_P VPWR sky130_fd_pr__pfet_01v8_hvt w=0.65 l=0.15 nf=1 m=1
XDAC1_P_MPB DAC_P DAC1_P__SB REFP VPWR sky130_fd_pr__pfet_01v8_hvt w=0.65 l=0.15 nf=1 m=1
XLATCH_HIGH_RESET_DATA_IS_MN LATCH_HIGH__RESET_DATA__SB RESET VGND VGND sky130_fd_pr__nfet_01v8 w=0.65 l=0.15 nf=1 m=1
XLATCH_HIGH_RESET_DATA_IS_MP LATCH_HIGH__RESET_DATA__SB RESET VPWR VPWR sky130_fd_pr__pfet_01v8_hvt w=0.65 l=0.15 nf=1 m=1
XLATCH_HIGH_RESET_DATA_MNA LATCH_HIGH__DATA LATCH_HIGH__RESET_DATA__SB HI_RAW VGND sky130_fd_pr__nfet_01v8 w=0.65 l=0.15 nf=1 m=1
XLATCH_HIGH_RESET_DATA_MNB LATCH_HIGH__DATA RESET VGND VGND sky130_fd_pr__nfet_01v8 w=0.65 l=0.15 nf=1 m=1
XLATCH_HIGH_RESET_DATA_MPA LATCH_HIGH__DATA RESET HI_RAW VPWR sky130_fd_pr__pfet_01v8_hvt w=0.65 l=0.15 nf=1 m=1
XLATCH_HIGH_RESET_DATA_MPB LATCH_HIGH__DATA LATCH_HIGH__RESET_DATA__SB VGND VPWR sky130_fd_pr__pfet_01v8_hvt w=0.65 l=0.15 nf=1 m=1
XLATCH_HIGH_SAMPLE_ICLK_MN LATCH_HIGH__SAMPLE__CLKB HOLD VGND VGND sky130_fd_pr__nfet_01v8 w=0.65 l=0.15 nf=1 m=1
XLATCH_HIGH_SAMPLE_ICLK_MP LATCH_HIGH__SAMPLE__CLKB HOLD VPWR VPWR sky130_fd_pr__pfet_01v8_hvt w=0.65 l=0.15 nf=1 m=1
XLATCH_HIGH_SAMPLE_M1_MN LATCH_HIGH__SAMPLE__MB LATCH_HIGH__SAMPLE__M VGND VGND sky130_fd_pr__nfet_01v8 w=0.65 l=0.15 nf=1 m=1
XLATCH_HIGH_SAMPLE_M1_MP LATCH_HIGH__SAMPLE__MB LATCH_HIGH__SAMPLE__M VPWR VPWR sky130_fd_pr__pfet_01v8_hvt w=0.65 l=0.15 nf=1 m=1
XLATCH_HIGH_SAMPLE_M2_MN LATCH_HIGH__SAMPLE__MF LATCH_HIGH__SAMPLE__MB VGND VGND sky130_fd_pr__nfet_01v8 w=0.65 l=0.15 nf=1 m=1
XLATCH_HIGH_SAMPLE_M2_MP LATCH_HIGH__SAMPLE__MF LATCH_HIGH__SAMPLE__MB VPWR VPWR sky130_fd_pr__pfet_01v8_hvt w=0.65 l=0.15 nf=1 m=1
XLATCH_HIGH_SAMPLE_MNIN LATCH_HIGH__SAMPLE__M LATCH_HIGH__SAMPLE__CLKB LATCH_HIGH__DATA VGND sky130_fd_pr__nfet_01v8 w=0.65 l=0.15 nf=1 m=1
XLATCH_HIGH_SAMPLE_MNMF LATCH_HIGH__SAMPLE__M HOLD LATCH_HIGH__SAMPLE__MF VGND sky130_fd_pr__nfet_01v8 w=0.65 l=0.15 nf=1 m=1
XLATCH_HIGH_SAMPLE_MNOUT LATCH_HIGH__SAMPLE__T HOLD LATCH_HIGH__SAMPLE__MF VGND sky130_fd_pr__nfet_01v8 w=0.65 l=0.15 nf=1 m=1
XLATCH_HIGH_SAMPLE_MNSF LATCH_HIGH__SAMPLE__T LATCH_HIGH__SAMPLE__CLKB HIGH VGND sky130_fd_pr__nfet_01v8 w=0.65 l=0.15 nf=1 m=1
XLATCH_HIGH_SAMPLE_MPIN LATCH_HIGH__SAMPLE__M HOLD LATCH_HIGH__DATA VPWR sky130_fd_pr__pfet_01v8_hvt w=0.65 l=0.15 nf=1 m=1
XLATCH_HIGH_SAMPLE_MPMF LATCH_HIGH__SAMPLE__M LATCH_HIGH__SAMPLE__CLKB LATCH_HIGH__SAMPLE__MF VPWR sky130_fd_pr__pfet_01v8_hvt w=0.65 l=0.15 nf=1 m=1
XLATCH_HIGH_SAMPLE_MPOUT LATCH_HIGH__SAMPLE__T LATCH_HIGH__SAMPLE__CLKB LATCH_HIGH__SAMPLE__MF VPWR sky130_fd_pr__pfet_01v8_hvt w=0.65 l=0.15 nf=1 m=1
XLATCH_HIGH_SAMPLE_MPSF LATCH_HIGH__SAMPLE__T HOLD HIGH VPWR sky130_fd_pr__pfet_01v8_hvt w=0.65 l=0.15 nf=1 m=1
XLATCH_HIGH_SAMPLE_S1_MN LATCH_HIGH__SAMPLE__TB LATCH_HIGH__SAMPLE__T VGND VGND sky130_fd_pr__nfet_01v8 w=0.65 l=0.15 nf=1 m=1
XLATCH_HIGH_SAMPLE_S1_MP LATCH_HIGH__SAMPLE__TB LATCH_HIGH__SAMPLE__T VPWR VPWR sky130_fd_pr__pfet_01v8_hvt w=0.65 l=0.15 nf=1 m=1
XLATCH_HIGH_SAMPLE_S2_MN HIGH LATCH_HIGH__SAMPLE__TB VGND VGND sky130_fd_pr__nfet_01v8 w=0.65 l=0.15 nf=1 m=1
XLATCH_HIGH_SAMPLE_S2_MP HIGH LATCH_HIGH__SAMPLE__TB VPWR VPWR sky130_fd_pr__pfet_01v8_hvt w=0.65 l=0.15 nf=1 m=1
XLATCH_LOW_RESET_DATA_IS_MN LATCH_LOW__RESET_DATA__SB RESET VGND VGND sky130_fd_pr__nfet_01v8 w=0.65 l=0.15 nf=1 m=1
XLATCH_LOW_RESET_DATA_IS_MP LATCH_LOW__RESET_DATA__SB RESET VPWR VPWR sky130_fd_pr__pfet_01v8_hvt w=0.65 l=0.15 nf=1 m=1
XLATCH_LOW_RESET_DATA_MNA LATCH_LOW__DATA LATCH_LOW__RESET_DATA__SB LO_RAW VGND sky130_fd_pr__nfet_01v8 w=0.65 l=0.15 nf=1 m=1
XLATCH_LOW_RESET_DATA_MNB LATCH_LOW__DATA RESET VGND VGND sky130_fd_pr__nfet_01v8 w=0.65 l=0.15 nf=1 m=1
XLATCH_LOW_RESET_DATA_MPA LATCH_LOW__DATA RESET LO_RAW VPWR sky130_fd_pr__pfet_01v8_hvt w=0.65 l=0.15 nf=1 m=1
XLATCH_LOW_RESET_DATA_MPB LATCH_LOW__DATA LATCH_LOW__RESET_DATA__SB VGND VPWR sky130_fd_pr__pfet_01v8_hvt w=0.65 l=0.15 nf=1 m=1
XLATCH_LOW_SAMPLE_ICLK_MN LATCH_LOW__SAMPLE__CLKB HOLD VGND VGND sky130_fd_pr__nfet_01v8 w=0.65 l=0.15 nf=1 m=1
XLATCH_LOW_SAMPLE_ICLK_MP LATCH_LOW__SAMPLE__CLKB HOLD VPWR VPWR sky130_fd_pr__pfet_01v8_hvt w=0.65 l=0.15 nf=1 m=1
XLATCH_LOW_SAMPLE_M1_MN LATCH_LOW__SAMPLE__MB LATCH_LOW__SAMPLE__M VGND VGND sky130_fd_pr__nfet_01v8 w=0.65 l=0.15 nf=1 m=1
XLATCH_LOW_SAMPLE_M1_MP LATCH_LOW__SAMPLE__MB LATCH_LOW__SAMPLE__M VPWR VPWR sky130_fd_pr__pfet_01v8_hvt w=0.65 l=0.15 nf=1 m=1
XLATCH_LOW_SAMPLE_M2_MN LATCH_LOW__SAMPLE__MF LATCH_LOW__SAMPLE__MB VGND VGND sky130_fd_pr__nfet_01v8 w=0.65 l=0.15 nf=1 m=1
XLATCH_LOW_SAMPLE_M2_MP LATCH_LOW__SAMPLE__MF LATCH_LOW__SAMPLE__MB VPWR VPWR sky130_fd_pr__pfet_01v8_hvt w=0.65 l=0.15 nf=1 m=1
XLATCH_LOW_SAMPLE_MNIN LATCH_LOW__SAMPLE__M LATCH_LOW__SAMPLE__CLKB LATCH_LOW__DATA VGND sky130_fd_pr__nfet_01v8 w=0.65 l=0.15 nf=1 m=1
XLATCH_LOW_SAMPLE_MNMF LATCH_LOW__SAMPLE__M HOLD LATCH_LOW__SAMPLE__MF VGND sky130_fd_pr__nfet_01v8 w=0.65 l=0.15 nf=1 m=1
XLATCH_LOW_SAMPLE_MNOUT LATCH_LOW__SAMPLE__T HOLD LATCH_LOW__SAMPLE__MF VGND sky130_fd_pr__nfet_01v8 w=0.65 l=0.15 nf=1 m=1
XLATCH_LOW_SAMPLE_MNSF LATCH_LOW__SAMPLE__T LATCH_LOW__SAMPLE__CLKB LOW VGND sky130_fd_pr__nfet_01v8 w=0.65 l=0.15 nf=1 m=1
XLATCH_LOW_SAMPLE_MPIN LATCH_LOW__SAMPLE__M HOLD LATCH_LOW__DATA VPWR sky130_fd_pr__pfet_01v8_hvt w=0.65 l=0.15 nf=1 m=1
XLATCH_LOW_SAMPLE_MPMF LATCH_LOW__SAMPLE__M LATCH_LOW__SAMPLE__CLKB LATCH_LOW__SAMPLE__MF VPWR sky130_fd_pr__pfet_01v8_hvt w=0.65 l=0.15 nf=1 m=1
XLATCH_LOW_SAMPLE_MPOUT LATCH_LOW__SAMPLE__T LATCH_LOW__SAMPLE__CLKB LATCH_LOW__SAMPLE__MF VPWR sky130_fd_pr__pfet_01v8_hvt w=0.65 l=0.15 nf=1 m=1
XLATCH_LOW_SAMPLE_MPSF LATCH_LOW__SAMPLE__T HOLD LOW VPWR sky130_fd_pr__pfet_01v8_hvt w=0.65 l=0.15 nf=1 m=1
XLATCH_LOW_SAMPLE_S1_MN LATCH_LOW__SAMPLE__TB LATCH_LOW__SAMPLE__T VGND VGND sky130_fd_pr__nfet_01v8 w=0.65 l=0.15 nf=1 m=1
XLATCH_LOW_SAMPLE_S1_MP LATCH_LOW__SAMPLE__TB LATCH_LOW__SAMPLE__T VPWR VPWR sky130_fd_pr__pfet_01v8_hvt w=0.65 l=0.15 nf=1 m=1
XLATCH_LOW_SAMPLE_S2_MN LOW LATCH_LOW__SAMPLE__TB VGND VGND sky130_fd_pr__nfet_01v8 w=0.65 l=0.15 nf=1 m=1
XLATCH_LOW_SAMPLE_S2_MP LOW LATCH_LOW__SAMPLE__TB VPWR VPWR sky130_fd_pr__pfet_01v8_hvt w=0.65 l=0.15 nf=1 m=1
XMDAC_N_AMP_C_MILLER_P0 MDAC_N__AMP__PRE MDAC_N__AMP__COMP sky130_fd_pr__cap_mim_m3_1 w=15.625 l=15.625
XMDAC_N_AMP_FIRST_N_INN MDAC_N__AMP__FIRST__MIR MDAC_N__SUM MDAC_N__AMP__FIRST__TAIL VGND sky130_fd_pr__nfet_01v8 w=10 l=1 nf=1 m=1
XMDAC_N_AMP_FIRST_N_INP MDAC_N__AMP__PRE VCM MDAC_N__AMP__FIRST__TAIL VGND sky130_fd_pr__nfet_01v8 w=10 l=1 nf=1 m=1
XMDAC_N_AMP_FIRST_N_TAIL MDAC_N__AMP__FIRST__TAIL BIAS VGND VGND sky130_fd_pr__nfet_01v8 w=2 l=1 nf=1 m=1
XMDAC_N_AMP_FIRST_P_DIODE MDAC_N__AMP__FIRST__MIR MDAC_N__AMP__FIRST__MIR VPWR VPWR sky130_fd_pr__pfet_01v8_hvt w=20 l=1 nf=1 m=1
XMDAC_N_AMP_FIRST_P_MIRROR MDAC_N__AMP__PRE MDAC_N__AMP__FIRST__MIR VPWR VPWR sky130_fd_pr__pfet_01v8_hvt w=20 l=1 nf=1 m=1
XMDAC_N_AMP_N_SECOND OUTN BIAS VGND VGND sky130_fd_pr__nfet_01v8 w=10 l=1 nf=1 m=1
XMDAC_N_AMP_P_SECOND OUTN MDAC_N__AMP__PRE VPWR VPWR sky130_fd_pr__pfet_01v8_hvt w=20 l=1 nf=1 m=1
XMDAC_N_AMP_R_ZERO_P0 MDAC_N__AMP__COMP OUTN VGND sky130_fd_pr__res_xhigh_po_1p41 l=0.54
XMDAC_N_C_FEEDBACK_P0 MDAC_N__SUM OUTN sky130_fd_pr__cap_mim_m3_1 w=22.17 l=22.17
XMDAC_N_C_SAMPLE_P0 MDAC_N__SUM MDAC_N__BOTTOM sky130_fd_pr__cap_mim_m3_1 w=22.17 l=22.17
XMDAC_N_C_SAMPLE_P1 MDAC_N__SUM MDAC_N__BOTTOM sky130_fd_pr__cap_mim_m3_1 w=22.17 l=22.17
XMDAC_N_HOLD_N DAC_N SAMPLEB MDAC_N__BOTTOM VGND sky130_fd_pr__nfet_01v8 w=8 l=0.15 nf=1 m=1
XMDAC_N_HOLD_P DAC_N SAMPLE MDAC_N__BOTTOM VPWR sky130_fd_pr__pfet_01v8_hvt w=12 l=0.15 nf=1 m=1
XMDAC_N_RESET_OUT_N VCM SAMPLE OUTN VGND sky130_fd_pr__nfet_01v8 w=8 l=0.15 nf=1 m=1
XMDAC_N_RESET_OUT_P VCM SAMPLEB OUTN VPWR sky130_fd_pr__pfet_01v8_hvt w=12 l=0.15 nf=1 m=1
XMDAC_N_RESET_SUM_N VCM SAMPLE MDAC_N__SUM VGND sky130_fd_pr__nfet_01v8 w=8 l=0.15 nf=1 m=1
XMDAC_N_RESET_SUM_P VCM SAMPLEB MDAC_N__SUM VPWR sky130_fd_pr__pfet_01v8_hvt w=12 l=0.15 nf=1 m=1
XMDAC_N_SAMPLE_N VINN SAMPLE MDAC_N__BOTTOM VGND sky130_fd_pr__nfet_01v8 w=8 l=0.15 nf=1 m=1
XMDAC_N_SAMPLE_P VINN SAMPLEB MDAC_N__BOTTOM VPWR sky130_fd_pr__pfet_01v8_hvt w=12 l=0.15 nf=1 m=1
XMDAC_P_AMP_C_MILLER_P0 MDAC_P__AMP__PRE MDAC_P__AMP__COMP sky130_fd_pr__cap_mim_m3_1 w=15.625 l=15.625
XMDAC_P_AMP_FIRST_N_INN MDAC_P__AMP__FIRST__MIR MDAC_P__SUM MDAC_P__AMP__FIRST__TAIL VGND sky130_fd_pr__nfet_01v8 w=10 l=1 nf=1 m=1
XMDAC_P_AMP_FIRST_N_INP MDAC_P__AMP__PRE VCM MDAC_P__AMP__FIRST__TAIL VGND sky130_fd_pr__nfet_01v8 w=10 l=1 nf=1 m=1
XMDAC_P_AMP_FIRST_N_TAIL MDAC_P__AMP__FIRST__TAIL BIAS VGND VGND sky130_fd_pr__nfet_01v8 w=2 l=1 nf=1 m=1
XMDAC_P_AMP_FIRST_P_DIODE MDAC_P__AMP__FIRST__MIR MDAC_P__AMP__FIRST__MIR VPWR VPWR sky130_fd_pr__pfet_01v8_hvt w=20 l=1 nf=1 m=1
XMDAC_P_AMP_FIRST_P_MIRROR MDAC_P__AMP__PRE MDAC_P__AMP__FIRST__MIR VPWR VPWR sky130_fd_pr__pfet_01v8_hvt w=20 l=1 nf=1 m=1
XMDAC_P_AMP_N_SECOND OUTP BIAS VGND VGND sky130_fd_pr__nfet_01v8 w=10 l=1 nf=1 m=1
XMDAC_P_AMP_P_SECOND OUTP MDAC_P__AMP__PRE VPWR VPWR sky130_fd_pr__pfet_01v8_hvt w=20 l=1 nf=1 m=1
XMDAC_P_AMP_R_ZERO_P0 MDAC_P__AMP__COMP OUTP VGND sky130_fd_pr__res_xhigh_po_1p41 l=0.54
XMDAC_P_C_FEEDBACK_P0 MDAC_P__SUM OUTP sky130_fd_pr__cap_mim_m3_1 w=22.17 l=22.17
XMDAC_P_C_SAMPLE_P0 MDAC_P__SUM MDAC_P__BOTTOM sky130_fd_pr__cap_mim_m3_1 w=22.17 l=22.17
XMDAC_P_C_SAMPLE_P1 MDAC_P__SUM MDAC_P__BOTTOM sky130_fd_pr__cap_mim_m3_1 w=22.17 l=22.17
XMDAC_P_HOLD_N DAC_P SAMPLEB MDAC_P__BOTTOM VGND sky130_fd_pr__nfet_01v8 w=8 l=0.15 nf=1 m=1
XMDAC_P_HOLD_P DAC_P SAMPLE MDAC_P__BOTTOM VPWR sky130_fd_pr__pfet_01v8_hvt w=12 l=0.15 nf=1 m=1
XMDAC_P_RESET_OUT_N VCM SAMPLE OUTP VGND sky130_fd_pr__nfet_01v8 w=8 l=0.15 nf=1 m=1
XMDAC_P_RESET_OUT_P VCM SAMPLEB OUTP VPWR sky130_fd_pr__pfet_01v8_hvt w=12 l=0.15 nf=1 m=1
XMDAC_P_RESET_SUM_N VCM SAMPLE MDAC_P__SUM VGND sky130_fd_pr__nfet_01v8 w=8 l=0.15 nf=1 m=1
XMDAC_P_RESET_SUM_P VCM SAMPLEB MDAC_P__SUM VPWR sky130_fd_pr__pfet_01v8_hvt w=12 l=0.15 nf=1 m=1
XMDAC_P_SAMPLE_N VINP SAMPLE MDAC_P__BOTTOM VGND sky130_fd_pr__nfet_01v8 w=8 l=0.15 nf=1 m=1
XMDAC_P_SAMPLE_P VINP SAMPLEB MDAC_P__BOTTOM VPWR sky130_fd_pr__pfet_01v8_hvt w=12 l=0.15 nf=1 m=1
XSAMPLE_INV_MN SAMPLEB SAMPLE VGND VGND sky130_fd_pr__nfet_01v8 w=0.65 l=0.15 nf=1 m=1
XSAMPLE_INV_MP SAMPLEB SAMPLE VPWR VPWR sky130_fd_pr__pfet_01v8_hvt w=0.65 l=0.15 nf=1 m=1
XSUBADC_HIGH_N_OUT HI_RAW SUBADC__HIGH__PRE VGND VGND sky130_fd_pr__nfet_01v8 w=4 l=0.15 nf=1 m=1
XSUBADC_HIGH_PREAMP_N_INN SUBADC__HIGH__PREAMP__MIR SUBADC__AVG_HIGH SUBADC__HIGH__PREAMP__TAIL VGND sky130_fd_pr__nfet_01v8 w=10 l=1 nf=1 m=1
XSUBADC_HIGH_PREAMP_N_INP SUBADC__HIGH__PRE SUBADC__AVG_P SUBADC__HIGH__PREAMP__TAIL VGND sky130_fd_pr__nfet_01v8 w=10 l=1 nf=1 m=1
XSUBADC_HIGH_PREAMP_N_TAIL SUBADC__HIGH__PREAMP__TAIL BIAS VGND VGND sky130_fd_pr__nfet_01v8 w=2 l=1 nf=1 m=1
XSUBADC_HIGH_PREAMP_P_DIODE SUBADC__HIGH__PREAMP__MIR SUBADC__HIGH__PREAMP__MIR VPWR VPWR sky130_fd_pr__pfet_01v8_hvt w=20 l=1 nf=1 m=1
XSUBADC_HIGH_PREAMP_P_MIRROR SUBADC__HIGH__PRE SUBADC__HIGH__PREAMP__MIR VPWR VPWR sky130_fd_pr__pfet_01v8_hvt w=20 l=1 nf=1 m=1
XSUBADC_HIGH_P_OUT HI_RAW SUBADC__HIGH__PRE VPWR VPWR sky130_fd_pr__pfet_01v8_hvt w=8 l=0.15 nf=1 m=1
XSUBADC_LOW_N_OUT LO_RAW SUBADC__LOW__PRE VGND VGND sky130_fd_pr__nfet_01v8 w=4 l=0.15 nf=1 m=1
XSUBADC_LOW_PREAMP_N_INN SUBADC__LOW__PREAMP__MIR SUBADC__AVG_LOW SUBADC__LOW__PREAMP__TAIL VGND sky130_fd_pr__nfet_01v8 w=10 l=1 nf=1 m=1
XSUBADC_LOW_PREAMP_N_INP SUBADC__LOW__PRE SUBADC__AVG_P SUBADC__LOW__PREAMP__TAIL VGND sky130_fd_pr__nfet_01v8 w=10 l=1 nf=1 m=1
XSUBADC_LOW_PREAMP_N_TAIL SUBADC__LOW__PREAMP__TAIL BIAS VGND VGND sky130_fd_pr__nfet_01v8 w=2 l=1 nf=1 m=1
XSUBADC_LOW_PREAMP_P_DIODE SUBADC__LOW__PREAMP__MIR SUBADC__LOW__PREAMP__MIR VPWR VPWR sky130_fd_pr__pfet_01v8_hvt w=20 l=1 nf=1 m=1
XSUBADC_LOW_PREAMP_P_MIRROR SUBADC__LOW__PRE SUBADC__LOW__PREAMP__MIR VPWR VPWR sky130_fd_pr__pfet_01v8_hvt w=20 l=1 nf=1 m=1
XSUBADC_LOW_P_OUT LO_RAW SUBADC__LOW__PRE VPWR VPWR sky130_fd_pr__pfet_01v8_hvt w=8 l=0.15 nf=1 m=1
XSUBADC_R_HIGH0_P0 VINN SUBADC_R_HIGH0_R0_N0 VGND sky130_fd_pr__res_xhigh_po_1p41 l=29.21
XSUBADC_R_HIGH0_P1 SUBADC_R_HIGH0_R0_N0 SUBADC_R_HIGH0_R0_N1 VGND sky130_fd_pr__res_xhigh_po_1p41 l=29.21
XSUBADC_R_HIGH0_P10 SUBADC_R_HIGH0_R0_N9 SUBADC_R_HIGH0_R0_N10 VGND sky130_fd_pr__res_xhigh_po_1p41 l=29.21
XSUBADC_R_HIGH0_P11 SUBADC_R_HIGH0_R0_N10 SUBADC_R_HIGH0_R0_N11 VGND sky130_fd_pr__res_xhigh_po_1p41 l=29.21
XSUBADC_R_HIGH0_P12 SUBADC_R_HIGH0_R0_N11 SUBADC_R_HIGH0_R0_N12 VGND sky130_fd_pr__res_xhigh_po_1p41 l=29.21
XSUBADC_R_HIGH0_P13 SUBADC_R_HIGH0_R0_N12 SUBADC_R_HIGH0_R0_N13 VGND sky130_fd_pr__res_xhigh_po_1p41 l=29.21
XSUBADC_R_HIGH0_P14 SUBADC_R_HIGH0_R0_N13 SUBADC_R_HIGH0_R0_N14 VGND sky130_fd_pr__res_xhigh_po_1p41 l=29.21
XSUBADC_R_HIGH0_P15 SUBADC_R_HIGH0_R0_N14 SUBADC_R_HIGH0_R0_N15 VGND sky130_fd_pr__res_xhigh_po_1p41 l=29.21
XSUBADC_R_HIGH0_P16 SUBADC_R_HIGH0_R0_N15 SUBADC_R_HIGH0_R0_N16 VGND sky130_fd_pr__res_xhigh_po_1p41 l=29.21
XSUBADC_R_HIGH0_P17 SUBADC_R_HIGH0_R0_N16 SUBADC_R_HIGH0_R0_N17 VGND sky130_fd_pr__res_xhigh_po_1p41 l=29.21
XSUBADC_R_HIGH0_P18 SUBADC_R_HIGH0_R0_N17 SUBADC_R_HIGH0_R0_N18 VGND sky130_fd_pr__res_xhigh_po_1p41 l=29.21
XSUBADC_R_HIGH0_P19 SUBADC_R_HIGH0_R0_N18 SUBADC_R_HIGH0_R0_N19 VGND sky130_fd_pr__res_xhigh_po_1p41 l=29.21
XSUBADC_R_HIGH0_P2 SUBADC_R_HIGH0_R0_N1 SUBADC_R_HIGH0_R0_N2 VGND sky130_fd_pr__res_xhigh_po_1p41 l=29.21
XSUBADC_R_HIGH0_P20 SUBADC_R_HIGH0_R0_N19 SUBADC_R_HIGH0_R0_N20 VGND sky130_fd_pr__res_xhigh_po_1p41 l=29.21
XSUBADC_R_HIGH0_P21 SUBADC_R_HIGH0_R0_N20 SUBADC_R_HIGH0_R0_N21 VGND sky130_fd_pr__res_xhigh_po_1p41 l=29.21
XSUBADC_R_HIGH0_P22 SUBADC_R_HIGH0_R0_N21 SUBADC_R_HIGH0_R0_N22 VGND sky130_fd_pr__res_xhigh_po_1p41 l=29.21
XSUBADC_R_HIGH0_P23 SUBADC_R_HIGH0_R0_N22 SUBADC__AVG_HIGH VGND sky130_fd_pr__res_xhigh_po_1p41 l=29.21
XSUBADC_R_HIGH0_P3 SUBADC_R_HIGH0_R0_N2 SUBADC_R_HIGH0_R0_N3 VGND sky130_fd_pr__res_xhigh_po_1p41 l=29.21
XSUBADC_R_HIGH0_P4 SUBADC_R_HIGH0_R0_N3 SUBADC_R_HIGH0_R0_N4 VGND sky130_fd_pr__res_xhigh_po_1p41 l=29.21
XSUBADC_R_HIGH0_P5 SUBADC_R_HIGH0_R0_N4 SUBADC_R_HIGH0_R0_N5 VGND sky130_fd_pr__res_xhigh_po_1p41 l=29.21
XSUBADC_R_HIGH0_P6 SUBADC_R_HIGH0_R0_N5 SUBADC_R_HIGH0_R0_N6 VGND sky130_fd_pr__res_xhigh_po_1p41 l=29.21
XSUBADC_R_HIGH0_P7 SUBADC_R_HIGH0_R0_N6 SUBADC_R_HIGH0_R0_N7 VGND sky130_fd_pr__res_xhigh_po_1p41 l=29.21
XSUBADC_R_HIGH0_P8 SUBADC_R_HIGH0_R0_N7 SUBADC_R_HIGH0_R0_N8 VGND sky130_fd_pr__res_xhigh_po_1p41 l=29.21
XSUBADC_R_HIGH0_P9 SUBADC_R_HIGH0_R0_N8 SUBADC_R_HIGH0_R0_N9 VGND sky130_fd_pr__res_xhigh_po_1p41 l=29.21
XSUBADC_R_HIGH1_P0 THP SUBADC_R_HIGH1_R0_N0 VGND sky130_fd_pr__res_xhigh_po_1p41 l=29.21
XSUBADC_R_HIGH1_P1 SUBADC_R_HIGH1_R0_N0 SUBADC_R_HIGH1_R0_N1 VGND sky130_fd_pr__res_xhigh_po_1p41 l=29.21
XSUBADC_R_HIGH1_P10 SUBADC_R_HIGH1_R0_N9 SUBADC_R_HIGH1_R0_N10 VGND sky130_fd_pr__res_xhigh_po_1p41 l=29.21
XSUBADC_R_HIGH1_P11 SUBADC_R_HIGH1_R0_N10 SUBADC_R_HIGH1_R0_N11 VGND sky130_fd_pr__res_xhigh_po_1p41 l=29.21
XSUBADC_R_HIGH1_P12 SUBADC_R_HIGH1_R0_N11 SUBADC_R_HIGH1_R0_N12 VGND sky130_fd_pr__res_xhigh_po_1p41 l=29.21
XSUBADC_R_HIGH1_P13 SUBADC_R_HIGH1_R0_N12 SUBADC_R_HIGH1_R0_N13 VGND sky130_fd_pr__res_xhigh_po_1p41 l=29.21
XSUBADC_R_HIGH1_P14 SUBADC_R_HIGH1_R0_N13 SUBADC_R_HIGH1_R0_N14 VGND sky130_fd_pr__res_xhigh_po_1p41 l=29.21
XSUBADC_R_HIGH1_P15 SUBADC_R_HIGH1_R0_N14 SUBADC_R_HIGH1_R0_N15 VGND sky130_fd_pr__res_xhigh_po_1p41 l=29.21
XSUBADC_R_HIGH1_P16 SUBADC_R_HIGH1_R0_N15 SUBADC_R_HIGH1_R0_N16 VGND sky130_fd_pr__res_xhigh_po_1p41 l=29.21
XSUBADC_R_HIGH1_P17 SUBADC_R_HIGH1_R0_N16 SUBADC_R_HIGH1_R0_N17 VGND sky130_fd_pr__res_xhigh_po_1p41 l=29.21
XSUBADC_R_HIGH1_P18 SUBADC_R_HIGH1_R0_N17 SUBADC_R_HIGH1_R0_N18 VGND sky130_fd_pr__res_xhigh_po_1p41 l=29.21
XSUBADC_R_HIGH1_P19 SUBADC_R_HIGH1_R0_N18 SUBADC_R_HIGH1_R0_N19 VGND sky130_fd_pr__res_xhigh_po_1p41 l=29.21
XSUBADC_R_HIGH1_P2 SUBADC_R_HIGH1_R0_N1 SUBADC_R_HIGH1_R0_N2 VGND sky130_fd_pr__res_xhigh_po_1p41 l=29.21
XSUBADC_R_HIGH1_P20 SUBADC_R_HIGH1_R0_N19 SUBADC_R_HIGH1_R0_N20 VGND sky130_fd_pr__res_xhigh_po_1p41 l=29.21
XSUBADC_R_HIGH1_P21 SUBADC_R_HIGH1_R0_N20 SUBADC_R_HIGH1_R0_N21 VGND sky130_fd_pr__res_xhigh_po_1p41 l=29.21
XSUBADC_R_HIGH1_P22 SUBADC_R_HIGH1_R0_N21 SUBADC_R_HIGH1_R0_N22 VGND sky130_fd_pr__res_xhigh_po_1p41 l=29.21
XSUBADC_R_HIGH1_P23 SUBADC_R_HIGH1_R0_N22 SUBADC__AVG_HIGH VGND sky130_fd_pr__res_xhigh_po_1p41 l=29.21
XSUBADC_R_HIGH1_P3 SUBADC_R_HIGH1_R0_N2 SUBADC_R_HIGH1_R0_N3 VGND sky130_fd_pr__res_xhigh_po_1p41 l=29.21
XSUBADC_R_HIGH1_P4 SUBADC_R_HIGH1_R0_N3 SUBADC_R_HIGH1_R0_N4 VGND sky130_fd_pr__res_xhigh_po_1p41 l=29.21
XSUBADC_R_HIGH1_P5 SUBADC_R_HIGH1_R0_N4 SUBADC_R_HIGH1_R0_N5 VGND sky130_fd_pr__res_xhigh_po_1p41 l=29.21
XSUBADC_R_HIGH1_P6 SUBADC_R_HIGH1_R0_N5 SUBADC_R_HIGH1_R0_N6 VGND sky130_fd_pr__res_xhigh_po_1p41 l=29.21
XSUBADC_R_HIGH1_P7 SUBADC_R_HIGH1_R0_N6 SUBADC_R_HIGH1_R0_N7 VGND sky130_fd_pr__res_xhigh_po_1p41 l=29.21
XSUBADC_R_HIGH1_P8 SUBADC_R_HIGH1_R0_N7 SUBADC_R_HIGH1_R0_N8 VGND sky130_fd_pr__res_xhigh_po_1p41 l=29.21
XSUBADC_R_HIGH1_P9 SUBADC_R_HIGH1_R0_N8 SUBADC_R_HIGH1_R0_N9 VGND sky130_fd_pr__res_xhigh_po_1p41 l=29.21
XSUBADC_R_LOW0_P0 VINN SUBADC_R_LOW0_R0_N0 VGND sky130_fd_pr__res_xhigh_po_1p41 l=29.21
XSUBADC_R_LOW0_P1 SUBADC_R_LOW0_R0_N0 SUBADC_R_LOW0_R0_N1 VGND sky130_fd_pr__res_xhigh_po_1p41 l=29.21
XSUBADC_R_LOW0_P10 SUBADC_R_LOW0_R0_N9 SUBADC_R_LOW0_R0_N10 VGND sky130_fd_pr__res_xhigh_po_1p41 l=29.21
XSUBADC_R_LOW0_P11 SUBADC_R_LOW0_R0_N10 SUBADC_R_LOW0_R0_N11 VGND sky130_fd_pr__res_xhigh_po_1p41 l=29.21
XSUBADC_R_LOW0_P12 SUBADC_R_LOW0_R0_N11 SUBADC_R_LOW0_R0_N12 VGND sky130_fd_pr__res_xhigh_po_1p41 l=29.21
XSUBADC_R_LOW0_P13 SUBADC_R_LOW0_R0_N12 SUBADC_R_LOW0_R0_N13 VGND sky130_fd_pr__res_xhigh_po_1p41 l=29.21
XSUBADC_R_LOW0_P14 SUBADC_R_LOW0_R0_N13 SUBADC_R_LOW0_R0_N14 VGND sky130_fd_pr__res_xhigh_po_1p41 l=29.21
XSUBADC_R_LOW0_P15 SUBADC_R_LOW0_R0_N14 SUBADC_R_LOW0_R0_N15 VGND sky130_fd_pr__res_xhigh_po_1p41 l=29.21
XSUBADC_R_LOW0_P16 SUBADC_R_LOW0_R0_N15 SUBADC_R_LOW0_R0_N16 VGND sky130_fd_pr__res_xhigh_po_1p41 l=29.21
XSUBADC_R_LOW0_P17 SUBADC_R_LOW0_R0_N16 SUBADC_R_LOW0_R0_N17 VGND sky130_fd_pr__res_xhigh_po_1p41 l=29.21
XSUBADC_R_LOW0_P18 SUBADC_R_LOW0_R0_N17 SUBADC_R_LOW0_R0_N18 VGND sky130_fd_pr__res_xhigh_po_1p41 l=29.21
XSUBADC_R_LOW0_P19 SUBADC_R_LOW0_R0_N18 SUBADC_R_LOW0_R0_N19 VGND sky130_fd_pr__res_xhigh_po_1p41 l=29.21
XSUBADC_R_LOW0_P2 SUBADC_R_LOW0_R0_N1 SUBADC_R_LOW0_R0_N2 VGND sky130_fd_pr__res_xhigh_po_1p41 l=29.21
XSUBADC_R_LOW0_P20 SUBADC_R_LOW0_R0_N19 SUBADC_R_LOW0_R0_N20 VGND sky130_fd_pr__res_xhigh_po_1p41 l=29.21
XSUBADC_R_LOW0_P21 SUBADC_R_LOW0_R0_N20 SUBADC_R_LOW0_R0_N21 VGND sky130_fd_pr__res_xhigh_po_1p41 l=29.21
XSUBADC_R_LOW0_P22 SUBADC_R_LOW0_R0_N21 SUBADC_R_LOW0_R0_N22 VGND sky130_fd_pr__res_xhigh_po_1p41 l=29.21
XSUBADC_R_LOW0_P23 SUBADC_R_LOW0_R0_N22 SUBADC__AVG_LOW VGND sky130_fd_pr__res_xhigh_po_1p41 l=29.21
XSUBADC_R_LOW0_P3 SUBADC_R_LOW0_R0_N2 SUBADC_R_LOW0_R0_N3 VGND sky130_fd_pr__res_xhigh_po_1p41 l=29.21
XSUBADC_R_LOW0_P4 SUBADC_R_LOW0_R0_N3 SUBADC_R_LOW0_R0_N4 VGND sky130_fd_pr__res_xhigh_po_1p41 l=29.21
XSUBADC_R_LOW0_P5 SUBADC_R_LOW0_R0_N4 SUBADC_R_LOW0_R0_N5 VGND sky130_fd_pr__res_xhigh_po_1p41 l=29.21
XSUBADC_R_LOW0_P6 SUBADC_R_LOW0_R0_N5 SUBADC_R_LOW0_R0_N6 VGND sky130_fd_pr__res_xhigh_po_1p41 l=29.21
XSUBADC_R_LOW0_P7 SUBADC_R_LOW0_R0_N6 SUBADC_R_LOW0_R0_N7 VGND sky130_fd_pr__res_xhigh_po_1p41 l=29.21
XSUBADC_R_LOW0_P8 SUBADC_R_LOW0_R0_N7 SUBADC_R_LOW0_R0_N8 VGND sky130_fd_pr__res_xhigh_po_1p41 l=29.21
XSUBADC_R_LOW0_P9 SUBADC_R_LOW0_R0_N8 SUBADC_R_LOW0_R0_N9 VGND sky130_fd_pr__res_xhigh_po_1p41 l=29.21
XSUBADC_R_LOW1_P0 THN SUBADC_R_LOW1_R0_N0 VGND sky130_fd_pr__res_xhigh_po_1p41 l=29.21
XSUBADC_R_LOW1_P1 SUBADC_R_LOW1_R0_N0 SUBADC_R_LOW1_R0_N1 VGND sky130_fd_pr__res_xhigh_po_1p41 l=29.21
XSUBADC_R_LOW1_P10 SUBADC_R_LOW1_R0_N9 SUBADC_R_LOW1_R0_N10 VGND sky130_fd_pr__res_xhigh_po_1p41 l=29.21
XSUBADC_R_LOW1_P11 SUBADC_R_LOW1_R0_N10 SUBADC_R_LOW1_R0_N11 VGND sky130_fd_pr__res_xhigh_po_1p41 l=29.21
XSUBADC_R_LOW1_P12 SUBADC_R_LOW1_R0_N11 SUBADC_R_LOW1_R0_N12 VGND sky130_fd_pr__res_xhigh_po_1p41 l=29.21
XSUBADC_R_LOW1_P13 SUBADC_R_LOW1_R0_N12 SUBADC_R_LOW1_R0_N13 VGND sky130_fd_pr__res_xhigh_po_1p41 l=29.21
XSUBADC_R_LOW1_P14 SUBADC_R_LOW1_R0_N13 SUBADC_R_LOW1_R0_N14 VGND sky130_fd_pr__res_xhigh_po_1p41 l=29.21
XSUBADC_R_LOW1_P15 SUBADC_R_LOW1_R0_N14 SUBADC_R_LOW1_R0_N15 VGND sky130_fd_pr__res_xhigh_po_1p41 l=29.21
XSUBADC_R_LOW1_P16 SUBADC_R_LOW1_R0_N15 SUBADC_R_LOW1_R0_N16 VGND sky130_fd_pr__res_xhigh_po_1p41 l=29.21
XSUBADC_R_LOW1_P17 SUBADC_R_LOW1_R0_N16 SUBADC_R_LOW1_R0_N17 VGND sky130_fd_pr__res_xhigh_po_1p41 l=29.21
XSUBADC_R_LOW1_P18 SUBADC_R_LOW1_R0_N17 SUBADC_R_LOW1_R0_N18 VGND sky130_fd_pr__res_xhigh_po_1p41 l=29.21
XSUBADC_R_LOW1_P19 SUBADC_R_LOW1_R0_N18 SUBADC_R_LOW1_R0_N19 VGND sky130_fd_pr__res_xhigh_po_1p41 l=29.21
XSUBADC_R_LOW1_P2 SUBADC_R_LOW1_R0_N1 SUBADC_R_LOW1_R0_N2 VGND sky130_fd_pr__res_xhigh_po_1p41 l=29.21
XSUBADC_R_LOW1_P20 SUBADC_R_LOW1_R0_N19 SUBADC_R_LOW1_R0_N20 VGND sky130_fd_pr__res_xhigh_po_1p41 l=29.21
XSUBADC_R_LOW1_P21 SUBADC_R_LOW1_R0_N20 SUBADC_R_LOW1_R0_N21 VGND sky130_fd_pr__res_xhigh_po_1p41 l=29.21
XSUBADC_R_LOW1_P22 SUBADC_R_LOW1_R0_N21 SUBADC_R_LOW1_R0_N22 VGND sky130_fd_pr__res_xhigh_po_1p41 l=29.21
XSUBADC_R_LOW1_P23 SUBADC_R_LOW1_R0_N22 SUBADC__AVG_LOW VGND sky130_fd_pr__res_xhigh_po_1p41 l=29.21
XSUBADC_R_LOW1_P3 SUBADC_R_LOW1_R0_N2 SUBADC_R_LOW1_R0_N3 VGND sky130_fd_pr__res_xhigh_po_1p41 l=29.21
XSUBADC_R_LOW1_P4 SUBADC_R_LOW1_R0_N3 SUBADC_R_LOW1_R0_N4 VGND sky130_fd_pr__res_xhigh_po_1p41 l=29.21
XSUBADC_R_LOW1_P5 SUBADC_R_LOW1_R0_N4 SUBADC_R_LOW1_R0_N5 VGND sky130_fd_pr__res_xhigh_po_1p41 l=29.21
XSUBADC_R_LOW1_P6 SUBADC_R_LOW1_R0_N5 SUBADC_R_LOW1_R0_N6 VGND sky130_fd_pr__res_xhigh_po_1p41 l=29.21
XSUBADC_R_LOW1_P7 SUBADC_R_LOW1_R0_N6 SUBADC_R_LOW1_R0_N7 VGND sky130_fd_pr__res_xhigh_po_1p41 l=29.21
XSUBADC_R_LOW1_P8 SUBADC_R_LOW1_R0_N7 SUBADC_R_LOW1_R0_N8 VGND sky130_fd_pr__res_xhigh_po_1p41 l=29.21
XSUBADC_R_LOW1_P9 SUBADC_R_LOW1_R0_N8 SUBADC_R_LOW1_R0_N9 VGND sky130_fd_pr__res_xhigh_po_1p41 l=29.21
XSUBADC_R_P0_P0 VINP SUBADC_R_P0_R0_N0 VGND sky130_fd_pr__res_xhigh_po_1p41 l=29.21
XSUBADC_R_P0_P1 SUBADC_R_P0_R0_N0 SUBADC_R_P0_R0_N1 VGND sky130_fd_pr__res_xhigh_po_1p41 l=29.21
XSUBADC_R_P0_P10 SUBADC_R_P0_R0_N9 SUBADC_R_P0_R0_N10 VGND sky130_fd_pr__res_xhigh_po_1p41 l=29.21
XSUBADC_R_P0_P11 SUBADC_R_P0_R0_N10 SUBADC_R_P0_R0_N11 VGND sky130_fd_pr__res_xhigh_po_1p41 l=29.21
XSUBADC_R_P0_P12 SUBADC_R_P0_R0_N11 SUBADC_R_P0_R0_N12 VGND sky130_fd_pr__res_xhigh_po_1p41 l=29.21
XSUBADC_R_P0_P13 SUBADC_R_P0_R0_N12 SUBADC_R_P0_R0_N13 VGND sky130_fd_pr__res_xhigh_po_1p41 l=29.21
XSUBADC_R_P0_P14 SUBADC_R_P0_R0_N13 SUBADC_R_P0_R0_N14 VGND sky130_fd_pr__res_xhigh_po_1p41 l=29.21
XSUBADC_R_P0_P15 SUBADC_R_P0_R0_N14 SUBADC_R_P0_R0_N15 VGND sky130_fd_pr__res_xhigh_po_1p41 l=29.21
XSUBADC_R_P0_P16 SUBADC_R_P0_R0_N15 SUBADC_R_P0_R0_N16 VGND sky130_fd_pr__res_xhigh_po_1p41 l=29.21
XSUBADC_R_P0_P17 SUBADC_R_P0_R0_N16 SUBADC_R_P0_R0_N17 VGND sky130_fd_pr__res_xhigh_po_1p41 l=29.21
XSUBADC_R_P0_P18 SUBADC_R_P0_R0_N17 SUBADC_R_P0_R0_N18 VGND sky130_fd_pr__res_xhigh_po_1p41 l=29.21
XSUBADC_R_P0_P19 SUBADC_R_P0_R0_N18 SUBADC_R_P0_R0_N19 VGND sky130_fd_pr__res_xhigh_po_1p41 l=29.21
XSUBADC_R_P0_P2 SUBADC_R_P0_R0_N1 SUBADC_R_P0_R0_N2 VGND sky130_fd_pr__res_xhigh_po_1p41 l=29.21
XSUBADC_R_P0_P20 SUBADC_R_P0_R0_N19 SUBADC_R_P0_R0_N20 VGND sky130_fd_pr__res_xhigh_po_1p41 l=29.21
XSUBADC_R_P0_P21 SUBADC_R_P0_R0_N20 SUBADC_R_P0_R0_N21 VGND sky130_fd_pr__res_xhigh_po_1p41 l=29.21
XSUBADC_R_P0_P22 SUBADC_R_P0_R0_N21 SUBADC_R_P0_R0_N22 VGND sky130_fd_pr__res_xhigh_po_1p41 l=29.21
XSUBADC_R_P0_P23 SUBADC_R_P0_R0_N22 SUBADC__AVG_P VGND sky130_fd_pr__res_xhigh_po_1p41 l=29.21
XSUBADC_R_P0_P3 SUBADC_R_P0_R0_N2 SUBADC_R_P0_R0_N3 VGND sky130_fd_pr__res_xhigh_po_1p41 l=29.21
XSUBADC_R_P0_P4 SUBADC_R_P0_R0_N3 SUBADC_R_P0_R0_N4 VGND sky130_fd_pr__res_xhigh_po_1p41 l=29.21
XSUBADC_R_P0_P5 SUBADC_R_P0_R0_N4 SUBADC_R_P0_R0_N5 VGND sky130_fd_pr__res_xhigh_po_1p41 l=29.21
XSUBADC_R_P0_P6 SUBADC_R_P0_R0_N5 SUBADC_R_P0_R0_N6 VGND sky130_fd_pr__res_xhigh_po_1p41 l=29.21
XSUBADC_R_P0_P7 SUBADC_R_P0_R0_N6 SUBADC_R_P0_R0_N7 VGND sky130_fd_pr__res_xhigh_po_1p41 l=29.21
XSUBADC_R_P0_P8 SUBADC_R_P0_R0_N7 SUBADC_R_P0_R0_N8 VGND sky130_fd_pr__res_xhigh_po_1p41 l=29.21
XSUBADC_R_P0_P9 SUBADC_R_P0_R0_N8 SUBADC_R_P0_R0_N9 VGND sky130_fd_pr__res_xhigh_po_1p41 l=29.21
XSUBADC_R_P1_P0 VCM SUBADC_R_P1_R0_N0 VGND sky130_fd_pr__res_xhigh_po_1p41 l=29.21
XSUBADC_R_P1_P1 SUBADC_R_P1_R0_N0 SUBADC_R_P1_R0_N1 VGND sky130_fd_pr__res_xhigh_po_1p41 l=29.21
XSUBADC_R_P1_P10 SUBADC_R_P1_R0_N9 SUBADC_R_P1_R0_N10 VGND sky130_fd_pr__res_xhigh_po_1p41 l=29.21
XSUBADC_R_P1_P11 SUBADC_R_P1_R0_N10 SUBADC_R_P1_R0_N11 VGND sky130_fd_pr__res_xhigh_po_1p41 l=29.21
XSUBADC_R_P1_P12 SUBADC_R_P1_R0_N11 SUBADC_R_P1_R0_N12 VGND sky130_fd_pr__res_xhigh_po_1p41 l=29.21
XSUBADC_R_P1_P13 SUBADC_R_P1_R0_N12 SUBADC_R_P1_R0_N13 VGND sky130_fd_pr__res_xhigh_po_1p41 l=29.21
XSUBADC_R_P1_P14 SUBADC_R_P1_R0_N13 SUBADC_R_P1_R0_N14 VGND sky130_fd_pr__res_xhigh_po_1p41 l=29.21
XSUBADC_R_P1_P15 SUBADC_R_P1_R0_N14 SUBADC_R_P1_R0_N15 VGND sky130_fd_pr__res_xhigh_po_1p41 l=29.21
XSUBADC_R_P1_P16 SUBADC_R_P1_R0_N15 SUBADC_R_P1_R0_N16 VGND sky130_fd_pr__res_xhigh_po_1p41 l=29.21
XSUBADC_R_P1_P17 SUBADC_R_P1_R0_N16 SUBADC_R_P1_R0_N17 VGND sky130_fd_pr__res_xhigh_po_1p41 l=29.21
XSUBADC_R_P1_P18 SUBADC_R_P1_R0_N17 SUBADC_R_P1_R0_N18 VGND sky130_fd_pr__res_xhigh_po_1p41 l=29.21
XSUBADC_R_P1_P19 SUBADC_R_P1_R0_N18 SUBADC_R_P1_R0_N19 VGND sky130_fd_pr__res_xhigh_po_1p41 l=29.21
XSUBADC_R_P1_P2 SUBADC_R_P1_R0_N1 SUBADC_R_P1_R0_N2 VGND sky130_fd_pr__res_xhigh_po_1p41 l=29.21
XSUBADC_R_P1_P20 SUBADC_R_P1_R0_N19 SUBADC_R_P1_R0_N20 VGND sky130_fd_pr__res_xhigh_po_1p41 l=29.21
XSUBADC_R_P1_P21 SUBADC_R_P1_R0_N20 SUBADC_R_P1_R0_N21 VGND sky130_fd_pr__res_xhigh_po_1p41 l=29.21
XSUBADC_R_P1_P22 SUBADC_R_P1_R0_N21 SUBADC_R_P1_R0_N22 VGND sky130_fd_pr__res_xhigh_po_1p41 l=29.21
XSUBADC_R_P1_P23 SUBADC_R_P1_R0_N22 SUBADC__AVG_P VGND sky130_fd_pr__res_xhigh_po_1p41 l=29.21
XSUBADC_R_P1_P3 SUBADC_R_P1_R0_N2 SUBADC_R_P1_R0_N3 VGND sky130_fd_pr__res_xhigh_po_1p41 l=29.21
XSUBADC_R_P1_P4 SUBADC_R_P1_R0_N3 SUBADC_R_P1_R0_N4 VGND sky130_fd_pr__res_xhigh_po_1p41 l=29.21
XSUBADC_R_P1_P5 SUBADC_R_P1_R0_N4 SUBADC_R_P1_R0_N5 VGND sky130_fd_pr__res_xhigh_po_1p41 l=29.21
XSUBADC_R_P1_P6 SUBADC_R_P1_R0_N5 SUBADC_R_P1_R0_N6 VGND sky130_fd_pr__res_xhigh_po_1p41 l=29.21
XSUBADC_R_P1_P7 SUBADC_R_P1_R0_N6 SUBADC_R_P1_R0_N7 VGND sky130_fd_pr__res_xhigh_po_1p41 l=29.21
XSUBADC_R_P1_P8 SUBADC_R_P1_R0_N7 SUBADC_R_P1_R0_N8 VGND sky130_fd_pr__res_xhigh_po_1p41 l=29.21
XSUBADC_R_P1_P9 SUBADC_R_P1_R0_N8 SUBADC_R_P1_R0_N9 VGND sky130_fd_pr__res_xhigh_po_1p41 l=29.21
.ends pipeline16_stage

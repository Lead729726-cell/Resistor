.subckt SDM8_OTA_FIRST INP INN BIAS OUT VPWR VGND
XN_INN MIR INN TAIL VGND sky130_fd_pr__nfet_01v8 w=10 l=1 nf=1 m=1
XN_INP OUT INP TAIL VGND sky130_fd_pr__nfet_01v8 w=10 l=1 nf=1 m=1
XN_TAIL TAIL BIAS VGND VGND sky130_fd_pr__nfet_01v8 w=2 l=1 nf=1 m=1
XP_DIODE MIR MIR VPWR VPWR sky130_fd_pr__pfet_01v8_hvt w=20 l=1 nf=1 m=1
XP_MIRROR OUT MIR VPWR VPWR sky130_fd_pr__pfet_01v8_hvt w=20 l=1 nf=1 m=1
.ends SDM8_OTA_FIRST
.subckt ADC16_OTA INP INN BIAS OUT VPWR VGND
CC_MILLER PRE COMP 5e-13
XFIRST INP INN BIAS PRE VPWR VGND SDM8_OTA_FIRST
XN_SECOND OUT BIAS VGND VGND sky130_fd_pr__nfet_01v8 w=10 l=1 nf=1 m=1
XP_SECOND OUT PRE VPWR VPWR sky130_fd_pr__pfet_01v8_hvt w=20 l=1 nf=1 m=1
RR_ZERO COMP OUT 1000
.ends ADC16_OTA
.subckt SAR12_TG A Y EN ENB VPWR VGND
XN A EN Y VGND sky130_fd_pr__nfet_01v8 w=8 l=0.15 nf=1 m=1
XP A ENB Y VPWR sky130_fd_pr__pfet_01v8_hvt w=12 l=0.15 nf=1 m=1
.ends SAR12_TG
.subckt pipeline16_mdac VIN DAC VCM BIAS SAMPLE SAMPLEB OUT VPWR VGND
XAMP VCM SUM BIAS OUT VPWR VGND ADC16_OTA
CC_FEEDBACK SUM OUT 1e-12
CC_SAMPLE SUM BOTTOM 2e-12
XHOLD DAC BOTTOM SAMPLEB SAMPLE VPWR VGND SAR12_TG
XRESET_OUT VCM OUT SAMPLE SAMPLEB VPWR VGND SAR12_TG
XRESET_SUM VCM SUM SAMPLE SAMPLEB VPWR VGND SAR12_TG
XSAMPLE VIN BOTTOM SAMPLE SAMPLEB VPWR VGND SAR12_TG
.ends pipeline16_mdac

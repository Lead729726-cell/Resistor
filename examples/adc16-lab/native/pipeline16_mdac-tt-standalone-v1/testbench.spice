Resistor Indust actual ADC16 MOS reference
.include "/mnt/d/Coldbrew/Resistor/.runtime/adc16/native/pipeline16_mdac-tt-standalone-v1/supported-tt.spice"
.include "/mnt/d/Coldbrew/Resistor/.runtime/adc16/native/pipeline16_mdac-tt-standalone-v1/analog.spice"
.option sparse scale=1e-6 method=gear maxord=2 reltol=1e-5 vntol=1e-6 abstol=1e-12
.temp 27.0
VGND VGND 0 0
VDD SUPPLY VGND 1.8
R_SUPPLY SUPPLY VPWR .1
XU VIN DAC VCM BIAS SAMPLE SAMPLEB OUT VPWR VGND pipeline16_mdac
V_VCM VCM VGND 0.9
V_BIAS BIAS VGND 0.75
V_VIN VIN VGND 0.975
V_DAC DAC VGND 0.9
V_SAMPLE SAMPLE VGND PULSE(0 1.8 .1u 1n 1n 4.8u 10u)
V_SAMPLEB SAMPLEB VGND PULSE(1.8 0 .1u 1n 1n 4.8u 10u)
.control
set num_threads=1
set numdgt=17
set wr_singlescale
set wr_vecnames
tran 2e-09 2e-05 0 2e-09
let supply_current = -i(VDD)
wrdata waveform.dat v(VIN) v(OUT) supply_current
echo ADC16_NATIVE_COMPLETE
quit
.endc
.end

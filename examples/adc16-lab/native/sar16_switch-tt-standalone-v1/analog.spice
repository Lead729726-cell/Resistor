.subckt sar16_switch A Y EN ENB VPWR VGND
XN A EN Y VGND sky130_fd_pr__nfet_01v8 w=8 l=0.15 nf=1 m=1
XP A ENB Y VPWR sky130_fd_pr__pfet_01v8_hvt w=12 l=0.15 nf=1 m=1
.ends sar16_switch

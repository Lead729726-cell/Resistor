Resistor Indust actual ADC16 MOS reference
.include "/mnt/d/Coldbrew/Resistor/.runtime/adc16/native/sar16_switch-tt-standalone-v1/supported-tt.spice"
.include "/mnt/d/Coldbrew/Resistor/.runtime/adc16/native/sar16_switch-tt-standalone-v1/analog.spice"
.option sparse scale=1e-6 method=gear maxord=2 reltol=1e-5 vntol=1e-6 abstol=1e-12
.temp 27.0
VGND VGND 0 0
VDD SUPPLY VGND 1.8
R_SUPPLY SUPPLY VPWR .1
XU A Y EN ENB VPWR VGND sar16_switch
V_A A VGND PWL(0 .3 5u .3 5.01u 1.5 12u 1.5 12.01u .3 20u .3)
V_EN EN VGND 1.8
V_ENB ENB VGND 0
C_LOAD Y VGND 1p
R_LEAK Y VGND 1g
.control
set num_threads=1
set numdgt=17
set wr_singlescale
set wr_vecnames
tran 2e-09 2e-05 0 2e-09
let supply_current = -i(VDD)
wrdata waveform.dat v(A) v(Y) supply_current
echo ADC16_NATIVE_COMPLETE
quit
.endc
.end

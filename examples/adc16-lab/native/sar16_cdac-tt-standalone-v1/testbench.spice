Resistor Indust actual ADC16 MOS reference
.include "/mnt/d/Coldbrew/Resistor/.runtime/adc16/native/sar16_cdac-tt-standalone-v1/supported-tt.spice"
.include "/mnt/d/Coldbrew/Resistor/.runtime/adc16/native/sar16_cdac-tt-standalone-v1/analog.spice"
.option sparse scale=1e-6 method=gear maxord=2 reltol=1e-5 vntol=1e-6 abstol=1e-12
.temp 27.0
VGND VGND 0 0
VDD SUPPLY VGND 1.8
R_SUPPLY SUPPLY VPWR .1
XU VINP VINN VREF VCM SAMPLE TOPP TOPN B0 B1 B2 B3 B4 B5 B6 B7 B8 B9 B10 B11 B12 B13 B14 B15 VPWR VGND sar16_cdac
V_VINP VINP VGND 0.95
V_VINN VINN VGND 0.85
V_VREF VREF VGND 1.2
V_VCM VCM VGND 1.2
V_SAMPLE SAMPLE VGND PWL(0 1.8 8u 1.8 8.01u 0 20u 0)
V_B0 B0 VGND 0
V_B1 B1 VGND 0
V_B2 B2 VGND 0
V_B3 B3 VGND 0
V_B4 B4 VGND 0
V_B5 B5 VGND 0
V_B6 B6 VGND 0
V_B7 B7 VGND 0
V_B8 B8 VGND 0
V_B9 B9 VGND 0
V_B10 B10 VGND 0
V_B11 B11 VGND 0
V_B12 B12 VGND 0
V_B13 B13 VGND 0
V_B14 B14 VGND 0
V_B15 B15 VGND PWL(0 0 12u 0 12.01u 1.8 20u 1.8)
.control
set num_threads=1
set numdgt=17
set wr_singlescale
set wr_vecnames
tran 2e-09 2e-05 0 2e-09
let supply_current = -i(VDD)
wrdata waveform.dat v(TOPP) v(TOPN) v(SAMPLE) v(B15) supply_current
echo ADC16_NATIVE_COMPLETE
quit
.endc
.end

.subckt SDM8_OTA_FIRST INP INN BIAS OUT VPWR VGND
XN_INN MIR INN TAIL VGND sky130_fd_pr__nfet_01v8 w=10 l=1 nf=1 m=1
XN_INP OUT INP TAIL VGND sky130_fd_pr__nfet_01v8 w=10 l=1 nf=1 m=1
XN_TAIL TAIL BIAS VGND VGND sky130_fd_pr__nfet_01v8 w=2 l=1 nf=1 m=1
XP_DIODE MIR MIR VPWR VPWR sky130_fd_pr__pfet_01v8_hvt w=20 l=1 nf=1 m=1
XP_MIRROR OUT MIR VPWR VPWR sky130_fd_pr__pfet_01v8_hvt w=20 l=1 nf=1 m=1
.ends SDM8_OTA_FIRST
.subckt ADC16_OTA INP INN BIAS OUT VPWR VGND
CC_MILLER PRE COMP 5e-13
XFIRST INP INN BIAS PRE VPWR VGND SDM8_OTA_FIRST
XN_SECOND OUT BIAS VGND VGND sky130_fd_pr__nfet_01v8 w=10 l=1 nf=1 m=1
XP_SECOND OUT PRE VPWR VPWR sky130_fd_pr__pfet_01v8_hvt w=20 l=1 nf=1 m=1
RR_ZERO COMP OUT 1000
.ends ADC16_OTA
.subckt SDM8_RESET_SWITCH RESET RESETB VCM SUM OUT VPWR VGND
XN_RESET0 SUM RESET VCM VGND sky130_fd_pr__nfet_01v8 w=2 l=0.15 nf=1 m=1
XN_RESET1 OUT RESET VCM VGND sky130_fd_pr__nfet_01v8 w=2 l=0.15 nf=1 m=1
XP_RESET0 SUM RESETB VCM VPWR sky130_fd_pr__pfet_01v8_hvt w=4 l=0.15 nf=1 m=1
XP_RESET1 OUT RESETB VCM VPWR sky130_fd_pr__pfet_01v8_hvt w=4 l=0.15 nf=1 m=1
.ends SDM8_RESET_SWITCH
.subckt sdm16_integrator VIN SIGNAL BITSTREAM VCM BIAS OUT RESET RESETB VPWR VGND
XAMP TRACK_REF SUM BIAS OUT VPWR VGND ADC16_OTA
CC_INT OUT SUM 4e-12
XRESET_SWITCH RESET RESETB VCM SUM OUT VPWR VGND SDM8_RESET_SWITCH
RR_FEEDBACK BITSTREAM SUM 250000
RR_INPUT VIN SUM 500000
RR_REF_CM VCM TRACK_REF 200000
RR_REF_SIGNAL SIGNAL TRACK_REF 100000
.ends sdm16_integrator

.subckt sar16_bridge TOP FINE
CC_BRIDGE TOP FINE 2.13333333333e-12
.ends sar16_bridge

.subckt sar16_unit_cap TOP BOTTOM
CC_UNIT TOP BOTTOM 1e-12
.ends sar16_unit_cap

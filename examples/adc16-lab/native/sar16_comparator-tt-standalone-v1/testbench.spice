Resistor Indust actual ADC16 MOS reference
.include "/mnt/d/Coldbrew/Resistor/.runtime/adc16/native/sar16_comparator-tt-standalone-v1/supported-tt.spice"
.include "/mnt/d/Coldbrew/Resistor/.runtime/adc16/native/sar16_comparator-tt-standalone-v1/analog.spice"
.option sparse scale=1e-6 method=gear maxord=2 reltol=1e-5 vntol=1e-6 abstol=1e-12
.temp 27.0
VGND VGND 0 0
VDD SUPPLY VGND 1.8
R_SUPPLY SUPPLY VPWR .1
XU INP INN EVAL OUTP OUTN VPWR VGND sar16_comparator
V_INP INP VGND 0.9001
V_INN INN VGND 0.9
V_EVAL EVAL VGND PWL(0 0 2u 0 2.001u 1.8 20u 1.8)
.control
set num_threads=1
set numdgt=17
set wr_singlescale
set wr_vecnames
tran 2e-09 2e-05 0 2e-09
let supply_current = -i(VDD)
wrdata waveform.dat v(INP) v(INN) v(OUTP) v(OUTN) supply_current
echo ADC16_NATIVE_COMPLETE
quit
.endc
.end

.subckt adc16_reference VCM VPWR VGND
CC_DECAP VCM VGND 2e-11
RR_BOTTOM VCM VGND 100
RR_TOP VPWR VCM 100
.ends adc16_reference

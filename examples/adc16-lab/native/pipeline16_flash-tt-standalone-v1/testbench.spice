Resistor Indust actual ADC16 MOS reference
.include "/mnt/d/Coldbrew/Resistor/.runtime/adc16/native/pipeline16_flash-tt-standalone-v1/supported-tt.spice"
.include "/mnt/d/Coldbrew/Resistor/.runtime/adc16/native/pipeline16_flash-tt-standalone-v1/analog.spice"
.option sparse scale=1e-6 method=gear maxord=2 reltol=1e-5 vntol=1e-6 abstol=1e-12
.temp 27.0
VGND VGND 0 0
VDD SUPPLY VGND 1.8
R_SUPPLY SUPPLY VPWR .1
XU VINP VINN VCM FP FM BIAS CLK RESET Q0 Q1 Q2 VPWR VGND pipeline16_flash
V_VINP VINP VGND 0.975
V_VINN VINN VGND 0.825
V_VCM VCM VGND 0.9
V_BIAS BIAS VGND 0.75
V_FP FP VGND 1.5
V_FM FM VGND 0.3
V_RESET RESET VGND PWL(0 1.8 1.99u 1.8 2u 0 20u 0)
V_CLK CLK VGND PULSE(0 1.8 5u 1n 1n 4.9u 10u)
.control
set num_threads=1
set numdgt=17
set wr_singlescale
set wr_vecnames
tran 2e-09 2e-05 0 2e-09
let supply_current = -i(VDD)
wrdata waveform.dat v(VINP) v(VINN) v(Q0) v(Q1) v(Q2) supply_current
echo ADC16_NATIVE_COMPLETE
quit
.endc
.end

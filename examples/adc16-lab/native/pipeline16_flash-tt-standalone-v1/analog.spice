.subckt PREAMP INP INN BIAS OUT VPWR VGND
XN_INN MIR INN TAIL VGND sky130_fd_pr__nfet_01v8 w=10 l=1 nf=1 m=1
XN_INP OUT INP TAIL VGND sky130_fd_pr__nfet_01v8 w=10 l=1 nf=1 m=1
XN_TAIL TAIL BIAS VGND VGND sky130_fd_pr__nfet_01v8 w=2 l=1 nf=1 m=1
XP_DIODE MIR MIR VPWR VPWR sky130_fd_pr__pfet_01v8_hvt w=20 l=1 nf=1 m=1
XP_MIRROR OUT MIR VPWR VPWR sky130_fd_pr__pfet_01v8_hvt w=20 l=1 nf=1 m=1
.ends PREAMP
.subckt ADC16_COMPARATOR INP INN BIAS OUT VPWR VGND
XN_OUT OUT PRE VGND VGND sky130_fd_pr__nfet_01v8 w=4 l=0.15 nf=1 m=1
XPREAMP INP INN BIAS PRE VPWR VGND PREAMP
XP_OUT OUT PRE VPWR VPWR sky130_fd_pr__pfet_01v8_hvt w=8 l=0.15 nf=1 m=1
.ends ADC16_COMPARATOR
.subckt INV A Y VPWR VGND
XMN Y A VGND VGND sky130_fd_pr__nfet_01v8 w=0.65 l=0.15 nf=1 m=1
XMP Y A VPWR VPWR sky130_fd_pr__pfet_01v8_hvt w=0.65 l=0.15 nf=1 m=1
.ends INV
.subckt MUX2 A B S Y VPWR VGND
XIS S SB VPWR VGND INV
XMNA Y SB A VGND sky130_fd_pr__nfet_01v8 w=0.65 l=0.15 nf=1 m=1
XMNB Y S B VGND sky130_fd_pr__nfet_01v8 w=0.65 l=0.15 nf=1 m=1
XMPA Y S A VPWR sky130_fd_pr__pfet_01v8_hvt w=0.65 l=0.15 nf=1 m=1
XMPB Y SB B VPWR sky130_fd_pr__pfet_01v8_hvt w=0.65 l=0.15 nf=1 m=1
.ends MUX2
.subckt DFF D CLK Q VPWR VGND
XICLK CLK CLKB VPWR VGND INV
XM1 M MB VPWR VGND INV
XM2 MB MF VPWR VGND INV
XMNIN M CLKB D VGND sky130_fd_pr__nfet_01v8 w=0.65 l=0.15 nf=1 m=1
XMNMF M CLK MF VGND sky130_fd_pr__nfet_01v8 w=0.65 l=0.15 nf=1 m=1
XMNOUT T CLK MF VGND sky130_fd_pr__nfet_01v8 w=0.65 l=0.15 nf=1 m=1
XMNSF T CLKB Q VGND sky130_fd_pr__nfet_01v8 w=0.65 l=0.15 nf=1 m=1
XMPIN M CLK D VPWR sky130_fd_pr__pfet_01v8_hvt w=0.65 l=0.15 nf=1 m=1
XMPMF M CLKB MF VPWR sky130_fd_pr__pfet_01v8_hvt w=0.65 l=0.15 nf=1 m=1
XMPOUT T CLKB MF VPWR sky130_fd_pr__pfet_01v8_hvt w=0.65 l=0.15 nf=1 m=1
XMPSF T CLK Q VPWR sky130_fd_pr__pfet_01v8_hvt w=0.65 l=0.15 nf=1 m=1
XS1 T TB VPWR VGND INV
XS2 TB Q VPWR VGND INV
.ends DFF
.subckt SDM8_SAMPLE_LATCH D CLK RESET Q VPWR VGND
XRESET_DATA D VGND RESET DATA VPWR VGND MUX2
XSAMPLE DATA CLK Q VPWR VGND DFF
.ends SDM8_SAMPLE_LATCH
.subckt pipeline16_flash VINP VINN VCM FP FM BIAS CLK RESET Q0 Q1 Q2 VPWR VGND
XCMP0 AVG_P AVG_0 BIAS RAW_Q0 VPWR VGND ADC16_COMPARATOR
XCMP1 AVG_P AVG_1 BIAS RAW_Q1 VPWR VGND ADC16_COMPARATOR
XCMP2 AVG_P AVG_2 BIAS RAW_Q2 VPWR VGND ADC16_COMPARATOR
XLATCH0 RAW_Q0 CLK RESET Q0 VPWR VGND SDM8_SAMPLE_LATCH
XLATCH1 RAW_Q1 CLK RESET Q1 VPWR VGND SDM8_SAMPLE_LATCH
XLATCH2 RAW_Q2 CLK RESET Q2 VPWR VGND SDM8_SAMPLE_LATCH
RR_N00 VINN AVG_0 1000000
RR_N01 FM AVG_0 1000000
RR_N10 VINN AVG_1 1000000
RR_N11 VCM AVG_1 1000000
RR_N20 VINN AVG_2 1000000
RR_N21 FP AVG_2 1000000
RR_P0 VINP AVG_P 1000000
RR_P1 VCM AVG_P 1000000
.ends pipeline16_flash

.subckt SDM8_INPUT_FILTER VIN OUT VPWR VGND
CC_AA OUT VGND 1e-10
RR_AA VIN OUT 100
.ends SDM8_INPUT_FILTER
.subckt ADC16_REFERENCE VCM VPWR VGND
CC_DECAP VCM VGND 2e-11
RR_BOTTOM VCM VGND 100
RR_TOP VPWR VCM 100
.ends ADC16_REFERENCE
.subckt ADC16_BIAS BIAS VPWR VGND
XN_DIODE BIAS BIAS VGND VGND sky130_fd_pr__nfet_01v8 w=2 l=1 nf=1 m=1
RR_BIAS VPWR BIAS 200000
.ends ADC16_BIAS
.subckt INV A Y VPWR VGND
XMN Y A VGND VGND sky130_fd_pr__nfet_01v8 w=0.65 l=0.15 nf=1 m=1
XMP Y A VPWR VPWR sky130_fd_pr__pfet_01v8_hvt w=0.65 l=0.15 nf=1 m=1
.ends INV
.subckt SDM8_CLOCK_BUFFER CLK CLK_OUT VPWR VGND
XFIRST CLK CLKB VPWR VGND INV
XSECOND CLKB CLK_OUT VPWR VGND INV
.ends SDM8_CLOCK_BUFFER
.subckt SDM8_OTA_FIRST INP INN BIAS OUT VPWR VGND
XN_INN MIR INN TAIL VGND sky130_fd_pr__nfet_01v8 w=10 l=1 nf=1 m=1
XN_INP OUT INP TAIL VGND sky130_fd_pr__nfet_01v8 w=10 l=1 nf=1 m=1
XN_TAIL TAIL BIAS VGND VGND sky130_fd_pr__nfet_01v8 w=2 l=1 nf=1 m=1
XP_DIODE MIR MIR VPWR VPWR sky130_fd_pr__pfet_01v8_hvt w=20 l=1 nf=1 m=1
XP_MIRROR OUT MIR VPWR VPWR sky130_fd_pr__pfet_01v8_hvt w=20 l=1 nf=1 m=1
.ends SDM8_OTA_FIRST
.subckt SDM8_OTA INP INN BIAS OUT VPWR VGND
CC_MILLER PRE COMP 5e-13
XFIRST INP INN BIAS PRE VPWR VGND SDM8_OTA_FIRST
XN_SECOND OUT BIAS VGND VGND sky130_fd_pr__nfet_01v8 w=10 l=1 nf=1 m=1
XP_SECOND OUT PRE VPWR VPWR sky130_fd_pr__pfet_01v8_hvt w=20 l=1 nf=1 m=1
RR_ZERO COMP OUT 1000
.ends SDM8_OTA
.subckt SDM8_RESET_SWITCH RESET RESETB VCM SUM OUT VPWR VGND
XN_RESET0 SUM RESET VCM VGND sky130_fd_pr__nfet_01v8 w=2 l=0.15 nf=1 m=1
XN_RESET1 OUT RESET VCM VGND sky130_fd_pr__nfet_01v8 w=2 l=0.15 nf=1 m=1
XP_RESET0 SUM RESETB VCM VPWR sky130_fd_pr__pfet_01v8_hvt w=4 l=0.15 nf=1 m=1
XP_RESET1 OUT RESETB VCM VPWR sky130_fd_pr__pfet_01v8_hvt w=4 l=0.15 nf=1 m=1
.ends SDM8_RESET_SWITCH
.subckt SDM8_INTEGRATOR VIN DACB VCM BIAS OUT RESET RESETB VPWR VGND
XAMP VCM SUM BIAS OUT VPWR VGND SDM8_OTA
CC_INT OUT SUM 4e-12
XRESET_SWITCH RESET RESETB VCM SUM OUT VPWR VGND SDM8_RESET_SWITCH
RR_FEEDBACK DACB SUM 500000
RR_INPUT VIN SUM 500000
.ends SDM8_INTEGRATOR
.subckt ADC16_OTA INP INN BIAS OUT VPWR VGND
CC_MILLER PRE COMP 5e-13
XFIRST INP INN BIAS PRE VPWR VGND SDM8_OTA_FIRST
XN_SECOND OUT BIAS VGND VGND sky130_fd_pr__nfet_01v8 w=10 l=1 nf=1 m=1
XP_SECOND OUT PRE VPWR VPWR sky130_fd_pr__pfet_01v8_hvt w=20 l=1 nf=1 m=1
RR_ZERO COMP OUT 1000
.ends ADC16_OTA
.subckt SDM16_INTEGRATOR2 VIN SIGNAL BITSTREAM VCM BIAS OUT RESET RESETB VPWR VGND
XAMP TRACK_REF SUM BIAS OUT VPWR VGND ADC16_OTA
CC_INT OUT SUM 4e-12
XRESET_SWITCH RESET RESETB VCM SUM OUT VPWR VGND SDM8_RESET_SWITCH
RR_FEEDBACK BITSTREAM SUM 250000
RR_INPUT VIN SUM 500000
RR_REF_CM VCM TRACK_REF 200000
RR_REF_SIGNAL SIGNAL TRACK_REF 100000
.ends SDM16_INTEGRATOR2
.subckt PREAMP INP INN BIAS OUT VPWR VGND
XN_INN MIR INN TAIL VGND sky130_fd_pr__nfet_01v8 w=10 l=1 nf=1 m=1
XN_INP OUT INP TAIL VGND sky130_fd_pr__nfet_01v8 w=10 l=1 nf=1 m=1
XN_TAIL TAIL BIAS VGND VGND sky130_fd_pr__nfet_01v8 w=2 l=1 nf=1 m=1
XP_DIODE MIR MIR VPWR VPWR sky130_fd_pr__pfet_01v8_hvt w=20 l=1 nf=1 m=1
XP_MIRROR OUT MIR VPWR VPWR sky130_fd_pr__pfet_01v8_hvt w=20 l=1 nf=1 m=1
.ends PREAMP
.subckt ADC16_COMPARATOR INP INN BIAS OUT VPWR VGND
XN_OUT OUT PRE VGND VGND sky130_fd_pr__nfet_01v8 w=4 l=0.15 nf=1 m=1
XPREAMP INP INN BIAS PRE VPWR VGND PREAMP
XP_OUT OUT PRE VPWR VPWR sky130_fd_pr__pfet_01v8_hvt w=8 l=0.15 nf=1 m=1
.ends ADC16_COMPARATOR
.subckt MUX2 A B S Y VPWR VGND
XIS S SB VPWR VGND INV
XMNA Y SB A VGND sky130_fd_pr__nfet_01v8 w=0.65 l=0.15 nf=1 m=1
XMNB Y S B VGND sky130_fd_pr__nfet_01v8 w=0.65 l=0.15 nf=1 m=1
XMPA Y S A VPWR sky130_fd_pr__pfet_01v8_hvt w=0.65 l=0.15 nf=1 m=1
XMPB Y SB B VPWR sky130_fd_pr__pfet_01v8_hvt w=0.65 l=0.15 nf=1 m=1
.ends MUX2
.subckt DFF D CLK Q VPWR VGND
XICLK CLK CLKB VPWR VGND INV
XM1 M MB VPWR VGND INV
XM2 MB MF VPWR VGND INV
XMNIN M CLKB D VGND sky130_fd_pr__nfet_01v8 w=0.65 l=0.15 nf=1 m=1
XMNMF M CLK MF VGND sky130_fd_pr__nfet_01v8 w=0.65 l=0.15 nf=1 m=1
XMNOUT T CLK MF VGND sky130_fd_pr__nfet_01v8 w=0.65 l=0.15 nf=1 m=1
XMNSF T CLKB Q VGND sky130_fd_pr__nfet_01v8 w=0.65 l=0.15 nf=1 m=1
XMPIN M CLK D VPWR sky130_fd_pr__pfet_01v8_hvt w=0.65 l=0.15 nf=1 m=1
XMPMF M CLKB MF VPWR sky130_fd_pr__pfet_01v8_hvt w=0.65 l=0.15 nf=1 m=1
XMPOUT T CLKB MF VPWR sky130_fd_pr__pfet_01v8_hvt w=0.65 l=0.15 nf=1 m=1
XMPSF T CLK Q VPWR sky130_fd_pr__pfet_01v8_hvt w=0.65 l=0.15 nf=1 m=1
XS1 T TB VPWR VGND INV
XS2 TB Q VPWR VGND INV
.ends DFF
.subckt SDM8_SAMPLE_LATCH D CLK RESET Q VPWR VGND
XRESET_DATA D VGND RESET DATA VPWR VGND MUX2
XSAMPLE DATA CLK Q VPWR VGND DFF
.ends SDM8_SAMPLE_LATCH
.subckt SDM8_DAC BITSTREAM DACB VPWR VGND
XNRZ BITSTREAM DACB VPWR VGND INV
.ends SDM8_DAC
.subckt sdm16_modulator VIN CLK RESET BITSTREAM VCM BIAS INT1 INT2 VPWR VGND
XBIAS_SOURCE BIAS VPWR VGND ADC16_BIAS
XBIT_LATCH CMP SAMPLE_CLK RESET BITSTREAM VPWR VGND SDM8_SAMPLE_LATCH
XCLOCK CLK SAMPLE_CLK VPWR VGND SDM8_CLOCK_BUFFER
XFEEDBACK_DAC BITSTREAM DACB VPWR VGND SDM8_DAC
XINPUT VIN FILTERED VPWR VGND SDM8_INPUT_FILTER
XINTEGRATOR1 FILTERED DACB VCM BIAS INT1 RESET RESETB VPWR VGND SDM8_INTEGRATOR
XINTEGRATOR2 INT1 FILTERED BITSTREAM VCM BIAS INT2 RESET RESETB VPWR VGND SDM16_INTEGRATOR2
XQUANTIZER INT2 VCM BIAS CMP VPWR VGND ADC16_COMPARATOR
XREFERENCE VCM VPWR VGND ADC16_REFERENCE
XRESET_INV RESET RESETB VPWR VGND INV
.ends sdm16_modulator

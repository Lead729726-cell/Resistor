.subckt INV A Y VPWR VGND
XMN Y A VGND VGND sky130_fd_pr__nfet_01v8 w=0.65 l=0.15 nf=1 m=1
XMP Y A VPWR VPWR sky130_fd_pr__pfet_01v8_hvt w=0.65 l=0.15 nf=1 m=1
.ends INV
.subckt SAR12_TG A Y EN ENB VPWR VGND
XN A EN Y VGND sky130_fd_pr__nfet_01v8 w=8 l=0.15 nf=1 m=1
XP A ENB Y VPWR sky130_fd_pr__pfet_01v8_hvt w=12 l=0.15 nf=1 m=1
.ends SAR12_TG
.subckt SAR12_REFMUX VIN REF SAMPLE SAMPLEB OUT VPWR VGND
XACQUIRE VIN OUT SAMPLE SAMPLEB VPWR VGND SAR12_TG
XCONVERT REF OUT SAMPLEB SAMPLE VPWR VGND SAR12_TG
.ends SAR12_REFMUX
.subckt SAR16_BRIDGE TOP FINE
CC_BRIDGE TOP FINE 2.13333333333e-12
.ends SAR16_BRIDGE
.subckt SAR12_BITMUX HI LO BIT OUT VPWR VGND
XHIGH HI OUT BIT BITB VPWR VGND SAR12_TG
XINV BIT BITB VPWR VGND INV
XLOW LO OUT BITB BIT VPWR VGND SAR12_TG
.ends SAR12_BITMUX
.subckt SAR16_UNIT TOP BOTTOM
CC_UNIT TOP BOTTOM 1e-12
.ends SAR16_UNIT
.subckt SAR16_CDAC VINP VINN VREF VCM SAMPLE TOPP TOPN B0 B1 B2 B3 B4 B5 B6 B7 B8 B9 B10 B11 B12 B13 B14 B15 VPWR VGND
XBRIDGE_0N TOPN BANK1N SAR16_BRIDGE
XBRIDGE_0P TOPP BANK1P SAR16_BRIDGE
XBRIDGE_1N BANK1N BANK2N SAR16_BRIDGE
XBRIDGE_1P BANK1P BANK2P SAR16_BRIDGE
XBRIDGE_2N BANK2N BANK3N SAR16_BRIDGE
XBRIDGE_2P BANK2P BANK3P SAR16_BRIDGE
XHIN VINN VREF SAMPLE SAMPLEB HIN VPWR VGND SAR12_REFMUX
XHIP VINP VREF SAMPLE SAMPLEB HIP VPWR VGND SAR12_REFMUX
XLON VINN VGND SAMPLE SAMPLEB LON VPWR VGND SAR12_REFMUX
XLOP VINP VGND SAMPLE SAMPLEB LOP VPWR VGND SAR12_REFMUX
XN_BANK0_B0_SW LON HIN B12 N_BANK0_B0 VPWR VGND SAR12_BITMUX
XN_BANK0_B0_U0 TOPN N_BANK0_B0 SAR16_UNIT
XN_BANK0_B0_U1 TOPN N_BANK0_B0 SAR16_UNIT
XN_BANK0_B1_SW LON HIN B13 N_BANK0_B1 VPWR VGND SAR12_BITMUX
XN_BANK0_B1_U0 TOPN N_BANK0_B1 SAR16_UNIT
XN_BANK0_B1_U1 TOPN N_BANK0_B1 SAR16_UNIT
XN_BANK0_B1_U2 TOPN N_BANK0_B1 SAR16_UNIT
XN_BANK0_B1_U3 TOPN N_BANK0_B1 SAR16_UNIT
XN_BANK0_B2_SW LON HIN B14 N_BANK0_B2 VPWR VGND SAR12_BITMUX
XN_BANK0_B2_U0 TOPN N_BANK0_B2 SAR16_UNIT
XN_BANK0_B2_U1 TOPN N_BANK0_B2 SAR16_UNIT
XN_BANK0_B2_U2 TOPN N_BANK0_B2 SAR16_UNIT
XN_BANK0_B2_U3 TOPN N_BANK0_B2 SAR16_UNIT
XN_BANK0_B2_U4 TOPN N_BANK0_B2 SAR16_UNIT
XN_BANK0_B2_U5 TOPN N_BANK0_B2 SAR16_UNIT
XN_BANK0_B2_U6 TOPN N_BANK0_B2 SAR16_UNIT
XN_BANK0_B2_U7 TOPN N_BANK0_B2 SAR16_UNIT
XN_BANK0_B3_SW LON HIN B15 N_BANK0_B3 VPWR VGND SAR12_BITMUX
XN_BANK0_B3_U0 TOPN N_BANK0_B3 SAR16_UNIT
XN_BANK0_B3_U1 TOPN N_BANK0_B3 SAR16_UNIT
XN_BANK0_B3_U10 TOPN N_BANK0_B3 SAR16_UNIT
XN_BANK0_B3_U11 TOPN N_BANK0_B3 SAR16_UNIT
XN_BANK0_B3_U12 TOPN N_BANK0_B3 SAR16_UNIT
XN_BANK0_B3_U13 TOPN N_BANK0_B3 SAR16_UNIT
XN_BANK0_B3_U14 TOPN N_BANK0_B3 SAR16_UNIT
XN_BANK0_B3_U15 TOPN N_BANK0_B3 SAR16_UNIT
XN_BANK0_B3_U2 TOPN N_BANK0_B3 SAR16_UNIT
XN_BANK0_B3_U3 TOPN N_BANK0_B3 SAR16_UNIT
XN_BANK0_B3_U4 TOPN N_BANK0_B3 SAR16_UNIT
XN_BANK0_B3_U5 TOPN N_BANK0_B3 SAR16_UNIT
XN_BANK0_B3_U6 TOPN N_BANK0_B3 SAR16_UNIT
XN_BANK0_B3_U7 TOPN N_BANK0_B3 SAR16_UNIT
XN_BANK0_B3_U8 TOPN N_BANK0_B3 SAR16_UNIT
XN_BANK0_B3_U9 TOPN N_BANK0_B3 SAR16_UNIT
XN_BANK1_B0_SW LON HIN B8 N_BANK1_B0 VPWR VGND SAR12_BITMUX
XN_BANK1_B0_U0 BANK1N N_BANK1_B0 SAR16_UNIT
XN_BANK1_B0_U1 BANK1N N_BANK1_B0 SAR16_UNIT
XN_BANK1_B1_SW LON HIN B9 N_BANK1_B1 VPWR VGND SAR12_BITMUX
XN_BANK1_B1_U0 BANK1N N_BANK1_B1 SAR16_UNIT
XN_BANK1_B1_U1 BANK1N N_BANK1_B1 SAR16_UNIT
XN_BANK1_B1_U2 BANK1N N_BANK1_B1 SAR16_UNIT
XN_BANK1_B1_U3 BANK1N N_BANK1_B1 SAR16_UNIT
XN_BANK1_B2_SW LON HIN B10 N_BANK1_B2 VPWR VGND SAR12_BITMUX
XN_BANK1_B2_U0 BANK1N N_BANK1_B2 SAR16_UNIT
XN_BANK1_B2_U1 BANK1N N_BANK1_B2 SAR16_UNIT
XN_BANK1_B2_U2 BANK1N N_BANK1_B2 SAR16_UNIT
XN_BANK1_B2_U3 BANK1N N_BANK1_B2 SAR16_UNIT
XN_BANK1_B2_U4 BANK1N N_BANK1_B2 SAR16_UNIT
XN_BANK1_B2_U5 BANK1N N_BANK1_B2 SAR16_UNIT
XN_BANK1_B2_U6 BANK1N N_BANK1_B2 SAR16_UNIT
XN_BANK1_B2_U7 BANK1N N_BANK1_B2 SAR16_UNIT
XN_BANK1_B3_SW LON HIN B11 N_BANK1_B3 VPWR VGND SAR12_BITMUX
XN_BANK1_B3_U0 BANK1N N_BANK1_B3 SAR16_UNIT
XN_BANK1_B3_U1 BANK1N N_BANK1_B3 SAR16_UNIT
XN_BANK1_B3_U10 BANK1N N_BANK1_B3 SAR16_UNIT
XN_BANK1_B3_U11 BANK1N N_BANK1_B3 SAR16_UNIT
XN_BANK1_B3_U12 BANK1N N_BANK1_B3 SAR16_UNIT
XN_BANK1_B3_U13 BANK1N N_BANK1_B3 SAR16_UNIT
XN_BANK1_B3_U14 BANK1N N_BANK1_B3 SAR16_UNIT
XN_BANK1_B3_U15 BANK1N N_BANK1_B3 SAR16_UNIT
XN_BANK1_B3_U2 BANK1N N_BANK1_B3 SAR16_UNIT
XN_BANK1_B3_U3 BANK1N N_BANK1_B3 SAR16_UNIT
XN_BANK1_B3_U4 BANK1N N_BANK1_B3 SAR16_UNIT
XN_BANK1_B3_U5 BANK1N N_BANK1_B3 SAR16_UNIT
XN_BANK1_B3_U6 BANK1N N_BANK1_B3 SAR16_UNIT
XN_BANK1_B3_U7 BANK1N N_BANK1_B3 SAR16_UNIT
XN_BANK1_B3_U8 BANK1N N_BANK1_B3 SAR16_UNIT
XN_BANK1_B3_U9 BANK1N N_BANK1_B3 SAR16_UNIT
XN_BANK2_B0_SW LON HIN B4 N_BANK2_B0 VPWR VGND SAR12_BITMUX
XN_BANK2_B0_U0 BANK2N N_BANK2_B0 SAR16_UNIT
XN_BANK2_B0_U1 BANK2N N_BANK2_B0 SAR16_UNIT
XN_BANK2_B1_SW LON HIN B5 N_BANK2_B1 VPWR VGND SAR12_BITMUX
XN_BANK2_B1_U0 BANK2N N_BANK2_B1 SAR16_UNIT
XN_BANK2_B1_U1 BANK2N N_BANK2_B1 SAR16_UNIT
XN_BANK2_B1_U2 BANK2N N_BANK2_B1 SAR16_UNIT
XN_BANK2_B1_U3 BANK2N N_BANK2_B1 SAR16_UNIT
XN_BANK2_B2_SW LON HIN B6 N_BANK2_B2 VPWR VGND SAR12_BITMUX
XN_BANK2_B2_U0 BANK2N N_BANK2_B2 SAR16_UNIT
XN_BANK2_B2_U1 BANK2N N_BANK2_B2 SAR16_UNIT
XN_BANK2_B2_U2 BANK2N N_BANK2_B2 SAR16_UNIT
XN_BANK2_B2_U3 BANK2N N_BANK2_B2 SAR16_UNIT
XN_BANK2_B2_U4 BANK2N N_BANK2_B2 SAR16_UNIT
XN_BANK2_B2_U5 BANK2N N_BANK2_B2 SAR16_UNIT
XN_BANK2_B2_U6 BANK2N N_BANK2_B2 SAR16_UNIT
XN_BANK2_B2_U7 BANK2N N_BANK2_B2 SAR16_UNIT
XN_BANK2_B3_SW LON HIN B7 N_BANK2_B3 VPWR VGND SAR12_BITMUX
XN_BANK2_B3_U0 BANK2N N_BANK2_B3 SAR16_UNIT
XN_BANK2_B3_U1 BANK2N N_BANK2_B3 SAR16_UNIT
XN_BANK2_B3_U10 BANK2N N_BANK2_B3 SAR16_UNIT
XN_BANK2_B3_U11 BANK2N N_BANK2_B3 SAR16_UNIT
XN_BANK2_B3_U12 BANK2N N_BANK2_B3 SAR16_UNIT
XN_BANK2_B3_U13 BANK2N N_BANK2_B3 SAR16_UNIT
XN_BANK2_B3_U14 BANK2N N_BANK2_B3 SAR16_UNIT
XN_BANK2_B3_U15 BANK2N N_BANK2_B3 SAR16_UNIT
XN_BANK2_B3_U2 BANK2N N_BANK2_B3 SAR16_UNIT
XN_BANK2_B3_U3 BANK2N N_BANK2_B3 SAR16_UNIT
XN_BANK2_B3_U4 BANK2N N_BANK2_B3 SAR16_UNIT
XN_BANK2_B3_U5 BANK2N N_BANK2_B3 SAR16_UNIT
XN_BANK2_B3_U6 BANK2N N_BANK2_B3 SAR16_UNIT
XN_BANK2_B3_U7 BANK2N N_BANK2_B3 SAR16_UNIT
XN_BANK2_B3_U8 BANK2N N_BANK2_B3 SAR16_UNIT
XN_BANK2_B3_U9 BANK2N N_BANK2_B3 SAR16_UNIT
XN_BANK3_B0_SW LON HIN B0 N_BANK3_B0 VPWR VGND SAR12_BITMUX
XN_BANK3_B0_U0 BANK3N N_BANK3_B0 SAR16_UNIT
XN_BANK3_B0_U1 BANK3N N_BANK3_B0 SAR16_UNIT
XN_BANK3_B1_SW LON HIN B1 N_BANK3_B1 VPWR VGND SAR12_BITMUX
XN_BANK3_B1_U0 BANK3N N_BANK3_B1 SAR16_UNIT
XN_BANK3_B1_U1 BANK3N N_BANK3_B1 SAR16_UNIT
XN_BANK3_B1_U2 BANK3N N_BANK3_B1 SAR16_UNIT
XN_BANK3_B1_U3 BANK3N N_BANK3_B1 SAR16_UNIT
XN_BANK3_B2_SW LON HIN B2 N_BANK3_B2 VPWR VGND SAR12_BITMUX
XN_BANK3_B2_U0 BANK3N N_BANK3_B2 SAR16_UNIT
XN_BANK3_B2_U1 BANK3N N_BANK3_B2 SAR16_UNIT
XN_BANK3_B2_U2 BANK3N N_BANK3_B2 SAR16_UNIT
XN_BANK3_B2_U3 BANK3N N_BANK3_B2 SAR16_UNIT
XN_BANK3_B2_U4 BANK3N N_BANK3_B2 SAR16_UNIT
XN_BANK3_B2_U5 BANK3N N_BANK3_B2 SAR16_UNIT
XN_BANK3_B2_U6 BANK3N N_BANK3_B2 SAR16_UNIT
XN_BANK3_B2_U7 BANK3N N_BANK3_B2 SAR16_UNIT
XN_BANK3_B3_SW LON HIN B3 N_BANK3_B3 VPWR VGND SAR12_BITMUX
XN_BANK3_B3_U0 BANK3N N_BANK3_B3 SAR16_UNIT
XN_BANK3_B3_U1 BANK3N N_BANK3_B3 SAR16_UNIT
XN_BANK3_B3_U10 BANK3N N_BANK3_B3 SAR16_UNIT
XN_BANK3_B3_U11 BANK3N N_BANK3_B3 SAR16_UNIT
XN_BANK3_B3_U12 BANK3N N_BANK3_B3 SAR16_UNIT
XN_BANK3_B3_U13 BANK3N N_BANK3_B3 SAR16_UNIT
XN_BANK3_B3_U14 BANK3N N_BANK3_B3 SAR16_UNIT
XN_BANK3_B3_U15 BANK3N N_BANK3_B3 SAR16_UNIT
XN_BANK3_B3_U2 BANK3N N_BANK3_B3 SAR16_UNIT
XN_BANK3_B3_U3 BANK3N N_BANK3_B3 SAR16_UNIT
XN_BANK3_B3_U4 BANK3N N_BANK3_B3 SAR16_UNIT
XN_BANK3_B3_U5 BANK3N N_BANK3_B3 SAR16_UNIT
XN_BANK3_B3_U6 BANK3N N_BANK3_B3 SAR16_UNIT
XN_BANK3_B3_U7 BANK3N N_BANK3_B3 SAR16_UNIT
XN_BANK3_B3_U8 BANK3N N_BANK3_B3 SAR16_UNIT
XN_BANK3_B3_U9 BANK3N N_BANK3_B3 SAR16_UNIT
XN_BANK3_DUMMY_U0 BANK3N HIN SAR16_UNIT
XN_BANK3_DUMMY_U1 BANK3N HIN SAR16_UNIT
XP_BANK0_B0_SW HIP LOP B12 P_BANK0_B0 VPWR VGND SAR12_BITMUX
XP_BANK0_B0_U0 TOPP P_BANK0_B0 SAR16_UNIT
XP_BANK0_B0_U1 TOPP P_BANK0_B0 SAR16_UNIT
XP_BANK0_B1_SW HIP LOP B13 P_BANK0_B1 VPWR VGND SAR12_BITMUX
XP_BANK0_B1_U0 TOPP P_BANK0_B1 SAR16_UNIT
XP_BANK0_B1_U1 TOPP P_BANK0_B1 SAR16_UNIT
XP_BANK0_B1_U2 TOPP P_BANK0_B1 SAR16_UNIT
XP_BANK0_B1_U3 TOPP P_BANK0_B1 SAR16_UNIT
XP_BANK0_B2_SW HIP LOP B14 P_BANK0_B2 VPWR VGND SAR12_BITMUX
XP_BANK0_B2_U0 TOPP P_BANK0_B2 SAR16_UNIT
XP_BANK0_B2_U1 TOPP P_BANK0_B2 SAR16_UNIT
XP_BANK0_B2_U2 TOPP P_BANK0_B2 SAR16_UNIT
XP_BANK0_B2_U3 TOPP P_BANK0_B2 SAR16_UNIT
XP_BANK0_B2_U4 TOPP P_BANK0_B2 SAR16_UNIT
XP_BANK0_B2_U5 TOPP P_BANK0_B2 SAR16_UNIT
XP_BANK0_B2_U6 TOPP P_BANK0_B2 SAR16_UNIT
XP_BANK0_B2_U7 TOPP P_BANK0_B2 SAR16_UNIT
XP_BANK0_B3_SW HIP LOP B15 P_BANK0_B3 VPWR VGND SAR12_BITMUX
XP_BANK0_B3_U0 TOPP P_BANK0_B3 SAR16_UNIT
XP_BANK0_B3_U1 TOPP P_BANK0_B3 SAR16_UNIT
XP_BANK0_B3_U10 TOPP P_BANK0_B3 SAR16_UNIT
XP_BANK0_B3_U11 TOPP P_BANK0_B3 SAR16_UNIT
XP_BANK0_B3_U12 TOPP P_BANK0_B3 SAR16_UNIT
XP_BANK0_B3_U13 TOPP P_BANK0_B3 SAR16_UNIT
XP_BANK0_B3_U14 TOPP P_BANK0_B3 SAR16_UNIT
XP_BANK0_B3_U15 TOPP P_BANK0_B3 SAR16_UNIT
XP_BANK0_B3_U2 TOPP P_BANK0_B3 SAR16_UNIT
XP_BANK0_B3_U3 TOPP P_BANK0_B3 SAR16_UNIT
XP_BANK0_B3_U4 TOPP P_BANK0_B3 SAR16_UNIT
XP_BANK0_B3_U5 TOPP P_BANK0_B3 SAR16_UNIT
XP_BANK0_B3_U6 TOPP P_BANK0_B3 SAR16_UNIT
XP_BANK0_B3_U7 TOPP P_BANK0_B3 SAR16_UNIT
XP_BANK0_B3_U8 TOPP P_BANK0_B3 SAR16_UNIT
XP_BANK0_B3_U9 TOPP P_BANK0_B3 SAR16_UNIT
XP_BANK1_B0_SW HIP LOP B8 P_BANK1_B0 VPWR VGND SAR12_BITMUX
XP_BANK1_B0_U0 BANK1P P_BANK1_B0 SAR16_UNIT
XP_BANK1_B0_U1 BANK1P P_BANK1_B0 SAR16_UNIT
XP_BANK1_B1_SW HIP LOP B9 P_BANK1_B1 VPWR VGND SAR12_BITMUX
XP_BANK1_B1_U0 BANK1P P_BANK1_B1 SAR16_UNIT
XP_BANK1_B1_U1 BANK1P P_BANK1_B1 SAR16_UNIT
XP_BANK1_B1_U2 BANK1P P_BANK1_B1 SAR16_UNIT
XP_BANK1_B1_U3 BANK1P P_BANK1_B1 SAR16_UNIT
XP_BANK1_B2_SW HIP LOP B10 P_BANK1_B2 VPWR VGND SAR12_BITMUX
XP_BANK1_B2_U0 BANK1P P_BANK1_B2 SAR16_UNIT
XP_BANK1_B2_U1 BANK1P P_BANK1_B2 SAR16_UNIT
XP_BANK1_B2_U2 BANK1P P_BANK1_B2 SAR16_UNIT
XP_BANK1_B2_U3 BANK1P P_BANK1_B2 SAR16_UNIT
XP_BANK1_B2_U4 BANK1P P_BANK1_B2 SAR16_UNIT
XP_BANK1_B2_U5 BANK1P P_BANK1_B2 SAR16_UNIT
XP_BANK1_B2_U6 BANK1P P_BANK1_B2 SAR16_UNIT
XP_BANK1_B2_U7 BANK1P P_BANK1_B2 SAR16_UNIT
XP_BANK1_B3_SW HIP LOP B11 P_BANK1_B3 VPWR VGND SAR12_BITMUX
XP_BANK1_B3_U0 BANK1P P_BANK1_B3 SAR16_UNIT
XP_BANK1_B3_U1 BANK1P P_BANK1_B3 SAR16_UNIT
XP_BANK1_B3_U10 BANK1P P_BANK1_B3 SAR16_UNIT
XP_BANK1_B3_U11 BANK1P P_BANK1_B3 SAR16_UNIT
XP_BANK1_B3_U12 BANK1P P_BANK1_B3 SAR16_UNIT
XP_BANK1_B3_U13 BANK1P P_BANK1_B3 SAR16_UNIT
XP_BANK1_B3_U14 BANK1P P_BANK1_B3 SAR16_UNIT
XP_BANK1_B3_U15 BANK1P P_BANK1_B3 SAR16_UNIT
XP_BANK1_B3_U2 BANK1P P_BANK1_B3 SAR16_UNIT
XP_BANK1_B3_U3 BANK1P P_BANK1_B3 SAR16_UNIT
XP_BANK1_B3_U4 BANK1P P_BANK1_B3 SAR16_UNIT
XP_BANK1_B3_U5 BANK1P P_BANK1_B3 SAR16_UNIT
XP_BANK1_B3_U6 BANK1P P_BANK1_B3 SAR16_UNIT
XP_BANK1_B3_U7 BANK1P P_BANK1_B3 SAR16_UNIT
XP_BANK1_B3_U8 BANK1P P_BANK1_B3 SAR16_UNIT
XP_BANK1_B3_U9 BANK1P P_BANK1_B3 SAR16_UNIT
XP_BANK2_B0_SW HIP LOP B4 P_BANK2_B0 VPWR VGND SAR12_BITMUX
XP_BANK2_B0_U0 BANK2P P_BANK2_B0 SAR16_UNIT
XP_BANK2_B0_U1 BANK2P P_BANK2_B0 SAR16_UNIT
XP_BANK2_B1_SW HIP LOP B5 P_BANK2_B1 VPWR VGND SAR12_BITMUX
XP_BANK2_B1_U0 BANK2P P_BANK2_B1 SAR16_UNIT
XP_BANK2_B1_U1 BANK2P P_BANK2_B1 SAR16_UNIT
XP_BANK2_B1_U2 BANK2P P_BANK2_B1 SAR16_UNIT
XP_BANK2_B1_U3 BANK2P P_BANK2_B1 SAR16_UNIT
XP_BANK2_B2_SW HIP LOP B6 P_BANK2_B2 VPWR VGND SAR12_BITMUX
XP_BANK2_B2_U0 BANK2P P_BANK2_B2 SAR16_UNIT
XP_BANK2_B2_U1 BANK2P P_BANK2_B2 SAR16_UNIT
XP_BANK2_B2_U2 BANK2P P_BANK2_B2 SAR16_UNIT
XP_BANK2_B2_U3 BANK2P P_BANK2_B2 SAR16_UNIT
XP_BANK2_B2_U4 BANK2P P_BANK2_B2 SAR16_UNIT
XP_BANK2_B2_U5 BANK2P P_BANK2_B2 SAR16_UNIT
XP_BANK2_B2_U6 BANK2P P_BANK2_B2 SAR16_UNIT
XP_BANK2_B2_U7 BANK2P P_BANK2_B2 SAR16_UNIT
XP_BANK2_B3_SW HIP LOP B7 P_BANK2_B3 VPWR VGND SAR12_BITMUX
XP_BANK2_B3_U0 BANK2P P_BANK2_B3 SAR16_UNIT
XP_BANK2_B3_U1 BANK2P P_BANK2_B3 SAR16_UNIT
XP_BANK2_B3_U10 BANK2P P_BANK2_B3 SAR16_UNIT
XP_BANK2_B3_U11 BANK2P P_BANK2_B3 SAR16_UNIT
XP_BANK2_B3_U12 BANK2P P_BANK2_B3 SAR16_UNIT
XP_BANK2_B3_U13 BANK2P P_BANK2_B3 SAR16_UNIT
XP_BANK2_B3_U14 BANK2P P_BANK2_B3 SAR16_UNIT
XP_BANK2_B3_U15 BANK2P P_BANK2_B3 SAR16_UNIT
XP_BANK2_B3_U2 BANK2P P_BANK2_B3 SAR16_UNIT
XP_BANK2_B3_U3 BANK2P P_BANK2_B3 SAR16_UNIT
XP_BANK2_B3_U4 BANK2P P_BANK2_B3 SAR16_UNIT
XP_BANK2_B3_U5 BANK2P P_BANK2_B3 SAR16_UNIT
XP_BANK2_B3_U6 BANK2P P_BANK2_B3 SAR16_UNIT
XP_BANK2_B3_U7 BANK2P P_BANK2_B3 SAR16_UNIT
XP_BANK2_B3_U8 BANK2P P_BANK2_B3 SAR16_UNIT
XP_BANK2_B3_U9 BANK2P P_BANK2_B3 SAR16_UNIT
XP_BANK3_B0_SW HIP LOP B0 P_BANK3_B0 VPWR VGND SAR12_BITMUX
XP_BANK3_B0_U0 BANK3P P_BANK3_B0 SAR16_UNIT
XP_BANK3_B0_U1 BANK3P P_BANK3_B0 SAR16_UNIT
XP_BANK3_B1_SW HIP LOP B1 P_BANK3_B1 VPWR VGND SAR12_BITMUX
XP_BANK3_B1_U0 BANK3P P_BANK3_B1 SAR16_UNIT
XP_BANK3_B1_U1 BANK3P P_BANK3_B1 SAR16_UNIT
XP_BANK3_B1_U2 BANK3P P_BANK3_B1 SAR16_UNIT
XP_BANK3_B1_U3 BANK3P P_BANK3_B1 SAR16_UNIT
XP_BANK3_B2_SW HIP LOP B2 P_BANK3_B2 VPWR VGND SAR12_BITMUX
XP_BANK3_B2_U0 BANK3P P_BANK3_B2 SAR16_UNIT
XP_BANK3_B2_U1 BANK3P P_BANK3_B2 SAR16_UNIT
XP_BANK3_B2_U2 BANK3P P_BANK3_B2 SAR16_UNIT
XP_BANK3_B2_U3 BANK3P P_BANK3_B2 SAR16_UNIT
XP_BANK3_B2_U4 BANK3P P_BANK3_B2 SAR16_UNIT
XP_BANK3_B2_U5 BANK3P P_BANK3_B2 SAR16_UNIT
XP_BANK3_B2_U6 BANK3P P_BANK3_B2 SAR16_UNIT
XP_BANK3_B2_U7 BANK3P P_BANK3_B2 SAR16_UNIT
XP_BANK3_B3_SW HIP LOP B3 P_BANK3_B3 VPWR VGND SAR12_BITMUX
XP_BANK3_B3_U0 BANK3P P_BANK3_B3 SAR16_UNIT
XP_BANK3_B3_U1 BANK3P P_BANK3_B3 SAR16_UNIT
XP_BANK3_B3_U10 BANK3P P_BANK3_B3 SAR16_UNIT
XP_BANK3_B3_U11 BANK3P P_BANK3_B3 SAR16_UNIT
XP_BANK3_B3_U12 BANK3P P_BANK3_B3 SAR16_UNIT
XP_BANK3_B3_U13 BANK3P P_BANK3_B3 SAR16_UNIT
XP_BANK3_B3_U14 BANK3P P_BANK3_B3 SAR16_UNIT
XP_BANK3_B3_U15 BANK3P P_BANK3_B3 SAR16_UNIT
XP_BANK3_B3_U2 BANK3P P_BANK3_B3 SAR16_UNIT
XP_BANK3_B3_U3 BANK3P P_BANK3_B3 SAR16_UNIT
XP_BANK3_B3_U4 BANK3P P_BANK3_B3 SAR16_UNIT
XP_BANK3_B3_U5 BANK3P P_BANK3_B3 SAR16_UNIT
XP_BANK3_B3_U6 BANK3P P_BANK3_B3 SAR16_UNIT
XP_BANK3_B3_U7 BANK3P P_BANK3_B3 SAR16_UNIT
XP_BANK3_B3_U8 BANK3P P_BANK3_B3 SAR16_UNIT
XP_BANK3_B3_U9 BANK3P P_BANK3_B3 SAR16_UNIT
XP_BANK3_DUMMY_U0 BANK3P LOP SAR16_UNIT
XP_BANK3_DUMMY_U1 BANK3P LOP SAR16_UNIT
XRESET_0N VCM TOPN SAMPLE SAMPLEB VPWR VGND SAR12_TG
XRESET_0P VCM TOPP SAMPLE SAMPLEB VPWR VGND SAR12_TG
XRESET_1N VCM BANK1N SAMPLE SAMPLEB VPWR VGND SAR12_TG
XRESET_1P VCM BANK1P SAMPLE SAMPLEB VPWR VGND SAR12_TG
XRESET_2N VCM BANK2N SAMPLE SAMPLEB VPWR VGND SAR12_TG
XRESET_2P VCM BANK2P SAMPLE SAMPLEB VPWR VGND SAR12_TG
XRESET_3N VCM BANK3N SAMPLE SAMPLEB VPWR VGND SAR12_TG
XRESET_3P VCM BANK3P SAMPLE SAMPLEB VPWR VGND SAR12_TG
XSAMPLE_INV SAMPLE SAMPLEB VPWR VGND INV
.ends SAR16_CDAC
.subckt SAR12_PREAMP INP INN BIAS OUTP OUTN VPWR VGND
XINPUT0 OUTN INP TAIL VGND sky130_fd_pr__nfet_01v8 w=10 l=1 nf=1 m=1
XINPUT1 OUTP INN TAIL VGND sky130_fd_pr__nfet_01v8 w=10 l=1 nf=1 m=1
XINPUT2 OUTP INN TAIL VGND sky130_fd_pr__nfet_01v8 w=10 l=1 nf=1 m=1
XINPUT3 OUTN INP TAIL VGND sky130_fd_pr__nfet_01v8 w=10 l=1 nf=1 m=1
RLOAD_OUTN VPWR OUTN 100000
RLOAD_OUTP VPWR OUTP 100000
XTAIL TAIL BIAS VGND VGND sky130_fd_pr__nfet_01v8 w=4 l=1 nf=1 m=1
.ends SAR12_PREAMP
.subckt SAR12_LATCH INP INN EVAL OUTP OUTN VPWR VGND
XBUF0_OUTN QP OUTN_B VPWR VGND INV
XBUF0_OUTP QN OUTP_B VPWR VGND INV
XBUF1_OUTN OUTN_B OUTN VPWR VGND INV
XBUF1_OUTP OUTP_B OUTP VPWR VGND INV
XINPUT0 FN INP TAIL VGND sky130_fd_pr__nfet_01v8 w=10 l=0.5 nf=1 m=1
XINPUT1 FP INN TAIL VGND sky130_fd_pr__nfet_01v8 w=10 l=0.5 nf=1 m=1
XINPUT2 FP INN TAIL VGND sky130_fd_pr__nfet_01v8 w=10 l=0.5 nf=1 m=1
XINPUT3 FN INP TAIL VGND sky130_fd_pr__nfet_01v8 w=10 l=0.5 nf=1 m=1
XLN_QN QN QP FP VGND sky130_fd_pr__nfet_01v8 w=8 l=0.15 nf=1 m=1
XLN_QP QP QN FN VGND sky130_fd_pr__nfet_01v8 w=8 l=0.15 nf=1 m=1
XLP_QN QN QP VPWR VPWR sky130_fd_pr__pfet_01v8_hvt w=4 l=0.15 nf=1 m=1
XLP_QP QP QN VPWR VPWR sky130_fd_pr__pfet_01v8_hvt w=4 l=0.15 nf=1 m=1
XPRE_FN FN EVAL VPWR VPWR sky130_fd_pr__pfet_01v8_hvt w=2 l=0.15 nf=1 m=1
XPRE_FP FP EVAL VPWR VPWR sky130_fd_pr__pfet_01v8_hvt w=2 l=0.15 nf=1 m=1
XRESET_QN QN EVAL VPWR VPWR sky130_fd_pr__pfet_01v8_hvt w=4 l=0.15 nf=1 m=1
XRESET_QP QP EVAL VPWR VPWR sky130_fd_pr__pfet_01v8_hvt w=4 l=0.15 nf=1 m=1
XTAIL TAIL EVAL VGND VGND sky130_fd_pr__nfet_01v8 w=20 l=0.15 nf=1 m=1
.ends SAR12_LATCH
.subckt SAR12_COMPARATOR INP INN EVAL OUTP OUTN VPWR VGND
XBIAS_DIODE BIAS BIAS VGND VGND sky130_fd_pr__nfet_01v8 w=4 l=1 nf=1 m=1
RBIAS_RES VPWR BIAS 100000
XLATCH PRE1P PRE1N EVAL OUTP OUTN VPWR VGND SAR12_LATCH
CLOAD_PRE1N PRE1N VGND 5e-13
CLOAD_PRE1P PRE1P VGND 5e-13
XPRE0 INP INN BIAS PRE0P PRE0N VPWR VGND SAR12_PREAMP
XPRE1 PRE0P PRE0N BIAS PRE1P PRE1N VPWR VGND SAR12_PREAMP
.ends SAR12_COMPARATOR
.subckt sar16_analog VINP VINN VREF VCM SAMPLE EVAL TOPP TOPN COMP COMPN B0 B1 B2 B3 B4 B5 B6 B7 B8 B9 B10 B11 B12 B13 B14 B15 VPWR VGND
XCOMPARE TOPN TOPP EVAL COMP COMPN VPWR VGND SAR12_COMPARATOR
XDAC VINP VINN VREF VCM SAMPLE TOPP TOPN B0 B1 B2 B3 B4 B5 B6 B7 B8 B9 B10 B11 B12 B13 B14 B15 VPWR VGND SAR16_CDAC
.ends sar16_analog

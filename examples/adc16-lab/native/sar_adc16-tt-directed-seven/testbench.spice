Differential 16-bit SAR with actual retained charge and dynamic MOS latch
.include "/mnt/d/Coldbrew/Resistor/.runtime/adc16/native/sar_adc16-tt-directed-seven/supported-tt.spice"
.option sparse scale=1e-6 method=gear maxord=2 reltol=1e-5 vntol=1e-6 abstol=1e-12 chgtol=1e-16
.include "/mnt/d/Coldbrew/Resistor/.runtime/adc16/native/sar_adc16-tt-directed-seven/analog.spice"
.temp 27.0
VGND VGND 0 0
VDD VDD_DRV VGND 1.8
RVDD VDD_DRV VPWR 0.1
VINP VINP_DRV VGND PWL(0 0.900009155273 0.000148 0.900009155273)
R_VINP VINP_DRV VINP 50
VINN VINN_DRV VGND PWL(0 0.899990844727 0.000148 0.899990844727)
R_VINN VINN_DRV VINN 50
VREF VREF_DRV VGND 1.2
RREF VREF_DRV VREF 2
CREF VREF VGND 1n
VCM VCM_DRV VGND 1.2
RVCM VCM_DRV VCM 10
CVCM VCM VGND 100p
VD_SAMPLE DRV_SAMPLE VGND PWL(0 1.8 0.000148 1.8)
RD_SAMPLE DRV_SAMPLE SAMPLE 2000
CD_SAMPLE SAMPLE VGND 2p
VD_EVAL DRV_EVAL VGND PWL(0 0 0.000148 0)
RD_EVAL DRV_EVAL EVAL 2000
CD_EVAL EVAL VGND 2p
VD_B0 DRV_B0 VGND PWL(0 0 0.000148 0)
RD_B0 DRV_B0 B0 2000
CD_B0 B0 VGND 2p
VD_B1 DRV_B1 VGND PWL(0 0 0.000148 0)
RD_B1 DRV_B1 B1 2000
CD_B1 B1 VGND 2p
VD_B2 DRV_B2 VGND PWL(0 0 0.000148 0)
RD_B2 DRV_B2 B2 2000
CD_B2 B2 VGND 2p
VD_B3 DRV_B3 VGND PWL(0 0 0.000148 0)
RD_B3 DRV_B3 B3 2000
CD_B3 B3 VGND 2p
VD_B4 DRV_B4 VGND PWL(0 0 0.000148 0)
RD_B4 DRV_B4 B4 2000
CD_B4 B4 VGND 2p
VD_B5 DRV_B5 VGND PWL(0 0 0.000148 0)
RD_B5 DRV_B5 B5 2000
CD_B5 B5 VGND 2p
VD_B6 DRV_B6 VGND PWL(0 0 0.000148 0)
RD_B6 DRV_B6 B6 2000
CD_B6 B6 VGND 2p
VD_B7 DRV_B7 VGND PWL(0 0 0.000148 0)
RD_B7 DRV_B7 B7 2000
CD_B7 B7 VGND 2p
VD_B8 DRV_B8 VGND PWL(0 0 0.000148 0)
RD_B8 DRV_B8 B8 2000
CD_B8 B8 VGND 2p
VD_B9 DRV_B9 VGND PWL(0 0 0.000148 0)
RD_B9 DRV_B9 B9 2000
CD_B9 B9 VGND 2p
VD_B10 DRV_B10 VGND PWL(0 0 0.000148 0)
RD_B10 DRV_B10 B10 2000
CD_B10 B10 VGND 2p
VD_B11 DRV_B11 VGND PWL(0 0 0.000148 0)
RD_B11 DRV_B11 B11 2000
CD_B11 B11 VGND 2p
VD_B12 DRV_B12 VGND PWL(0 0 0.000148 0)
RD_B12 DRV_B12 B12 2000
CD_B12 B12 VGND 2p
VD_B13 DRV_B13 VGND PWL(0 0 0.000148 0)
RD_B13 DRV_B13 B13 2000
CD_B13 B13 VGND 2p
VD_B14 DRV_B14 VGND PWL(0 0 0.000148 0)
RD_B14 DRV_B14 B14 2000
CD_B14 B14 VGND 2p
VD_B15 DRV_B15 VGND PWL(0 0 0.000148 0)
RD_B15 DRV_B15 B15 2000
CD_B15 B15 VGND 2p
XU VINP VINN VREF VCM SAMPLE EVAL TOPP TOPN COMP COMPN B0 B1 B2 B3 B4 B5 B6 B7 B8 B9 B10 B11 B12 B13 B14 B15 VPWR VGND sar16_analog
.tran 1e-08 0.000148 0 1e-08
.control
set num_threads=1
set numdgt=17
set wr_singlescale
set wr_vecnames
save v(VINP) v(VINN) v(SAMPLE) v(EVAL) v(TOPP) v(TOPN) v(COMP) v(COMPN) v(B0) v(B1) v(B2) v(B3) v(B4) v(B5) v(B6) v(B7) v(B8) v(B9) v(B10) v(B11) v(B12) v(B13) v(B14) v(B15) i(VDD) i(VREF) v(VPWR)
echo frame bit trial comp compn topp topn vin decision > decisions.csv
let sar12_previous = @VINP[pwl]
let sar12_stimulus = vector(8)
let sar12_stimulus[0] = 0
let sar12_stimulus[1] = sar12_previous[length(sar12_previous)-1]
let sar12_stimulus[2] = 1e-09
let sar12_stimulus[3] = sar12_stimulus[1]
let sar12_stimulus[4] = 3e-09
let sar12_stimulus[5] = 0.900009155273
let sar12_stimulus[6] = 0.000148
let sar12_stimulus[7] = sar12_stimulus[5]
alter @VINP[pwl] = sar12_stimulus
let sar12_previous = @VINN[pwl]
let sar12_stimulus = vector(8)
let sar12_stimulus[0] = 0
let sar12_stimulus[1] = sar12_previous[length(sar12_previous)-1]
let sar12_stimulus[2] = 1e-09
let sar12_stimulus[3] = sar12_stimulus[1]
let sar12_stimulus[4] = 3e-09
let sar12_stimulus[5] = 0.899990844727
let sar12_stimulus[6] = 0.000148
let sar12_stimulus[7] = sar12_stimulus[5]
alter @VINN[pwl] = sar12_stimulus
let sar12_previous = @VD_SAMPLE[pwl]
let sar12_stimulus = vector(8)
let sar12_stimulus[0] = 0
let sar12_stimulus[1] = sar12_previous[length(sar12_previous)-1]
let sar12_stimulus[2] = 1e-09
let sar12_stimulus[3] = sar12_stimulus[1]
let sar12_stimulus[4] = 3e-09
let sar12_stimulus[5] = 1.8
let sar12_stimulus[6] = 0.000148
let sar12_stimulus[7] = sar12_stimulus[5]
alter @VD_SAMPLE[pwl] = sar12_stimulus
let sar12_previous = @VD_EVAL[pwl]
let sar12_stimulus = vector(8)
let sar12_stimulus[0] = 0
let sar12_stimulus[1] = sar12_previous[length(sar12_previous)-1]
let sar12_stimulus[2] = 1e-09
let sar12_stimulus[3] = sar12_stimulus[1]
let sar12_stimulus[4] = 3e-09
let sar12_stimulus[5] = 0
let sar12_stimulus[6] = 0.000148
let sar12_stimulus[7] = sar12_stimulus[5]
alter @VD_EVAL[pwl] = sar12_stimulus
let sar12_previous = @VD_B0[pwl]
let sar12_stimulus = vector(8)
let sar12_stimulus[0] = 0
let sar12_stimulus[1] = sar12_previous[length(sar12_previous)-1]
let sar12_stimulus[2] = 1e-09
let sar12_stimulus[3] = sar12_stimulus[1]
let sar12_stimulus[4] = 3e-09
let sar12_stimulus[5] = 0
let sar12_stimulus[6] = 0.000148
let sar12_stimulus[7] = sar12_stimulus[5]
alter @VD_B0[pwl] = sar12_stimulus
let sar12_previous = @VD_B1[pwl]
let sar12_stimulus = vector(8)
let sar12_stimulus[0] = 0
let sar12_stimulus[1] = sar12_previous[length(sar12_previous)-1]
let sar12_stimulus[2] = 1e-09
let sar12_stimulus[3] = sar12_stimulus[1]
let sar12_stimulus[4] = 3e-09
let sar12_stimulus[5] = 0
let sar12_stimulus[6] = 0.000148
let sar12_stimulus[7] = sar12_stimulus[5]
alter @VD_B1[pwl] = sar12_stimulus
let sar12_previous = @VD_B2[pwl]
let sar12_stimulus = vector(8)
let sar12_stimulus[0] = 0
let sar12_stimulus[1] = sar12_previous[length(sar12_previous)-1]
let sar12_stimulus[2] = 1e-09
let sar12_stimulus[3] = sar12_stimulus[1]
let sar12_stimulus[4] = 3e-09
let sar12_stimulus[5] = 0
let sar12_stimulus[6] = 0.000148
let sar12_stimulus[7] = sar12_stimulus[5]
alter @VD_B2[pwl] = sar12_stimulus
let sar12_previous = @VD_B3[pwl]
let sar12_stimulus = vector(8)
let sar12_stimulus[0] = 0
let sar12_stimulus[1] = sar12_previous[length(sar12_previous)-1]
let sar12_stimulus[2] = 1e-09
let sar12_stimulus[3] = sar12_stimulus[1]
let sar12_stimulus[4] = 3e-09
let sar12_stimulus[5] = 0
let sar12_stimulus[6] = 0.000148
let sar12_stimulus[7] = sar12_stimulus[5]
alter @VD_B3[pwl] = sar12_stimulus
let sar12_previous = @VD_B4[pwl]
let sar12_stimulus = vector(8)
let sar12_stimulus[0] = 0
let sar12_stimulus[1] = sar12_previous[length(sar12_previous)-1]
let sar12_stimulus[2] = 1e-09
let sar12_stimulus[3] = sar12_stimulus[1]
let sar12_stimulus[4] = 3e-09
let sar12_stimulus[5] = 0
let sar12_stimulus[6] = 0.000148
let sar12_stimulus[7] = sar12_stimulus[5]
alter @VD_B4[pwl] = sar12_stimulus
let sar12_previous = @VD_B5[pwl]
let sar12_stimulus = vector(8)
let sar12_stimulus[0] = 0
let sar12_stimulus[1] = sar12_previous[length(sar12_previous)-1]
let sar12_stimulus[2] = 1e-09
let sar12_stimulus[3] = sar12_stimulus[1]
let sar12_stimulus[4] = 3e-09
let sar12_stimulus[5] = 0
let sar12_stimulus[6] = 0.000148
let sar12_stimulus[7] = sar12_stimulus[5]
alter @VD_B5[pwl] = sar12_stimulus
let sar12_previous = @VD_B6[pwl]
let sar12_stimulus = vector(8)
let sar12_stimulus[0] = 0
let sar12_stimulus[1] = sar12_previous[length(sar12_previous)-1]
let sar12_stimulus[2] = 1e-09
let sar12_stimulus[3] = sar12_stimulus[1]
let sar12_stimulus[4] = 3e-09
let sar12_stimulus[5] = 0
let sar12_stimulus[6] = 0.000148
let sar12_stimulus[7] = sar12_stimulus[5]
alter @VD_B6[pwl] = sar12_stimulus
let sar12_previous = @VD_B7[pwl]
let sar12_stimulus = vector(8)
let sar12_stimulus[0] = 0
let sar12_stimulus[1] = sar12_previous[length(sar12_previous)-1]
let sar12_stimulus[2] = 1e-09
let sar12_stimulus[3] = sar12_stimulus[1]
let sar12_stimulus[4] = 3e-09
let sar12_stimulus[5] = 0
let sar12_stimulus[6] = 0.000148
let sar12_stimulus[7] = sar12_stimulus[5]
alter @VD_B7[pwl] = sar12_stimulus
let sar12_previous = @VD_B8[pwl]
let sar12_stimulus = vector(8)
let sar12_stimulus[0] = 0
let sar12_stimulus[1] = sar12_previous[length(sar12_previous)-1]
let sar12_stimulus[2] = 1e-09
let sar12_stimulus[3] = sar12_stimulus[1]
let sar12_stimulus[4] = 3e-09
let sar12_stimulus[5] = 0
let sar12_stimulus[6] = 0.000148
let sar12_stimulus[7] = sar12_stimulus[5]
alter @VD_B8[pwl] = sar12_stimulus
let sar12_previous = @VD_B9[pwl]
let sar12_stimulus = vector(8)
let sar12_stimulus[0] = 0
let sar12_stimulus[1] = sar12_previous[length(sar12_previous)-1]
let sar12_stimulus[2] = 1e-09
let sar12_stimulus[3] = sar12_stimulus[1]
let sar12_stimulus[4] = 3e-09
let sar12_stimulus[5] = 0
let sar12_stimulus[6] = 0.000148
let sar12_stimulus[7] = sar12_stimulus[5]
alter @VD_B9[pwl] = sar12_stimulus
let sar12_previous = @VD_B10[pwl]
let sar12_stimulus = vector(8)
let sar12_stimulus[0] = 0
let sar12_stimulus[1] = sar12_previous[length(sar12_previous)-1]
let sar12_stimulus[2] = 1e-09
let sar12_stimulus[3] = sar12_stimulus[1]
let sar12_stimulus[4] = 3e-09
let sar12_stimulus[5] = 0
let sar12_stimulus[6] = 0.000148
let sar12_stimulus[7] = sar12_stimulus[5]
alter @VD_B10[pwl] = sar12_stimulus
let sar12_previous = @VD_B11[pwl]
let sar12_stimulus = vector(8)
let sar12_stimulus[0] = 0
let sar12_stimulus[1] = sar12_previous[length(sar12_previous)-1]
let sar12_stimulus[2] = 1e-09
let sar12_stimulus[3] = sar12_stimulus[1]
let sar12_stimulus[4] = 3e-09
let sar12_stimulus[5] = 0
let sar12_stimulus[6] = 0.000148
let sar12_stimulus[7] = sar12_stimulus[5]
alter @VD_B11[pwl] = sar12_stimulus
let sar12_previous = @VD_B12[pwl]
let sar12_stimulus = vector(8)
let sar12_stimulus[0] = 0
let sar12_stimulus[1] = sar12_previous[length(sar12_previous)-1]
let sar12_stimulus[2] = 1e-09
let sar12_stimulus[3] = sar12_stimulus[1]
let sar12_stimulus[4] = 3e-09
let sar12_stimulus[5] = 0
let sar12_stimulus[6] = 0.000148
let sar12_stimulus[7] = sar12_stimulus[5]
alter @VD_B12[pwl] = sar12_stimulus
let sar12_previous = @VD_B13[pwl]
let sar12_stimulus = vector(8)
let sar12_stimulus[0] = 0
let sar12_stimulus[1] = sar12_previous[length(sar12_previous)-1]
let sar12_stimulus[2] = 1e-09
let sar12_stimulus[3] = sar12_stimulus[1]
let sar12_stimulus[4] = 3e-09
let sar12_stimulus[5] = 0
let sar12_stimulus[6] = 0.000148
let sar12_stimulus[7] = sar12_stimulus[5]
alter @VD_B13[pwl] = sar12_stimulus
let sar12_previous = @VD_B14[pwl]
let sar12_stimulus = vector(8)
let sar12_stimulus[0] = 0
let sar12_stimulus[1] = sar12_previous[length(sar12_previous)-1]
let sar12_stimulus[2] = 1e-09
let sar12_stimulus[3] = sar12_stimulus[1]
let sar12_stimulus[4] = 3e-09
let sar12_stimulus[5] = 0
let sar12_stimulus[6] = 0.000148
let sar12_stimulus[7] = sar12_stimulus[5]
alter @VD_B14[pwl] = sar12_stimulus
let sar12_previous = @VD_B15[pwl]
let sar12_stimulus = vector(8)
let sar12_stimulus[0] = 0
let sar12_stimulus[1] = sar12_previous[length(sar12_previous)-1]
let sar12_stimulus[2] = 1e-09
let sar12_stimulus[3] = sar12_stimulus[1]
let sar12_stimulus[4] = 3e-09
let sar12_stimulus[5] = 0
let sar12_stimulus[6] = 0.000148
let sar12_stimulus[7] = sar12_stimulus[5]
alter @VD_B15[pwl] = sar12_stimulus
let sar12_code = 0
stop when time = 8e-06
stop when time = 8.5e-06
stop when time = 9e-06
stop when time = 9.5e-06
stop when time = 1e-05
stop when time = 1.05e-05
stop when time = 1.1e-05
stop when time = 1.15e-05
stop when time = 1.2e-05
stop when time = 1.25e-05
stop when time = 1.3e-05
stop when time = 1.35e-05
stop when time = 1.4e-05
stop when time = 1.45e-05
stop when time = 1.5e-05
stop when time = 1.55e-05
stop when time = 1.6e-05
stop when time = 1.65e-05
stop when time = 1.7e-05
stop when time = 1.75e-05
stop when time = 1.8e-05
stop when time = 1.85e-05
stop when time = 1.9e-05
stop when time = 1.95e-05
stop when time = 2e-05
stop when time = 2.05e-05
stop when time = 2.1e-05
stop when time = 2.15e-05
stop when time = 2.2e-05
stop when time = 2.25e-05
stop when time = 2.3e-05
stop when time = 2.35e-05
stop when time = 2.4e-05
stop when time = 2.45e-05
stop when time = 3.25e-05
stop when time = 3.3e-05
stop when time = 3.35e-05
stop when time = 3.4e-05
stop when time = 3.45e-05
stop when time = 3.5e-05
stop when time = 3.55e-05
stop when time = 3.6e-05
stop when time = 3.65e-05
stop when time = 3.7e-05
stop when time = 3.75e-05
stop when time = 3.8e-05
stop when time = 3.85e-05
stop when time = 3.9e-05
stop when time = 3.95e-05
stop when time = 4e-05
stop when time = 4.05e-05
stop when time = 4.1e-05
stop when time = 4.15e-05
stop when time = 4.2e-05
stop when time = 4.24999999999999e-05
stop when time = 4.29999999999999e-05
stop when time = 4.34999999999999e-05
stop when time = 4.39999999999999e-05
stop when time = 4.44999999999999e-05
stop when time = 4.49999999999999e-05
stop when time = 4.54999999999999e-05
stop when time = 4.59999999999999e-05
stop when time = 4.64999999999999e-05
stop when time = 4.69999999999999e-05
stop when time = 4.74999999999999e-05
stop when time = 4.79999999999999e-05
stop when time = 4.84999999999999e-05
stop when time = 4.89999999999999e-05
stop when time = 5.69999999999999e-05
stop when time = 5.74999999999999e-05
stop when time = 5.79999999999999e-05
stop when time = 5.84999999999999e-05
stop when time = 5.89999999999999e-05
stop when time = 5.94999999999999e-05
stop when time = 5.99999999999999e-05
stop when time = 6.04999999999999e-05
stop when time = 6.09999999999999e-05
stop when time = 6.14999999999999e-05
stop when time = 6.19999999999999e-05
stop when time = 6.24999999999999e-05
stop when time = 6.29999999999999e-05
stop when time = 6.34999999999999e-05
stop when time = 6.39999999999999e-05
stop when time = 6.44999999999999e-05
stop when time = 6.49999999999999e-05
stop when time = 6.54999999999999e-05
stop when time = 6.59999999999999e-05
stop when time = 6.64999999999999e-05
stop when time = 6.69999999999999e-05
stop when time = 6.74999999999999e-05
stop when time = 6.79999999999999e-05
stop when time = 6.84999999999999e-05
stop when time = 6.89999999999999e-05
stop when time = 6.94999999999999e-05
stop when time = 6.99999999999999e-05
stop when time = 7.04999999999999e-05
stop when time = 7.09999999999999e-05
stop when time = 7.14999999999999e-05
stop when time = 7.19999999999999e-05
stop when time = 7.24999999999999e-05
stop when time = 7.29999999999999e-05
stop when time = 7.34999999999999e-05
stop when time = 8.14999999999999e-05
stop when time = 8.19999999999999e-05
stop when time = 8.24999999999999e-05
stop when time = 8.29999999999999e-05
stop when time = 8.34999999999999e-05
stop when time = 8.39999999999999e-05
stop when time = 8.44999999999999e-05
stop when time = 8.49999999999999e-05
stop when time = 8.54999999999999e-05
stop when time = 8.59999999999999e-05
stop when time = 8.64999999999999e-05
stop when time = 8.69999999999999e-05
stop when time = 8.74999999999999e-05
stop when time = 8.79999999999999e-05
stop when time = 8.84999999999999e-05
stop when time = 8.89999999999999e-05
stop when time = 8.94999999999999e-05
stop when time = 8.99999999999999e-05
stop when time = 9.04999999999999e-05
stop when time = 9.09999999999999e-05
stop when time = 9.14999999999999e-05
stop when time = 9.19999999999999e-05
stop when time = 9.24999999999999e-05
stop when time = 9.29999999999999e-05
stop when time = 9.34999999999999e-05
stop when time = 9.39999999999999e-05
stop when time = 9.44999999999999e-05
stop when time = 9.49999999999999e-05
stop when time = 9.54999999999999e-05
stop when time = 9.59999999999999e-05
stop when time = 9.64999999999999e-05
stop when time = 9.69999999999999e-05
stop when time = 9.74999999999998e-05
stop when time = 9.79999999999998e-05
stop when time = 0.000106
stop when time = 0.0001065
stop when time = 0.000107
stop when time = 0.0001075
stop when time = 0.000108
stop when time = 0.0001085
stop when time = 0.000109
stop when time = 0.0001095
stop when time = 0.00011
stop when time = 0.0001105
stop when time = 0.000111
stop when time = 0.0001115
stop when time = 0.000112
stop when time = 0.0001125
stop when time = 0.000113
stop when time = 0.0001135
stop when time = 0.000114
stop when time = 0.0001145
stop when time = 0.000115
stop when time = 0.0001155
stop when time = 0.000116
stop when time = 0.0001165
stop when time = 0.000117
stop when time = 0.0001175
stop when time = 0.000118
stop when time = 0.0001185
stop when time = 0.000119
stop when time = 0.0001195
stop when time = 0.00012
stop when time = 0.0001205
stop when time = 0.000121
stop when time = 0.0001215
stop when time = 0.000122
stop when time = 0.0001225
stop when time = 0.0001305
stop when time = 0.000131
stop when time = 0.0001315
stop when time = 0.000132
stop when time = 0.0001325
stop when time = 0.000133
stop when time = 0.0001335
stop when time = 0.000134
stop when time = 0.0001345
stop when time = 0.000135
stop when time = 0.0001355
stop when time = 0.000136
stop when time = 0.0001365
stop when time = 0.000137
stop when time = 0.0001375
stop when time = 0.000138
stop when time = 0.0001385
stop when time = 0.000139
stop when time = 0.0001395
stop when time = 0.00014
stop when time = 0.0001405
stop when time = 0.000141
stop when time = 0.0001415
stop when time = 0.000142
stop when time = 0.0001425
stop when time = 0.000143
stop when time = 0.0001435
stop when time = 0.000144
stop when time = 0.0001445
stop when time = 0.000145
stop when time = 0.0001455
stop when time = 0.000146
stop when time = 0.0001465
stop when time = 0.000147
echo actual_pause_time_s > pause-times.txt
run
let sar12_k = length(time)-1
if abs(time[sar12_k] - 8e-06) > 1e-12
print time[sar12_k]
echo expected_pause_time_s 8e-06
echo SAR12_PAUSE_FAILED
quit 1
end
print time[sar12_k] >> pause-times.txt
let sar12_previous = @VD_SAMPLE[pwl]
let sar12_stimulus = vector(8)
let sar12_stimulus[0] = 0
let sar12_stimulus[1] = sar12_previous[length(sar12_previous)-1]
let sar12_stimulus[2] = 8.001e-06
let sar12_stimulus[3] = sar12_stimulus[1]
let sar12_stimulus[4] = 8.003e-06
let sar12_stimulus[5] = 0
let sar12_stimulus[6] = 0.000148
let sar12_stimulus[7] = sar12_stimulus[5]
alter @VD_SAMPLE[pwl] = sar12_stimulus
resume
let sar12_k = length(time)-1
if abs(time[sar12_k] - 8.5e-06) > 1e-12
print time[sar12_k]
echo expected_pause_time_s 8.5e-06
echo SAR12_PAUSE_FAILED
quit 1
end
print time[sar12_k] >> pause-times.txt
let sar12_previous = @VD_EVAL[pwl]
let sar12_stimulus = vector(8)
let sar12_stimulus[0] = 0
let sar12_stimulus[1] = sar12_previous[length(sar12_previous)-1]
let sar12_stimulus[2] = 8.501e-06
let sar12_stimulus[3] = sar12_stimulus[1]
let sar12_stimulus[4] = 8.503e-06
let sar12_stimulus[5] = 0
let sar12_stimulus[6] = 0.000148
let sar12_stimulus[7] = sar12_stimulus[5]
alter @VD_EVAL[pwl] = sar12_stimulus
let sar12_trial = sar12_code + 32768
let sar12_drive = (floor(sar12_trial / 1) - 2*floor(sar12_trial / 2))*1.8
let sar12_previous = @VD_B0[pwl]
let sar12_stimulus = vector(8)
let sar12_stimulus[0] = 0
let sar12_stimulus[1] = sar12_previous[length(sar12_previous)-1]
let sar12_stimulus[2] = 8.501e-06
let sar12_stimulus[3] = sar12_stimulus[1]
let sar12_stimulus[4] = 8.503e-06
let sar12_stimulus[5] = sar12_drive
let sar12_stimulus[6] = 0.000148
let sar12_stimulus[7] = sar12_stimulus[5]
alter @VD_B0[pwl] = sar12_stimulus
let sar12_drive = (floor(sar12_trial / 2) - 2*floor(sar12_trial / 4))*1.8
let sar12_previous = @VD_B1[pwl]
let sar12_stimulus = vector(8)
let sar12_stimulus[0] = 0
let sar12_stimulus[1] = sar12_previous[length(sar12_previous)-1]
let sar12_stimulus[2] = 8.501e-06
let sar12_stimulus[3] = sar12_stimulus[1]
let sar12_stimulus[4] = 8.503e-06
let sar12_stimulus[5] = sar12_drive
let sar12_stimulus[6] = 0.000148
let sar12_stimulus[7] = sar12_stimulus[5]
alter @VD_B1[pwl] = sar12_stimulus
let sar12_drive = (floor(sar12_trial / 4) - 2*floor(sar12_trial / 8))*1.8
let sar12_previous = @VD_B2[pwl]
let sar12_stimulus = vector(8)
let sar12_stimulus[0] = 0
let sar12_stimulus[1] = sar12_previous[length(sar12_previous)-1]
let sar12_stimulus[2] = 8.501e-06
let sar12_stimulus[3] = sar12_stimulus[1]
let sar12_stimulus[4] = 8.503e-06
let sar12_stimulus[5] = sar12_drive
let sar12_stimulus[6] = 0.000148
let sar12_stimulus[7] = sar12_stimulus[5]
alter @VD_B2[pwl] = sar12_stimulus
let sar12_drive = (floor(sar12_trial / 8) - 2*floor(sar12_trial / 16))*1.8
let sar12_previous = @VD_B3[pwl]
let sar12_stimulus = vector(8)
let sar12_stimulus[0] = 0
let sar12_stimulus[1] = sar12_previous[length(sar12_previous)-1]
let sar12_stimulus[2] = 8.501e-06
let sar12_stimulus[3] = sar12_stimulus[1]
let sar12_stimulus[4] = 8.503e-06
let sar12_stimulus[5] = sar12_drive
let sar12_stimulus[6] = 0.000148
let sar12_stimulus[7] = sar12_stimulus[5]
alter @VD_B3[pwl] = sar12_stimulus
let sar12_drive = (floor(sar12_trial / 16) - 2*floor(sar12_trial / 32))*1.8
let sar12_previous = @VD_B4[pwl]
let sar12_stimulus = vector(8)
let sar12_stimulus[0] = 0
let sar12_stimulus[1] = sar12_previous[length(sar12_previous)-1]
let sar12_stimulus[2] = 8.501e-06
let sar12_stimulus[3] = sar12_stimulus[1]
let sar12_stimulus[4] = 8.503e-06
let sar12_stimulus[5] = sar12_drive
let sar12_stimulus[6] = 0.000148
let sar12_stimulus[7] = sar12_stimulus[5]
alter @VD_B4[pwl] = sar12_stimulus
let sar12_drive = (floor(sar12_trial / 32) - 2*floor(sar12_trial / 64))*1.8
let sar12_previous = @VD_B5[pwl]
let sar12_stimulus = vector(8)
let sar12_stimulus[0] = 0
let sar12_stimulus[1] = sar12_previous[length(sar12_previous)-1]
let sar12_stimulus[2] = 8.501e-06
let sar12_stimulus[3] = sar12_stimulus[1]
let sar12_stimulus[4] = 8.503e-06
let sar12_stimulus[5] = sar12_drive
let sar12_stimulus[6] = 0.000148
let sar12_stimulus[7] = sar12_stimulus[5]
alter @VD_B5[pwl] = sar12_stimulus
let sar12_drive = (floor(sar12_trial / 64) - 2*floor(sar12_trial / 128))*1.8
let sar12_previous = @VD_B6[pwl]
let sar12_stimulus = vector(8)
let sar12_stimulus[0] = 0
let sar12_stimulus[1] = sar12_previous[length(sar12_previous)-1]
let sar12_stimulus[2] = 8.501e-06
let sar12_stimulus[3] = sar12_stimulus[1]
let sar12_stimulus[4] = 8.503e-06
let sar12_stimulus[5] = sar12_drive
let sar12_stimulus[6] = 0.000148
let sar12_stimulus[7] = sar12_stimulus[5]
alter @VD_B6[pwl] = sar12_stimulus
let sar12_drive = (floor(sar12_trial / 128) - 2*floor(sar12_trial / 256))*1.8
let sar12_previous = @VD_B7[pwl]
let sar12_stimulus = vector(8)
let sar12_stimulus[0] = 0
let sar12_stimulus[1] = sar12_previous[length(sar12_previous)-1]
let sar12_stimulus[2] = 8.501e-06
let sar12_stimulus[3] = sar12_stimulus[1]
let sar12_stimulus[4] = 8.503e-06
let sar12_stimulus[5] = sar12_drive
let sar12_stimulus[6] = 0.000148
let sar12_stimulus[7] = sar12_stimulus[5]
alter @VD_B7[pwl] = sar12_stimulus
let sar12_drive = (floor(sar12_trial / 256) - 2*floor(sar12_trial / 512))*1.8
let sar12_previous = @VD_B8[pwl]
let sar12_stimulus = vector(8)
let sar12_stimulus[0] = 0
let sar12_stimulus[1] = sar12_previous[length(sar12_previous)-1]
let sar12_stimulus[2] = 8.501e-06
let sar12_stimulus[3] = sar12_stimulus[1]
let sar12_stimulus[4] = 8.503e-06
let sar12_stimulus[5] = sar12_drive
let sar12_stimulus[6] = 0.000148
let sar12_stimulus[7] = sar12_stimulus[5]
alter @VD_B8[pwl] = sar12_stimulus
let sar12_drive = (floor(sar12_trial / 512) - 2*floor(sar12_trial / 1024))*1.8
let sar12_previous = @VD_B9[pwl]
let sar12_stimulus = vector(8)
let sar12_stimulus[0] = 0
let sar12_stimulus[1] = sar12_previous[length(sar12_previous)-1]
let sar12_stimulus[2] = 8.501e-06
let sar12_stimulus[3] = sar12_stimulus[1]
let sar12_stimulus[4] = 8.503e-06
let sar12_stimulus[5] = sar12_drive
let sar12_stimulus[6] = 0.000148
let sar12_stimulus[7] = sar12_stimulus[5]
alter @VD_B9[pwl] = sar12_stimulus
let sar12_drive = (floor(sar12_trial / 1024) - 2*floor(sar12_trial / 2048))*1.8
let sar12_previous = @VD_B10[pwl]
let sar12_stimulus = vector(8)
let sar12_stimulus[0] = 0
let sar12_stimulus[1] = sar12_previous[length(sar12_previous)-1]
let sar12_stimulus[2] = 8.501e-06
let sar12_stimulus[3] = sar12_stimulus[1]
let sar12_stimulus[4] = 8.503e-06
let sar12_stimulus[5] = sar12_drive
let sar12_stimulus[6] = 0.000148
let sar12_stimulus[7] = sar12_stimulus[5]
alter @VD_B10[pwl] = sar12_stimulus
let sar12_drive = (floor(sar12_trial / 2048) - 2*floor(sar12_trial / 4096))*1.8
let sar12_previous = @VD_B11[pwl]
let sar12_stimulus = vector(8)
let sar12_stimulus[0] = 0
let sar12_stimulus[1] = sar12_previous[length(sar12_previous)-1]
let sar12_stimulus[2] = 8.501e-06
let sar12_stimulus[3] = sar12_stimulus[1]
let sar12_stimulus[4] = 8.503e-06
let sar12_stimulus[5] = sar12_drive
let sar12_stimulus[6] = 0.000148
let sar12_stimulus[7] = sar12_stimulus[5]
alter @VD_B11[pwl] = sar12_stimulus
let sar12_drive = (floor(sar12_trial / 4096) - 2*floor(sar12_trial / 8192))*1.8
let sar12_previous = @VD_B12[pwl]
let sar12_stimulus = vector(8)
let sar12_stimulus[0] = 0
let sar12_stimulus[1] = sar12_previous[length(sar12_previous)-1]
let sar12_stimulus[2] = 8.501e-06
let sar12_stimulus[3] = sar12_stimulus[1]
let sar12_stimulus[4] = 8.503e-06
let sar12_stimulus[5] = sar12_drive
let sar12_stimulus[6] = 0.000148
let sar12_stimulus[7] = sar12_stimulus[5]
alter @VD_B12[pwl] = sar12_stimulus
let sar12_drive = (floor(sar12_trial / 8192) - 2*floor(sar12_trial / 16384))*1.8
let sar12_previous = @VD_B13[pwl]
let sar12_stimulus = vector(8)
let sar12_stimulus[0] = 0
let sar12_stimulus[1] = sar12_previous[length(sar12_previous)-1]
let sar12_stimulus[2] = 8.501e-06
let sar12_stimulus[3] = sar12_stimulus[1]
let sar12_stimulus[4] = 8.503e-06
let sar12_stimulus[5] = sar12_drive
let sar12_stimulus[6] = 0.000148
let sar12_stimulus[7] = sar12_stimulus[5]
alter @VD_B13[pwl] = sar12_stimulus
let sar12_drive = (floor(sar12_trial / 16384) - 2*floor(sar12_trial / 32768))*1.8
let sar12_previous = @VD_B14[pwl]
let sar12_stimulus = vector(8)
let sar12_stimulus[0] = 0
let sar12_stimulus[1] = sar12_previous[length(sar12_previous)-1]
let sar12_stimulus[2] = 8.501e-06
let sar12_stimulus[3] = sar12_stimulus[1]
let sar12_stimulus[4] = 8.503e-06
let sar12_stimulus[5] = sar12_drive
let sar12_stimulus[6] = 0.000148
let sar12_stimulus[7] = sar12_stimulus[5]
alter @VD_B14[pwl] = sar12_stimulus
let sar12_drive = (floor(sar12_trial / 32768) - 2*floor(sar12_trial / 65536))*1.8
let sar12_previous = @VD_B15[pwl]
let sar12_stimulus = vector(8)
let sar12_stimulus[0] = 0
let sar12_stimulus[1] = sar12_previous[length(sar12_previous)-1]
let sar12_stimulus[2] = 8.501e-06
let sar12_stimulus[3] = sar12_stimulus[1]
let sar12_stimulus[4] = 8.503e-06
let sar12_stimulus[5] = sar12_drive
let sar12_stimulus[6] = 0.000148
let sar12_stimulus[7] = sar12_stimulus[5]
alter @VD_B15[pwl] = sar12_stimulus
resume
let sar12_k = length(time)-1
if abs(time[sar12_k] - 9e-06) > 1e-12
print time[sar12_k]
echo expected_pause_time_s 9e-06
echo SAR12_PAUSE_FAILED
quit 1
end
print time[sar12_k] >> pause-times.txt
let sar12_previous = @VD_EVAL[pwl]
let sar12_stimulus = vector(8)
let sar12_stimulus[0] = 0
let sar12_stimulus[1] = sar12_previous[length(sar12_previous)-1]
let sar12_stimulus[2] = 9.001e-06
let sar12_stimulus[3] = sar12_stimulus[1]
let sar12_stimulus[4] = 9.003e-06
let sar12_stimulus[5] = 1.8
let sar12_stimulus[6] = 0.000148
let sar12_stimulus[7] = sar12_stimulus[5]
alter @VD_EVAL[pwl] = sar12_stimulus
resume
let sar12_k = length(time)-1
if abs(time[sar12_k] - 9.5e-06) > 1e-12
print time[sar12_k]
echo expected_pause_time_s 9.5e-06
echo SAR12_PAUSE_FAILED
quit 1
end
print time[sar12_k] >> pause-times.txt
let sar12_k = length(time)-1
let sar12_cmp = v(COMP)[sar12_k]
let sar12_cmpn = v(COMPN)[sar12_k]
let sar12_p = v(TOPP)[sar12_k]
let sar12_n = v(TOPN)[sar12_k]
let sar12_decision = 0
if sar12_cmp >= 0.9
let sar12_code = sar12_trial
let sar12_decision = 1
end
echo 0 15 $&sar12_trial $&sar12_cmp $&sar12_cmpn $&sar12_p $&sar12_n 1.8310546875e-05 $&sar12_decision >> decisions.csv
let sar12_previous = @VD_EVAL[pwl]
let sar12_stimulus = vector(8)
let sar12_stimulus[0] = 0
let sar12_stimulus[1] = sar12_previous[length(sar12_previous)-1]
let sar12_stimulus[2] = 9.501e-06
let sar12_stimulus[3] = sar12_stimulus[1]
let sar12_stimulus[4] = 9.503e-06
let sar12_stimulus[5] = 0
let sar12_stimulus[6] = 0.000148
let sar12_stimulus[7] = sar12_stimulus[5]
alter @VD_EVAL[pwl] = sar12_stimulus
let sar12_trial = sar12_code + 16384
let sar12_drive = (floor(sar12_trial / 1) - 2*floor(sar12_trial / 2))*1.8
let sar12_previous = @VD_B0[pwl]
let sar12_stimulus = vector(8)
let sar12_stimulus[0] = 0
let sar12_stimulus[1] = sar12_previous[length(sar12_previous)-1]
let sar12_stimulus[2] = 9.501e-06
let sar12_stimulus[3] = sar12_stimulus[1]
let sar12_stimulus[4] = 9.503e-06
let sar12_stimulus[5] = sar12_drive
let sar12_stimulus[6] = 0.000148
let sar12_stimulus[7] = sar12_stimulus[5]
alter @VD_B0[pwl] = sar12_stimulus
let sar12_drive = (floor(sar12_trial / 2) - 2*floor(sar12_trial / 4))*1.8
let sar12_previous = @VD_B1[pwl]
let sar12_stimulus = vector(8)
let sar12_stimulus[0] = 0
let sar12_stimulus[1] = sar12_previous[length(sar12_previous)-1]
let sar12_stimulus[2] = 9.501e-06
let sar12_stimulus[3] = sar12_stimulus[1]
let sar12_stimulus[4] = 9.503e-06
let sar12_stimulus[5] = sar12_drive
let sar12_stimulus[6] = 0.000148
let sar12_stimulus[7] = sar12_stimulus[5]
alter @VD_B1[pwl] = sar12_stimulus
let sar12_drive = (floor(sar12_trial / 4) - 2*floor(sar12_trial / 8))*1.8
let sar12_previous = @VD_B2[pwl]
let sar12_stimulus = vector(8)
let sar12_stimulus[0] = 0
let sar12_stimulus[1] = sar12_previous[length(sar12_previous)-1]
let sar12_stimulus[2] = 9.501e-06
let sar12_stimulus[3] = sar12_stimulus[1]
let sar12_stimulus[4] = 9.503e-06
let sar12_stimulus[5] = sar12_drive
let sar12_stimulus[6] = 0.000148
let sar12_stimulus[7] = sar12_stimulus[5]
alter @VD_B2[pwl] = sar12_stimulus
let sar12_drive = (floor(sar12_trial / 8) - 2*floor(sar12_trial / 16))*1.8
let sar12_previous = @VD_B3[pwl]
let sar12_stimulus = vector(8)
let sar12_stimulus[0] = 0
let sar12_stimulus[1] = sar12_previous[length(sar12_previous)-1]
let sar12_stimulus[2] = 9.501e-06
let sar12_stimulus[3] = sar12_stimulus[1]
let sar12_stimulus[4] = 9.503e-06
let sar12_stimulus[5] = sar12_drive
let sar12_stimulus[6] = 0.000148
let sar12_stimulus[7] = sar12_stimulus[5]
alter @VD_B3[pwl] = sar12_stimulus
let sar12_drive = (floor(sar12_trial / 16) - 2*floor(sar12_trial / 32))*1.8
let sar12_previous = @VD_B4[pwl]
let sar12_stimulus = vector(8)
let sar12_stimulus[0] = 0
let sar12_stimulus[1] = sar12_previous[length(sar12_previous)-1]
let sar12_stimulus[2] = 9.501e-06
let sar12_stimulus[3] = sar12_stimulus[1]
let sar12_stimulus[4] = 9.503e-06
let sar12_stimulus[5] = sar12_drive
let sar12_stimulus[6] = 0.000148
let sar12_stimulus[7] = sar12_stimulus[5]
alter @VD_B4[pwl] = sar12_stimulus
let sar12_drive = (floor(sar12_trial / 32) - 2*floor(sar12_trial / 64))*1.8
let sar12_previous = @VD_B5[pwl]
let sar12_stimulus = vector(8)
let sar12_stimulus[0] = 0
let sar12_stimulus[1] = sar12_previous[length(sar12_previous)-1]
let sar12_stimulus[2] = 9.501e-06
let sar12_stimulus[3] = sar12_stimulus[1]
let sar12_stimulus[4] = 9.503e-06
let sar12_stimulus[5] = sar12_drive
let sar12_stimulus[6] = 0.000148
let sar12_stimulus[7] = sar12_stimulus[5]
alter @VD_B5[pwl] = sar12_stimulus
let sar12_drive = (floor(sar12_trial / 64) - 2*floor(sar12_trial / 128))*1.8
let sar12_previous = @VD_B6[pwl]
let sar12_stimulus = vector(8)
let sar12_stimulus[0] = 0
let sar12_stimulus[1] = sar12_previous[length(sar12_previous)-1]
let sar12_stimulus[2] = 9.501e-06
let sar12_stimulus[3] = sar12_stimulus[1]
let sar12_stimulus[4] = 9.503e-06
let sar12_stimulus[5] = sar12_drive
let sar12_stimulus[6] = 0.000148
let sar12_stimulus[7] = sar12_stimulus[5]
alter @VD_B6[pwl] = sar12_stimulus
let sar12_drive = (floor(sar12_trial / 128) - 2*floor(sar12_trial / 256))*1.8
let sar12_previous = @VD_B7[pwl]
let sar12_stimulus = vector(8)
let sar12_stimulus[0] = 0
let sar12_stimulus[1] = sar12_previous[length(sar12_previous)-1]
let sar12_stimulus[2] = 9.501e-06
let sar12_stimulus[3] = sar12_stimulus[1]
let sar12_stimulus[4] = 9.503e-06
let sar12_stimulus[5] = sar12_drive
let sar12_stimulus[6] = 0.000148
let sar12_stimulus[7] = sar12_stimulus[5]
alter @VD_B7[pwl] = sar12_stimulus
let sar12_drive = (floor(sar12_trial / 256) - 2*floor(sar12_trial / 512))*1.8
let sar12_previous = @VD_B8[pwl]
let sar12_stimulus = vector(8)
let sar12_stimulus[0] = 0
let sar12_stimulus[1] = sar12_previous[length(sar12_previous)-1]
let sar12_stimulus[2] = 9.501e-06
let sar12_stimulus[3] = sar12_stimulus[1]
let sar12_stimulus[4] = 9.503e-06
let sar12_stimulus[5] = sar12_drive
let sar12_stimulus[6] = 0.000148
let sar12_stimulus[7] = sar12_stimulus[5]
alter @VD_B8[pwl] = sar12_stimulus
let sar12_drive = (floor(sar12_trial / 512) - 2*floor(sar12_trial / 1024))*1.8
let sar12_previous = @VD_B9[pwl]
let sar12_stimulus = vector(8)
let sar12_stimulus[0] = 0
let sar12_stimulus[1] = sar12_previous[length(sar12_previous)-1]
let sar12_stimulus[2] = 9.501e-06
let sar12_stimulus[3] = sar12_stimulus[1]
let sar12_stimulus[4] = 9.503e-06
let sar12_stimulus[5] = sar12_drive
let sar12_stimulus[6] = 0.000148
let sar12_stimulus[7] = sar12_stimulus[5]
alter @VD_B9[pwl] = sar12_stimulus
let sar12_drive = (floor(sar12_trial / 1024) - 2*floor(sar12_trial / 2048))*1.8
let sar12_previous = @VD_B10[pwl]
let sar12_stimulus = vector(8)
let sar12_stimulus[0] = 0
let sar12_stimulus[1] = sar12_previous[length(sar12_previous)-1]
let sar12_stimulus[2] = 9.501e-06
let sar12_stimulus[3] = sar12_stimulus[1]
let sar12_stimulus[4] = 9.503e-06
let sar12_stimulus[5] = sar12_drive
let sar12_stimulus[6] = 0.000148
let sar12_stimulus[7] = sar12_stimulus[5]
alter @VD_B10[pwl] = sar12_stimulus
let sar12_drive = (floor(sar12_trial / 2048) - 2*floor(sar12_trial / 4096))*1.8
let sar12_previous = @VD_B11[pwl]
let sar12_stimulus = vector(8)
let sar12_stimulus[0] = 0
let sar12_stimulus[1] = sar12_previous[length(sar12_previous)-1]
let sar12_stimulus[2] = 9.501e-06
let sar12_stimulus[3] = sar12_stimulus[1]
let sar12_stimulus[4] = 9.503e-06
let sar12_stimulus[5] = sar12_drive
let sar12_stimulus[6] = 0.000148
let sar12_stimulus[7] = sar12_stimulus[5]
alter @VD_B11[pwl] = sar12_stimulus
let sar12_drive = (floor(sar12_trial / 4096) - 2*floor(sar12_trial / 8192))*1.8
let sar12_previous = @VD_B12[pwl]
let sar12_stimulus = vector(8)
let sar12_stimulus[0] = 0
let sar12_stimulus[1] = sar12_previous[length(sar12_previous)-1]
let sar12_stimulus[2] = 9.501e-06
let sar12_stimulus[3] = sar12_stimulus[1]
let sar12_stimulus[4] = 9.503e-06
let sar12_stimulus[5] = sar12_drive
let sar12_stimulus[6] = 0.000148
let sar12_stimulus[7] = sar12_stimulus[5]
alter @VD_B12[pwl] = sar12_stimulus
let sar12_drive = (floor(sar12_trial / 8192) - 2*floor(sar12_trial / 16384))*1.8
let sar12_previous = @VD_B13[pwl]
let sar12_stimulus = vector(8)
let sar12_stimulus[0] = 0
let sar12_stimulus[1] = sar12_previous[length(sar12_previous)-1]
let sar12_stimulus[2] = 9.501e-06
let sar12_stimulus[3] = sar12_stimulus[1]
let sar12_stimulus[4] = 9.503e-06
let sar12_stimulus[5] = sar12_drive
let sar12_stimulus[6] = 0.000148
let sar12_stimulus[7] = sar12_stimulus[5]
alter @VD_B13[pwl] = sar12_stimulus
let sar12_drive = (floor(sar12_trial / 16384) - 2*floor(sar12_trial / 32768))*1.8
let sar12_previous = @VD_B14[pwl]
let sar12_stimulus = vector(8)
let sar12_stimulus[0] = 0
let sar12_stimulus[1] = sar12_previous[length(sar12_previous)-1]
let sar12_stimulus[2] = 9.501e-06
let sar12_stimulus[3] = sar12_stimulus[1]
let sar12_stimulus[4] = 9.503e-06
let sar12_stimulus[5] = sar12_drive
let sar12_stimulus[6] = 0.000148
let sar12_stimulus[7] = sar12_stimulus[5]
alter @VD_B14[pwl] = sar12_stimulus
let sar12_drive = (floor(sar12_trial / 32768) - 2*floor(sar12_trial / 65536))*1.8
let sar12_previous = @VD_B15[pwl]
let sar12_stimulus = vector(8)
let sar12_stimulus[0] = 0
let sar12_stimulus[1] = sar12_previous[length(sar12_previous)-1]
let sar12_stimulus[2] = 9.501e-06
let sar12_stimulus[3] = sar12_stimulus[1]
let sar12_stimulus[4] = 9.503e-06
let sar12_stimulus[5] = sar12_drive
let sar12_stimulus[6] = 0.000148
let sar12_stimulus[7] = sar12_stimulus[5]
alter @VD_B15[pwl] = sar12_stimulus
resume
let sar12_k = length(time)-1
if abs(time[sar12_k] - 1e-05) > 1e-12
print time[sar12_k]
echo expected_pause_time_s 1e-05
echo SAR12_PAUSE_FAILED
quit 1
end
print time[sar12_k] >> pause-times.txt
let sar12_previous = @VD_EVAL[pwl]
let sar12_stimulus = vector(8)
let sar12_stimulus[0] = 0
let sar12_stimulus[1] = sar12_previous[length(sar12_previous)-1]
let sar12_stimulus[2] = 1.0001e-05
let sar12_stimulus[3] = sar12_stimulus[1]
let sar12_stimulus[4] = 1.0003e-05
let sar12_stimulus[5] = 1.8
let sar12_stimulus[6] = 0.000148
let sar12_stimulus[7] = sar12_stimulus[5]
alter @VD_EVAL[pwl] = sar12_stimulus
resume
let sar12_k = length(time)-1
if abs(time[sar12_k] - 1.05e-05) > 1e-12
print time[sar12_k]
echo expected_pause_time_s 1.05e-05
echo SAR12_PAUSE_FAILED
quit 1
end
print time[sar12_k] >> pause-times.txt
let sar12_k = length(time)-1
let sar12_cmp = v(COMP)[sar12_k]
let sar12_cmpn = v(COMPN)[sar12_k]
let sar12_p = v(TOPP)[sar12_k]
let sar12_n = v(TOPN)[sar12_k]
let sar12_decision = 0
if sar12_cmp >= 0.9
let sar12_code = sar12_trial
let sar12_decision = 1
end
echo 0 14 $&sar12_trial $&sar12_cmp $&sar12_cmpn $&sar12_p $&sar12_n 1.8310546875e-05 $&sar12_decision >> decisions.csv
let sar12_previous = @VD_EVAL[pwl]
let sar12_stimulus = vector(8)
let sar12_stimulus[0] = 0
let sar12_stimulus[1] = sar12_previous[length(sar12_previous)-1]
let sar12_stimulus[2] = 1.0501e-05
let sar12_stimulus[3] = sar12_stimulus[1]
let sar12_stimulus[4] = 1.0503e-05
let sar12_stimulus[5] = 0
let sar12_stimulus[6] = 0.000148
let sar12_stimulus[7] = sar12_stimulus[5]
alter @VD_EVAL[pwl] = sar12_stimulus
let sar12_trial = sar12_code + 8192
let sar12_drive = (floor(sar12_trial / 1) - 2*floor(sar12_trial / 2))*1.8
let sar12_previous = @VD_B0[pwl]
let sar12_stimulus = vector(8)
let sar12_stimulus[0] = 0
let sar12_stimulus[1] = sar12_previous[length(sar12_previous)-1]
let sar12_stimulus[2] = 1.0501e-05
let sar12_stimulus[3] = sar12_stimulus[1]
let sar12_stimulus[4] = 1.0503e-05
let sar12_stimulus[5] = sar12_drive
let sar12_stimulus[6] = 0.000148
let sar12_stimulus[7] = sar12_stimulus[5]
alter @VD_B0[pwl] = sar12_stimulus
let sar12_drive = (floor(sar12_trial / 2) - 2*floor(sar12_trial / 4))*1.8
let sar12_previous = @VD_B1[pwl]
let sar12_stimulus = vector(8)
let sar12_stimulus[0] = 0
let sar12_stimulus[1] = sar12_previous[length(sar12_previous)-1]
let sar12_stimulus[2] = 1.0501e-05
let sar12_stimulus[3] = sar12_stimulus[1]
let sar12_stimulus[4] = 1.0503e-05
let sar12_stimulus[5] = sar12_drive
let sar12_stimulus[6] = 0.000148
let sar12_stimulus[7] = sar12_stimulus[5]
alter @VD_B1[pwl] = sar12_stimulus
let sar12_drive = (floor(sar12_trial / 4) - 2*floor(sar12_trial / 8))*1.8
let sar12_previous = @VD_B2[pwl]
let sar12_stimulus = vector(8)
let sar12_stimulus[0] = 0
let sar12_stimulus[1] = sar12_previous[length(sar12_previous)-1]
let sar12_stimulus[2] = 1.0501e-05
let sar12_stimulus[3] = sar12_stimulus[1]
let sar12_stimulus[4] = 1.0503e-05
let sar12_stimulus[5] = sar12_drive
let sar12_stimulus[6] = 0.000148
let sar12_stimulus[7] = sar12_stimulus[5]
alter @VD_B2[pwl] = sar12_stimulus
let sar12_drive = (floor(sar12_trial / 8) - 2*floor(sar12_trial / 16))*1.8
let sar12_previous = @VD_B3[pwl]
let sar12_stimulus = vector(8)
let sar12_stimulus[0] = 0
let sar12_stimulus[1] = sar12_previous[length(sar12_previous)-1]
let sar12_stimulus[2] = 1.0501e-05
let sar12_stimulus[3] = sar12_stimulus[1]
let sar12_stimulus[4] = 1.0503e-05
let sar12_stimulus[5] = sar12_drive
let sar12_stimulus[6] = 0.000148
let sar12_stimulus[7] = sar12_stimulus[5]
alter @VD_B3[pwl] = sar12_stimulus
let sar12_drive = (floor(sar12_trial / 16) - 2*floor(sar12_trial / 32))*1.8
let sar12_previous = @VD_B4[pwl]
let sar12_stimulus = vector(8)
let sar12_stimulus[0] = 0
let sar12_stimulus[1] = sar12_previous[length(sar12_previous)-1]
let sar12_stimulus[2] = 1.0501e-05
let sar12_stimulus[3] = sar12_stimulus[1]
let sar12_stimulus[4] = 1.0503e-05
let sar12_stimulus[5] = sar12_drive
let sar12_stimulus[6] = 0.000148
let sar12_stimulus[7] = sar12_stimulus[5]
alter @VD_B4[pwl] = sar12_stimulus
let sar12_drive = (floor(sar12_trial / 32) - 2*floor(sar12_trial / 64))*1.8
let sar12_previous = @VD_B5[pwl]
let sar12_stimulus = vector(8)
let sar12_stimulus[0] = 0
let sar12_stimulus[1] = sar12_previous[length(sar12_previous)-1]
let sar12_stimulus[2] = 1.0501e-05
let sar12_stimulus[3] = sar12_stimulus[1]
let sar12_stimulus[4] = 1.0503e-05
let sar12_stimulus[5] = sar12_drive
let sar12_stimulus[6] = 0.000148
let sar12_stimulus[7] = sar12_stimulus[5]
alter @VD_B5[pwl] = sar12_stimulus
let sar12_drive = (floor(sar12_trial / 64) - 2*floor(sar12_trial / 128))*1.8
let sar12_previous = @VD_B6[pwl]
let sar12_stimulus = vector(8)
let sar12_stimulus[0] = 0
let sar12_stimulus[1] = sar12_previous[length(sar12_previous)-1]
let sar12_stimulus[2] = 1.0501e-05
let sar12_stimulus[3] = sar12_stimulus[1]
let sar12_stimulus[4] = 1.0503e-05
let sar12_stimulus[5] = sar12_drive
let sar12_stimulus[6] = 0.000148
let sar12_stimulus[7] = sar12_stimulus[5]
alter @VD_B6[pwl] = sar12_stimulus
let sar12_drive = (floor(sar12_trial / 128) - 2*floor(sar12_trial / 256))*1.8
let sar12_previous = @VD_B7[pwl]
let sar12_stimulus = vector(8)
let sar12_stimulus[0] = 0
let sar12_stimulus[1] = sar12_previous[length(sar12_previous)-1]
let sar12_stimulus[2] = 1.0501e-05
let sar12_stimulus[3] = sar12_stimulus[1]
let sar12_stimulus[4] = 1.0503e-05
let sar12_stimulus[5] = sar12_drive
let sar12_stimulus[6] = 0.000148
let sar12_stimulus[7] = sar12_stimulus[5]
alter @VD_B7[pwl] = sar12_stimulus
let sar12_drive = (floor(sar12_trial / 256) - 2*floor(sar12_trial / 512))*1.8
let sar12_previous = @VD_B8[pwl]
let sar12_stimulus = vector(8)
let sar12_stimulus[0] = 0
let sar12_stimulus[1] = sar12_previous[length(sar12_previous)-1]
let sar12_stimulus[2] = 1.0501e-05
let sar12_stimulus[3] = sar12_stimulus[1]
let sar12_stimulus[4] = 1.0503e-05
let sar12_stimulus[5] = sar12_drive
let sar12_stimulus[6] = 0.000148
let sar12_stimulus[7] = sar12_stimulus[5]
alter @VD_B8[pwl] = sar12_stimulus
let sar12_drive = (floor(sar12_trial / 512) - 2*floor(sar12_trial / 1024))*1.8
let sar12_previous = @VD_B9[pwl]
let sar12_stimulus = vector(8)
let sar12_stimulus[0] = 0
let sar12_stimulus[1] = sar12_previous[length(sar12_previous)-1]
let sar12_stimulus[2] = 1.0501e-05
let sar12_stimulus[3] = sar12_stimulus[1]
let sar12_stimulus[4] = 1.0503e-05
let sar12_stimulus[5] = sar12_drive
let sar12_stimulus[6] = 0.000148
let sar12_stimulus[7] = sar12_stimulus[5]
alter @VD_B9[pwl] = sar12_stimulus
let sar12_drive = (floor(sar12_trial / 1024) - 2*floor(sar12_trial / 2048))*1.8
let sar12_previous = @VD_B10[pwl]
let sar12_stimulus = vector(8)
let sar12_stimulus[0] = 0
let sar12_stimulus[1] = sar12_previous[length(sar12_previous)-1]
let sar12_stimulus[2] = 1.0501e-05
let sar12_stimulus[3] = sar12_stimulus[1]
let sar12_stimulus[4] = 1.0503e-05
let sar12_stimulus[5] = sar12_drive
let sar12_stimulus[6] = 0.000148
let sar12_stimulus[7] = sar12_stimulus[5]
alter @VD_B10[pwl] = sar12_stimulus
let sar12_drive = (floor(sar12_trial / 2048) - 2*floor(sar12_trial / 4096))*1.8
let sar12_previous = @VD_B11[pwl]
let sar12_stimulus = vector(8)
let sar12_stimulus[0] = 0
let sar12_stimulus[1] = sar12_previous[length(sar12_previous)-1]
let sar12_stimulus[2] = 1.0501e-05
let sar12_stimulus[3] = sar12_stimulus[1]
let sar12_stimulus[4] = 1.0503e-05
let sar12_stimulus[5] = sar12_drive
let sar12_stimulus[6] = 0.000148
let sar12_stimulus[7] = sar12_stimulus[5]
alter @VD_B11[pwl] = sar12_stimulus
let sar12_drive = (floor(sar12_trial / 4096) - 2*floor(sar12_trial / 8192))*1.8
let sar12_previous = @VD_B12[pwl]
let sar12_stimulus = vector(8)
let sar12_stimulus[0] = 0
let sar12_stimulus[1] = sar12_previous[length(sar12_previous)-1]
let sar12_stimulus[2] = 1.0501e-05
let sar12_stimulus[3] = sar12_stimulus[1]
let sar12_stimulus[4] = 1.0503e-05
let sar12_stimulus[5] = sar12_drive
let sar12_stimulus[6] = 0.000148
let sar12_stimulus[7] = sar12_stimulus[5]
alter @VD_B12[pwl] = sar12_stimulus
let sar12_drive = (floor(sar12_trial / 8192) - 2*floor(sar12_trial / 16384))*1.8
let sar12_previous = @VD_B13[pwl]
let sar12_stimulus = vector(8)
let sar12_stimulus[0] = 0
let sar12_stimulus[1] = sar12_previous[length(sar12_previous)-1]
let sar12_stimulus[2] = 1.0501e-05
let sar12_stimulus[3] = sar12_stimulus[1]
let sar12_stimulus[4] = 1.0503e-05
let sar12_stimulus[5] = sar12_drive
let sar12_stimulus[6] = 0.000148
let sar12_stimulus[7] = sar12_stimulus[5]
alter @VD_B13[pwl] = sar12_stimulus
let sar12_drive = (floor(sar12_trial / 16384) - 2*floor(sar12_trial / 32768))*1.8
let sar12_previous = @VD_B14[pwl]
let sar12_stimulus = vector(8)
let sar12_stimulus[0] = 0
let sar12_stimulus[1] = sar12_previous[length(sar12_previous)-1]
let sar12_stimulus[2] = 1.0501e-05
let sar12_stimulus[3] = sar12_stimulus[1]
let sar12_stimulus[4] = 1.0503e-05
let sar12_stimulus[5] = sar12_drive
let sar12_stimulus[6] = 0.000148
let sar12_stimulus[7] = sar12_stimulus[5]
alter @VD_B14[pwl] = sar12_stimulus
let sar12_drive = (floor(sar12_trial / 32768) - 2*floor(sar12_trial / 65536))*1.8
let sar12_previous = @VD_B15[pwl]
let sar12_stimulus = vector(8)
let sar12_stimulus[0] = 0
let sar12_stimulus[1] = sar12_previous[length(sar12_previous)-1]
let sar12_stimulus[2] = 1.0501e-05
let sar12_stimulus[3] = sar12_stimulus[1]
let sar12_stimulus[4] = 1.0503e-05
let sar12_stimulus[5] = sar12_drive
let sar12_stimulus[6] = 0.000148
let sar12_stimulus[7] = sar12_stimulus[5]
alter @VD_B15[pwl] = sar12_stimulus
resume
let sar12_k = length(time)-1
if abs(time[sar12_k] - 1.1e-05) > 1e-12
print time[sar12_k]
echo expected_pause_time_s 1.1e-05
echo SAR12_PAUSE_FAILED
quit 1
end
print time[sar12_k] >> pause-times.txt
let sar12_previous = @VD_EVAL[pwl]
let sar12_stimulus = vector(8)
let sar12_stimulus[0] = 0
let sar12_stimulus[1] = sar12_previous[length(sar12_previous)-1]
let sar12_stimulus[2] = 1.1001e-05
let sar12_stimulus[3] = sar12_stimulus[1]
let sar12_stimulus[4] = 1.1003e-05
let sar12_stimulus[5] = 1.8
let sar12_stimulus[6] = 0.000148
let sar12_stimulus[7] = sar12_stimulus[5]
alter @VD_EVAL[pwl] = sar12_stimulus
resume
let sar12_k = length(time)-1
if abs(time[sar12_k] - 1.15e-05) > 1e-12
print time[sar12_k]
echo expected_pause_time_s 1.15e-05
echo SAR12_PAUSE_FAILED
quit 1
end
print time[sar12_k] >> pause-times.txt
let sar12_k = length(time)-1
let sar12_cmp = v(COMP)[sar12_k]
let sar12_cmpn = v(COMPN)[sar12_k]
let sar12_p = v(TOPP)[sar12_k]
let sar12_n = v(TOPN)[sar12_k]
let sar12_decision = 0
if sar12_cmp >= 0.9
let sar12_code = sar12_trial
let sar12_decision = 1
end
echo 0 13 $&sar12_trial $&sar12_cmp $&sar12_cmpn $&sar12_p $&sar12_n 1.8310546875e-05 $&sar12_decision >> decisions.csv
let sar12_previous = @VD_EVAL[pwl]
let sar12_stimulus = vector(8)
let sar12_stimulus[0] = 0
let sar12_stimulus[1] = sar12_previous[length(sar12_previous)-1]
let sar12_stimulus[2] = 1.1501e-05
let sar12_stimulus[3] = sar12_stimulus[1]
let sar12_stimulus[4] = 1.1503e-05
let sar12_stimulus[5] = 0
let sar12_stimulus[6] = 0.000148
let sar12_stimulus[7] = sar12_stimulus[5]
alter @VD_EVAL[pwl] = sar12_stimulus
let sar12_trial = sar12_code + 4096
let sar12_drive = (floor(sar12_trial / 1) - 2*floor(sar12_trial / 2))*1.8
let sar12_previous = @VD_B0[pwl]
let sar12_stimulus = vector(8)
let sar12_stimulus[0] = 0
let sar12_stimulus[1] = sar12_previous[length(sar12_previous)-1]
let sar12_stimulus[2] = 1.1501e-05
let sar12_stimulus[3] = sar12_stimulus[1]
let sar12_stimulus[4] = 1.1503e-05
let sar12_stimulus[5] = sar12_drive
let sar12_stimulus[6] = 0.000148
let sar12_stimulus[7] = sar12_stimulus[5]
alter @VD_B0[pwl] = sar12_stimulus
let sar12_drive = (floor(sar12_trial / 2) - 2*floor(sar12_trial / 4))*1.8
let sar12_previous = @VD_B1[pwl]
let sar12_stimulus = vector(8)
let sar12_stimulus[0] = 0
let sar12_stimulus[1] = sar12_previous[length(sar12_previous)-1]
let sar12_stimulus[2] = 1.1501e-05
let sar12_stimulus[3] = sar12_stimulus[1]
let sar12_stimulus[4] = 1.1503e-05
let sar12_stimulus[5] = sar12_drive
let sar12_stimulus[6] = 0.000148
let sar12_stimulus[7] = sar12_stimulus[5]
alter @VD_B1[pwl] = sar12_stimulus
let sar12_drive = (floor(sar12_trial / 4) - 2*floor(sar12_trial / 8))*1.8
let sar12_previous = @VD_B2[pwl]
let sar12_stimulus = vector(8)
let sar12_stimulus[0] = 0
let sar12_stimulus[1] = sar12_previous[length(sar12_previous)-1]
let sar12_stimulus[2] = 1.1501e-05
let sar12_stimulus[3] = sar12_stimulus[1]
let sar12_stimulus[4] = 1.1503e-05
let sar12_stimulus[5] = sar12_drive
let sar12_stimulus[6] = 0.000148
let sar12_stimulus[7] = sar12_stimulus[5]
alter @VD_B2[pwl] = sar12_stimulus
let sar12_drive = (floor(sar12_trial / 8) - 2*floor(sar12_trial / 16))*1.8
let sar12_previous = @VD_B3[pwl]
let sar12_stimulus = vector(8)
let sar12_stimulus[0] = 0
let sar12_stimulus[1] = sar12_previous[length(sar12_previous)-1]
let sar12_stimulus[2] = 1.1501e-05
let sar12_stimulus[3] = sar12_stimulus[1]
let sar12_stimulus[4] = 1.1503e-05
let sar12_stimulus[5] = sar12_drive
let sar12_stimulus[6] = 0.000148
let sar12_stimulus[7] = sar12_stimulus[5]
alter @VD_B3[pwl] = sar12_stimulus
let sar12_drive = (floor(sar12_trial / 16) - 2*floor(sar12_trial / 32))*1.8
let sar12_previous = @VD_B4[pwl]
let sar12_stimulus = vector(8)
let sar12_stimulus[0] = 0
let sar12_stimulus[1] = sar12_previous[length(sar12_previous)-1]
let sar12_stimulus[2] = 1.1501e-05
let sar12_stimulus[3] = sar12_stimulus[1]
let sar12_stimulus[4] = 1.1503e-05
let sar12_stimulus[5] = sar12_drive
let sar12_stimulus[6] = 0.000148
let sar12_stimulus[7] = sar12_stimulus[5]
alter @VD_B4[pwl] = sar12_stimulus
let sar12_drive = (floor(sar12_trial / 32) - 2*floor(sar12_trial / 64))*1.8
let sar12_previous = @VD_B5[pwl]
let sar12_stimulus = vector(8)
let sar12_stimulus[0] = 0
let sar12_stimulus[1] = sar12_previous[length(sar12_previous)-1]
let sar12_stimulus[2] = 1.1501e-05
let sar12_stimulus[3] = sar12_stimulus[1]
let sar12_stimulus[4] = 1.1503e-05
let sar12_stimulus[5] = sar12_drive
let sar12_stimulus[6] = 0.000148
let sar12_stimulus[7] = sar12_stimulus[5]
alter @VD_B5[pwl] = sar12_stimulus
let sar12_drive = (floor(sar12_trial / 64) - 2*floor(sar12_trial / 128))*1.8
let sar12_previous = @VD_B6[pwl]
let sar12_stimulus = vector(8)
let sar12_stimulus[0] = 0
let sar12_stimulus[1] = sar12_previous[length(sar12_previous)-1]
let sar12_stimulus[2] = 1.1501e-05
let sar12_stimulus[3] = sar12_stimulus[1]
let sar12_stimulus[4] = 1.1503e-05
let sar12_stimulus[5] = sar12_drive
let sar12_stimulus[6] = 0.000148
let sar12_stimulus[7] = sar12_stimulus[5]
alter @VD_B6[pwl] = sar12_stimulus
let sar12_drive = (floor(sar12_trial / 128) - 2*floor(sar12_trial / 256))*1.8
let sar12_previous = @VD_B7[pwl]
let sar12_stimulus = vector(8)
let sar12_stimulus[0] = 0
let sar12_stimulus[1] = sar12_previous[length(sar12_previous)-1]
let sar12_stimulus[2] = 1.1501e-05
let sar12_stimulus[3] = sar12_stimulus[1]
let sar12_stimulus[4] = 1.1503e-05
let sar12_stimulus[5] = sar12_drive
let sar12_stimulus[6] = 0.000148
let sar12_stimulus[7] = sar12_stimulus[5]
alter @VD_B7[pwl] = sar12_stimulus
let sar12_drive = (floor(sar12_trial / 256) - 2*floor(sar12_trial / 512))*1.8
let sar12_previous = @VD_B8[pwl]
let sar12_stimulus = vector(8)
let sar12_stimulus[0] = 0
let sar12_stimulus[1] = sar12_previous[length(sar12_previous)-1]
let sar12_stimulus[2] = 1.1501e-05
let sar12_stimulus[3] = sar12_stimulus[1]
let sar12_stimulus[4] = 1.1503e-05
let sar12_stimulus[5] = sar12_drive
let sar12_stimulus[6] = 0.000148
let sar12_stimulus[7] = sar12_stimulus[5]
alter @VD_B8[pwl] = sar12_stimulus
let sar12_drive = (floor(sar12_trial / 512) - 2*floor(sar12_trial / 1024))*1.8
let sar12_previous = @VD_B9[pwl]
let sar12_stimulus = vector(8)
let sar12_stimulus[0] = 0
let sar12_stimulus[1] = sar12_previous[length(sar12_previous)-1]
let sar12_stimulus[2] = 1.1501e-05
let sar12_stimulus[3] = sar12_stimulus[1]
let sar12_stimulus[4] = 1.1503e-05
let sar12_stimulus[5] = sar12_drive
let sar12_stimulus[6] = 0.000148
let sar12_stimulus[7] = sar12_stimulus[5]
alter @VD_B9[pwl] = sar12_stimulus
let sar12_drive = (floor(sar12_trial / 1024) - 2*floor(sar12_trial / 2048))*1.8
let sar12_previous = @VD_B10[pwl]
let sar12_stimulus = vector(8)
let sar12_stimulus[0] = 0
let sar12_stimulus[1] = sar12_previous[length(sar12_previous)-1]
let sar12_stimulus[2] = 1.1501e-05
let sar12_stimulus[3] = sar12_stimulus[1]
let sar12_stimulus[4] = 1.1503e-05
let sar12_stimulus[5] = sar12_drive
let sar12_stimulus[6] = 0.000148
let sar12_stimulus[7] = sar12_stimulus[5]
alter @VD_B10[pwl] = sar12_stimulus
let sar12_drive = (floor(sar12_trial / 2048) - 2*floor(sar12_trial / 4096))*1.8
let sar12_previous = @VD_B11[pwl]
let sar12_stimulus = vector(8)
let sar12_stimulus[0] = 0
let sar12_stimulus[1] = sar12_previous[length(sar12_previous)-1]
let sar12_stimulus[2] = 1.1501e-05
let sar12_stimulus[3] = sar12_stimulus[1]
let sar12_stimulus[4] = 1.1503e-05
let sar12_stimulus[5] = sar12_drive
let sar12_stimulus[6] = 0.000148
let sar12_stimulus[7] = sar12_stimulus[5]
alter @VD_B11[pwl] = sar12_stimulus
let sar12_drive = (floor(sar12_trial / 4096) - 2*floor(sar12_trial / 8192))*1.8
let sar12_previous = @VD_B12[pwl]
let sar12_stimulus = vector(8)
let sar12_stimulus[0] = 0
let sar12_stimulus[1] = sar12_previous[length(sar12_previous)-1]
let sar12_stimulus[2] = 1.1501e-05
let sar12_stimulus[3] = sar12_stimulus[1]
let sar12_stimulus[4] = 1.1503e-05
let sar12_stimulus[5] = sar12_drive
let sar12_stimulus[6] = 0.000148
let sar12_stimulus[7] = sar12_stimulus[5]
alter @VD_B12[pwl] = sar12_stimulus
let sar12_drive = (floor(sar12_trial / 8192) - 2*floor(sar12_trial / 16384))*1.8
let sar12_previous = @VD_B13[pwl]
let sar12_stimulus = vector(8)
let sar12_stimulus[0] = 0
let sar12_stimulus[1] = sar12_previous[length(sar12_previous)-1]
let sar12_stimulus[2] = 1.1501e-05
let sar12_stimulus[3] = sar12_stimulus[1]
let sar12_stimulus[4] = 1.1503e-05
let sar12_stimulus[5] = sar12_drive
let sar12_stimulus[6] = 0.000148
let sar12_stimulus[7] = sar12_stimulus[5]
alter @VD_B13[pwl] = sar12_stimulus
let sar12_drive = (floor(sar12_trial / 16384) - 2*floor(sar12_trial / 32768))*1.8
let sar12_previous = @VD_B14[pwl]
let sar12_stimulus = vector(8)
let sar12_stimulus[0] = 0
let sar12_stimulus[1] = sar12_previous[length(sar12_previous)-1]
let sar12_stimulus[2] = 1.1501e-05
let sar12_stimulus[3] = sar12_stimulus[1]
let sar12_stimulus[4] = 1.1503e-05
let sar12_stimulus[5] = sar12_drive
let sar12_stimulus[6] = 0.000148
let sar12_stimulus[7] = sar12_stimulus[5]
alter @VD_B14[pwl] = sar12_stimulus
let sar12_drive = (floor(sar12_trial / 32768) - 2*floor(sar12_trial / 65536))*1.8
let sar12_previous = @VD_B15[pwl]
let sar12_stimulus = vector(8)
let sar12_stimulus[0] = 0
let sar12_stimulus[1] = sar12_previous[length(sar12_previous)-1]
let sar12_stimulus[2] = 1.1501e-05
let sar12_stimulus[3] = sar12_stimulus[1]
let sar12_stimulus[4] = 1.1503e-05
let sar12_stimulus[5] = sar12_drive
let sar12_stimulus[6] = 0.000148
let sar12_stimulus[7] = sar12_stimulus[5]
alter @VD_B15[pwl] = sar12_stimulus
resume
let sar12_k = length(time)-1
if abs(time[sar12_k] - 1.2e-05) > 1e-12
print time[sar12_k]
echo expected_pause_time_s 1.2e-05
echo SAR12_PAUSE_FAILED
quit 1
end
print time[sar12_k] >> pause-times.txt
let sar12_previous = @VD_EVAL[pwl]
let sar12_stimulus = vector(8)
let sar12_stimulus[0] = 0
let sar12_stimulus[1] = sar12_previous[length(sar12_previous)-1]
let sar12_stimulus[2] = 1.2001e-05
let sar12_stimulus[3] = sar12_stimulus[1]
let sar12_stimulus[4] = 1.2003e-05
let sar12_stimulus[5] = 1.8
let sar12_stimulus[6] = 0.000148
let sar12_stimulus[7] = sar12_stimulus[5]
alter @VD_EVAL[pwl] = sar12_stimulus
resume
let sar12_k = length(time)-1
if abs(time[sar12_k] - 1.25e-05) > 1e-12
print time[sar12_k]
echo expected_pause_time_s 1.25e-05
echo SAR12_PAUSE_FAILED
quit 1
end
print time[sar12_k] >> pause-times.txt
let sar12_k = length(time)-1
let sar12_cmp = v(COMP)[sar12_k]
let sar12_cmpn = v(COMPN)[sar12_k]
let sar12_p = v(TOPP)[sar12_k]
let sar12_n = v(TOPN)[sar12_k]
let sar12_decision = 0
if sar12_cmp >= 0.9
let sar12_code = sar12_trial
let sar12_decision = 1
end
echo 0 12 $&sar12_trial $&sar12_cmp $&sar12_cmpn $&sar12_p $&sar12_n 1.8310546875e-05 $&sar12_decision >> decisions.csv
let sar12_previous = @VD_EVAL[pwl]
let sar12_stimulus = vector(8)
let sar12_stimulus[0] = 0
let sar12_stimulus[1] = sar12_previous[length(sar12_previous)-1]
let sar12_stimulus[2] = 1.2501e-05
let sar12_stimulus[3] = sar12_stimulus[1]
let sar12_stimulus[4] = 1.2503e-05
let sar12_stimulus[5] = 0
let sar12_stimulus[6] = 0.000148
let sar12_stimulus[7] = sar12_stimulus[5]
alter @VD_EVAL[pwl] = sar12_stimulus
let sar12_trial = sar12_code + 2048
let sar12_drive = (floor(sar12_trial / 1) - 2*floor(sar12_trial / 2))*1.8
let sar12_previous = @VD_B0[pwl]
let sar12_stimulus = vector(8)
let sar12_stimulus[0] = 0
let sar12_stimulus[1] = sar12_previous[length(sar12_previous)-1]
let sar12_stimulus[2] = 1.2501e-05
let sar12_stimulus[3] = sar12_stimulus[1]
let sar12_stimulus[4] = 1.2503e-05
let sar12_stimulus[5] = sar12_drive
let sar12_stimulus[6] = 0.000148
let sar12_stimulus[7] = sar12_stimulus[5]
alter @VD_B0[pwl] = sar12_stimulus
let sar12_drive = (floor(sar12_trial / 2) - 2*floor(sar12_trial / 4))*1.8
let sar12_previous = @VD_B1[pwl]
let sar12_stimulus = vector(8)
let sar12_stimulus[0] = 0
let sar12_stimulus[1] = sar12_previous[length(sar12_previous)-1]
let sar12_stimulus[2] = 1.2501e-05
let sar12_stimulus[3] = sar12_stimulus[1]
let sar12_stimulus[4] = 1.2503e-05
let sar12_stimulus[5] = sar12_drive
let sar12_stimulus[6] = 0.000148
let sar12_stimulus[7] = sar12_stimulus[5]
alter @VD_B1[pwl] = sar12_stimulus
let sar12_drive = (floor(sar12_trial / 4) - 2*floor(sar12_trial / 8))*1.8
let sar12_previous = @VD_B2[pwl]
let sar12_stimulus = vector(8)
let sar12_stimulus[0] = 0
let sar12_stimulus[1] = sar12_previous[length(sar12_previous)-1]
let sar12_stimulus[2] = 1.2501e-05
let sar12_stimulus[3] = sar12_stimulus[1]
let sar12_stimulus[4] = 1.2503e-05
let sar12_stimulus[5] = sar12_drive
let sar12_stimulus[6] = 0.000148
let sar12_stimulus[7] = sar12_stimulus[5]
alter @VD_B2[pwl] = sar12_stimulus
let sar12_drive = (floor(sar12_trial / 8) - 2*floor(sar12_trial / 16))*1.8
let sar12_previous = @VD_B3[pwl]
let sar12_stimulus = vector(8)
let sar12_stimulus[0] = 0
let sar12_stimulus[1] = sar12_previous[length(sar12_previous)-1]
let sar12_stimulus[2] = 1.2501e-05
let sar12_stimulus[3] = sar12_stimulus[1]
let sar12_stimulus[4] = 1.2503e-05
let sar12_stimulus[5] = sar12_drive
let sar12_stimulus[6] = 0.000148
let sar12_stimulus[7] = sar12_stimulus[5]
alter @VD_B3[pwl] = sar12_stimulus
let sar12_drive = (floor(sar12_trial / 16) - 2*floor(sar12_trial / 32))*1.8
let sar12_previous = @VD_B4[pwl]
let sar12_stimulus = vector(8)
let sar12_stimulus[0] = 0
let sar12_stimulus[1] = sar12_previous[length(sar12_previous)-1]
let sar12_stimulus[2] = 1.2501e-05
let sar12_stimulus[3] = sar12_stimulus[1]
let sar12_stimulus[4] = 1.2503e-05
let sar12_stimulus[5] = sar12_drive
let sar12_stimulus[6] = 0.000148
let sar12_stimulus[7] = sar12_stimulus[5]
alter @VD_B4[pwl] = sar12_stimulus
let sar12_drive = (floor(sar12_trial / 32) - 2*floor(sar12_trial / 64))*1.8
let sar12_previous = @VD_B5[pwl]
let sar12_stimulus = vector(8)
let sar12_stimulus[0] = 0
let sar12_stimulus[1] = sar12_previous[length(sar12_previous)-1]
let sar12_stimulus[2] = 1.2501e-05
let sar12_stimulus[3] = sar12_stimulus[1]
let sar12_stimulus[4] = 1.2503e-05
let sar12_stimulus[5] = sar12_drive
let sar12_stimulus[6] = 0.000148
let sar12_stimulus[7] = sar12_stimulus[5]
alter @VD_B5[pwl] = sar12_stimulus
let sar12_drive = (floor(sar12_trial / 64) - 2*floor(sar12_trial / 128))*1.8
let sar12_previous = @VD_B6[pwl]
let sar12_stimulus = vector(8)
let sar12_stimulus[0] = 0
let sar12_stimulus[1] = sar12_previous[length(sar12_previous)-1]
let sar12_stimulus[2] = 1.2501e-05
let sar12_stimulus[3] = sar12_stimulus[1]
let sar12_stimulus[4] = 1.2503e-05
let sar12_stimulus[5] = sar12_drive
let sar12_stimulus[6] = 0.000148
let sar12_stimulus[7] = sar12_stimulus[5]
alter @VD_B6[pwl] = sar12_stimulus
let sar12_drive = (floor(sar12_trial / 128) - 2*floor(sar12_trial / 256))*1.8
let sar12_previous = @VD_B7[pwl]
let sar12_stimulus = vector(8)
let sar12_stimulus[0] = 0
let sar12_stimulus[1] = sar12_previous[length(sar12_previous)-1]
let sar12_stimulus[2] = 1.2501e-05
let sar12_stimulus[3] = sar12_stimulus[1]
let sar12_stimulus[4] = 1.2503e-05
let sar12_stimulus[5] = sar12_drive
let sar12_stimulus[6] = 0.000148
let sar12_stimulus[7] = sar12_stimulus[5]
alter @VD_B7[pwl] = sar12_stimulus
let sar12_drive = (floor(sar12_trial / 256) - 2*floor(sar12_trial / 512))*1.8
let sar12_previous = @VD_B8[pwl]
let sar12_stimulus = vector(8)
let sar12_stimulus[0] = 0
let sar12_stimulus[1] = sar12_previous[length(sar12_previous)-1]
let sar12_stimulus[2] = 1.2501e-05
let sar12_stimulus[3] = sar12_stimulus[1]
let sar12_stimulus[4] = 1.2503e-05
let sar12_stimulus[5] = sar12_drive
let sar12_stimulus[6] = 0.000148
let sar12_stimulus[7] = sar12_stimulus[5]
alter @VD_B8[pwl] = sar12_stimulus
let sar12_drive = (floor(sar12_trial / 512) - 2*floor(sar12_trial / 1024))*1.8
let sar12_previous = @VD_B9[pwl]
let sar12_stimulus = vector(8)
let sar12_stimulus[0] = 0
let sar12_stimulus[1] = sar12_previous[length(sar12_previous)-1]
let sar12_stimulus[2] = 1.2501e-05
let sar12_stimulus[3] = sar12_stimulus[1]
let sar12_stimulus[4] = 1.2503e-05
let sar12_stimulus[5] = sar12_drive
let sar12_stimulus[6] = 0.000148
let sar12_stimulus[7] = sar12_stimulus[5]
alter @VD_B9[pwl] = sar12_stimulus
let sar12_drive = (floor(sar12_trial / 1024) - 2*floor(sar12_trial / 2048))*1.8
let sar12_previous = @VD_B10[pwl]
let sar12_stimulus = vector(8)
let sar12_stimulus[0] = 0
let sar12_stimulus[1] = sar12_previous[length(sar12_previous)-1]
let sar12_stimulus[2] = 1.2501e-05
let sar12_stimulus[3] = sar12_stimulus[1]
let sar12_stimulus[4] = 1.2503e-05
let sar12_stimulus[5] = sar12_drive
let sar12_stimulus[6] = 0.000148
let sar12_stimulus[7] = sar12_stimulus[5]
alter @VD_B10[pwl] = sar12_stimulus
let sar12_drive = (floor(sar12_trial / 2048) - 2*floor(sar12_trial / 4096))*1.8
let sar12_previous = @VD_B11[pwl]
let sar12_stimulus = vector(8)
let sar12_stimulus[0] = 0
let sar12_stimulus[1] = sar12_previous[length(sar12_previous)-1]
let sar12_stimulus[2] = 1.2501e-05
let sar12_stimulus[3] = sar12_stimulus[1]
let sar12_stimulus[4] = 1.2503e-05
let sar12_stimulus[5] = sar12_drive
let sar12_stimulus[6] = 0.000148
let sar12_stimulus[7] = sar12_stimulus[5]
alter @VD_B11[pwl] = sar12_stimulus
let sar12_drive = (floor(sar12_trial / 4096) - 2*floor(sar12_trial / 8192))*1.8
let sar12_previous = @VD_B12[pwl]
let sar12_stimulus = vector(8)
let sar12_stimulus[0] = 0
let sar12_stimulus[1] = sar12_previous[length(sar12_previous)-1]
let sar12_stimulus[2] = 1.2501e-05
let sar12_stimulus[3] = sar12_stimulus[1]
let sar12_stimulus[4] = 1.2503e-05
let sar12_stimulus[5] = sar12_drive
let sar12_stimulus[6] = 0.000148
let sar12_stimulus[7] = sar12_stimulus[5]
alter @VD_B12[pwl] = sar12_stimulus
let sar12_drive = (floor(sar12_trial / 8192) - 2*floor(sar12_trial / 16384))*1.8
let sar12_previous = @VD_B13[pwl]
let sar12_stimulus = vector(8)
let sar12_stimulus[0] = 0
let sar12_stimulus[1] = sar12_previous[length(sar12_previous)-1]
let sar12_stimulus[2] = 1.2501e-05
let sar12_stimulus[3] = sar12_stimulus[1]
let sar12_stimulus[4] = 1.2503e-05
let sar12_stimulus[5] = sar12_drive
let sar12_stimulus[6] = 0.000148
let sar12_stimulus[7] = sar12_stimulus[5]
alter @VD_B13[pwl] = sar12_stimulus
let sar12_drive = (floor(sar12_trial / 16384) - 2*floor(sar12_trial / 32768))*1.8
let sar12_previous = @VD_B14[pwl]
let sar12_stimulus = vector(8)
let sar12_stimulus[0] = 0
let sar12_stimulus[1] = sar12_previous[length(sar12_previous)-1]
let sar12_stimulus[2] = 1.2501e-05
let sar12_stimulus[3] = sar12_stimulus[1]
let sar12_stimulus[4] = 1.2503e-05
let sar12_stimulus[5] = sar12_drive
let sar12_stimulus[6] = 0.000148
let sar12_stimulus[7] = sar12_stimulus[5]
alter @VD_B14[pwl] = sar12_stimulus
let sar12_drive = (floor(sar12_trial / 32768) - 2*floor(sar12_trial / 65536))*1.8
let sar12_previous = @VD_B15[pwl]
let sar12_stimulus = vector(8)
let sar12_stimulus[0] = 0
let sar12_stimulus[1] = sar12_previous[length(sar12_previous)-1]
let sar12_stimulus[2] = 1.2501e-05
let sar12_stimulus[3] = sar12_stimulus[1]
let sar12_stimulus[4] = 1.2503e-05
let sar12_stimulus[5] = sar12_drive
let sar12_stimulus[6] = 0.000148
let sar12_stimulus[7] = sar12_stimulus[5]
alter @VD_B15[pwl] = sar12_stimulus
resume
let sar12_k = length(time)-1
if abs(time[sar12_k] - 1.3e-05) > 1e-12
print time[sar12_k]
echo expected_pause_time_s 1.3e-05
echo SAR12_PAUSE_FAILED
quit 1
end
print time[sar12_k] >> pause-times.txt
let sar12_previous = @VD_EVAL[pwl]
let sar12_stimulus = vector(8)
let sar12_stimulus[0] = 0
let sar12_stimulus[1] = sar12_previous[length(sar12_previous)-1]
let sar12_stimulus[2] = 1.3001e-05
let sar12_stimulus[3] = sar12_stimulus[1]
let sar12_stimulus[4] = 1.3003e-05
let sar12_stimulus[5] = 1.8
let sar12_stimulus[6] = 0.000148
let sar12_stimulus[7] = sar12_stimulus[5]
alter @VD_EVAL[pwl] = sar12_stimulus
resume
let sar12_k = length(time)-1
if abs(time[sar12_k] - 1.35e-05) > 1e-12
print time[sar12_k]
echo expected_pause_time_s 1.35e-05
echo SAR12_PAUSE_FAILED
quit 1
end
print time[sar12_k] >> pause-times.txt
let sar12_k = length(time)-1
let sar12_cmp = v(COMP)[sar12_k]
let sar12_cmpn = v(COMPN)[sar12_k]
let sar12_p = v(TOPP)[sar12_k]
let sar12_n = v(TOPN)[sar12_k]
let sar12_decision = 0
if sar12_cmp >= 0.9
let sar12_code = sar12_trial
let sar12_decision = 1
end
echo 0 11 $&sar12_trial $&sar12_cmp $&sar12_cmpn $&sar12_p $&sar12_n 1.8310546875e-05 $&sar12_decision >> decisions.csv
let sar12_previous = @VD_EVAL[pwl]
let sar12_stimulus = vector(8)
let sar12_stimulus[0] = 0
let sar12_stimulus[1] = sar12_previous[length(sar12_previous)-1]
let sar12_stimulus[2] = 1.3501e-05
let sar12_stimulus[3] = sar12_stimulus[1]
let sar12_stimulus[4] = 1.3503e-05
let sar12_stimulus[5] = 0
let sar12_stimulus[6] = 0.000148
let sar12_stimulus[7] = sar12_stimulus[5]
alter @VD_EVAL[pwl] = sar12_stimulus
let sar12_trial = sar12_code + 1024
let sar12_drive = (floor(sar12_trial / 1) - 2*floor(sar12_trial / 2))*1.8
let sar12_previous = @VD_B0[pwl]
let sar12_stimulus = vector(8)
let sar12_stimulus[0] = 0
let sar12_stimulus[1] = sar12_previous[length(sar12_previous)-1]
let sar12_stimulus[2] = 1.3501e-05
let sar12_stimulus[3] = sar12_stimulus[1]
let sar12_stimulus[4] = 1.3503e-05
let sar12_stimulus[5] = sar12_drive
let sar12_stimulus[6] = 0.000148
let sar12_stimulus[7] = sar12_stimulus[5]
alter @VD_B0[pwl] = sar12_stimulus
let sar12_drive = (floor(sar12_trial / 2) - 2*floor(sar12_trial / 4))*1.8
let sar12_previous = @VD_B1[pwl]
let sar12_stimulus = vector(8)
let sar12_stimulus[0] = 0
let sar12_stimulus[1] = sar12_previous[length(sar12_previous)-1]
let sar12_stimulus[2] = 1.3501e-05
let sar12_stimulus[3] = sar12_stimulus[1]
let sar12_stimulus[4] = 1.3503e-05
let sar12_stimulus[5] = sar12_drive
let sar12_stimulus[6] = 0.000148
let sar12_stimulus[7] = sar12_stimulus[5]
alter @VD_B1[pwl] = sar12_stimulus
let sar12_drive = (floor(sar12_trial / 4) - 2*floor(sar12_trial / 8))*1.8
let sar12_previous = @VD_B2[pwl]
let sar12_stimulus = vector(8)
let sar12_stimulus[0] = 0
let sar12_stimulus[1] = sar12_previous[length(sar12_previous)-1]
let sar12_stimulus[2] = 1.3501e-05
let sar12_stimulus[3] = sar12_stimulus[1]
let sar12_stimulus[4] = 1.3503e-05
let sar12_stimulus[5] = sar12_drive
let sar12_stimulus[6] = 0.000148
let sar12_stimulus[7] = sar12_stimulus[5]
alter @VD_B2[pwl] = sar12_stimulus
let sar12_drive = (floor(sar12_trial / 8) - 2*floor(sar12_trial / 16))*1.8
let sar12_previous = @VD_B3[pwl]
let sar12_stimulus = vector(8)
let sar12_stimulus[0] = 0
let sar12_stimulus[1] = sar12_previous[length(sar12_previous)-1]
let sar12_stimulus[2] = 1.3501e-05
let sar12_stimulus[3] = sar12_stimulus[1]
let sar12_stimulus[4] = 1.3503e-05
let sar12_stimulus[5] = sar12_drive
let sar12_stimulus[6] = 0.000148
let sar12_stimulus[7] = sar12_stimulus[5]
alter @VD_B3[pwl] = sar12_stimulus
let sar12_drive = (floor(sar12_trial / 16) - 2*floor(sar12_trial / 32))*1.8
let sar12_previous = @VD_B4[pwl]
let sar12_stimulus = vector(8)
let sar12_stimulus[0] = 0
let sar12_stimulus[1] = sar12_previous[length(sar12_previous)-1]
let sar12_stimulus[2] = 1.3501e-05
let sar12_stimulus[3] = sar12_stimulus[1]
let sar12_stimulus[4] = 1.3503e-05
let sar12_stimulus[5] = sar12_drive
let sar12_stimulus[6] = 0.000148
let sar12_stimulus[7] = sar12_stimulus[5]
alter @VD_B4[pwl] = sar12_stimulus
let sar12_drive = (floor(sar12_trial / 32) - 2*floor(sar12_trial / 64))*1.8
let sar12_previous = @VD_B5[pwl]
let sar12_stimulus = vector(8)
let sar12_stimulus[0] = 0
let sar12_stimulus[1] = sar12_previous[length(sar12_previous)-1]
let sar12_stimulus[2] = 1.3501e-05
let sar12_stimulus[3] = sar12_stimulus[1]
let sar12_stimulus[4] = 1.3503e-05
let sar12_stimulus[5] = sar12_drive
let sar12_stimulus[6] = 0.000148
let sar12_stimulus[7] = sar12_stimulus[5]
alter @VD_B5[pwl] = sar12_stimulus
let sar12_drive = (floor(sar12_trial / 64) - 2*floor(sar12_trial / 128))*1.8
let sar12_previous = @VD_B6[pwl]
let sar12_stimulus = vector(8)
let sar12_stimulus[0] = 0
let sar12_stimulus[1] = sar12_previous[length(sar12_previous)-1]
let sar12_stimulus[2] = 1.3501e-05
let sar12_stimulus[3] = sar12_stimulus[1]
let sar12_stimulus[4] = 1.3503e-05
let sar12_stimulus[5] = sar12_drive
let sar12_stimulus[6] = 0.000148
let sar12_stimulus[7] = sar12_stimulus[5]
alter @VD_B6[pwl] = sar12_stimulus
let sar12_drive = (floor(sar12_trial / 128) - 2*floor(sar12_trial / 256))*1.8
let sar12_previous = @VD_B7[pwl]
let sar12_stimulus = vector(8)
let sar12_stimulus[0] = 0
let sar12_stimulus[1] = sar12_previous[length(sar12_previous)-1]
let sar12_stimulus[2] = 1.3501e-05
let sar12_stimulus[3] = sar12_stimulus[1]
let sar12_stimulus[4] = 1.3503e-05
let sar12_stimulus[5] = sar12_drive
let sar12_stimulus[6] = 0.000148
let sar12_stimulus[7] = sar12_stimulus[5]
alter @VD_B7[pwl] = sar12_stimulus
let sar12_drive = (floor(sar12_trial / 256) - 2*floor(sar12_trial / 512))*1.8
let sar12_previous = @VD_B8[pwl]
let sar12_stimulus = vector(8)
let sar12_stimulus[0] = 0
let sar12_stimulus[1] = sar12_previous[length(sar12_previous)-1]
let sar12_stimulus[2] = 1.3501e-05
let sar12_stimulus[3] = sar12_stimulus[1]
let sar12_stimulus[4] = 1.3503e-05
let sar12_stimulus[5] = sar12_drive
let sar12_stimulus[6] = 0.000148
let sar12_stimulus[7] = sar12_stimulus[5]
alter @VD_B8[pwl] = sar12_stimulus
let sar12_drive = (floor(sar12_trial / 512) - 2*floor(sar12_trial / 1024))*1.8
let sar12_previous = @VD_B9[pwl]
let sar12_stimulus = vector(8)
let sar12_stimulus[0] = 0
let sar12_stimulus[1] = sar12_previous[length(sar12_previous)-1]
let sar12_stimulus[2] = 1.3501e-05
let sar12_stimulus[3] = sar12_stimulus[1]
let sar12_stimulus[4] = 1.3503e-05
let sar12_stimulus[5] = sar12_drive
let sar12_stimulus[6] = 0.000148
let sar12_stimulus[7] = sar12_stimulus[5]
alter @VD_B9[pwl] = sar12_stimulus
let sar12_drive = (floor(sar12_trial / 1024) - 2*floor(sar12_trial / 2048))*1.8
let sar12_previous = @VD_B10[pwl]
let sar12_stimulus = vector(8)
let sar12_stimulus[0] = 0
let sar12_stimulus[1] = sar12_previous[length(sar12_previous)-1]
let sar12_stimulus[2] = 1.3501e-05
let sar12_stimulus[3] = sar12_stimulus[1]
let sar12_stimulus[4] = 1.3503e-05
let sar12_stimulus[5] = sar12_drive
let sar12_stimulus[6] = 0.000148
let sar12_stimulus[7] = sar12_stimulus[5]
alter @VD_B10[pwl] = sar12_stimulus
let sar12_drive = (floor(sar12_trial / 2048) - 2*floor(sar12_trial / 4096))*1.8
let sar12_previous = @VD_B11[pwl]
let sar12_stimulus = vector(8)
let sar12_stimulus[0] = 0
let sar12_stimulus[1] = sar12_previous[length(sar12_previous)-1]
let sar12_stimulus[2] = 1.3501e-05
let sar12_stimulus[3] = sar12_stimulus[1]
let sar12_stimulus[4] = 1.3503e-05
let sar12_stimulus[5] = sar12_drive
let sar12_stimulus[6] = 0.000148
let sar12_stimulus[7] = sar12_stimulus[5]
alter @VD_B11[pwl] = sar12_stimulus
let sar12_drive = (floor(sar12_trial / 4096) - 2*floor(sar12_trial / 8192))*1.8
let sar12_previous = @VD_B12[pwl]
let sar12_stimulus = vector(8)
let sar12_stimulus[0] = 0
let sar12_stimulus[1] = sar12_previous[length(sar12_previous)-1]
let sar12_stimulus[2] = 1.3501e-05
let sar12_stimulus[3] = sar12_stimulus[1]
let sar12_stimulus[4] = 1.3503e-05
let sar12_stimulus[5] = sar12_drive
let sar12_stimulus[6] = 0.000148
let sar12_stimulus[7] = sar12_stimulus[5]
alter @VD_B12[pwl] = sar12_stimulus
let sar12_drive = (floor(sar12_trial / 8192) - 2*floor(sar12_trial / 16384))*1.8
let sar12_previous = @VD_B13[pwl]
let sar12_stimulus = vector(8)
let sar12_stimulus[0] = 0
let sar12_stimulus[1] = sar12_previous[length(sar12_previous)-1]
let sar12_stimulus[2] = 1.3501e-05
let sar12_stimulus[3] = sar12_stimulus[1]
let sar12_stimulus[4] = 1.3503e-05
let sar12_stimulus[5] = sar12_drive
let sar12_stimulus[6] = 0.000148
let sar12_stimulus[7] = sar12_stimulus[5]
alter @VD_B13[pwl] = sar12_stimulus
let sar12_drive = (floor(sar12_trial / 16384) - 2*floor(sar12_trial / 32768))*1.8
let sar12_previous = @VD_B14[pwl]
let sar12_stimulus = vector(8)
let sar12_stimulus[0] = 0
let sar12_stimulus[1] = sar12_previous[length(sar12_previous)-1]
let sar12_stimulus[2] = 1.3501e-05
let sar12_stimulus[3] = sar12_stimulus[1]
let sar12_stimulus[4] = 1.3503e-05
let sar12_stimulus[5] = sar12_drive
let sar12_stimulus[6] = 0.000148
let sar12_stimulus[7] = sar12_stimulus[5]
alter @VD_B14[pwl] = sar12_stimulus
let sar12_drive = (floor(sar12_trial / 32768) - 2*floor(sar12_trial / 65536))*1.8
let sar12_previous = @VD_B15[pwl]
let sar12_stimulus = vector(8)
let sar12_stimulus[0] = 0
let sar12_stimulus[1] = sar12_previous[length(sar12_previous)-1]
let sar12_stimulus[2] = 1.3501e-05
let sar12_stimulus[3] = sar12_stimulus[1]
let sar12_stimulus[4] = 1.3503e-05
let sar12_stimulus[5] = sar12_drive
let sar12_stimulus[6] = 0.000148
let sar12_stimulus[7] = sar12_stimulus[5]
alter @VD_B15[pwl] = sar12_stimulus
resume
let sar12_k = length(time)-1
if abs(time[sar12_k] - 1.4e-05) > 1e-12
print time[sar12_k]
echo expected_pause_time_s 1.4e-05
echo SAR12_PAUSE_FAILED
quit 1
end
print time[sar12_k] >> pause-times.txt
let sar12_previous = @VD_EVAL[pwl]
let sar12_stimulus = vector(8)
let sar12_stimulus[0] = 0
let sar12_stimulus[1] = sar12_previous[length(sar12_previous)-1]
let sar12_stimulus[2] = 1.4001e-05
let sar12_stimulus[3] = sar12_stimulus[1]
let sar12_stimulus[4] = 1.4003e-05
let sar12_stimulus[5] = 1.8
let sar12_stimulus[6] = 0.000148
let sar12_stimulus[7] = sar12_stimulus[5]
alter @VD_EVAL[pwl] = sar12_stimulus
resume
let sar12_k = length(time)-1
if abs(time[sar12_k] - 1.45e-05) > 1e-12
print time[sar12_k]
echo expected_pause_time_s 1.45e-05
echo SAR12_PAUSE_FAILED
quit 1
end
print time[sar12_k] >> pause-times.txt
let sar12_k = length(time)-1
let sar12_cmp = v(COMP)[sar12_k]
let sar12_cmpn = v(COMPN)[sar12_k]
let sar12_p = v(TOPP)[sar12_k]
let sar12_n = v(TOPN)[sar12_k]
let sar12_decision = 0
if sar12_cmp >= 0.9
let sar12_code = sar12_trial
let sar12_decision = 1
end
echo 0 10 $&sar12_trial $&sar12_cmp $&sar12_cmpn $&sar12_p $&sar12_n 1.8310546875e-05 $&sar12_decision >> decisions.csv
let sar12_previous = @VD_EVAL[pwl]
let sar12_stimulus = vector(8)
let sar12_stimulus[0] = 0
let sar12_stimulus[1] = sar12_previous[length(sar12_previous)-1]
let sar12_stimulus[2] = 1.4501e-05
let sar12_stimulus[3] = sar12_stimulus[1]
let sar12_stimulus[4] = 1.4503e-05
let sar12_stimulus[5] = 0
let sar12_stimulus[6] = 0.000148
let sar12_stimulus[7] = sar12_stimulus[5]
alter @VD_EVAL[pwl] = sar12_stimulus
let sar12_trial = sar12_code + 512
let sar12_drive = (floor(sar12_trial / 1) - 2*floor(sar12_trial / 2))*1.8
let sar12_previous = @VD_B0[pwl]
let sar12_stimulus = vector(8)
let sar12_stimulus[0] = 0
let sar12_stimulus[1] = sar12_previous[length(sar12_previous)-1]
let sar12_stimulus[2] = 1.4501e-05
let sar12_stimulus[3] = sar12_stimulus[1]
let sar12_stimulus[4] = 1.4503e-05
let sar12_stimulus[5] = sar12_drive
let sar12_stimulus[6] = 0.000148
let sar12_stimulus[7] = sar12_stimulus[5]
alter @VD_B0[pwl] = sar12_stimulus
let sar12_drive = (floor(sar12_trial / 2) - 2*floor(sar12_trial / 4))*1.8
let sar12_previous = @VD_B1[pwl]
let sar12_stimulus = vector(8)
let sar12_stimulus[0] = 0
let sar12_stimulus[1] = sar12_previous[length(sar12_previous)-1]
let sar12_stimulus[2] = 1.4501e-05
let sar12_stimulus[3] = sar12_stimulus[1]
let sar12_stimulus[4] = 1.4503e-05
let sar12_stimulus[5] = sar12_drive
let sar12_stimulus[6] = 0.000148
let sar12_stimulus[7] = sar12_stimulus[5]
alter @VD_B1[pwl] = sar12_stimulus
let sar12_drive = (floor(sar12_trial / 4) - 2*floor(sar12_trial / 8))*1.8
let sar12_previous = @VD_B2[pwl]
let sar12_stimulus = vector(8)
let sar12_stimulus[0] = 0
let sar12_stimulus[1] = sar12_previous[length(sar12_previous)-1]
let sar12_stimulus[2] = 1.4501e-05
let sar12_stimulus[3] = sar12_stimulus[1]
let sar12_stimulus[4] = 1.4503e-05
let sar12_stimulus[5] = sar12_drive
let sar12_stimulus[6] = 0.000148
let sar12_stimulus[7] = sar12_stimulus[5]
alter @VD_B2[pwl] = sar12_stimulus
let sar12_drive = (floor(sar12_trial / 8) - 2*floor(sar12_trial / 16))*1.8
let sar12_previous = @VD_B3[pwl]
let sar12_stimulus = vector(8)
let sar12_stimulus[0] = 0
let sar12_stimulus[1] = sar12_previous[length(sar12_previous)-1]
let sar12_stimulus[2] = 1.4501e-05
let sar12_stimulus[3] = sar12_stimulus[1]
let sar12_stimulus[4] = 1.4503e-05
let sar12_stimulus[5] = sar12_drive
let sar12_stimulus[6] = 0.000148
let sar12_stimulus[7] = sar12_stimulus[5]
alter @VD_B3[pwl] = sar12_stimulus
let sar12_drive = (floor(sar12_trial / 16) - 2*floor(sar12_trial / 32))*1.8
let sar12_previous = @VD_B4[pwl]
let sar12_stimulus = vector(8)
let sar12_stimulus[0] = 0
let sar12_stimulus[1] = sar12_previous[length(sar12_previous)-1]
let sar12_stimulus[2] = 1.4501e-05
let sar12_stimulus[3] = sar12_stimulus[1]
let sar12_stimulus[4] = 1.4503e-05
let sar12_stimulus[5] = sar12_drive
let sar12_stimulus[6] = 0.000148
let sar12_stimulus[7] = sar12_stimulus[5]
alter @VD_B4[pwl] = sar12_stimulus
let sar12_drive = (floor(sar12_trial / 32) - 2*floor(sar12_trial / 64))*1.8
let sar12_previous = @VD_B5[pwl]
let sar12_stimulus = vector(8)
let sar12_stimulus[0] = 0
let sar12_stimulus[1] = sar12_previous[length(sar12_previous)-1]
let sar12_stimulus[2] = 1.4501e-05
let sar12_stimulus[3] = sar12_stimulus[1]
let sar12_stimulus[4] = 1.4503e-05
let sar12_stimulus[5] = sar12_drive
let sar12_stimulus[6] = 0.000148
let sar12_stimulus[7] = sar12_stimulus[5]
alter @VD_B5[pwl] = sar12_stimulus
let sar12_drive = (floor(sar12_trial / 64) - 2*floor(sar12_trial / 128))*1.8
let sar12_previous = @VD_B6[pwl]
let sar12_stimulus = vector(8)
let sar12_stimulus[0] = 0
let sar12_stimulus[1] = sar12_previous[length(sar12_previous)-1]
let sar12_stimulus[2] = 1.4501e-05
let sar12_stimulus[3] = sar12_stimulus[1]
let sar12_stimulus[4] = 1.4503e-05
let sar12_stimulus[5] = sar12_drive
let sar12_stimulus[6] = 0.000148
let sar12_stimulus[7] = sar12_stimulus[5]
alter @VD_B6[pwl] = sar12_stimulus
let sar12_drive = (floor(sar12_trial / 128) - 2*floor(sar12_trial / 256))*1.8
let sar12_previous = @VD_B7[pwl]
let sar12_stimulus = vector(8)
let sar12_stimulus[0] = 0
let sar12_stimulus[1] = sar12_previous[length(sar12_previous)-1]
let sar12_stimulus[2] = 1.4501e-05
let sar12_stimulus[3] = sar12_stimulus[1]
let sar12_stimulus[4] = 1.4503e-05
let sar12_stimulus[5] = sar12_drive
let sar12_stimulus[6] = 0.000148
let sar12_stimulus[7] = sar12_stimulus[5]
alter @VD_B7[pwl] = sar12_stimulus
let sar12_drive = (floor(sar12_trial / 256) - 2*floor(sar12_trial / 512))*1.8
let sar12_previous = @VD_B8[pwl]
let sar12_stimulus = vector(8)
let sar12_stimulus[0] = 0
let sar12_stimulus[1] = sar12_previous[length(sar12_previous)-1]
let sar12_stimulus[2] = 1.4501e-05
let sar12_stimulus[3] = sar12_stimulus[1]
let sar12_stimulus[4] = 1.4503e-05
let sar12_stimulus[5] = sar12_drive
let sar12_stimulus[6] = 0.000148
let sar12_stimulus[7] = sar12_stimulus[5]
alter @VD_B8[pwl] = sar12_stimulus
let sar12_drive = (floor(sar12_trial / 512) - 2*floor(sar12_trial / 1024))*1.8
let sar12_previous = @VD_B9[pwl]
let sar12_stimulus = vector(8)
let sar12_stimulus[0] = 0
let sar12_stimulus[1] = sar12_previous[length(sar12_previous)-1]
let sar12_stimulus[2] = 1.4501e-05
let sar12_stimulus[3] = sar12_stimulus[1]
let sar12_stimulus[4] = 1.4503e-05
let sar12_stimulus[5] = sar12_drive
let sar12_stimulus[6] = 0.000148
let sar12_stimulus[7] = sar12_stimulus[5]
alter @VD_B9[pwl] = sar12_stimulus
let sar12_drive = (floor(sar12_trial / 1024) - 2*floor(sar12_trial / 2048))*1.8
let sar12_previous = @VD_B10[pwl]
let sar12_stimulus = vector(8)
let sar12_stimulus[0] = 0
let sar12_stimulus[1] = sar12_previous[length(sar12_previous)-1]
let sar12_stimulus[2] = 1.4501e-05
let sar12_stimulus[3] = sar12_stimulus[1]
let sar12_stimulus[4] = 1.4503e-05
let sar12_stimulus[5] = sar12_drive
let sar12_stimulus[6] = 0.000148
let sar12_stimulus[7] = sar12_stimulus[5]
alter @VD_B10[pwl] = sar12_stimulus
let sar12_drive = (floor(sar12_trial / 2048) - 2*floor(sar12_trial / 4096))*1.8
let sar12_previous = @VD_B11[pwl]
let sar12_stimulus = vector(8)
let sar12_stimulus[0] = 0
let sar12_stimulus[1] = sar12_previous[length(sar12_previous)-1]
let sar12_stimulus[2] = 1.4501e-05
let sar12_stimulus[3] = sar12_stimulus[1]
let sar12_stimulus[4] = 1.4503e-05
let sar12_stimulus[5] = sar12_drive
let sar12_stimulus[6] = 0.000148
let sar12_stimulus[7] = sar12_stimulus[5]
alter @VD_B11[pwl] = sar12_stimulus
let sar12_drive = (floor(sar12_trial / 4096) - 2*floor(sar12_trial / 8192))*1.8
let sar12_previous = @VD_B12[pwl]
let sar12_stimulus = vector(8)
let sar12_stimulus[0] = 0
let sar12_stimulus[1] = sar12_previous[length(sar12_previous)-1]
let sar12_stimulus[2] = 1.4501e-05
let sar12_stimulus[3] = sar12_stimulus[1]
let sar12_stimulus[4] = 1.4503e-05
let sar12_stimulus[5] = sar12_drive
let sar12_stimulus[6] = 0.000148
let sar12_stimulus[7] = sar12_stimulus[5]
alter @VD_B12[pwl] = sar12_stimulus
let sar12_drive = (floor(sar12_trial / 8192) - 2*floor(sar12_trial / 16384))*1.8
let sar12_previous = @VD_B13[pwl]
let sar12_stimulus = vector(8)
let sar12_stimulus[0] = 0
let sar12_stimulus[1] = sar12_previous[length(sar12_previous)-1]
let sar12_stimulus[2] = 1.4501e-05
let sar12_stimulus[3] = sar12_stimulus[1]
let sar12_stimulus[4] = 1.4503e-05
let sar12_stimulus[5] = sar12_drive
let sar12_stimulus[6] = 0.000148
let sar12_stimulus[7] = sar12_stimulus[5]
alter @VD_B13[pwl] = sar12_stimulus
let sar12_drive = (floor(sar12_trial / 16384) - 2*floor(sar12_trial / 32768))*1.8
let sar12_previous = @VD_B14[pwl]
let sar12_stimulus = vector(8)
let sar12_stimulus[0] = 0
let sar12_stimulus[1] = sar12_previous[length(sar12_previous)-1]
let sar12_stimulus[2] = 1.4501e-05
let sar12_stimulus[3] = sar12_stimulus[1]
let sar12_stimulus[4] = 1.4503e-05
let sar12_stimulus[5] = sar12_drive
let sar12_stimulus[6] = 0.000148
let sar12_stimulus[7] = sar12_stimulus[5]
alter @VD_B14[pwl] = sar12_stimulus
let sar12_drive = (floor(sar12_trial / 32768) - 2*floor(sar12_trial / 65536))*1.8
let sar12_previous = @VD_B15[pwl]
let sar12_stimulus = vector(8)
let sar12_stimulus[0] = 0
let sar12_stimulus[1] = sar12_previous[length(sar12_previous)-1]
let sar12_stimulus[2] = 1.4501e-05
let sar12_stimulus[3] = sar12_stimulus[1]
let sar12_stimulus[4] = 1.4503e-05
let sar12_stimulus[5] = sar12_drive
let sar12_stimulus[6] = 0.000148
let sar12_stimulus[7] = sar12_stimulus[5]
alter @VD_B15[pwl] = sar12_stimulus
resume
let sar12_k = length(time)-1
if abs(time[sar12_k] - 1.5e-05) > 1e-12
print time[sar12_k]
echo expected_pause_time_s 1.5e-05
echo SAR12_PAUSE_FAILED
quit 1
end
print time[sar12_k] >> pause-times.txt
let sar12_previous = @VD_EVAL[pwl]
let sar12_stimulus = vector(8)
let sar12_stimulus[0] = 0
let sar12_stimulus[1] = sar12_previous[length(sar12_previous)-1]
let sar12_stimulus[2] = 1.5001e-05
let sar12_stimulus[3] = sar12_stimulus[1]
let sar12_stimulus[4] = 1.5003e-05
let sar12_stimulus[5] = 1.8
let sar12_stimulus[6] = 0.000148
let sar12_stimulus[7] = sar12_stimulus[5]
alter @VD_EVAL[pwl] = sar12_stimulus
resume
let sar12_k = length(time)-1
if abs(time[sar12_k] - 1.55e-05) > 1e-12
print time[sar12_k]
echo expected_pause_time_s 1.55e-05
echo SAR12_PAUSE_FAILED
quit 1
end
print time[sar12_k] >> pause-times.txt
let sar12_k = length(time)-1
let sar12_cmp = v(COMP)[sar12_k]
let sar12_cmpn = v(COMPN)[sar12_k]
let sar12_p = v(TOPP)[sar12_k]
let sar12_n = v(TOPN)[sar12_k]
let sar12_decision = 0
if sar12_cmp >= 0.9
let sar12_code = sar12_trial
let sar12_decision = 1
end
echo 0 9 $&sar12_trial $&sar12_cmp $&sar12_cmpn $&sar12_p $&sar12_n 1.8310546875e-05 $&sar12_decision >> decisions.csv
let sar12_previous = @VD_EVAL[pwl]
let sar12_stimulus = vector(8)
let sar12_stimulus[0] = 0
let sar12_stimulus[1] = sar12_previous[length(sar12_previous)-1]
let sar12_stimulus[2] = 1.5501e-05
let sar12_stimulus[3] = sar12_stimulus[1]
let sar12_stimulus[4] = 1.5503e-05
let sar12_stimulus[5] = 0
let sar12_stimulus[6] = 0.000148
let sar12_stimulus[7] = sar12_stimulus[5]
alter @VD_EVAL[pwl] = sar12_stimulus
let sar12_trial = sar12_code + 256
let sar12_drive = (floor(sar12_trial / 1) - 2*floor(sar12_trial / 2))*1.8
let sar12_previous = @VD_B0[pwl]
let sar12_stimulus = vector(8)
let sar12_stimulus[0] = 0
let sar12_stimulus[1] = sar12_previous[length(sar12_previous)-1]
let sar12_stimulus[2] = 1.5501e-05
let sar12_stimulus[3] = sar12_stimulus[1]
let sar12_stimulus[4] = 1.5503e-05
let sar12_stimulus[5] = sar12_drive
let sar12_stimulus[6] = 0.000148
let sar12_stimulus[7] = sar12_stimulus[5]
alter @VD_B0[pwl] = sar12_stimulus
let sar12_drive = (floor(sar12_trial / 2) - 2*floor(sar12_trial / 4))*1.8
let sar12_previous = @VD_B1[pwl]
let sar12_stimulus = vector(8)
let sar12_stimulus[0] = 0
let sar12_stimulus[1] = sar12_previous[length(sar12_previous)-1]
let sar12_stimulus[2] = 1.5501e-05
let sar12_stimulus[3] = sar12_stimulus[1]
let sar12_stimulus[4] = 1.5503e-05
let sar12_stimulus[5] = sar12_drive
let sar12_stimulus[6] = 0.000148
let sar12_stimulus[7] = sar12_stimulus[5]
alter @VD_B1[pwl] = sar12_stimulus
let sar12_drive = (floor(sar12_trial / 4) - 2*floor(sar12_trial / 8))*1.8
let sar12_previous = @VD_B2[pwl]
let sar12_stimulus = vector(8)
let sar12_stimulus[0] = 0
let sar12_stimulus[1] = sar12_previous[length(sar12_previous)-1]
let sar12_stimulus[2] = 1.5501e-05
let sar12_stimulus[3] = sar12_stimulus[1]
let sar12_stimulus[4] = 1.5503e-05
let sar12_stimulus[5] = sar12_drive
let sar12_stimulus[6] = 0.000148
let sar12_stimulus[7] = sar12_stimulus[5]
alter @VD_B2[pwl] = sar12_stimulus
let sar12_drive = (floor(sar12_trial / 8) - 2*floor(sar12_trial / 16))*1.8
let sar12_previous = @VD_B3[pwl]
let sar12_stimulus = vector(8)
let sar12_stimulus[0] = 0
let sar12_stimulus[1] = sar12_previous[length(sar12_previous)-1]
let sar12_stimulus[2] = 1.5501e-05
let sar12_stimulus[3] = sar12_stimulus[1]
let sar12_stimulus[4] = 1.5503e-05
let sar12_stimulus[5] = sar12_drive
let sar12_stimulus[6] = 0.000148
let sar12_stimulus[7] = sar12_stimulus[5]
alter @VD_B3[pwl] = sar12_stimulus
let sar12_drive = (floor(sar12_trial / 16) - 2*floor(sar12_trial / 32))*1.8
let sar12_previous = @VD_B4[pwl]
let sar12_stimulus = vector(8)
let sar12_stimulus[0] = 0
let sar12_stimulus[1] = sar12_previous[length(sar12_previous)-1]
let sar12_stimulus[2] = 1.5501e-05
let sar12_stimulus[3] = sar12_stimulus[1]
let sar12_stimulus[4] = 1.5503e-05
let sar12_stimulus[5] = sar12_drive
let sar12_stimulus[6] = 0.000148
let sar12_stimulus[7] = sar12_stimulus[5]
alter @VD_B4[pwl] = sar12_stimulus
let sar12_drive = (floor(sar12_trial / 32) - 2*floor(sar12_trial / 64))*1.8
let sar12_previous = @VD_B5[pwl]
let sar12_stimulus = vector(8)
let sar12_stimulus[0] = 0
let sar12_stimulus[1] = sar12_previous[length(sar12_previous)-1]
let sar12_stimulus[2] = 1.5501e-05
let sar12_stimulus[3] = sar12_stimulus[1]
let sar12_stimulus[4] = 1.5503e-05
let sar12_stimulus[5] = sar12_drive
let sar12_stimulus[6] = 0.000148
let sar12_stimulus[7] = sar12_stimulus[5]
alter @VD_B5[pwl] = sar12_stimulus
let sar12_drive = (floor(sar12_trial / 64) - 2*floor(sar12_trial / 128))*1.8
let sar12_previous = @VD_B6[pwl]
let sar12_stimulus = vector(8)
let sar12_stimulus[0] = 0
let sar12_stimulus[1] = sar12_previous[length(sar12_previous)-1]
let sar12_stimulus[2] = 1.5501e-05
let sar12_stimulus[3] = sar12_stimulus[1]
let sar12_stimulus[4] = 1.5503e-05
let sar12_stimulus[5] = sar12_drive
let sar12_stimulus[6] = 0.000148
let sar12_stimulus[7] = sar12_stimulus[5]
alter @VD_B6[pwl] = sar12_stimulus
let sar12_drive = (floor(sar12_trial / 128) - 2*floor(sar12_trial / 256))*1.8
let sar12_previous = @VD_B7[pwl]
let sar12_stimulus = vector(8)
let sar12_stimulus[0] = 0
let sar12_stimulus[1] = sar12_previous[length(sar12_previous)-1]
let sar12_stimulus[2] = 1.5501e-05
let sar12_stimulus[3] = sar12_stimulus[1]
let sar12_stimulus[4] = 1.5503e-05
let sar12_stimulus[5] = sar12_drive
let sar12_stimulus[6] = 0.000148
let sar12_stimulus[7] = sar12_stimulus[5]
alter @VD_B7[pwl] = sar12_stimulus
let sar12_drive = (floor(sar12_trial / 256) - 2*floor(sar12_trial / 512))*1.8
let sar12_previous = @VD_B8[pwl]
let sar12_stimulus = vector(8)
let sar12_stimulus[0] = 0
let sar12_stimulus[1] = sar12_previous[length(sar12_previous)-1]
let sar12_stimulus[2] = 1.5501e-05
let sar12_stimulus[3] = sar12_stimulus[1]
let sar12_stimulus[4] = 1.5503e-05
let sar12_stimulus[5] = sar12_drive
let sar12_stimulus[6] = 0.000148
let sar12_stimulus[7] = sar12_stimulus[5]
alter @VD_B8[pwl] = sar12_stimulus
let sar12_drive = (floor(sar12_trial / 512) - 2*floor(sar12_trial / 1024))*1.8
let sar12_previous = @VD_B9[pwl]
let sar12_stimulus = vector(8)
let sar12_stimulus[0] = 0
let sar12_stimulus[1] = sar12_previous[length(sar12_previous)-1]
let sar12_stimulus[2] = 1.5501e-05
let sar12_stimulus[3] = sar12_stimulus[1]
let sar12_stimulus[4] = 1.5503e-05
let sar12_stimulus[5] = sar12_drive
let sar12_stimulus[6] = 0.000148
let sar12_stimulus[7] = sar12_stimulus[5]
alter @VD_B9[pwl] = sar12_stimulus
let sar12_drive = (floor(sar12_trial / 1024) - 2*floor(sar12_trial / 2048))*1.8
let sar12_previous = @VD_B10[pwl]
let sar12_stimulus = vector(8)
let sar12_stimulus[0] = 0
let sar12_stimulus[1] = sar12_previous[length(sar12_previous)-1]
let sar12_stimulus[2] = 1.5501e-05
let sar12_stimulus[3] = sar12_stimulus[1]
let sar12_stimulus[4] = 1.5503e-05
let sar12_stimulus[5] = sar12_drive
let sar12_stimulus[6] = 0.000148
let sar12_stimulus[7] = sar12_stimulus[5]
alter @VD_B10[pwl] = sar12_stimulus
let sar12_drive = (floor(sar12_trial / 2048) - 2*floor(sar12_trial / 4096))*1.8
let sar12_previous = @VD_B11[pwl]
let sar12_stimulus = vector(8)
let sar12_stimulus[0] = 0
let sar12_stimulus[1] = sar12_previous[length(sar12_previous)-1]
let sar12_stimulus[2] = 1.5501e-05
let sar12_stimulus[3] = sar12_stimulus[1]
let sar12_stimulus[4] = 1.5503e-05
let sar12_stimulus[5] = sar12_drive
let sar12_stimulus[6] = 0.000148
let sar12_stimulus[7] = sar12_stimulus[5]
alter @VD_B11[pwl] = sar12_stimulus
let sar12_drive = (floor(sar12_trial / 4096) - 2*floor(sar12_trial / 8192))*1.8
let sar12_previous = @VD_B12[pwl]
let sar12_stimulus = vector(8)
let sar12_stimulus[0] = 0
let sar12_stimulus[1] = sar12_previous[length(sar12_previous)-1]
let sar12_stimulus[2] = 1.5501e-05
let sar12_stimulus[3] = sar12_stimulus[1]
let sar12_stimulus[4] = 1.5503e-05
let sar12_stimulus[5] = sar12_drive
let sar12_stimulus[6] = 0.000148
let sar12_stimulus[7] = sar12_stimulus[5]
alter @VD_B12[pwl] = sar12_stimulus
let sar12_drive = (floor(sar12_trial / 8192) - 2*floor(sar12_trial / 16384))*1.8
let sar12_previous = @VD_B13[pwl]
let sar12_stimulus = vector(8)
let sar12_stimulus[0] = 0
let sar12_stimulus[1] = sar12_previous[length(sar12_previous)-1]
let sar12_stimulus[2] = 1.5501e-05
let sar12_stimulus[3] = sar12_stimulus[1]
let sar12_stimulus[4] = 1.5503e-05
let sar12_stimulus[5] = sar12_drive
let sar12_stimulus[6] = 0.000148
let sar12_stimulus[7] = sar12_stimulus[5]
alter @VD_B13[pwl] = sar12_stimulus
let sar12_drive = (floor(sar12_trial / 16384) - 2*floor(sar12_trial / 32768))*1.8
let sar12_previous = @VD_B14[pwl]
let sar12_stimulus = vector(8)
let sar12_stimulus[0] = 0
let sar12_stimulus[1] = sar12_previous[length(sar12_previous)-1]
let sar12_stimulus[2] = 1.5501e-05
let sar12_stimulus[3] = sar12_stimulus[1]
let sar12_stimulus[4] = 1.5503e-05
let sar12_stimulus[5] = sar12_drive
let sar12_stimulus[6] = 0.000148
let sar12_stimulus[7] = sar12_stimulus[5]
alter @VD_B14[pwl] = sar12_stimulus
let sar12_drive = (floor(sar12_trial / 32768) - 2*floor(sar12_trial / 65536))*1.8
let sar12_previous = @VD_B15[pwl]
let sar12_stimulus = vector(8)
let sar12_stimulus[0] = 0
let sar12_stimulus[1] = sar12_previous[length(sar12_previous)-1]
let sar12_stimulus[2] = 1.5501e-05
let sar12_stimulus[3] = sar12_stimulus[1]
let sar12_stimulus[4] = 1.5503e-05
let sar12_stimulus[5] = sar12_drive
let sar12_stimulus[6] = 0.000148
let sar12_stimulus[7] = sar12_stimulus[5]
alter @VD_B15[pwl] = sar12_stimulus
resume
let sar12_k = length(time)-1
if abs(time[sar12_k] - 1.6e-05) > 1e-12
print time[sar12_k]
echo expected_pause_time_s 1.6e-05
echo SAR12_PAUSE_FAILED
quit 1
end
print time[sar12_k] >> pause-times.txt
let sar12_previous = @VD_EVAL[pwl]
let sar12_stimulus = vector(8)
let sar12_stimulus[0] = 0
let sar12_stimulus[1] = sar12_previous[length(sar12_previous)-1]
let sar12_stimulus[2] = 1.6001e-05
let sar12_stimulus[3] = sar12_stimulus[1]
let sar12_stimulus[4] = 1.6003e-05
let sar12_stimulus[5] = 1.8
let sar12_stimulus[6] = 0.000148
let sar12_stimulus[7] = sar12_stimulus[5]
alter @VD_EVAL[pwl] = sar12_stimulus
resume
let sar12_k = length(time)-1
if abs(time[sar12_k] - 1.65e-05) > 1e-12
print time[sar12_k]
echo expected_pause_time_s 1.65e-05
echo SAR12_PAUSE_FAILED
quit 1
end
print time[sar12_k] >> pause-times.txt
let sar12_k = length(time)-1
let sar12_cmp = v(COMP)[sar12_k]
let sar12_cmpn = v(COMPN)[sar12_k]
let sar12_p = v(TOPP)[sar12_k]
let sar12_n = v(TOPN)[sar12_k]
let sar12_decision = 0
if sar12_cmp >= 0.9
let sar12_code = sar12_trial
let sar12_decision = 1
end
echo 0 8 $&sar12_trial $&sar12_cmp $&sar12_cmpn $&sar12_p $&sar12_n 1.8310546875e-05 $&sar12_decision >> decisions.csv
let sar12_previous = @VD_EVAL[pwl]
let sar12_stimulus = vector(8)
let sar12_stimulus[0] = 0
let sar12_stimulus[1] = sar12_previous[length(sar12_previous)-1]
let sar12_stimulus[2] = 1.6501e-05
let sar12_stimulus[3] = sar12_stimulus[1]
let sar12_stimulus[4] = 1.6503e-05
let sar12_stimulus[5] = 0
let sar12_stimulus[6] = 0.000148
let sar12_stimulus[7] = sar12_stimulus[5]
alter @VD_EVAL[pwl] = sar12_stimulus
let sar12_trial = sar12_code + 128
let sar12_drive = (floor(sar12_trial / 1) - 2*floor(sar12_trial / 2))*1.8
let sar12_previous = @VD_B0[pwl]
let sar12_stimulus = vector(8)
let sar12_stimulus[0] = 0
let sar12_stimulus[1] = sar12_previous[length(sar12_previous)-1]
let sar12_stimulus[2] = 1.6501e-05
let sar12_stimulus[3] = sar12_stimulus[1]
let sar12_stimulus[4] = 1.6503e-05
let sar12_stimulus[5] = sar12_drive
let sar12_stimulus[6] = 0.000148
let sar12_stimulus[7] = sar12_stimulus[5]
alter @VD_B0[pwl] = sar12_stimulus
let sar12_drive = (floor(sar12_trial / 2) - 2*floor(sar12_trial / 4))*1.8
let sar12_previous = @VD_B1[pwl]
let sar12_stimulus = vector(8)
let sar12_stimulus[0] = 0
let sar12_stimulus[1] = sar12_previous[length(sar12_previous)-1]
let sar12_stimulus[2] = 1.6501e-05
let sar12_stimulus[3] = sar12_stimulus[1]
let sar12_stimulus[4] = 1.6503e-05
let sar12_stimulus[5] = sar12_drive
let sar12_stimulus[6] = 0.000148
let sar12_stimulus[7] = sar12_stimulus[5]
alter @VD_B1[pwl] = sar12_stimulus
let sar12_drive = (floor(sar12_trial / 4) - 2*floor(sar12_trial / 8))*1.8
let sar12_previous = @VD_B2[pwl]
let sar12_stimulus = vector(8)
let sar12_stimulus[0] = 0
let sar12_stimulus[1] = sar12_previous[length(sar12_previous)-1]
let sar12_stimulus[2] = 1.6501e-05
let sar12_stimulus[3] = sar12_stimulus[1]
let sar12_stimulus[4] = 1.6503e-05
let sar12_stimulus[5] = sar12_drive
let sar12_stimulus[6] = 0.000148
let sar12_stimulus[7] = sar12_stimulus[5]
alter @VD_B2[pwl] = sar12_stimulus
let sar12_drive = (floor(sar12_trial / 8) - 2*floor(sar12_trial / 16))*1.8
let sar12_previous = @VD_B3[pwl]
let sar12_stimulus = vector(8)
let sar12_stimulus[0] = 0
let sar12_stimulus[1] = sar12_previous[length(sar12_previous)-1]
let sar12_stimulus[2] = 1.6501e-05
let sar12_stimulus[3] = sar12_stimulus[1]
let sar12_stimulus[4] = 1.6503e-05
let sar12_stimulus[5] = sar12_drive
let sar12_stimulus[6] = 0.000148
let sar12_stimulus[7] = sar12_stimulus[5]
alter @VD_B3[pwl] = sar12_stimulus
let sar12_drive = (floor(sar12_trial / 16) - 2*floor(sar12_trial / 32))*1.8
let sar12_previous = @VD_B4[pwl]
let sar12_stimulus = vector(8)
let sar12_stimulus[0] = 0
let sar12_stimulus[1] = sar12_previous[length(sar12_previous)-1]
let sar12_stimulus[2] = 1.6501e-05
let sar12_stimulus[3] = sar12_stimulus[1]
let sar12_stimulus[4] = 1.6503e-05
let sar12_stimulus[5] = sar12_drive
let sar12_stimulus[6] = 0.000148
let sar12_stimulus[7] = sar12_stimulus[5]
alter @VD_B4[pwl] = sar12_stimulus
let sar12_drive = (floor(sar12_trial / 32) - 2*floor(sar12_trial / 64))*1.8
let sar12_previous = @VD_B5[pwl]
let sar12_stimulus = vector(8)
let sar12_stimulus[0] = 0
let sar12_stimulus[1] = sar12_previous[length(sar12_previous)-1]
let sar12_stimulus[2] = 1.6501e-05
let sar12_stimulus[3] = sar12_stimulus[1]
let sar12_stimulus[4] = 1.6503e-05
let sar12_stimulus[5] = sar12_drive
let sar12_stimulus[6] = 0.000148
let sar12_stimulus[7] = sar12_stimulus[5]
alter @VD_B5[pwl] = sar12_stimulus
let sar12_drive = (floor(sar12_trial / 64) - 2*floor(sar12_trial / 128))*1.8
let sar12_previous = @VD_B6[pwl]
let sar12_stimulus = vector(8)
let sar12_stimulus[0] = 0
let sar12_stimulus[1] = sar12_previous[length(sar12_previous)-1]
let sar12_stimulus[2] = 1.6501e-05
let sar12_stimulus[3] = sar12_stimulus[1]
let sar12_stimulus[4] = 1.6503e-05
let sar12_stimulus[5] = sar12_drive
let sar12_stimulus[6] = 0.000148
let sar12_stimulus[7] = sar12_stimulus[5]
alter @VD_B6[pwl] = sar12_stimulus
let sar12_drive = (floor(sar12_trial / 128) - 2*floor(sar12_trial / 256))*1.8
let sar12_previous = @VD_B7[pwl]
let sar12_stimulus = vector(8)
let sar12_stimulus[0] = 0
let sar12_stimulus[1] = sar12_previous[length(sar12_previous)-1]
let sar12_stimulus[2] = 1.6501e-05
let sar12_stimulus[3] = sar12_stimulus[1]
let sar12_stimulus[4] = 1.6503e-05
let sar12_stimulus[5] = sar12_drive
let sar12_stimulus[6] = 0.000148
let sar12_stimulus[7] = sar12_stimulus[5]
alter @VD_B7[pwl] = sar12_stimulus
let sar12_drive = (floor(sar12_trial / 256) - 2*floor(sar12_trial / 512))*1.8
let sar12_previous = @VD_B8[pwl]
let sar12_stimulus = vector(8)
let sar12_stimulus[0] = 0
let sar12_stimulus[1] = sar12_previous[length(sar12_previous)-1]
let sar12_stimulus[2] = 1.6501e-05
let sar12_stimulus[3] = sar12_stimulus[1]
let sar12_stimulus[4] = 1.6503e-05
let sar12_stimulus[5] = sar12_drive
let sar12_stimulus[6] = 0.000148
let sar12_stimulus[7] = sar12_stimulus[5]
alter @VD_B8[pwl] = sar12_stimulus
let sar12_drive = (floor(sar12_trial / 512) - 2*floor(sar12_trial / 1024))*1.8
let sar12_previous = @VD_B9[pwl]
let sar12_stimulus = vector(8)
let sar12_stimulus[0] = 0
let sar12_stimulus[1] = sar12_previous[length(sar12_previous)-1]
let sar12_stimulus[2] = 1.6501e-05
let sar12_stimulus[3] = sar12_stimulus[1]
let sar12_stimulus[4] = 1.6503e-05
let sar12_stimulus[5] = sar12_drive
let sar12_stimulus[6] = 0.000148
let sar12_stimulus[7] = sar12_stimulus[5]
alter @VD_B9[pwl] = sar12_stimulus
let sar12_drive = (floor(sar12_trial / 1024) - 2*floor(sar12_trial / 2048))*1.8
let sar12_previous = @VD_B10[pwl]
let sar12_stimulus = vector(8)
let sar12_stimulus[0] = 0
let sar12_stimulus[1] = sar12_previous[length(sar12_previous)-1]
let sar12_stimulus[2] = 1.6501e-05
let sar12_stimulus[3] = sar12_stimulus[1]
let sar12_stimulus[4] = 1.6503e-05
let sar12_stimulus[5] = sar12_drive
let sar12_stimulus[6] = 0.000148
let sar12_stimulus[7] = sar12_stimulus[5]
alter @VD_B10[pwl] = sar12_stimulus
let sar12_drive = (floor(sar12_trial / 2048) - 2*floor(sar12_trial / 4096))*1.8
let sar12_previous = @VD_B11[pwl]
let sar12_stimulus = vector(8)
let sar12_stimulus[0] = 0
let sar12_stimulus[1] = sar12_previous[length(sar12_previous)-1]
let sar12_stimulus[2] = 1.6501e-05
let sar12_stimulus[3] = sar12_stimulus[1]
let sar12_stimulus[4] = 1.6503e-05
let sar12_stimulus[5] = sar12_drive
let sar12_stimulus[6] = 0.000148
let sar12_stimulus[7] = sar12_stimulus[5]
alter @VD_B11[pwl] = sar12_stimulus
let sar12_drive = (floor(sar12_trial / 4096) - 2*floor(sar12_trial / 8192))*1.8
let sar12_previous = @VD_B12[pwl]
let sar12_stimulus = vector(8)
let sar12_stimulus[0] = 0
let sar12_stimulus[1] = sar12_previous[length(sar12_previous)-1]
let sar12_stimulus[2] = 1.6501e-05
let sar12_stimulus[3] = sar12_stimulus[1]
let sar12_stimulus[4] = 1.6503e-05
let sar12_stimulus[5] = sar12_drive
let sar12_stimulus[6] = 0.000148
let sar12_stimulus[7] = sar12_stimulus[5]
alter @VD_B12[pwl] = sar12_stimulus
let sar12_drive = (floor(sar12_trial / 8192) - 2*floor(sar12_trial / 16384))*1.8
let sar12_previous = @VD_B13[pwl]
let sar12_stimulus = vector(8)
let sar12_stimulus[0] = 0
let sar12_stimulus[1] = sar12_previous[length(sar12_previous)-1]
let sar12_stimulus[2] = 1.6501e-05
let sar12_stimulus[3] = sar12_stimulus[1]
let sar12_stimulus[4] = 1.6503e-05
let sar12_stimulus[5] = sar12_drive
let sar12_stimulus[6] = 0.000148
let sar12_stimulus[7] = sar12_stimulus[5]
alter @VD_B13[pwl] = sar12_stimulus
let sar12_drive = (floor(sar12_trial / 16384) - 2*floor(sar12_trial / 32768))*1.8
let sar12_previous = @VD_B14[pwl]
let sar12_stimulus = vector(8)
let sar12_stimulus[0] = 0
let sar12_stimulus[1] = sar12_previous[length(sar12_previous)-1]
let sar12_stimulus[2] = 1.6501e-05
let sar12_stimulus[3] = sar12_stimulus[1]
let sar12_stimulus[4] = 1.6503e-05
let sar12_stimulus[5] = sar12_drive
let sar12_stimulus[6] = 0.000148
let sar12_stimulus[7] = sar12_stimulus[5]
alter @VD_B14[pwl] = sar12_stimulus
let sar12_drive = (floor(sar12_trial / 32768) - 2*floor(sar12_trial / 65536))*1.8
let sar12_previous = @VD_B15[pwl]
let sar12_stimulus = vector(8)
let sar12_stimulus[0] = 0
let sar12_stimulus[1] = sar12_previous[length(sar12_previous)-1]
let sar12_stimulus[2] = 1.6501e-05
let sar12_stimulus[3] = sar12_stimulus[1]
let sar12_stimulus[4] = 1.6503e-05
let sar12_stimulus[5] = sar12_drive
let sar12_stimulus[6] = 0.000148
let sar12_stimulus[7] = sar12_stimulus[5]
alter @VD_B15[pwl] = sar12_stimulus
resume
let sar12_k = length(time)-1
if abs(time[sar12_k] - 1.7e-05) > 1e-12
print time[sar12_k]
echo expected_pause_time_s 1.7e-05
echo SAR12_PAUSE_FAILED
quit 1
end
print time[sar12_k] >> pause-times.txt
let sar12_previous = @VD_EVAL[pwl]
let sar12_stimulus = vector(8)
let sar12_stimulus[0] = 0
let sar12_stimulus[1] = sar12_previous[length(sar12_previous)-1]
let sar12_stimulus[2] = 1.7001e-05
let sar12_stimulus[3] = sar12_stimulus[1]
let sar12_stimulus[4] = 1.7003e-05
let sar12_stimulus[5] = 1.8
let sar12_stimulus[6] = 0.000148
let sar12_stimulus[7] = sar12_stimulus[5]
alter @VD_EVAL[pwl] = sar12_stimulus
resume
let sar12_k = length(time)-1
if abs(time[sar12_k] - 1.75e-05) > 1e-12
print time[sar12_k]
echo expected_pause_time_s 1.75e-05
echo SAR12_PAUSE_FAILED
quit 1
end
print time[sar12_k] >> pause-times.txt
let sar12_k = length(time)-1
let sar12_cmp = v(COMP)[sar12_k]
let sar12_cmpn = v(COMPN)[sar12_k]
let sar12_p = v(TOPP)[sar12_k]
let sar12_n = v(TOPN)[sar12_k]
let sar12_decision = 0
if sar12_cmp >= 0.9
let sar12_code = sar12_trial
let sar12_decision = 1
end
echo 0 7 $&sar12_trial $&sar12_cmp $&sar12_cmpn $&sar12_p $&sar12_n 1.8310546875e-05 $&sar12_decision >> decisions.csv
let sar12_previous = @VD_EVAL[pwl]
let sar12_stimulus = vector(8)
let sar12_stimulus[0] = 0
let sar12_stimulus[1] = sar12_previous[length(sar12_previous)-1]
let sar12_stimulus[2] = 1.7501e-05
let sar12_stimulus[3] = sar12_stimulus[1]
let sar12_stimulus[4] = 1.7503e-05
let sar12_stimulus[5] = 0
let sar12_stimulus[6] = 0.000148
let sar12_stimulus[7] = sar12_stimulus[5]
alter @VD_EVAL[pwl] = sar12_stimulus
let sar12_trial = sar12_code + 64
let sar12_drive = (floor(sar12_trial / 1) - 2*floor(sar12_trial / 2))*1.8
let sar12_previous = @VD_B0[pwl]
let sar12_stimulus = vector(8)
let sar12_stimulus[0] = 0
let sar12_stimulus[1] = sar12_previous[length(sar12_previous)-1]
let sar12_stimulus[2] = 1.7501e-05
let sar12_stimulus[3] = sar12_stimulus[1]
let sar12_stimulus[4] = 1.7503e-05
let sar12_stimulus[5] = sar12_drive
let sar12_stimulus[6] = 0.000148
let sar12_stimulus[7] = sar12_stimulus[5]
alter @VD_B0[pwl] = sar12_stimulus
let sar12_drive = (floor(sar12_trial / 2) - 2*floor(sar12_trial / 4))*1.8
let sar12_previous = @VD_B1[pwl]
let sar12_stimulus = vector(8)
let sar12_stimulus[0] = 0
let sar12_stimulus[1] = sar12_previous[length(sar12_previous)-1]
let sar12_stimulus[2] = 1.7501e-05
let sar12_stimulus[3] = sar12_stimulus[1]
let sar12_stimulus[4] = 1.7503e-05
let sar12_stimulus[5] = sar12_drive
let sar12_stimulus[6] = 0.000148
let sar12_stimulus[7] = sar12_stimulus[5]
alter @VD_B1[pwl] = sar12_stimulus
let sar12_drive = (floor(sar12_trial / 4) - 2*floor(sar12_trial / 8))*1.8
let sar12_previous = @VD_B2[pwl]
let sar12_stimulus = vector(8)
let sar12_stimulus[0] = 0
let sar12_stimulus[1] = sar12_previous[length(sar12_previous)-1]
let sar12_stimulus[2] = 1.7501e-05
let sar12_stimulus[3] = sar12_stimulus[1]
let sar12_stimulus[4] = 1.7503e-05
let sar12_stimulus[5] = sar12_drive
let sar12_stimulus[6] = 0.000148
let sar12_stimulus[7] = sar12_stimulus[5]
alter @VD_B2[pwl] = sar12_stimulus
let sar12_drive = (floor(sar12_trial / 8) - 2*floor(sar12_trial / 16))*1.8
let sar12_previous = @VD_B3[pwl]
let sar12_stimulus = vector(8)
let sar12_stimulus[0] = 0
let sar12_stimulus[1] = sar12_previous[length(sar12_previous)-1]
let sar12_stimulus[2] = 1.7501e-05
let sar12_stimulus[3] = sar12_stimulus[1]
let sar12_stimulus[4] = 1.7503e-05
let sar12_stimulus[5] = sar12_drive
let sar12_stimulus[6] = 0.000148
let sar12_stimulus[7] = sar12_stimulus[5]
alter @VD_B3[pwl] = sar12_stimulus
let sar12_drive = (floor(sar12_trial / 16) - 2*floor(sar12_trial / 32))*1.8
let sar12_previous = @VD_B4[pwl]
let sar12_stimulus = vector(8)
let sar12_stimulus[0] = 0
let sar12_stimulus[1] = sar12_previous[length(sar12_previous)-1]
let sar12_stimulus[2] = 1.7501e-05
let sar12_stimulus[3] = sar12_stimulus[1]
let sar12_stimulus[4] = 1.7503e-05
let sar12_stimulus[5] = sar12_drive
let sar12_stimulus[6] = 0.000148
let sar12_stimulus[7] = sar12_stimulus[5]
alter @VD_B4[pwl] = sar12_stimulus
let sar12_drive = (floor(sar12_trial / 32) - 2*floor(sar12_trial / 64))*1.8
let sar12_previous = @VD_B5[pwl]
let sar12_stimulus = vector(8)
let sar12_stimulus[0] = 0
let sar12_stimulus[1] = sar12_previous[length(sar12_previous)-1]
let sar12_stimulus[2] = 1.7501e-05
let sar12_stimulus[3] = sar12_stimulus[1]
let sar12_stimulus[4] = 1.7503e-05
let sar12_stimulus[5] = sar12_drive
let sar12_stimulus[6] = 0.000148
let sar12_stimulus[7] = sar12_stimulus[5]
alter @VD_B5[pwl] = sar12_stimulus
let sar12_drive = (floor(sar12_trial / 64) - 2*floor(sar12_trial / 128))*1.8
let sar12_previous = @VD_B6[pwl]
let sar12_stimulus = vector(8)
let sar12_stimulus[0] = 0
let sar12_stimulus[1] = sar12_previous[length(sar12_previous)-1]
let sar12_stimulus[2] = 1.7501e-05
let sar12_stimulus[3] = sar12_stimulus[1]
let sar12_stimulus[4] = 1.7503e-05
let sar12_stimulus[5] = sar12_drive
let sar12_stimulus[6] = 0.000148
let sar12_stimulus[7] = sar12_stimulus[5]
alter @VD_B6[pwl] = sar12_stimulus
let sar12_drive = (floor(sar12_trial / 128) - 2*floor(sar12_trial / 256))*1.8
let sar12_previous = @VD_B7[pwl]
let sar12_stimulus = vector(8)
let sar12_stimulus[0] = 0
let sar12_stimulus[1] = sar12_previous[length(sar12_previous)-1]
let sar12_stimulus[2] = 1.7501e-05
let sar12_stimulus[3] = sar12_stimulus[1]
let sar12_stimulus[4] = 1.7503e-05
let sar12_stimulus[5] = sar12_drive
let sar12_stimulus[6] = 0.000148
let sar12_stimulus[7] = sar12_stimulus[5]
alter @VD_B7[pwl] = sar12_stimulus
let sar12_drive = (floor(sar12_trial / 256) - 2*floor(sar12_trial / 512))*1.8
let sar12_previous = @VD_B8[pwl]
let sar12_stimulus = vector(8)
let sar12_stimulus[0] = 0
let sar12_stimulus[1] = sar12_previous[length(sar12_previous)-1]
let sar12_stimulus[2] = 1.7501e-05
let sar12_stimulus[3] = sar12_stimulus[1]
let sar12_stimulus[4] = 1.7503e-05
let sar12_stimulus[5] = sar12_drive
let sar12_stimulus[6] = 0.000148
let sar12_stimulus[7] = sar12_stimulus[5]
alter @VD_B8[pwl] = sar12_stimulus
let sar12_drive = (floor(sar12_trial / 512) - 2*floor(sar12_trial / 1024))*1.8
let sar12_previous = @VD_B9[pwl]
let sar12_stimulus = vector(8)
let sar12_stimulus[0] = 0
let sar12_stimulus[1] = sar12_previous[length(sar12_previous)-1]
let sar12_stimulus[2] = 1.7501e-05
let sar12_stimulus[3] = sar12_stimulus[1]
let sar12_stimulus[4] = 1.7503e-05
let sar12_stimulus[5] = sar12_drive
let sar12_stimulus[6] = 0.000148
let sar12_stimulus[7] = sar12_stimulus[5]
alter @VD_B9[pwl] = sar12_stimulus
let sar12_drive = (floor(sar12_trial / 1024) - 2*floor(sar12_trial / 2048))*1.8
let sar12_previous = @VD_B10[pwl]
let sar12_stimulus = vector(8)
let sar12_stimulus[0] = 0
let sar12_stimulus[1] = sar12_previous[length(sar12_previous)-1]
let sar12_stimulus[2] = 1.7501e-05
let sar12_stimulus[3] = sar12_stimulus[1]
let sar12_stimulus[4] = 1.7503e-05
let sar12_stimulus[5] = sar12_drive
let sar12_stimulus[6] = 0.000148
let sar12_stimulus[7] = sar12_stimulus[5]
alter @VD_B10[pwl] = sar12_stimulus
let sar12_drive = (floor(sar12_trial / 2048) - 2*floor(sar12_trial / 4096))*1.8
let sar12_previous = @VD_B11[pwl]
let sar12_stimulus = vector(8)
let sar12_stimulus[0] = 0
let sar12_stimulus[1] = sar12_previous[length(sar12_previous)-1]
let sar12_stimulus[2] = 1.7501e-05
let sar12_stimulus[3] = sar12_stimulus[1]
let sar12_stimulus[4] = 1.7503e-05
let sar12_stimulus[5] = sar12_drive
let sar12_stimulus[6] = 0.000148
let sar12_stimulus[7] = sar12_stimulus[5]
alter @VD_B11[pwl] = sar12_stimulus
let sar12_drive = (floor(sar12_trial / 4096) - 2*floor(sar12_trial / 8192))*1.8
let sar12_previous = @VD_B12[pwl]
let sar12_stimulus = vector(8)
let sar12_stimulus[0] = 0
let sar12_stimulus[1] = sar12_previous[length(sar12_previous)-1]
let sar12_stimulus[2] = 1.7501e-05
let sar12_stimulus[3] = sar12_stimulus[1]
let sar12_stimulus[4] = 1.7503e-05
let sar12_stimulus[5] = sar12_drive
let sar12_stimulus[6] = 0.000148
let sar12_stimulus[7] = sar12_stimulus[5]
alter @VD_B12[pwl] = sar12_stimulus
let sar12_drive = (floor(sar12_trial / 8192) - 2*floor(sar12_trial / 16384))*1.8
let sar12_previous = @VD_B13[pwl]
let sar12_stimulus = vector(8)
let sar12_stimulus[0] = 0
let sar12_stimulus[1] = sar12_previous[length(sar12_previous)-1]
let sar12_stimulus[2] = 1.7501e-05
let sar12_stimulus[3] = sar12_stimulus[1]
let sar12_stimulus[4] = 1.7503e-05
let sar12_stimulus[5] = sar12_drive
let sar12_stimulus[6] = 0.000148
let sar12_stimulus[7] = sar12_stimulus[5]
alter @VD_B13[pwl] = sar12_stimulus
let sar12_drive = (floor(sar12_trial / 16384) - 2*floor(sar12_trial / 32768))*1.8
let sar12_previous = @VD_B14[pwl]
let sar12_stimulus = vector(8)
let sar12_stimulus[0] = 0
let sar12_stimulus[1] = sar12_previous[length(sar12_previous)-1]
let sar12_stimulus[2] = 1.7501e-05
let sar12_stimulus[3] = sar12_stimulus[1]
let sar12_stimulus[4] = 1.7503e-05
let sar12_stimulus[5] = sar12_drive
let sar12_stimulus[6] = 0.000148
let sar12_stimulus[7] = sar12_stimulus[5]
alter @VD_B14[pwl] = sar12_stimulus
let sar12_drive = (floor(sar12_trial / 32768) - 2*floor(sar12_trial / 65536))*1.8
let sar12_previous = @VD_B15[pwl]
let sar12_stimulus = vector(8)
let sar12_stimulus[0] = 0
let sar12_stimulus[1] = sar12_previous[length(sar12_previous)-1]
let sar12_stimulus[2] = 1.7501e-05
let sar12_stimulus[3] = sar12_stimulus[1]
let sar12_stimulus[4] = 1.7503e-05
let sar12_stimulus[5] = sar12_drive
let sar12_stimulus[6] = 0.000148
let sar12_stimulus[7] = sar12_stimulus[5]
alter @VD_B15[pwl] = sar12_stimulus
resume
let sar12_k = length(time)-1
if abs(time[sar12_k] - 1.8e-05) > 1e-12
print time[sar12_k]
echo expected_pause_time_s 1.8e-05
echo SAR12_PAUSE_FAILED
quit 1
end
print time[sar12_k] >> pause-times.txt
let sar12_previous = @VD_EVAL[pwl]
let sar12_stimulus = vector(8)
let sar12_stimulus[0] = 0
let sar12_stimulus[1] = sar12_previous[length(sar12_previous)-1]
let sar12_stimulus[2] = 1.8001e-05
let sar12_stimulus[3] = sar12_stimulus[1]
let sar12_stimulus[4] = 1.8003e-05
let sar12_stimulus[5] = 1.8
let sar12_stimulus[6] = 0.000148
let sar12_stimulus[7] = sar12_stimulus[5]
alter @VD_EVAL[pwl] = sar12_stimulus
resume
let sar12_k = length(time)-1
if abs(time[sar12_k] - 1.85e-05) > 1e-12
print time[sar12_k]
echo expected_pause_time_s 1.85e-05
echo SAR12_PAUSE_FAILED
quit 1
end
print time[sar12_k] >> pause-times.txt
let sar12_k = length(time)-1
let sar12_cmp = v(COMP)[sar12_k]
let sar12_cmpn = v(COMPN)[sar12_k]
let sar12_p = v(TOPP)[sar12_k]
let sar12_n = v(TOPN)[sar12_k]
let sar12_decision = 0
if sar12_cmp >= 0.9
let sar12_code = sar12_trial
let sar12_decision = 1
end
echo 0 6 $&sar12_trial $&sar12_cmp $&sar12_cmpn $&sar12_p $&sar12_n 1.8310546875e-05 $&sar12_decision >> decisions.csv
let sar12_previous = @VD_EVAL[pwl]
let sar12_stimulus = vector(8)
let sar12_stimulus[0] = 0
let sar12_stimulus[1] = sar12_previous[length(sar12_previous)-1]
let sar12_stimulus[2] = 1.8501e-05
let sar12_stimulus[3] = sar12_stimulus[1]
let sar12_stimulus[4] = 1.8503e-05
let sar12_stimulus[5] = 0
let sar12_stimulus[6] = 0.000148
let sar12_stimulus[7] = sar12_stimulus[5]
alter @VD_EVAL[pwl] = sar12_stimulus
let sar12_trial = sar12_code + 32
let sar12_drive = (floor(sar12_trial / 1) - 2*floor(sar12_trial / 2))*1.8
let sar12_previous = @VD_B0[pwl]
let sar12_stimulus = vector(8)
let sar12_stimulus[0] = 0
let sar12_stimulus[1] = sar12_previous[length(sar12_previous)-1]
let sar12_stimulus[2] = 1.8501e-05
let sar12_stimulus[3] = sar12_stimulus[1]
let sar12_stimulus[4] = 1.8503e-05
let sar12_stimulus[5] = sar12_drive
let sar12_stimulus[6] = 0.000148
let sar12_stimulus[7] = sar12_stimulus[5]
alter @VD_B0[pwl] = sar12_stimulus
let sar12_drive = (floor(sar12_trial / 2) - 2*floor(sar12_trial / 4))*1.8
let sar12_previous = @VD_B1[pwl]
let sar12_stimulus = vector(8)
let sar12_stimulus[0] = 0
let sar12_stimulus[1] = sar12_previous[length(sar12_previous)-1]
let sar12_stimulus[2] = 1.8501e-05
let sar12_stimulus[3] = sar12_stimulus[1]
let sar12_stimulus[4] = 1.8503e-05
let sar12_stimulus[5] = sar12_drive
let sar12_stimulus[6] = 0.000148
let sar12_stimulus[7] = sar12_stimulus[5]
alter @VD_B1[pwl] = sar12_stimulus
let sar12_drive = (floor(sar12_trial / 4) - 2*floor(sar12_trial / 8))*1.8
let sar12_previous = @VD_B2[pwl]
let sar12_stimulus = vector(8)
let sar12_stimulus[0] = 0
let sar12_stimulus[1] = sar12_previous[length(sar12_previous)-1]
let sar12_stimulus[2] = 1.8501e-05
let sar12_stimulus[3] = sar12_stimulus[1]
let sar12_stimulus[4] = 1.8503e-05
let sar12_stimulus[5] = sar12_drive
let sar12_stimulus[6] = 0.000148
let sar12_stimulus[7] = sar12_stimulus[5]
alter @VD_B2[pwl] = sar12_stimulus
let sar12_drive = (floor(sar12_trial / 8) - 2*floor(sar12_trial / 16))*1.8
let sar12_previous = @VD_B3[pwl]
let sar12_stimulus = vector(8)
let sar12_stimulus[0] = 0
let sar12_stimulus[1] = sar12_previous[length(sar12_previous)-1]
let sar12_stimulus[2] = 1.8501e-05
let sar12_stimulus[3] = sar12_stimulus[1]
let sar12_stimulus[4] = 1.8503e-05
let sar12_stimulus[5] = sar12_drive
let sar12_stimulus[6] = 0.000148
let sar12_stimulus[7] = sar12_stimulus[5]
alter @VD_B3[pwl] = sar12_stimulus
let sar12_drive = (floor(sar12_trial / 16) - 2*floor(sar12_trial / 32))*1.8
let sar12_previous = @VD_B4[pwl]
let sar12_stimulus = vector(8)
let sar12_stimulus[0] = 0
let sar12_stimulus[1] = sar12_previous[length(sar12_previous)-1]
let sar12_stimulus[2] = 1.8501e-05
let sar12_stimulus[3] = sar12_stimulus[1]
let sar12_stimulus[4] = 1.8503e-05
let sar12_stimulus[5] = sar12_drive
let sar12_stimulus[6] = 0.000148
let sar12_stimulus[7] = sar12_stimulus[5]
alter @VD_B4[pwl] = sar12_stimulus
let sar12_drive = (floor(sar12_trial / 32) - 2*floor(sar12_trial / 64))*1.8
let sar12_previous = @VD_B5[pwl]
let sar12_stimulus = vector(8)
let sar12_stimulus[0] = 0
let sar12_stimulus[1] = sar12_previous[length(sar12_previous)-1]
let sar12_stimulus[2] = 1.8501e-05
let sar12_stimulus[3] = sar12_stimulus[1]
let sar12_stimulus[4] = 1.8503e-05
let sar12_stimulus[5] = sar12_drive
let sar12_stimulus[6] = 0.000148
let sar12_stimulus[7] = sar12_stimulus[5]
alter @VD_B5[pwl] = sar12_stimulus
let sar12_drive = (floor(sar12_trial / 64) - 2*floor(sar12_trial / 128))*1.8
let sar12_previous = @VD_B6[pwl]
let sar12_stimulus = vector(8)
let sar12_stimulus[0] = 0
let sar12_stimulus[1] = sar12_previous[length(sar12_previous)-1]
let sar12_stimulus[2] = 1.8501e-05
let sar12_stimulus[3] = sar12_stimulus[1]
let sar12_stimulus[4] = 1.8503e-05
let sar12_stimulus[5] = sar12_drive
let sar12_stimulus[6] = 0.000148
let sar12_stimulus[7] = sar12_stimulus[5]
alter @VD_B6[pwl] = sar12_stimulus
let sar12_drive = (floor(sar12_trial / 128) - 2*floor(sar12_trial / 256))*1.8
let sar12_previous = @VD_B7[pwl]
let sar12_stimulus = vector(8)
let sar12_stimulus[0] = 0
let sar12_stimulus[1] = sar12_previous[length(sar12_previous)-1]
let sar12_stimulus[2] = 1.8501e-05
let sar12_stimulus[3] = sar12_stimulus[1]
let sar12_stimulus[4] = 1.8503e-05
let sar12_stimulus[5] = sar12_drive
let sar12_stimulus[6] = 0.000148
let sar12_stimulus[7] = sar12_stimulus[5]
alter @VD_B7[pwl] = sar12_stimulus
let sar12_drive = (floor(sar12_trial / 256) - 2*floor(sar12_trial / 512))*1.8
let sar12_previous = @VD_B8[pwl]
let sar12_stimulus = vector(8)
let sar12_stimulus[0] = 0
let sar12_stimulus[1] = sar12_previous[length(sar12_previous)-1]
let sar12_stimulus[2] = 1.8501e-05
let sar12_stimulus[3] = sar12_stimulus[1]
let sar12_stimulus[4] = 1.8503e-05
let sar12_stimulus[5] = sar12_drive
let sar12_stimulus[6] = 0.000148
let sar12_stimulus[7] = sar12_stimulus[5]
alter @VD_B8[pwl] = sar12_stimulus
let sar12_drive = (floor(sar12_trial / 512) - 2*floor(sar12_trial / 1024))*1.8
let sar12_previous = @VD_B9[pwl]
let sar12_stimulus = vector(8)
let sar12_stimulus[0] = 0
let sar12_stimulus[1] = sar12_previous[length(sar12_previous)-1]
let sar12_stimulus[2] = 1.8501e-05
let sar12_stimulus[3] = sar12_stimulus[1]
let sar12_stimulus[4] = 1.8503e-05
let sar12_stimulus[5] = sar12_drive
let sar12_stimulus[6] = 0.000148
let sar12_stimulus[7] = sar12_stimulus[5]
alter @VD_B9[pwl] = sar12_stimulus
let sar12_drive = (floor(sar12_trial / 1024) - 2*floor(sar12_trial / 2048))*1.8
let sar12_previous = @VD_B10[pwl]
let sar12_stimulus = vector(8)
let sar12_stimulus[0] = 0
let sar12_stimulus[1] = sar12_previous[length(sar12_previous)-1]
let sar12_stimulus[2] = 1.8501e-05
let sar12_stimulus[3] = sar12_stimulus[1]
let sar12_stimulus[4] = 1.8503e-05
let sar12_stimulus[5] = sar12_drive
let sar12_stimulus[6] = 0.000148
let sar12_stimulus[7] = sar12_stimulus[5]
alter @VD_B10[pwl] = sar12_stimulus
let sar12_drive = (floor(sar12_trial / 2048) - 2*floor(sar12_trial / 4096))*1.8
let sar12_previous = @VD_B11[pwl]
let sar12_stimulus = vector(8)
let sar12_stimulus[0] = 0
let sar12_stimulus[1] = sar12_previous[length(sar12_previous)-1]
let sar12_stimulus[2] = 1.8501e-05
let sar12_stimulus[3] = sar12_stimulus[1]
let sar12_stimulus[4] = 1.8503e-05
let sar12_stimulus[5] = sar12_drive
let sar12_stimulus[6] = 0.000148
let sar12_stimulus[7] = sar12_stimulus[5]
alter @VD_B11[pwl] = sar12_stimulus
let sar12_drive = (floor(sar12_trial / 4096) - 2*floor(sar12_trial / 8192))*1.8
let sar12_previous = @VD_B12[pwl]
let sar12_stimulus = vector(8)
let sar12_stimulus[0] = 0
let sar12_stimulus[1] = sar12_previous[length(sar12_previous)-1]
let sar12_stimulus[2] = 1.8501e-05
let sar12_stimulus[3] = sar12_stimulus[1]
let sar12_stimulus[4] = 1.8503e-05
let sar12_stimulus[5] = sar12_drive
let sar12_stimulus[6] = 0.000148
let sar12_stimulus[7] = sar12_stimulus[5]
alter @VD_B12[pwl] = sar12_stimulus
let sar12_drive = (floor(sar12_trial / 8192) - 2*floor(sar12_trial / 16384))*1.8
let sar12_previous = @VD_B13[pwl]
let sar12_stimulus = vector(8)
let sar12_stimulus[0] = 0
let sar12_stimulus[1] = sar12_previous[length(sar12_previous)-1]
let sar12_stimulus[2] = 1.8501e-05
let sar12_stimulus[3] = sar12_stimulus[1]
let sar12_stimulus[4] = 1.8503e-05
let sar12_stimulus[5] = sar12_drive
let sar12_stimulus[6] = 0.000148
let sar12_stimulus[7] = sar12_stimulus[5]
alter @VD_B13[pwl] = sar12_stimulus
let sar12_drive = (floor(sar12_trial / 16384) - 2*floor(sar12_trial / 32768))*1.8
let sar12_previous = @VD_B14[pwl]
let sar12_stimulus = vector(8)
let sar12_stimulus[0] = 0
let sar12_stimulus[1] = sar12_previous[length(sar12_previous)-1]
let sar12_stimulus[2] = 1.8501e-05
let sar12_stimulus[3] = sar12_stimulus[1]
let sar12_stimulus[4] = 1.8503e-05
let sar12_stimulus[5] = sar12_drive
let sar12_stimulus[6] = 0.000148
let sar12_stimulus[7] = sar12_stimulus[5]
alter @VD_B14[pwl] = sar12_stimulus
let sar12_drive = (floor(sar12_trial / 32768) - 2*floor(sar12_trial / 65536))*1.8
let sar12_previous = @VD_B15[pwl]
let sar12_stimulus = vector(8)
let sar12_stimulus[0] = 0
let sar12_stimulus[1] = sar12_previous[length(sar12_previous)-1]
let sar12_stimulus[2] = 1.8501e-05
let sar12_stimulus[3] = sar12_stimulus[1]
let sar12_stimulus[4] = 1.8503e-05
let sar12_stimulus[5] = sar12_drive
let sar12_stimulus[6] = 0.000148
let sar12_stimulus[7] = sar12_stimulus[5]
alter @VD_B15[pwl] = sar12_stimulus
resume
let sar12_k = length(time)-1
if abs(time[sar12_k] - 1.9e-05) > 1e-12
print time[sar12_k]
echo expected_pause_time_s 1.9e-05
echo SAR12_PAUSE_FAILED
quit 1
end
print time[sar12_k] >> pause-times.txt
let sar12_previous = @VD_EVAL[pwl]
let sar12_stimulus = vector(8)
let sar12_stimulus[0] = 0
let sar12_stimulus[1] = sar12_previous[length(sar12_previous)-1]
let sar12_stimulus[2] = 1.9001e-05
let sar12_stimulus[3] = sar12_stimulus[1]
let sar12_stimulus[4] = 1.9003e-05
let sar12_stimulus[5] = 1.8
let sar12_stimulus[6] = 0.000148
let sar12_stimulus[7] = sar12_stimulus[5]
alter @VD_EVAL[pwl] = sar12_stimulus
resume
let sar12_k = length(time)-1
if abs(time[sar12_k] - 1.95e-05) > 1e-12
print time[sar12_k]
echo expected_pause_time_s 1.95e-05
echo SAR12_PAUSE_FAILED
quit 1
end
print time[sar12_k] >> pause-times.txt
let sar12_k = length(time)-1
let sar12_cmp = v(COMP)[sar12_k]
let sar12_cmpn = v(COMPN)[sar12_k]
let sar12_p = v(TOPP)[sar12_k]
let sar12_n = v(TOPN)[sar12_k]
let sar12_decision = 0
if sar12_cmp >= 0.9
let sar12_code = sar12_trial
let sar12_decision = 1
end
echo 0 5 $&sar12_trial $&sar12_cmp $&sar12_cmpn $&sar12_p $&sar12_n 1.8310546875e-05 $&sar12_decision >> decisions.csv
let sar12_previous = @VD_EVAL[pwl]
let sar12_stimulus = vector(8)
let sar12_stimulus[0] = 0
let sar12_stimulus[1] = sar12_previous[length(sar12_previous)-1]
let sar12_stimulus[2] = 1.9501e-05
let sar12_stimulus[3] = sar12_stimulus[1]
let sar12_stimulus[4] = 1.9503e-05
let sar12_stimulus[5] = 0
let sar12_stimulus[6] = 0.000148
let sar12_stimulus[7] = sar12_stimulus[5]
alter @VD_EVAL[pwl] = sar12_stimulus
let sar12_trial = sar12_code + 16
let sar12_drive = (floor(sar12_trial / 1) - 2*floor(sar12_trial / 2))*1.8
let sar12_previous = @VD_B0[pwl]
let sar12_stimulus = vector(8)
let sar12_stimulus[0] = 0
let sar12_stimulus[1] = sar12_previous[length(sar12_previous)-1]
let sar12_stimulus[2] = 1.9501e-05
let sar12_stimulus[3] = sar12_stimulus[1]
let sar12_stimulus[4] = 1.9503e-05
let sar12_stimulus[5] = sar12_drive
let sar12_stimulus[6] = 0.000148
let sar12_stimulus[7] = sar12_stimulus[5]
alter @VD_B0[pwl] = sar12_stimulus
let sar12_drive = (floor(sar12_trial / 2) - 2*floor(sar12_trial / 4))*1.8
let sar12_previous = @VD_B1[pwl]
let sar12_stimulus = vector(8)
let sar12_stimulus[0] = 0
let sar12_stimulus[1] = sar12_previous[length(sar12_previous)-1]
let sar12_stimulus[2] = 1.9501e-05
let sar12_stimulus[3] = sar12_stimulus[1]
let sar12_stimulus[4] = 1.9503e-05
let sar12_stimulus[5] = sar12_drive
let sar12_stimulus[6] = 0.000148
let sar12_stimulus[7] = sar12_stimulus[5]
alter @VD_B1[pwl] = sar12_stimulus
let sar12_drive = (floor(sar12_trial / 4) - 2*floor(sar12_trial / 8))*1.8
let sar12_previous = @VD_B2[pwl]
let sar12_stimulus = vector(8)
let sar12_stimulus[0] = 0
let sar12_stimulus[1] = sar12_previous[length(sar12_previous)-1]
let sar12_stimulus[2] = 1.9501e-05
let sar12_stimulus[3] = sar12_stimulus[1]
let sar12_stimulus[4] = 1.9503e-05
let sar12_stimulus[5] = sar12_drive
let sar12_stimulus[6] = 0.000148
let sar12_stimulus[7] = sar12_stimulus[5]
alter @VD_B2[pwl] = sar12_stimulus
let sar12_drive = (floor(sar12_trial / 8) - 2*floor(sar12_trial / 16))*1.8
let sar12_previous = @VD_B3[pwl]
let sar12_stimulus = vector(8)
let sar12_stimulus[0] = 0
let sar12_stimulus[1] = sar12_previous[length(sar12_previous)-1]
let sar12_stimulus[2] = 1.9501e-05
let sar12_stimulus[3] = sar12_stimulus[1]
let sar12_stimulus[4] = 1.9503e-05
let sar12_stimulus[5] = sar12_drive
let sar12_stimulus[6] = 0.000148
let sar12_stimulus[7] = sar12_stimulus[5]
alter @VD_B3[pwl] = sar12_stimulus
let sar12_drive = (floor(sar12_trial / 16) - 2*floor(sar12_trial / 32))*1.8
let sar12_previous = @VD_B4[pwl]
let sar12_stimulus = vector(8)
let sar12_stimulus[0] = 0
let sar12_stimulus[1] = sar12_previous[length(sar12_previous)-1]
let sar12_stimulus[2] = 1.9501e-05
let sar12_stimulus[3] = sar12_stimulus[1]
let sar12_stimulus[4] = 1.9503e-05
let sar12_stimulus[5] = sar12_drive
let sar12_stimulus[6] = 0.000148
let sar12_stimulus[7] = sar12_stimulus[5]
alter @VD_B4[pwl] = sar12_stimulus
let sar12_drive = (floor(sar12_trial / 32) - 2*floor(sar12_trial / 64))*1.8
let sar12_previous = @VD_B5[pwl]
let sar12_stimulus = vector(8)
let sar12_stimulus[0] = 0
let sar12_stimulus[1] = sar12_previous[length(sar12_previous)-1]
let sar12_stimulus[2] = 1.9501e-05
let sar12_stimulus[3] = sar12_stimulus[1]
let sar12_stimulus[4] = 1.9503e-05
let sar12_stimulus[5] = sar12_drive
let sar12_stimulus[6] = 0.000148
let sar12_stimulus[7] = sar12_stimulus[5]
alter @VD_B5[pwl] = sar12_stimulus
let sar12_drive = (floor(sar12_trial / 64) - 2*floor(sar12_trial / 128))*1.8
let sar12_previous = @VD_B6[pwl]
let sar12_stimulus = vector(8)
let sar12_stimulus[0] = 0
let sar12_stimulus[1] = sar12_previous[length(sar12_previous)-1]
let sar12_stimulus[2] = 1.9501e-05
let sar12_stimulus[3] = sar12_stimulus[1]
let sar12_stimulus[4] = 1.9503e-05
let sar12_stimulus[5] = sar12_drive
let sar12_stimulus[6] = 0.000148
let sar12_stimulus[7] = sar12_stimulus[5]
alter @VD_B6[pwl] = sar12_stimulus
let sar12_drive = (floor(sar12_trial / 128) - 2*floor(sar12_trial / 256))*1.8
let sar12_previous = @VD_B7[pwl]
let sar12_stimulus = vector(8)
let sar12_stimulus[0] = 0
let sar12_stimulus[1] = sar12_previous[length(sar12_previous)-1]
let sar12_stimulus[2] = 1.9501e-05
let sar12_stimulus[3] = sar12_stimulus[1]
let sar12_stimulus[4] = 1.9503e-05
let sar12_stimulus[5] = sar12_drive
let sar12_stimulus[6] = 0.000148
let sar12_stimulus[7] = sar12_stimulus[5]
alter @VD_B7[pwl] = sar12_stimulus
let sar12_drive = (floor(sar12_trial / 256) - 2*floor(sar12_trial / 512))*1.8
let sar12_previous = @VD_B8[pwl]
let sar12_stimulus = vector(8)
let sar12_stimulus[0] = 0
let sar12_stimulus[1] = sar12_previous[length(sar12_previous)-1]
let sar12_stimulus[2] = 1.9501e-05
let sar12_stimulus[3] = sar12_stimulus[1]
let sar12_stimulus[4] = 1.9503e-05
let sar12_stimulus[5] = sar12_drive
let sar12_stimulus[6] = 0.000148
let sar12_stimulus[7] = sar12_stimulus[5]
alter @VD_B8[pwl] = sar12_stimulus
let sar12_drive = (floor(sar12_trial / 512) - 2*floor(sar12_trial / 1024))*1.8
let sar12_previous = @VD_B9[pwl]
let sar12_stimulus = vector(8)
let sar12_stimulus[0] = 0
let sar12_stimulus[1] = sar12_previous[length(sar12_previous)-1]
let sar12_stimulus[2] = 1.9501e-05
let sar12_stimulus[3] = sar12_stimulus[1]
let sar12_stimulus[4] = 1.9503e-05
let sar12_stimulus[5] = sar12_drive
let sar12_stimulus[6] = 0.000148
let sar12_stimulus[7] = sar12_stimulus[5]
alter @VD_B9[pwl] = sar12_stimulus
let sar12_drive = (floor(sar12_trial / 1024) - 2*floor(sar12_trial / 2048))*1.8
let sar12_previous = @VD_B10[pwl]
let sar12_stimulus = vector(8)
let sar12_stimulus[0] = 0
let sar12_stimulus[1] = sar12_previous[length(sar12_previous)-1]
let sar12_stimulus[2] = 1.9501e-05
let sar12_stimulus[3] = sar12_stimulus[1]
let sar12_stimulus[4] = 1.9503e-05
let sar12_stimulus[5] = sar12_drive
let sar12_stimulus[6] = 0.000148
let sar12_stimulus[7] = sar12_stimulus[5]
alter @VD_B10[pwl] = sar12_stimulus
let sar12_drive = (floor(sar12_trial / 2048) - 2*floor(sar12_trial / 4096))*1.8
let sar12_previous = @VD_B11[pwl]
let sar12_stimulus = vector(8)
let sar12_stimulus[0] = 0
let sar12_stimulus[1] = sar12_previous[length(sar12_previous)-1]
let sar12_stimulus[2] = 1.9501e-05
let sar12_stimulus[3] = sar12_stimulus[1]
let sar12_stimulus[4] = 1.9503e-05
let sar12_stimulus[5] = sar12_drive
let sar12_stimulus[6] = 0.000148
let sar12_stimulus[7] = sar12_stimulus[5]
alter @VD_B11[pwl] = sar12_stimulus
let sar12_drive = (floor(sar12_trial / 4096) - 2*floor(sar12_trial / 8192))*1.8
let sar12_previous = @VD_B12[pwl]
let sar12_stimulus = vector(8)
let sar12_stimulus[0] = 0
let sar12_stimulus[1] = sar12_previous[length(sar12_previous)-1]
let sar12_stimulus[2] = 1.9501e-05
let sar12_stimulus[3] = sar12_stimulus[1]
let sar12_stimulus[4] = 1.9503e-05
let sar12_stimulus[5] = sar12_drive
let sar12_stimulus[6] = 0.000148
let sar12_stimulus[7] = sar12_stimulus[5]
alter @VD_B12[pwl] = sar12_stimulus
let sar12_drive = (floor(sar12_trial / 8192) - 2*floor(sar12_trial / 16384))*1.8
let sar12_previous = @VD_B13[pwl]
let sar12_stimulus = vector(8)
let sar12_stimulus[0] = 0
let sar12_stimulus[1] = sar12_previous[length(sar12_previous)-1]
let sar12_stimulus[2] = 1.9501e-05
let sar12_stimulus[3] = sar12_stimulus[1]
let sar12_stimulus[4] = 1.9503e-05
let sar12_stimulus[5] = sar12_drive
let sar12_stimulus[6] = 0.000148
let sar12_stimulus[7] = sar12_stimulus[5]
alter @VD_B13[pwl] = sar12_stimulus
let sar12_drive = (floor(sar12_trial / 16384) - 2*floor(sar12_trial / 32768))*1.8
let sar12_previous = @VD_B14[pwl]
let sar12_stimulus = vector(8)
let sar12_stimulus[0] = 0
let sar12_stimulus[1] = sar12_previous[length(sar12_previous)-1]
let sar12_stimulus[2] = 1.9501e-05
let sar12_stimulus[3] = sar12_stimulus[1]
let sar12_stimulus[4] = 1.9503e-05
let sar12_stimulus[5] = sar12_drive
let sar12_stimulus[6] = 0.000148
let sar12_stimulus[7] = sar12_stimulus[5]
alter @VD_B14[pwl] = sar12_stimulus
let sar12_drive = (floor(sar12_trial / 32768) - 2*floor(sar12_trial / 65536))*1.8
let sar12_previous = @VD_B15[pwl]
let sar12_stimulus = vector(8)
let sar12_stimulus[0] = 0
let sar12_stimulus[1] = sar12_previous[length(sar12_previous)-1]
let sar12_stimulus[2] = 1.9501e-05
let sar12_stimulus[3] = sar12_stimulus[1]
let sar12_stimulus[4] = 1.9503e-05
let sar12_stimulus[5] = sar12_drive
let sar12_stimulus[6] = 0.000148
let sar12_stimulus[7] = sar12_stimulus[5]
alter @VD_B15[pwl] = sar12_stimulus
resume
let sar12_k = length(time)-1
if abs(time[sar12_k] - 2e-05) > 1e-12
print time[sar12_k]
echo expected_pause_time_s 2e-05
echo SAR12_PAUSE_FAILED
quit 1
end
print time[sar12_k] >> pause-times.txt
let sar12_previous = @VD_EVAL[pwl]
let sar12_stimulus = vector(8)
let sar12_stimulus[0] = 0
let sar12_stimulus[1] = sar12_previous[length(sar12_previous)-1]
let sar12_stimulus[2] = 2.0001e-05
let sar12_stimulus[3] = sar12_stimulus[1]
let sar12_stimulus[4] = 2.0003e-05
let sar12_stimulus[5] = 1.8
let sar12_stimulus[6] = 0.000148
let sar12_stimulus[7] = sar12_stimulus[5]
alter @VD_EVAL[pwl] = sar12_stimulus
resume
let sar12_k = length(time)-1
if abs(time[sar12_k] - 2.05e-05) > 1e-12
print time[sar12_k]
echo expected_pause_time_s 2.05e-05
echo SAR12_PAUSE_FAILED
quit 1
end
print time[sar12_k] >> pause-times.txt
let sar12_k = length(time)-1
let sar12_cmp = v(COMP)[sar12_k]
let sar12_cmpn = v(COMPN)[sar12_k]
let sar12_p = v(TOPP)[sar12_k]
let sar12_n = v(TOPN)[sar12_k]
let sar12_decision = 0
if sar12_cmp >= 0.9
let sar12_code = sar12_trial
let sar12_decision = 1
end
echo 0 4 $&sar12_trial $&sar12_cmp $&sar12_cmpn $&sar12_p $&sar12_n 1.8310546875e-05 $&sar12_decision >> decisions.csv
let sar12_previous = @VD_EVAL[pwl]
let sar12_stimulus = vector(8)
let sar12_stimulus[0] = 0
let sar12_stimulus[1] = sar12_previous[length(sar12_previous)-1]
let sar12_stimulus[2] = 2.0501e-05
let sar12_stimulus[3] = sar12_stimulus[1]
let sar12_stimulus[4] = 2.0503e-05
let sar12_stimulus[5] = 0
let sar12_stimulus[6] = 0.000148
let sar12_stimulus[7] = sar12_stimulus[5]
alter @VD_EVAL[pwl] = sar12_stimulus
let sar12_trial = sar12_code + 8
let sar12_drive = (floor(sar12_trial / 1) - 2*floor(sar12_trial / 2))*1.8
let sar12_previous = @VD_B0[pwl]
let sar12_stimulus = vector(8)
let sar12_stimulus[0] = 0
let sar12_stimulus[1] = sar12_previous[length(sar12_previous)-1]
let sar12_stimulus[2] = 2.0501e-05
let sar12_stimulus[3] = sar12_stimulus[1]
let sar12_stimulus[4] = 2.0503e-05
let sar12_stimulus[5] = sar12_drive
let sar12_stimulus[6] = 0.000148
let sar12_stimulus[7] = sar12_stimulus[5]
alter @VD_B0[pwl] = sar12_stimulus
let sar12_drive = (floor(sar12_trial / 2) - 2*floor(sar12_trial / 4))*1.8
let sar12_previous = @VD_B1[pwl]
let sar12_stimulus = vector(8)
let sar12_stimulus[0] = 0
let sar12_stimulus[1] = sar12_previous[length(sar12_previous)-1]
let sar12_stimulus[2] = 2.0501e-05
let sar12_stimulus[3] = sar12_stimulus[1]
let sar12_stimulus[4] = 2.0503e-05
let sar12_stimulus[5] = sar12_drive
let sar12_stimulus[6] = 0.000148
let sar12_stimulus[7] = sar12_stimulus[5]
alter @VD_B1[pwl] = sar12_stimulus
let sar12_drive = (floor(sar12_trial / 4) - 2*floor(sar12_trial / 8))*1.8
let sar12_previous = @VD_B2[pwl]
let sar12_stimulus = vector(8)
let sar12_stimulus[0] = 0
let sar12_stimulus[1] = sar12_previous[length(sar12_previous)-1]
let sar12_stimulus[2] = 2.0501e-05
let sar12_stimulus[3] = sar12_stimulus[1]
let sar12_stimulus[4] = 2.0503e-05
let sar12_stimulus[5] = sar12_drive
let sar12_stimulus[6] = 0.000148
let sar12_stimulus[7] = sar12_stimulus[5]
alter @VD_B2[pwl] = sar12_stimulus
let sar12_drive = (floor(sar12_trial / 8) - 2*floor(sar12_trial / 16))*1.8
let sar12_previous = @VD_B3[pwl]
let sar12_stimulus = vector(8)
let sar12_stimulus[0] = 0
let sar12_stimulus[1] = sar12_previous[length(sar12_previous)-1]
let sar12_stimulus[2] = 2.0501e-05
let sar12_stimulus[3] = sar12_stimulus[1]
let sar12_stimulus[4] = 2.0503e-05
let sar12_stimulus[5] = sar12_drive
let sar12_stimulus[6] = 0.000148
let sar12_stimulus[7] = sar12_stimulus[5]
alter @VD_B3[pwl] = sar12_stimulus
let sar12_drive = (floor(sar12_trial / 16) - 2*floor(sar12_trial / 32))*1.8
let sar12_previous = @VD_B4[pwl]
let sar12_stimulus = vector(8)
let sar12_stimulus[0] = 0
let sar12_stimulus[1] = sar12_previous[length(sar12_previous)-1]
let sar12_stimulus[2] = 2.0501e-05
let sar12_stimulus[3] = sar12_stimulus[1]
let sar12_stimulus[4] = 2.0503e-05
let sar12_stimulus[5] = sar12_drive
let sar12_stimulus[6] = 0.000148
let sar12_stimulus[7] = sar12_stimulus[5]
alter @VD_B4[pwl] = sar12_stimulus
let sar12_drive = (floor(sar12_trial / 32) - 2*floor(sar12_trial / 64))*1.8
let sar12_previous = @VD_B5[pwl]
let sar12_stimulus = vector(8)
let sar12_stimulus[0] = 0
let sar12_stimulus[1] = sar12_previous[length(sar12_previous)-1]
let sar12_stimulus[2] = 2.0501e-05
let sar12_stimulus[3] = sar12_stimulus[1]
let sar12_stimulus[4] = 2.0503e-05
let sar12_stimulus[5] = sar12_drive
let sar12_stimulus[6] = 0.000148
let sar12_stimulus[7] = sar12_stimulus[5]
alter @VD_B5[pwl] = sar12_stimulus
let sar12_drive = (floor(sar12_trial / 64) - 2*floor(sar12_trial / 128))*1.8
let sar12_previous = @VD_B6[pwl]
let sar12_stimulus = vector(8)
let sar12_stimulus[0] = 0
let sar12_stimulus[1] = sar12_previous[length(sar12_previous)-1]
let sar12_stimulus[2] = 2.0501e-05
let sar12_stimulus[3] = sar12_stimulus[1]
let sar12_stimulus[4] = 2.0503e-05
let sar12_stimulus[5] = sar12_drive
let sar12_stimulus[6] = 0.000148
let sar12_stimulus[7] = sar12_stimulus[5]
alter @VD_B6[pwl] = sar12_stimulus
let sar12_drive = (floor(sar12_trial / 128) - 2*floor(sar12_trial / 256))*1.8
let sar12_previous = @VD_B7[pwl]
let sar12_stimulus = vector(8)
let sar12_stimulus[0] = 0
let sar12_stimulus[1] = sar12_previous[length(sar12_previous)-1]
let sar12_stimulus[2] = 2.0501e-05
let sar12_stimulus[3] = sar12_stimulus[1]
let sar12_stimulus[4] = 2.0503e-05
let sar12_stimulus[5] = sar12_drive
let sar12_stimulus[6] = 0.000148
let sar12_stimulus[7] = sar12_stimulus[5]
alter @VD_B7[pwl] = sar12_stimulus
let sar12_drive = (floor(sar12_trial / 256) - 2*floor(sar12_trial / 512))*1.8
let sar12_previous = @VD_B8[pwl]
let sar12_stimulus = vector(8)
let sar12_stimulus[0] = 0
let sar12_stimulus[1] = sar12_previous[length(sar12_previous)-1]
let sar12_stimulus[2] = 2.0501e-05
let sar12_stimulus[3] = sar12_stimulus[1]
let sar12_stimulus[4] = 2.0503e-05
let sar12_stimulus[5] = sar12_drive
let sar12_stimulus[6] = 0.000148
let sar12_stimulus[7] = sar12_stimulus[5]
alter @VD_B8[pwl] = sar12_stimulus
let sar12_drive = (floor(sar12_trial / 512) - 2*floor(sar12_trial / 1024))*1.8
let sar12_previous = @VD_B9[pwl]
let sar12_stimulus = vector(8)
let sar12_stimulus[0] = 0
let sar12_stimulus[1] = sar12_previous[length(sar12_previous)-1]
let sar12_stimulus[2] = 2.0501e-05
let sar12_stimulus[3] = sar12_stimulus[1]
let sar12_stimulus[4] = 2.0503e-05
let sar12_stimulus[5] = sar12_drive
let sar12_stimulus[6] = 0.000148
let sar12_stimulus[7] = sar12_stimulus[5]
alter @VD_B9[pwl] = sar12_stimulus
let sar12_drive = (floor(sar12_trial / 1024) - 2*floor(sar12_trial / 2048))*1.8
let sar12_previous = @VD_B10[pwl]
let sar12_stimulus = vector(8)
let sar12_stimulus[0] = 0
let sar12_stimulus[1] = sar12_previous[length(sar12_previous)-1]
let sar12_stimulus[2] = 2.0501e-05
let sar12_stimulus[3] = sar12_stimulus[1]
let sar12_stimulus[4] = 2.0503e-05
let sar12_stimulus[5] = sar12_drive
let sar12_stimulus[6] = 0.000148
let sar12_stimulus[7] = sar12_stimulus[5]
alter @VD_B10[pwl] = sar12_stimulus
let sar12_drive = (floor(sar12_trial / 2048) - 2*floor(sar12_trial / 4096))*1.8
let sar12_previous = @VD_B11[pwl]
let sar12_stimulus = vector(8)
let sar12_stimulus[0] = 0
let sar12_stimulus[1] = sar12_previous[length(sar12_previous)-1]
let sar12_stimulus[2] = 2.0501e-05
let sar12_stimulus[3] = sar12_stimulus[1]
let sar12_stimulus[4] = 2.0503e-05
let sar12_stimulus[5] = sar12_drive
let sar12_stimulus[6] = 0.000148
let sar12_stimulus[7] = sar12_stimulus[5]
alter @VD_B11[pwl] = sar12_stimulus
let sar12_drive = (floor(sar12_trial / 4096) - 2*floor(sar12_trial / 8192))*1.8
let sar12_previous = @VD_B12[pwl]
let sar12_stimulus = vector(8)
let sar12_stimulus[0] = 0
let sar12_stimulus[1] = sar12_previous[length(sar12_previous)-1]
let sar12_stimulus[2] = 2.0501e-05
let sar12_stimulus[3] = sar12_stimulus[1]
let sar12_stimulus[4] = 2.0503e-05
let sar12_stimulus[5] = sar12_drive
let sar12_stimulus[6] = 0.000148
let sar12_stimulus[7] = sar12_stimulus[5]
alter @VD_B12[pwl] = sar12_stimulus
let sar12_drive = (floor(sar12_trial / 8192) - 2*floor(sar12_trial / 16384))*1.8
let sar12_previous = @VD_B13[pwl]
let sar12_stimulus = vector(8)
let sar12_stimulus[0] = 0
let sar12_stimulus[1] = sar12_previous[length(sar12_previous)-1]
let sar12_stimulus[2] = 2.0501e-05
let sar12_stimulus[3] = sar12_stimulus[1]
let sar12_stimulus[4] = 2.0503e-05
let sar12_stimulus[5] = sar12_drive
let sar12_stimulus[6] = 0.000148
let sar12_stimulus[7] = sar12_stimulus[5]
alter @VD_B13[pwl] = sar12_stimulus
let sar12_drive = (floor(sar12_trial / 16384) - 2*floor(sar12_trial / 32768))*1.8
let sar12_previous = @VD_B14[pwl]
let sar12_stimulus = vector(8)
let sar12_stimulus[0] = 0
let sar12_stimulus[1] = sar12_previous[length(sar12_previous)-1]
let sar12_stimulus[2] = 2.0501e-05
let sar12_stimulus[3] = sar12_stimulus[1]
let sar12_stimulus[4] = 2.0503e-05
let sar12_stimulus[5] = sar12_drive
let sar12_stimulus[6] = 0.000148
let sar12_stimulus[7] = sar12_stimulus[5]
alter @VD_B14[pwl] = sar12_stimulus
let sar12_drive = (floor(sar12_trial / 32768) - 2*floor(sar12_trial / 65536))*1.8
let sar12_previous = @VD_B15[pwl]
let sar12_stimulus = vector(8)
let sar12_stimulus[0] = 0
let sar12_stimulus[1] = sar12_previous[length(sar12_previous)-1]
let sar12_stimulus[2] = 2.0501e-05
let sar12_stimulus[3] = sar12_stimulus[1]
let sar12_stimulus[4] = 2.0503e-05
let sar12_stimulus[5] = sar12_drive
let sar12_stimulus[6] = 0.000148
let sar12_stimulus[7] = sar12_stimulus[5]
alter @VD_B15[pwl] = sar12_stimulus
resume
let sar12_k = length(time)-1
if abs(time[sar12_k] - 2.1e-05) > 1e-12
print time[sar12_k]
echo expected_pause_time_s 2.1e-05
echo SAR12_PAUSE_FAILED
quit 1
end
print time[sar12_k] >> pause-times.txt
let sar12_previous = @VD_EVAL[pwl]
let sar12_stimulus = vector(8)
let sar12_stimulus[0] = 0
let sar12_stimulus[1] = sar12_previous[length(sar12_previous)-1]
let sar12_stimulus[2] = 2.1001e-05
let sar12_stimulus[3] = sar12_stimulus[1]
let sar12_stimulus[4] = 2.1003e-05
let sar12_stimulus[5] = 1.8
let sar12_stimulus[6] = 0.000148
let sar12_stimulus[7] = sar12_stimulus[5]
alter @VD_EVAL[pwl] = sar12_stimulus
resume
let sar12_k = length(time)-1
if abs(time[sar12_k] - 2.15e-05) > 1e-12
print time[sar12_k]
echo expected_pause_time_s 2.15e-05
echo SAR12_PAUSE_FAILED
quit 1
end
print time[sar12_k] >> pause-times.txt
let sar12_k = length(time)-1
let sar12_cmp = v(COMP)[sar12_k]
let sar12_cmpn = v(COMPN)[sar12_k]
let sar12_p = v(TOPP)[sar12_k]
let sar12_n = v(TOPN)[sar12_k]
let sar12_decision = 0
if sar12_cmp >= 0.9
let sar12_code = sar12_trial
let sar12_decision = 1
end
echo 0 3 $&sar12_trial $&sar12_cmp $&sar12_cmpn $&sar12_p $&sar12_n 1.8310546875e-05 $&sar12_decision >> decisions.csv
let sar12_previous = @VD_EVAL[pwl]
let sar12_stimulus = vector(8)
let sar12_stimulus[0] = 0
let sar12_stimulus[1] = sar12_previous[length(sar12_previous)-1]
let sar12_stimulus[2] = 2.1501e-05
let sar12_stimulus[3] = sar12_stimulus[1]
let sar12_stimulus[4] = 2.1503e-05
let sar12_stimulus[5] = 0
let sar12_stimulus[6] = 0.000148
let sar12_stimulus[7] = sar12_stimulus[5]
alter @VD_EVAL[pwl] = sar12_stimulus
let sar12_trial = sar12_code + 4
let sar12_drive = (floor(sar12_trial / 1) - 2*floor(sar12_trial / 2))*1.8
let sar12_previous = @VD_B0[pwl]
let sar12_stimulus = vector(8)
let sar12_stimulus[0] = 0
let sar12_stimulus[1] = sar12_previous[length(sar12_previous)-1]
let sar12_stimulus[2] = 2.1501e-05
let sar12_stimulus[3] = sar12_stimulus[1]
let sar12_stimulus[4] = 2.1503e-05
let sar12_stimulus[5] = sar12_drive
let sar12_stimulus[6] = 0.000148
let sar12_stimulus[7] = sar12_stimulus[5]
alter @VD_B0[pwl] = sar12_stimulus
let sar12_drive = (floor(sar12_trial / 2) - 2*floor(sar12_trial / 4))*1.8
let sar12_previous = @VD_B1[pwl]
let sar12_stimulus = vector(8)
let sar12_stimulus[0] = 0
let sar12_stimulus[1] = sar12_previous[length(sar12_previous)-1]
let sar12_stimulus[2] = 2.1501e-05
let sar12_stimulus[3] = sar12_stimulus[1]
let sar12_stimulus[4] = 2.1503e-05
let sar12_stimulus[5] = sar12_drive
let sar12_stimulus[6] = 0.000148
let sar12_stimulus[7] = sar12_stimulus[5]
alter @VD_B1[pwl] = sar12_stimulus
let sar12_drive = (floor(sar12_trial / 4) - 2*floor(sar12_trial / 8))*1.8
let sar12_previous = @VD_B2[pwl]
let sar12_stimulus = vector(8)
let sar12_stimulus[0] = 0
let sar12_stimulus[1] = sar12_previous[length(sar12_previous)-1]
let sar12_stimulus[2] = 2.1501e-05
let sar12_stimulus[3] = sar12_stimulus[1]
let sar12_stimulus[4] = 2.1503e-05
let sar12_stimulus[5] = sar12_drive
let sar12_stimulus[6] = 0.000148
let sar12_stimulus[7] = sar12_stimulus[5]
alter @VD_B2[pwl] = sar12_stimulus
let sar12_drive = (floor(sar12_trial / 8) - 2*floor(sar12_trial / 16))*1.8
let sar12_previous = @VD_B3[pwl]
let sar12_stimulus = vector(8)
let sar12_stimulus[0] = 0
let sar12_stimulus[1] = sar12_previous[length(sar12_previous)-1]
let sar12_stimulus[2] = 2.1501e-05
let sar12_stimulus[3] = sar12_stimulus[1]
let sar12_stimulus[4] = 2.1503e-05
let sar12_stimulus[5] = sar12_drive
let sar12_stimulus[6] = 0.000148
let sar12_stimulus[7] = sar12_stimulus[5]
alter @VD_B3[pwl] = sar12_stimulus
let sar12_drive = (floor(sar12_trial / 16) - 2*floor(sar12_trial / 32))*1.8
let sar12_previous = @VD_B4[pwl]
let sar12_stimulus = vector(8)
let sar12_stimulus[0] = 0
let sar12_stimulus[1] = sar12_previous[length(sar12_previous)-1]
let sar12_stimulus[2] = 2.1501e-05
let sar12_stimulus[3] = sar12_stimulus[1]
let sar12_stimulus[4] = 2.1503e-05
let sar12_stimulus[5] = sar12_drive
let sar12_stimulus[6] = 0.000148
let sar12_stimulus[7] = sar12_stimulus[5]
alter @VD_B4[pwl] = sar12_stimulus
let sar12_drive = (floor(sar12_trial / 32) - 2*floor(sar12_trial / 64))*1.8
let sar12_previous = @VD_B5[pwl]
let sar12_stimulus = vector(8)
let sar12_stimulus[0] = 0
let sar12_stimulus[1] = sar12_previous[length(sar12_previous)-1]
let sar12_stimulus[2] = 2.1501e-05
let sar12_stimulus[3] = sar12_stimulus[1]
let sar12_stimulus[4] = 2.1503e-05
let sar12_stimulus[5] = sar12_drive
let sar12_stimulus[6] = 0.000148
let sar12_stimulus[7] = sar12_stimulus[5]
alter @VD_B5[pwl] = sar12_stimulus
let sar12_drive = (floor(sar12_trial / 64) - 2*floor(sar12_trial / 128))*1.8
let sar12_previous = @VD_B6[pwl]
let sar12_stimulus = vector(8)
let sar12_stimulus[0] = 0
let sar12_stimulus[1] = sar12_previous[length(sar12_previous)-1]
let sar12_stimulus[2] = 2.1501e-05
let sar12_stimulus[3] = sar12_stimulus[1]
let sar12_stimulus[4] = 2.1503e-05
let sar12_stimulus[5] = sar12_drive
let sar12_stimulus[6] = 0.000148
let sar12_stimulus[7] = sar12_stimulus[5]
alter @VD_B6[pwl] = sar12_stimulus
let sar12_drive = (floor(sar12_trial / 128) - 2*floor(sar12_trial / 256))*1.8
let sar12_previous = @VD_B7[pwl]
let sar12_stimulus = vector(8)
let sar12_stimulus[0] = 0
let sar12_stimulus[1] = sar12_previous[length(sar12_previous)-1]
let sar12_stimulus[2] = 2.1501e-05
let sar12_stimulus[3] = sar12_stimulus[1]
let sar12_stimulus[4] = 2.1503e-05
let sar12_stimulus[5] = sar12_drive
let sar12_stimulus[6] = 0.000148
let sar12_stimulus[7] = sar12_stimulus[5]
alter @VD_B7[pwl] = sar12_stimulus
let sar12_drive = (floor(sar12_trial / 256) - 2*floor(sar12_trial / 512))*1.8
let sar12_previous = @VD_B8[pwl]
let sar12_stimulus = vector(8)
let sar12_stimulus[0] = 0
let sar12_stimulus[1] = sar12_previous[length(sar12_previous)-1]
let sar12_stimulus[2] = 2.1501e-05
let sar12_stimulus[3] = sar12_stimulus[1]
let sar12_stimulus[4] = 2.1503e-05
let sar12_stimulus[5] = sar12_drive
let sar12_stimulus[6] = 0.000148
let sar12_stimulus[7] = sar12_stimulus[5]
alter @VD_B8[pwl] = sar12_stimulus
let sar12_drive = (floor(sar12_trial / 512) - 2*floor(sar12_trial / 1024))*1.8
let sar12_previous = @VD_B9[pwl]
let sar12_stimulus = vector(8)
let sar12_stimulus[0] = 0
let sar12_stimulus[1] = sar12_previous[length(sar12_previous)-1]
let sar12_stimulus[2] = 2.1501e-05
let sar12_stimulus[3] = sar12_stimulus[1]
let sar12_stimulus[4] = 2.1503e-05
let sar12_stimulus[5] = sar12_drive
let sar12_stimulus[6] = 0.000148
let sar12_stimulus[7] = sar12_stimulus[5]
alter @VD_B9[pwl] = sar12_stimulus
let sar12_drive = (floor(sar12_trial / 1024) - 2*floor(sar12_trial / 2048))*1.8
let sar12_previous = @VD_B10[pwl]
let sar12_stimulus = vector(8)
let sar12_stimulus[0] = 0
let sar12_stimulus[1] = sar12_previous[length(sar12_previous)-1]
let sar12_stimulus[2] = 2.1501e-05
let sar12_stimulus[3] = sar12_stimulus[1]
let sar12_stimulus[4] = 2.1503e-05
let sar12_stimulus[5] = sar12_drive
let sar12_stimulus[6] = 0.000148
let sar12_stimulus[7] = sar12_stimulus[5]
alter @VD_B10[pwl] = sar12_stimulus
let sar12_drive = (floor(sar12_trial / 2048) - 2*floor(sar12_trial / 4096))*1.8
let sar12_previous = @VD_B11[pwl]
let sar12_stimulus = vector(8)
let sar12_stimulus[0] = 0
let sar12_stimulus[1] = sar12_previous[length(sar12_previous)-1]
let sar12_stimulus[2] = 2.1501e-05
let sar12_stimulus[3] = sar12_stimulus[1]
let sar12_stimulus[4] = 2.1503e-05
let sar12_stimulus[5] = sar12_drive
let sar12_stimulus[6] = 0.000148
let sar12_stimulus[7] = sar12_stimulus[5]
alter @VD_B11[pwl] = sar12_stimulus
let sar12_drive = (floor(sar12_trial / 4096) - 2*floor(sar12_trial / 8192))*1.8
let sar12_previous = @VD_B12[pwl]
let sar12_stimulus = vector(8)
let sar12_stimulus[0] = 0
let sar12_stimulus[1] = sar12_previous[length(sar12_previous)-1]
let sar12_stimulus[2] = 2.1501e-05
let sar12_stimulus[3] = sar12_stimulus[1]
let sar12_stimulus[4] = 2.1503e-05
let sar12_stimulus[5] = sar12_drive
let sar12_stimulus[6] = 0.000148
let sar12_stimulus[7] = sar12_stimulus[5]
alter @VD_B12[pwl] = sar12_stimulus
let sar12_drive = (floor(sar12_trial / 8192) - 2*floor(sar12_trial / 16384))*1.8
let sar12_previous = @VD_B13[pwl]
let sar12_stimulus = vector(8)
let sar12_stimulus[0] = 0
let sar12_stimulus[1] = sar12_previous[length(sar12_previous)-1]
let sar12_stimulus[2] = 2.1501e-05
let sar12_stimulus[3] = sar12_stimulus[1]
let sar12_stimulus[4] = 2.1503e-05
let sar12_stimulus[5] = sar12_drive
let sar12_stimulus[6] = 0.000148
let sar12_stimulus[7] = sar12_stimulus[5]
alter @VD_B13[pwl] = sar12_stimulus
let sar12_drive = (floor(sar12_trial / 16384) - 2*floor(sar12_trial / 32768))*1.8
let sar12_previous = @VD_B14[pwl]
let sar12_stimulus = vector(8)
let sar12_stimulus[0] = 0
let sar12_stimulus[1] = sar12_previous[length(sar12_previous)-1]
let sar12_stimulus[2] = 2.1501e-05
let sar12_stimulus[3] = sar12_stimulus[1]
let sar12_stimulus[4] = 2.1503e-05
let sar12_stimulus[5] = sar12_drive
let sar12_stimulus[6] = 0.000148
let sar12_stimulus[7] = sar12_stimulus[5]
alter @VD_B14[pwl] = sar12_stimulus
let sar12_drive = (floor(sar12_trial / 32768) - 2*floor(sar12_trial / 65536))*1.8
let sar12_previous = @VD_B15[pwl]
let sar12_stimulus = vector(8)
let sar12_stimulus[0] = 0
let sar12_stimulus[1] = sar12_previous[length(sar12_previous)-1]
let sar12_stimulus[2] = 2.1501e-05
let sar12_stimulus[3] = sar12_stimulus[1]
let sar12_stimulus[4] = 2.1503e-05
let sar12_stimulus[5] = sar12_drive
let sar12_stimulus[6] = 0.000148
let sar12_stimulus[7] = sar12_stimulus[5]
alter @VD_B15[pwl] = sar12_stimulus
resume
let sar12_k = length(time)-1
if abs(time[sar12_k] - 2.2e-05) > 1e-12
print time[sar12_k]
echo expected_pause_time_s 2.2e-05
echo SAR12_PAUSE_FAILED
quit 1
end
print time[sar12_k] >> pause-times.txt
let sar12_previous = @VD_EVAL[pwl]
let sar12_stimulus = vector(8)
let sar12_stimulus[0] = 0
let sar12_stimulus[1] = sar12_previous[length(sar12_previous)-1]
let sar12_stimulus[2] = 2.2001e-05
let sar12_stimulus[3] = sar12_stimulus[1]
let sar12_stimulus[4] = 2.2003e-05
let sar12_stimulus[5] = 1.8
let sar12_stimulus[6] = 0.000148
let sar12_stimulus[7] = sar12_stimulus[5]
alter @VD_EVAL[pwl] = sar12_stimulus
resume
let sar12_k = length(time)-1
if abs(time[sar12_k] - 2.25e-05) > 1e-12
print time[sar12_k]
echo expected_pause_time_s 2.25e-05
echo SAR12_PAUSE_FAILED
quit 1
end
print time[sar12_k] >> pause-times.txt
let sar12_k = length(time)-1
let sar12_cmp = v(COMP)[sar12_k]
let sar12_cmpn = v(COMPN)[sar12_k]
let sar12_p = v(TOPP)[sar12_k]
let sar12_n = v(TOPN)[sar12_k]
let sar12_decision = 0
if sar12_cmp >= 0.9
let sar12_code = sar12_trial
let sar12_decision = 1
end
echo 0 2 $&sar12_trial $&sar12_cmp $&sar12_cmpn $&sar12_p $&sar12_n 1.8310546875e-05 $&sar12_decision >> decisions.csv
let sar12_previous = @VD_EVAL[pwl]
let sar12_stimulus = vector(8)
let sar12_stimulus[0] = 0
let sar12_stimulus[1] = sar12_previous[length(sar12_previous)-1]
let sar12_stimulus[2] = 2.2501e-05
let sar12_stimulus[3] = sar12_stimulus[1]
let sar12_stimulus[4] = 2.2503e-05
let sar12_stimulus[5] = 0
let sar12_stimulus[6] = 0.000148
let sar12_stimulus[7] = sar12_stimulus[5]
alter @VD_EVAL[pwl] = sar12_stimulus
let sar12_trial = sar12_code + 2
let sar12_drive = (floor(sar12_trial / 1) - 2*floor(sar12_trial / 2))*1.8
let sar12_previous = @VD_B0[pwl]
let sar12_stimulus = vector(8)
let sar12_stimulus[0] = 0
let sar12_stimulus[1] = sar12_previous[length(sar12_previous)-1]
let sar12_stimulus[2] = 2.2501e-05
let sar12_stimulus[3] = sar12_stimulus[1]
let sar12_stimulus[4] = 2.2503e-05
let sar12_stimulus[5] = sar12_drive
let sar12_stimulus[6] = 0.000148
let sar12_stimulus[7] = sar12_stimulus[5]
alter @VD_B0[pwl] = sar12_stimulus
let sar12_drive = (floor(sar12_trial / 2) - 2*floor(sar12_trial / 4))*1.8
let sar12_previous = @VD_B1[pwl]
let sar12_stimulus = vector(8)
let sar12_stimulus[0] = 0
let sar12_stimulus[1] = sar12_previous[length(sar12_previous)-1]
let sar12_stimulus[2] = 2.2501e-05
let sar12_stimulus[3] = sar12_stimulus[1]
let sar12_stimulus[4] = 2.2503e-05
let sar12_stimulus[5] = sar12_drive
let sar12_stimulus[6] = 0.000148
let sar12_stimulus[7] = sar12_stimulus[5]
alter @VD_B1[pwl] = sar12_stimulus
let sar12_drive = (floor(sar12_trial / 4) - 2*floor(sar12_trial / 8))*1.8
let sar12_previous = @VD_B2[pwl]
let sar12_stimulus = vector(8)
let sar12_stimulus[0] = 0
let sar12_stimulus[1] = sar12_previous[length(sar12_previous)-1]
let sar12_stimulus[2] = 2.2501e-05
let sar12_stimulus[3] = sar12_stimulus[1]
let sar12_stimulus[4] = 2.2503e-05
let sar12_stimulus[5] = sar12_drive
let sar12_stimulus[6] = 0.000148
let sar12_stimulus[7] = sar12_stimulus[5]
alter @VD_B2[pwl] = sar12_stimulus
let sar12_drive = (floor(sar12_trial / 8) - 2*floor(sar12_trial / 16))*1.8
let sar12_previous = @VD_B3[pwl]
let sar12_stimulus = vector(8)
let sar12_stimulus[0] = 0
let sar12_stimulus[1] = sar12_previous[length(sar12_previous)-1]
let sar12_stimulus[2] = 2.2501e-05
let sar12_stimulus[3] = sar12_stimulus[1]
let sar12_stimulus[4] = 2.2503e-05
let sar12_stimulus[5] = sar12_drive
let sar12_stimulus[6] = 0.000148
let sar12_stimulus[7] = sar12_stimulus[5]
alter @VD_B3[pwl] = sar12_stimulus
let sar12_drive = (floor(sar12_trial / 16) - 2*floor(sar12_trial / 32))*1.8
let sar12_previous = @VD_B4[pwl]
let sar12_stimulus = vector(8)
let sar12_stimulus[0] = 0
let sar12_stimulus[1] = sar12_previous[length(sar12_previous)-1]
let sar12_stimulus[2] = 2.2501e-05
let sar12_stimulus[3] = sar12_stimulus[1]
let sar12_stimulus[4] = 2.2503e-05
let sar12_stimulus[5] = sar12_drive
let sar12_stimulus[6] = 0.000148
let sar12_stimulus[7] = sar12_stimulus[5]
alter @VD_B4[pwl] = sar12_stimulus
let sar12_drive = (floor(sar12_trial / 32) - 2*floor(sar12_trial / 64))*1.8
let sar12_previous = @VD_B5[pwl]
let sar12_stimulus = vector(8)
let sar12_stimulus[0] = 0
let sar12_stimulus[1] = sar12_previous[length(sar12_previous)-1]
let sar12_stimulus[2] = 2.2501e-05
let sar12_stimulus[3] = sar12_stimulus[1]
let sar12_stimulus[4] = 2.2503e-05
let sar12_stimulus[5] = sar12_drive
let sar12_stimulus[6] = 0.000148
let sar12_stimulus[7] = sar12_stimulus[5]
alter @VD_B5[pwl] = sar12_stimulus
let sar12_drive = (floor(sar12_trial / 64) - 2*floor(sar12_trial / 128))*1.8
let sar12_previous = @VD_B6[pwl]
let sar12_stimulus = vector(8)
let sar12_stimulus[0] = 0
let sar12_stimulus[1] = sar12_previous[length(sar12_previous)-1]
let sar12_stimulus[2] = 2.2501e-05
let sar12_stimulus[3] = sar12_stimulus[1]
let sar12_stimulus[4] = 2.2503e-05
let sar12_stimulus[5] = sar12_drive
let sar12_stimulus[6] = 0.000148
let sar12_stimulus[7] = sar12_stimulus[5]
alter @VD_B6[pwl] = sar12_stimulus
let sar12_drive = (floor(sar12_trial / 128) - 2*floor(sar12_trial / 256))*1.8
let sar12_previous = @VD_B7[pwl]
let sar12_stimulus = vector(8)
let sar12_stimulus[0] = 0
let sar12_stimulus[1] = sar12_previous[length(sar12_previous)-1]
let sar12_stimulus[2] = 2.2501e-05
let sar12_stimulus[3] = sar12_stimulus[1]
let sar12_stimulus[4] = 2.2503e-05
let sar12_stimulus[5] = sar12_drive
let sar12_stimulus[6] = 0.000148
let sar12_stimulus[7] = sar12_stimulus[5]
alter @VD_B7[pwl] = sar12_stimulus
let sar12_drive = (floor(sar12_trial / 256) - 2*floor(sar12_trial / 512))*1.8
let sar12_previous = @VD_B8[pwl]
let sar12_stimulus = vector(8)
let sar12_stimulus[0] = 0
let sar12_stimulus[1] = sar12_previous[length(sar12_previous)-1]
let sar12_stimulus[2] = 2.2501e-05
let sar12_stimulus[3] = sar12_stimulus[1]
let sar12_stimulus[4] = 2.2503e-05
let sar12_stimulus[5] = sar12_drive
let sar12_stimulus[6] = 0.000148
let sar12_stimulus[7] = sar12_stimulus[5]
alter @VD_B8[pwl] = sar12_stimulus
let sar12_drive = (floor(sar12_trial / 512) - 2*floor(sar12_trial / 1024))*1.8
let sar12_previous = @VD_B9[pwl]
let sar12_stimulus = vector(8)
let sar12_stimulus[0] = 0
let sar12_stimulus[1] = sar12_previous[length(sar12_previous)-1]
let sar12_stimulus[2] = 2.2501e-05
let sar12_stimulus[3] = sar12_stimulus[1]
let sar12_stimulus[4] = 2.2503e-05
let sar12_stimulus[5] = sar12_drive
let sar12_stimulus[6] = 0.000148
let sar12_stimulus[7] = sar12_stimulus[5]
alter @VD_B9[pwl] = sar12_stimulus
let sar12_drive = (floor(sar12_trial / 1024) - 2*floor(sar12_trial / 2048))*1.8
let sar12_previous = @VD_B10[pwl]
let sar12_stimulus = vector(8)
let sar12_stimulus[0] = 0
let sar12_stimulus[1] = sar12_previous[length(sar12_previous)-1]
let sar12_stimulus[2] = 2.2501e-05
let sar12_stimulus[3] = sar12_stimulus[1]
let sar12_stimulus[4] = 2.2503e-05
let sar12_stimulus[5] = sar12_drive
let sar12_stimulus[6] = 0.000148
let sar12_stimulus[7] = sar12_stimulus[5]
alter @VD_B10[pwl] = sar12_stimulus
let sar12_drive = (floor(sar12_trial / 2048) - 2*floor(sar12_trial / 4096))*1.8
let sar12_previous = @VD_B11[pwl]
let sar12_stimulus = vector(8)
let sar12_stimulus[0] = 0
let sar12_stimulus[1] = sar12_previous[length(sar12_previous)-1]
let sar12_stimulus[2] = 2.2501e-05
let sar12_stimulus[3] = sar12_stimulus[1]
let sar12_stimulus[4] = 2.2503e-05
let sar12_stimulus[5] = sar12_drive
let sar12_stimulus[6] = 0.000148
let sar12_stimulus[7] = sar12_stimulus[5]
alter @VD_B11[pwl] = sar12_stimulus
let sar12_drive = (floor(sar12_trial / 4096) - 2*floor(sar12_trial / 8192))*1.8
let sar12_previous = @VD_B12[pwl]
let sar12_stimulus = vector(8)
let sar12_stimulus[0] = 0
let sar12_stimulus[1] = sar12_previous[length(sar12_previous)-1]
let sar12_stimulus[2] = 2.2501e-05
let sar12_stimulus[3] = sar12_stimulus[1]
let sar12_stimulus[4] = 2.2503e-05
let sar12_stimulus[5] = sar12_drive
let sar12_stimulus[6] = 0.000148
let sar12_stimulus[7] = sar12_stimulus[5]
alter @VD_B12[pwl] = sar12_stimulus
let sar12_drive = (floor(sar12_trial / 8192) - 2*floor(sar12_trial / 16384))*1.8
let sar12_previous = @VD_B13[pwl]
let sar12_stimulus = vector(8)
let sar12_stimulus[0] = 0
let sar12_stimulus[1] = sar12_previous[length(sar12_previous)-1]
let sar12_stimulus[2] = 2.2501e-05
let sar12_stimulus[3] = sar12_stimulus[1]
let sar12_stimulus[4] = 2.2503e-05
let sar12_stimulus[5] = sar12_drive
let sar12_stimulus[6] = 0.000148
let sar12_stimulus[7] = sar12_stimulus[5]
alter @VD_B13[pwl] = sar12_stimulus
let sar12_drive = (floor(sar12_trial / 16384) - 2*floor(sar12_trial / 32768))*1.8
let sar12_previous = @VD_B14[pwl]
let sar12_stimulus = vector(8)
let sar12_stimulus[0] = 0
let sar12_stimulus[1] = sar12_previous[length(sar12_previous)-1]
let sar12_stimulus[2] = 2.2501e-05
let sar12_stimulus[3] = sar12_stimulus[1]
let sar12_stimulus[4] = 2.2503e-05
let sar12_stimulus[5] = sar12_drive
let sar12_stimulus[6] = 0.000148
let sar12_stimulus[7] = sar12_stimulus[5]
alter @VD_B14[pwl] = sar12_stimulus
let sar12_drive = (floor(sar12_trial / 32768) - 2*floor(sar12_trial / 65536))*1.8
let sar12_previous = @VD_B15[pwl]
let sar12_stimulus = vector(8)
let sar12_stimulus[0] = 0
let sar12_stimulus[1] = sar12_previous[length(sar12_previous)-1]
let sar12_stimulus[2] = 2.2501e-05
let sar12_stimulus[3] = sar12_stimulus[1]
let sar12_stimulus[4] = 2.2503e-05
let sar12_stimulus[5] = sar12_drive
let sar12_stimulus[6] = 0.000148
let sar12_stimulus[7] = sar12_stimulus[5]
alter @VD_B15[pwl] = sar12_stimulus
resume
let sar12_k = length(time)-1
if abs(time[sar12_k] - 2.3e-05) > 1e-12
print time[sar12_k]
echo expected_pause_time_s 2.3e-05
echo SAR12_PAUSE_FAILED
quit 1
end
print time[sar12_k] >> pause-times.txt
let sar12_previous = @VD_EVAL[pwl]
let sar12_stimulus = vector(8)
let sar12_stimulus[0] = 0
let sar12_stimulus[1] = sar12_previous[length(sar12_previous)-1]
let sar12_stimulus[2] = 2.3001e-05
let sar12_stimulus[3] = sar12_stimulus[1]
let sar12_stimulus[4] = 2.3003e-05
let sar12_stimulus[5] = 1.8
let sar12_stimulus[6] = 0.000148
let sar12_stimulus[7] = sar12_stimulus[5]
alter @VD_EVAL[pwl] = sar12_stimulus
resume
let sar12_k = length(time)-1
if abs(time[sar12_k] - 2.35e-05) > 1e-12
print time[sar12_k]
echo expected_pause_time_s 2.35e-05
echo SAR12_PAUSE_FAILED
quit 1
end
print time[sar12_k] >> pause-times.txt
let sar12_k = length(time)-1
let sar12_cmp = v(COMP)[sar12_k]
let sar12_cmpn = v(COMPN)[sar12_k]
let sar12_p = v(TOPP)[sar12_k]
let sar12_n = v(TOPN)[sar12_k]
let sar12_decision = 0
if sar12_cmp >= 0.9
let sar12_code = sar12_trial
let sar12_decision = 1
end
echo 0 1 $&sar12_trial $&sar12_cmp $&sar12_cmpn $&sar12_p $&sar12_n 1.8310546875e-05 $&sar12_decision >> decisions.csv
let sar12_previous = @VD_EVAL[pwl]
let sar12_stimulus = vector(8)
let sar12_stimulus[0] = 0
let sar12_stimulus[1] = sar12_previous[length(sar12_previous)-1]
let sar12_stimulus[2] = 2.3501e-05
let sar12_stimulus[3] = sar12_stimulus[1]
let sar12_stimulus[4] = 2.3503e-05
let sar12_stimulus[5] = 0
let sar12_stimulus[6] = 0.000148
let sar12_stimulus[7] = sar12_stimulus[5]
alter @VD_EVAL[pwl] = sar12_stimulus
let sar12_trial = sar12_code + 1
let sar12_drive = (floor(sar12_trial / 1) - 2*floor(sar12_trial / 2))*1.8
let sar12_previous = @VD_B0[pwl]
let sar12_stimulus = vector(8)
let sar12_stimulus[0] = 0
let sar12_stimulus[1] = sar12_previous[length(sar12_previous)-1]
let sar12_stimulus[2] = 2.3501e-05
let sar12_stimulus[3] = sar12_stimulus[1]
let sar12_stimulus[4] = 2.3503e-05
let sar12_stimulus[5] = sar12_drive
let sar12_stimulus[6] = 0.000148
let sar12_stimulus[7] = sar12_stimulus[5]
alter @VD_B0[pwl] = sar12_stimulus
let sar12_drive = (floor(sar12_trial / 2) - 2*floor(sar12_trial / 4))*1.8
let sar12_previous = @VD_B1[pwl]
let sar12_stimulus = vector(8)
let sar12_stimulus[0] = 0
let sar12_stimulus[1] = sar12_previous[length(sar12_previous)-1]
let sar12_stimulus[2] = 2.3501e-05
let sar12_stimulus[3] = sar12_stimulus[1]
let sar12_stimulus[4] = 2.3503e-05
let sar12_stimulus[5] = sar12_drive
let sar12_stimulus[6] = 0.000148
let sar12_stimulus[7] = sar12_stimulus[5]
alter @VD_B1[pwl] = sar12_stimulus
let sar12_drive = (floor(sar12_trial / 4) - 2*floor(sar12_trial / 8))*1.8
let sar12_previous = @VD_B2[pwl]
let sar12_stimulus = vector(8)
let sar12_stimulus[0] = 0
let sar12_stimulus[1] = sar12_previous[length(sar12_previous)-1]
let sar12_stimulus[2] = 2.3501e-05
let sar12_stimulus[3] = sar12_stimulus[1]
let sar12_stimulus[4] = 2.3503e-05
let sar12_stimulus[5] = sar12_drive
let sar12_stimulus[6] = 0.000148
let sar12_stimulus[7] = sar12_stimulus[5]
alter @VD_B2[pwl] = sar12_stimulus
let sar12_drive = (floor(sar12_trial / 8) - 2*floor(sar12_trial / 16))*1.8
let sar12_previous = @VD_B3[pwl]
let sar12_stimulus = vector(8)
let sar12_stimulus[0] = 0
let sar12_stimulus[1] = sar12_previous[length(sar12_previous)-1]
let sar12_stimulus[2] = 2.3501e-05
let sar12_stimulus[3] = sar12_stimulus[1]
let sar12_stimulus[4] = 2.3503e-05
let sar12_stimulus[5] = sar12_drive
let sar12_stimulus[6] = 0.000148
let sar12_stimulus[7] = sar12_stimulus[5]
alter @VD_B3[pwl] = sar12_stimulus
let sar12_drive = (floor(sar12_trial / 16) - 2*floor(sar12_trial / 32))*1.8
let sar12_previous = @VD_B4[pwl]
let sar12_stimulus = vector(8)
let sar12_stimulus[0] = 0
let sar12_stimulus[1] = sar12_previous[length(sar12_previous)-1]
let sar12_stimulus[2] = 2.3501e-05
let sar12_stimulus[3] = sar12_stimulus[1]
let sar12_stimulus[4] = 2.3503e-05
let sar12_stimulus[5] = sar12_drive
let sar12_stimulus[6] = 0.000148
let sar12_stimulus[7] = sar12_stimulus[5]
alter @VD_B4[pwl] = sar12_stimulus
let sar12_drive = (floor(sar12_trial / 32) - 2*floor(sar12_trial / 64))*1.8
let sar12_previous = @VD_B5[pwl]
let sar12_stimulus = vector(8)
let sar12_stimulus[0] = 0
let sar12_stimulus[1] = sar12_previous[length(sar12_previous)-1]
let sar12_stimulus[2] = 2.3501e-05
let sar12_stimulus[3] = sar12_stimulus[1]
let sar12_stimulus[4] = 2.3503e-05
let sar12_stimulus[5] = sar12_drive
let sar12_stimulus[6] = 0.000148
let sar12_stimulus[7] = sar12_stimulus[5]
alter @VD_B5[pwl] = sar12_stimulus
let sar12_drive = (floor(sar12_trial / 64) - 2*floor(sar12_trial / 128))*1.8
let sar12_previous = @VD_B6[pwl]
let sar12_stimulus = vector(8)
let sar12_stimulus[0] = 0
let sar12_stimulus[1] = sar12_previous[length(sar12_previous)-1]
let sar12_stimulus[2] = 2.3501e-05
let sar12_stimulus[3] = sar12_stimulus[1]
let sar12_stimulus[4] = 2.3503e-05
let sar12_stimulus[5] = sar12_drive
let sar12_stimulus[6] = 0.000148
let sar12_stimulus[7] = sar12_stimulus[5]
alter @VD_B6[pwl] = sar12_stimulus
let sar12_drive = (floor(sar12_trial / 128) - 2*floor(sar12_trial / 256))*1.8
let sar12_previous = @VD_B7[pwl]
let sar12_stimulus = vector(8)
let sar12_stimulus[0] = 0
let sar12_stimulus[1] = sar12_previous[length(sar12_previous)-1]
let sar12_stimulus[2] = 2.3501e-05
let sar12_stimulus[3] = sar12_stimulus[1]
let sar12_stimulus[4] = 2.3503e-05
let sar12_stimulus[5] = sar12_drive
let sar12_stimulus[6] = 0.000148
let sar12_stimulus[7] = sar12_stimulus[5]
alter @VD_B7[pwl] = sar12_stimulus
let sar12_drive = (floor(sar12_trial / 256) - 2*floor(sar12_trial / 512))*1.8
let sar12_previous = @VD_B8[pwl]
let sar12_stimulus = vector(8)
let sar12_stimulus[0] = 0
let sar12_stimulus[1] = sar12_previous[length(sar12_previous)-1]
let sar12_stimulus[2] = 2.3501e-05
let sar12_stimulus[3] = sar12_stimulus[1]
let sar12_stimulus[4] = 2.3503e-05
let sar12_stimulus[5] = sar12_drive
let sar12_stimulus[6] = 0.000148
let sar12_stimulus[7] = sar12_stimulus[5]
alter @VD_B8[pwl] = sar12_stimulus
let sar12_drive = (floor(sar12_trial / 512) - 2*floor(sar12_trial / 1024))*1.8
let sar12_previous = @VD_B9[pwl]
let sar12_stimulus = vector(8)
let sar12_stimulus[0] = 0
let sar12_stimulus[1] = sar12_previous[length(sar12_previous)-1]
let sar12_stimulus[2] = 2.3501e-05
let sar12_stimulus[3] = sar12_stimulus[1]
let sar12_stimulus[4] = 2.3503e-05
let sar12_stimulus[5] = sar12_drive
let sar12_stimulus[6] = 0.000148
let sar12_stimulus[7] = sar12_stimulus[5]
alter @VD_B9[pwl] = sar12_stimulus
let sar12_drive = (floor(sar12_trial / 1024) - 2*floor(sar12_trial / 2048))*1.8
let sar12_previous = @VD_B10[pwl]
let sar12_stimulus = vector(8)
let sar12_stimulus[0] = 0
let sar12_stimulus[1] = sar12_previous[length(sar12_previous)-1]
let sar12_stimulus[2] = 2.3501e-05
let sar12_stimulus[3] = sar12_stimulus[1]
let sar12_stimulus[4] = 2.3503e-05
let sar12_stimulus[5] = sar12_drive
let sar12_stimulus[6] = 0.000148
let sar12_stimulus[7] = sar12_stimulus[5]
alter @VD_B10[pwl] = sar12_stimulus
let sar12_drive = (floor(sar12_trial / 2048) - 2*floor(sar12_trial / 4096))*1.8
let sar12_previous = @VD_B11[pwl]
let sar12_stimulus = vector(8)
let sar12_stimulus[0] = 0
let sar12_stimulus[1] = sar12_previous[length(sar12_previous)-1]
let sar12_stimulus[2] = 2.3501e-05
let sar12_stimulus[3] = sar12_stimulus[1]
let sar12_stimulus[4] = 2.3503e-05
let sar12_stimulus[5] = sar12_drive
let sar12_stimulus[6] = 0.000148
let sar12_stimulus[7] = sar12_stimulus[5]
alter @VD_B11[pwl] = sar12_stimulus
let sar12_drive = (floor(sar12_trial / 4096) - 2*floor(sar12_trial / 8192))*1.8
let sar12_previous = @VD_B12[pwl]
let sar12_stimulus = vector(8)
let sar12_stimulus[0] = 0
let sar12_stimulus[1] = sar12_previous[length(sar12_previous)-1]
let sar12_stimulus[2] = 2.3501e-05
let sar12_stimulus[3] = sar12_stimulus[1]
let sar12_stimulus[4] = 2.3503e-05
let sar12_stimulus[5] = sar12_drive
let sar12_stimulus[6] = 0.000148
let sar12_stimulus[7] = sar12_stimulus[5]
alter @VD_B12[pwl] = sar12_stimulus
let sar12_drive = (floor(sar12_trial / 8192) - 2*floor(sar12_trial / 16384))*1.8
let sar12_previous = @VD_B13[pwl]
let sar12_stimulus = vector(8)
let sar12_stimulus[0] = 0
let sar12_stimulus[1] = sar12_previous[length(sar12_previous)-1]
let sar12_stimulus[2] = 2.3501e-05
let sar12_stimulus[3] = sar12_stimulus[1]
let sar12_stimulus[4] = 2.3503e-05
let sar12_stimulus[5] = sar12_drive
let sar12_stimulus[6] = 0.000148
let sar12_stimulus[7] = sar12_stimulus[5]
alter @VD_B13[pwl] = sar12_stimulus
let sar12_drive = (floor(sar12_trial / 16384) - 2*floor(sar12_trial / 32768))*1.8
let sar12_previous = @VD_B14[pwl]
let sar12_stimulus = vector(8)
let sar12_stimulus[0] = 0
let sar12_stimulus[1] = sar12_previous[length(sar12_previous)-1]
let sar12_stimulus[2] = 2.3501e-05
let sar12_stimulus[3] = sar12_stimulus[1]
let sar12_stimulus[4] = 2.3503e-05
let sar12_stimulus[5] = sar12_drive
let sar12_stimulus[6] = 0.000148
let sar12_stimulus[7] = sar12_stimulus[5]
alter @VD_B14[pwl] = sar12_stimulus
let sar12_drive = (floor(sar12_trial / 32768) - 2*floor(sar12_trial / 65536))*1.8
let sar12_previous = @VD_B15[pwl]
let sar12_stimulus = vector(8)
let sar12_stimulus[0] = 0
let sar12_stimulus[1] = sar12_previous[length(sar12_previous)-1]
let sar12_stimulus[2] = 2.3501e-05
let sar12_stimulus[3] = sar12_stimulus[1]
let sar12_stimulus[4] = 2.3503e-05
let sar12_stimulus[5] = sar12_drive
let sar12_stimulus[6] = 0.000148
let sar12_stimulus[7] = sar12_stimulus[5]
alter @VD_B15[pwl] = sar12_stimulus
resume
let sar12_k = length(time)-1
if abs(time[sar12_k] - 2.4e-05) > 1e-12
print time[sar12_k]
echo expected_pause_time_s 2.4e-05
echo SAR12_PAUSE_FAILED
quit 1
end
print time[sar12_k] >> pause-times.txt
let sar12_previous = @VD_EVAL[pwl]
let sar12_stimulus = vector(8)
let sar12_stimulus[0] = 0
let sar12_stimulus[1] = sar12_previous[length(sar12_previous)-1]
let sar12_stimulus[2] = 2.4001e-05
let sar12_stimulus[3] = sar12_stimulus[1]
let sar12_stimulus[4] = 2.4003e-05
let sar12_stimulus[5] = 1.8
let sar12_stimulus[6] = 0.000148
let sar12_stimulus[7] = sar12_stimulus[5]
alter @VD_EVAL[pwl] = sar12_stimulus
resume
let sar12_k = length(time)-1
if abs(time[sar12_k] - 2.45e-05) > 1e-12
print time[sar12_k]
echo expected_pause_time_s 2.45e-05
echo SAR12_PAUSE_FAILED
quit 1
end
print time[sar12_k] >> pause-times.txt
let sar12_k = length(time)-1
let sar12_cmp = v(COMP)[sar12_k]
let sar12_cmpn = v(COMPN)[sar12_k]
let sar12_p = v(TOPP)[sar12_k]
let sar12_n = v(TOPN)[sar12_k]
let sar12_decision = 0
if sar12_cmp >= 0.9
let sar12_code = sar12_trial
let sar12_decision = 1
end
echo 0 0 $&sar12_trial $&sar12_cmp $&sar12_cmpn $&sar12_p $&sar12_n 1.8310546875e-05 $&sar12_decision >> decisions.csv
let sar12_previous = @VD_EVAL[pwl]
let sar12_stimulus = vector(8)
let sar12_stimulus[0] = 0
let sar12_stimulus[1] = sar12_previous[length(sar12_previous)-1]
let sar12_stimulus[2] = 2.4501e-05
let sar12_stimulus[3] = sar12_stimulus[1]
let sar12_stimulus[4] = 2.4503e-05
let sar12_stimulus[5] = 0
let sar12_stimulus[6] = 0.000148
let sar12_stimulus[7] = sar12_stimulus[5]
alter @VD_EVAL[pwl] = sar12_stimulus
let sar12_previous = @VINP[pwl]
let sar12_stimulus = vector(8)
let sar12_stimulus[0] = 0
let sar12_stimulus[1] = sar12_previous[length(sar12_previous)-1]
let sar12_stimulus[2] = 2.4501e-05
let sar12_stimulus[3] = sar12_stimulus[1]
let sar12_stimulus[4] = 2.4503e-05
let sar12_stimulus[5] = 0.300009155273
let sar12_stimulus[6] = 0.000148
let sar12_stimulus[7] = sar12_stimulus[5]
alter @VINP[pwl] = sar12_stimulus
let sar12_previous = @VINN[pwl]
let sar12_stimulus = vector(8)
let sar12_stimulus[0] = 0
let sar12_stimulus[1] = sar12_previous[length(sar12_previous)-1]
let sar12_stimulus[2] = 2.4501e-05
let sar12_stimulus[3] = sar12_stimulus[1]
let sar12_stimulus[4] = 2.4503e-05
let sar12_stimulus[5] = 1.49999084473
let sar12_stimulus[6] = 0.000148
let sar12_stimulus[7] = sar12_stimulus[5]
alter @VINN[pwl] = sar12_stimulus
let sar12_previous = @VD_SAMPLE[pwl]
let sar12_stimulus = vector(8)
let sar12_stimulus[0] = 0
let sar12_stimulus[1] = sar12_previous[length(sar12_previous)-1]
let sar12_stimulus[2] = 2.4501e-05
let sar12_stimulus[3] = sar12_stimulus[1]
let sar12_stimulus[4] = 2.4503e-05
let sar12_stimulus[5] = 1.8
let sar12_stimulus[6] = 0.000148
let sar12_stimulus[7] = sar12_stimulus[5]
alter @VD_SAMPLE[pwl] = sar12_stimulus
let sar12_previous = @VD_EVAL[pwl]
let sar12_stimulus = vector(8)
let sar12_stimulus[0] = 0
let sar12_stimulus[1] = sar12_previous[length(sar12_previous)-1]
let sar12_stimulus[2] = 2.4501e-05
let sar12_stimulus[3] = sar12_stimulus[1]
let sar12_stimulus[4] = 2.4503e-05
let sar12_stimulus[5] = 0
let sar12_stimulus[6] = 0.000148
let sar12_stimulus[7] = sar12_stimulus[5]
alter @VD_EVAL[pwl] = sar12_stimulus
let sar12_previous = @VD_B0[pwl]
let sar12_stimulus = vector(8)
let sar12_stimulus[0] = 0
let sar12_stimulus[1] = sar12_previous[length(sar12_previous)-1]
let sar12_stimulus[2] = 2.4501e-05
let sar12_stimulus[3] = sar12_stimulus[1]
let sar12_stimulus[4] = 2.4503e-05
let sar12_stimulus[5] = 0
let sar12_stimulus[6] = 0.000148
let sar12_stimulus[7] = sar12_stimulus[5]
alter @VD_B0[pwl] = sar12_stimulus
let sar12_previous = @VD_B1[pwl]
let sar12_stimulus = vector(8)
let sar12_stimulus[0] = 0
let sar12_stimulus[1] = sar12_previous[length(sar12_previous)-1]
let sar12_stimulus[2] = 2.4501e-05
let sar12_stimulus[3] = sar12_stimulus[1]
let sar12_stimulus[4] = 2.4503e-05
let sar12_stimulus[5] = 0
let sar12_stimulus[6] = 0.000148
let sar12_stimulus[7] = sar12_stimulus[5]
alter @VD_B1[pwl] = sar12_stimulus
let sar12_previous = @VD_B2[pwl]
let sar12_stimulus = vector(8)
let sar12_stimulus[0] = 0
let sar12_stimulus[1] = sar12_previous[length(sar12_previous)-1]
let sar12_stimulus[2] = 2.4501e-05
let sar12_stimulus[3] = sar12_stimulus[1]
let sar12_stimulus[4] = 2.4503e-05
let sar12_stimulus[5] = 0
let sar12_stimulus[6] = 0.000148
let sar12_stimulus[7] = sar12_stimulus[5]
alter @VD_B2[pwl] = sar12_stimulus
let sar12_previous = @VD_B3[pwl]
let sar12_stimulus = vector(8)
let sar12_stimulus[0] = 0
let sar12_stimulus[1] = sar12_previous[length(sar12_previous)-1]
let sar12_stimulus[2] = 2.4501e-05
let sar12_stimulus[3] = sar12_stimulus[1]
let sar12_stimulus[4] = 2.4503e-05
let sar12_stimulus[5] = 0
let sar12_stimulus[6] = 0.000148
let sar12_stimulus[7] = sar12_stimulus[5]
alter @VD_B3[pwl] = sar12_stimulus
let sar12_previous = @VD_B4[pwl]
let sar12_stimulus = vector(8)
let sar12_stimulus[0] = 0
let sar12_stimulus[1] = sar12_previous[length(sar12_previous)-1]
let sar12_stimulus[2] = 2.4501e-05
let sar12_stimulus[3] = sar12_stimulus[1]
let sar12_stimulus[4] = 2.4503e-05
let sar12_stimulus[5] = 0
let sar12_stimulus[6] = 0.000148
let sar12_stimulus[7] = sar12_stimulus[5]
alter @VD_B4[pwl] = sar12_stimulus
let sar12_previous = @VD_B5[pwl]
let sar12_stimulus = vector(8)
let sar12_stimulus[0] = 0
let sar12_stimulus[1] = sar12_previous[length(sar12_previous)-1]
let sar12_stimulus[2] = 2.4501e-05
let sar12_stimulus[3] = sar12_stimulus[1]
let sar12_stimulus[4] = 2.4503e-05
let sar12_stimulus[5] = 0
let sar12_stimulus[6] = 0.000148
let sar12_stimulus[7] = sar12_stimulus[5]
alter @VD_B5[pwl] = sar12_stimulus
let sar12_previous = @VD_B6[pwl]
let sar12_stimulus = vector(8)
let sar12_stimulus[0] = 0
let sar12_stimulus[1] = sar12_previous[length(sar12_previous)-1]
let sar12_stimulus[2] = 2.4501e-05
let sar12_stimulus[3] = sar12_stimulus[1]
let sar12_stimulus[4] = 2.4503e-05
let sar12_stimulus[5] = 0
let sar12_stimulus[6] = 0.000148
let sar12_stimulus[7] = sar12_stimulus[5]
alter @VD_B6[pwl] = sar12_stimulus
let sar12_previous = @VD_B7[pwl]
let sar12_stimulus = vector(8)
let sar12_stimulus[0] = 0
let sar12_stimulus[1] = sar12_previous[length(sar12_previous)-1]
let sar12_stimulus[2] = 2.4501e-05
let sar12_stimulus[3] = sar12_stimulus[1]
let sar12_stimulus[4] = 2.4503e-05
let sar12_stimulus[5] = 0
let sar12_stimulus[6] = 0.000148
let sar12_stimulus[7] = sar12_stimulus[5]
alter @VD_B7[pwl] = sar12_stimulus
let sar12_previous = @VD_B8[pwl]
let sar12_stimulus = vector(8)
let sar12_stimulus[0] = 0
let sar12_stimulus[1] = sar12_previous[length(sar12_previous)-1]
let sar12_stimulus[2] = 2.4501e-05
let sar12_stimulus[3] = sar12_stimulus[1]
let sar12_stimulus[4] = 2.4503e-05
let sar12_stimulus[5] = 0
let sar12_stimulus[6] = 0.000148
let sar12_stimulus[7] = sar12_stimulus[5]
alter @VD_B8[pwl] = sar12_stimulus
let sar12_previous = @VD_B9[pwl]
let sar12_stimulus = vector(8)
let sar12_stimulus[0] = 0
let sar12_stimulus[1] = sar12_previous[length(sar12_previous)-1]
let sar12_stimulus[2] = 2.4501e-05
let sar12_stimulus[3] = sar12_stimulus[1]
let sar12_stimulus[4] = 2.4503e-05
let sar12_stimulus[5] = 0
let sar12_stimulus[6] = 0.000148
let sar12_stimulus[7] = sar12_stimulus[5]
alter @VD_B9[pwl] = sar12_stimulus
let sar12_previous = @VD_B10[pwl]
let sar12_stimulus = vector(8)
let sar12_stimulus[0] = 0
let sar12_stimulus[1] = sar12_previous[length(sar12_previous)-1]
let sar12_stimulus[2] = 2.4501e-05
let sar12_stimulus[3] = sar12_stimulus[1]
let sar12_stimulus[4] = 2.4503e-05
let sar12_stimulus[5] = 0
let sar12_stimulus[6] = 0.000148
let sar12_stimulus[7] = sar12_stimulus[5]
alter @VD_B10[pwl] = sar12_stimulus
let sar12_previous = @VD_B11[pwl]
let sar12_stimulus = vector(8)
let sar12_stimulus[0] = 0
let sar12_stimulus[1] = sar12_previous[length(sar12_previous)-1]
let sar12_stimulus[2] = 2.4501e-05
let sar12_stimulus[3] = sar12_stimulus[1]
let sar12_stimulus[4] = 2.4503e-05
let sar12_stimulus[5] = 0
let sar12_stimulus[6] = 0.000148
let sar12_stimulus[7] = sar12_stimulus[5]
alter @VD_B11[pwl] = sar12_stimulus
let sar12_previous = @VD_B12[pwl]
let sar12_stimulus = vector(8)
let sar12_stimulus[0] = 0
let sar12_stimulus[1] = sar12_previous[length(sar12_previous)-1]
let sar12_stimulus[2] = 2.4501e-05
let sar12_stimulus[3] = sar12_stimulus[1]
let sar12_stimulus[4] = 2.4503e-05
let sar12_stimulus[5] = 0
let sar12_stimulus[6] = 0.000148
let sar12_stimulus[7] = sar12_stimulus[5]
alter @VD_B12[pwl] = sar12_stimulus
let sar12_previous = @VD_B13[pwl]
let sar12_stimulus = vector(8)
let sar12_stimulus[0] = 0
let sar12_stimulus[1] = sar12_previous[length(sar12_previous)-1]
let sar12_stimulus[2] = 2.4501e-05
let sar12_stimulus[3] = sar12_stimulus[1]
let sar12_stimulus[4] = 2.4503e-05
let sar12_stimulus[5] = 0
let sar12_stimulus[6] = 0.000148
let sar12_stimulus[7] = sar12_stimulus[5]
alter @VD_B13[pwl] = sar12_stimulus
let sar12_previous = @VD_B14[pwl]
let sar12_stimulus = vector(8)
let sar12_stimulus[0] = 0
let sar12_stimulus[1] = sar12_previous[length(sar12_previous)-1]
let sar12_stimulus[2] = 2.4501e-05
let sar12_stimulus[3] = sar12_stimulus[1]
let sar12_stimulus[4] = 2.4503e-05
let sar12_stimulus[5] = 0
let sar12_stimulus[6] = 0.000148
let sar12_stimulus[7] = sar12_stimulus[5]
alter @VD_B14[pwl] = sar12_stimulus
let sar12_previous = @VD_B15[pwl]
let sar12_stimulus = vector(8)
let sar12_stimulus[0] = 0
let sar12_stimulus[1] = sar12_previous[length(sar12_previous)-1]
let sar12_stimulus[2] = 2.4501e-05
let sar12_stimulus[3] = sar12_stimulus[1]
let sar12_stimulus[4] = 2.4503e-05
let sar12_stimulus[5] = 0
let sar12_stimulus[6] = 0.000148
let sar12_stimulus[7] = sar12_stimulus[5]
alter @VD_B15[pwl] = sar12_stimulus
let sar12_code = 0
resume
let sar12_k = length(time)-1
if abs(time[sar12_k] - 3.25e-05) > 1e-12
print time[sar12_k]
echo expected_pause_time_s 3.25e-05
echo SAR12_PAUSE_FAILED
quit 1
end
print time[sar12_k] >> pause-times.txt
let sar12_previous = @VD_SAMPLE[pwl]
let sar12_stimulus = vector(8)
let sar12_stimulus[0] = 0
let sar12_stimulus[1] = sar12_previous[length(sar12_previous)-1]
let sar12_stimulus[2] = 3.2501e-05
let sar12_stimulus[3] = sar12_stimulus[1]
let sar12_stimulus[4] = 3.2503e-05
let sar12_stimulus[5] = 0
let sar12_stimulus[6] = 0.000148
let sar12_stimulus[7] = sar12_stimulus[5]
alter @VD_SAMPLE[pwl] = sar12_stimulus
resume
let sar12_k = length(time)-1
if abs(time[sar12_k] - 3.3e-05) > 1e-12
print time[sar12_k]
echo expected_pause_time_s 3.3e-05
echo SAR12_PAUSE_FAILED
quit 1
end
print time[sar12_k] >> pause-times.txt
let sar12_previous = @VD_EVAL[pwl]
let sar12_stimulus = vector(8)
let sar12_stimulus[0] = 0
let sar12_stimulus[1] = sar12_previous[length(sar12_previous)-1]
let sar12_stimulus[2] = 3.3001e-05
let sar12_stimulus[3] = sar12_stimulus[1]
let sar12_stimulus[4] = 3.3003e-05
let sar12_stimulus[5] = 0
let sar12_stimulus[6] = 0.000148
let sar12_stimulus[7] = sar12_stimulus[5]
alter @VD_EVAL[pwl] = sar12_stimulus
let sar12_trial = sar12_code + 32768
let sar12_drive = (floor(sar12_trial / 1) - 2*floor(sar12_trial / 2))*1.8
let sar12_previous = @VD_B0[pwl]
let sar12_stimulus = vector(8)
let sar12_stimulus[0] = 0
let sar12_stimulus[1] = sar12_previous[length(sar12_previous)-1]
let sar12_stimulus[2] = 3.3001e-05
let sar12_stimulus[3] = sar12_stimulus[1]
let sar12_stimulus[4] = 3.3003e-05
let sar12_stimulus[5] = sar12_drive
let sar12_stimulus[6] = 0.000148
let sar12_stimulus[7] = sar12_stimulus[5]
alter @VD_B0[pwl] = sar12_stimulus
let sar12_drive = (floor(sar12_trial / 2) - 2*floor(sar12_trial / 4))*1.8
let sar12_previous = @VD_B1[pwl]
let sar12_stimulus = vector(8)
let sar12_stimulus[0] = 0
let sar12_stimulus[1] = sar12_previous[length(sar12_previous)-1]
let sar12_stimulus[2] = 3.3001e-05
let sar12_stimulus[3] = sar12_stimulus[1]
let sar12_stimulus[4] = 3.3003e-05
let sar12_stimulus[5] = sar12_drive
let sar12_stimulus[6] = 0.000148
let sar12_stimulus[7] = sar12_stimulus[5]
alter @VD_B1[pwl] = sar12_stimulus
let sar12_drive = (floor(sar12_trial / 4) - 2*floor(sar12_trial / 8))*1.8
let sar12_previous = @VD_B2[pwl]
let sar12_stimulus = vector(8)
let sar12_stimulus[0] = 0
let sar12_stimulus[1] = sar12_previous[length(sar12_previous)-1]
let sar12_stimulus[2] = 3.3001e-05
let sar12_stimulus[3] = sar12_stimulus[1]
let sar12_stimulus[4] = 3.3003e-05
let sar12_stimulus[5] = sar12_drive
let sar12_stimulus[6] = 0.000148
let sar12_stimulus[7] = sar12_stimulus[5]
alter @VD_B2[pwl] = sar12_stimulus
let sar12_drive = (floor(sar12_trial / 8) - 2*floor(sar12_trial / 16))*1.8
let sar12_previous = @VD_B3[pwl]
let sar12_stimulus = vector(8)
let sar12_stimulus[0] = 0
let sar12_stimulus[1] = sar12_previous[length(sar12_previous)-1]
let sar12_stimulus[2] = 3.3001e-05
let sar12_stimulus[3] = sar12_stimulus[1]
let sar12_stimulus[4] = 3.3003e-05
let sar12_stimulus[5] = sar12_drive
let sar12_stimulus[6] = 0.000148
let sar12_stimulus[7] = sar12_stimulus[5]
alter @VD_B3[pwl] = sar12_stimulus
let sar12_drive = (floor(sar12_trial / 16) - 2*floor(sar12_trial / 32))*1.8
let sar12_previous = @VD_B4[pwl]
let sar12_stimulus = vector(8)
let sar12_stimulus[0] = 0
let sar12_stimulus[1] = sar12_previous[length(sar12_previous)-1]
let sar12_stimulus[2] = 3.3001e-05
let sar12_stimulus[3] = sar12_stimulus[1]
let sar12_stimulus[4] = 3.3003e-05
let sar12_stimulus[5] = sar12_drive
let sar12_stimulus[6] = 0.000148
let sar12_stimulus[7] = sar12_stimulus[5]
alter @VD_B4[pwl] = sar12_stimulus
let sar12_drive = (floor(sar12_trial / 32) - 2*floor(sar12_trial / 64))*1.8
let sar12_previous = @VD_B5[pwl]
let sar12_stimulus = vector(8)
let sar12_stimulus[0] = 0
let sar12_stimulus[1] = sar12_previous[length(sar12_previous)-1]
let sar12_stimulus[2] = 3.3001e-05
let sar12_stimulus[3] = sar12_stimulus[1]
let sar12_stimulus[4] = 3.3003e-05
let sar12_stimulus[5] = sar12_drive
let sar12_stimulus[6] = 0.000148
let sar12_stimulus[7] = sar12_stimulus[5]
alter @VD_B5[pwl] = sar12_stimulus
let sar12_drive = (floor(sar12_trial / 64) - 2*floor(sar12_trial / 128))*1.8
let sar12_previous = @VD_B6[pwl]
let sar12_stimulus = vector(8)
let sar12_stimulus[0] = 0
let sar12_stimulus[1] = sar12_previous[length(sar12_previous)-1]
let sar12_stimulus[2] = 3.3001e-05
let sar12_stimulus[3] = sar12_stimulus[1]
let sar12_stimulus[4] = 3.3003e-05
let sar12_stimulus[5] = sar12_drive
let sar12_stimulus[6] = 0.000148
let sar12_stimulus[7] = sar12_stimulus[5]
alter @VD_B6[pwl] = sar12_stimulus
let sar12_drive = (floor(sar12_trial / 128) - 2*floor(sar12_trial / 256))*1.8
let sar12_previous = @VD_B7[pwl]
let sar12_stimulus = vector(8)
let sar12_stimulus[0] = 0
let sar12_stimulus[1] = sar12_previous[length(sar12_previous)-1]
let sar12_stimulus[2] = 3.3001e-05
let sar12_stimulus[3] = sar12_stimulus[1]
let sar12_stimulus[4] = 3.3003e-05
let sar12_stimulus[5] = sar12_drive
let sar12_stimulus[6] = 0.000148
let sar12_stimulus[7] = sar12_stimulus[5]
alter @VD_B7[pwl] = sar12_stimulus
let sar12_drive = (floor(sar12_trial / 256) - 2*floor(sar12_trial / 512))*1.8
let sar12_previous = @VD_B8[pwl]
let sar12_stimulus = vector(8)
let sar12_stimulus[0] = 0
let sar12_stimulus[1] = sar12_previous[length(sar12_previous)-1]
let sar12_stimulus[2] = 3.3001e-05
let sar12_stimulus[3] = sar12_stimulus[1]
let sar12_stimulus[4] = 3.3003e-05
let sar12_stimulus[5] = sar12_drive
let sar12_stimulus[6] = 0.000148
let sar12_stimulus[7] = sar12_stimulus[5]
alter @VD_B8[pwl] = sar12_stimulus
let sar12_drive = (floor(sar12_trial / 512) - 2*floor(sar12_trial / 1024))*1.8
let sar12_previous = @VD_B9[pwl]
let sar12_stimulus = vector(8)
let sar12_stimulus[0] = 0
let sar12_stimulus[1] = sar12_previous[length(sar12_previous)-1]
let sar12_stimulus[2] = 3.3001e-05
let sar12_stimulus[3] = sar12_stimulus[1]
let sar12_stimulus[4] = 3.3003e-05
let sar12_stimulus[5] = sar12_drive
let sar12_stimulus[6] = 0.000148
let sar12_stimulus[7] = sar12_stimulus[5]
alter @VD_B9[pwl] = sar12_stimulus
let sar12_drive = (floor(sar12_trial / 1024) - 2*floor(sar12_trial / 2048))*1.8
let sar12_previous = @VD_B10[pwl]
let sar12_stimulus = vector(8)
let sar12_stimulus[0] = 0
let sar12_stimulus[1] = sar12_previous[length(sar12_previous)-1]
let sar12_stimulus[2] = 3.3001e-05
let sar12_stimulus[3] = sar12_stimulus[1]
let sar12_stimulus[4] = 3.3003e-05
let sar12_stimulus[5] = sar12_drive
let sar12_stimulus[6] = 0.000148
let sar12_stimulus[7] = sar12_stimulus[5]
alter @VD_B10[pwl] = sar12_stimulus
let sar12_drive = (floor(sar12_trial / 2048) - 2*floor(sar12_trial / 4096))*1.8
let sar12_previous = @VD_B11[pwl]
let sar12_stimulus = vector(8)
let sar12_stimulus[0] = 0
let sar12_stimulus[1] = sar12_previous[length(sar12_previous)-1]
let sar12_stimulus[2] = 3.3001e-05
let sar12_stimulus[3] = sar12_stimulus[1]
let sar12_stimulus[4] = 3.3003e-05
let sar12_stimulus[5] = sar12_drive
let sar12_stimulus[6] = 0.000148
let sar12_stimulus[7] = sar12_stimulus[5]
alter @VD_B11[pwl] = sar12_stimulus
let sar12_drive = (floor(sar12_trial / 4096) - 2*floor(sar12_trial / 8192))*1.8
let sar12_previous = @VD_B12[pwl]
let sar12_stimulus = vector(8)
let sar12_stimulus[0] = 0
let sar12_stimulus[1] = sar12_previous[length(sar12_previous)-1]
let sar12_stimulus[2] = 3.3001e-05
let sar12_stimulus[3] = sar12_stimulus[1]
let sar12_stimulus[4] = 3.3003e-05
let sar12_stimulus[5] = sar12_drive
let sar12_stimulus[6] = 0.000148
let sar12_stimulus[7] = sar12_stimulus[5]
alter @VD_B12[pwl] = sar12_stimulus
let sar12_drive = (floor(sar12_trial / 8192) - 2*floor(sar12_trial / 16384))*1.8
let sar12_previous = @VD_B13[pwl]
let sar12_stimulus = vector(8)
let sar12_stimulus[0] = 0
let sar12_stimulus[1] = sar12_previous[length(sar12_previous)-1]
let sar12_stimulus[2] = 3.3001e-05
let sar12_stimulus[3] = sar12_stimulus[1]
let sar12_stimulus[4] = 3.3003e-05
let sar12_stimulus[5] = sar12_drive
let sar12_stimulus[6] = 0.000148
let sar12_stimulus[7] = sar12_stimulus[5]
alter @VD_B13[pwl] = sar12_stimulus
let sar12_drive = (floor(sar12_trial / 16384) - 2*floor(sar12_trial / 32768))*1.8
let sar12_previous = @VD_B14[pwl]
let sar12_stimulus = vector(8)
let sar12_stimulus[0] = 0
let sar12_stimulus[1] = sar12_previous[length(sar12_previous)-1]
let sar12_stimulus[2] = 3.3001e-05
let sar12_stimulus[3] = sar12_stimulus[1]
let sar12_stimulus[4] = 3.3003e-05
let sar12_stimulus[5] = sar12_drive
let sar12_stimulus[6] = 0.000148
let sar12_stimulus[7] = sar12_stimulus[5]
alter @VD_B14[pwl] = sar12_stimulus
let sar12_drive = (floor(sar12_trial / 32768) - 2*floor(sar12_trial / 65536))*1.8
let sar12_previous = @VD_B15[pwl]
let sar12_stimulus = vector(8)
let sar12_stimulus[0] = 0
let sar12_stimulus[1] = sar12_previous[length(sar12_previous)-1]
let sar12_stimulus[2] = 3.3001e-05
let sar12_stimulus[3] = sar12_stimulus[1]
let sar12_stimulus[4] = 3.3003e-05
let sar12_stimulus[5] = sar12_drive
let sar12_stimulus[6] = 0.000148
let sar12_stimulus[7] = sar12_stimulus[5]
alter @VD_B15[pwl] = sar12_stimulus
resume
let sar12_k = length(time)-1
if abs(time[sar12_k] - 3.35e-05) > 1e-12
print time[sar12_k]
echo expected_pause_time_s 3.35e-05
echo SAR12_PAUSE_FAILED
quit 1
end
print time[sar12_k] >> pause-times.txt
let sar12_previous = @VD_EVAL[pwl]
let sar12_stimulus = vector(8)
let sar12_stimulus[0] = 0
let sar12_stimulus[1] = sar12_previous[length(sar12_previous)-1]
let sar12_stimulus[2] = 3.3501e-05
let sar12_stimulus[3] = sar12_stimulus[1]
let sar12_stimulus[4] = 3.3503e-05
let sar12_stimulus[5] = 1.8
let sar12_stimulus[6] = 0.000148
let sar12_stimulus[7] = sar12_stimulus[5]
alter @VD_EVAL[pwl] = sar12_stimulus
resume
let sar12_k = length(time)-1
if abs(time[sar12_k] - 3.4e-05) > 1e-12
print time[sar12_k]
echo expected_pause_time_s 3.4e-05
echo SAR12_PAUSE_FAILED
quit 1
end
print time[sar12_k] >> pause-times.txt
let sar12_k = length(time)-1
let sar12_cmp = v(COMP)[sar12_k]
let sar12_cmpn = v(COMPN)[sar12_k]
let sar12_p = v(TOPP)[sar12_k]
let sar12_n = v(TOPN)[sar12_k]
let sar12_decision = 0
if sar12_cmp >= 0.9
let sar12_code = sar12_trial
let sar12_decision = 1
end
echo 1 15 $&sar12_trial $&sar12_cmp $&sar12_cmpn $&sar12_p $&sar12_n -1.19998168945312 $&sar12_decision >> decisions.csv
let sar12_previous = @VD_EVAL[pwl]
let sar12_stimulus = vector(8)
let sar12_stimulus[0] = 0
let sar12_stimulus[1] = sar12_previous[length(sar12_previous)-1]
let sar12_stimulus[2] = 3.4001e-05
let sar12_stimulus[3] = sar12_stimulus[1]
let sar12_stimulus[4] = 3.4003e-05
let sar12_stimulus[5] = 0
let sar12_stimulus[6] = 0.000148
let sar12_stimulus[7] = sar12_stimulus[5]
alter @VD_EVAL[pwl] = sar12_stimulus
let sar12_trial = sar12_code + 16384
let sar12_drive = (floor(sar12_trial / 1) - 2*floor(sar12_trial / 2))*1.8
let sar12_previous = @VD_B0[pwl]
let sar12_stimulus = vector(8)
let sar12_stimulus[0] = 0
let sar12_stimulus[1] = sar12_previous[length(sar12_previous)-1]
let sar12_stimulus[2] = 3.4001e-05
let sar12_stimulus[3] = sar12_stimulus[1]
let sar12_stimulus[4] = 3.4003e-05
let sar12_stimulus[5] = sar12_drive
let sar12_stimulus[6] = 0.000148
let sar12_stimulus[7] = sar12_stimulus[5]
alter @VD_B0[pwl] = sar12_stimulus
let sar12_drive = (floor(sar12_trial / 2) - 2*floor(sar12_trial / 4))*1.8
let sar12_previous = @VD_B1[pwl]
let sar12_stimulus = vector(8)
let sar12_stimulus[0] = 0
let sar12_stimulus[1] = sar12_previous[length(sar12_previous)-1]
let sar12_stimulus[2] = 3.4001e-05
let sar12_stimulus[3] = sar12_stimulus[1]
let sar12_stimulus[4] = 3.4003e-05
let sar12_stimulus[5] = sar12_drive
let sar12_stimulus[6] = 0.000148
let sar12_stimulus[7] = sar12_stimulus[5]
alter @VD_B1[pwl] = sar12_stimulus
let sar12_drive = (floor(sar12_trial / 4) - 2*floor(sar12_trial / 8))*1.8
let sar12_previous = @VD_B2[pwl]
let sar12_stimulus = vector(8)
let sar12_stimulus[0] = 0
let sar12_stimulus[1] = sar12_previous[length(sar12_previous)-1]
let sar12_stimulus[2] = 3.4001e-05
let sar12_stimulus[3] = sar12_stimulus[1]
let sar12_stimulus[4] = 3.4003e-05
let sar12_stimulus[5] = sar12_drive
let sar12_stimulus[6] = 0.000148
let sar12_stimulus[7] = sar12_stimulus[5]
alter @VD_B2[pwl] = sar12_stimulus
let sar12_drive = (floor(sar12_trial / 8) - 2*floor(sar12_trial / 16))*1.8
let sar12_previous = @VD_B3[pwl]
let sar12_stimulus = vector(8)
let sar12_stimulus[0] = 0
let sar12_stimulus[1] = sar12_previous[length(sar12_previous)-1]
let sar12_stimulus[2] = 3.4001e-05
let sar12_stimulus[3] = sar12_stimulus[1]
let sar12_stimulus[4] = 3.4003e-05
let sar12_stimulus[5] = sar12_drive
let sar12_stimulus[6] = 0.000148
let sar12_stimulus[7] = sar12_stimulus[5]
alter @VD_B3[pwl] = sar12_stimulus
let sar12_drive = (floor(sar12_trial / 16) - 2*floor(sar12_trial / 32))*1.8
let sar12_previous = @VD_B4[pwl]
let sar12_stimulus = vector(8)
let sar12_stimulus[0] = 0
let sar12_stimulus[1] = sar12_previous[length(sar12_previous)-1]
let sar12_stimulus[2] = 3.4001e-05
let sar12_stimulus[3] = sar12_stimulus[1]
let sar12_stimulus[4] = 3.4003e-05
let sar12_stimulus[5] = sar12_drive
let sar12_stimulus[6] = 0.000148
let sar12_stimulus[7] = sar12_stimulus[5]
alter @VD_B4[pwl] = sar12_stimulus
let sar12_drive = (floor(sar12_trial / 32) - 2*floor(sar12_trial / 64))*1.8
let sar12_previous = @VD_B5[pwl]
let sar12_stimulus = vector(8)
let sar12_stimulus[0] = 0
let sar12_stimulus[1] = sar12_previous[length(sar12_previous)-1]
let sar12_stimulus[2] = 3.4001e-05
let sar12_stimulus[3] = sar12_stimulus[1]
let sar12_stimulus[4] = 3.4003e-05
let sar12_stimulus[5] = sar12_drive
let sar12_stimulus[6] = 0.000148
let sar12_stimulus[7] = sar12_stimulus[5]
alter @VD_B5[pwl] = sar12_stimulus
let sar12_drive = (floor(sar12_trial / 64) - 2*floor(sar12_trial / 128))*1.8
let sar12_previous = @VD_B6[pwl]
let sar12_stimulus = vector(8)
let sar12_stimulus[0] = 0
let sar12_stimulus[1] = sar12_previous[length(sar12_previous)-1]
let sar12_stimulus[2] = 3.4001e-05
let sar12_stimulus[3] = sar12_stimulus[1]
let sar12_stimulus[4] = 3.4003e-05
let sar12_stimulus[5] = sar12_drive
let sar12_stimulus[6] = 0.000148
let sar12_stimulus[7] = sar12_stimulus[5]
alter @VD_B6[pwl] = sar12_stimulus
let sar12_drive = (floor(sar12_trial / 128) - 2*floor(sar12_trial / 256))*1.8
let sar12_previous = @VD_B7[pwl]
let sar12_stimulus = vector(8)
let sar12_stimulus[0] = 0
let sar12_stimulus[1] = sar12_previous[length(sar12_previous)-1]
let sar12_stimulus[2] = 3.4001e-05
let sar12_stimulus[3] = sar12_stimulus[1]
let sar12_stimulus[4] = 3.4003e-05
let sar12_stimulus[5] = sar12_drive
let sar12_stimulus[6] = 0.000148
let sar12_stimulus[7] = sar12_stimulus[5]
alter @VD_B7[pwl] = sar12_stimulus
let sar12_drive = (floor(sar12_trial / 256) - 2*floor(sar12_trial / 512))*1.8
let sar12_previous = @VD_B8[pwl]
let sar12_stimulus = vector(8)
let sar12_stimulus[0] = 0
let sar12_stimulus[1] = sar12_previous[length(sar12_previous)-1]
let sar12_stimulus[2] = 3.4001e-05
let sar12_stimulus[3] = sar12_stimulus[1]
let sar12_stimulus[4] = 3.4003e-05
let sar12_stimulus[5] = sar12_drive
let sar12_stimulus[6] = 0.000148
let sar12_stimulus[7] = sar12_stimulus[5]
alter @VD_B8[pwl] = sar12_stimulus
let sar12_drive = (floor(sar12_trial / 512) - 2*floor(sar12_trial / 1024))*1.8
let sar12_previous = @VD_B9[pwl]
let sar12_stimulus = vector(8)
let sar12_stimulus[0] = 0
let sar12_stimulus[1] = sar12_previous[length(sar12_previous)-1]
let sar12_stimulus[2] = 3.4001e-05
let sar12_stimulus[3] = sar12_stimulus[1]
let sar12_stimulus[4] = 3.4003e-05
let sar12_stimulus[5] = sar12_drive
let sar12_stimulus[6] = 0.000148
let sar12_stimulus[7] = sar12_stimulus[5]
alter @VD_B9[pwl] = sar12_stimulus
let sar12_drive = (floor(sar12_trial / 1024) - 2*floor(sar12_trial / 2048))*1.8
let sar12_previous = @VD_B10[pwl]
let sar12_stimulus = vector(8)
let sar12_stimulus[0] = 0
let sar12_stimulus[1] = sar12_previous[length(sar12_previous)-1]
let sar12_stimulus[2] = 3.4001e-05
let sar12_stimulus[3] = sar12_stimulus[1]
let sar12_stimulus[4] = 3.4003e-05
let sar12_stimulus[5] = sar12_drive
let sar12_stimulus[6] = 0.000148
let sar12_stimulus[7] = sar12_stimulus[5]
alter @VD_B10[pwl] = sar12_stimulus
let sar12_drive = (floor(sar12_trial / 2048) - 2*floor(sar12_trial / 4096))*1.8
let sar12_previous = @VD_B11[pwl]
let sar12_stimulus = vector(8)
let sar12_stimulus[0] = 0
let sar12_stimulus[1] = sar12_previous[length(sar12_previous)-1]
let sar12_stimulus[2] = 3.4001e-05
let sar12_stimulus[3] = sar12_stimulus[1]
let sar12_stimulus[4] = 3.4003e-05
let sar12_stimulus[5] = sar12_drive
let sar12_stimulus[6] = 0.000148
let sar12_stimulus[7] = sar12_stimulus[5]
alter @VD_B11[pwl] = sar12_stimulus
let sar12_drive = (floor(sar12_trial / 4096) - 2*floor(sar12_trial / 8192))*1.8
let sar12_previous = @VD_B12[pwl]
let sar12_stimulus = vector(8)
let sar12_stimulus[0] = 0
let sar12_stimulus[1] = sar12_previous[length(sar12_previous)-1]
let sar12_stimulus[2] = 3.4001e-05
let sar12_stimulus[3] = sar12_stimulus[1]
let sar12_stimulus[4] = 3.4003e-05
let sar12_stimulus[5] = sar12_drive
let sar12_stimulus[6] = 0.000148
let sar12_stimulus[7] = sar12_stimulus[5]
alter @VD_B12[pwl] = sar12_stimulus
let sar12_drive = (floor(sar12_trial / 8192) - 2*floor(sar12_trial / 16384))*1.8
let sar12_previous = @VD_B13[pwl]
let sar12_stimulus = vector(8)
let sar12_stimulus[0] = 0
let sar12_stimulus[1] = sar12_previous[length(sar12_previous)-1]
let sar12_stimulus[2] = 3.4001e-05
let sar12_stimulus[3] = sar12_stimulus[1]
let sar12_stimulus[4] = 3.4003e-05
let sar12_stimulus[5] = sar12_drive
let sar12_stimulus[6] = 0.000148
let sar12_stimulus[7] = sar12_stimulus[5]
alter @VD_B13[pwl] = sar12_stimulus
let sar12_drive = (floor(sar12_trial / 16384) - 2*floor(sar12_trial / 32768))*1.8
let sar12_previous = @VD_B14[pwl]
let sar12_stimulus = vector(8)
let sar12_stimulus[0] = 0
let sar12_stimulus[1] = sar12_previous[length(sar12_previous)-1]
let sar12_stimulus[2] = 3.4001e-05
let sar12_stimulus[3] = sar12_stimulus[1]
let sar12_stimulus[4] = 3.4003e-05
let sar12_stimulus[5] = sar12_drive
let sar12_stimulus[6] = 0.000148
let sar12_stimulus[7] = sar12_stimulus[5]
alter @VD_B14[pwl] = sar12_stimulus
let sar12_drive = (floor(sar12_trial / 32768) - 2*floor(sar12_trial / 65536))*1.8
let sar12_previous = @VD_B15[pwl]
let sar12_stimulus = vector(8)
let sar12_stimulus[0] = 0
let sar12_stimulus[1] = sar12_previous[length(sar12_previous)-1]
let sar12_stimulus[2] = 3.4001e-05
let sar12_stimulus[3] = sar12_stimulus[1]
let sar12_stimulus[4] = 3.4003e-05
let sar12_stimulus[5] = sar12_drive
let sar12_stimulus[6] = 0.000148
let sar12_stimulus[7] = sar12_stimulus[5]
alter @VD_B15[pwl] = sar12_stimulus
resume
let sar12_k = length(time)-1
if abs(time[sar12_k] - 3.45e-05) > 1e-12
print time[sar12_k]
echo expected_pause_time_s 3.45e-05
echo SAR12_PAUSE_FAILED
quit 1
end
print time[sar12_k] >> pause-times.txt
let sar12_previous = @VD_EVAL[pwl]
let sar12_stimulus = vector(8)
let sar12_stimulus[0] = 0
let sar12_stimulus[1] = sar12_previous[length(sar12_previous)-1]
let sar12_stimulus[2] = 3.4501e-05
let sar12_stimulus[3] = sar12_stimulus[1]
let sar12_stimulus[4] = 3.4503e-05
let sar12_stimulus[5] = 1.8
let sar12_stimulus[6] = 0.000148
let sar12_stimulus[7] = sar12_stimulus[5]
alter @VD_EVAL[pwl] = sar12_stimulus
resume
let sar12_k = length(time)-1
if abs(time[sar12_k] - 3.5e-05) > 1e-12
print time[sar12_k]
echo expected_pause_time_s 3.5e-05
echo SAR12_PAUSE_FAILED
quit 1
end
print time[sar12_k] >> pause-times.txt
let sar12_k = length(time)-1
let sar12_cmp = v(COMP)[sar12_k]
let sar12_cmpn = v(COMPN)[sar12_k]
let sar12_p = v(TOPP)[sar12_k]
let sar12_n = v(TOPN)[sar12_k]
let sar12_decision = 0
if sar12_cmp >= 0.9
let sar12_code = sar12_trial
let sar12_decision = 1
end
echo 1 14 $&sar12_trial $&sar12_cmp $&sar12_cmpn $&sar12_p $&sar12_n -1.19998168945312 $&sar12_decision >> decisions.csv
let sar12_previous = @VD_EVAL[pwl]
let sar12_stimulus = vector(8)
let sar12_stimulus[0] = 0
let sar12_stimulus[1] = sar12_previous[length(sar12_previous)-1]
let sar12_stimulus[2] = 3.5001e-05
let sar12_stimulus[3] = sar12_stimulus[1]
let sar12_stimulus[4] = 3.5003e-05
let sar12_stimulus[5] = 0
let sar12_stimulus[6] = 0.000148
let sar12_stimulus[7] = sar12_stimulus[5]
alter @VD_EVAL[pwl] = sar12_stimulus
let sar12_trial = sar12_code + 8192
let sar12_drive = (floor(sar12_trial / 1) - 2*floor(sar12_trial / 2))*1.8
let sar12_previous = @VD_B0[pwl]
let sar12_stimulus = vector(8)
let sar12_stimulus[0] = 0
let sar12_stimulus[1] = sar12_previous[length(sar12_previous)-1]
let sar12_stimulus[2] = 3.5001e-05
let sar12_stimulus[3] = sar12_stimulus[1]
let sar12_stimulus[4] = 3.5003e-05
let sar12_stimulus[5] = sar12_drive
let sar12_stimulus[6] = 0.000148
let sar12_stimulus[7] = sar12_stimulus[5]
alter @VD_B0[pwl] = sar12_stimulus
let sar12_drive = (floor(sar12_trial / 2) - 2*floor(sar12_trial / 4))*1.8
let sar12_previous = @VD_B1[pwl]
let sar12_stimulus = vector(8)
let sar12_stimulus[0] = 0
let sar12_stimulus[1] = sar12_previous[length(sar12_previous)-1]
let sar12_stimulus[2] = 3.5001e-05
let sar12_stimulus[3] = sar12_stimulus[1]
let sar12_stimulus[4] = 3.5003e-05
let sar12_stimulus[5] = sar12_drive
let sar12_stimulus[6] = 0.000148
let sar12_stimulus[7] = sar12_stimulus[5]
alter @VD_B1[pwl] = sar12_stimulus
let sar12_drive = (floor(sar12_trial / 4) - 2*floor(sar12_trial / 8))*1.8
let sar12_previous = @VD_B2[pwl]
let sar12_stimulus = vector(8)
let sar12_stimulus[0] = 0
let sar12_stimulus[1] = sar12_previous[length(sar12_previous)-1]
let sar12_stimulus[2] = 3.5001e-05
let sar12_stimulus[3] = sar12_stimulus[1]
let sar12_stimulus[4] = 3.5003e-05
let sar12_stimulus[5] = sar12_drive
let sar12_stimulus[6] = 0.000148
let sar12_stimulus[7] = sar12_stimulus[5]
alter @VD_B2[pwl] = sar12_stimulus
let sar12_drive = (floor(sar12_trial / 8) - 2*floor(sar12_trial / 16))*1.8
let sar12_previous = @VD_B3[pwl]
let sar12_stimulus = vector(8)
let sar12_stimulus[0] = 0
let sar12_stimulus[1] = sar12_previous[length(sar12_previous)-1]
let sar12_stimulus[2] = 3.5001e-05
let sar12_stimulus[3] = sar12_stimulus[1]
let sar12_stimulus[4] = 3.5003e-05
let sar12_stimulus[5] = sar12_drive
let sar12_stimulus[6] = 0.000148
let sar12_stimulus[7] = sar12_stimulus[5]
alter @VD_B3[pwl] = sar12_stimulus
let sar12_drive = (floor(sar12_trial / 16) - 2*floor(sar12_trial / 32))*1.8
let sar12_previous = @VD_B4[pwl]
let sar12_stimulus = vector(8)
let sar12_stimulus[0] = 0
let sar12_stimulus[1] = sar12_previous[length(sar12_previous)-1]
let sar12_stimulus[2] = 3.5001e-05
let sar12_stimulus[3] = sar12_stimulus[1]
let sar12_stimulus[4] = 3.5003e-05
let sar12_stimulus[5] = sar12_drive
let sar12_stimulus[6] = 0.000148
let sar12_stimulus[7] = sar12_stimulus[5]
alter @VD_B4[pwl] = sar12_stimulus
let sar12_drive = (floor(sar12_trial / 32) - 2*floor(sar12_trial / 64))*1.8
let sar12_previous = @VD_B5[pwl]
let sar12_stimulus = vector(8)
let sar12_stimulus[0] = 0
let sar12_stimulus[1] = sar12_previous[length(sar12_previous)-1]
let sar12_stimulus[2] = 3.5001e-05
let sar12_stimulus[3] = sar12_stimulus[1]
let sar12_stimulus[4] = 3.5003e-05
let sar12_stimulus[5] = sar12_drive
let sar12_stimulus[6] = 0.000148
let sar12_stimulus[7] = sar12_stimulus[5]
alter @VD_B5[pwl] = sar12_stimulus
let sar12_drive = (floor(sar12_trial / 64) - 2*floor(sar12_trial / 128))*1.8
let sar12_previous = @VD_B6[pwl]
let sar12_stimulus = vector(8)
let sar12_stimulus[0] = 0
let sar12_stimulus[1] = sar12_previous[length(sar12_previous)-1]
let sar12_stimulus[2] = 3.5001e-05
let sar12_stimulus[3] = sar12_stimulus[1]
let sar12_stimulus[4] = 3.5003e-05
let sar12_stimulus[5] = sar12_drive
let sar12_stimulus[6] = 0.000148
let sar12_stimulus[7] = sar12_stimulus[5]
alter @VD_B6[pwl] = sar12_stimulus
let sar12_drive = (floor(sar12_trial / 128) - 2*floor(sar12_trial / 256))*1.8
let sar12_previous = @VD_B7[pwl]
let sar12_stimulus = vector(8)
let sar12_stimulus[0] = 0
let sar12_stimulus[1] = sar12_previous[length(sar12_previous)-1]
let sar12_stimulus[2] = 3.5001e-05
let sar12_stimulus[3] = sar12_stimulus[1]
let sar12_stimulus[4] = 3.5003e-05
let sar12_stimulus[5] = sar12_drive
let sar12_stimulus[6] = 0.000148
let sar12_stimulus[7] = sar12_stimulus[5]
alter @VD_B7[pwl] = sar12_stimulus
let sar12_drive = (floor(sar12_trial / 256) - 2*floor(sar12_trial / 512))*1.8
let sar12_previous = @VD_B8[pwl]
let sar12_stimulus = vector(8)
let sar12_stimulus[0] = 0
let sar12_stimulus[1] = sar12_previous[length(sar12_previous)-1]
let sar12_stimulus[2] = 3.5001e-05
let sar12_stimulus[3] = sar12_stimulus[1]
let sar12_stimulus[4] = 3.5003e-05
let sar12_stimulus[5] = sar12_drive
let sar12_stimulus[6] = 0.000148
let sar12_stimulus[7] = sar12_stimulus[5]
alter @VD_B8[pwl] = sar12_stimulus
let sar12_drive = (floor(sar12_trial / 512) - 2*floor(sar12_trial / 1024))*1.8
let sar12_previous = @VD_B9[pwl]
let sar12_stimulus = vector(8)
let sar12_stimulus[0] = 0
let sar12_stimulus[1] = sar12_previous[length(sar12_previous)-1]
let sar12_stimulus[2] = 3.5001e-05
let sar12_stimulus[3] = sar12_stimulus[1]
let sar12_stimulus[4] = 3.5003e-05
let sar12_stimulus[5] = sar12_drive
let sar12_stimulus[6] = 0.000148
let sar12_stimulus[7] = sar12_stimulus[5]
alter @VD_B9[pwl] = sar12_stimulus
let sar12_drive = (floor(sar12_trial / 1024) - 2*floor(sar12_trial / 2048))*1.8
let sar12_previous = @VD_B10[pwl]
let sar12_stimulus = vector(8)
let sar12_stimulus[0] = 0
let sar12_stimulus[1] = sar12_previous[length(sar12_previous)-1]
let sar12_stimulus[2] = 3.5001e-05
let sar12_stimulus[3] = sar12_stimulus[1]
let sar12_stimulus[4] = 3.5003e-05
let sar12_stimulus[5] = sar12_drive
let sar12_stimulus[6] = 0.000148
let sar12_stimulus[7] = sar12_stimulus[5]
alter @VD_B10[pwl] = sar12_stimulus
let sar12_drive = (floor(sar12_trial / 2048) - 2*floor(sar12_trial / 4096))*1.8
let sar12_previous = @VD_B11[pwl]
let sar12_stimulus = vector(8)
let sar12_stimulus[0] = 0
let sar12_stimulus[1] = sar12_previous[length(sar12_previous)-1]
let sar12_stimulus[2] = 3.5001e-05
let sar12_stimulus[3] = sar12_stimulus[1]
let sar12_stimulus[4] = 3.5003e-05
let sar12_stimulus[5] = sar12_drive
let sar12_stimulus[6] = 0.000148
let sar12_stimulus[7] = sar12_stimulus[5]
alter @VD_B11[pwl] = sar12_stimulus
let sar12_drive = (floor(sar12_trial / 4096) - 2*floor(sar12_trial / 8192))*1.8
let sar12_previous = @VD_B12[pwl]
let sar12_stimulus = vector(8)
let sar12_stimulus[0] = 0
let sar12_stimulus[1] = sar12_previous[length(sar12_previous)-1]
let sar12_stimulus[2] = 3.5001e-05
let sar12_stimulus[3] = sar12_stimulus[1]
let sar12_stimulus[4] = 3.5003e-05
let sar12_stimulus[5] = sar12_drive
let sar12_stimulus[6] = 0.000148
let sar12_stimulus[7] = sar12_stimulus[5]
alter @VD_B12[pwl] = sar12_stimulus
let sar12_drive = (floor(sar12_trial / 8192) - 2*floor(sar12_trial / 16384))*1.8
let sar12_previous = @VD_B13[pwl]
let sar12_stimulus = vector(8)
let sar12_stimulus[0] = 0
let sar12_stimulus[1] = sar12_previous[length(sar12_previous)-1]
let sar12_stimulus[2] = 3.5001e-05
let sar12_stimulus[3] = sar12_stimulus[1]
let sar12_stimulus[4] = 3.5003e-05
let sar12_stimulus[5] = sar12_drive
let sar12_stimulus[6] = 0.000148
let sar12_stimulus[7] = sar12_stimulus[5]
alter @VD_B13[pwl] = sar12_stimulus
let sar12_drive = (floor(sar12_trial / 16384) - 2*floor(sar12_trial / 32768))*1.8
let sar12_previous = @VD_B14[pwl]
let sar12_stimulus = vector(8)
let sar12_stimulus[0] = 0
let sar12_stimulus[1] = sar12_previous[length(sar12_previous)-1]
let sar12_stimulus[2] = 3.5001e-05
let sar12_stimulus[3] = sar12_stimulus[1]
let sar12_stimulus[4] = 3.5003e-05
let sar12_stimulus[5] = sar12_drive
let sar12_stimulus[6] = 0.000148
let sar12_stimulus[7] = sar12_stimulus[5]
alter @VD_B14[pwl] = sar12_stimulus
let sar12_drive = (floor(sar12_trial / 32768) - 2*floor(sar12_trial / 65536))*1.8
let sar12_previous = @VD_B15[pwl]
let sar12_stimulus = vector(8)
let sar12_stimulus[0] = 0
let sar12_stimulus[1] = sar12_previous[length(sar12_previous)-1]
let sar12_stimulus[2] = 3.5001e-05
let sar12_stimulus[3] = sar12_stimulus[1]
let sar12_stimulus[4] = 3.5003e-05
let sar12_stimulus[5] = sar12_drive
let sar12_stimulus[6] = 0.000148
let sar12_stimulus[7] = sar12_stimulus[5]
alter @VD_B15[pwl] = sar12_stimulus
resume
let sar12_k = length(time)-1
if abs(time[sar12_k] - 3.55e-05) > 1e-12
print time[sar12_k]
echo expected_pause_time_s 3.55e-05
echo SAR12_PAUSE_FAILED
quit 1
end
print time[sar12_k] >> pause-times.txt
let sar12_previous = @VD_EVAL[pwl]
let sar12_stimulus = vector(8)
let sar12_stimulus[0] = 0
let sar12_stimulus[1] = sar12_previous[length(sar12_previous)-1]
let sar12_stimulus[2] = 3.5501e-05
let sar12_stimulus[3] = sar12_stimulus[1]
let sar12_stimulus[4] = 3.5503e-05
let sar12_stimulus[5] = 1.8
let sar12_stimulus[6] = 0.000148
let sar12_stimulus[7] = sar12_stimulus[5]
alter @VD_EVAL[pwl] = sar12_stimulus
resume
let sar12_k = length(time)-1
if abs(time[sar12_k] - 3.6e-05) > 1e-12
print time[sar12_k]
echo expected_pause_time_s 3.6e-05
echo SAR12_PAUSE_FAILED
quit 1
end
print time[sar12_k] >> pause-times.txt
let sar12_k = length(time)-1
let sar12_cmp = v(COMP)[sar12_k]
let sar12_cmpn = v(COMPN)[sar12_k]
let sar12_p = v(TOPP)[sar12_k]
let sar12_n = v(TOPN)[sar12_k]
let sar12_decision = 0
if sar12_cmp >= 0.9
let sar12_code = sar12_trial
let sar12_decision = 1
end
echo 1 13 $&sar12_trial $&sar12_cmp $&sar12_cmpn $&sar12_p $&sar12_n -1.19998168945312 $&sar12_decision >> decisions.csv
let sar12_previous = @VD_EVAL[pwl]
let sar12_stimulus = vector(8)
let sar12_stimulus[0] = 0
let sar12_stimulus[1] = sar12_previous[length(sar12_previous)-1]
let sar12_stimulus[2] = 3.6001e-05
let sar12_stimulus[3] = sar12_stimulus[1]
let sar12_stimulus[4] = 3.6003e-05
let sar12_stimulus[5] = 0
let sar12_stimulus[6] = 0.000148
let sar12_stimulus[7] = sar12_stimulus[5]
alter @VD_EVAL[pwl] = sar12_stimulus
let sar12_trial = sar12_code + 4096
let sar12_drive = (floor(sar12_trial / 1) - 2*floor(sar12_trial / 2))*1.8
let sar12_previous = @VD_B0[pwl]
let sar12_stimulus = vector(8)
let sar12_stimulus[0] = 0
let sar12_stimulus[1] = sar12_previous[length(sar12_previous)-1]
let sar12_stimulus[2] = 3.6001e-05
let sar12_stimulus[3] = sar12_stimulus[1]
let sar12_stimulus[4] = 3.6003e-05
let sar12_stimulus[5] = sar12_drive
let sar12_stimulus[6] = 0.000148
let sar12_stimulus[7] = sar12_stimulus[5]
alter @VD_B0[pwl] = sar12_stimulus
let sar12_drive = (floor(sar12_trial / 2) - 2*floor(sar12_trial / 4))*1.8
let sar12_previous = @VD_B1[pwl]
let sar12_stimulus = vector(8)
let sar12_stimulus[0] = 0
let sar12_stimulus[1] = sar12_previous[length(sar12_previous)-1]
let sar12_stimulus[2] = 3.6001e-05
let sar12_stimulus[3] = sar12_stimulus[1]
let sar12_stimulus[4] = 3.6003e-05
let sar12_stimulus[5] = sar12_drive
let sar12_stimulus[6] = 0.000148
let sar12_stimulus[7] = sar12_stimulus[5]
alter @VD_B1[pwl] = sar12_stimulus
let sar12_drive = (floor(sar12_trial / 4) - 2*floor(sar12_trial / 8))*1.8
let sar12_previous = @VD_B2[pwl]
let sar12_stimulus = vector(8)
let sar12_stimulus[0] = 0
let sar12_stimulus[1] = sar12_previous[length(sar12_previous)-1]
let sar12_stimulus[2] = 3.6001e-05
let sar12_stimulus[3] = sar12_stimulus[1]
let sar12_stimulus[4] = 3.6003e-05
let sar12_stimulus[5] = sar12_drive
let sar12_stimulus[6] = 0.000148
let sar12_stimulus[7] = sar12_stimulus[5]
alter @VD_B2[pwl] = sar12_stimulus
let sar12_drive = (floor(sar12_trial / 8) - 2*floor(sar12_trial / 16))*1.8
let sar12_previous = @VD_B3[pwl]
let sar12_stimulus = vector(8)
let sar12_stimulus[0] = 0
let sar12_stimulus[1] = sar12_previous[length(sar12_previous)-1]
let sar12_stimulus[2] = 3.6001e-05
let sar12_stimulus[3] = sar12_stimulus[1]
let sar12_stimulus[4] = 3.6003e-05
let sar12_stimulus[5] = sar12_drive
let sar12_stimulus[6] = 0.000148
let sar12_stimulus[7] = sar12_stimulus[5]
alter @VD_B3[pwl] = sar12_stimulus
let sar12_drive = (floor(sar12_trial / 16) - 2*floor(sar12_trial / 32))*1.8
let sar12_previous = @VD_B4[pwl]
let sar12_stimulus = vector(8)
let sar12_stimulus[0] = 0
let sar12_stimulus[1] = sar12_previous[length(sar12_previous)-1]
let sar12_stimulus[2] = 3.6001e-05
let sar12_stimulus[3] = sar12_stimulus[1]
let sar12_stimulus[4] = 3.6003e-05
let sar12_stimulus[5] = sar12_drive
let sar12_stimulus[6] = 0.000148
let sar12_stimulus[7] = sar12_stimulus[5]
alter @VD_B4[pwl] = sar12_stimulus
let sar12_drive = (floor(sar12_trial / 32) - 2*floor(sar12_trial / 64))*1.8
let sar12_previous = @VD_B5[pwl]
let sar12_stimulus = vector(8)
let sar12_stimulus[0] = 0
let sar12_stimulus[1] = sar12_previous[length(sar12_previous)-1]
let sar12_stimulus[2] = 3.6001e-05
let sar12_stimulus[3] = sar12_stimulus[1]
let sar12_stimulus[4] = 3.6003e-05
let sar12_stimulus[5] = sar12_drive
let sar12_stimulus[6] = 0.000148
let sar12_stimulus[7] = sar12_stimulus[5]
alter @VD_B5[pwl] = sar12_stimulus
let sar12_drive = (floor(sar12_trial / 64) - 2*floor(sar12_trial / 128))*1.8
let sar12_previous = @VD_B6[pwl]
let sar12_stimulus = vector(8)
let sar12_stimulus[0] = 0
let sar12_stimulus[1] = sar12_previous[length(sar12_previous)-1]
let sar12_stimulus[2] = 3.6001e-05
let sar12_stimulus[3] = sar12_stimulus[1]
let sar12_stimulus[4] = 3.6003e-05
let sar12_stimulus[5] = sar12_drive
let sar12_stimulus[6] = 0.000148
let sar12_stimulus[7] = sar12_stimulus[5]
alter @VD_B6[pwl] = sar12_stimulus
let sar12_drive = (floor(sar12_trial / 128) - 2*floor(sar12_trial / 256))*1.8
let sar12_previous = @VD_B7[pwl]
let sar12_stimulus = vector(8)
let sar12_stimulus[0] = 0
let sar12_stimulus[1] = sar12_previous[length(sar12_previous)-1]
let sar12_stimulus[2] = 3.6001e-05
let sar12_stimulus[3] = sar12_stimulus[1]
let sar12_stimulus[4] = 3.6003e-05
let sar12_stimulus[5] = sar12_drive
let sar12_stimulus[6] = 0.000148
let sar12_stimulus[7] = sar12_stimulus[5]
alter @VD_B7[pwl] = sar12_stimulus
let sar12_drive = (floor(sar12_trial / 256) - 2*floor(sar12_trial / 512))*1.8
let sar12_previous = @VD_B8[pwl]
let sar12_stimulus = vector(8)
let sar12_stimulus[0] = 0
let sar12_stimulus[1] = sar12_previous[length(sar12_previous)-1]
let sar12_stimulus[2] = 3.6001e-05
let sar12_stimulus[3] = sar12_stimulus[1]
let sar12_stimulus[4] = 3.6003e-05
let sar12_stimulus[5] = sar12_drive
let sar12_stimulus[6] = 0.000148
let sar12_stimulus[7] = sar12_stimulus[5]
alter @VD_B8[pwl] = sar12_stimulus
let sar12_drive = (floor(sar12_trial / 512) - 2*floor(sar12_trial / 1024))*1.8
let sar12_previous = @VD_B9[pwl]
let sar12_stimulus = vector(8)
let sar12_stimulus[0] = 0
let sar12_stimulus[1] = sar12_previous[length(sar12_previous)-1]
let sar12_stimulus[2] = 3.6001e-05
let sar12_stimulus[3] = sar12_stimulus[1]
let sar12_stimulus[4] = 3.6003e-05
let sar12_stimulus[5] = sar12_drive
let sar12_stimulus[6] = 0.000148
let sar12_stimulus[7] = sar12_stimulus[5]
alter @VD_B9[pwl] = sar12_stimulus
let sar12_drive = (floor(sar12_trial / 1024) - 2*floor(sar12_trial / 2048))*1.8
let sar12_previous = @VD_B10[pwl]
let sar12_stimulus = vector(8)
let sar12_stimulus[0] = 0
let sar12_stimulus[1] = sar12_previous[length(sar12_previous)-1]
let sar12_stimulus[2] = 3.6001e-05
let sar12_stimulus[3] = sar12_stimulus[1]
let sar12_stimulus[4] = 3.6003e-05
let sar12_stimulus[5] = sar12_drive
let sar12_stimulus[6] = 0.000148
let sar12_stimulus[7] = sar12_stimulus[5]
alter @VD_B10[pwl] = sar12_stimulus
let sar12_drive = (floor(sar12_trial / 2048) - 2*floor(sar12_trial / 4096))*1.8
let sar12_previous = @VD_B11[pwl]
let sar12_stimulus = vector(8)
let sar12_stimulus[0] = 0
let sar12_stimulus[1] = sar12_previous[length(sar12_previous)-1]
let sar12_stimulus[2] = 3.6001e-05
let sar12_stimulus[3] = sar12_stimulus[1]
let sar12_stimulus[4] = 3.6003e-05
let sar12_stimulus[5] = sar12_drive
let sar12_stimulus[6] = 0.000148
let sar12_stimulus[7] = sar12_stimulus[5]
alter @VD_B11[pwl] = sar12_stimulus
let sar12_drive = (floor(sar12_trial / 4096) - 2*floor(sar12_trial / 8192))*1.8
let sar12_previous = @VD_B12[pwl]
let sar12_stimulus = vector(8)
let sar12_stimulus[0] = 0
let sar12_stimulus[1] = sar12_previous[length(sar12_previous)-1]
let sar12_stimulus[2] = 3.6001e-05
let sar12_stimulus[3] = sar12_stimulus[1]
let sar12_stimulus[4] = 3.6003e-05
let sar12_stimulus[5] = sar12_drive
let sar12_stimulus[6] = 0.000148
let sar12_stimulus[7] = sar12_stimulus[5]
alter @VD_B12[pwl] = sar12_stimulus
let sar12_drive = (floor(sar12_trial / 8192) - 2*floor(sar12_trial / 16384))*1.8
let sar12_previous = @VD_B13[pwl]
let sar12_stimulus = vector(8)
let sar12_stimulus[0] = 0
let sar12_stimulus[1] = sar12_previous[length(sar12_previous)-1]
let sar12_stimulus[2] = 3.6001e-05
let sar12_stimulus[3] = sar12_stimulus[1]
let sar12_stimulus[4] = 3.6003e-05
let sar12_stimulus[5] = sar12_drive
let sar12_stimulus[6] = 0.000148
let sar12_stimulus[7] = sar12_stimulus[5]
alter @VD_B13[pwl] = sar12_stimulus
let sar12_drive = (floor(sar12_trial / 16384) - 2*floor(sar12_trial / 32768))*1.8
let sar12_previous = @VD_B14[pwl]
let sar12_stimulus = vector(8)
let sar12_stimulus[0] = 0
let sar12_stimulus[1] = sar12_previous[length(sar12_previous)-1]
let sar12_stimulus[2] = 3.6001e-05
let sar12_stimulus[3] = sar12_stimulus[1]
let sar12_stimulus[4] = 3.6003e-05
let sar12_stimulus[5] = sar12_drive
let sar12_stimulus[6] = 0.000148
let sar12_stimulus[7] = sar12_stimulus[5]
alter @VD_B14[pwl] = sar12_stimulus
let sar12_drive = (floor(sar12_trial / 32768) - 2*floor(sar12_trial / 65536))*1.8
let sar12_previous = @VD_B15[pwl]
let sar12_stimulus = vector(8)
let sar12_stimulus[0] = 0
let sar12_stimulus[1] = sar12_previous[length(sar12_previous)-1]
let sar12_stimulus[2] = 3.6001e-05
let sar12_stimulus[3] = sar12_stimulus[1]
let sar12_stimulus[4] = 3.6003e-05
let sar12_stimulus[5] = sar12_drive
let sar12_stimulus[6] = 0.000148
let sar12_stimulus[7] = sar12_stimulus[5]
alter @VD_B15[pwl] = sar12_stimulus
resume
let sar12_k = length(time)-1
if abs(time[sar12_k] - 3.65e-05) > 1e-12
print time[sar12_k]
echo expected_pause_time_s 3.65e-05
echo SAR12_PAUSE_FAILED
quit 1
end
print time[sar12_k] >> pause-times.txt
let sar12_previous = @VD_EVAL[pwl]
let sar12_stimulus = vector(8)
let sar12_stimulus[0] = 0
let sar12_stimulus[1] = sar12_previous[length(sar12_previous)-1]
let sar12_stimulus[2] = 3.6501e-05
let sar12_stimulus[3] = sar12_stimulus[1]
let sar12_stimulus[4] = 3.6503e-05
let sar12_stimulus[5] = 1.8
let sar12_stimulus[6] = 0.000148
let sar12_stimulus[7] = sar12_stimulus[5]
alter @VD_EVAL[pwl] = sar12_stimulus
resume
let sar12_k = length(time)-1
if abs(time[sar12_k] - 3.7e-05) > 1e-12
print time[sar12_k]
echo expected_pause_time_s 3.7e-05
echo SAR12_PAUSE_FAILED
quit 1
end
print time[sar12_k] >> pause-times.txt
let sar12_k = length(time)-1
let sar12_cmp = v(COMP)[sar12_k]
let sar12_cmpn = v(COMPN)[sar12_k]
let sar12_p = v(TOPP)[sar12_k]
let sar12_n = v(TOPN)[sar12_k]
let sar12_decision = 0
if sar12_cmp >= 0.9
let sar12_code = sar12_trial
let sar12_decision = 1
end
echo 1 12 $&sar12_trial $&sar12_cmp $&sar12_cmpn $&sar12_p $&sar12_n -1.19998168945312 $&sar12_decision >> decisions.csv
let sar12_previous = @VD_EVAL[pwl]
let sar12_stimulus = vector(8)
let sar12_stimulus[0] = 0
let sar12_stimulus[1] = sar12_previous[length(sar12_previous)-1]
let sar12_stimulus[2] = 3.7001e-05
let sar12_stimulus[3] = sar12_stimulus[1]
let sar12_stimulus[4] = 3.7003e-05
let sar12_stimulus[5] = 0
let sar12_stimulus[6] = 0.000148
let sar12_stimulus[7] = sar12_stimulus[5]
alter @VD_EVAL[pwl] = sar12_stimulus
let sar12_trial = sar12_code + 2048
let sar12_drive = (floor(sar12_trial / 1) - 2*floor(sar12_trial / 2))*1.8
let sar12_previous = @VD_B0[pwl]
let sar12_stimulus = vector(8)
let sar12_stimulus[0] = 0
let sar12_stimulus[1] = sar12_previous[length(sar12_previous)-1]
let sar12_stimulus[2] = 3.7001e-05
let sar12_stimulus[3] = sar12_stimulus[1]
let sar12_stimulus[4] = 3.7003e-05
let sar12_stimulus[5] = sar12_drive
let sar12_stimulus[6] = 0.000148
let sar12_stimulus[7] = sar12_stimulus[5]
alter @VD_B0[pwl] = sar12_stimulus
let sar12_drive = (floor(sar12_trial / 2) - 2*floor(sar12_trial / 4))*1.8
let sar12_previous = @VD_B1[pwl]
let sar12_stimulus = vector(8)
let sar12_stimulus[0] = 0
let sar12_stimulus[1] = sar12_previous[length(sar12_previous)-1]
let sar12_stimulus[2] = 3.7001e-05
let sar12_stimulus[3] = sar12_stimulus[1]
let sar12_stimulus[4] = 3.7003e-05
let sar12_stimulus[5] = sar12_drive
let sar12_stimulus[6] = 0.000148
let sar12_stimulus[7] = sar12_stimulus[5]
alter @VD_B1[pwl] = sar12_stimulus
let sar12_drive = (floor(sar12_trial / 4) - 2*floor(sar12_trial / 8))*1.8
let sar12_previous = @VD_B2[pwl]
let sar12_stimulus = vector(8)
let sar12_stimulus[0] = 0
let sar12_stimulus[1] = sar12_previous[length(sar12_previous)-1]
let sar12_stimulus[2] = 3.7001e-05
let sar12_stimulus[3] = sar12_stimulus[1]
let sar12_stimulus[4] = 3.7003e-05
let sar12_stimulus[5] = sar12_drive
let sar12_stimulus[6] = 0.000148
let sar12_stimulus[7] = sar12_stimulus[5]
alter @VD_B2[pwl] = sar12_stimulus
let sar12_drive = (floor(sar12_trial / 8) - 2*floor(sar12_trial / 16))*1.8
let sar12_previous = @VD_B3[pwl]
let sar12_stimulus = vector(8)
let sar12_stimulus[0] = 0
let sar12_stimulus[1] = sar12_previous[length(sar12_previous)-1]
let sar12_stimulus[2] = 3.7001e-05
let sar12_stimulus[3] = sar12_stimulus[1]
let sar12_stimulus[4] = 3.7003e-05
let sar12_stimulus[5] = sar12_drive
let sar12_stimulus[6] = 0.000148
let sar12_stimulus[7] = sar12_stimulus[5]
alter @VD_B3[pwl] = sar12_stimulus
let sar12_drive = (floor(sar12_trial / 16) - 2*floor(sar12_trial / 32))*1.8
let sar12_previous = @VD_B4[pwl]
let sar12_stimulus = vector(8)
let sar12_stimulus[0] = 0
let sar12_stimulus[1] = sar12_previous[length(sar12_previous)-1]
let sar12_stimulus[2] = 3.7001e-05
let sar12_stimulus[3] = sar12_stimulus[1]
let sar12_stimulus[4] = 3.7003e-05
let sar12_stimulus[5] = sar12_drive
let sar12_stimulus[6] = 0.000148
let sar12_stimulus[7] = sar12_stimulus[5]
alter @VD_B4[pwl] = sar12_stimulus
let sar12_drive = (floor(sar12_trial / 32) - 2*floor(sar12_trial / 64))*1.8
let sar12_previous = @VD_B5[pwl]
let sar12_stimulus = vector(8)
let sar12_stimulus[0] = 0
let sar12_stimulus[1] = sar12_previous[length(sar12_previous)-1]
let sar12_stimulus[2] = 3.7001e-05
let sar12_stimulus[3] = sar12_stimulus[1]
let sar12_stimulus[4] = 3.7003e-05
let sar12_stimulus[5] = sar12_drive
let sar12_stimulus[6] = 0.000148
let sar12_stimulus[7] = sar12_stimulus[5]
alter @VD_B5[pwl] = sar12_stimulus
let sar12_drive = (floor(sar12_trial / 64) - 2*floor(sar12_trial / 128))*1.8
let sar12_previous = @VD_B6[pwl]
let sar12_stimulus = vector(8)
let sar12_stimulus[0] = 0
let sar12_stimulus[1] = sar12_previous[length(sar12_previous)-1]
let sar12_stimulus[2] = 3.7001e-05
let sar12_stimulus[3] = sar12_stimulus[1]
let sar12_stimulus[4] = 3.7003e-05
let sar12_stimulus[5] = sar12_drive
let sar12_stimulus[6] = 0.000148
let sar12_stimulus[7] = sar12_stimulus[5]
alter @VD_B6[pwl] = sar12_stimulus
let sar12_drive = (floor(sar12_trial / 128) - 2*floor(sar12_trial / 256))*1.8
let sar12_previous = @VD_B7[pwl]
let sar12_stimulus = vector(8)
let sar12_stimulus[0] = 0
let sar12_stimulus[1] = sar12_previous[length(sar12_previous)-1]
let sar12_stimulus[2] = 3.7001e-05
let sar12_stimulus[3] = sar12_stimulus[1]
let sar12_stimulus[4] = 3.7003e-05
let sar12_stimulus[5] = sar12_drive
let sar12_stimulus[6] = 0.000148
let sar12_stimulus[7] = sar12_stimulus[5]
alter @VD_B7[pwl] = sar12_stimulus
let sar12_drive = (floor(sar12_trial / 256) - 2*floor(sar12_trial / 512))*1.8
let sar12_previous = @VD_B8[pwl]
let sar12_stimulus = vector(8)
let sar12_stimulus[0] = 0
let sar12_stimulus[1] = sar12_previous[length(sar12_previous)-1]
let sar12_stimulus[2] = 3.7001e-05
let sar12_stimulus[3] = sar12_stimulus[1]
let sar12_stimulus[4] = 3.7003e-05
let sar12_stimulus[5] = sar12_drive
let sar12_stimulus[6] = 0.000148
let sar12_stimulus[7] = sar12_stimulus[5]
alter @VD_B8[pwl] = sar12_stimulus
let sar12_drive = (floor(sar12_trial / 512) - 2*floor(sar12_trial / 1024))*1.8
let sar12_previous = @VD_B9[pwl]
let sar12_stimulus = vector(8)
let sar12_stimulus[0] = 0
let sar12_stimulus[1] = sar12_previous[length(sar12_previous)-1]
let sar12_stimulus[2] = 3.7001e-05
let sar12_stimulus[3] = sar12_stimulus[1]
let sar12_stimulus[4] = 3.7003e-05
let sar12_stimulus[5] = sar12_drive
let sar12_stimulus[6] = 0.000148
let sar12_stimulus[7] = sar12_stimulus[5]
alter @VD_B9[pwl] = sar12_stimulus
let sar12_drive = (floor(sar12_trial / 1024) - 2*floor(sar12_trial / 2048))*1.8
let sar12_previous = @VD_B10[pwl]
let sar12_stimulus = vector(8)
let sar12_stimulus[0] = 0
let sar12_stimulus[1] = sar12_previous[length(sar12_previous)-1]
let sar12_stimulus[2] = 3.7001e-05
let sar12_stimulus[3] = sar12_stimulus[1]
let sar12_stimulus[4] = 3.7003e-05
let sar12_stimulus[5] = sar12_drive
let sar12_stimulus[6] = 0.000148
let sar12_stimulus[7] = sar12_stimulus[5]
alter @VD_B10[pwl] = sar12_stimulus
let sar12_drive = (floor(sar12_trial / 2048) - 2*floor(sar12_trial / 4096))*1.8
let sar12_previous = @VD_B11[pwl]
let sar12_stimulus = vector(8)
let sar12_stimulus[0] = 0
let sar12_stimulus[1] = sar12_previous[length(sar12_previous)-1]
let sar12_stimulus[2] = 3.7001e-05
let sar12_stimulus[3] = sar12_stimulus[1]
let sar12_stimulus[4] = 3.7003e-05
let sar12_stimulus[5] = sar12_drive
let sar12_stimulus[6] = 0.000148
let sar12_stimulus[7] = sar12_stimulus[5]
alter @VD_B11[pwl] = sar12_stimulus
let sar12_drive = (floor(sar12_trial / 4096) - 2*floor(sar12_trial / 8192))*1.8
let sar12_previous = @VD_B12[pwl]
let sar12_stimulus = vector(8)
let sar12_stimulus[0] = 0
let sar12_stimulus[1] = sar12_previous[length(sar12_previous)-1]
let sar12_stimulus[2] = 3.7001e-05
let sar12_stimulus[3] = sar12_stimulus[1]
let sar12_stimulus[4] = 3.7003e-05
let sar12_stimulus[5] = sar12_drive
let sar12_stimulus[6] = 0.000148
let sar12_stimulus[7] = sar12_stimulus[5]
alter @VD_B12[pwl] = sar12_stimulus
let sar12_drive = (floor(sar12_trial / 8192) - 2*floor(sar12_trial / 16384))*1.8
let sar12_previous = @VD_B13[pwl]
let sar12_stimulus = vector(8)
let sar12_stimulus[0] = 0
let sar12_stimulus[1] = sar12_previous[length(sar12_previous)-1]
let sar12_stimulus[2] = 3.7001e-05
let sar12_stimulus[3] = sar12_stimulus[1]
let sar12_stimulus[4] = 3.7003e-05
let sar12_stimulus[5] = sar12_drive
let sar12_stimulus[6] = 0.000148
let sar12_stimulus[7] = sar12_stimulus[5]
alter @VD_B13[pwl] = sar12_stimulus
let sar12_drive = (floor(sar12_trial / 16384) - 2*floor(sar12_trial / 32768))*1.8
let sar12_previous = @VD_B14[pwl]
let sar12_stimulus = vector(8)
let sar12_stimulus[0] = 0
let sar12_stimulus[1] = sar12_previous[length(sar12_previous)-1]
let sar12_stimulus[2] = 3.7001e-05
let sar12_stimulus[3] = sar12_stimulus[1]
let sar12_stimulus[4] = 3.7003e-05
let sar12_stimulus[5] = sar12_drive
let sar12_stimulus[6] = 0.000148
let sar12_stimulus[7] = sar12_stimulus[5]
alter @VD_B14[pwl] = sar12_stimulus
let sar12_drive = (floor(sar12_trial / 32768) - 2*floor(sar12_trial / 65536))*1.8
let sar12_previous = @VD_B15[pwl]
let sar12_stimulus = vector(8)
let sar12_stimulus[0] = 0
let sar12_stimulus[1] = sar12_previous[length(sar12_previous)-1]
let sar12_stimulus[2] = 3.7001e-05
let sar12_stimulus[3] = sar12_stimulus[1]
let sar12_stimulus[4] = 3.7003e-05
let sar12_stimulus[5] = sar12_drive
let sar12_stimulus[6] = 0.000148
let sar12_stimulus[7] = sar12_stimulus[5]
alter @VD_B15[pwl] = sar12_stimulus
resume
let sar12_k = length(time)-1
if abs(time[sar12_k] - 3.75e-05) > 1e-12
print time[sar12_k]
echo expected_pause_time_s 3.75e-05
echo SAR12_PAUSE_FAILED
quit 1
end
print time[sar12_k] >> pause-times.txt
let sar12_previous = @VD_EVAL[pwl]
let sar12_stimulus = vector(8)
let sar12_stimulus[0] = 0
let sar12_stimulus[1] = sar12_previous[length(sar12_previous)-1]
let sar12_stimulus[2] = 3.7501e-05
let sar12_stimulus[3] = sar12_stimulus[1]
let sar12_stimulus[4] = 3.7503e-05
let sar12_stimulus[5] = 1.8
let sar12_stimulus[6] = 0.000148
let sar12_stimulus[7] = sar12_stimulus[5]
alter @VD_EVAL[pwl] = sar12_stimulus
resume
let sar12_k = length(time)-1
if abs(time[sar12_k] - 3.8e-05) > 1e-12
print time[sar12_k]
echo expected_pause_time_s 3.8e-05
echo SAR12_PAUSE_FAILED
quit 1
end
print time[sar12_k] >> pause-times.txt
let sar12_k = length(time)-1
let sar12_cmp = v(COMP)[sar12_k]
let sar12_cmpn = v(COMPN)[sar12_k]
let sar12_p = v(TOPP)[sar12_k]
let sar12_n = v(TOPN)[sar12_k]
let sar12_decision = 0
if sar12_cmp >= 0.9
let sar12_code = sar12_trial
let sar12_decision = 1
end
echo 1 11 $&sar12_trial $&sar12_cmp $&sar12_cmpn $&sar12_p $&sar12_n -1.19998168945312 $&sar12_decision >> decisions.csv
let sar12_previous = @VD_EVAL[pwl]
let sar12_stimulus = vector(8)
let sar12_stimulus[0] = 0
let sar12_stimulus[1] = sar12_previous[length(sar12_previous)-1]
let sar12_stimulus[2] = 3.8001e-05
let sar12_stimulus[3] = sar12_stimulus[1]
let sar12_stimulus[4] = 3.8003e-05
let sar12_stimulus[5] = 0
let sar12_stimulus[6] = 0.000148
let sar12_stimulus[7] = sar12_stimulus[5]
alter @VD_EVAL[pwl] = sar12_stimulus
let sar12_trial = sar12_code + 1024
let sar12_drive = (floor(sar12_trial / 1) - 2*floor(sar12_trial / 2))*1.8
let sar12_previous = @VD_B0[pwl]
let sar12_stimulus = vector(8)
let sar12_stimulus[0] = 0
let sar12_stimulus[1] = sar12_previous[length(sar12_previous)-1]
let sar12_stimulus[2] = 3.8001e-05
let sar12_stimulus[3] = sar12_stimulus[1]
let sar12_stimulus[4] = 3.8003e-05
let sar12_stimulus[5] = sar12_drive
let sar12_stimulus[6] = 0.000148
let sar12_stimulus[7] = sar12_stimulus[5]
alter @VD_B0[pwl] = sar12_stimulus
let sar12_drive = (floor(sar12_trial / 2) - 2*floor(sar12_trial / 4))*1.8
let sar12_previous = @VD_B1[pwl]
let sar12_stimulus = vector(8)
let sar12_stimulus[0] = 0
let sar12_stimulus[1] = sar12_previous[length(sar12_previous)-1]
let sar12_stimulus[2] = 3.8001e-05
let sar12_stimulus[3] = sar12_stimulus[1]
let sar12_stimulus[4] = 3.8003e-05
let sar12_stimulus[5] = sar12_drive
let sar12_stimulus[6] = 0.000148
let sar12_stimulus[7] = sar12_stimulus[5]
alter @VD_B1[pwl] = sar12_stimulus
let sar12_drive = (floor(sar12_trial / 4) - 2*floor(sar12_trial / 8))*1.8
let sar12_previous = @VD_B2[pwl]
let sar12_stimulus = vector(8)
let sar12_stimulus[0] = 0
let sar12_stimulus[1] = sar12_previous[length(sar12_previous)-1]
let sar12_stimulus[2] = 3.8001e-05
let sar12_stimulus[3] = sar12_stimulus[1]
let sar12_stimulus[4] = 3.8003e-05
let sar12_stimulus[5] = sar12_drive
let sar12_stimulus[6] = 0.000148
let sar12_stimulus[7] = sar12_stimulus[5]
alter @VD_B2[pwl] = sar12_stimulus
let sar12_drive = (floor(sar12_trial / 8) - 2*floor(sar12_trial / 16))*1.8
let sar12_previous = @VD_B3[pwl]
let sar12_stimulus = vector(8)
let sar12_stimulus[0] = 0
let sar12_stimulus[1] = sar12_previous[length(sar12_previous)-1]
let sar12_stimulus[2] = 3.8001e-05
let sar12_stimulus[3] = sar12_stimulus[1]
let sar12_stimulus[4] = 3.8003e-05
let sar12_stimulus[5] = sar12_drive
let sar12_stimulus[6] = 0.000148
let sar12_stimulus[7] = sar12_stimulus[5]
alter @VD_B3[pwl] = sar12_stimulus
let sar12_drive = (floor(sar12_trial / 16) - 2*floor(sar12_trial / 32))*1.8
let sar12_previous = @VD_B4[pwl]
let sar12_stimulus = vector(8)
let sar12_stimulus[0] = 0
let sar12_stimulus[1] = sar12_previous[length(sar12_previous)-1]
let sar12_stimulus[2] = 3.8001e-05
let sar12_stimulus[3] = sar12_stimulus[1]
let sar12_stimulus[4] = 3.8003e-05
let sar12_stimulus[5] = sar12_drive
let sar12_stimulus[6] = 0.000148
let sar12_stimulus[7] = sar12_stimulus[5]
alter @VD_B4[pwl] = sar12_stimulus
let sar12_drive = (floor(sar12_trial / 32) - 2*floor(sar12_trial / 64))*1.8
let sar12_previous = @VD_B5[pwl]
let sar12_stimulus = vector(8)
let sar12_stimulus[0] = 0
let sar12_stimulus[1] = sar12_previous[length(sar12_previous)-1]
let sar12_stimulus[2] = 3.8001e-05
let sar12_stimulus[3] = sar12_stimulus[1]
let sar12_stimulus[4] = 3.8003e-05
let sar12_stimulus[5] = sar12_drive
let sar12_stimulus[6] = 0.000148
let sar12_stimulus[7] = sar12_stimulus[5]
alter @VD_B5[pwl] = sar12_stimulus
let sar12_drive = (floor(sar12_trial / 64) - 2*floor(sar12_trial / 128))*1.8
let sar12_previous = @VD_B6[pwl]
let sar12_stimulus = vector(8)
let sar12_stimulus[0] = 0
let sar12_stimulus[1] = sar12_previous[length(sar12_previous)-1]
let sar12_stimulus[2] = 3.8001e-05
let sar12_stimulus[3] = sar12_stimulus[1]
let sar12_stimulus[4] = 3.8003e-05
let sar12_stimulus[5] = sar12_drive
let sar12_stimulus[6] = 0.000148
let sar12_stimulus[7] = sar12_stimulus[5]
alter @VD_B6[pwl] = sar12_stimulus
let sar12_drive = (floor(sar12_trial / 128) - 2*floor(sar12_trial / 256))*1.8
let sar12_previous = @VD_B7[pwl]
let sar12_stimulus = vector(8)
let sar12_stimulus[0] = 0
let sar12_stimulus[1] = sar12_previous[length(sar12_previous)-1]
let sar12_stimulus[2] = 3.8001e-05
let sar12_stimulus[3] = sar12_stimulus[1]
let sar12_stimulus[4] = 3.8003e-05
let sar12_stimulus[5] = sar12_drive
let sar12_stimulus[6] = 0.000148
let sar12_stimulus[7] = sar12_stimulus[5]
alter @VD_B7[pwl] = sar12_stimulus
let sar12_drive = (floor(sar12_trial / 256) - 2*floor(sar12_trial / 512))*1.8
let sar12_previous = @VD_B8[pwl]
let sar12_stimulus = vector(8)
let sar12_stimulus[0] = 0
let sar12_stimulus[1] = sar12_previous[length(sar12_previous)-1]
let sar12_stimulus[2] = 3.8001e-05
let sar12_stimulus[3] = sar12_stimulus[1]
let sar12_stimulus[4] = 3.8003e-05
let sar12_stimulus[5] = sar12_drive
let sar12_stimulus[6] = 0.000148
let sar12_stimulus[7] = sar12_stimulus[5]
alter @VD_B8[pwl] = sar12_stimulus
let sar12_drive = (floor(sar12_trial / 512) - 2*floor(sar12_trial / 1024))*1.8
let sar12_previous = @VD_B9[pwl]
let sar12_stimulus = vector(8)
let sar12_stimulus[0] = 0
let sar12_stimulus[1] = sar12_previous[length(sar12_previous)-1]
let sar12_stimulus[2] = 3.8001e-05
let sar12_stimulus[3] = sar12_stimulus[1]
let sar12_stimulus[4] = 3.8003e-05
let sar12_stimulus[5] = sar12_drive
let sar12_stimulus[6] = 0.000148
let sar12_stimulus[7] = sar12_stimulus[5]
alter @VD_B9[pwl] = sar12_stimulus
let sar12_drive = (floor(sar12_trial / 1024) - 2*floor(sar12_trial / 2048))*1.8
let sar12_previous = @VD_B10[pwl]
let sar12_stimulus = vector(8)
let sar12_stimulus[0] = 0
let sar12_stimulus[1] = sar12_previous[length(sar12_previous)-1]
let sar12_stimulus[2] = 3.8001e-05
let sar12_stimulus[3] = sar12_stimulus[1]
let sar12_stimulus[4] = 3.8003e-05
let sar12_stimulus[5] = sar12_drive
let sar12_stimulus[6] = 0.000148
let sar12_stimulus[7] = sar12_stimulus[5]
alter @VD_B10[pwl] = sar12_stimulus
let sar12_drive = (floor(sar12_trial / 2048) - 2*floor(sar12_trial / 4096))*1.8
let sar12_previous = @VD_B11[pwl]
let sar12_stimulus = vector(8)
let sar12_stimulus[0] = 0
let sar12_stimulus[1] = sar12_previous[length(sar12_previous)-1]
let sar12_stimulus[2] = 3.8001e-05
let sar12_stimulus[3] = sar12_stimulus[1]
let sar12_stimulus[4] = 3.8003e-05
let sar12_stimulus[5] = sar12_drive
let sar12_stimulus[6] = 0.000148
let sar12_stimulus[7] = sar12_stimulus[5]
alter @VD_B11[pwl] = sar12_stimulus
let sar12_drive = (floor(sar12_trial / 4096) - 2*floor(sar12_trial / 8192))*1.8
let sar12_previous = @VD_B12[pwl]
let sar12_stimulus = vector(8)
let sar12_stimulus[0] = 0
let sar12_stimulus[1] = sar12_previous[length(sar12_previous)-1]
let sar12_stimulus[2] = 3.8001e-05
let sar12_stimulus[3] = sar12_stimulus[1]
let sar12_stimulus[4] = 3.8003e-05
let sar12_stimulus[5] = sar12_drive
let sar12_stimulus[6] = 0.000148
let sar12_stimulus[7] = sar12_stimulus[5]
alter @VD_B12[pwl] = sar12_stimulus
let sar12_drive = (floor(sar12_trial / 8192) - 2*floor(sar12_trial / 16384))*1.8
let sar12_previous = @VD_B13[pwl]
let sar12_stimulus = vector(8)
let sar12_stimulus[0] = 0
let sar12_stimulus[1] = sar12_previous[length(sar12_previous)-1]
let sar12_stimulus[2] = 3.8001e-05
let sar12_stimulus[3] = sar12_stimulus[1]
let sar12_stimulus[4] = 3.8003e-05
let sar12_stimulus[5] = sar12_drive
let sar12_stimulus[6] = 0.000148
let sar12_stimulus[7] = sar12_stimulus[5]
alter @VD_B13[pwl] = sar12_stimulus
let sar12_drive = (floor(sar12_trial / 16384) - 2*floor(sar12_trial / 32768))*1.8
let sar12_previous = @VD_B14[pwl]
let sar12_stimulus = vector(8)
let sar12_stimulus[0] = 0
let sar12_stimulus[1] = sar12_previous[length(sar12_previous)-1]
let sar12_stimulus[2] = 3.8001e-05
let sar12_stimulus[3] = sar12_stimulus[1]
let sar12_stimulus[4] = 3.8003e-05
let sar12_stimulus[5] = sar12_drive
let sar12_stimulus[6] = 0.000148
let sar12_stimulus[7] = sar12_stimulus[5]
alter @VD_B14[pwl] = sar12_stimulus
let sar12_drive = (floor(sar12_trial / 32768) - 2*floor(sar12_trial / 65536))*1.8
let sar12_previous = @VD_B15[pwl]
let sar12_stimulus = vector(8)
let sar12_stimulus[0] = 0
let sar12_stimulus[1] = sar12_previous[length(sar12_previous)-1]
let sar12_stimulus[2] = 3.8001e-05
let sar12_stimulus[3] = sar12_stimulus[1]
let sar12_stimulus[4] = 3.8003e-05
let sar12_stimulus[5] = sar12_drive
let sar12_stimulus[6] = 0.000148
let sar12_stimulus[7] = sar12_stimulus[5]
alter @VD_B15[pwl] = sar12_stimulus
resume
let sar12_k = length(time)-1
if abs(time[sar12_k] - 3.85e-05) > 1e-12
print time[sar12_k]
echo expected_pause_time_s 3.85e-05
echo SAR12_PAUSE_FAILED
quit 1
end
print time[sar12_k] >> pause-times.txt
let sar12_previous = @VD_EVAL[pwl]
let sar12_stimulus = vector(8)
let sar12_stimulus[0] = 0
let sar12_stimulus[1] = sar12_previous[length(sar12_previous)-1]
let sar12_stimulus[2] = 3.8501e-05
let sar12_stimulus[3] = sar12_stimulus[1]
let sar12_stimulus[4] = 3.8503e-05
let sar12_stimulus[5] = 1.8
let sar12_stimulus[6] = 0.000148
let sar12_stimulus[7] = sar12_stimulus[5]
alter @VD_EVAL[pwl] = sar12_stimulus
resume
let sar12_k = length(time)-1
if abs(time[sar12_k] - 3.9e-05) > 1e-12
print time[sar12_k]
echo expected_pause_time_s 3.9e-05
echo SAR12_PAUSE_FAILED
quit 1
end
print time[sar12_k] >> pause-times.txt
let sar12_k = length(time)-1
let sar12_cmp = v(COMP)[sar12_k]
let sar12_cmpn = v(COMPN)[sar12_k]
let sar12_p = v(TOPP)[sar12_k]
let sar12_n = v(TOPN)[sar12_k]
let sar12_decision = 0
if sar12_cmp >= 0.9
let sar12_code = sar12_trial
let sar12_decision = 1
end
echo 1 10 $&sar12_trial $&sar12_cmp $&sar12_cmpn $&sar12_p $&sar12_n -1.19998168945312 $&sar12_decision >> decisions.csv
let sar12_previous = @VD_EVAL[pwl]
let sar12_stimulus = vector(8)
let sar12_stimulus[0] = 0
let sar12_stimulus[1] = sar12_previous[length(sar12_previous)-1]
let sar12_stimulus[2] = 3.9001e-05
let sar12_stimulus[3] = sar12_stimulus[1]
let sar12_stimulus[4] = 3.9003e-05
let sar12_stimulus[5] = 0
let sar12_stimulus[6] = 0.000148
let sar12_stimulus[7] = sar12_stimulus[5]
alter @VD_EVAL[pwl] = sar12_stimulus
let sar12_trial = sar12_code + 512
let sar12_drive = (floor(sar12_trial / 1) - 2*floor(sar12_trial / 2))*1.8
let sar12_previous = @VD_B0[pwl]
let sar12_stimulus = vector(8)
let sar12_stimulus[0] = 0
let sar12_stimulus[1] = sar12_previous[length(sar12_previous)-1]
let sar12_stimulus[2] = 3.9001e-05
let sar12_stimulus[3] = sar12_stimulus[1]
let sar12_stimulus[4] = 3.9003e-05
let sar12_stimulus[5] = sar12_drive
let sar12_stimulus[6] = 0.000148
let sar12_stimulus[7] = sar12_stimulus[5]
alter @VD_B0[pwl] = sar12_stimulus
let sar12_drive = (floor(sar12_trial / 2) - 2*floor(sar12_trial / 4))*1.8
let sar12_previous = @VD_B1[pwl]
let sar12_stimulus = vector(8)
let sar12_stimulus[0] = 0
let sar12_stimulus[1] = sar12_previous[length(sar12_previous)-1]
let sar12_stimulus[2] = 3.9001e-05
let sar12_stimulus[3] = sar12_stimulus[1]
let sar12_stimulus[4] = 3.9003e-05
let sar12_stimulus[5] = sar12_drive
let sar12_stimulus[6] = 0.000148
let sar12_stimulus[7] = sar12_stimulus[5]
alter @VD_B1[pwl] = sar12_stimulus
let sar12_drive = (floor(sar12_trial / 4) - 2*floor(sar12_trial / 8))*1.8
let sar12_previous = @VD_B2[pwl]
let sar12_stimulus = vector(8)
let sar12_stimulus[0] = 0
let sar12_stimulus[1] = sar12_previous[length(sar12_previous)-1]
let sar12_stimulus[2] = 3.9001e-05
let sar12_stimulus[3] = sar12_stimulus[1]
let sar12_stimulus[4] = 3.9003e-05
let sar12_stimulus[5] = sar12_drive
let sar12_stimulus[6] = 0.000148
let sar12_stimulus[7] = sar12_stimulus[5]
alter @VD_B2[pwl] = sar12_stimulus
let sar12_drive = (floor(sar12_trial / 8) - 2*floor(sar12_trial / 16))*1.8
let sar12_previous = @VD_B3[pwl]
let sar12_stimulus = vector(8)
let sar12_stimulus[0] = 0
let sar12_stimulus[1] = sar12_previous[length(sar12_previous)-1]
let sar12_stimulus[2] = 3.9001e-05
let sar12_stimulus[3] = sar12_stimulus[1]
let sar12_stimulus[4] = 3.9003e-05
let sar12_stimulus[5] = sar12_drive
let sar12_stimulus[6] = 0.000148
let sar12_stimulus[7] = sar12_stimulus[5]
alter @VD_B3[pwl] = sar12_stimulus
let sar12_drive = (floor(sar12_trial / 16) - 2*floor(sar12_trial / 32))*1.8
let sar12_previous = @VD_B4[pwl]
let sar12_stimulus = vector(8)
let sar12_stimulus[0] = 0
let sar12_stimulus[1] = sar12_previous[length(sar12_previous)-1]
let sar12_stimulus[2] = 3.9001e-05
let sar12_stimulus[3] = sar12_stimulus[1]
let sar12_stimulus[4] = 3.9003e-05
let sar12_stimulus[5] = sar12_drive
let sar12_stimulus[6] = 0.000148
let sar12_stimulus[7] = sar12_stimulus[5]
alter @VD_B4[pwl] = sar12_stimulus
let sar12_drive = (floor(sar12_trial / 32) - 2*floor(sar12_trial / 64))*1.8
let sar12_previous = @VD_B5[pwl]
let sar12_stimulus = vector(8)
let sar12_stimulus[0] = 0
let sar12_stimulus[1] = sar12_previous[length(sar12_previous)-1]
let sar12_stimulus[2] = 3.9001e-05
let sar12_stimulus[3] = sar12_stimulus[1]
let sar12_stimulus[4] = 3.9003e-05
let sar12_stimulus[5] = sar12_drive
let sar12_stimulus[6] = 0.000148
let sar12_stimulus[7] = sar12_stimulus[5]
alter @VD_B5[pwl] = sar12_stimulus
let sar12_drive = (floor(sar12_trial / 64) - 2*floor(sar12_trial / 128))*1.8
let sar12_previous = @VD_B6[pwl]
let sar12_stimulus = vector(8)
let sar12_stimulus[0] = 0
let sar12_stimulus[1] = sar12_previous[length(sar12_previous)-1]
let sar12_stimulus[2] = 3.9001e-05
let sar12_stimulus[3] = sar12_stimulus[1]
let sar12_stimulus[4] = 3.9003e-05
let sar12_stimulus[5] = sar12_drive
let sar12_stimulus[6] = 0.000148
let sar12_stimulus[7] = sar12_stimulus[5]
alter @VD_B6[pwl] = sar12_stimulus
let sar12_drive = (floor(sar12_trial / 128) - 2*floor(sar12_trial / 256))*1.8
let sar12_previous = @VD_B7[pwl]
let sar12_stimulus = vector(8)
let sar12_stimulus[0] = 0
let sar12_stimulus[1] = sar12_previous[length(sar12_previous)-1]
let sar12_stimulus[2] = 3.9001e-05
let sar12_stimulus[3] = sar12_stimulus[1]
let sar12_stimulus[4] = 3.9003e-05
let sar12_stimulus[5] = sar12_drive
let sar12_stimulus[6] = 0.000148
let sar12_stimulus[7] = sar12_stimulus[5]
alter @VD_B7[pwl] = sar12_stimulus
let sar12_drive = (floor(sar12_trial / 256) - 2*floor(sar12_trial / 512))*1.8
let sar12_previous = @VD_B8[pwl]
let sar12_stimulus = vector(8)
let sar12_stimulus[0] = 0
let sar12_stimulus[1] = sar12_previous[length(sar12_previous)-1]
let sar12_stimulus[2] = 3.9001e-05
let sar12_stimulus[3] = sar12_stimulus[1]
let sar12_stimulus[4] = 3.9003e-05
let sar12_stimulus[5] = sar12_drive
let sar12_stimulus[6] = 0.000148
let sar12_stimulus[7] = sar12_stimulus[5]
alter @VD_B8[pwl] = sar12_stimulus
let sar12_drive = (floor(sar12_trial / 512) - 2*floor(sar12_trial / 1024))*1.8
let sar12_previous = @VD_B9[pwl]
let sar12_stimulus = vector(8)
let sar12_stimulus[0] = 0
let sar12_stimulus[1] = sar12_previous[length(sar12_previous)-1]
let sar12_stimulus[2] = 3.9001e-05
let sar12_stimulus[3] = sar12_stimulus[1]
let sar12_stimulus[4] = 3.9003e-05
let sar12_stimulus[5] = sar12_drive
let sar12_stimulus[6] = 0.000148
let sar12_stimulus[7] = sar12_stimulus[5]
alter @VD_B9[pwl] = sar12_stimulus
let sar12_drive = (floor(sar12_trial / 1024) - 2*floor(sar12_trial / 2048))*1.8
let sar12_previous = @VD_B10[pwl]
let sar12_stimulus = vector(8)
let sar12_stimulus[0] = 0
let sar12_stimulus[1] = sar12_previous[length(sar12_previous)-1]
let sar12_stimulus[2] = 3.9001e-05
let sar12_stimulus[3] = sar12_stimulus[1]
let sar12_stimulus[4] = 3.9003e-05
let sar12_stimulus[5] = sar12_drive
let sar12_stimulus[6] = 0.000148
let sar12_stimulus[7] = sar12_stimulus[5]
alter @VD_B10[pwl] = sar12_stimulus
let sar12_drive = (floor(sar12_trial / 2048) - 2*floor(sar12_trial / 4096))*1.8
let sar12_previous = @VD_B11[pwl]
let sar12_stimulus = vector(8)
let sar12_stimulus[0] = 0
let sar12_stimulus[1] = sar12_previous[length(sar12_previous)-1]
let sar12_stimulus[2] = 3.9001e-05
let sar12_stimulus[3] = sar12_stimulus[1]
let sar12_stimulus[4] = 3.9003e-05
let sar12_stimulus[5] = sar12_drive
let sar12_stimulus[6] = 0.000148
let sar12_stimulus[7] = sar12_stimulus[5]
alter @VD_B11[pwl] = sar12_stimulus
let sar12_drive = (floor(sar12_trial / 4096) - 2*floor(sar12_trial / 8192))*1.8
let sar12_previous = @VD_B12[pwl]
let sar12_stimulus = vector(8)
let sar12_stimulus[0] = 0
let sar12_stimulus[1] = sar12_previous[length(sar12_previous)-1]
let sar12_stimulus[2] = 3.9001e-05
let sar12_stimulus[3] = sar12_stimulus[1]
let sar12_stimulus[4] = 3.9003e-05
let sar12_stimulus[5] = sar12_drive
let sar12_stimulus[6] = 0.000148
let sar12_stimulus[7] = sar12_stimulus[5]
alter @VD_B12[pwl] = sar12_stimulus
let sar12_drive = (floor(sar12_trial / 8192) - 2*floor(sar12_trial / 16384))*1.8
let sar12_previous = @VD_B13[pwl]
let sar12_stimulus = vector(8)
let sar12_stimulus[0] = 0
let sar12_stimulus[1] = sar12_previous[length(sar12_previous)-1]
let sar12_stimulus[2] = 3.9001e-05
let sar12_stimulus[3] = sar12_stimulus[1]
let sar12_stimulus[4] = 3.9003e-05
let sar12_stimulus[5] = sar12_drive
let sar12_stimulus[6] = 0.000148
let sar12_stimulus[7] = sar12_stimulus[5]
alter @VD_B13[pwl] = sar12_stimulus
let sar12_drive = (floor(sar12_trial / 16384) - 2*floor(sar12_trial / 32768))*1.8
let sar12_previous = @VD_B14[pwl]
let sar12_stimulus = vector(8)
let sar12_stimulus[0] = 0
let sar12_stimulus[1] = sar12_previous[length(sar12_previous)-1]
let sar12_stimulus[2] = 3.9001e-05
let sar12_stimulus[3] = sar12_stimulus[1]
let sar12_stimulus[4] = 3.9003e-05
let sar12_stimulus[5] = sar12_drive
let sar12_stimulus[6] = 0.000148
let sar12_stimulus[7] = sar12_stimulus[5]
alter @VD_B14[pwl] = sar12_stimulus
let sar12_drive = (floor(sar12_trial / 32768) - 2*floor(sar12_trial / 65536))*1.8
let sar12_previous = @VD_B15[pwl]
let sar12_stimulus = vector(8)
let sar12_stimulus[0] = 0
let sar12_stimulus[1] = sar12_previous[length(sar12_previous)-1]
let sar12_stimulus[2] = 3.9001e-05
let sar12_stimulus[3] = sar12_stimulus[1]
let sar12_stimulus[4] = 3.9003e-05
let sar12_stimulus[5] = sar12_drive
let sar12_stimulus[6] = 0.000148
let sar12_stimulus[7] = sar12_stimulus[5]
alter @VD_B15[pwl] = sar12_stimulus
resume
let sar12_k = length(time)-1
if abs(time[sar12_k] - 3.95e-05) > 1e-12
print time[sar12_k]
echo expected_pause_time_s 3.95e-05
echo SAR12_PAUSE_FAILED
quit 1
end
print time[sar12_k] >> pause-times.txt
let sar12_previous = @VD_EVAL[pwl]
let sar12_stimulus = vector(8)
let sar12_stimulus[0] = 0
let sar12_stimulus[1] = sar12_previous[length(sar12_previous)-1]
let sar12_stimulus[2] = 3.9501e-05
let sar12_stimulus[3] = sar12_stimulus[1]
let sar12_stimulus[4] = 3.9503e-05
let sar12_stimulus[5] = 1.8
let sar12_stimulus[6] = 0.000148
let sar12_stimulus[7] = sar12_stimulus[5]
alter @VD_EVAL[pwl] = sar12_stimulus
resume
let sar12_k = length(time)-1
if abs(time[sar12_k] - 4e-05) > 1e-12
print time[sar12_k]
echo expected_pause_time_s 4e-05
echo SAR12_PAUSE_FAILED
quit 1
end
print time[sar12_k] >> pause-times.txt
let sar12_k = length(time)-1
let sar12_cmp = v(COMP)[sar12_k]
let sar12_cmpn = v(COMPN)[sar12_k]
let sar12_p = v(TOPP)[sar12_k]
let sar12_n = v(TOPN)[sar12_k]
let sar12_decision = 0
if sar12_cmp >= 0.9
let sar12_code = sar12_trial
let sar12_decision = 1
end
echo 1 9 $&sar12_trial $&sar12_cmp $&sar12_cmpn $&sar12_p $&sar12_n -1.19998168945312 $&sar12_decision >> decisions.csv
let sar12_previous = @VD_EVAL[pwl]
let sar12_stimulus = vector(8)
let sar12_stimulus[0] = 0
let sar12_stimulus[1] = sar12_previous[length(sar12_previous)-1]
let sar12_stimulus[2] = 4.0001e-05
let sar12_stimulus[3] = sar12_stimulus[1]
let sar12_stimulus[4] = 4.0003e-05
let sar12_stimulus[5] = 0
let sar12_stimulus[6] = 0.000148
let sar12_stimulus[7] = sar12_stimulus[5]
alter @VD_EVAL[pwl] = sar12_stimulus
let sar12_trial = sar12_code + 256
let sar12_drive = (floor(sar12_trial / 1) - 2*floor(sar12_trial / 2))*1.8
let sar12_previous = @VD_B0[pwl]
let sar12_stimulus = vector(8)
let sar12_stimulus[0] = 0
let sar12_stimulus[1] = sar12_previous[length(sar12_previous)-1]
let sar12_stimulus[2] = 4.0001e-05
let sar12_stimulus[3] = sar12_stimulus[1]
let sar12_stimulus[4] = 4.0003e-05
let sar12_stimulus[5] = sar12_drive
let sar12_stimulus[6] = 0.000148
let sar12_stimulus[7] = sar12_stimulus[5]
alter @VD_B0[pwl] = sar12_stimulus
let sar12_drive = (floor(sar12_trial / 2) - 2*floor(sar12_trial / 4))*1.8
let sar12_previous = @VD_B1[pwl]
let sar12_stimulus = vector(8)
let sar12_stimulus[0] = 0
let sar12_stimulus[1] = sar12_previous[length(sar12_previous)-1]
let sar12_stimulus[2] = 4.0001e-05
let sar12_stimulus[3] = sar12_stimulus[1]
let sar12_stimulus[4] = 4.0003e-05
let sar12_stimulus[5] = sar12_drive
let sar12_stimulus[6] = 0.000148
let sar12_stimulus[7] = sar12_stimulus[5]
alter @VD_B1[pwl] = sar12_stimulus
let sar12_drive = (floor(sar12_trial / 4) - 2*floor(sar12_trial / 8))*1.8
let sar12_previous = @VD_B2[pwl]
let sar12_stimulus = vector(8)
let sar12_stimulus[0] = 0
let sar12_stimulus[1] = sar12_previous[length(sar12_previous)-1]
let sar12_stimulus[2] = 4.0001e-05
let sar12_stimulus[3] = sar12_stimulus[1]
let sar12_stimulus[4] = 4.0003e-05
let sar12_stimulus[5] = sar12_drive
let sar12_stimulus[6] = 0.000148
let sar12_stimulus[7] = sar12_stimulus[5]
alter @VD_B2[pwl] = sar12_stimulus
let sar12_drive = (floor(sar12_trial / 8) - 2*floor(sar12_trial / 16))*1.8
let sar12_previous = @VD_B3[pwl]
let sar12_stimulus = vector(8)
let sar12_stimulus[0] = 0
let sar12_stimulus[1] = sar12_previous[length(sar12_previous)-1]
let sar12_stimulus[2] = 4.0001e-05
let sar12_stimulus[3] = sar12_stimulus[1]
let sar12_stimulus[4] = 4.0003e-05
let sar12_stimulus[5] = sar12_drive
let sar12_stimulus[6] = 0.000148
let sar12_stimulus[7] = sar12_stimulus[5]
alter @VD_B3[pwl] = sar12_stimulus
let sar12_drive = (floor(sar12_trial / 16) - 2*floor(sar12_trial / 32))*1.8
let sar12_previous = @VD_B4[pwl]
let sar12_stimulus = vector(8)
let sar12_stimulus[0] = 0
let sar12_stimulus[1] = sar12_previous[length(sar12_previous)-1]
let sar12_stimulus[2] = 4.0001e-05
let sar12_stimulus[3] = sar12_stimulus[1]
let sar12_stimulus[4] = 4.0003e-05
let sar12_stimulus[5] = sar12_drive
let sar12_stimulus[6] = 0.000148
let sar12_stimulus[7] = sar12_stimulus[5]
alter @VD_B4[pwl] = sar12_stimulus
let sar12_drive = (floor(sar12_trial / 32) - 2*floor(sar12_trial / 64))*1.8
let sar12_previous = @VD_B5[pwl]
let sar12_stimulus = vector(8)
let sar12_stimulus[0] = 0
let sar12_stimulus[1] = sar12_previous[length(sar12_previous)-1]
let sar12_stimulus[2] = 4.0001e-05
let sar12_stimulus[3] = sar12_stimulus[1]
let sar12_stimulus[4] = 4.0003e-05
let sar12_stimulus[5] = sar12_drive
let sar12_stimulus[6] = 0.000148
let sar12_stimulus[7] = sar12_stimulus[5]
alter @VD_B5[pwl] = sar12_stimulus
let sar12_drive = (floor(sar12_trial / 64) - 2*floor(sar12_trial / 128))*1.8
let sar12_previous = @VD_B6[pwl]
let sar12_stimulus = vector(8)
let sar12_stimulus[0] = 0
let sar12_stimulus[1] = sar12_previous[length(sar12_previous)-1]
let sar12_stimulus[2] = 4.0001e-05
let sar12_stimulus[3] = sar12_stimulus[1]
let sar12_stimulus[4] = 4.0003e-05
let sar12_stimulus[5] = sar12_drive
let sar12_stimulus[6] = 0.000148
let sar12_stimulus[7] = sar12_stimulus[5]
alter @VD_B6[pwl] = sar12_stimulus
let sar12_drive = (floor(sar12_trial / 128) - 2*floor(sar12_trial / 256))*1.8
let sar12_previous = @VD_B7[pwl]
let sar12_stimulus = vector(8)
let sar12_stimulus[0] = 0
let sar12_stimulus[1] = sar12_previous[length(sar12_previous)-1]
let sar12_stimulus[2] = 4.0001e-05
let sar12_stimulus[3] = sar12_stimulus[1]
let sar12_stimulus[4] = 4.0003e-05
let sar12_stimulus[5] = sar12_drive
let sar12_stimulus[6] = 0.000148
let sar12_stimulus[7] = sar12_stimulus[5]
alter @VD_B7[pwl] = sar12_stimulus
let sar12_drive = (floor(sar12_trial / 256) - 2*floor(sar12_trial / 512))*1.8
let sar12_previous = @VD_B8[pwl]
let sar12_stimulus = vector(8)
let sar12_stimulus[0] = 0
let sar12_stimulus[1] = sar12_previous[length(sar12_previous)-1]
let sar12_stimulus[2] = 4.0001e-05
let sar12_stimulus[3] = sar12_stimulus[1]
let sar12_stimulus[4] = 4.0003e-05
let sar12_stimulus[5] = sar12_drive
let sar12_stimulus[6] = 0.000148
let sar12_stimulus[7] = sar12_stimulus[5]
alter @VD_B8[pwl] = sar12_stimulus
let sar12_drive = (floor(sar12_trial / 512) - 2*floor(sar12_trial / 1024))*1.8
let sar12_previous = @VD_B9[pwl]
let sar12_stimulus = vector(8)
let sar12_stimulus[0] = 0
let sar12_stimulus[1] = sar12_previous[length(sar12_previous)-1]
let sar12_stimulus[2] = 4.0001e-05
let sar12_stimulus[3] = sar12_stimulus[1]
let sar12_stimulus[4] = 4.0003e-05
let sar12_stimulus[5] = sar12_drive
let sar12_stimulus[6] = 0.000148
let sar12_stimulus[7] = sar12_stimulus[5]
alter @VD_B9[pwl] = sar12_stimulus
let sar12_drive = (floor(sar12_trial / 1024) - 2*floor(sar12_trial / 2048))*1.8
let sar12_previous = @VD_B10[pwl]
let sar12_stimulus = vector(8)
let sar12_stimulus[0] = 0
let sar12_stimulus[1] = sar12_previous[length(sar12_previous)-1]
let sar12_stimulus[2] = 4.0001e-05
let sar12_stimulus[3] = sar12_stimulus[1]
let sar12_stimulus[4] = 4.0003e-05
let sar12_stimulus[5] = sar12_drive
let sar12_stimulus[6] = 0.000148
let sar12_stimulus[7] = sar12_stimulus[5]
alter @VD_B10[pwl] = sar12_stimulus
let sar12_drive = (floor(sar12_trial / 2048) - 2*floor(sar12_trial / 4096))*1.8
let sar12_previous = @VD_B11[pwl]
let sar12_stimulus = vector(8)
let sar12_stimulus[0] = 0
let sar12_stimulus[1] = sar12_previous[length(sar12_previous)-1]
let sar12_stimulus[2] = 4.0001e-05
let sar12_stimulus[3] = sar12_stimulus[1]
let sar12_stimulus[4] = 4.0003e-05
let sar12_stimulus[5] = sar12_drive
let sar12_stimulus[6] = 0.000148
let sar12_stimulus[7] = sar12_stimulus[5]
alter @VD_B11[pwl] = sar12_stimulus
let sar12_drive = (floor(sar12_trial / 4096) - 2*floor(sar12_trial / 8192))*1.8
let sar12_previous = @VD_B12[pwl]
let sar12_stimulus = vector(8)
let sar12_stimulus[0] = 0
let sar12_stimulus[1] = sar12_previous[length(sar12_previous)-1]
let sar12_stimulus[2] = 4.0001e-05
let sar12_stimulus[3] = sar12_stimulus[1]
let sar12_stimulus[4] = 4.0003e-05
let sar12_stimulus[5] = sar12_drive
let sar12_stimulus[6] = 0.000148
let sar12_stimulus[7] = sar12_stimulus[5]
alter @VD_B12[pwl] = sar12_stimulus
let sar12_drive = (floor(sar12_trial / 8192) - 2*floor(sar12_trial / 16384))*1.8
let sar12_previous = @VD_B13[pwl]
let sar12_stimulus = vector(8)
let sar12_stimulus[0] = 0
let sar12_stimulus[1] = sar12_previous[length(sar12_previous)-1]
let sar12_stimulus[2] = 4.0001e-05
let sar12_stimulus[3] = sar12_stimulus[1]
let sar12_stimulus[4] = 4.0003e-05
let sar12_stimulus[5] = sar12_drive
let sar12_stimulus[6] = 0.000148
let sar12_stimulus[7] = sar12_stimulus[5]
alter @VD_B13[pwl] = sar12_stimulus
let sar12_drive = (floor(sar12_trial / 16384) - 2*floor(sar12_trial / 32768))*1.8
let sar12_previous = @VD_B14[pwl]
let sar12_stimulus = vector(8)
let sar12_stimulus[0] = 0
let sar12_stimulus[1] = sar12_previous[length(sar12_previous)-1]
let sar12_stimulus[2] = 4.0001e-05
let sar12_stimulus[3] = sar12_stimulus[1]
let sar12_stimulus[4] = 4.0003e-05
let sar12_stimulus[5] = sar12_drive
let sar12_stimulus[6] = 0.000148
let sar12_stimulus[7] = sar12_stimulus[5]
alter @VD_B14[pwl] = sar12_stimulus
let sar12_drive = (floor(sar12_trial / 32768) - 2*floor(sar12_trial / 65536))*1.8
let sar12_previous = @VD_B15[pwl]
let sar12_stimulus = vector(8)
let sar12_stimulus[0] = 0
let sar12_stimulus[1] = sar12_previous[length(sar12_previous)-1]
let sar12_stimulus[2] = 4.0001e-05
let sar12_stimulus[3] = sar12_stimulus[1]
let sar12_stimulus[4] = 4.0003e-05
let sar12_stimulus[5] = sar12_drive
let sar12_stimulus[6] = 0.000148
let sar12_stimulus[7] = sar12_stimulus[5]
alter @VD_B15[pwl] = sar12_stimulus
resume
let sar12_k = length(time)-1
if abs(time[sar12_k] - 4.05e-05) > 1e-12
print time[sar12_k]
echo expected_pause_time_s 4.05e-05
echo SAR12_PAUSE_FAILED
quit 1
end
print time[sar12_k] >> pause-times.txt
let sar12_previous = @VD_EVAL[pwl]
let sar12_stimulus = vector(8)
let sar12_stimulus[0] = 0
let sar12_stimulus[1] = sar12_previous[length(sar12_previous)-1]
let sar12_stimulus[2] = 4.0501e-05
let sar12_stimulus[3] = sar12_stimulus[1]
let sar12_stimulus[4] = 4.0503e-05
let sar12_stimulus[5] = 1.8
let sar12_stimulus[6] = 0.000148
let sar12_stimulus[7] = sar12_stimulus[5]
alter @VD_EVAL[pwl] = sar12_stimulus
resume
let sar12_k = length(time)-1
if abs(time[sar12_k] - 4.1e-05) > 1e-12
print time[sar12_k]
echo expected_pause_time_s 4.1e-05
echo SAR12_PAUSE_FAILED
quit 1
end
print time[sar12_k] >> pause-times.txt
let sar12_k = length(time)-1
let sar12_cmp = v(COMP)[sar12_k]
let sar12_cmpn = v(COMPN)[sar12_k]
let sar12_p = v(TOPP)[sar12_k]
let sar12_n = v(TOPN)[sar12_k]
let sar12_decision = 0
if sar12_cmp >= 0.9
let sar12_code = sar12_trial
let sar12_decision = 1
end
echo 1 8 $&sar12_trial $&sar12_cmp $&sar12_cmpn $&sar12_p $&sar12_n -1.19998168945312 $&sar12_decision >> decisions.csv
let sar12_previous = @VD_EVAL[pwl]
let sar12_stimulus = vector(8)
let sar12_stimulus[0] = 0
let sar12_stimulus[1] = sar12_previous[length(sar12_previous)-1]
let sar12_stimulus[2] = 4.1001e-05
let sar12_stimulus[3] = sar12_stimulus[1]
let sar12_stimulus[4] = 4.1003e-05
let sar12_stimulus[5] = 0
let sar12_stimulus[6] = 0.000148
let sar12_stimulus[7] = sar12_stimulus[5]
alter @VD_EVAL[pwl] = sar12_stimulus
let sar12_trial = sar12_code + 128
let sar12_drive = (floor(sar12_trial / 1) - 2*floor(sar12_trial / 2))*1.8
let sar12_previous = @VD_B0[pwl]
let sar12_stimulus = vector(8)
let sar12_stimulus[0] = 0
let sar12_stimulus[1] = sar12_previous[length(sar12_previous)-1]
let sar12_stimulus[2] = 4.1001e-05
let sar12_stimulus[3] = sar12_stimulus[1]
let sar12_stimulus[4] = 4.1003e-05
let sar12_stimulus[5] = sar12_drive
let sar12_stimulus[6] = 0.000148
let sar12_stimulus[7] = sar12_stimulus[5]
alter @VD_B0[pwl] = sar12_stimulus
let sar12_drive = (floor(sar12_trial / 2) - 2*floor(sar12_trial / 4))*1.8
let sar12_previous = @VD_B1[pwl]
let sar12_stimulus = vector(8)
let sar12_stimulus[0] = 0
let sar12_stimulus[1] = sar12_previous[length(sar12_previous)-1]
let sar12_stimulus[2] = 4.1001e-05
let sar12_stimulus[3] = sar12_stimulus[1]
let sar12_stimulus[4] = 4.1003e-05
let sar12_stimulus[5] = sar12_drive
let sar12_stimulus[6] = 0.000148
let sar12_stimulus[7] = sar12_stimulus[5]
alter @VD_B1[pwl] = sar12_stimulus
let sar12_drive = (floor(sar12_trial / 4) - 2*floor(sar12_trial / 8))*1.8
let sar12_previous = @VD_B2[pwl]
let sar12_stimulus = vector(8)
let sar12_stimulus[0] = 0
let sar12_stimulus[1] = sar12_previous[length(sar12_previous)-1]
let sar12_stimulus[2] = 4.1001e-05
let sar12_stimulus[3] = sar12_stimulus[1]
let sar12_stimulus[4] = 4.1003e-05
let sar12_stimulus[5] = sar12_drive
let sar12_stimulus[6] = 0.000148
let sar12_stimulus[7] = sar12_stimulus[5]
alter @VD_B2[pwl] = sar12_stimulus
let sar12_drive = (floor(sar12_trial / 8) - 2*floor(sar12_trial / 16))*1.8
let sar12_previous = @VD_B3[pwl]
let sar12_stimulus = vector(8)
let sar12_stimulus[0] = 0
let sar12_stimulus[1] = sar12_previous[length(sar12_previous)-1]
let sar12_stimulus[2] = 4.1001e-05
let sar12_stimulus[3] = sar12_stimulus[1]
let sar12_stimulus[4] = 4.1003e-05
let sar12_stimulus[5] = sar12_drive
let sar12_stimulus[6] = 0.000148
let sar12_stimulus[7] = sar12_stimulus[5]
alter @VD_B3[pwl] = sar12_stimulus
let sar12_drive = (floor(sar12_trial / 16) - 2*floor(sar12_trial / 32))*1.8
let sar12_previous = @VD_B4[pwl]
let sar12_stimulus = vector(8)
let sar12_stimulus[0] = 0
let sar12_stimulus[1] = sar12_previous[length(sar12_previous)-1]
let sar12_stimulus[2] = 4.1001e-05
let sar12_stimulus[3] = sar12_stimulus[1]
let sar12_stimulus[4] = 4.1003e-05
let sar12_stimulus[5] = sar12_drive
let sar12_stimulus[6] = 0.000148
let sar12_stimulus[7] = sar12_stimulus[5]
alter @VD_B4[pwl] = sar12_stimulus
let sar12_drive = (floor(sar12_trial / 32) - 2*floor(sar12_trial / 64))*1.8
let sar12_previous = @VD_B5[pwl]
let sar12_stimulus = vector(8)
let sar12_stimulus[0] = 0
let sar12_stimulus[1] = sar12_previous[length(sar12_previous)-1]
let sar12_stimulus[2] = 4.1001e-05
let sar12_stimulus[3] = sar12_stimulus[1]
let sar12_stimulus[4] = 4.1003e-05
let sar12_stimulus[5] = sar12_drive
let sar12_stimulus[6] = 0.000148
let sar12_stimulus[7] = sar12_stimulus[5]
alter @VD_B5[pwl] = sar12_stimulus
let sar12_drive = (floor(sar12_trial / 64) - 2*floor(sar12_trial / 128))*1.8
let sar12_previous = @VD_B6[pwl]
let sar12_stimulus = vector(8)
let sar12_stimulus[0] = 0
let sar12_stimulus[1] = sar12_previous[length(sar12_previous)-1]
let sar12_stimulus[2] = 4.1001e-05
let sar12_stimulus[3] = sar12_stimulus[1]
let sar12_stimulus[4] = 4.1003e-05
let sar12_stimulus[5] = sar12_drive
let sar12_stimulus[6] = 0.000148
let sar12_stimulus[7] = sar12_stimulus[5]
alter @VD_B6[pwl] = sar12_stimulus
let sar12_drive = (floor(sar12_trial / 128) - 2*floor(sar12_trial / 256))*1.8
let sar12_previous = @VD_B7[pwl]
let sar12_stimulus = vector(8)
let sar12_stimulus[0] = 0
let sar12_stimulus[1] = sar12_previous[length(sar12_previous)-1]
let sar12_stimulus[2] = 4.1001e-05
let sar12_stimulus[3] = sar12_stimulus[1]
let sar12_stimulus[4] = 4.1003e-05
let sar12_stimulus[5] = sar12_drive
let sar12_stimulus[6] = 0.000148
let sar12_stimulus[7] = sar12_stimulus[5]
alter @VD_B7[pwl] = sar12_stimulus
let sar12_drive = (floor(sar12_trial / 256) - 2*floor(sar12_trial / 512))*1.8
let sar12_previous = @VD_B8[pwl]
let sar12_stimulus = vector(8)
let sar12_stimulus[0] = 0
let sar12_stimulus[1] = sar12_previous[length(sar12_previous)-1]
let sar12_stimulus[2] = 4.1001e-05
let sar12_stimulus[3] = sar12_stimulus[1]
let sar12_stimulus[4] = 4.1003e-05
let sar12_stimulus[5] = sar12_drive
let sar12_stimulus[6] = 0.000148
let sar12_stimulus[7] = sar12_stimulus[5]
alter @VD_B8[pwl] = sar12_stimulus
let sar12_drive = (floor(sar12_trial / 512) - 2*floor(sar12_trial / 1024))*1.8
let sar12_previous = @VD_B9[pwl]
let sar12_stimulus = vector(8)
let sar12_stimulus[0] = 0
let sar12_stimulus[1] = sar12_previous[length(sar12_previous)-1]
let sar12_stimulus[2] = 4.1001e-05
let sar12_stimulus[3] = sar12_stimulus[1]
let sar12_stimulus[4] = 4.1003e-05
let sar12_stimulus[5] = sar12_drive
let sar12_stimulus[6] = 0.000148
let sar12_stimulus[7] = sar12_stimulus[5]
alter @VD_B9[pwl] = sar12_stimulus
let sar12_drive = (floor(sar12_trial / 1024) - 2*floor(sar12_trial / 2048))*1.8
let sar12_previous = @VD_B10[pwl]
let sar12_stimulus = vector(8)
let sar12_stimulus[0] = 0
let sar12_stimulus[1] = sar12_previous[length(sar12_previous)-1]
let sar12_stimulus[2] = 4.1001e-05
let sar12_stimulus[3] = sar12_stimulus[1]
let sar12_stimulus[4] = 4.1003e-05
let sar12_stimulus[5] = sar12_drive
let sar12_stimulus[6] = 0.000148
let sar12_stimulus[7] = sar12_stimulus[5]
alter @VD_B10[pwl] = sar12_stimulus
let sar12_drive = (floor(sar12_trial / 2048) - 2*floor(sar12_trial / 4096))*1.8
let sar12_previous = @VD_B11[pwl]
let sar12_stimulus = vector(8)
let sar12_stimulus[0] = 0
let sar12_stimulus[1] = sar12_previous[length(sar12_previous)-1]
let sar12_stimulus[2] = 4.1001e-05
let sar12_stimulus[3] = sar12_stimulus[1]
let sar12_stimulus[4] = 4.1003e-05
let sar12_stimulus[5] = sar12_drive
let sar12_stimulus[6] = 0.000148
let sar12_stimulus[7] = sar12_stimulus[5]
alter @VD_B11[pwl] = sar12_stimulus
let sar12_drive = (floor(sar12_trial / 4096) - 2*floor(sar12_trial / 8192))*1.8
let sar12_previous = @VD_B12[pwl]
let sar12_stimulus = vector(8)
let sar12_stimulus[0] = 0
let sar12_stimulus[1] = sar12_previous[length(sar12_previous)-1]
let sar12_stimulus[2] = 4.1001e-05
let sar12_stimulus[3] = sar12_stimulus[1]
let sar12_stimulus[4] = 4.1003e-05
let sar12_stimulus[5] = sar12_drive
let sar12_stimulus[6] = 0.000148
let sar12_stimulus[7] = sar12_stimulus[5]
alter @VD_B12[pwl] = sar12_stimulus
let sar12_drive = (floor(sar12_trial / 8192) - 2*floor(sar12_trial / 16384))*1.8
let sar12_previous = @VD_B13[pwl]
let sar12_stimulus = vector(8)
let sar12_stimulus[0] = 0
let sar12_stimulus[1] = sar12_previous[length(sar12_previous)-1]
let sar12_stimulus[2] = 4.1001e-05
let sar12_stimulus[3] = sar12_stimulus[1]
let sar12_stimulus[4] = 4.1003e-05
let sar12_stimulus[5] = sar12_drive
let sar12_stimulus[6] = 0.000148
let sar12_stimulus[7] = sar12_stimulus[5]
alter @VD_B13[pwl] = sar12_stimulus
let sar12_drive = (floor(sar12_trial / 16384) - 2*floor(sar12_trial / 32768))*1.8
let sar12_previous = @VD_B14[pwl]
let sar12_stimulus = vector(8)
let sar12_stimulus[0] = 0
let sar12_stimulus[1] = sar12_previous[length(sar12_previous)-1]
let sar12_stimulus[2] = 4.1001e-05
let sar12_stimulus[3] = sar12_stimulus[1]
let sar12_stimulus[4] = 4.1003e-05
let sar12_stimulus[5] = sar12_drive
let sar12_stimulus[6] = 0.000148
let sar12_stimulus[7] = sar12_stimulus[5]
alter @VD_B14[pwl] = sar12_stimulus
let sar12_drive = (floor(sar12_trial / 32768) - 2*floor(sar12_trial / 65536))*1.8
let sar12_previous = @VD_B15[pwl]
let sar12_stimulus = vector(8)
let sar12_stimulus[0] = 0
let sar12_stimulus[1] = sar12_previous[length(sar12_previous)-1]
let sar12_stimulus[2] = 4.1001e-05
let sar12_stimulus[3] = sar12_stimulus[1]
let sar12_stimulus[4] = 4.1003e-05
let sar12_stimulus[5] = sar12_drive
let sar12_stimulus[6] = 0.000148
let sar12_stimulus[7] = sar12_stimulus[5]
alter @VD_B15[pwl] = sar12_stimulus
resume
let sar12_k = length(time)-1
if abs(time[sar12_k] - 4.15e-05) > 1e-12
print time[sar12_k]
echo expected_pause_time_s 4.15e-05
echo SAR12_PAUSE_FAILED
quit 1
end
print time[sar12_k] >> pause-times.txt
let sar12_previous = @VD_EVAL[pwl]
let sar12_stimulus = vector(8)
let sar12_stimulus[0] = 0
let sar12_stimulus[1] = sar12_previous[length(sar12_previous)-1]
let sar12_stimulus[2] = 4.1501e-05
let sar12_stimulus[3] = sar12_stimulus[1]
let sar12_stimulus[4] = 4.1503e-05
let sar12_stimulus[5] = 1.8
let sar12_stimulus[6] = 0.000148
let sar12_stimulus[7] = sar12_stimulus[5]
alter @VD_EVAL[pwl] = sar12_stimulus
resume
let sar12_k = length(time)-1
if abs(time[sar12_k] - 4.2e-05) > 1e-12
print time[sar12_k]
echo expected_pause_time_s 4.2e-05
echo SAR12_PAUSE_FAILED
quit 1
end
print time[sar12_k] >> pause-times.txt
let sar12_k = length(time)-1
let sar12_cmp = v(COMP)[sar12_k]
let sar12_cmpn = v(COMPN)[sar12_k]
let sar12_p = v(TOPP)[sar12_k]
let sar12_n = v(TOPN)[sar12_k]
let sar12_decision = 0
if sar12_cmp >= 0.9
let sar12_code = sar12_trial
let sar12_decision = 1
end
echo 1 7 $&sar12_trial $&sar12_cmp $&sar12_cmpn $&sar12_p $&sar12_n -1.19998168945312 $&sar12_decision >> decisions.csv
let sar12_previous = @VD_EVAL[pwl]
let sar12_stimulus = vector(8)
let sar12_stimulus[0] = 0
let sar12_stimulus[1] = sar12_previous[length(sar12_previous)-1]
let sar12_stimulus[2] = 4.2001e-05
let sar12_stimulus[3] = sar12_stimulus[1]
let sar12_stimulus[4] = 4.2003e-05
let sar12_stimulus[5] = 0
let sar12_stimulus[6] = 0.000148
let sar12_stimulus[7] = sar12_stimulus[5]
alter @VD_EVAL[pwl] = sar12_stimulus
let sar12_trial = sar12_code + 64
let sar12_drive = (floor(sar12_trial / 1) - 2*floor(sar12_trial / 2))*1.8
let sar12_previous = @VD_B0[pwl]
let sar12_stimulus = vector(8)
let sar12_stimulus[0] = 0
let sar12_stimulus[1] = sar12_previous[length(sar12_previous)-1]
let sar12_stimulus[2] = 4.2001e-05
let sar12_stimulus[3] = sar12_stimulus[1]
let sar12_stimulus[4] = 4.2003e-05
let sar12_stimulus[5] = sar12_drive
let sar12_stimulus[6] = 0.000148
let sar12_stimulus[7] = sar12_stimulus[5]
alter @VD_B0[pwl] = sar12_stimulus
let sar12_drive = (floor(sar12_trial / 2) - 2*floor(sar12_trial / 4))*1.8
let sar12_previous = @VD_B1[pwl]
let sar12_stimulus = vector(8)
let sar12_stimulus[0] = 0
let sar12_stimulus[1] = sar12_previous[length(sar12_previous)-1]
let sar12_stimulus[2] = 4.2001e-05
let sar12_stimulus[3] = sar12_stimulus[1]
let sar12_stimulus[4] = 4.2003e-05
let sar12_stimulus[5] = sar12_drive
let sar12_stimulus[6] = 0.000148
let sar12_stimulus[7] = sar12_stimulus[5]
alter @VD_B1[pwl] = sar12_stimulus
let sar12_drive = (floor(sar12_trial / 4) - 2*floor(sar12_trial / 8))*1.8
let sar12_previous = @VD_B2[pwl]
let sar12_stimulus = vector(8)
let sar12_stimulus[0] = 0
let sar12_stimulus[1] = sar12_previous[length(sar12_previous)-1]
let sar12_stimulus[2] = 4.2001e-05
let sar12_stimulus[3] = sar12_stimulus[1]
let sar12_stimulus[4] = 4.2003e-05
let sar12_stimulus[5] = sar12_drive
let sar12_stimulus[6] = 0.000148
let sar12_stimulus[7] = sar12_stimulus[5]
alter @VD_B2[pwl] = sar12_stimulus
let sar12_drive = (floor(sar12_trial / 8) - 2*floor(sar12_trial / 16))*1.8
let sar12_previous = @VD_B3[pwl]
let sar12_stimulus = vector(8)
let sar12_stimulus[0] = 0
let sar12_stimulus[1] = sar12_previous[length(sar12_previous)-1]
let sar12_stimulus[2] = 4.2001e-05
let sar12_stimulus[3] = sar12_stimulus[1]
let sar12_stimulus[4] = 4.2003e-05
let sar12_stimulus[5] = sar12_drive
let sar12_stimulus[6] = 0.000148
let sar12_stimulus[7] = sar12_stimulus[5]
alter @VD_B3[pwl] = sar12_stimulus
let sar12_drive = (floor(sar12_trial / 16) - 2*floor(sar12_trial / 32))*1.8
let sar12_previous = @VD_B4[pwl]
let sar12_stimulus = vector(8)
let sar12_stimulus[0] = 0
let sar12_stimulus[1] = sar12_previous[length(sar12_previous)-1]
let sar12_stimulus[2] = 4.2001e-05
let sar12_stimulus[3] = sar12_stimulus[1]
let sar12_stimulus[4] = 4.2003e-05
let sar12_stimulus[5] = sar12_drive
let sar12_stimulus[6] = 0.000148
let sar12_stimulus[7] = sar12_stimulus[5]
alter @VD_B4[pwl] = sar12_stimulus
let sar12_drive = (floor(sar12_trial / 32) - 2*floor(sar12_trial / 64))*1.8
let sar12_previous = @VD_B5[pwl]
let sar12_stimulus = vector(8)
let sar12_stimulus[0] = 0
let sar12_stimulus[1] = sar12_previous[length(sar12_previous)-1]
let sar12_stimulus[2] = 4.2001e-05
let sar12_stimulus[3] = sar12_stimulus[1]
let sar12_stimulus[4] = 4.2003e-05
let sar12_stimulus[5] = sar12_drive
let sar12_stimulus[6] = 0.000148
let sar12_stimulus[7] = sar12_stimulus[5]
alter @VD_B5[pwl] = sar12_stimulus
let sar12_drive = (floor(sar12_trial / 64) - 2*floor(sar12_trial / 128))*1.8
let sar12_previous = @VD_B6[pwl]
let sar12_stimulus = vector(8)
let sar12_stimulus[0] = 0
let sar12_stimulus[1] = sar12_previous[length(sar12_previous)-1]
let sar12_stimulus[2] = 4.2001e-05
let sar12_stimulus[3] = sar12_stimulus[1]
let sar12_stimulus[4] = 4.2003e-05
let sar12_stimulus[5] = sar12_drive
let sar12_stimulus[6] = 0.000148
let sar12_stimulus[7] = sar12_stimulus[5]
alter @VD_B6[pwl] = sar12_stimulus
let sar12_drive = (floor(sar12_trial / 128) - 2*floor(sar12_trial / 256))*1.8
let sar12_previous = @VD_B7[pwl]
let sar12_stimulus = vector(8)
let sar12_stimulus[0] = 0
let sar12_stimulus[1] = sar12_previous[length(sar12_previous)-1]
let sar12_stimulus[2] = 4.2001e-05
let sar12_stimulus[3] = sar12_stimulus[1]
let sar12_stimulus[4] = 4.2003e-05
let sar12_stimulus[5] = sar12_drive
let sar12_stimulus[6] = 0.000148
let sar12_stimulus[7] = sar12_stimulus[5]
alter @VD_B7[pwl] = sar12_stimulus
let sar12_drive = (floor(sar12_trial / 256) - 2*floor(sar12_trial / 512))*1.8
let sar12_previous = @VD_B8[pwl]
let sar12_stimulus = vector(8)
let sar12_stimulus[0] = 0
let sar12_stimulus[1] = sar12_previous[length(sar12_previous)-1]
let sar12_stimulus[2] = 4.2001e-05
let sar12_stimulus[3] = sar12_stimulus[1]
let sar12_stimulus[4] = 4.2003e-05
let sar12_stimulus[5] = sar12_drive
let sar12_stimulus[6] = 0.000148
let sar12_stimulus[7] = sar12_stimulus[5]
alter @VD_B8[pwl] = sar12_stimulus
let sar12_drive = (floor(sar12_trial / 512) - 2*floor(sar12_trial / 1024))*1.8
let sar12_previous = @VD_B9[pwl]
let sar12_stimulus = vector(8)
let sar12_stimulus[0] = 0
let sar12_stimulus[1] = sar12_previous[length(sar12_previous)-1]
let sar12_stimulus[2] = 4.2001e-05
let sar12_stimulus[3] = sar12_stimulus[1]
let sar12_stimulus[4] = 4.2003e-05
let sar12_stimulus[5] = sar12_drive
let sar12_stimulus[6] = 0.000148
let sar12_stimulus[7] = sar12_stimulus[5]
alter @VD_B9[pwl] = sar12_stimulus
let sar12_drive = (floor(sar12_trial / 1024) - 2*floor(sar12_trial / 2048))*1.8
let sar12_previous = @VD_B10[pwl]
let sar12_stimulus = vector(8)
let sar12_stimulus[0] = 0
let sar12_stimulus[1] = sar12_previous[length(sar12_previous)-1]
let sar12_stimulus[2] = 4.2001e-05
let sar12_stimulus[3] = sar12_stimulus[1]
let sar12_stimulus[4] = 4.2003e-05
let sar12_stimulus[5] = sar12_drive
let sar12_stimulus[6] = 0.000148
let sar12_stimulus[7] = sar12_stimulus[5]
alter @VD_B10[pwl] = sar12_stimulus
let sar12_drive = (floor(sar12_trial / 2048) - 2*floor(sar12_trial / 4096))*1.8
let sar12_previous = @VD_B11[pwl]
let sar12_stimulus = vector(8)
let sar12_stimulus[0] = 0
let sar12_stimulus[1] = sar12_previous[length(sar12_previous)-1]
let sar12_stimulus[2] = 4.2001e-05
let sar12_stimulus[3] = sar12_stimulus[1]
let sar12_stimulus[4] = 4.2003e-05
let sar12_stimulus[5] = sar12_drive
let sar12_stimulus[6] = 0.000148
let sar12_stimulus[7] = sar12_stimulus[5]
alter @VD_B11[pwl] = sar12_stimulus
let sar12_drive = (floor(sar12_trial / 4096) - 2*floor(sar12_trial / 8192))*1.8
let sar12_previous = @VD_B12[pwl]
let sar12_stimulus = vector(8)
let sar12_stimulus[0] = 0
let sar12_stimulus[1] = sar12_previous[length(sar12_previous)-1]
let sar12_stimulus[2] = 4.2001e-05
let sar12_stimulus[3] = sar12_stimulus[1]
let sar12_stimulus[4] = 4.2003e-05
let sar12_stimulus[5] = sar12_drive
let sar12_stimulus[6] = 0.000148
let sar12_stimulus[7] = sar12_stimulus[5]
alter @VD_B12[pwl] = sar12_stimulus
let sar12_drive = (floor(sar12_trial / 8192) - 2*floor(sar12_trial / 16384))*1.8
let sar12_previous = @VD_B13[pwl]
let sar12_stimulus = vector(8)
let sar12_stimulus[0] = 0
let sar12_stimulus[1] = sar12_previous[length(sar12_previous)-1]
let sar12_stimulus[2] = 4.2001e-05
let sar12_stimulus[3] = sar12_stimulus[1]
let sar12_stimulus[4] = 4.2003e-05
let sar12_stimulus[5] = sar12_drive
let sar12_stimulus[6] = 0.000148
let sar12_stimulus[7] = sar12_stimulus[5]
alter @VD_B13[pwl] = sar12_stimulus
let sar12_drive = (floor(sar12_trial / 16384) - 2*floor(sar12_trial / 32768))*1.8
let sar12_previous = @VD_B14[pwl]
let sar12_stimulus = vector(8)
let sar12_stimulus[0] = 0
let sar12_stimulus[1] = sar12_previous[length(sar12_previous)-1]
let sar12_stimulus[2] = 4.2001e-05
let sar12_stimulus[3] = sar12_stimulus[1]
let sar12_stimulus[4] = 4.2003e-05
let sar12_stimulus[5] = sar12_drive
let sar12_stimulus[6] = 0.000148
let sar12_stimulus[7] = sar12_stimulus[5]
alter @VD_B14[pwl] = sar12_stimulus
let sar12_drive = (floor(sar12_trial / 32768) - 2*floor(sar12_trial / 65536))*1.8
let sar12_previous = @VD_B15[pwl]
let sar12_stimulus = vector(8)
let sar12_stimulus[0] = 0
let sar12_stimulus[1] = sar12_previous[length(sar12_previous)-1]
let sar12_stimulus[2] = 4.2001e-05
let sar12_stimulus[3] = sar12_stimulus[1]
let sar12_stimulus[4] = 4.2003e-05
let sar12_stimulus[5] = sar12_drive
let sar12_stimulus[6] = 0.000148
let sar12_stimulus[7] = sar12_stimulus[5]
alter @VD_B15[pwl] = sar12_stimulus
resume
let sar12_k = length(time)-1
if abs(time[sar12_k] - 4.24999999999999e-05) > 1e-12
print time[sar12_k]
echo expected_pause_time_s 4.24999999999999e-05
echo SAR12_PAUSE_FAILED
quit 1
end
print time[sar12_k] >> pause-times.txt
let sar12_previous = @VD_EVAL[pwl]
let sar12_stimulus = vector(8)
let sar12_stimulus[0] = 0
let sar12_stimulus[1] = sar12_previous[length(sar12_previous)-1]
let sar12_stimulus[2] = 4.2501e-05
let sar12_stimulus[3] = sar12_stimulus[1]
let sar12_stimulus[4] = 4.25029999999999e-05
let sar12_stimulus[5] = 1.8
let sar12_stimulus[6] = 0.000148
let sar12_stimulus[7] = sar12_stimulus[5]
alter @VD_EVAL[pwl] = sar12_stimulus
resume
let sar12_k = length(time)-1
if abs(time[sar12_k] - 4.29999999999999e-05) > 1e-12
print time[sar12_k]
echo expected_pause_time_s 4.29999999999999e-05
echo SAR12_PAUSE_FAILED
quit 1
end
print time[sar12_k] >> pause-times.txt
let sar12_k = length(time)-1
let sar12_cmp = v(COMP)[sar12_k]
let sar12_cmpn = v(COMPN)[sar12_k]
let sar12_p = v(TOPP)[sar12_k]
let sar12_n = v(TOPN)[sar12_k]
let sar12_decision = 0
if sar12_cmp >= 0.9
let sar12_code = sar12_trial
let sar12_decision = 1
end
echo 1 6 $&sar12_trial $&sar12_cmp $&sar12_cmpn $&sar12_p $&sar12_n -1.19998168945312 $&sar12_decision >> decisions.csv
let sar12_previous = @VD_EVAL[pwl]
let sar12_stimulus = vector(8)
let sar12_stimulus[0] = 0
let sar12_stimulus[1] = sar12_previous[length(sar12_previous)-1]
let sar12_stimulus[2] = 4.30009999999999e-05
let sar12_stimulus[3] = sar12_stimulus[1]
let sar12_stimulus[4] = 4.30029999999999e-05
let sar12_stimulus[5] = 0
let sar12_stimulus[6] = 0.000148
let sar12_stimulus[7] = sar12_stimulus[5]
alter @VD_EVAL[pwl] = sar12_stimulus
let sar12_trial = sar12_code + 32
let sar12_drive = (floor(sar12_trial / 1) - 2*floor(sar12_trial / 2))*1.8
let sar12_previous = @VD_B0[pwl]
let sar12_stimulus = vector(8)
let sar12_stimulus[0] = 0
let sar12_stimulus[1] = sar12_previous[length(sar12_previous)-1]
let sar12_stimulus[2] = 4.30009999999999e-05
let sar12_stimulus[3] = sar12_stimulus[1]
let sar12_stimulus[4] = 4.30029999999999e-05
let sar12_stimulus[5] = sar12_drive
let sar12_stimulus[6] = 0.000148
let sar12_stimulus[7] = sar12_stimulus[5]
alter @VD_B0[pwl] = sar12_stimulus
let sar12_drive = (floor(sar12_trial / 2) - 2*floor(sar12_trial / 4))*1.8
let sar12_previous = @VD_B1[pwl]
let sar12_stimulus = vector(8)
let sar12_stimulus[0] = 0
let sar12_stimulus[1] = sar12_previous[length(sar12_previous)-1]
let sar12_stimulus[2] = 4.30009999999999e-05
let sar12_stimulus[3] = sar12_stimulus[1]
let sar12_stimulus[4] = 4.30029999999999e-05
let sar12_stimulus[5] = sar12_drive
let sar12_stimulus[6] = 0.000148
let sar12_stimulus[7] = sar12_stimulus[5]
alter @VD_B1[pwl] = sar12_stimulus
let sar12_drive = (floor(sar12_trial / 4) - 2*floor(sar12_trial / 8))*1.8
let sar12_previous = @VD_B2[pwl]
let sar12_stimulus = vector(8)
let sar12_stimulus[0] = 0
let sar12_stimulus[1] = sar12_previous[length(sar12_previous)-1]
let sar12_stimulus[2] = 4.30009999999999e-05
let sar12_stimulus[3] = sar12_stimulus[1]
let sar12_stimulus[4] = 4.30029999999999e-05
let sar12_stimulus[5] = sar12_drive
let sar12_stimulus[6] = 0.000148
let sar12_stimulus[7] = sar12_stimulus[5]
alter @VD_B2[pwl] = sar12_stimulus
let sar12_drive = (floor(sar12_trial / 8) - 2*floor(sar12_trial / 16))*1.8
let sar12_previous = @VD_B3[pwl]
let sar12_stimulus = vector(8)
let sar12_stimulus[0] = 0
let sar12_stimulus[1] = sar12_previous[length(sar12_previous)-1]
let sar12_stimulus[2] = 4.30009999999999e-05
let sar12_stimulus[3] = sar12_stimulus[1]
let sar12_stimulus[4] = 4.30029999999999e-05
let sar12_stimulus[5] = sar12_drive
let sar12_stimulus[6] = 0.000148
let sar12_stimulus[7] = sar12_stimulus[5]
alter @VD_B3[pwl] = sar12_stimulus
let sar12_drive = (floor(sar12_trial / 16) - 2*floor(sar12_trial / 32))*1.8
let sar12_previous = @VD_B4[pwl]
let sar12_stimulus = vector(8)
let sar12_stimulus[0] = 0
let sar12_stimulus[1] = sar12_previous[length(sar12_previous)-1]
let sar12_stimulus[2] = 4.30009999999999e-05
let sar12_stimulus[3] = sar12_stimulus[1]
let sar12_stimulus[4] = 4.30029999999999e-05
let sar12_stimulus[5] = sar12_drive
let sar12_stimulus[6] = 0.000148
let sar12_stimulus[7] = sar12_stimulus[5]
alter @VD_B4[pwl] = sar12_stimulus
let sar12_drive = (floor(sar12_trial / 32) - 2*floor(sar12_trial / 64))*1.8
let sar12_previous = @VD_B5[pwl]
let sar12_stimulus = vector(8)
let sar12_stimulus[0] = 0
let sar12_stimulus[1] = sar12_previous[length(sar12_previous)-1]
let sar12_stimulus[2] = 4.30009999999999e-05
let sar12_stimulus[3] = sar12_stimulus[1]
let sar12_stimulus[4] = 4.30029999999999e-05
let sar12_stimulus[5] = sar12_drive
let sar12_stimulus[6] = 0.000148
let sar12_stimulus[7] = sar12_stimulus[5]
alter @VD_B5[pwl] = sar12_stimulus
let sar12_drive = (floor(sar12_trial / 64) - 2*floor(sar12_trial / 128))*1.8
let sar12_previous = @VD_B6[pwl]
let sar12_stimulus = vector(8)
let sar12_stimulus[0] = 0
let sar12_stimulus[1] = sar12_previous[length(sar12_previous)-1]
let sar12_stimulus[2] = 4.30009999999999e-05
let sar12_stimulus[3] = sar12_stimulus[1]
let sar12_stimulus[4] = 4.30029999999999e-05
let sar12_stimulus[5] = sar12_drive
let sar12_stimulus[6] = 0.000148
let sar12_stimulus[7] = sar12_stimulus[5]
alter @VD_B6[pwl] = sar12_stimulus
let sar12_drive = (floor(sar12_trial / 128) - 2*floor(sar12_trial / 256))*1.8
let sar12_previous = @VD_B7[pwl]
let sar12_stimulus = vector(8)
let sar12_stimulus[0] = 0
let sar12_stimulus[1] = sar12_previous[length(sar12_previous)-1]
let sar12_stimulus[2] = 4.30009999999999e-05
let sar12_stimulus[3] = sar12_stimulus[1]
let sar12_stimulus[4] = 4.30029999999999e-05
let sar12_stimulus[5] = sar12_drive
let sar12_stimulus[6] = 0.000148
let sar12_stimulus[7] = sar12_stimulus[5]
alter @VD_B7[pwl] = sar12_stimulus
let sar12_drive = (floor(sar12_trial / 256) - 2*floor(sar12_trial / 512))*1.8
let sar12_previous = @VD_B8[pwl]
let sar12_stimulus = vector(8)
let sar12_stimulus[0] = 0
let sar12_stimulus[1] = sar12_previous[length(sar12_previous)-1]
let sar12_stimulus[2] = 4.30009999999999e-05
let sar12_stimulus[3] = sar12_stimulus[1]
let sar12_stimulus[4] = 4.30029999999999e-05
let sar12_stimulus[5] = sar12_drive
let sar12_stimulus[6] = 0.000148
let sar12_stimulus[7] = sar12_stimulus[5]
alter @VD_B8[pwl] = sar12_stimulus
let sar12_drive = (floor(sar12_trial / 512) - 2*floor(sar12_trial / 1024))*1.8
let sar12_previous = @VD_B9[pwl]
let sar12_stimulus = vector(8)
let sar12_stimulus[0] = 0
let sar12_stimulus[1] = sar12_previous[length(sar12_previous)-1]
let sar12_stimulus[2] = 4.30009999999999e-05
let sar12_stimulus[3] = sar12_stimulus[1]
let sar12_stimulus[4] = 4.30029999999999e-05
let sar12_stimulus[5] = sar12_drive
let sar12_stimulus[6] = 0.000148
let sar12_stimulus[7] = sar12_stimulus[5]
alter @VD_B9[pwl] = sar12_stimulus
let sar12_drive = (floor(sar12_trial / 1024) - 2*floor(sar12_trial / 2048))*1.8
let sar12_previous = @VD_B10[pwl]
let sar12_stimulus = vector(8)
let sar12_stimulus[0] = 0
let sar12_stimulus[1] = sar12_previous[length(sar12_previous)-1]
let sar12_stimulus[2] = 4.30009999999999e-05
let sar12_stimulus[3] = sar12_stimulus[1]
let sar12_stimulus[4] = 4.30029999999999e-05
let sar12_stimulus[5] = sar12_drive
let sar12_stimulus[6] = 0.000148
let sar12_stimulus[7] = sar12_stimulus[5]
alter @VD_B10[pwl] = sar12_stimulus
let sar12_drive = (floor(sar12_trial / 2048) - 2*floor(sar12_trial / 4096))*1.8
let sar12_previous = @VD_B11[pwl]
let sar12_stimulus = vector(8)
let sar12_stimulus[0] = 0
let sar12_stimulus[1] = sar12_previous[length(sar12_previous)-1]
let sar12_stimulus[2] = 4.30009999999999e-05
let sar12_stimulus[3] = sar12_stimulus[1]
let sar12_stimulus[4] = 4.30029999999999e-05
let sar12_stimulus[5] = sar12_drive
let sar12_stimulus[6] = 0.000148
let sar12_stimulus[7] = sar12_stimulus[5]
alter @VD_B11[pwl] = sar12_stimulus
let sar12_drive = (floor(sar12_trial / 4096) - 2*floor(sar12_trial / 8192))*1.8
let sar12_previous = @VD_B12[pwl]
let sar12_stimulus = vector(8)
let sar12_stimulus[0] = 0
let sar12_stimulus[1] = sar12_previous[length(sar12_previous)-1]
let sar12_stimulus[2] = 4.30009999999999e-05
let sar12_stimulus[3] = sar12_stimulus[1]
let sar12_stimulus[4] = 4.30029999999999e-05
let sar12_stimulus[5] = sar12_drive
let sar12_stimulus[6] = 0.000148
let sar12_stimulus[7] = sar12_stimulus[5]
alter @VD_B12[pwl] = sar12_stimulus
let sar12_drive = (floor(sar12_trial / 8192) - 2*floor(sar12_trial / 16384))*1.8
let sar12_previous = @VD_B13[pwl]
let sar12_stimulus = vector(8)
let sar12_stimulus[0] = 0
let sar12_stimulus[1] = sar12_previous[length(sar12_previous)-1]
let sar12_stimulus[2] = 4.30009999999999e-05
let sar12_stimulus[3] = sar12_stimulus[1]
let sar12_stimulus[4] = 4.30029999999999e-05
let sar12_stimulus[5] = sar12_drive
let sar12_stimulus[6] = 0.000148
let sar12_stimulus[7] = sar12_stimulus[5]
alter @VD_B13[pwl] = sar12_stimulus
let sar12_drive = (floor(sar12_trial / 16384) - 2*floor(sar12_trial / 32768))*1.8
let sar12_previous = @VD_B14[pwl]
let sar12_stimulus = vector(8)
let sar12_stimulus[0] = 0
let sar12_stimulus[1] = sar12_previous[length(sar12_previous)-1]
let sar12_stimulus[2] = 4.30009999999999e-05
let sar12_stimulus[3] = sar12_stimulus[1]
let sar12_stimulus[4] = 4.30029999999999e-05
let sar12_stimulus[5] = sar12_drive
let sar12_stimulus[6] = 0.000148
let sar12_stimulus[7] = sar12_stimulus[5]
alter @VD_B14[pwl] = sar12_stimulus
let sar12_drive = (floor(sar12_trial / 32768) - 2*floor(sar12_trial / 65536))*1.8
let sar12_previous = @VD_B15[pwl]
let sar12_stimulus = vector(8)
let sar12_stimulus[0] = 0
let sar12_stimulus[1] = sar12_previous[length(sar12_previous)-1]
let sar12_stimulus[2] = 4.30009999999999e-05
let sar12_stimulus[3] = sar12_stimulus[1]
let sar12_stimulus[4] = 4.30029999999999e-05
let sar12_stimulus[5] = sar12_drive
let sar12_stimulus[6] = 0.000148
let sar12_stimulus[7] = sar12_stimulus[5]
alter @VD_B15[pwl] = sar12_stimulus
resume
let sar12_k = length(time)-1
if abs(time[sar12_k] - 4.34999999999999e-05) > 1e-12
print time[sar12_k]
echo expected_pause_time_s 4.34999999999999e-05
echo SAR12_PAUSE_FAILED
quit 1
end
print time[sar12_k] >> pause-times.txt
let sar12_previous = @VD_EVAL[pwl]
let sar12_stimulus = vector(8)
let sar12_stimulus[0] = 0
let sar12_stimulus[1] = sar12_previous[length(sar12_previous)-1]
let sar12_stimulus[2] = 4.35009999999999e-05
let sar12_stimulus[3] = sar12_stimulus[1]
let sar12_stimulus[4] = 4.35029999999999e-05
let sar12_stimulus[5] = 1.8
let sar12_stimulus[6] = 0.000148
let sar12_stimulus[7] = sar12_stimulus[5]
alter @VD_EVAL[pwl] = sar12_stimulus
resume
let sar12_k = length(time)-1
if abs(time[sar12_k] - 4.39999999999999e-05) > 1e-12
print time[sar12_k]
echo expected_pause_time_s 4.39999999999999e-05
echo SAR12_PAUSE_FAILED
quit 1
end
print time[sar12_k] >> pause-times.txt
let sar12_k = length(time)-1
let sar12_cmp = v(COMP)[sar12_k]
let sar12_cmpn = v(COMPN)[sar12_k]
let sar12_p = v(TOPP)[sar12_k]
let sar12_n = v(TOPN)[sar12_k]
let sar12_decision = 0
if sar12_cmp >= 0.9
let sar12_code = sar12_trial
let sar12_decision = 1
end
echo 1 5 $&sar12_trial $&sar12_cmp $&sar12_cmpn $&sar12_p $&sar12_n -1.19998168945312 $&sar12_decision >> decisions.csv
let sar12_previous = @VD_EVAL[pwl]
let sar12_stimulus = vector(8)
let sar12_stimulus[0] = 0
let sar12_stimulus[1] = sar12_previous[length(sar12_previous)-1]
let sar12_stimulus[2] = 4.40009999999999e-05
let sar12_stimulus[3] = sar12_stimulus[1]
let sar12_stimulus[4] = 4.40029999999999e-05
let sar12_stimulus[5] = 0
let sar12_stimulus[6] = 0.000148
let sar12_stimulus[7] = sar12_stimulus[5]
alter @VD_EVAL[pwl] = sar12_stimulus
let sar12_trial = sar12_code + 16
let sar12_drive = (floor(sar12_trial / 1) - 2*floor(sar12_trial / 2))*1.8
let sar12_previous = @VD_B0[pwl]
let sar12_stimulus = vector(8)
let sar12_stimulus[0] = 0
let sar12_stimulus[1] = sar12_previous[length(sar12_previous)-1]
let sar12_stimulus[2] = 4.40009999999999e-05
let sar12_stimulus[3] = sar12_stimulus[1]
let sar12_stimulus[4] = 4.40029999999999e-05
let sar12_stimulus[5] = sar12_drive
let sar12_stimulus[6] = 0.000148
let sar12_stimulus[7] = sar12_stimulus[5]
alter @VD_B0[pwl] = sar12_stimulus
let sar12_drive = (floor(sar12_trial / 2) - 2*floor(sar12_trial / 4))*1.8
let sar12_previous = @VD_B1[pwl]
let sar12_stimulus = vector(8)
let sar12_stimulus[0] = 0
let sar12_stimulus[1] = sar12_previous[length(sar12_previous)-1]
let sar12_stimulus[2] = 4.40009999999999e-05
let sar12_stimulus[3] = sar12_stimulus[1]
let sar12_stimulus[4] = 4.40029999999999e-05
let sar12_stimulus[5] = sar12_drive
let sar12_stimulus[6] = 0.000148
let sar12_stimulus[7] = sar12_stimulus[5]
alter @VD_B1[pwl] = sar12_stimulus
let sar12_drive = (floor(sar12_trial / 4) - 2*floor(sar12_trial / 8))*1.8
let sar12_previous = @VD_B2[pwl]
let sar12_stimulus = vector(8)
let sar12_stimulus[0] = 0
let sar12_stimulus[1] = sar12_previous[length(sar12_previous)-1]
let sar12_stimulus[2] = 4.40009999999999e-05
let sar12_stimulus[3] = sar12_stimulus[1]
let sar12_stimulus[4] = 4.40029999999999e-05
let sar12_stimulus[5] = sar12_drive
let sar12_stimulus[6] = 0.000148
let sar12_stimulus[7] = sar12_stimulus[5]
alter @VD_B2[pwl] = sar12_stimulus
let sar12_drive = (floor(sar12_trial / 8) - 2*floor(sar12_trial / 16))*1.8
let sar12_previous = @VD_B3[pwl]
let sar12_stimulus = vector(8)
let sar12_stimulus[0] = 0
let sar12_stimulus[1] = sar12_previous[length(sar12_previous)-1]
let sar12_stimulus[2] = 4.40009999999999e-05
let sar12_stimulus[3] = sar12_stimulus[1]
let sar12_stimulus[4] = 4.40029999999999e-05
let sar12_stimulus[5] = sar12_drive
let sar12_stimulus[6] = 0.000148
let sar12_stimulus[7] = sar12_stimulus[5]
alter @VD_B3[pwl] = sar12_stimulus
let sar12_drive = (floor(sar12_trial / 16) - 2*floor(sar12_trial / 32))*1.8
let sar12_previous = @VD_B4[pwl]
let sar12_stimulus = vector(8)
let sar12_stimulus[0] = 0
let sar12_stimulus[1] = sar12_previous[length(sar12_previous)-1]
let sar12_stimulus[2] = 4.40009999999999e-05
let sar12_stimulus[3] = sar12_stimulus[1]
let sar12_stimulus[4] = 4.40029999999999e-05
let sar12_stimulus[5] = sar12_drive
let sar12_stimulus[6] = 0.000148
let sar12_stimulus[7] = sar12_stimulus[5]
alter @VD_B4[pwl] = sar12_stimulus
let sar12_drive = (floor(sar12_trial / 32) - 2*floor(sar12_trial / 64))*1.8
let sar12_previous = @VD_B5[pwl]
let sar12_stimulus = vector(8)
let sar12_stimulus[0] = 0
let sar12_stimulus[1] = sar12_previous[length(sar12_previous)-1]
let sar12_stimulus[2] = 4.40009999999999e-05
let sar12_stimulus[3] = sar12_stimulus[1]
let sar12_stimulus[4] = 4.40029999999999e-05
let sar12_stimulus[5] = sar12_drive
let sar12_stimulus[6] = 0.000148
let sar12_stimulus[7] = sar12_stimulus[5]
alter @VD_B5[pwl] = sar12_stimulus
let sar12_drive = (floor(sar12_trial / 64) - 2*floor(sar12_trial / 128))*1.8
let sar12_previous = @VD_B6[pwl]
let sar12_stimulus = vector(8)
let sar12_stimulus[0] = 0
let sar12_stimulus[1] = sar12_previous[length(sar12_previous)-1]
let sar12_stimulus[2] = 4.40009999999999e-05
let sar12_stimulus[3] = sar12_stimulus[1]
let sar12_stimulus[4] = 4.40029999999999e-05
let sar12_stimulus[5] = sar12_drive
let sar12_stimulus[6] = 0.000148
let sar12_stimulus[7] = sar12_stimulus[5]
alter @VD_B6[pwl] = sar12_stimulus
let sar12_drive = (floor(sar12_trial / 128) - 2*floor(sar12_trial / 256))*1.8
let sar12_previous = @VD_B7[pwl]
let sar12_stimulus = vector(8)
let sar12_stimulus[0] = 0
let sar12_stimulus[1] = sar12_previous[length(sar12_previous)-1]
let sar12_stimulus[2] = 4.40009999999999e-05
let sar12_stimulus[3] = sar12_stimulus[1]
let sar12_stimulus[4] = 4.40029999999999e-05
let sar12_stimulus[5] = sar12_drive
let sar12_stimulus[6] = 0.000148
let sar12_stimulus[7] = sar12_stimulus[5]
alter @VD_B7[pwl] = sar12_stimulus
let sar12_drive = (floor(sar12_trial / 256) - 2*floor(sar12_trial / 512))*1.8
let sar12_previous = @VD_B8[pwl]
let sar12_stimulus = vector(8)
let sar12_stimulus[0] = 0
let sar12_stimulus[1] = sar12_previous[length(sar12_previous)-1]
let sar12_stimulus[2] = 4.40009999999999e-05
let sar12_stimulus[3] = sar12_stimulus[1]
let sar12_stimulus[4] = 4.40029999999999e-05
let sar12_stimulus[5] = sar12_drive
let sar12_stimulus[6] = 0.000148
let sar12_stimulus[7] = sar12_stimulus[5]
alter @VD_B8[pwl] = sar12_stimulus
let sar12_drive = (floor(sar12_trial / 512) - 2*floor(sar12_trial / 1024))*1.8
let sar12_previous = @VD_B9[pwl]
let sar12_stimulus = vector(8)
let sar12_stimulus[0] = 0
let sar12_stimulus[1] = sar12_previous[length(sar12_previous)-1]
let sar12_stimulus[2] = 4.40009999999999e-05
let sar12_stimulus[3] = sar12_stimulus[1]
let sar12_stimulus[4] = 4.40029999999999e-05
let sar12_stimulus[5] = sar12_drive
let sar12_stimulus[6] = 0.000148
let sar12_stimulus[7] = sar12_stimulus[5]
alter @VD_B9[pwl] = sar12_stimulus
let sar12_drive = (floor(sar12_trial / 1024) - 2*floor(sar12_trial / 2048))*1.8
let sar12_previous = @VD_B10[pwl]
let sar12_stimulus = vector(8)
let sar12_stimulus[0] = 0
let sar12_stimulus[1] = sar12_previous[length(sar12_previous)-1]
let sar12_stimulus[2] = 4.40009999999999e-05
let sar12_stimulus[3] = sar12_stimulus[1]
let sar12_stimulus[4] = 4.40029999999999e-05
let sar12_stimulus[5] = sar12_drive
let sar12_stimulus[6] = 0.000148
let sar12_stimulus[7] = sar12_stimulus[5]
alter @VD_B10[pwl] = sar12_stimulus
let sar12_drive = (floor(sar12_trial / 2048) - 2*floor(sar12_trial / 4096))*1.8
let sar12_previous = @VD_B11[pwl]
let sar12_stimulus = vector(8)
let sar12_stimulus[0] = 0
let sar12_stimulus[1] = sar12_previous[length(sar12_previous)-1]
let sar12_stimulus[2] = 4.40009999999999e-05
let sar12_stimulus[3] = sar12_stimulus[1]
let sar12_stimulus[4] = 4.40029999999999e-05
let sar12_stimulus[5] = sar12_drive
let sar12_stimulus[6] = 0.000148
let sar12_stimulus[7] = sar12_stimulus[5]
alter @VD_B11[pwl] = sar12_stimulus
let sar12_drive = (floor(sar12_trial / 4096) - 2*floor(sar12_trial / 8192))*1.8
let sar12_previous = @VD_B12[pwl]
let sar12_stimulus = vector(8)
let sar12_stimulus[0] = 0
let sar12_stimulus[1] = sar12_previous[length(sar12_previous)-1]
let sar12_stimulus[2] = 4.40009999999999e-05
let sar12_stimulus[3] = sar12_stimulus[1]
let sar12_stimulus[4] = 4.40029999999999e-05
let sar12_stimulus[5] = sar12_drive
let sar12_stimulus[6] = 0.000148
let sar12_stimulus[7] = sar12_stimulus[5]
alter @VD_B12[pwl] = sar12_stimulus
let sar12_drive = (floor(sar12_trial / 8192) - 2*floor(sar12_trial / 16384))*1.8
let sar12_previous = @VD_B13[pwl]
let sar12_stimulus = vector(8)
let sar12_stimulus[0] = 0
let sar12_stimulus[1] = sar12_previous[length(sar12_previous)-1]
let sar12_stimulus[2] = 4.40009999999999e-05
let sar12_stimulus[3] = sar12_stimulus[1]
let sar12_stimulus[4] = 4.40029999999999e-05
let sar12_stimulus[5] = sar12_drive
let sar12_stimulus[6] = 0.000148
let sar12_stimulus[7] = sar12_stimulus[5]
alter @VD_B13[pwl] = sar12_stimulus
let sar12_drive = (floor(sar12_trial / 16384) - 2*floor(sar12_trial / 32768))*1.8
let sar12_previous = @VD_B14[pwl]
let sar12_stimulus = vector(8)
let sar12_stimulus[0] = 0
let sar12_stimulus[1] = sar12_previous[length(sar12_previous)-1]
let sar12_stimulus[2] = 4.40009999999999e-05
let sar12_stimulus[3] = sar12_stimulus[1]
let sar12_stimulus[4] = 4.40029999999999e-05
let sar12_stimulus[5] = sar12_drive
let sar12_stimulus[6] = 0.000148
let sar12_stimulus[7] = sar12_stimulus[5]
alter @VD_B14[pwl] = sar12_stimulus
let sar12_drive = (floor(sar12_trial / 32768) - 2*floor(sar12_trial / 65536))*1.8
let sar12_previous = @VD_B15[pwl]
let sar12_stimulus = vector(8)
let sar12_stimulus[0] = 0
let sar12_stimulus[1] = sar12_previous[length(sar12_previous)-1]
let sar12_stimulus[2] = 4.40009999999999e-05
let sar12_stimulus[3] = sar12_stimulus[1]
let sar12_stimulus[4] = 4.40029999999999e-05
let sar12_stimulus[5] = sar12_drive
let sar12_stimulus[6] = 0.000148
let sar12_stimulus[7] = sar12_stimulus[5]
alter @VD_B15[pwl] = sar12_stimulus
resume
let sar12_k = length(time)-1
if abs(time[sar12_k] - 4.44999999999999e-05) > 1e-12
print time[sar12_k]
echo expected_pause_time_s 4.44999999999999e-05
echo SAR12_PAUSE_FAILED
quit 1
end
print time[sar12_k] >> pause-times.txt
let sar12_previous = @VD_EVAL[pwl]
let sar12_stimulus = vector(8)
let sar12_stimulus[0] = 0
let sar12_stimulus[1] = sar12_previous[length(sar12_previous)-1]
let sar12_stimulus[2] = 4.45009999999999e-05
let sar12_stimulus[3] = sar12_stimulus[1]
let sar12_stimulus[4] = 4.45029999999999e-05
let sar12_stimulus[5] = 1.8
let sar12_stimulus[6] = 0.000148
let sar12_stimulus[7] = sar12_stimulus[5]
alter @VD_EVAL[pwl] = sar12_stimulus
resume
let sar12_k = length(time)-1
if abs(time[sar12_k] - 4.49999999999999e-05) > 1e-12
print time[sar12_k]
echo expected_pause_time_s 4.49999999999999e-05
echo SAR12_PAUSE_FAILED
quit 1
end
print time[sar12_k] >> pause-times.txt
let sar12_k = length(time)-1
let sar12_cmp = v(COMP)[sar12_k]
let sar12_cmpn = v(COMPN)[sar12_k]
let sar12_p = v(TOPP)[sar12_k]
let sar12_n = v(TOPN)[sar12_k]
let sar12_decision = 0
if sar12_cmp >= 0.9
let sar12_code = sar12_trial
let sar12_decision = 1
end
echo 1 4 $&sar12_trial $&sar12_cmp $&sar12_cmpn $&sar12_p $&sar12_n -1.19998168945312 $&sar12_decision >> decisions.csv
let sar12_previous = @VD_EVAL[pwl]
let sar12_stimulus = vector(8)
let sar12_stimulus[0] = 0
let sar12_stimulus[1] = sar12_previous[length(sar12_previous)-1]
let sar12_stimulus[2] = 4.50009999999999e-05
let sar12_stimulus[3] = sar12_stimulus[1]
let sar12_stimulus[4] = 4.50029999999999e-05
let sar12_stimulus[5] = 0
let sar12_stimulus[6] = 0.000148
let sar12_stimulus[7] = sar12_stimulus[5]
alter @VD_EVAL[pwl] = sar12_stimulus
let sar12_trial = sar12_code + 8
let sar12_drive = (floor(sar12_trial / 1) - 2*floor(sar12_trial / 2))*1.8
let sar12_previous = @VD_B0[pwl]
let sar12_stimulus = vector(8)
let sar12_stimulus[0] = 0
let sar12_stimulus[1] = sar12_previous[length(sar12_previous)-1]
let sar12_stimulus[2] = 4.50009999999999e-05
let sar12_stimulus[3] = sar12_stimulus[1]
let sar12_stimulus[4] = 4.50029999999999e-05
let sar12_stimulus[5] = sar12_drive
let sar12_stimulus[6] = 0.000148
let sar12_stimulus[7] = sar12_stimulus[5]
alter @VD_B0[pwl] = sar12_stimulus
let sar12_drive = (floor(sar12_trial / 2) - 2*floor(sar12_trial / 4))*1.8
let sar12_previous = @VD_B1[pwl]
let sar12_stimulus = vector(8)
let sar12_stimulus[0] = 0
let sar12_stimulus[1] = sar12_previous[length(sar12_previous)-1]
let sar12_stimulus[2] = 4.50009999999999e-05
let sar12_stimulus[3] = sar12_stimulus[1]
let sar12_stimulus[4] = 4.50029999999999e-05
let sar12_stimulus[5] = sar12_drive
let sar12_stimulus[6] = 0.000148
let sar12_stimulus[7] = sar12_stimulus[5]
alter @VD_B1[pwl] = sar12_stimulus
let sar12_drive = (floor(sar12_trial / 4) - 2*floor(sar12_trial / 8))*1.8
let sar12_previous = @VD_B2[pwl]
let sar12_stimulus = vector(8)
let sar12_stimulus[0] = 0
let sar12_stimulus[1] = sar12_previous[length(sar12_previous)-1]
let sar12_stimulus[2] = 4.50009999999999e-05
let sar12_stimulus[3] = sar12_stimulus[1]
let sar12_stimulus[4] = 4.50029999999999e-05
let sar12_stimulus[5] = sar12_drive
let sar12_stimulus[6] = 0.000148
let sar12_stimulus[7] = sar12_stimulus[5]
alter @VD_B2[pwl] = sar12_stimulus
let sar12_drive = (floor(sar12_trial / 8) - 2*floor(sar12_trial / 16))*1.8
let sar12_previous = @VD_B3[pwl]
let sar12_stimulus = vector(8)
let sar12_stimulus[0] = 0
let sar12_stimulus[1] = sar12_previous[length(sar12_previous)-1]
let sar12_stimulus[2] = 4.50009999999999e-05
let sar12_stimulus[3] = sar12_stimulus[1]
let sar12_stimulus[4] = 4.50029999999999e-05
let sar12_stimulus[5] = sar12_drive
let sar12_stimulus[6] = 0.000148
let sar12_stimulus[7] = sar12_stimulus[5]
alter @VD_B3[pwl] = sar12_stimulus
let sar12_drive = (floor(sar12_trial / 16) - 2*floor(sar12_trial / 32))*1.8
let sar12_previous = @VD_B4[pwl]
let sar12_stimulus = vector(8)
let sar12_stimulus[0] = 0
let sar12_stimulus[1] = sar12_previous[length(sar12_previous)-1]
let sar12_stimulus[2] = 4.50009999999999e-05
let sar12_stimulus[3] = sar12_stimulus[1]
let sar12_stimulus[4] = 4.50029999999999e-05
let sar12_stimulus[5] = sar12_drive
let sar12_stimulus[6] = 0.000148
let sar12_stimulus[7] = sar12_stimulus[5]
alter @VD_B4[pwl] = sar12_stimulus
let sar12_drive = (floor(sar12_trial / 32) - 2*floor(sar12_trial / 64))*1.8
let sar12_previous = @VD_B5[pwl]
let sar12_stimulus = vector(8)
let sar12_stimulus[0] = 0
let sar12_stimulus[1] = sar12_previous[length(sar12_previous)-1]
let sar12_stimulus[2] = 4.50009999999999e-05
let sar12_stimulus[3] = sar12_stimulus[1]
let sar12_stimulus[4] = 4.50029999999999e-05
let sar12_stimulus[5] = sar12_drive
let sar12_stimulus[6] = 0.000148
let sar12_stimulus[7] = sar12_stimulus[5]
alter @VD_B5[pwl] = sar12_stimulus
let sar12_drive = (floor(sar12_trial / 64) - 2*floor(sar12_trial / 128))*1.8
let sar12_previous = @VD_B6[pwl]
let sar12_stimulus = vector(8)
let sar12_stimulus[0] = 0
let sar12_stimulus[1] = sar12_previous[length(sar12_previous)-1]
let sar12_stimulus[2] = 4.50009999999999e-05
let sar12_stimulus[3] = sar12_stimulus[1]
let sar12_stimulus[4] = 4.50029999999999e-05
let sar12_stimulus[5] = sar12_drive
let sar12_stimulus[6] = 0.000148
let sar12_stimulus[7] = sar12_stimulus[5]
alter @VD_B6[pwl] = sar12_stimulus
let sar12_drive = (floor(sar12_trial / 128) - 2*floor(sar12_trial / 256))*1.8
let sar12_previous = @VD_B7[pwl]
let sar12_stimulus = vector(8)
let sar12_stimulus[0] = 0
let sar12_stimulus[1] = sar12_previous[length(sar12_previous)-1]
let sar12_stimulus[2] = 4.50009999999999e-05
let sar12_stimulus[3] = sar12_stimulus[1]
let sar12_stimulus[4] = 4.50029999999999e-05
let sar12_stimulus[5] = sar12_drive
let sar12_stimulus[6] = 0.000148
let sar12_stimulus[7] = sar12_stimulus[5]
alter @VD_B7[pwl] = sar12_stimulus
let sar12_drive = (floor(sar12_trial / 256) - 2*floor(sar12_trial / 512))*1.8
let sar12_previous = @VD_B8[pwl]
let sar12_stimulus = vector(8)
let sar12_stimulus[0] = 0
let sar12_stimulus[1] = sar12_previous[length(sar12_previous)-1]
let sar12_stimulus[2] = 4.50009999999999e-05
let sar12_stimulus[3] = sar12_stimulus[1]
let sar12_stimulus[4] = 4.50029999999999e-05
let sar12_stimulus[5] = sar12_drive
let sar12_stimulus[6] = 0.000148
let sar12_stimulus[7] = sar12_stimulus[5]
alter @VD_B8[pwl] = sar12_stimulus
let sar12_drive = (floor(sar12_trial / 512) - 2*floor(sar12_trial / 1024))*1.8
let sar12_previous = @VD_B9[pwl]
let sar12_stimulus = vector(8)
let sar12_stimulus[0] = 0
let sar12_stimulus[1] = sar12_previous[length(sar12_previous)-1]
let sar12_stimulus[2] = 4.50009999999999e-05
let sar12_stimulus[3] = sar12_stimulus[1]
let sar12_stimulus[4] = 4.50029999999999e-05
let sar12_stimulus[5] = sar12_drive
let sar12_stimulus[6] = 0.000148
let sar12_stimulus[7] = sar12_stimulus[5]
alter @VD_B9[pwl] = sar12_stimulus
let sar12_drive = (floor(sar12_trial / 1024) - 2*floor(sar12_trial / 2048))*1.8
let sar12_previous = @VD_B10[pwl]
let sar12_stimulus = vector(8)
let sar12_stimulus[0] = 0
let sar12_stimulus[1] = sar12_previous[length(sar12_previous)-1]
let sar12_stimulus[2] = 4.50009999999999e-05
let sar12_stimulus[3] = sar12_stimulus[1]
let sar12_stimulus[4] = 4.50029999999999e-05
let sar12_stimulus[5] = sar12_drive
let sar12_stimulus[6] = 0.000148
let sar12_stimulus[7] = sar12_stimulus[5]
alter @VD_B10[pwl] = sar12_stimulus
let sar12_drive = (floor(sar12_trial / 2048) - 2*floor(sar12_trial / 4096))*1.8
let sar12_previous = @VD_B11[pwl]
let sar12_stimulus = vector(8)
let sar12_stimulus[0] = 0
let sar12_stimulus[1] = sar12_previous[length(sar12_previous)-1]
let sar12_stimulus[2] = 4.50009999999999e-05
let sar12_stimulus[3] = sar12_stimulus[1]
let sar12_stimulus[4] = 4.50029999999999e-05
let sar12_stimulus[5] = sar12_drive
let sar12_stimulus[6] = 0.000148
let sar12_stimulus[7] = sar12_stimulus[5]
alter @VD_B11[pwl] = sar12_stimulus
let sar12_drive = (floor(sar12_trial / 4096) - 2*floor(sar12_trial / 8192))*1.8
let sar12_previous = @VD_B12[pwl]
let sar12_stimulus = vector(8)
let sar12_stimulus[0] = 0
let sar12_stimulus[1] = sar12_previous[length(sar12_previous)-1]
let sar12_stimulus[2] = 4.50009999999999e-05
let sar12_stimulus[3] = sar12_stimulus[1]
let sar12_stimulus[4] = 4.50029999999999e-05
let sar12_stimulus[5] = sar12_drive
let sar12_stimulus[6] = 0.000148
let sar12_stimulus[7] = sar12_stimulus[5]
alter @VD_B12[pwl] = sar12_stimulus
let sar12_drive = (floor(sar12_trial / 8192) - 2*floor(sar12_trial / 16384))*1.8
let sar12_previous = @VD_B13[pwl]
let sar12_stimulus = vector(8)
let sar12_stimulus[0] = 0
let sar12_stimulus[1] = sar12_previous[length(sar12_previous)-1]
let sar12_stimulus[2] = 4.50009999999999e-05
let sar12_stimulus[3] = sar12_stimulus[1]
let sar12_stimulus[4] = 4.50029999999999e-05
let sar12_stimulus[5] = sar12_drive
let sar12_stimulus[6] = 0.000148
let sar12_stimulus[7] = sar12_stimulus[5]
alter @VD_B13[pwl] = sar12_stimulus
let sar12_drive = (floor(sar12_trial / 16384) - 2*floor(sar12_trial / 32768))*1.8
let sar12_previous = @VD_B14[pwl]
let sar12_stimulus = vector(8)
let sar12_stimulus[0] = 0
let sar12_stimulus[1] = sar12_previous[length(sar12_previous)-1]
let sar12_stimulus[2] = 4.50009999999999e-05
let sar12_stimulus[3] = sar12_stimulus[1]
let sar12_stimulus[4] = 4.50029999999999e-05
let sar12_stimulus[5] = sar12_drive
let sar12_stimulus[6] = 0.000148
let sar12_stimulus[7] = sar12_stimulus[5]
alter @VD_B14[pwl] = sar12_stimulus
let sar12_drive = (floor(sar12_trial / 32768) - 2*floor(sar12_trial / 65536))*1.8
let sar12_previous = @VD_B15[pwl]
let sar12_stimulus = vector(8)
let sar12_stimulus[0] = 0
let sar12_stimulus[1] = sar12_previous[length(sar12_previous)-1]
let sar12_stimulus[2] = 4.50009999999999e-05
let sar12_stimulus[3] = sar12_stimulus[1]
let sar12_stimulus[4] = 4.50029999999999e-05
let sar12_stimulus[5] = sar12_drive
let sar12_stimulus[6] = 0.000148
let sar12_stimulus[7] = sar12_stimulus[5]
alter @VD_B15[pwl] = sar12_stimulus
resume
let sar12_k = length(time)-1
if abs(time[sar12_k] - 4.54999999999999e-05) > 1e-12
print time[sar12_k]
echo expected_pause_time_s 4.54999999999999e-05
echo SAR12_PAUSE_FAILED
quit 1
end
print time[sar12_k] >> pause-times.txt
let sar12_previous = @VD_EVAL[pwl]
let sar12_stimulus = vector(8)
let sar12_stimulus[0] = 0
let sar12_stimulus[1] = sar12_previous[length(sar12_previous)-1]
let sar12_stimulus[2] = 4.55009999999999e-05
let sar12_stimulus[3] = sar12_stimulus[1]
let sar12_stimulus[4] = 4.55029999999999e-05
let sar12_stimulus[5] = 1.8
let sar12_stimulus[6] = 0.000148
let sar12_stimulus[7] = sar12_stimulus[5]
alter @VD_EVAL[pwl] = sar12_stimulus
resume
let sar12_k = length(time)-1
if abs(time[sar12_k] - 4.59999999999999e-05) > 1e-12
print time[sar12_k]
echo expected_pause_time_s 4.59999999999999e-05
echo SAR12_PAUSE_FAILED
quit 1
end
print time[sar12_k] >> pause-times.txt
let sar12_k = length(time)-1
let sar12_cmp = v(COMP)[sar12_k]
let sar12_cmpn = v(COMPN)[sar12_k]
let sar12_p = v(TOPP)[sar12_k]
let sar12_n = v(TOPN)[sar12_k]
let sar12_decision = 0
if sar12_cmp >= 0.9
let sar12_code = sar12_trial
let sar12_decision = 1
end
echo 1 3 $&sar12_trial $&sar12_cmp $&sar12_cmpn $&sar12_p $&sar12_n -1.19998168945312 $&sar12_decision >> decisions.csv
let sar12_previous = @VD_EVAL[pwl]
let sar12_stimulus = vector(8)
let sar12_stimulus[0] = 0
let sar12_stimulus[1] = sar12_previous[length(sar12_previous)-1]
let sar12_stimulus[2] = 4.60009999999999e-05
let sar12_stimulus[3] = sar12_stimulus[1]
let sar12_stimulus[4] = 4.60029999999999e-05
let sar12_stimulus[5] = 0
let sar12_stimulus[6] = 0.000148
let sar12_stimulus[7] = sar12_stimulus[5]
alter @VD_EVAL[pwl] = sar12_stimulus
let sar12_trial = sar12_code + 4
let sar12_drive = (floor(sar12_trial / 1) - 2*floor(sar12_trial / 2))*1.8
let sar12_previous = @VD_B0[pwl]
let sar12_stimulus = vector(8)
let sar12_stimulus[0] = 0
let sar12_stimulus[1] = sar12_previous[length(sar12_previous)-1]
let sar12_stimulus[2] = 4.60009999999999e-05
let sar12_stimulus[3] = sar12_stimulus[1]
let sar12_stimulus[4] = 4.60029999999999e-05
let sar12_stimulus[5] = sar12_drive
let sar12_stimulus[6] = 0.000148
let sar12_stimulus[7] = sar12_stimulus[5]
alter @VD_B0[pwl] = sar12_stimulus
let sar12_drive = (floor(sar12_trial / 2) - 2*floor(sar12_trial / 4))*1.8
let sar12_previous = @VD_B1[pwl]
let sar12_stimulus = vector(8)
let sar12_stimulus[0] = 0
let sar12_stimulus[1] = sar12_previous[length(sar12_previous)-1]
let sar12_stimulus[2] = 4.60009999999999e-05
let sar12_stimulus[3] = sar12_stimulus[1]
let sar12_stimulus[4] = 4.60029999999999e-05
let sar12_stimulus[5] = sar12_drive
let sar12_stimulus[6] = 0.000148
let sar12_stimulus[7] = sar12_stimulus[5]
alter @VD_B1[pwl] = sar12_stimulus
let sar12_drive = (floor(sar12_trial / 4) - 2*floor(sar12_trial / 8))*1.8
let sar12_previous = @VD_B2[pwl]
let sar12_stimulus = vector(8)
let sar12_stimulus[0] = 0
let sar12_stimulus[1] = sar12_previous[length(sar12_previous)-1]
let sar12_stimulus[2] = 4.60009999999999e-05
let sar12_stimulus[3] = sar12_stimulus[1]
let sar12_stimulus[4] = 4.60029999999999e-05
let sar12_stimulus[5] = sar12_drive
let sar12_stimulus[6] = 0.000148
let sar12_stimulus[7] = sar12_stimulus[5]
alter @VD_B2[pwl] = sar12_stimulus
let sar12_drive = (floor(sar12_trial / 8) - 2*floor(sar12_trial / 16))*1.8
let sar12_previous = @VD_B3[pwl]
let sar12_stimulus = vector(8)
let sar12_stimulus[0] = 0
let sar12_stimulus[1] = sar12_previous[length(sar12_previous)-1]
let sar12_stimulus[2] = 4.60009999999999e-05
let sar12_stimulus[3] = sar12_stimulus[1]
let sar12_stimulus[4] = 4.60029999999999e-05
let sar12_stimulus[5] = sar12_drive
let sar12_stimulus[6] = 0.000148
let sar12_stimulus[7] = sar12_stimulus[5]
alter @VD_B3[pwl] = sar12_stimulus
let sar12_drive = (floor(sar12_trial / 16) - 2*floor(sar12_trial / 32))*1.8
let sar12_previous = @VD_B4[pwl]
let sar12_stimulus = vector(8)
let sar12_stimulus[0] = 0
let sar12_stimulus[1] = sar12_previous[length(sar12_previous)-1]
let sar12_stimulus[2] = 4.60009999999999e-05
let sar12_stimulus[3] = sar12_stimulus[1]
let sar12_stimulus[4] = 4.60029999999999e-05
let sar12_stimulus[5] = sar12_drive
let sar12_stimulus[6] = 0.000148
let sar12_stimulus[7] = sar12_stimulus[5]
alter @VD_B4[pwl] = sar12_stimulus
let sar12_drive = (floor(sar12_trial / 32) - 2*floor(sar12_trial / 64))*1.8
let sar12_previous = @VD_B5[pwl]
let sar12_stimulus = vector(8)
let sar12_stimulus[0] = 0
let sar12_stimulus[1] = sar12_previous[length(sar12_previous)-1]
let sar12_stimulus[2] = 4.60009999999999e-05
let sar12_stimulus[3] = sar12_stimulus[1]
let sar12_stimulus[4] = 4.60029999999999e-05
let sar12_stimulus[5] = sar12_drive
let sar12_stimulus[6] = 0.000148
let sar12_stimulus[7] = sar12_stimulus[5]
alter @VD_B5[pwl] = sar12_stimulus
let sar12_drive = (floor(sar12_trial / 64) - 2*floor(sar12_trial / 128))*1.8
let sar12_previous = @VD_B6[pwl]
let sar12_stimulus = vector(8)
let sar12_stimulus[0] = 0
let sar12_stimulus[1] = sar12_previous[length(sar12_previous)-1]
let sar12_stimulus[2] = 4.60009999999999e-05
let sar12_stimulus[3] = sar12_stimulus[1]
let sar12_stimulus[4] = 4.60029999999999e-05
let sar12_stimulus[5] = sar12_drive
let sar12_stimulus[6] = 0.000148
let sar12_stimulus[7] = sar12_stimulus[5]
alter @VD_B6[pwl] = sar12_stimulus
let sar12_drive = (floor(sar12_trial / 128) - 2*floor(sar12_trial / 256))*1.8
let sar12_previous = @VD_B7[pwl]
let sar12_stimulus = vector(8)
let sar12_stimulus[0] = 0
let sar12_stimulus[1] = sar12_previous[length(sar12_previous)-1]
let sar12_stimulus[2] = 4.60009999999999e-05
let sar12_stimulus[3] = sar12_stimulus[1]
let sar12_stimulus[4] = 4.60029999999999e-05
let sar12_stimulus[5] = sar12_drive
let sar12_stimulus[6] = 0.000148
let sar12_stimulus[7] = sar12_stimulus[5]
alter @VD_B7[pwl] = sar12_stimulus
let sar12_drive = (floor(sar12_trial / 256) - 2*floor(sar12_trial / 512))*1.8
let sar12_previous = @VD_B8[pwl]
let sar12_stimulus = vector(8)
let sar12_stimulus[0] = 0
let sar12_stimulus[1] = sar12_previous[length(sar12_previous)-1]
let sar12_stimulus[2] = 4.60009999999999e-05
let sar12_stimulus[3] = sar12_stimulus[1]
let sar12_stimulus[4] = 4.60029999999999e-05
let sar12_stimulus[5] = sar12_drive
let sar12_stimulus[6] = 0.000148
let sar12_stimulus[7] = sar12_stimulus[5]
alter @VD_B8[pwl] = sar12_stimulus
let sar12_drive = (floor(sar12_trial / 512) - 2*floor(sar12_trial / 1024))*1.8
let sar12_previous = @VD_B9[pwl]
let sar12_stimulus = vector(8)
let sar12_stimulus[0] = 0
let sar12_stimulus[1] = sar12_previous[length(sar12_previous)-1]
let sar12_stimulus[2] = 4.60009999999999e-05
let sar12_stimulus[3] = sar12_stimulus[1]
let sar12_stimulus[4] = 4.60029999999999e-05
let sar12_stimulus[5] = sar12_drive
let sar12_stimulus[6] = 0.000148
let sar12_stimulus[7] = sar12_stimulus[5]
alter @VD_B9[pwl] = sar12_stimulus
let sar12_drive = (floor(sar12_trial / 1024) - 2*floor(sar12_trial / 2048))*1.8
let sar12_previous = @VD_B10[pwl]
let sar12_stimulus = vector(8)
let sar12_stimulus[0] = 0
let sar12_stimulus[1] = sar12_previous[length(sar12_previous)-1]
let sar12_stimulus[2] = 4.60009999999999e-05
let sar12_stimulus[3] = sar12_stimulus[1]
let sar12_stimulus[4] = 4.60029999999999e-05
let sar12_stimulus[5] = sar12_drive
let sar12_stimulus[6] = 0.000148
let sar12_stimulus[7] = sar12_stimulus[5]
alter @VD_B10[pwl] = sar12_stimulus
let sar12_drive = (floor(sar12_trial / 2048) - 2*floor(sar12_trial / 4096))*1.8
let sar12_previous = @VD_B11[pwl]
let sar12_stimulus = vector(8)
let sar12_stimulus[0] = 0
let sar12_stimulus[1] = sar12_previous[length(sar12_previous)-1]
let sar12_stimulus[2] = 4.60009999999999e-05
let sar12_stimulus[3] = sar12_stimulus[1]
let sar12_stimulus[4] = 4.60029999999999e-05
let sar12_stimulus[5] = sar12_drive
let sar12_stimulus[6] = 0.000148
let sar12_stimulus[7] = sar12_stimulus[5]
alter @VD_B11[pwl] = sar12_stimulus
let sar12_drive = (floor(sar12_trial / 4096) - 2*floor(sar12_trial / 8192))*1.8
let sar12_previous = @VD_B12[pwl]
let sar12_stimulus = vector(8)
let sar12_stimulus[0] = 0
let sar12_stimulus[1] = sar12_previous[length(sar12_previous)-1]
let sar12_stimulus[2] = 4.60009999999999e-05
let sar12_stimulus[3] = sar12_stimulus[1]
let sar12_stimulus[4] = 4.60029999999999e-05
let sar12_stimulus[5] = sar12_drive
let sar12_stimulus[6] = 0.000148
let sar12_stimulus[7] = sar12_stimulus[5]
alter @VD_B12[pwl] = sar12_stimulus
let sar12_drive = (floor(sar12_trial / 8192) - 2*floor(sar12_trial / 16384))*1.8
let sar12_previous = @VD_B13[pwl]
let sar12_stimulus = vector(8)
let sar12_stimulus[0] = 0
let sar12_stimulus[1] = sar12_previous[length(sar12_previous)-1]
let sar12_stimulus[2] = 4.60009999999999e-05
let sar12_stimulus[3] = sar12_stimulus[1]
let sar12_stimulus[4] = 4.60029999999999e-05
let sar12_stimulus[5] = sar12_drive
let sar12_stimulus[6] = 0.000148
let sar12_stimulus[7] = sar12_stimulus[5]
alter @VD_B13[pwl] = sar12_stimulus
let sar12_drive = (floor(sar12_trial / 16384) - 2*floor(sar12_trial / 32768))*1.8
let sar12_previous = @VD_B14[pwl]
let sar12_stimulus = vector(8)
let sar12_stimulus[0] = 0
let sar12_stimulus[1] = sar12_previous[length(sar12_previous)-1]
let sar12_stimulus[2] = 4.60009999999999e-05
let sar12_stimulus[3] = sar12_stimulus[1]
let sar12_stimulus[4] = 4.60029999999999e-05
let sar12_stimulus[5] = sar12_drive
let sar12_stimulus[6] = 0.000148
let sar12_stimulus[7] = sar12_stimulus[5]
alter @VD_B14[pwl] = sar12_stimulus
let sar12_drive = (floor(sar12_trial / 32768) - 2*floor(sar12_trial / 65536))*1.8
let sar12_previous = @VD_B15[pwl]
let sar12_stimulus = vector(8)
let sar12_stimulus[0] = 0
let sar12_stimulus[1] = sar12_previous[length(sar12_previous)-1]
let sar12_stimulus[2] = 4.60009999999999e-05
let sar12_stimulus[3] = sar12_stimulus[1]
let sar12_stimulus[4] = 4.60029999999999e-05
let sar12_stimulus[5] = sar12_drive
let sar12_stimulus[6] = 0.000148
let sar12_stimulus[7] = sar12_stimulus[5]
alter @VD_B15[pwl] = sar12_stimulus
resume
let sar12_k = length(time)-1
if abs(time[sar12_k] - 4.64999999999999e-05) > 1e-12
print time[sar12_k]
echo expected_pause_time_s 4.64999999999999e-05
echo SAR12_PAUSE_FAILED
quit 1
end
print time[sar12_k] >> pause-times.txt
let sar12_previous = @VD_EVAL[pwl]
let sar12_stimulus = vector(8)
let sar12_stimulus[0] = 0
let sar12_stimulus[1] = sar12_previous[length(sar12_previous)-1]
let sar12_stimulus[2] = 4.65009999999999e-05
let sar12_stimulus[3] = sar12_stimulus[1]
let sar12_stimulus[4] = 4.65029999999999e-05
let sar12_stimulus[5] = 1.8
let sar12_stimulus[6] = 0.000148
let sar12_stimulus[7] = sar12_stimulus[5]
alter @VD_EVAL[pwl] = sar12_stimulus
resume
let sar12_k = length(time)-1
if abs(time[sar12_k] - 4.69999999999999e-05) > 1e-12
print time[sar12_k]
echo expected_pause_time_s 4.69999999999999e-05
echo SAR12_PAUSE_FAILED
quit 1
end
print time[sar12_k] >> pause-times.txt
let sar12_k = length(time)-1
let sar12_cmp = v(COMP)[sar12_k]
let sar12_cmpn = v(COMPN)[sar12_k]
let sar12_p = v(TOPP)[sar12_k]
let sar12_n = v(TOPN)[sar12_k]
let sar12_decision = 0
if sar12_cmp >= 0.9
let sar12_code = sar12_trial
let sar12_decision = 1
end
echo 1 2 $&sar12_trial $&sar12_cmp $&sar12_cmpn $&sar12_p $&sar12_n -1.19998168945312 $&sar12_decision >> decisions.csv
let sar12_previous = @VD_EVAL[pwl]
let sar12_stimulus = vector(8)
let sar12_stimulus[0] = 0
let sar12_stimulus[1] = sar12_previous[length(sar12_previous)-1]
let sar12_stimulus[2] = 4.70009999999999e-05
let sar12_stimulus[3] = sar12_stimulus[1]
let sar12_stimulus[4] = 4.70029999999999e-05
let sar12_stimulus[5] = 0
let sar12_stimulus[6] = 0.000148
let sar12_stimulus[7] = sar12_stimulus[5]
alter @VD_EVAL[pwl] = sar12_stimulus
let sar12_trial = sar12_code + 2
let sar12_drive = (floor(sar12_trial / 1) - 2*floor(sar12_trial / 2))*1.8
let sar12_previous = @VD_B0[pwl]
let sar12_stimulus = vector(8)
let sar12_stimulus[0] = 0
let sar12_stimulus[1] = sar12_previous[length(sar12_previous)-1]
let sar12_stimulus[2] = 4.70009999999999e-05
let sar12_stimulus[3] = sar12_stimulus[1]
let sar12_stimulus[4] = 4.70029999999999e-05
let sar12_stimulus[5] = sar12_drive
let sar12_stimulus[6] = 0.000148
let sar12_stimulus[7] = sar12_stimulus[5]
alter @VD_B0[pwl] = sar12_stimulus
let sar12_drive = (floor(sar12_trial / 2) - 2*floor(sar12_trial / 4))*1.8
let sar12_previous = @VD_B1[pwl]
let sar12_stimulus = vector(8)
let sar12_stimulus[0] = 0
let sar12_stimulus[1] = sar12_previous[length(sar12_previous)-1]
let sar12_stimulus[2] = 4.70009999999999e-05
let sar12_stimulus[3] = sar12_stimulus[1]
let sar12_stimulus[4] = 4.70029999999999e-05
let sar12_stimulus[5] = sar12_drive
let sar12_stimulus[6] = 0.000148
let sar12_stimulus[7] = sar12_stimulus[5]
alter @VD_B1[pwl] = sar12_stimulus
let sar12_drive = (floor(sar12_trial / 4) - 2*floor(sar12_trial / 8))*1.8
let sar12_previous = @VD_B2[pwl]
let sar12_stimulus = vector(8)
let sar12_stimulus[0] = 0
let sar12_stimulus[1] = sar12_previous[length(sar12_previous)-1]
let sar12_stimulus[2] = 4.70009999999999e-05
let sar12_stimulus[3] = sar12_stimulus[1]
let sar12_stimulus[4] = 4.70029999999999e-05
let sar12_stimulus[5] = sar12_drive
let sar12_stimulus[6] = 0.000148
let sar12_stimulus[7] = sar12_stimulus[5]
alter @VD_B2[pwl] = sar12_stimulus
let sar12_drive = (floor(sar12_trial / 8) - 2*floor(sar12_trial / 16))*1.8
let sar12_previous = @VD_B3[pwl]
let sar12_stimulus = vector(8)
let sar12_stimulus[0] = 0
let sar12_stimulus[1] = sar12_previous[length(sar12_previous)-1]
let sar12_stimulus[2] = 4.70009999999999e-05
let sar12_stimulus[3] = sar12_stimulus[1]
let sar12_stimulus[4] = 4.70029999999999e-05
let sar12_stimulus[5] = sar12_drive
let sar12_stimulus[6] = 0.000148
let sar12_stimulus[7] = sar12_stimulus[5]
alter @VD_B3[pwl] = sar12_stimulus
let sar12_drive = (floor(sar12_trial / 16) - 2*floor(sar12_trial / 32))*1.8
let sar12_previous = @VD_B4[pwl]
let sar12_stimulus = vector(8)
let sar12_stimulus[0] = 0
let sar12_stimulus[1] = sar12_previous[length(sar12_previous)-1]
let sar12_stimulus[2] = 4.70009999999999e-05
let sar12_stimulus[3] = sar12_stimulus[1]
let sar12_stimulus[4] = 4.70029999999999e-05
let sar12_stimulus[5] = sar12_drive
let sar12_stimulus[6] = 0.000148
let sar12_stimulus[7] = sar12_stimulus[5]
alter @VD_B4[pwl] = sar12_stimulus
let sar12_drive = (floor(sar12_trial / 32) - 2*floor(sar12_trial / 64))*1.8
let sar12_previous = @VD_B5[pwl]
let sar12_stimulus = vector(8)
let sar12_stimulus[0] = 0
let sar12_stimulus[1] = sar12_previous[length(sar12_previous)-1]
let sar12_stimulus[2] = 4.70009999999999e-05
let sar12_stimulus[3] = sar12_stimulus[1]
let sar12_stimulus[4] = 4.70029999999999e-05
let sar12_stimulus[5] = sar12_drive
let sar12_stimulus[6] = 0.000148
let sar12_stimulus[7] = sar12_stimulus[5]
alter @VD_B5[pwl] = sar12_stimulus
let sar12_drive = (floor(sar12_trial / 64) - 2*floor(sar12_trial / 128))*1.8
let sar12_previous = @VD_B6[pwl]
let sar12_stimulus = vector(8)
let sar12_stimulus[0] = 0
let sar12_stimulus[1] = sar12_previous[length(sar12_previous)-1]
let sar12_stimulus[2] = 4.70009999999999e-05
let sar12_stimulus[3] = sar12_stimulus[1]
let sar12_stimulus[4] = 4.70029999999999e-05
let sar12_stimulus[5] = sar12_drive
let sar12_stimulus[6] = 0.000148
let sar12_stimulus[7] = sar12_stimulus[5]
alter @VD_B6[pwl] = sar12_stimulus
let sar12_drive = (floor(sar12_trial / 128) - 2*floor(sar12_trial / 256))*1.8
let sar12_previous = @VD_B7[pwl]
let sar12_stimulus = vector(8)
let sar12_stimulus[0] = 0
let sar12_stimulus[1] = sar12_previous[length(sar12_previous)-1]
let sar12_stimulus[2] = 4.70009999999999e-05
let sar12_stimulus[3] = sar12_stimulus[1]
let sar12_stimulus[4] = 4.70029999999999e-05
let sar12_stimulus[5] = sar12_drive
let sar12_stimulus[6] = 0.000148
let sar12_stimulus[7] = sar12_stimulus[5]
alter @VD_B7[pwl] = sar12_stimulus
let sar12_drive = (floor(sar12_trial / 256) - 2*floor(sar12_trial / 512))*1.8
let sar12_previous = @VD_B8[pwl]
let sar12_stimulus = vector(8)
let sar12_stimulus[0] = 0
let sar12_stimulus[1] = sar12_previous[length(sar12_previous)-1]
let sar12_stimulus[2] = 4.70009999999999e-05
let sar12_stimulus[3] = sar12_stimulus[1]
let sar12_stimulus[4] = 4.70029999999999e-05
let sar12_stimulus[5] = sar12_drive
let sar12_stimulus[6] = 0.000148
let sar12_stimulus[7] = sar12_stimulus[5]
alter @VD_B8[pwl] = sar12_stimulus
let sar12_drive = (floor(sar12_trial / 512) - 2*floor(sar12_trial / 1024))*1.8
let sar12_previous = @VD_B9[pwl]
let sar12_stimulus = vector(8)
let sar12_stimulus[0] = 0
let sar12_stimulus[1] = sar12_previous[length(sar12_previous)-1]
let sar12_stimulus[2] = 4.70009999999999e-05
let sar12_stimulus[3] = sar12_stimulus[1]
let sar12_stimulus[4] = 4.70029999999999e-05
let sar12_stimulus[5] = sar12_drive
let sar12_stimulus[6] = 0.000148
let sar12_stimulus[7] = sar12_stimulus[5]
alter @VD_B9[pwl] = sar12_stimulus
let sar12_drive = (floor(sar12_trial / 1024) - 2*floor(sar12_trial / 2048))*1.8
let sar12_previous = @VD_B10[pwl]
let sar12_stimulus = vector(8)
let sar12_stimulus[0] = 0
let sar12_stimulus[1] = sar12_previous[length(sar12_previous)-1]
let sar12_stimulus[2] = 4.70009999999999e-05
let sar12_stimulus[3] = sar12_stimulus[1]
let sar12_stimulus[4] = 4.70029999999999e-05
let sar12_stimulus[5] = sar12_drive
let sar12_stimulus[6] = 0.000148
let sar12_stimulus[7] = sar12_stimulus[5]
alter @VD_B10[pwl] = sar12_stimulus
let sar12_drive = (floor(sar12_trial / 2048) - 2*floor(sar12_trial / 4096))*1.8
let sar12_previous = @VD_B11[pwl]
let sar12_stimulus = vector(8)
let sar12_stimulus[0] = 0
let sar12_stimulus[1] = sar12_previous[length(sar12_previous)-1]
let sar12_stimulus[2] = 4.70009999999999e-05
let sar12_stimulus[3] = sar12_stimulus[1]
let sar12_stimulus[4] = 4.70029999999999e-05
let sar12_stimulus[5] = sar12_drive
let sar12_stimulus[6] = 0.000148
let sar12_stimulus[7] = sar12_stimulus[5]
alter @VD_B11[pwl] = sar12_stimulus
let sar12_drive = (floor(sar12_trial / 4096) - 2*floor(sar12_trial / 8192))*1.8
let sar12_previous = @VD_B12[pwl]
let sar12_stimulus = vector(8)
let sar12_stimulus[0] = 0
let sar12_stimulus[1] = sar12_previous[length(sar12_previous)-1]
let sar12_stimulus[2] = 4.70009999999999e-05
let sar12_stimulus[3] = sar12_stimulus[1]
let sar12_stimulus[4] = 4.70029999999999e-05
let sar12_stimulus[5] = sar12_drive
let sar12_stimulus[6] = 0.000148
let sar12_stimulus[7] = sar12_stimulus[5]
alter @VD_B12[pwl] = sar12_stimulus
let sar12_drive = (floor(sar12_trial / 8192) - 2*floor(sar12_trial / 16384))*1.8
let sar12_previous = @VD_B13[pwl]
let sar12_stimulus = vector(8)
let sar12_stimulus[0] = 0
let sar12_stimulus[1] = sar12_previous[length(sar12_previous)-1]
let sar12_stimulus[2] = 4.70009999999999e-05
let sar12_stimulus[3] = sar12_stimulus[1]
let sar12_stimulus[4] = 4.70029999999999e-05
let sar12_stimulus[5] = sar12_drive
let sar12_stimulus[6] = 0.000148
let sar12_stimulus[7] = sar12_stimulus[5]
alter @VD_B13[pwl] = sar12_stimulus
let sar12_drive = (floor(sar12_trial / 16384) - 2*floor(sar12_trial / 32768))*1.8
let sar12_previous = @VD_B14[pwl]
let sar12_stimulus = vector(8)
let sar12_stimulus[0] = 0
let sar12_stimulus[1] = sar12_previous[length(sar12_previous)-1]
let sar12_stimulus[2] = 4.70009999999999e-05
let sar12_stimulus[3] = sar12_stimulus[1]
let sar12_stimulus[4] = 4.70029999999999e-05
let sar12_stimulus[5] = sar12_drive
let sar12_stimulus[6] = 0.000148
let sar12_stimulus[7] = sar12_stimulus[5]
alter @VD_B14[pwl] = sar12_stimulus
let sar12_drive = (floor(sar12_trial / 32768) - 2*floor(sar12_trial / 65536))*1.8
let sar12_previous = @VD_B15[pwl]
let sar12_stimulus = vector(8)
let sar12_stimulus[0] = 0
let sar12_stimulus[1] = sar12_previous[length(sar12_previous)-1]
let sar12_stimulus[2] = 4.70009999999999e-05
let sar12_stimulus[3] = sar12_stimulus[1]
let sar12_stimulus[4] = 4.70029999999999e-05
let sar12_stimulus[5] = sar12_drive
let sar12_stimulus[6] = 0.000148
let sar12_stimulus[7] = sar12_stimulus[5]
alter @VD_B15[pwl] = sar12_stimulus
resume
let sar12_k = length(time)-1
if abs(time[sar12_k] - 4.74999999999999e-05) > 1e-12
print time[sar12_k]
echo expected_pause_time_s 4.74999999999999e-05
echo SAR12_PAUSE_FAILED
quit 1
end
print time[sar12_k] >> pause-times.txt
let sar12_previous = @VD_EVAL[pwl]
let sar12_stimulus = vector(8)
let sar12_stimulus[0] = 0
let sar12_stimulus[1] = sar12_previous[length(sar12_previous)-1]
let sar12_stimulus[2] = 4.75009999999999e-05
let sar12_stimulus[3] = sar12_stimulus[1]
let sar12_stimulus[4] = 4.75029999999999e-05
let sar12_stimulus[5] = 1.8
let sar12_stimulus[6] = 0.000148
let sar12_stimulus[7] = sar12_stimulus[5]
alter @VD_EVAL[pwl] = sar12_stimulus
resume
let sar12_k = length(time)-1
if abs(time[sar12_k] - 4.79999999999999e-05) > 1e-12
print time[sar12_k]
echo expected_pause_time_s 4.79999999999999e-05
echo SAR12_PAUSE_FAILED
quit 1
end
print time[sar12_k] >> pause-times.txt
let sar12_k = length(time)-1
let sar12_cmp = v(COMP)[sar12_k]
let sar12_cmpn = v(COMPN)[sar12_k]
let sar12_p = v(TOPP)[sar12_k]
let sar12_n = v(TOPN)[sar12_k]
let sar12_decision = 0
if sar12_cmp >= 0.9
let sar12_code = sar12_trial
let sar12_decision = 1
end
echo 1 1 $&sar12_trial $&sar12_cmp $&sar12_cmpn $&sar12_p $&sar12_n -1.19998168945312 $&sar12_decision >> decisions.csv
let sar12_previous = @VD_EVAL[pwl]
let sar12_stimulus = vector(8)
let sar12_stimulus[0] = 0
let sar12_stimulus[1] = sar12_previous[length(sar12_previous)-1]
let sar12_stimulus[2] = 4.80009999999999e-05
let sar12_stimulus[3] = sar12_stimulus[1]
let sar12_stimulus[4] = 4.80029999999999e-05
let sar12_stimulus[5] = 0
let sar12_stimulus[6] = 0.000148
let sar12_stimulus[7] = sar12_stimulus[5]
alter @VD_EVAL[pwl] = sar12_stimulus
let sar12_trial = sar12_code + 1
let sar12_drive = (floor(sar12_trial / 1) - 2*floor(sar12_trial / 2))*1.8
let sar12_previous = @VD_B0[pwl]
let sar12_stimulus = vector(8)
let sar12_stimulus[0] = 0
let sar12_stimulus[1] = sar12_previous[length(sar12_previous)-1]
let sar12_stimulus[2] = 4.80009999999999e-05
let sar12_stimulus[3] = sar12_stimulus[1]
let sar12_stimulus[4] = 4.80029999999999e-05
let sar12_stimulus[5] = sar12_drive
let sar12_stimulus[6] = 0.000148
let sar12_stimulus[7] = sar12_stimulus[5]
alter @VD_B0[pwl] = sar12_stimulus
let sar12_drive = (floor(sar12_trial / 2) - 2*floor(sar12_trial / 4))*1.8
let sar12_previous = @VD_B1[pwl]
let sar12_stimulus = vector(8)
let sar12_stimulus[0] = 0
let sar12_stimulus[1] = sar12_previous[length(sar12_previous)-1]
let sar12_stimulus[2] = 4.80009999999999e-05
let sar12_stimulus[3] = sar12_stimulus[1]
let sar12_stimulus[4] = 4.80029999999999e-05
let sar12_stimulus[5] = sar12_drive
let sar12_stimulus[6] = 0.000148
let sar12_stimulus[7] = sar12_stimulus[5]
alter @VD_B1[pwl] = sar12_stimulus
let sar12_drive = (floor(sar12_trial / 4) - 2*floor(sar12_trial / 8))*1.8
let sar12_previous = @VD_B2[pwl]
let sar12_stimulus = vector(8)
let sar12_stimulus[0] = 0
let sar12_stimulus[1] = sar12_previous[length(sar12_previous)-1]
let sar12_stimulus[2] = 4.80009999999999e-05
let sar12_stimulus[3] = sar12_stimulus[1]
let sar12_stimulus[4] = 4.80029999999999e-05
let sar12_stimulus[5] = sar12_drive
let sar12_stimulus[6] = 0.000148
let sar12_stimulus[7] = sar12_stimulus[5]
alter @VD_B2[pwl] = sar12_stimulus
let sar12_drive = (floor(sar12_trial / 8) - 2*floor(sar12_trial / 16))*1.8
let sar12_previous = @VD_B3[pwl]
let sar12_stimulus = vector(8)
let sar12_stimulus[0] = 0
let sar12_stimulus[1] = sar12_previous[length(sar12_previous)-1]
let sar12_stimulus[2] = 4.80009999999999e-05
let sar12_stimulus[3] = sar12_stimulus[1]
let sar12_stimulus[4] = 4.80029999999999e-05
let sar12_stimulus[5] = sar12_drive
let sar12_stimulus[6] = 0.000148
let sar12_stimulus[7] = sar12_stimulus[5]
alter @VD_B3[pwl] = sar12_stimulus
let sar12_drive = (floor(sar12_trial / 16) - 2*floor(sar12_trial / 32))*1.8
let sar12_previous = @VD_B4[pwl]
let sar12_stimulus = vector(8)
let sar12_stimulus[0] = 0
let sar12_stimulus[1] = sar12_previous[length(sar12_previous)-1]
let sar12_stimulus[2] = 4.80009999999999e-05
let sar12_stimulus[3] = sar12_stimulus[1]
let sar12_stimulus[4] = 4.80029999999999e-05
let sar12_stimulus[5] = sar12_drive
let sar12_stimulus[6] = 0.000148
let sar12_stimulus[7] = sar12_stimulus[5]
alter @VD_B4[pwl] = sar12_stimulus
let sar12_drive = (floor(sar12_trial / 32) - 2*floor(sar12_trial / 64))*1.8
let sar12_previous = @VD_B5[pwl]
let sar12_stimulus = vector(8)
let sar12_stimulus[0] = 0
let sar12_stimulus[1] = sar12_previous[length(sar12_previous)-1]
let sar12_stimulus[2] = 4.80009999999999e-05
let sar12_stimulus[3] = sar12_stimulus[1]
let sar12_stimulus[4] = 4.80029999999999e-05
let sar12_stimulus[5] = sar12_drive
let sar12_stimulus[6] = 0.000148
let sar12_stimulus[7] = sar12_stimulus[5]
alter @VD_B5[pwl] = sar12_stimulus
let sar12_drive = (floor(sar12_trial / 64) - 2*floor(sar12_trial / 128))*1.8
let sar12_previous = @VD_B6[pwl]
let sar12_stimulus = vector(8)
let sar12_stimulus[0] = 0
let sar12_stimulus[1] = sar12_previous[length(sar12_previous)-1]
let sar12_stimulus[2] = 4.80009999999999e-05
let sar12_stimulus[3] = sar12_stimulus[1]
let sar12_stimulus[4] = 4.80029999999999e-05
let sar12_stimulus[5] = sar12_drive
let sar12_stimulus[6] = 0.000148
let sar12_stimulus[7] = sar12_stimulus[5]
alter @VD_B6[pwl] = sar12_stimulus
let sar12_drive = (floor(sar12_trial / 128) - 2*floor(sar12_trial / 256))*1.8
let sar12_previous = @VD_B7[pwl]
let sar12_stimulus = vector(8)
let sar12_stimulus[0] = 0
let sar12_stimulus[1] = sar12_previous[length(sar12_previous)-1]
let sar12_stimulus[2] = 4.80009999999999e-05
let sar12_stimulus[3] = sar12_stimulus[1]
let sar12_stimulus[4] = 4.80029999999999e-05
let sar12_stimulus[5] = sar12_drive
let sar12_stimulus[6] = 0.000148
let sar12_stimulus[7] = sar12_stimulus[5]
alter @VD_B7[pwl] = sar12_stimulus
let sar12_drive = (floor(sar12_trial / 256) - 2*floor(sar12_trial / 512))*1.8
let sar12_previous = @VD_B8[pwl]
let sar12_stimulus = vector(8)
let sar12_stimulus[0] = 0
let sar12_stimulus[1] = sar12_previous[length(sar12_previous)-1]
let sar12_stimulus[2] = 4.80009999999999e-05
let sar12_stimulus[3] = sar12_stimulus[1]
let sar12_stimulus[4] = 4.80029999999999e-05
let sar12_stimulus[5] = sar12_drive
let sar12_stimulus[6] = 0.000148
let sar12_stimulus[7] = sar12_stimulus[5]
alter @VD_B8[pwl] = sar12_stimulus
let sar12_drive = (floor(sar12_trial / 512) - 2*floor(sar12_trial / 1024))*1.8
let sar12_previous = @VD_B9[pwl]
let sar12_stimulus = vector(8)
let sar12_stimulus[0] = 0
let sar12_stimulus[1] = sar12_previous[length(sar12_previous)-1]
let sar12_stimulus[2] = 4.80009999999999e-05
let sar12_stimulus[3] = sar12_stimulus[1]
let sar12_stimulus[4] = 4.80029999999999e-05
let sar12_stimulus[5] = sar12_drive
let sar12_stimulus[6] = 0.000148
let sar12_stimulus[7] = sar12_stimulus[5]
alter @VD_B9[pwl] = sar12_stimulus
let sar12_drive = (floor(sar12_trial / 1024) - 2*floor(sar12_trial / 2048))*1.8
let sar12_previous = @VD_B10[pwl]
let sar12_stimulus = vector(8)
let sar12_stimulus[0] = 0
let sar12_stimulus[1] = sar12_previous[length(sar12_previous)-1]
let sar12_stimulus[2] = 4.80009999999999e-05
let sar12_stimulus[3] = sar12_stimulus[1]
let sar12_stimulus[4] = 4.80029999999999e-05
let sar12_stimulus[5] = sar12_drive
let sar12_stimulus[6] = 0.000148
let sar12_stimulus[7] = sar12_stimulus[5]
alter @VD_B10[pwl] = sar12_stimulus
let sar12_drive = (floor(sar12_trial / 2048) - 2*floor(sar12_trial / 4096))*1.8
let sar12_previous = @VD_B11[pwl]
let sar12_stimulus = vector(8)
let sar12_stimulus[0] = 0
let sar12_stimulus[1] = sar12_previous[length(sar12_previous)-1]
let sar12_stimulus[2] = 4.80009999999999e-05
let sar12_stimulus[3] = sar12_stimulus[1]
let sar12_stimulus[4] = 4.80029999999999e-05
let sar12_stimulus[5] = sar12_drive
let sar12_stimulus[6] = 0.000148
let sar12_stimulus[7] = sar12_stimulus[5]
alter @VD_B11[pwl] = sar12_stimulus
let sar12_drive = (floor(sar12_trial / 4096) - 2*floor(sar12_trial / 8192))*1.8
let sar12_previous = @VD_B12[pwl]
let sar12_stimulus = vector(8)
let sar12_stimulus[0] = 0
let sar12_stimulus[1] = sar12_previous[length(sar12_previous)-1]
let sar12_stimulus[2] = 4.80009999999999e-05
let sar12_stimulus[3] = sar12_stimulus[1]
let sar12_stimulus[4] = 4.80029999999999e-05
let sar12_stimulus[5] = sar12_drive
let sar12_stimulus[6] = 0.000148
let sar12_stimulus[7] = sar12_stimulus[5]
alter @VD_B12[pwl] = sar12_stimulus
let sar12_drive = (floor(sar12_trial / 8192) - 2*floor(sar12_trial / 16384))*1.8
let sar12_previous = @VD_B13[pwl]
let sar12_stimulus = vector(8)
let sar12_stimulus[0] = 0
let sar12_stimulus[1] = sar12_previous[length(sar12_previous)-1]
let sar12_stimulus[2] = 4.80009999999999e-05
let sar12_stimulus[3] = sar12_stimulus[1]
let sar12_stimulus[4] = 4.80029999999999e-05
let sar12_stimulus[5] = sar12_drive
let sar12_stimulus[6] = 0.000148
let sar12_stimulus[7] = sar12_stimulus[5]
alter @VD_B13[pwl] = sar12_stimulus
let sar12_drive = (floor(sar12_trial / 16384) - 2*floor(sar12_trial / 32768))*1.8
let sar12_previous = @VD_B14[pwl]
let sar12_stimulus = vector(8)
let sar12_stimulus[0] = 0
let sar12_stimulus[1] = sar12_previous[length(sar12_previous)-1]
let sar12_stimulus[2] = 4.80009999999999e-05
let sar12_stimulus[3] = sar12_stimulus[1]
let sar12_stimulus[4] = 4.80029999999999e-05
let sar12_stimulus[5] = sar12_drive
let sar12_stimulus[6] = 0.000148
let sar12_stimulus[7] = sar12_stimulus[5]
alter @VD_B14[pwl] = sar12_stimulus
let sar12_drive = (floor(sar12_trial / 32768) - 2*floor(sar12_trial / 65536))*1.8
let sar12_previous = @VD_B15[pwl]
let sar12_stimulus = vector(8)
let sar12_stimulus[0] = 0
let sar12_stimulus[1] = sar12_previous[length(sar12_previous)-1]
let sar12_stimulus[2] = 4.80009999999999e-05
let sar12_stimulus[3] = sar12_stimulus[1]
let sar12_stimulus[4] = 4.80029999999999e-05
let sar12_stimulus[5] = sar12_drive
let sar12_stimulus[6] = 0.000148
let sar12_stimulus[7] = sar12_stimulus[5]
alter @VD_B15[pwl] = sar12_stimulus
resume
let sar12_k = length(time)-1
if abs(time[sar12_k] - 4.84999999999999e-05) > 1e-12
print time[sar12_k]
echo expected_pause_time_s 4.84999999999999e-05
echo SAR12_PAUSE_FAILED
quit 1
end
print time[sar12_k] >> pause-times.txt
let sar12_previous = @VD_EVAL[pwl]
let sar12_stimulus = vector(8)
let sar12_stimulus[0] = 0
let sar12_stimulus[1] = sar12_previous[length(sar12_previous)-1]
let sar12_stimulus[2] = 4.85009999999999e-05
let sar12_stimulus[3] = sar12_stimulus[1]
let sar12_stimulus[4] = 4.85029999999999e-05
let sar12_stimulus[5] = 1.8
let sar12_stimulus[6] = 0.000148
let sar12_stimulus[7] = sar12_stimulus[5]
alter @VD_EVAL[pwl] = sar12_stimulus
resume
let sar12_k = length(time)-1
if abs(time[sar12_k] - 4.89999999999999e-05) > 1e-12
print time[sar12_k]
echo expected_pause_time_s 4.89999999999999e-05
echo SAR12_PAUSE_FAILED
quit 1
end
print time[sar12_k] >> pause-times.txt
let sar12_k = length(time)-1
let sar12_cmp = v(COMP)[sar12_k]
let sar12_cmpn = v(COMPN)[sar12_k]
let sar12_p = v(TOPP)[sar12_k]
let sar12_n = v(TOPN)[sar12_k]
let sar12_decision = 0
if sar12_cmp >= 0.9
let sar12_code = sar12_trial
let sar12_decision = 1
end
echo 1 0 $&sar12_trial $&sar12_cmp $&sar12_cmpn $&sar12_p $&sar12_n -1.19998168945312 $&sar12_decision >> decisions.csv
let sar12_previous = @VD_EVAL[pwl]
let sar12_stimulus = vector(8)
let sar12_stimulus[0] = 0
let sar12_stimulus[1] = sar12_previous[length(sar12_previous)-1]
let sar12_stimulus[2] = 4.90009999999999e-05
let sar12_stimulus[3] = sar12_stimulus[1]
let sar12_stimulus[4] = 4.90029999999999e-05
let sar12_stimulus[5] = 0
let sar12_stimulus[6] = 0.000148
let sar12_stimulus[7] = sar12_stimulus[5]
alter @VD_EVAL[pwl] = sar12_stimulus
let sar12_previous = @VINP[pwl]
let sar12_stimulus = vector(8)
let sar12_stimulus[0] = 0
let sar12_stimulus[1] = sar12_previous[length(sar12_previous)-1]
let sar12_stimulus[2] = 4.90009999999999e-05
let sar12_stimulus[3] = sar12_stimulus[1]
let sar12_stimulus[4] = 4.90029999999999e-05
let sar12_stimulus[5] = 0.30002746582
let sar12_stimulus[6] = 0.000148
let sar12_stimulus[7] = sar12_stimulus[5]
alter @VINP[pwl] = sar12_stimulus
let sar12_previous = @VINN[pwl]
let sar12_stimulus = vector(8)
let sar12_stimulus[0] = 0
let sar12_stimulus[1] = sar12_previous[length(sar12_previous)-1]
let sar12_stimulus[2] = 4.90009999999999e-05
let sar12_stimulus[3] = sar12_stimulus[1]
let sar12_stimulus[4] = 4.90029999999999e-05
let sar12_stimulus[5] = 1.49997253418
let sar12_stimulus[6] = 0.000148
let sar12_stimulus[7] = sar12_stimulus[5]
alter @VINN[pwl] = sar12_stimulus
let sar12_previous = @VD_SAMPLE[pwl]
let sar12_stimulus = vector(8)
let sar12_stimulus[0] = 0
let sar12_stimulus[1] = sar12_previous[length(sar12_previous)-1]
let sar12_stimulus[2] = 4.90009999999999e-05
let sar12_stimulus[3] = sar12_stimulus[1]
let sar12_stimulus[4] = 4.90029999999999e-05
let sar12_stimulus[5] = 1.8
let sar12_stimulus[6] = 0.000148
let sar12_stimulus[7] = sar12_stimulus[5]
alter @VD_SAMPLE[pwl] = sar12_stimulus
let sar12_previous = @VD_EVAL[pwl]
let sar12_stimulus = vector(8)
let sar12_stimulus[0] = 0
let sar12_stimulus[1] = sar12_previous[length(sar12_previous)-1]
let sar12_stimulus[2] = 4.90009999999999e-05
let sar12_stimulus[3] = sar12_stimulus[1]
let sar12_stimulus[4] = 4.90029999999999e-05
let sar12_stimulus[5] = 0
let sar12_stimulus[6] = 0.000148
let sar12_stimulus[7] = sar12_stimulus[5]
alter @VD_EVAL[pwl] = sar12_stimulus
let sar12_previous = @VD_B0[pwl]
let sar12_stimulus = vector(8)
let sar12_stimulus[0] = 0
let sar12_stimulus[1] = sar12_previous[length(sar12_previous)-1]
let sar12_stimulus[2] = 4.90009999999999e-05
let sar12_stimulus[3] = sar12_stimulus[1]
let sar12_stimulus[4] = 4.90029999999999e-05
let sar12_stimulus[5] = 0
let sar12_stimulus[6] = 0.000148
let sar12_stimulus[7] = sar12_stimulus[5]
alter @VD_B0[pwl] = sar12_stimulus
let sar12_previous = @VD_B1[pwl]
let sar12_stimulus = vector(8)
let sar12_stimulus[0] = 0
let sar12_stimulus[1] = sar12_previous[length(sar12_previous)-1]
let sar12_stimulus[2] = 4.90009999999999e-05
let sar12_stimulus[3] = sar12_stimulus[1]
let sar12_stimulus[4] = 4.90029999999999e-05
let sar12_stimulus[5] = 0
let sar12_stimulus[6] = 0.000148
let sar12_stimulus[7] = sar12_stimulus[5]
alter @VD_B1[pwl] = sar12_stimulus
let sar12_previous = @VD_B2[pwl]
let sar12_stimulus = vector(8)
let sar12_stimulus[0] = 0
let sar12_stimulus[1] = sar12_previous[length(sar12_previous)-1]
let sar12_stimulus[2] = 4.90009999999999e-05
let sar12_stimulus[3] = sar12_stimulus[1]
let sar12_stimulus[4] = 4.90029999999999e-05
let sar12_stimulus[5] = 0
let sar12_stimulus[6] = 0.000148
let sar12_stimulus[7] = sar12_stimulus[5]
alter @VD_B2[pwl] = sar12_stimulus
let sar12_previous = @VD_B3[pwl]
let sar12_stimulus = vector(8)
let sar12_stimulus[0] = 0
let sar12_stimulus[1] = sar12_previous[length(sar12_previous)-1]
let sar12_stimulus[2] = 4.90009999999999e-05
let sar12_stimulus[3] = sar12_stimulus[1]
let sar12_stimulus[4] = 4.90029999999999e-05
let sar12_stimulus[5] = 0
let sar12_stimulus[6] = 0.000148
let sar12_stimulus[7] = sar12_stimulus[5]
alter @VD_B3[pwl] = sar12_stimulus
let sar12_previous = @VD_B4[pwl]
let sar12_stimulus = vector(8)
let sar12_stimulus[0] = 0
let sar12_stimulus[1] = sar12_previous[length(sar12_previous)-1]
let sar12_stimulus[2] = 4.90009999999999e-05
let sar12_stimulus[3] = sar12_stimulus[1]
let sar12_stimulus[4] = 4.90029999999999e-05
let sar12_stimulus[5] = 0
let sar12_stimulus[6] = 0.000148
let sar12_stimulus[7] = sar12_stimulus[5]
alter @VD_B4[pwl] = sar12_stimulus
let sar12_previous = @VD_B5[pwl]
let sar12_stimulus = vector(8)
let sar12_stimulus[0] = 0
let sar12_stimulus[1] = sar12_previous[length(sar12_previous)-1]
let sar12_stimulus[2] = 4.90009999999999e-05
let sar12_stimulus[3] = sar12_stimulus[1]
let sar12_stimulus[4] = 4.90029999999999e-05
let sar12_stimulus[5] = 0
let sar12_stimulus[6] = 0.000148
let sar12_stimulus[7] = sar12_stimulus[5]
alter @VD_B5[pwl] = sar12_stimulus
let sar12_previous = @VD_B6[pwl]
let sar12_stimulus = vector(8)
let sar12_stimulus[0] = 0
let sar12_stimulus[1] = sar12_previous[length(sar12_previous)-1]
let sar12_stimulus[2] = 4.90009999999999e-05
let sar12_stimulus[3] = sar12_stimulus[1]
let sar12_stimulus[4] = 4.90029999999999e-05
let sar12_stimulus[5] = 0
let sar12_stimulus[6] = 0.000148
let sar12_stimulus[7] = sar12_stimulus[5]
alter @VD_B6[pwl] = sar12_stimulus
let sar12_previous = @VD_B7[pwl]
let sar12_stimulus = vector(8)
let sar12_stimulus[0] = 0
let sar12_stimulus[1] = sar12_previous[length(sar12_previous)-1]
let sar12_stimulus[2] = 4.90009999999999e-05
let sar12_stimulus[3] = sar12_stimulus[1]
let sar12_stimulus[4] = 4.90029999999999e-05
let sar12_stimulus[5] = 0
let sar12_stimulus[6] = 0.000148
let sar12_stimulus[7] = sar12_stimulus[5]
alter @VD_B7[pwl] = sar12_stimulus
let sar12_previous = @VD_B8[pwl]
let sar12_stimulus = vector(8)
let sar12_stimulus[0] = 0
let sar12_stimulus[1] = sar12_previous[length(sar12_previous)-1]
let sar12_stimulus[2] = 4.90009999999999e-05
let sar12_stimulus[3] = sar12_stimulus[1]
let sar12_stimulus[4] = 4.90029999999999e-05
let sar12_stimulus[5] = 0
let sar12_stimulus[6] = 0.000148
let sar12_stimulus[7] = sar12_stimulus[5]
alter @VD_B8[pwl] = sar12_stimulus
let sar12_previous = @VD_B9[pwl]
let sar12_stimulus = vector(8)
let sar12_stimulus[0] = 0
let sar12_stimulus[1] = sar12_previous[length(sar12_previous)-1]
let sar12_stimulus[2] = 4.90009999999999e-05
let sar12_stimulus[3] = sar12_stimulus[1]
let sar12_stimulus[4] = 4.90029999999999e-05
let sar12_stimulus[5] = 0
let sar12_stimulus[6] = 0.000148
let sar12_stimulus[7] = sar12_stimulus[5]
alter @VD_B9[pwl] = sar12_stimulus
let sar12_previous = @VD_B10[pwl]
let sar12_stimulus = vector(8)
let sar12_stimulus[0] = 0
let sar12_stimulus[1] = sar12_previous[length(sar12_previous)-1]
let sar12_stimulus[2] = 4.90009999999999e-05
let sar12_stimulus[3] = sar12_stimulus[1]
let sar12_stimulus[4] = 4.90029999999999e-05
let sar12_stimulus[5] = 0
let sar12_stimulus[6] = 0.000148
let sar12_stimulus[7] = sar12_stimulus[5]
alter @VD_B10[pwl] = sar12_stimulus
let sar12_previous = @VD_B11[pwl]
let sar12_stimulus = vector(8)
let sar12_stimulus[0] = 0
let sar12_stimulus[1] = sar12_previous[length(sar12_previous)-1]
let sar12_stimulus[2] = 4.90009999999999e-05
let sar12_stimulus[3] = sar12_stimulus[1]
let sar12_stimulus[4] = 4.90029999999999e-05
let sar12_stimulus[5] = 0
let sar12_stimulus[6] = 0.000148
let sar12_stimulus[7] = sar12_stimulus[5]
alter @VD_B11[pwl] = sar12_stimulus
let sar12_previous = @VD_B12[pwl]
let sar12_stimulus = vector(8)
let sar12_stimulus[0] = 0
let sar12_stimulus[1] = sar12_previous[length(sar12_previous)-1]
let sar12_stimulus[2] = 4.90009999999999e-05
let sar12_stimulus[3] = sar12_stimulus[1]
let sar12_stimulus[4] = 4.90029999999999e-05
let sar12_stimulus[5] = 0
let sar12_stimulus[6] = 0.000148
let sar12_stimulus[7] = sar12_stimulus[5]
alter @VD_B12[pwl] = sar12_stimulus
let sar12_previous = @VD_B13[pwl]
let sar12_stimulus = vector(8)
let sar12_stimulus[0] = 0
let sar12_stimulus[1] = sar12_previous[length(sar12_previous)-1]
let sar12_stimulus[2] = 4.90009999999999e-05
let sar12_stimulus[3] = sar12_stimulus[1]
let sar12_stimulus[4] = 4.90029999999999e-05
let sar12_stimulus[5] = 0
let sar12_stimulus[6] = 0.000148
let sar12_stimulus[7] = sar12_stimulus[5]
alter @VD_B13[pwl] = sar12_stimulus
let sar12_previous = @VD_B14[pwl]
let sar12_stimulus = vector(8)
let sar12_stimulus[0] = 0
let sar12_stimulus[1] = sar12_previous[length(sar12_previous)-1]
let sar12_stimulus[2] = 4.90009999999999e-05
let sar12_stimulus[3] = sar12_stimulus[1]
let sar12_stimulus[4] = 4.90029999999999e-05
let sar12_stimulus[5] = 0
let sar12_stimulus[6] = 0.000148
let sar12_stimulus[7] = sar12_stimulus[5]
alter @VD_B14[pwl] = sar12_stimulus
let sar12_previous = @VD_B15[pwl]
let sar12_stimulus = vector(8)
let sar12_stimulus[0] = 0
let sar12_stimulus[1] = sar12_previous[length(sar12_previous)-1]
let sar12_stimulus[2] = 4.90009999999999e-05
let sar12_stimulus[3] = sar12_stimulus[1]
let sar12_stimulus[4] = 4.90029999999999e-05
let sar12_stimulus[5] = 0
let sar12_stimulus[6] = 0.000148
let sar12_stimulus[7] = sar12_stimulus[5]
alter @VD_B15[pwl] = sar12_stimulus
let sar12_code = 0
resume
let sar12_k = length(time)-1
if abs(time[sar12_k] - 5.69999999999999e-05) > 1e-12
print time[sar12_k]
echo expected_pause_time_s 5.69999999999999e-05
echo SAR12_PAUSE_FAILED
quit 1
end
print time[sar12_k] >> pause-times.txt
let sar12_previous = @VD_SAMPLE[pwl]
let sar12_stimulus = vector(8)
let sar12_stimulus[0] = 0
let sar12_stimulus[1] = sar12_previous[length(sar12_previous)-1]
let sar12_stimulus[2] = 5.70009999999999e-05
let sar12_stimulus[3] = sar12_stimulus[1]
let sar12_stimulus[4] = 5.70029999999999e-05
let sar12_stimulus[5] = 0
let sar12_stimulus[6] = 0.000148
let sar12_stimulus[7] = sar12_stimulus[5]
alter @VD_SAMPLE[pwl] = sar12_stimulus
resume
let sar12_k = length(time)-1
if abs(time[sar12_k] - 5.74999999999999e-05) > 1e-12
print time[sar12_k]
echo expected_pause_time_s 5.74999999999999e-05
echo SAR12_PAUSE_FAILED
quit 1
end
print time[sar12_k] >> pause-times.txt
let sar12_previous = @VD_EVAL[pwl]
let sar12_stimulus = vector(8)
let sar12_stimulus[0] = 0
let sar12_stimulus[1] = sar12_previous[length(sar12_previous)-1]
let sar12_stimulus[2] = 5.75009999999999e-05
let sar12_stimulus[3] = sar12_stimulus[1]
let sar12_stimulus[4] = 5.75029999999999e-05
let sar12_stimulus[5] = 0
let sar12_stimulus[6] = 0.000148
let sar12_stimulus[7] = sar12_stimulus[5]
alter @VD_EVAL[pwl] = sar12_stimulus
let sar12_trial = sar12_code + 32768
let sar12_drive = (floor(sar12_trial / 1) - 2*floor(sar12_trial / 2))*1.8
let sar12_previous = @VD_B0[pwl]
let sar12_stimulus = vector(8)
let sar12_stimulus[0] = 0
let sar12_stimulus[1] = sar12_previous[length(sar12_previous)-1]
let sar12_stimulus[2] = 5.75009999999999e-05
let sar12_stimulus[3] = sar12_stimulus[1]
let sar12_stimulus[4] = 5.75029999999999e-05
let sar12_stimulus[5] = sar12_drive
let sar12_stimulus[6] = 0.000148
let sar12_stimulus[7] = sar12_stimulus[5]
alter @VD_B0[pwl] = sar12_stimulus
let sar12_drive = (floor(sar12_trial / 2) - 2*floor(sar12_trial / 4))*1.8
let sar12_previous = @VD_B1[pwl]
let sar12_stimulus = vector(8)
let sar12_stimulus[0] = 0
let sar12_stimulus[1] = sar12_previous[length(sar12_previous)-1]
let sar12_stimulus[2] = 5.75009999999999e-05
let sar12_stimulus[3] = sar12_stimulus[1]
let sar12_stimulus[4] = 5.75029999999999e-05
let sar12_stimulus[5] = sar12_drive
let sar12_stimulus[6] = 0.000148
let sar12_stimulus[7] = sar12_stimulus[5]
alter @VD_B1[pwl] = sar12_stimulus
let sar12_drive = (floor(sar12_trial / 4) - 2*floor(sar12_trial / 8))*1.8
let sar12_previous = @VD_B2[pwl]
let sar12_stimulus = vector(8)
let sar12_stimulus[0] = 0
let sar12_stimulus[1] = sar12_previous[length(sar12_previous)-1]
let sar12_stimulus[2] = 5.75009999999999e-05
let sar12_stimulus[3] = sar12_stimulus[1]
let sar12_stimulus[4] = 5.75029999999999e-05
let sar12_stimulus[5] = sar12_drive
let sar12_stimulus[6] = 0.000148
let sar12_stimulus[7] = sar12_stimulus[5]
alter @VD_B2[pwl] = sar12_stimulus
let sar12_drive = (floor(sar12_trial / 8) - 2*floor(sar12_trial / 16))*1.8
let sar12_previous = @VD_B3[pwl]
let sar12_stimulus = vector(8)
let sar12_stimulus[0] = 0
let sar12_stimulus[1] = sar12_previous[length(sar12_previous)-1]
let sar12_stimulus[2] = 5.75009999999999e-05
let sar12_stimulus[3] = sar12_stimulus[1]
let sar12_stimulus[4] = 5.75029999999999e-05
let sar12_stimulus[5] = sar12_drive
let sar12_stimulus[6] = 0.000148
let sar12_stimulus[7] = sar12_stimulus[5]
alter @VD_B3[pwl] = sar12_stimulus
let sar12_drive = (floor(sar12_trial / 16) - 2*floor(sar12_trial / 32))*1.8
let sar12_previous = @VD_B4[pwl]
let sar12_stimulus = vector(8)
let sar12_stimulus[0] = 0
let sar12_stimulus[1] = sar12_previous[length(sar12_previous)-1]
let sar12_stimulus[2] = 5.75009999999999e-05
let sar12_stimulus[3] = sar12_stimulus[1]
let sar12_stimulus[4] = 5.75029999999999e-05
let sar12_stimulus[5] = sar12_drive
let sar12_stimulus[6] = 0.000148
let sar12_stimulus[7] = sar12_stimulus[5]
alter @VD_B4[pwl] = sar12_stimulus
let sar12_drive = (floor(sar12_trial / 32) - 2*floor(sar12_trial / 64))*1.8
let sar12_previous = @VD_B5[pwl]
let sar12_stimulus = vector(8)
let sar12_stimulus[0] = 0
let sar12_stimulus[1] = sar12_previous[length(sar12_previous)-1]
let sar12_stimulus[2] = 5.75009999999999e-05
let sar12_stimulus[3] = sar12_stimulus[1]
let sar12_stimulus[4] = 5.75029999999999e-05
let sar12_stimulus[5] = sar12_drive
let sar12_stimulus[6] = 0.000148
let sar12_stimulus[7] = sar12_stimulus[5]
alter @VD_B5[pwl] = sar12_stimulus
let sar12_drive = (floor(sar12_trial / 64) - 2*floor(sar12_trial / 128))*1.8
let sar12_previous = @VD_B6[pwl]
let sar12_stimulus = vector(8)
let sar12_stimulus[0] = 0
let sar12_stimulus[1] = sar12_previous[length(sar12_previous)-1]
let sar12_stimulus[2] = 5.75009999999999e-05
let sar12_stimulus[3] = sar12_stimulus[1]
let sar12_stimulus[4] = 5.75029999999999e-05
let sar12_stimulus[5] = sar12_drive
let sar12_stimulus[6] = 0.000148
let sar12_stimulus[7] = sar12_stimulus[5]
alter @VD_B6[pwl] = sar12_stimulus
let sar12_drive = (floor(sar12_trial / 128) - 2*floor(sar12_trial / 256))*1.8
let sar12_previous = @VD_B7[pwl]
let sar12_stimulus = vector(8)
let sar12_stimulus[0] = 0
let sar12_stimulus[1] = sar12_previous[length(sar12_previous)-1]
let sar12_stimulus[2] = 5.75009999999999e-05
let sar12_stimulus[3] = sar12_stimulus[1]
let sar12_stimulus[4] = 5.75029999999999e-05
let sar12_stimulus[5] = sar12_drive
let sar12_stimulus[6] = 0.000148
let sar12_stimulus[7] = sar12_stimulus[5]
alter @VD_B7[pwl] = sar12_stimulus
let sar12_drive = (floor(sar12_trial / 256) - 2*floor(sar12_trial / 512))*1.8
let sar12_previous = @VD_B8[pwl]
let sar12_stimulus = vector(8)
let sar12_stimulus[0] = 0
let sar12_stimulus[1] = sar12_previous[length(sar12_previous)-1]
let sar12_stimulus[2] = 5.75009999999999e-05
let sar12_stimulus[3] = sar12_stimulus[1]
let sar12_stimulus[4] = 5.75029999999999e-05
let sar12_stimulus[5] = sar12_drive
let sar12_stimulus[6] = 0.000148
let sar12_stimulus[7] = sar12_stimulus[5]
alter @VD_B8[pwl] = sar12_stimulus
let sar12_drive = (floor(sar12_trial / 512) - 2*floor(sar12_trial / 1024))*1.8
let sar12_previous = @VD_B9[pwl]
let sar12_stimulus = vector(8)
let sar12_stimulus[0] = 0
let sar12_stimulus[1] = sar12_previous[length(sar12_previous)-1]
let sar12_stimulus[2] = 5.75009999999999e-05
let sar12_stimulus[3] = sar12_stimulus[1]
let sar12_stimulus[4] = 5.75029999999999e-05
let sar12_stimulus[5] = sar12_drive
let sar12_stimulus[6] = 0.000148
let sar12_stimulus[7] = sar12_stimulus[5]
alter @VD_B9[pwl] = sar12_stimulus
let sar12_drive = (floor(sar12_trial / 1024) - 2*floor(sar12_trial / 2048))*1.8
let sar12_previous = @VD_B10[pwl]
let sar12_stimulus = vector(8)
let sar12_stimulus[0] = 0
let sar12_stimulus[1] = sar12_previous[length(sar12_previous)-1]
let sar12_stimulus[2] = 5.75009999999999e-05
let sar12_stimulus[3] = sar12_stimulus[1]
let sar12_stimulus[4] = 5.75029999999999e-05
let sar12_stimulus[5] = sar12_drive
let sar12_stimulus[6] = 0.000148
let sar12_stimulus[7] = sar12_stimulus[5]
alter @VD_B10[pwl] = sar12_stimulus
let sar12_drive = (floor(sar12_trial / 2048) - 2*floor(sar12_trial / 4096))*1.8
let sar12_previous = @VD_B11[pwl]
let sar12_stimulus = vector(8)
let sar12_stimulus[0] = 0
let sar12_stimulus[1] = sar12_previous[length(sar12_previous)-1]
let sar12_stimulus[2] = 5.75009999999999e-05
let sar12_stimulus[3] = sar12_stimulus[1]
let sar12_stimulus[4] = 5.75029999999999e-05
let sar12_stimulus[5] = sar12_drive
let sar12_stimulus[6] = 0.000148
let sar12_stimulus[7] = sar12_stimulus[5]
alter @VD_B11[pwl] = sar12_stimulus
let sar12_drive = (floor(sar12_trial / 4096) - 2*floor(sar12_trial / 8192))*1.8
let sar12_previous = @VD_B12[pwl]
let sar12_stimulus = vector(8)
let sar12_stimulus[0] = 0
let sar12_stimulus[1] = sar12_previous[length(sar12_previous)-1]
let sar12_stimulus[2] = 5.75009999999999e-05
let sar12_stimulus[3] = sar12_stimulus[1]
let sar12_stimulus[4] = 5.75029999999999e-05
let sar12_stimulus[5] = sar12_drive
let sar12_stimulus[6] = 0.000148
let sar12_stimulus[7] = sar12_stimulus[5]
alter @VD_B12[pwl] = sar12_stimulus
let sar12_drive = (floor(sar12_trial / 8192) - 2*floor(sar12_trial / 16384))*1.8
let sar12_previous = @VD_B13[pwl]
let sar12_stimulus = vector(8)
let sar12_stimulus[0] = 0
let sar12_stimulus[1] = sar12_previous[length(sar12_previous)-1]
let sar12_stimulus[2] = 5.75009999999999e-05
let sar12_stimulus[3] = sar12_stimulus[1]
let sar12_stimulus[4] = 5.75029999999999e-05
let sar12_stimulus[5] = sar12_drive
let sar12_stimulus[6] = 0.000148
let sar12_stimulus[7] = sar12_stimulus[5]
alter @VD_B13[pwl] = sar12_stimulus
let sar12_drive = (floor(sar12_trial / 16384) - 2*floor(sar12_trial / 32768))*1.8
let sar12_previous = @VD_B14[pwl]
let sar12_stimulus = vector(8)
let sar12_stimulus[0] = 0
let sar12_stimulus[1] = sar12_previous[length(sar12_previous)-1]
let sar12_stimulus[2] = 5.75009999999999e-05
let sar12_stimulus[3] = sar12_stimulus[1]
let sar12_stimulus[4] = 5.75029999999999e-05
let sar12_stimulus[5] = sar12_drive
let sar12_stimulus[6] = 0.000148
let sar12_stimulus[7] = sar12_stimulus[5]
alter @VD_B14[pwl] = sar12_stimulus
let sar12_drive = (floor(sar12_trial / 32768) - 2*floor(sar12_trial / 65536))*1.8
let sar12_previous = @VD_B15[pwl]
let sar12_stimulus = vector(8)
let sar12_stimulus[0] = 0
let sar12_stimulus[1] = sar12_previous[length(sar12_previous)-1]
let sar12_stimulus[2] = 5.75009999999999e-05
let sar12_stimulus[3] = sar12_stimulus[1]
let sar12_stimulus[4] = 5.75029999999999e-05
let sar12_stimulus[5] = sar12_drive
let sar12_stimulus[6] = 0.000148
let sar12_stimulus[7] = sar12_stimulus[5]
alter @VD_B15[pwl] = sar12_stimulus
resume
let sar12_k = length(time)-1
if abs(time[sar12_k] - 5.79999999999999e-05) > 1e-12
print time[sar12_k]
echo expected_pause_time_s 5.79999999999999e-05
echo SAR12_PAUSE_FAILED
quit 1
end
print time[sar12_k] >> pause-times.txt
let sar12_previous = @VD_EVAL[pwl]
let sar12_stimulus = vector(8)
let sar12_stimulus[0] = 0
let sar12_stimulus[1] = sar12_previous[length(sar12_previous)-1]
let sar12_stimulus[2] = 5.80009999999999e-05
let sar12_stimulus[3] = sar12_stimulus[1]
let sar12_stimulus[4] = 5.80029999999999e-05
let sar12_stimulus[5] = 1.8
let sar12_stimulus[6] = 0.000148
let sar12_stimulus[7] = sar12_stimulus[5]
alter @VD_EVAL[pwl] = sar12_stimulus
resume
let sar12_k = length(time)-1
if abs(time[sar12_k] - 5.84999999999999e-05) > 1e-12
print time[sar12_k]
echo expected_pause_time_s 5.84999999999999e-05
echo SAR12_PAUSE_FAILED
quit 1
end
print time[sar12_k] >> pause-times.txt
let sar12_k = length(time)-1
let sar12_cmp = v(COMP)[sar12_k]
let sar12_cmpn = v(COMPN)[sar12_k]
let sar12_p = v(TOPP)[sar12_k]
let sar12_n = v(TOPN)[sar12_k]
let sar12_decision = 0
if sar12_cmp >= 0.9
let sar12_code = sar12_trial
let sar12_decision = 1
end
echo 2 15 $&sar12_trial $&sar12_cmp $&sar12_cmpn $&sar12_p $&sar12_n -1.19994506835937 $&sar12_decision >> decisions.csv
let sar12_previous = @VD_EVAL[pwl]
let sar12_stimulus = vector(8)
let sar12_stimulus[0] = 0
let sar12_stimulus[1] = sar12_previous[length(sar12_previous)-1]
let sar12_stimulus[2] = 5.85009999999999e-05
let sar12_stimulus[3] = sar12_stimulus[1]
let sar12_stimulus[4] = 5.85029999999999e-05
let sar12_stimulus[5] = 0
let sar12_stimulus[6] = 0.000148
let sar12_stimulus[7] = sar12_stimulus[5]
alter @VD_EVAL[pwl] = sar12_stimulus
let sar12_trial = sar12_code + 16384
let sar12_drive = (floor(sar12_trial / 1) - 2*floor(sar12_trial / 2))*1.8
let sar12_previous = @VD_B0[pwl]
let sar12_stimulus = vector(8)
let sar12_stimulus[0] = 0
let sar12_stimulus[1] = sar12_previous[length(sar12_previous)-1]
let sar12_stimulus[2] = 5.85009999999999e-05
let sar12_stimulus[3] = sar12_stimulus[1]
let sar12_stimulus[4] = 5.85029999999999e-05
let sar12_stimulus[5] = sar12_drive
let sar12_stimulus[6] = 0.000148
let sar12_stimulus[7] = sar12_stimulus[5]
alter @VD_B0[pwl] = sar12_stimulus
let sar12_drive = (floor(sar12_trial / 2) - 2*floor(sar12_trial / 4))*1.8
let sar12_previous = @VD_B1[pwl]
let sar12_stimulus = vector(8)
let sar12_stimulus[0] = 0
let sar12_stimulus[1] = sar12_previous[length(sar12_previous)-1]
let sar12_stimulus[2] = 5.85009999999999e-05
let sar12_stimulus[3] = sar12_stimulus[1]
let sar12_stimulus[4] = 5.85029999999999e-05
let sar12_stimulus[5] = sar12_drive
let sar12_stimulus[6] = 0.000148
let sar12_stimulus[7] = sar12_stimulus[5]
alter @VD_B1[pwl] = sar12_stimulus
let sar12_drive = (floor(sar12_trial / 4) - 2*floor(sar12_trial / 8))*1.8
let sar12_previous = @VD_B2[pwl]
let sar12_stimulus = vector(8)
let sar12_stimulus[0] = 0
let sar12_stimulus[1] = sar12_previous[length(sar12_previous)-1]
let sar12_stimulus[2] = 5.85009999999999e-05
let sar12_stimulus[3] = sar12_stimulus[1]
let sar12_stimulus[4] = 5.85029999999999e-05
let sar12_stimulus[5] = sar12_drive
let sar12_stimulus[6] = 0.000148
let sar12_stimulus[7] = sar12_stimulus[5]
alter @VD_B2[pwl] = sar12_stimulus
let sar12_drive = (floor(sar12_trial / 8) - 2*floor(sar12_trial / 16))*1.8
let sar12_previous = @VD_B3[pwl]
let sar12_stimulus = vector(8)
let sar12_stimulus[0] = 0
let sar12_stimulus[1] = sar12_previous[length(sar12_previous)-1]
let sar12_stimulus[2] = 5.85009999999999e-05
let sar12_stimulus[3] = sar12_stimulus[1]
let sar12_stimulus[4] = 5.85029999999999e-05
let sar12_stimulus[5] = sar12_drive
let sar12_stimulus[6] = 0.000148
let sar12_stimulus[7] = sar12_stimulus[5]
alter @VD_B3[pwl] = sar12_stimulus
let sar12_drive = (floor(sar12_trial / 16) - 2*floor(sar12_trial / 32))*1.8
let sar12_previous = @VD_B4[pwl]
let sar12_stimulus = vector(8)
let sar12_stimulus[0] = 0
let sar12_stimulus[1] = sar12_previous[length(sar12_previous)-1]
let sar12_stimulus[2] = 5.85009999999999e-05
let sar12_stimulus[3] = sar12_stimulus[1]
let sar12_stimulus[4] = 5.85029999999999e-05
let sar12_stimulus[5] = sar12_drive
let sar12_stimulus[6] = 0.000148
let sar12_stimulus[7] = sar12_stimulus[5]
alter @VD_B4[pwl] = sar12_stimulus
let sar12_drive = (floor(sar12_trial / 32) - 2*floor(sar12_trial / 64))*1.8
let sar12_previous = @VD_B5[pwl]
let sar12_stimulus = vector(8)
let sar12_stimulus[0] = 0
let sar12_stimulus[1] = sar12_previous[length(sar12_previous)-1]
let sar12_stimulus[2] = 5.85009999999999e-05
let sar12_stimulus[3] = sar12_stimulus[1]
let sar12_stimulus[4] = 5.85029999999999e-05
let sar12_stimulus[5] = sar12_drive
let sar12_stimulus[6] = 0.000148
let sar12_stimulus[7] = sar12_stimulus[5]
alter @VD_B5[pwl] = sar12_stimulus
let sar12_drive = (floor(sar12_trial / 64) - 2*floor(sar12_trial / 128))*1.8
let sar12_previous = @VD_B6[pwl]
let sar12_stimulus = vector(8)
let sar12_stimulus[0] = 0
let sar12_stimulus[1] = sar12_previous[length(sar12_previous)-1]
let sar12_stimulus[2] = 5.85009999999999e-05
let sar12_stimulus[3] = sar12_stimulus[1]
let sar12_stimulus[4] = 5.85029999999999e-05
let sar12_stimulus[5] = sar12_drive
let sar12_stimulus[6] = 0.000148
let sar12_stimulus[7] = sar12_stimulus[5]
alter @VD_B6[pwl] = sar12_stimulus
let sar12_drive = (floor(sar12_trial / 128) - 2*floor(sar12_trial / 256))*1.8
let sar12_previous = @VD_B7[pwl]
let sar12_stimulus = vector(8)
let sar12_stimulus[0] = 0
let sar12_stimulus[1] = sar12_previous[length(sar12_previous)-1]
let sar12_stimulus[2] = 5.85009999999999e-05
let sar12_stimulus[3] = sar12_stimulus[1]
let sar12_stimulus[4] = 5.85029999999999e-05
let sar12_stimulus[5] = sar12_drive
let sar12_stimulus[6] = 0.000148
let sar12_stimulus[7] = sar12_stimulus[5]
alter @VD_B7[pwl] = sar12_stimulus
let sar12_drive = (floor(sar12_trial / 256) - 2*floor(sar12_trial / 512))*1.8
let sar12_previous = @VD_B8[pwl]
let sar12_stimulus = vector(8)
let sar12_stimulus[0] = 0
let sar12_stimulus[1] = sar12_previous[length(sar12_previous)-1]
let sar12_stimulus[2] = 5.85009999999999e-05
let sar12_stimulus[3] = sar12_stimulus[1]
let sar12_stimulus[4] = 5.85029999999999e-05
let sar12_stimulus[5] = sar12_drive
let sar12_stimulus[6] = 0.000148
let sar12_stimulus[7] = sar12_stimulus[5]
alter @VD_B8[pwl] = sar12_stimulus
let sar12_drive = (floor(sar12_trial / 512) - 2*floor(sar12_trial / 1024))*1.8
let sar12_previous = @VD_B9[pwl]
let sar12_stimulus = vector(8)
let sar12_stimulus[0] = 0
let sar12_stimulus[1] = sar12_previous[length(sar12_previous)-1]
let sar12_stimulus[2] = 5.85009999999999e-05
let sar12_stimulus[3] = sar12_stimulus[1]
let sar12_stimulus[4] = 5.85029999999999e-05
let sar12_stimulus[5] = sar12_drive
let sar12_stimulus[6] = 0.000148
let sar12_stimulus[7] = sar12_stimulus[5]
alter @VD_B9[pwl] = sar12_stimulus
let sar12_drive = (floor(sar12_trial / 1024) - 2*floor(sar12_trial / 2048))*1.8
let sar12_previous = @VD_B10[pwl]
let sar12_stimulus = vector(8)
let sar12_stimulus[0] = 0
let sar12_stimulus[1] = sar12_previous[length(sar12_previous)-1]
let sar12_stimulus[2] = 5.85009999999999e-05
let sar12_stimulus[3] = sar12_stimulus[1]
let sar12_stimulus[4] = 5.85029999999999e-05
let sar12_stimulus[5] = sar12_drive
let sar12_stimulus[6] = 0.000148
let sar12_stimulus[7] = sar12_stimulus[5]
alter @VD_B10[pwl] = sar12_stimulus
let sar12_drive = (floor(sar12_trial / 2048) - 2*floor(sar12_trial / 4096))*1.8
let sar12_previous = @VD_B11[pwl]
let sar12_stimulus = vector(8)
let sar12_stimulus[0] = 0
let sar12_stimulus[1] = sar12_previous[length(sar12_previous)-1]
let sar12_stimulus[2] = 5.85009999999999e-05
let sar12_stimulus[3] = sar12_stimulus[1]
let sar12_stimulus[4] = 5.85029999999999e-05
let sar12_stimulus[5] = sar12_drive
let sar12_stimulus[6] = 0.000148
let sar12_stimulus[7] = sar12_stimulus[5]
alter @VD_B11[pwl] = sar12_stimulus
let sar12_drive = (floor(sar12_trial / 4096) - 2*floor(sar12_trial / 8192))*1.8
let sar12_previous = @VD_B12[pwl]
let sar12_stimulus = vector(8)
let sar12_stimulus[0] = 0
let sar12_stimulus[1] = sar12_previous[length(sar12_previous)-1]
let sar12_stimulus[2] = 5.85009999999999e-05
let sar12_stimulus[3] = sar12_stimulus[1]
let sar12_stimulus[4] = 5.85029999999999e-05
let sar12_stimulus[5] = sar12_drive
let sar12_stimulus[6] = 0.000148
let sar12_stimulus[7] = sar12_stimulus[5]
alter @VD_B12[pwl] = sar12_stimulus
let sar12_drive = (floor(sar12_trial / 8192) - 2*floor(sar12_trial / 16384))*1.8
let sar12_previous = @VD_B13[pwl]
let sar12_stimulus = vector(8)
let sar12_stimulus[0] = 0
let sar12_stimulus[1] = sar12_previous[length(sar12_previous)-1]
let sar12_stimulus[2] = 5.85009999999999e-05
let sar12_stimulus[3] = sar12_stimulus[1]
let sar12_stimulus[4] = 5.85029999999999e-05
let sar12_stimulus[5] = sar12_drive
let sar12_stimulus[6] = 0.000148
let sar12_stimulus[7] = sar12_stimulus[5]
alter @VD_B13[pwl] = sar12_stimulus
let sar12_drive = (floor(sar12_trial / 16384) - 2*floor(sar12_trial / 32768))*1.8
let sar12_previous = @VD_B14[pwl]
let sar12_stimulus = vector(8)
let sar12_stimulus[0] = 0
let sar12_stimulus[1] = sar12_previous[length(sar12_previous)-1]
let sar12_stimulus[2] = 5.85009999999999e-05
let sar12_stimulus[3] = sar12_stimulus[1]
let sar12_stimulus[4] = 5.85029999999999e-05
let sar12_stimulus[5] = sar12_drive
let sar12_stimulus[6] = 0.000148
let sar12_stimulus[7] = sar12_stimulus[5]
alter @VD_B14[pwl] = sar12_stimulus
let sar12_drive = (floor(sar12_trial / 32768) - 2*floor(sar12_trial / 65536))*1.8
let sar12_previous = @VD_B15[pwl]
let sar12_stimulus = vector(8)
let sar12_stimulus[0] = 0
let sar12_stimulus[1] = sar12_previous[length(sar12_previous)-1]
let sar12_stimulus[2] = 5.85009999999999e-05
let sar12_stimulus[3] = sar12_stimulus[1]
let sar12_stimulus[4] = 5.85029999999999e-05
let sar12_stimulus[5] = sar12_drive
let sar12_stimulus[6] = 0.000148
let sar12_stimulus[7] = sar12_stimulus[5]
alter @VD_B15[pwl] = sar12_stimulus
resume
let sar12_k = length(time)-1
if abs(time[sar12_k] - 5.89999999999999e-05) > 1e-12
print time[sar12_k]
echo expected_pause_time_s 5.89999999999999e-05
echo SAR12_PAUSE_FAILED
quit 1
end
print time[sar12_k] >> pause-times.txt
let sar12_previous = @VD_EVAL[pwl]
let sar12_stimulus = vector(8)
let sar12_stimulus[0] = 0
let sar12_stimulus[1] = sar12_previous[length(sar12_previous)-1]
let sar12_stimulus[2] = 5.90009999999999e-05
let sar12_stimulus[3] = sar12_stimulus[1]
let sar12_stimulus[4] = 5.90029999999999e-05
let sar12_stimulus[5] = 1.8
let sar12_stimulus[6] = 0.000148
let sar12_stimulus[7] = sar12_stimulus[5]
alter @VD_EVAL[pwl] = sar12_stimulus
resume
let sar12_k = length(time)-1
if abs(time[sar12_k] - 5.94999999999999e-05) > 1e-12
print time[sar12_k]
echo expected_pause_time_s 5.94999999999999e-05
echo SAR12_PAUSE_FAILED
quit 1
end
print time[sar12_k] >> pause-times.txt
let sar12_k = length(time)-1
let sar12_cmp = v(COMP)[sar12_k]
let sar12_cmpn = v(COMPN)[sar12_k]
let sar12_p = v(TOPP)[sar12_k]
let sar12_n = v(TOPN)[sar12_k]
let sar12_decision = 0
if sar12_cmp >= 0.9
let sar12_code = sar12_trial
let sar12_decision = 1
end
echo 2 14 $&sar12_trial $&sar12_cmp $&sar12_cmpn $&sar12_p $&sar12_n -1.19994506835937 $&sar12_decision >> decisions.csv
let sar12_previous = @VD_EVAL[pwl]
let sar12_stimulus = vector(8)
let sar12_stimulus[0] = 0
let sar12_stimulus[1] = sar12_previous[length(sar12_previous)-1]
let sar12_stimulus[2] = 5.95009999999999e-05
let sar12_stimulus[3] = sar12_stimulus[1]
let sar12_stimulus[4] = 5.95029999999999e-05
let sar12_stimulus[5] = 0
let sar12_stimulus[6] = 0.000148
let sar12_stimulus[7] = sar12_stimulus[5]
alter @VD_EVAL[pwl] = sar12_stimulus
let sar12_trial = sar12_code + 8192
let sar12_drive = (floor(sar12_trial / 1) - 2*floor(sar12_trial / 2))*1.8
let sar12_previous = @VD_B0[pwl]
let sar12_stimulus = vector(8)
let sar12_stimulus[0] = 0
let sar12_stimulus[1] = sar12_previous[length(sar12_previous)-1]
let sar12_stimulus[2] = 5.95009999999999e-05
let sar12_stimulus[3] = sar12_stimulus[1]
let sar12_stimulus[4] = 5.95029999999999e-05
let sar12_stimulus[5] = sar12_drive
let sar12_stimulus[6] = 0.000148
let sar12_stimulus[7] = sar12_stimulus[5]
alter @VD_B0[pwl] = sar12_stimulus
let sar12_drive = (floor(sar12_trial / 2) - 2*floor(sar12_trial / 4))*1.8
let sar12_previous = @VD_B1[pwl]
let sar12_stimulus = vector(8)
let sar12_stimulus[0] = 0
let sar12_stimulus[1] = sar12_previous[length(sar12_previous)-1]
let sar12_stimulus[2] = 5.95009999999999e-05
let sar12_stimulus[3] = sar12_stimulus[1]
let sar12_stimulus[4] = 5.95029999999999e-05
let sar12_stimulus[5] = sar12_drive
let sar12_stimulus[6] = 0.000148
let sar12_stimulus[7] = sar12_stimulus[5]
alter @VD_B1[pwl] = sar12_stimulus
let sar12_drive = (floor(sar12_trial / 4) - 2*floor(sar12_trial / 8))*1.8
let sar12_previous = @VD_B2[pwl]
let sar12_stimulus = vector(8)
let sar12_stimulus[0] = 0
let sar12_stimulus[1] = sar12_previous[length(sar12_previous)-1]
let sar12_stimulus[2] = 5.95009999999999e-05
let sar12_stimulus[3] = sar12_stimulus[1]
let sar12_stimulus[4] = 5.95029999999999e-05
let sar12_stimulus[5] = sar12_drive
let sar12_stimulus[6] = 0.000148
let sar12_stimulus[7] = sar12_stimulus[5]
alter @VD_B2[pwl] = sar12_stimulus
let sar12_drive = (floor(sar12_trial / 8) - 2*floor(sar12_trial / 16))*1.8
let sar12_previous = @VD_B3[pwl]
let sar12_stimulus = vector(8)
let sar12_stimulus[0] = 0
let sar12_stimulus[1] = sar12_previous[length(sar12_previous)-1]
let sar12_stimulus[2] = 5.95009999999999e-05
let sar12_stimulus[3] = sar12_stimulus[1]
let sar12_stimulus[4] = 5.95029999999999e-05
let sar12_stimulus[5] = sar12_drive
let sar12_stimulus[6] = 0.000148
let sar12_stimulus[7] = sar12_stimulus[5]
alter @VD_B3[pwl] = sar12_stimulus
let sar12_drive = (floor(sar12_trial / 16) - 2*floor(sar12_trial / 32))*1.8
let sar12_previous = @VD_B4[pwl]
let sar12_stimulus = vector(8)
let sar12_stimulus[0] = 0
let sar12_stimulus[1] = sar12_previous[length(sar12_previous)-1]
let sar12_stimulus[2] = 5.95009999999999e-05
let sar12_stimulus[3] = sar12_stimulus[1]
let sar12_stimulus[4] = 5.95029999999999e-05
let sar12_stimulus[5] = sar12_drive
let sar12_stimulus[6] = 0.000148
let sar12_stimulus[7] = sar12_stimulus[5]
alter @VD_B4[pwl] = sar12_stimulus
let sar12_drive = (floor(sar12_trial / 32) - 2*floor(sar12_trial / 64))*1.8
let sar12_previous = @VD_B5[pwl]
let sar12_stimulus = vector(8)
let sar12_stimulus[0] = 0
let sar12_stimulus[1] = sar12_previous[length(sar12_previous)-1]
let sar12_stimulus[2] = 5.95009999999999e-05
let sar12_stimulus[3] = sar12_stimulus[1]
let sar12_stimulus[4] = 5.95029999999999e-05
let sar12_stimulus[5] = sar12_drive
let sar12_stimulus[6] = 0.000148
let sar12_stimulus[7] = sar12_stimulus[5]
alter @VD_B5[pwl] = sar12_stimulus
let sar12_drive = (floor(sar12_trial / 64) - 2*floor(sar12_trial / 128))*1.8
let sar12_previous = @VD_B6[pwl]
let sar12_stimulus = vector(8)
let sar12_stimulus[0] = 0
let sar12_stimulus[1] = sar12_previous[length(sar12_previous)-1]
let sar12_stimulus[2] = 5.95009999999999e-05
let sar12_stimulus[3] = sar12_stimulus[1]
let sar12_stimulus[4] = 5.95029999999999e-05
let sar12_stimulus[5] = sar12_drive
let sar12_stimulus[6] = 0.000148
let sar12_stimulus[7] = sar12_stimulus[5]
alter @VD_B6[pwl] = sar12_stimulus
let sar12_drive = (floor(sar12_trial / 128) - 2*floor(sar12_trial / 256))*1.8
let sar12_previous = @VD_B7[pwl]
let sar12_stimulus = vector(8)
let sar12_stimulus[0] = 0
let sar12_stimulus[1] = sar12_previous[length(sar12_previous)-1]
let sar12_stimulus[2] = 5.95009999999999e-05
let sar12_stimulus[3] = sar12_stimulus[1]
let sar12_stimulus[4] = 5.95029999999999e-05
let sar12_stimulus[5] = sar12_drive
let sar12_stimulus[6] = 0.000148
let sar12_stimulus[7] = sar12_stimulus[5]
alter @VD_B7[pwl] = sar12_stimulus
let sar12_drive = (floor(sar12_trial / 256) - 2*floor(sar12_trial / 512))*1.8
let sar12_previous = @VD_B8[pwl]
let sar12_stimulus = vector(8)
let sar12_stimulus[0] = 0
let sar12_stimulus[1] = sar12_previous[length(sar12_previous)-1]
let sar12_stimulus[2] = 5.95009999999999e-05
let sar12_stimulus[3] = sar12_stimulus[1]
let sar12_stimulus[4] = 5.95029999999999e-05
let sar12_stimulus[5] = sar12_drive
let sar12_stimulus[6] = 0.000148
let sar12_stimulus[7] = sar12_stimulus[5]
alter @VD_B8[pwl] = sar12_stimulus
let sar12_drive = (floor(sar12_trial / 512) - 2*floor(sar12_trial / 1024))*1.8
let sar12_previous = @VD_B9[pwl]
let sar12_stimulus = vector(8)
let sar12_stimulus[0] = 0
let sar12_stimulus[1] = sar12_previous[length(sar12_previous)-1]
let sar12_stimulus[2] = 5.95009999999999e-05
let sar12_stimulus[3] = sar12_stimulus[1]
let sar12_stimulus[4] = 5.95029999999999e-05
let sar12_stimulus[5] = sar12_drive
let sar12_stimulus[6] = 0.000148
let sar12_stimulus[7] = sar12_stimulus[5]
alter @VD_B9[pwl] = sar12_stimulus
let sar12_drive = (floor(sar12_trial / 1024) - 2*floor(sar12_trial / 2048))*1.8
let sar12_previous = @VD_B10[pwl]
let sar12_stimulus = vector(8)
let sar12_stimulus[0] = 0
let sar12_stimulus[1] = sar12_previous[length(sar12_previous)-1]
let sar12_stimulus[2] = 5.95009999999999e-05
let sar12_stimulus[3] = sar12_stimulus[1]
let sar12_stimulus[4] = 5.95029999999999e-05
let sar12_stimulus[5] = sar12_drive
let sar12_stimulus[6] = 0.000148
let sar12_stimulus[7] = sar12_stimulus[5]
alter @VD_B10[pwl] = sar12_stimulus
let sar12_drive = (floor(sar12_trial / 2048) - 2*floor(sar12_trial / 4096))*1.8
let sar12_previous = @VD_B11[pwl]
let sar12_stimulus = vector(8)
let sar12_stimulus[0] = 0
let sar12_stimulus[1] = sar12_previous[length(sar12_previous)-1]
let sar12_stimulus[2] = 5.95009999999999e-05
let sar12_stimulus[3] = sar12_stimulus[1]
let sar12_stimulus[4] = 5.95029999999999e-05
let sar12_stimulus[5] = sar12_drive
let sar12_stimulus[6] = 0.000148
let sar12_stimulus[7] = sar12_stimulus[5]
alter @VD_B11[pwl] = sar12_stimulus
let sar12_drive = (floor(sar12_trial / 4096) - 2*floor(sar12_trial / 8192))*1.8
let sar12_previous = @VD_B12[pwl]
let sar12_stimulus = vector(8)
let sar12_stimulus[0] = 0
let sar12_stimulus[1] = sar12_previous[length(sar12_previous)-1]
let sar12_stimulus[2] = 5.95009999999999e-05
let sar12_stimulus[3] = sar12_stimulus[1]
let sar12_stimulus[4] = 5.95029999999999e-05
let sar12_stimulus[5] = sar12_drive
let sar12_stimulus[6] = 0.000148
let sar12_stimulus[7] = sar12_stimulus[5]
alter @VD_B12[pwl] = sar12_stimulus
let sar12_drive = (floor(sar12_trial / 8192) - 2*floor(sar12_trial / 16384))*1.8
let sar12_previous = @VD_B13[pwl]
let sar12_stimulus = vector(8)
let sar12_stimulus[0] = 0
let sar12_stimulus[1] = sar12_previous[length(sar12_previous)-1]
let sar12_stimulus[2] = 5.95009999999999e-05
let sar12_stimulus[3] = sar12_stimulus[1]
let sar12_stimulus[4] = 5.95029999999999e-05
let sar12_stimulus[5] = sar12_drive
let sar12_stimulus[6] = 0.000148
let sar12_stimulus[7] = sar12_stimulus[5]
alter @VD_B13[pwl] = sar12_stimulus
let sar12_drive = (floor(sar12_trial / 16384) - 2*floor(sar12_trial / 32768))*1.8
let sar12_previous = @VD_B14[pwl]
let sar12_stimulus = vector(8)
let sar12_stimulus[0] = 0
let sar12_stimulus[1] = sar12_previous[length(sar12_previous)-1]
let sar12_stimulus[2] = 5.95009999999999e-05
let sar12_stimulus[3] = sar12_stimulus[1]
let sar12_stimulus[4] = 5.95029999999999e-05
let sar12_stimulus[5] = sar12_drive
let sar12_stimulus[6] = 0.000148
let sar12_stimulus[7] = sar12_stimulus[5]
alter @VD_B14[pwl] = sar12_stimulus
let sar12_drive = (floor(sar12_trial / 32768) - 2*floor(sar12_trial / 65536))*1.8
let sar12_previous = @VD_B15[pwl]
let sar12_stimulus = vector(8)
let sar12_stimulus[0] = 0
let sar12_stimulus[1] = sar12_previous[length(sar12_previous)-1]
let sar12_stimulus[2] = 5.95009999999999e-05
let sar12_stimulus[3] = sar12_stimulus[1]
let sar12_stimulus[4] = 5.95029999999999e-05
let sar12_stimulus[5] = sar12_drive
let sar12_stimulus[6] = 0.000148
let sar12_stimulus[7] = sar12_stimulus[5]
alter @VD_B15[pwl] = sar12_stimulus
resume
let sar12_k = length(time)-1
if abs(time[sar12_k] - 5.99999999999999e-05) > 1e-12
print time[sar12_k]
echo expected_pause_time_s 5.99999999999999e-05
echo SAR12_PAUSE_FAILED
quit 1
end
print time[sar12_k] >> pause-times.txt
let sar12_previous = @VD_EVAL[pwl]
let sar12_stimulus = vector(8)
let sar12_stimulus[0] = 0
let sar12_stimulus[1] = sar12_previous[length(sar12_previous)-1]
let sar12_stimulus[2] = 6.00009999999999e-05
let sar12_stimulus[3] = sar12_stimulus[1]
let sar12_stimulus[4] = 6.00029999999999e-05
let sar12_stimulus[5] = 1.8
let sar12_stimulus[6] = 0.000148
let sar12_stimulus[7] = sar12_stimulus[5]
alter @VD_EVAL[pwl] = sar12_stimulus
resume
let sar12_k = length(time)-1
if abs(time[sar12_k] - 6.04999999999999e-05) > 1e-12
print time[sar12_k]
echo expected_pause_time_s 6.04999999999999e-05
echo SAR12_PAUSE_FAILED
quit 1
end
print time[sar12_k] >> pause-times.txt
let sar12_k = length(time)-1
let sar12_cmp = v(COMP)[sar12_k]
let sar12_cmpn = v(COMPN)[sar12_k]
let sar12_p = v(TOPP)[sar12_k]
let sar12_n = v(TOPN)[sar12_k]
let sar12_decision = 0
if sar12_cmp >= 0.9
let sar12_code = sar12_trial
let sar12_decision = 1
end
echo 2 13 $&sar12_trial $&sar12_cmp $&sar12_cmpn $&sar12_p $&sar12_n -1.19994506835937 $&sar12_decision >> decisions.csv
let sar12_previous = @VD_EVAL[pwl]
let sar12_stimulus = vector(8)
let sar12_stimulus[0] = 0
let sar12_stimulus[1] = sar12_previous[length(sar12_previous)-1]
let sar12_stimulus[2] = 6.05009999999999e-05
let sar12_stimulus[3] = sar12_stimulus[1]
let sar12_stimulus[4] = 6.05029999999999e-05
let sar12_stimulus[5] = 0
let sar12_stimulus[6] = 0.000148
let sar12_stimulus[7] = sar12_stimulus[5]
alter @VD_EVAL[pwl] = sar12_stimulus
let sar12_trial = sar12_code + 4096
let sar12_drive = (floor(sar12_trial / 1) - 2*floor(sar12_trial / 2))*1.8
let sar12_previous = @VD_B0[pwl]
let sar12_stimulus = vector(8)
let sar12_stimulus[0] = 0
let sar12_stimulus[1] = sar12_previous[length(sar12_previous)-1]
let sar12_stimulus[2] = 6.05009999999999e-05
let sar12_stimulus[3] = sar12_stimulus[1]
let sar12_stimulus[4] = 6.05029999999999e-05
let sar12_stimulus[5] = sar12_drive
let sar12_stimulus[6] = 0.000148
let sar12_stimulus[7] = sar12_stimulus[5]
alter @VD_B0[pwl] = sar12_stimulus
let sar12_drive = (floor(sar12_trial / 2) - 2*floor(sar12_trial / 4))*1.8
let sar12_previous = @VD_B1[pwl]
let sar12_stimulus = vector(8)
let sar12_stimulus[0] = 0
let sar12_stimulus[1] = sar12_previous[length(sar12_previous)-1]
let sar12_stimulus[2] = 6.05009999999999e-05
let sar12_stimulus[3] = sar12_stimulus[1]
let sar12_stimulus[4] = 6.05029999999999e-05
let sar12_stimulus[5] = sar12_drive
let sar12_stimulus[6] = 0.000148
let sar12_stimulus[7] = sar12_stimulus[5]
alter @VD_B1[pwl] = sar12_stimulus
let sar12_drive = (floor(sar12_trial / 4) - 2*floor(sar12_trial / 8))*1.8
let sar12_previous = @VD_B2[pwl]
let sar12_stimulus = vector(8)
let sar12_stimulus[0] = 0
let sar12_stimulus[1] = sar12_previous[length(sar12_previous)-1]
let sar12_stimulus[2] = 6.05009999999999e-05
let sar12_stimulus[3] = sar12_stimulus[1]
let sar12_stimulus[4] = 6.05029999999999e-05
let sar12_stimulus[5] = sar12_drive
let sar12_stimulus[6] = 0.000148
let sar12_stimulus[7] = sar12_stimulus[5]
alter @VD_B2[pwl] = sar12_stimulus
let sar12_drive = (floor(sar12_trial / 8) - 2*floor(sar12_trial / 16))*1.8
let sar12_previous = @VD_B3[pwl]
let sar12_stimulus = vector(8)
let sar12_stimulus[0] = 0
let sar12_stimulus[1] = sar12_previous[length(sar12_previous)-1]
let sar12_stimulus[2] = 6.05009999999999e-05
let sar12_stimulus[3] = sar12_stimulus[1]
let sar12_stimulus[4] = 6.05029999999999e-05
let sar12_stimulus[5] = sar12_drive
let sar12_stimulus[6] = 0.000148
let sar12_stimulus[7] = sar12_stimulus[5]
alter @VD_B3[pwl] = sar12_stimulus
let sar12_drive = (floor(sar12_trial / 16) - 2*floor(sar12_trial / 32))*1.8
let sar12_previous = @VD_B4[pwl]
let sar12_stimulus = vector(8)
let sar12_stimulus[0] = 0
let sar12_stimulus[1] = sar12_previous[length(sar12_previous)-1]
let sar12_stimulus[2] = 6.05009999999999e-05
let sar12_stimulus[3] = sar12_stimulus[1]
let sar12_stimulus[4] = 6.05029999999999e-05
let sar12_stimulus[5] = sar12_drive
let sar12_stimulus[6] = 0.000148
let sar12_stimulus[7] = sar12_stimulus[5]
alter @VD_B4[pwl] = sar12_stimulus
let sar12_drive = (floor(sar12_trial / 32) - 2*floor(sar12_trial / 64))*1.8
let sar12_previous = @VD_B5[pwl]
let sar12_stimulus = vector(8)
let sar12_stimulus[0] = 0
let sar12_stimulus[1] = sar12_previous[length(sar12_previous)-1]
let sar12_stimulus[2] = 6.05009999999999e-05
let sar12_stimulus[3] = sar12_stimulus[1]
let sar12_stimulus[4] = 6.05029999999999e-05
let sar12_stimulus[5] = sar12_drive
let sar12_stimulus[6] = 0.000148
let sar12_stimulus[7] = sar12_stimulus[5]
alter @VD_B5[pwl] = sar12_stimulus
let sar12_drive = (floor(sar12_trial / 64) - 2*floor(sar12_trial / 128))*1.8
let sar12_previous = @VD_B6[pwl]
let sar12_stimulus = vector(8)
let sar12_stimulus[0] = 0
let sar12_stimulus[1] = sar12_previous[length(sar12_previous)-1]
let sar12_stimulus[2] = 6.05009999999999e-05
let sar12_stimulus[3] = sar12_stimulus[1]
let sar12_stimulus[4] = 6.05029999999999e-05
let sar12_stimulus[5] = sar12_drive
let sar12_stimulus[6] = 0.000148
let sar12_stimulus[7] = sar12_stimulus[5]
alter @VD_B6[pwl] = sar12_stimulus
let sar12_drive = (floor(sar12_trial / 128) - 2*floor(sar12_trial / 256))*1.8
let sar12_previous = @VD_B7[pwl]
let sar12_stimulus = vector(8)
let sar12_stimulus[0] = 0
let sar12_stimulus[1] = sar12_previous[length(sar12_previous)-1]
let sar12_stimulus[2] = 6.05009999999999e-05
let sar12_stimulus[3] = sar12_stimulus[1]
let sar12_stimulus[4] = 6.05029999999999e-05
let sar12_stimulus[5] = sar12_drive
let sar12_stimulus[6] = 0.000148
let sar12_stimulus[7] = sar12_stimulus[5]
alter @VD_B7[pwl] = sar12_stimulus
let sar12_drive = (floor(sar12_trial / 256) - 2*floor(sar12_trial / 512))*1.8
let sar12_previous = @VD_B8[pwl]
let sar12_stimulus = vector(8)
let sar12_stimulus[0] = 0
let sar12_stimulus[1] = sar12_previous[length(sar12_previous)-1]
let sar12_stimulus[2] = 6.05009999999999e-05
let sar12_stimulus[3] = sar12_stimulus[1]
let sar12_stimulus[4] = 6.05029999999999e-05
let sar12_stimulus[5] = sar12_drive
let sar12_stimulus[6] = 0.000148
let sar12_stimulus[7] = sar12_stimulus[5]
alter @VD_B8[pwl] = sar12_stimulus
let sar12_drive = (floor(sar12_trial / 512) - 2*floor(sar12_trial / 1024))*1.8
let sar12_previous = @VD_B9[pwl]
let sar12_stimulus = vector(8)
let sar12_stimulus[0] = 0
let sar12_stimulus[1] = sar12_previous[length(sar12_previous)-1]
let sar12_stimulus[2] = 6.05009999999999e-05
let sar12_stimulus[3] = sar12_stimulus[1]
let sar12_stimulus[4] = 6.05029999999999e-05
let sar12_stimulus[5] = sar12_drive
let sar12_stimulus[6] = 0.000148
let sar12_stimulus[7] = sar12_stimulus[5]
alter @VD_B9[pwl] = sar12_stimulus
let sar12_drive = (floor(sar12_trial / 1024) - 2*floor(sar12_trial / 2048))*1.8
let sar12_previous = @VD_B10[pwl]
let sar12_stimulus = vector(8)
let sar12_stimulus[0] = 0
let sar12_stimulus[1] = sar12_previous[length(sar12_previous)-1]
let sar12_stimulus[2] = 6.05009999999999e-05
let sar12_stimulus[3] = sar12_stimulus[1]
let sar12_stimulus[4] = 6.05029999999999e-05
let sar12_stimulus[5] = sar12_drive
let sar12_stimulus[6] = 0.000148
let sar12_stimulus[7] = sar12_stimulus[5]
alter @VD_B10[pwl] = sar12_stimulus
let sar12_drive = (floor(sar12_trial / 2048) - 2*floor(sar12_trial / 4096))*1.8
let sar12_previous = @VD_B11[pwl]
let sar12_stimulus = vector(8)
let sar12_stimulus[0] = 0
let sar12_stimulus[1] = sar12_previous[length(sar12_previous)-1]
let sar12_stimulus[2] = 6.05009999999999e-05
let sar12_stimulus[3] = sar12_stimulus[1]
let sar12_stimulus[4] = 6.05029999999999e-05
let sar12_stimulus[5] = sar12_drive
let sar12_stimulus[6] = 0.000148
let sar12_stimulus[7] = sar12_stimulus[5]
alter @VD_B11[pwl] = sar12_stimulus
let sar12_drive = (floor(sar12_trial / 4096) - 2*floor(sar12_trial / 8192))*1.8
let sar12_previous = @VD_B12[pwl]
let sar12_stimulus = vector(8)
let sar12_stimulus[0] = 0
let sar12_stimulus[1] = sar12_previous[length(sar12_previous)-1]
let sar12_stimulus[2] = 6.05009999999999e-05
let sar12_stimulus[3] = sar12_stimulus[1]
let sar12_stimulus[4] = 6.05029999999999e-05
let sar12_stimulus[5] = sar12_drive
let sar12_stimulus[6] = 0.000148
let sar12_stimulus[7] = sar12_stimulus[5]
alter @VD_B12[pwl] = sar12_stimulus
let sar12_drive = (floor(sar12_trial / 8192) - 2*floor(sar12_trial / 16384))*1.8
let sar12_previous = @VD_B13[pwl]
let sar12_stimulus = vector(8)
let sar12_stimulus[0] = 0
let sar12_stimulus[1] = sar12_previous[length(sar12_previous)-1]
let sar12_stimulus[2] = 6.05009999999999e-05
let sar12_stimulus[3] = sar12_stimulus[1]
let sar12_stimulus[4] = 6.05029999999999e-05
let sar12_stimulus[5] = sar12_drive
let sar12_stimulus[6] = 0.000148
let sar12_stimulus[7] = sar12_stimulus[5]
alter @VD_B13[pwl] = sar12_stimulus
let sar12_drive = (floor(sar12_trial / 16384) - 2*floor(sar12_trial / 32768))*1.8
let sar12_previous = @VD_B14[pwl]
let sar12_stimulus = vector(8)
let sar12_stimulus[0] = 0
let sar12_stimulus[1] = sar12_previous[length(sar12_previous)-1]
let sar12_stimulus[2] = 6.05009999999999e-05
let sar12_stimulus[3] = sar12_stimulus[1]
let sar12_stimulus[4] = 6.05029999999999e-05
let sar12_stimulus[5] = sar12_drive
let sar12_stimulus[6] = 0.000148
let sar12_stimulus[7] = sar12_stimulus[5]
alter @VD_B14[pwl] = sar12_stimulus
let sar12_drive = (floor(sar12_trial / 32768) - 2*floor(sar12_trial / 65536))*1.8
let sar12_previous = @VD_B15[pwl]
let sar12_stimulus = vector(8)
let sar12_stimulus[0] = 0
let sar12_stimulus[1] = sar12_previous[length(sar12_previous)-1]
let sar12_stimulus[2] = 6.05009999999999e-05
let sar12_stimulus[3] = sar12_stimulus[1]
let sar12_stimulus[4] = 6.05029999999999e-05
let sar12_stimulus[5] = sar12_drive
let sar12_stimulus[6] = 0.000148
let sar12_stimulus[7] = sar12_stimulus[5]
alter @VD_B15[pwl] = sar12_stimulus
resume
let sar12_k = length(time)-1
if abs(time[sar12_k] - 6.09999999999999e-05) > 1e-12
print time[sar12_k]
echo expected_pause_time_s 6.09999999999999e-05
echo SAR12_PAUSE_FAILED
quit 1
end
print time[sar12_k] >> pause-times.txt
let sar12_previous = @VD_EVAL[pwl]
let sar12_stimulus = vector(8)
let sar12_stimulus[0] = 0
let sar12_stimulus[1] = sar12_previous[length(sar12_previous)-1]
let sar12_stimulus[2] = 6.10009999999999e-05
let sar12_stimulus[3] = sar12_stimulus[1]
let sar12_stimulus[4] = 6.10029999999999e-05
let sar12_stimulus[5] = 1.8
let sar12_stimulus[6] = 0.000148
let sar12_stimulus[7] = sar12_stimulus[5]
alter @VD_EVAL[pwl] = sar12_stimulus
resume
let sar12_k = length(time)-1
if abs(time[sar12_k] - 6.14999999999999e-05) > 1e-12
print time[sar12_k]
echo expected_pause_time_s 6.14999999999999e-05
echo SAR12_PAUSE_FAILED
quit 1
end
print time[sar12_k] >> pause-times.txt
let sar12_k = length(time)-1
let sar12_cmp = v(COMP)[sar12_k]
let sar12_cmpn = v(COMPN)[sar12_k]
let sar12_p = v(TOPP)[sar12_k]
let sar12_n = v(TOPN)[sar12_k]
let sar12_decision = 0
if sar12_cmp >= 0.9
let sar12_code = sar12_trial
let sar12_decision = 1
end
echo 2 12 $&sar12_trial $&sar12_cmp $&sar12_cmpn $&sar12_p $&sar12_n -1.19994506835937 $&sar12_decision >> decisions.csv
let sar12_previous = @VD_EVAL[pwl]
let sar12_stimulus = vector(8)
let sar12_stimulus[0] = 0
let sar12_stimulus[1] = sar12_previous[length(sar12_previous)-1]
let sar12_stimulus[2] = 6.15009999999999e-05
let sar12_stimulus[3] = sar12_stimulus[1]
let sar12_stimulus[4] = 6.15029999999999e-05
let sar12_stimulus[5] = 0
let sar12_stimulus[6] = 0.000148
let sar12_stimulus[7] = sar12_stimulus[5]
alter @VD_EVAL[pwl] = sar12_stimulus
let sar12_trial = sar12_code + 2048
let sar12_drive = (floor(sar12_trial / 1) - 2*floor(sar12_trial / 2))*1.8
let sar12_previous = @VD_B0[pwl]
let sar12_stimulus = vector(8)
let sar12_stimulus[0] = 0
let sar12_stimulus[1] = sar12_previous[length(sar12_previous)-1]
let sar12_stimulus[2] = 6.15009999999999e-05
let sar12_stimulus[3] = sar12_stimulus[1]
let sar12_stimulus[4] = 6.15029999999999e-05
let sar12_stimulus[5] = sar12_drive
let sar12_stimulus[6] = 0.000148
let sar12_stimulus[7] = sar12_stimulus[5]
alter @VD_B0[pwl] = sar12_stimulus
let sar12_drive = (floor(sar12_trial / 2) - 2*floor(sar12_trial / 4))*1.8
let sar12_previous = @VD_B1[pwl]
let sar12_stimulus = vector(8)
let sar12_stimulus[0] = 0
let sar12_stimulus[1] = sar12_previous[length(sar12_previous)-1]
let sar12_stimulus[2] = 6.15009999999999e-05
let sar12_stimulus[3] = sar12_stimulus[1]
let sar12_stimulus[4] = 6.15029999999999e-05
let sar12_stimulus[5] = sar12_drive
let sar12_stimulus[6] = 0.000148
let sar12_stimulus[7] = sar12_stimulus[5]
alter @VD_B1[pwl] = sar12_stimulus
let sar12_drive = (floor(sar12_trial / 4) - 2*floor(sar12_trial / 8))*1.8
let sar12_previous = @VD_B2[pwl]
let sar12_stimulus = vector(8)
let sar12_stimulus[0] = 0
let sar12_stimulus[1] = sar12_previous[length(sar12_previous)-1]
let sar12_stimulus[2] = 6.15009999999999e-05
let sar12_stimulus[3] = sar12_stimulus[1]
let sar12_stimulus[4] = 6.15029999999999e-05
let sar12_stimulus[5] = sar12_drive
let sar12_stimulus[6] = 0.000148
let sar12_stimulus[7] = sar12_stimulus[5]
alter @VD_B2[pwl] = sar12_stimulus
let sar12_drive = (floor(sar12_trial / 8) - 2*floor(sar12_trial / 16))*1.8
let sar12_previous = @VD_B3[pwl]
let sar12_stimulus = vector(8)
let sar12_stimulus[0] = 0
let sar12_stimulus[1] = sar12_previous[length(sar12_previous)-1]
let sar12_stimulus[2] = 6.15009999999999e-05
let sar12_stimulus[3] = sar12_stimulus[1]
let sar12_stimulus[4] = 6.15029999999999e-05
let sar12_stimulus[5] = sar12_drive
let sar12_stimulus[6] = 0.000148
let sar12_stimulus[7] = sar12_stimulus[5]
alter @VD_B3[pwl] = sar12_stimulus
let sar12_drive = (floor(sar12_trial / 16) - 2*floor(sar12_trial / 32))*1.8
let sar12_previous = @VD_B4[pwl]
let sar12_stimulus = vector(8)
let sar12_stimulus[0] = 0
let sar12_stimulus[1] = sar12_previous[length(sar12_previous)-1]
let sar12_stimulus[2] = 6.15009999999999e-05
let sar12_stimulus[3] = sar12_stimulus[1]
let sar12_stimulus[4] = 6.15029999999999e-05
let sar12_stimulus[5] = sar12_drive
let sar12_stimulus[6] = 0.000148
let sar12_stimulus[7] = sar12_stimulus[5]
alter @VD_B4[pwl] = sar12_stimulus
let sar12_drive = (floor(sar12_trial / 32) - 2*floor(sar12_trial / 64))*1.8
let sar12_previous = @VD_B5[pwl]
let sar12_stimulus = vector(8)
let sar12_stimulus[0] = 0
let sar12_stimulus[1] = sar12_previous[length(sar12_previous)-1]
let sar12_stimulus[2] = 6.15009999999999e-05
let sar12_stimulus[3] = sar12_stimulus[1]
let sar12_stimulus[4] = 6.15029999999999e-05
let sar12_stimulus[5] = sar12_drive
let sar12_stimulus[6] = 0.000148
let sar12_stimulus[7] = sar12_stimulus[5]
alter @VD_B5[pwl] = sar12_stimulus
let sar12_drive = (floor(sar12_trial / 64) - 2*floor(sar12_trial / 128))*1.8
let sar12_previous = @VD_B6[pwl]
let sar12_stimulus = vector(8)
let sar12_stimulus[0] = 0
let sar12_stimulus[1] = sar12_previous[length(sar12_previous)-1]
let sar12_stimulus[2] = 6.15009999999999e-05
let sar12_stimulus[3] = sar12_stimulus[1]
let sar12_stimulus[4] = 6.15029999999999e-05
let sar12_stimulus[5] = sar12_drive
let sar12_stimulus[6] = 0.000148
let sar12_stimulus[7] = sar12_stimulus[5]
alter @VD_B6[pwl] = sar12_stimulus
let sar12_drive = (floor(sar12_trial / 128) - 2*floor(sar12_trial / 256))*1.8
let sar12_previous = @VD_B7[pwl]
let sar12_stimulus = vector(8)
let sar12_stimulus[0] = 0
let sar12_stimulus[1] = sar12_previous[length(sar12_previous)-1]
let sar12_stimulus[2] = 6.15009999999999e-05
let sar12_stimulus[3] = sar12_stimulus[1]
let sar12_stimulus[4] = 6.15029999999999e-05
let sar12_stimulus[5] = sar12_drive
let sar12_stimulus[6] = 0.000148
let sar12_stimulus[7] = sar12_stimulus[5]
alter @VD_B7[pwl] = sar12_stimulus
let sar12_drive = (floor(sar12_trial / 256) - 2*floor(sar12_trial / 512))*1.8
let sar12_previous = @VD_B8[pwl]
let sar12_stimulus = vector(8)
let sar12_stimulus[0] = 0
let sar12_stimulus[1] = sar12_previous[length(sar12_previous)-1]
let sar12_stimulus[2] = 6.15009999999999e-05
let sar12_stimulus[3] = sar12_stimulus[1]
let sar12_stimulus[4] = 6.15029999999999e-05
let sar12_stimulus[5] = sar12_drive
let sar12_stimulus[6] = 0.000148
let sar12_stimulus[7] = sar12_stimulus[5]
alter @VD_B8[pwl] = sar12_stimulus
let sar12_drive = (floor(sar12_trial / 512) - 2*floor(sar12_trial / 1024))*1.8
let sar12_previous = @VD_B9[pwl]
let sar12_stimulus = vector(8)
let sar12_stimulus[0] = 0
let sar12_stimulus[1] = sar12_previous[length(sar12_previous)-1]
let sar12_stimulus[2] = 6.15009999999999e-05
let sar12_stimulus[3] = sar12_stimulus[1]
let sar12_stimulus[4] = 6.15029999999999e-05
let sar12_stimulus[5] = sar12_drive
let sar12_stimulus[6] = 0.000148
let sar12_stimulus[7] = sar12_stimulus[5]
alter @VD_B9[pwl] = sar12_stimulus
let sar12_drive = (floor(sar12_trial / 1024) - 2*floor(sar12_trial / 2048))*1.8
let sar12_previous = @VD_B10[pwl]
let sar12_stimulus = vector(8)
let sar12_stimulus[0] = 0
let sar12_stimulus[1] = sar12_previous[length(sar12_previous)-1]
let sar12_stimulus[2] = 6.15009999999999e-05
let sar12_stimulus[3] = sar12_stimulus[1]
let sar12_stimulus[4] = 6.15029999999999e-05
let sar12_stimulus[5] = sar12_drive
let sar12_stimulus[6] = 0.000148
let sar12_stimulus[7] = sar12_stimulus[5]
alter @VD_B10[pwl] = sar12_stimulus
let sar12_drive = (floor(sar12_trial / 2048) - 2*floor(sar12_trial / 4096))*1.8
let sar12_previous = @VD_B11[pwl]
let sar12_stimulus = vector(8)
let sar12_stimulus[0] = 0
let sar12_stimulus[1] = sar12_previous[length(sar12_previous)-1]
let sar12_stimulus[2] = 6.15009999999999e-05
let sar12_stimulus[3] = sar12_stimulus[1]
let sar12_stimulus[4] = 6.15029999999999e-05
let sar12_stimulus[5] = sar12_drive
let sar12_stimulus[6] = 0.000148
let sar12_stimulus[7] = sar12_stimulus[5]
alter @VD_B11[pwl] = sar12_stimulus
let sar12_drive = (floor(sar12_trial / 4096) - 2*floor(sar12_trial / 8192))*1.8
let sar12_previous = @VD_B12[pwl]
let sar12_stimulus = vector(8)
let sar12_stimulus[0] = 0
let sar12_stimulus[1] = sar12_previous[length(sar12_previous)-1]
let sar12_stimulus[2] = 6.15009999999999e-05
let sar12_stimulus[3] = sar12_stimulus[1]
let sar12_stimulus[4] = 6.15029999999999e-05
let sar12_stimulus[5] = sar12_drive
let sar12_stimulus[6] = 0.000148
let sar12_stimulus[7] = sar12_stimulus[5]
alter @VD_B12[pwl] = sar12_stimulus
let sar12_drive = (floor(sar12_trial / 8192) - 2*floor(sar12_trial / 16384))*1.8
let sar12_previous = @VD_B13[pwl]
let sar12_stimulus = vector(8)
let sar12_stimulus[0] = 0
let sar12_stimulus[1] = sar12_previous[length(sar12_previous)-1]
let sar12_stimulus[2] = 6.15009999999999e-05
let sar12_stimulus[3] = sar12_stimulus[1]
let sar12_stimulus[4] = 6.15029999999999e-05
let sar12_stimulus[5] = sar12_drive
let sar12_stimulus[6] = 0.000148
let sar12_stimulus[7] = sar12_stimulus[5]
alter @VD_B13[pwl] = sar12_stimulus
let sar12_drive = (floor(sar12_trial / 16384) - 2*floor(sar12_trial / 32768))*1.8
let sar12_previous = @VD_B14[pwl]
let sar12_stimulus = vector(8)
let sar12_stimulus[0] = 0
let sar12_stimulus[1] = sar12_previous[length(sar12_previous)-1]
let sar12_stimulus[2] = 6.15009999999999e-05
let sar12_stimulus[3] = sar12_stimulus[1]
let sar12_stimulus[4] = 6.15029999999999e-05
let sar12_stimulus[5] = sar12_drive
let sar12_stimulus[6] = 0.000148
let sar12_stimulus[7] = sar12_stimulus[5]
alter @VD_B14[pwl] = sar12_stimulus
let sar12_drive = (floor(sar12_trial / 32768) - 2*floor(sar12_trial / 65536))*1.8
let sar12_previous = @VD_B15[pwl]
let sar12_stimulus = vector(8)
let sar12_stimulus[0] = 0
let sar12_stimulus[1] = sar12_previous[length(sar12_previous)-1]
let sar12_stimulus[2] = 6.15009999999999e-05
let sar12_stimulus[3] = sar12_stimulus[1]
let sar12_stimulus[4] = 6.15029999999999e-05
let sar12_stimulus[5] = sar12_drive
let sar12_stimulus[6] = 0.000148
let sar12_stimulus[7] = sar12_stimulus[5]
alter @VD_B15[pwl] = sar12_stimulus
resume
let sar12_k = length(time)-1
if abs(time[sar12_k] - 6.19999999999999e-05) > 1e-12
print time[sar12_k]
echo expected_pause_time_s 6.19999999999999e-05
echo SAR12_PAUSE_FAILED
quit 1
end
print time[sar12_k] >> pause-times.txt
let sar12_previous = @VD_EVAL[pwl]
let sar12_stimulus = vector(8)
let sar12_stimulus[0] = 0
let sar12_stimulus[1] = sar12_previous[length(sar12_previous)-1]
let sar12_stimulus[2] = 6.20009999999999e-05
let sar12_stimulus[3] = sar12_stimulus[1]
let sar12_stimulus[4] = 6.20029999999999e-05
let sar12_stimulus[5] = 1.8
let sar12_stimulus[6] = 0.000148
let sar12_stimulus[7] = sar12_stimulus[5]
alter @VD_EVAL[pwl] = sar12_stimulus
resume
let sar12_k = length(time)-1
if abs(time[sar12_k] - 6.24999999999999e-05) > 1e-12
print time[sar12_k]
echo expected_pause_time_s 6.24999999999999e-05
echo SAR12_PAUSE_FAILED
quit 1
end
print time[sar12_k] >> pause-times.txt
let sar12_k = length(time)-1
let sar12_cmp = v(COMP)[sar12_k]
let sar12_cmpn = v(COMPN)[sar12_k]
let sar12_p = v(TOPP)[sar12_k]
let sar12_n = v(TOPN)[sar12_k]
let sar12_decision = 0
if sar12_cmp >= 0.9
let sar12_code = sar12_trial
let sar12_decision = 1
end
echo 2 11 $&sar12_trial $&sar12_cmp $&sar12_cmpn $&sar12_p $&sar12_n -1.19994506835937 $&sar12_decision >> decisions.csv
let sar12_previous = @VD_EVAL[pwl]
let sar12_stimulus = vector(8)
let sar12_stimulus[0] = 0
let sar12_stimulus[1] = sar12_previous[length(sar12_previous)-1]
let sar12_stimulus[2] = 6.25009999999999e-05
let sar12_stimulus[3] = sar12_stimulus[1]
let sar12_stimulus[4] = 6.25029999999999e-05
let sar12_stimulus[5] = 0
let sar12_stimulus[6] = 0.000148
let sar12_stimulus[7] = sar12_stimulus[5]
alter @VD_EVAL[pwl] = sar12_stimulus
let sar12_trial = sar12_code + 1024
let sar12_drive = (floor(sar12_trial / 1) - 2*floor(sar12_trial / 2))*1.8
let sar12_previous = @VD_B0[pwl]
let sar12_stimulus = vector(8)
let sar12_stimulus[0] = 0
let sar12_stimulus[1] = sar12_previous[length(sar12_previous)-1]
let sar12_stimulus[2] = 6.25009999999999e-05
let sar12_stimulus[3] = sar12_stimulus[1]
let sar12_stimulus[4] = 6.25029999999999e-05
let sar12_stimulus[5] = sar12_drive
let sar12_stimulus[6] = 0.000148
let sar12_stimulus[7] = sar12_stimulus[5]
alter @VD_B0[pwl] = sar12_stimulus
let sar12_drive = (floor(sar12_trial / 2) - 2*floor(sar12_trial / 4))*1.8
let sar12_previous = @VD_B1[pwl]
let sar12_stimulus = vector(8)
let sar12_stimulus[0] = 0
let sar12_stimulus[1] = sar12_previous[length(sar12_previous)-1]
let sar12_stimulus[2] = 6.25009999999999e-05
let sar12_stimulus[3] = sar12_stimulus[1]
let sar12_stimulus[4] = 6.25029999999999e-05
let sar12_stimulus[5] = sar12_drive
let sar12_stimulus[6] = 0.000148
let sar12_stimulus[7] = sar12_stimulus[5]
alter @VD_B1[pwl] = sar12_stimulus
let sar12_drive = (floor(sar12_trial / 4) - 2*floor(sar12_trial / 8))*1.8
let sar12_previous = @VD_B2[pwl]
let sar12_stimulus = vector(8)
let sar12_stimulus[0] = 0
let sar12_stimulus[1] = sar12_previous[length(sar12_previous)-1]
let sar12_stimulus[2] = 6.25009999999999e-05
let sar12_stimulus[3] = sar12_stimulus[1]
let sar12_stimulus[4] = 6.25029999999999e-05
let sar12_stimulus[5] = sar12_drive
let sar12_stimulus[6] = 0.000148
let sar12_stimulus[7] = sar12_stimulus[5]
alter @VD_B2[pwl] = sar12_stimulus
let sar12_drive = (floor(sar12_trial / 8) - 2*floor(sar12_trial / 16))*1.8
let sar12_previous = @VD_B3[pwl]
let sar12_stimulus = vector(8)
let sar12_stimulus[0] = 0
let sar12_stimulus[1] = sar12_previous[length(sar12_previous)-1]
let sar12_stimulus[2] = 6.25009999999999e-05
let sar12_stimulus[3] = sar12_stimulus[1]
let sar12_stimulus[4] = 6.25029999999999e-05
let sar12_stimulus[5] = sar12_drive
let sar12_stimulus[6] = 0.000148
let sar12_stimulus[7] = sar12_stimulus[5]
alter @VD_B3[pwl] = sar12_stimulus
let sar12_drive = (floor(sar12_trial / 16) - 2*floor(sar12_trial / 32))*1.8
let sar12_previous = @VD_B4[pwl]
let sar12_stimulus = vector(8)
let sar12_stimulus[0] = 0
let sar12_stimulus[1] = sar12_previous[length(sar12_previous)-1]
let sar12_stimulus[2] = 6.25009999999999e-05
let sar12_stimulus[3] = sar12_stimulus[1]
let sar12_stimulus[4] = 6.25029999999999e-05
let sar12_stimulus[5] = sar12_drive
let sar12_stimulus[6] = 0.000148
let sar12_stimulus[7] = sar12_stimulus[5]
alter @VD_B4[pwl] = sar12_stimulus
let sar12_drive = (floor(sar12_trial / 32) - 2*floor(sar12_trial / 64))*1.8
let sar12_previous = @VD_B5[pwl]
let sar12_stimulus = vector(8)
let sar12_stimulus[0] = 0
let sar12_stimulus[1] = sar12_previous[length(sar12_previous)-1]
let sar12_stimulus[2] = 6.25009999999999e-05
let sar12_stimulus[3] = sar12_stimulus[1]
let sar12_stimulus[4] = 6.25029999999999e-05
let sar12_stimulus[5] = sar12_drive
let sar12_stimulus[6] = 0.000148
let sar12_stimulus[7] = sar12_stimulus[5]
alter @VD_B5[pwl] = sar12_stimulus
let sar12_drive = (floor(sar12_trial / 64) - 2*floor(sar12_trial / 128))*1.8
let sar12_previous = @VD_B6[pwl]
let sar12_stimulus = vector(8)
let sar12_stimulus[0] = 0
let sar12_stimulus[1] = sar12_previous[length(sar12_previous)-1]
let sar12_stimulus[2] = 6.25009999999999e-05
let sar12_stimulus[3] = sar12_stimulus[1]
let sar12_stimulus[4] = 6.25029999999999e-05
let sar12_stimulus[5] = sar12_drive
let sar12_stimulus[6] = 0.000148
let sar12_stimulus[7] = sar12_stimulus[5]
alter @VD_B6[pwl] = sar12_stimulus
let sar12_drive = (floor(sar12_trial / 128) - 2*floor(sar12_trial / 256))*1.8
let sar12_previous = @VD_B7[pwl]
let sar12_stimulus = vector(8)
let sar12_stimulus[0] = 0
let sar12_stimulus[1] = sar12_previous[length(sar12_previous)-1]
let sar12_stimulus[2] = 6.25009999999999e-05
let sar12_stimulus[3] = sar12_stimulus[1]
let sar12_stimulus[4] = 6.25029999999999e-05
let sar12_stimulus[5] = sar12_drive
let sar12_stimulus[6] = 0.000148
let sar12_stimulus[7] = sar12_stimulus[5]
alter @VD_B7[pwl] = sar12_stimulus
let sar12_drive = (floor(sar12_trial / 256) - 2*floor(sar12_trial / 512))*1.8
let sar12_previous = @VD_B8[pwl]
let sar12_stimulus = vector(8)
let sar12_stimulus[0] = 0
let sar12_stimulus[1] = sar12_previous[length(sar12_previous)-1]
let sar12_stimulus[2] = 6.25009999999999e-05
let sar12_stimulus[3] = sar12_stimulus[1]
let sar12_stimulus[4] = 6.25029999999999e-05
let sar12_stimulus[5] = sar12_drive
let sar12_stimulus[6] = 0.000148
let sar12_stimulus[7] = sar12_stimulus[5]
alter @VD_B8[pwl] = sar12_stimulus
let sar12_drive = (floor(sar12_trial / 512) - 2*floor(sar12_trial / 1024))*1.8
let sar12_previous = @VD_B9[pwl]
let sar12_stimulus = vector(8)
let sar12_stimulus[0] = 0
let sar12_stimulus[1] = sar12_previous[length(sar12_previous)-1]
let sar12_stimulus[2] = 6.25009999999999e-05
let sar12_stimulus[3] = sar12_stimulus[1]
let sar12_stimulus[4] = 6.25029999999999e-05
let sar12_stimulus[5] = sar12_drive
let sar12_stimulus[6] = 0.000148
let sar12_stimulus[7] = sar12_stimulus[5]
alter @VD_B9[pwl] = sar12_stimulus
let sar12_drive = (floor(sar12_trial / 1024) - 2*floor(sar12_trial / 2048))*1.8
let sar12_previous = @VD_B10[pwl]
let sar12_stimulus = vector(8)
let sar12_stimulus[0] = 0
let sar12_stimulus[1] = sar12_previous[length(sar12_previous)-1]
let sar12_stimulus[2] = 6.25009999999999e-05
let sar12_stimulus[3] = sar12_stimulus[1]
let sar12_stimulus[4] = 6.25029999999999e-05
let sar12_stimulus[5] = sar12_drive
let sar12_stimulus[6] = 0.000148
let sar12_stimulus[7] = sar12_stimulus[5]
alter @VD_B10[pwl] = sar12_stimulus
let sar12_drive = (floor(sar12_trial / 2048) - 2*floor(sar12_trial / 4096))*1.8
let sar12_previous = @VD_B11[pwl]
let sar12_stimulus = vector(8)
let sar12_stimulus[0] = 0
let sar12_stimulus[1] = sar12_previous[length(sar12_previous)-1]
let sar12_stimulus[2] = 6.25009999999999e-05
let sar12_stimulus[3] = sar12_stimulus[1]
let sar12_stimulus[4] = 6.25029999999999e-05
let sar12_stimulus[5] = sar12_drive
let sar12_stimulus[6] = 0.000148
let sar12_stimulus[7] = sar12_stimulus[5]
alter @VD_B11[pwl] = sar12_stimulus
let sar12_drive = (floor(sar12_trial / 4096) - 2*floor(sar12_trial / 8192))*1.8
let sar12_previous = @VD_B12[pwl]
let sar12_stimulus = vector(8)
let sar12_stimulus[0] = 0
let sar12_stimulus[1] = sar12_previous[length(sar12_previous)-1]
let sar12_stimulus[2] = 6.25009999999999e-05
let sar12_stimulus[3] = sar12_stimulus[1]
let sar12_stimulus[4] = 6.25029999999999e-05
let sar12_stimulus[5] = sar12_drive
let sar12_stimulus[6] = 0.000148
let sar12_stimulus[7] = sar12_stimulus[5]
alter @VD_B12[pwl] = sar12_stimulus
let sar12_drive = (floor(sar12_trial / 8192) - 2*floor(sar12_trial / 16384))*1.8
let sar12_previous = @VD_B13[pwl]
let sar12_stimulus = vector(8)
let sar12_stimulus[0] = 0
let sar12_stimulus[1] = sar12_previous[length(sar12_previous)-1]
let sar12_stimulus[2] = 6.25009999999999e-05
let sar12_stimulus[3] = sar12_stimulus[1]
let sar12_stimulus[4] = 6.25029999999999e-05
let sar12_stimulus[5] = sar12_drive
let sar12_stimulus[6] = 0.000148
let sar12_stimulus[7] = sar12_stimulus[5]
alter @VD_B13[pwl] = sar12_stimulus
let sar12_drive = (floor(sar12_trial / 16384) - 2*floor(sar12_trial / 32768))*1.8
let sar12_previous = @VD_B14[pwl]
let sar12_stimulus = vector(8)
let sar12_stimulus[0] = 0
let sar12_stimulus[1] = sar12_previous[length(sar12_previous)-1]
let sar12_stimulus[2] = 6.25009999999999e-05
let sar12_stimulus[3] = sar12_stimulus[1]
let sar12_stimulus[4] = 6.25029999999999e-05
let sar12_stimulus[5] = sar12_drive
let sar12_stimulus[6] = 0.000148
let sar12_stimulus[7] = sar12_stimulus[5]
alter @VD_B14[pwl] = sar12_stimulus
let sar12_drive = (floor(sar12_trial / 32768) - 2*floor(sar12_trial / 65536))*1.8
let sar12_previous = @VD_B15[pwl]
let sar12_stimulus = vector(8)
let sar12_stimulus[0] = 0
let sar12_stimulus[1] = sar12_previous[length(sar12_previous)-1]
let sar12_stimulus[2] = 6.25009999999999e-05
let sar12_stimulus[3] = sar12_stimulus[1]
let sar12_stimulus[4] = 6.25029999999999e-05
let sar12_stimulus[5] = sar12_drive
let sar12_stimulus[6] = 0.000148
let sar12_stimulus[7] = sar12_stimulus[5]
alter @VD_B15[pwl] = sar12_stimulus
resume
let sar12_k = length(time)-1
if abs(time[sar12_k] - 6.29999999999999e-05) > 1e-12
print time[sar12_k]
echo expected_pause_time_s 6.29999999999999e-05
echo SAR12_PAUSE_FAILED
quit 1
end
print time[sar12_k] >> pause-times.txt
let sar12_previous = @VD_EVAL[pwl]
let sar12_stimulus = vector(8)
let sar12_stimulus[0] = 0
let sar12_stimulus[1] = sar12_previous[length(sar12_previous)-1]
let sar12_stimulus[2] = 6.30009999999999e-05
let sar12_stimulus[3] = sar12_stimulus[1]
let sar12_stimulus[4] = 6.30029999999999e-05
let sar12_stimulus[5] = 1.8
let sar12_stimulus[6] = 0.000148
let sar12_stimulus[7] = sar12_stimulus[5]
alter @VD_EVAL[pwl] = sar12_stimulus
resume
let sar12_k = length(time)-1
if abs(time[sar12_k] - 6.34999999999999e-05) > 1e-12
print time[sar12_k]
echo expected_pause_time_s 6.34999999999999e-05
echo SAR12_PAUSE_FAILED
quit 1
end
print time[sar12_k] >> pause-times.txt
let sar12_k = length(time)-1
let sar12_cmp = v(COMP)[sar12_k]
let sar12_cmpn = v(COMPN)[sar12_k]
let sar12_p = v(TOPP)[sar12_k]
let sar12_n = v(TOPN)[sar12_k]
let sar12_decision = 0
if sar12_cmp >= 0.9
let sar12_code = sar12_trial
let sar12_decision = 1
end
echo 2 10 $&sar12_trial $&sar12_cmp $&sar12_cmpn $&sar12_p $&sar12_n -1.19994506835937 $&sar12_decision >> decisions.csv
let sar12_previous = @VD_EVAL[pwl]
let sar12_stimulus = vector(8)
let sar12_stimulus[0] = 0
let sar12_stimulus[1] = sar12_previous[length(sar12_previous)-1]
let sar12_stimulus[2] = 6.35009999999999e-05
let sar12_stimulus[3] = sar12_stimulus[1]
let sar12_stimulus[4] = 6.35029999999999e-05
let sar12_stimulus[5] = 0
let sar12_stimulus[6] = 0.000148
let sar12_stimulus[7] = sar12_stimulus[5]
alter @VD_EVAL[pwl] = sar12_stimulus
let sar12_trial = sar12_code + 512
let sar12_drive = (floor(sar12_trial / 1) - 2*floor(sar12_trial / 2))*1.8
let sar12_previous = @VD_B0[pwl]
let sar12_stimulus = vector(8)
let sar12_stimulus[0] = 0
let sar12_stimulus[1] = sar12_previous[length(sar12_previous)-1]
let sar12_stimulus[2] = 6.35009999999999e-05
let sar12_stimulus[3] = sar12_stimulus[1]
let sar12_stimulus[4] = 6.35029999999999e-05
let sar12_stimulus[5] = sar12_drive
let sar12_stimulus[6] = 0.000148
let sar12_stimulus[7] = sar12_stimulus[5]
alter @VD_B0[pwl] = sar12_stimulus
let sar12_drive = (floor(sar12_trial / 2) - 2*floor(sar12_trial / 4))*1.8
let sar12_previous = @VD_B1[pwl]
let sar12_stimulus = vector(8)
let sar12_stimulus[0] = 0
let sar12_stimulus[1] = sar12_previous[length(sar12_previous)-1]
let sar12_stimulus[2] = 6.35009999999999e-05
let sar12_stimulus[3] = sar12_stimulus[1]
let sar12_stimulus[4] = 6.35029999999999e-05
let sar12_stimulus[5] = sar12_drive
let sar12_stimulus[6] = 0.000148
let sar12_stimulus[7] = sar12_stimulus[5]
alter @VD_B1[pwl] = sar12_stimulus
let sar12_drive = (floor(sar12_trial / 4) - 2*floor(sar12_trial / 8))*1.8
let sar12_previous = @VD_B2[pwl]
let sar12_stimulus = vector(8)
let sar12_stimulus[0] = 0
let sar12_stimulus[1] = sar12_previous[length(sar12_previous)-1]
let sar12_stimulus[2] = 6.35009999999999e-05
let sar12_stimulus[3] = sar12_stimulus[1]
let sar12_stimulus[4] = 6.35029999999999e-05
let sar12_stimulus[5] = sar12_drive
let sar12_stimulus[6] = 0.000148
let sar12_stimulus[7] = sar12_stimulus[5]
alter @VD_B2[pwl] = sar12_stimulus
let sar12_drive = (floor(sar12_trial / 8) - 2*floor(sar12_trial / 16))*1.8
let sar12_previous = @VD_B3[pwl]
let sar12_stimulus = vector(8)
let sar12_stimulus[0] = 0
let sar12_stimulus[1] = sar12_previous[length(sar12_previous)-1]
let sar12_stimulus[2] = 6.35009999999999e-05
let sar12_stimulus[3] = sar12_stimulus[1]
let sar12_stimulus[4] = 6.35029999999999e-05
let sar12_stimulus[5] = sar12_drive
let sar12_stimulus[6] = 0.000148
let sar12_stimulus[7] = sar12_stimulus[5]
alter @VD_B3[pwl] = sar12_stimulus
let sar12_drive = (floor(sar12_trial / 16) - 2*floor(sar12_trial / 32))*1.8
let sar12_previous = @VD_B4[pwl]
let sar12_stimulus = vector(8)
let sar12_stimulus[0] = 0
let sar12_stimulus[1] = sar12_previous[length(sar12_previous)-1]
let sar12_stimulus[2] = 6.35009999999999e-05
let sar12_stimulus[3] = sar12_stimulus[1]
let sar12_stimulus[4] = 6.35029999999999e-05
let sar12_stimulus[5] = sar12_drive
let sar12_stimulus[6] = 0.000148
let sar12_stimulus[7] = sar12_stimulus[5]
alter @VD_B4[pwl] = sar12_stimulus
let sar12_drive = (floor(sar12_trial / 32) - 2*floor(sar12_trial / 64))*1.8
let sar12_previous = @VD_B5[pwl]
let sar12_stimulus = vector(8)
let sar12_stimulus[0] = 0
let sar12_stimulus[1] = sar12_previous[length(sar12_previous)-1]
let sar12_stimulus[2] = 6.35009999999999e-05
let sar12_stimulus[3] = sar12_stimulus[1]
let sar12_stimulus[4] = 6.35029999999999e-05
let sar12_stimulus[5] = sar12_drive
let sar12_stimulus[6] = 0.000148
let sar12_stimulus[7] = sar12_stimulus[5]
alter @VD_B5[pwl] = sar12_stimulus
let sar12_drive = (floor(sar12_trial / 64) - 2*floor(sar12_trial / 128))*1.8
let sar12_previous = @VD_B6[pwl]
let sar12_stimulus = vector(8)
let sar12_stimulus[0] = 0
let sar12_stimulus[1] = sar12_previous[length(sar12_previous)-1]
let sar12_stimulus[2] = 6.35009999999999e-05
let sar12_stimulus[3] = sar12_stimulus[1]
let sar12_stimulus[4] = 6.35029999999999e-05
let sar12_stimulus[5] = sar12_drive
let sar12_stimulus[6] = 0.000148
let sar12_stimulus[7] = sar12_stimulus[5]
alter @VD_B6[pwl] = sar12_stimulus
let sar12_drive = (floor(sar12_trial / 128) - 2*floor(sar12_trial / 256))*1.8
let sar12_previous = @VD_B7[pwl]
let sar12_stimulus = vector(8)
let sar12_stimulus[0] = 0
let sar12_stimulus[1] = sar12_previous[length(sar12_previous)-1]
let sar12_stimulus[2] = 6.35009999999999e-05
let sar12_stimulus[3] = sar12_stimulus[1]
let sar12_stimulus[4] = 6.35029999999999e-05
let sar12_stimulus[5] = sar12_drive
let sar12_stimulus[6] = 0.000148
let sar12_stimulus[7] = sar12_stimulus[5]
alter @VD_B7[pwl] = sar12_stimulus
let sar12_drive = (floor(sar12_trial / 256) - 2*floor(sar12_trial / 512))*1.8
let sar12_previous = @VD_B8[pwl]
let sar12_stimulus = vector(8)
let sar12_stimulus[0] = 0
let sar12_stimulus[1] = sar12_previous[length(sar12_previous)-1]
let sar12_stimulus[2] = 6.35009999999999e-05
let sar12_stimulus[3] = sar12_stimulus[1]
let sar12_stimulus[4] = 6.35029999999999e-05
let sar12_stimulus[5] = sar12_drive
let sar12_stimulus[6] = 0.000148
let sar12_stimulus[7] = sar12_stimulus[5]
alter @VD_B8[pwl] = sar12_stimulus
let sar12_drive = (floor(sar12_trial / 512) - 2*floor(sar12_trial / 1024))*1.8
let sar12_previous = @VD_B9[pwl]
let sar12_stimulus = vector(8)
let sar12_stimulus[0] = 0
let sar12_stimulus[1] = sar12_previous[length(sar12_previous)-1]
let sar12_stimulus[2] = 6.35009999999999e-05
let sar12_stimulus[3] = sar12_stimulus[1]
let sar12_stimulus[4] = 6.35029999999999e-05
let sar12_stimulus[5] = sar12_drive
let sar12_stimulus[6] = 0.000148
let sar12_stimulus[7] = sar12_stimulus[5]
alter @VD_B9[pwl] = sar12_stimulus
let sar12_drive = (floor(sar12_trial / 1024) - 2*floor(sar12_trial / 2048))*1.8
let sar12_previous = @VD_B10[pwl]
let sar12_stimulus = vector(8)
let sar12_stimulus[0] = 0
let sar12_stimulus[1] = sar12_previous[length(sar12_previous)-1]
let sar12_stimulus[2] = 6.35009999999999e-05
let sar12_stimulus[3] = sar12_stimulus[1]
let sar12_stimulus[4] = 6.35029999999999e-05
let sar12_stimulus[5] = sar12_drive
let sar12_stimulus[6] = 0.000148
let sar12_stimulus[7] = sar12_stimulus[5]
alter @VD_B10[pwl] = sar12_stimulus
let sar12_drive = (floor(sar12_trial / 2048) - 2*floor(sar12_trial / 4096))*1.8
let sar12_previous = @VD_B11[pwl]
let sar12_stimulus = vector(8)
let sar12_stimulus[0] = 0
let sar12_stimulus[1] = sar12_previous[length(sar12_previous)-1]
let sar12_stimulus[2] = 6.35009999999999e-05
let sar12_stimulus[3] = sar12_stimulus[1]
let sar12_stimulus[4] = 6.35029999999999e-05
let sar12_stimulus[5] = sar12_drive
let sar12_stimulus[6] = 0.000148
let sar12_stimulus[7] = sar12_stimulus[5]
alter @VD_B11[pwl] = sar12_stimulus
let sar12_drive = (floor(sar12_trial / 4096) - 2*floor(sar12_trial / 8192))*1.8
let sar12_previous = @VD_B12[pwl]
let sar12_stimulus = vector(8)
let sar12_stimulus[0] = 0
let sar12_stimulus[1] = sar12_previous[length(sar12_previous)-1]
let sar12_stimulus[2] = 6.35009999999999e-05
let sar12_stimulus[3] = sar12_stimulus[1]
let sar12_stimulus[4] = 6.35029999999999e-05
let sar12_stimulus[5] = sar12_drive
let sar12_stimulus[6] = 0.000148
let sar12_stimulus[7] = sar12_stimulus[5]
alter @VD_B12[pwl] = sar12_stimulus
let sar12_drive = (floor(sar12_trial / 8192) - 2*floor(sar12_trial / 16384))*1.8
let sar12_previous = @VD_B13[pwl]
let sar12_stimulus = vector(8)
let sar12_stimulus[0] = 0
let sar12_stimulus[1] = sar12_previous[length(sar12_previous)-1]
let sar12_stimulus[2] = 6.35009999999999e-05
let sar12_stimulus[3] = sar12_stimulus[1]
let sar12_stimulus[4] = 6.35029999999999e-05
let sar12_stimulus[5] = sar12_drive
let sar12_stimulus[6] = 0.000148
let sar12_stimulus[7] = sar12_stimulus[5]
alter @VD_B13[pwl] = sar12_stimulus
let sar12_drive = (floor(sar12_trial / 16384) - 2*floor(sar12_trial / 32768))*1.8
let sar12_previous = @VD_B14[pwl]
let sar12_stimulus = vector(8)
let sar12_stimulus[0] = 0
let sar12_stimulus[1] = sar12_previous[length(sar12_previous)-1]
let sar12_stimulus[2] = 6.35009999999999e-05
let sar12_stimulus[3] = sar12_stimulus[1]
let sar12_stimulus[4] = 6.35029999999999e-05
let sar12_stimulus[5] = sar12_drive
let sar12_stimulus[6] = 0.000148
let sar12_stimulus[7] = sar12_stimulus[5]
alter @VD_B14[pwl] = sar12_stimulus
let sar12_drive = (floor(sar12_trial / 32768) - 2*floor(sar12_trial / 65536))*1.8
let sar12_previous = @VD_B15[pwl]
let sar12_stimulus = vector(8)
let sar12_stimulus[0] = 0
let sar12_stimulus[1] = sar12_previous[length(sar12_previous)-1]
let sar12_stimulus[2] = 6.35009999999999e-05
let sar12_stimulus[3] = sar12_stimulus[1]
let sar12_stimulus[4] = 6.35029999999999e-05
let sar12_stimulus[5] = sar12_drive
let sar12_stimulus[6] = 0.000148
let sar12_stimulus[7] = sar12_stimulus[5]
alter @VD_B15[pwl] = sar12_stimulus
resume
let sar12_k = length(time)-1
if abs(time[sar12_k] - 6.39999999999999e-05) > 1e-12
print time[sar12_k]
echo expected_pause_time_s 6.39999999999999e-05
echo SAR12_PAUSE_FAILED
quit 1
end
print time[sar12_k] >> pause-times.txt
let sar12_previous = @VD_EVAL[pwl]
let sar12_stimulus = vector(8)
let sar12_stimulus[0] = 0
let sar12_stimulus[1] = sar12_previous[length(sar12_previous)-1]
let sar12_stimulus[2] = 6.40009999999999e-05
let sar12_stimulus[3] = sar12_stimulus[1]
let sar12_stimulus[4] = 6.40029999999999e-05
let sar12_stimulus[5] = 1.8
let sar12_stimulus[6] = 0.000148
let sar12_stimulus[7] = sar12_stimulus[5]
alter @VD_EVAL[pwl] = sar12_stimulus
resume
let sar12_k = length(time)-1
if abs(time[sar12_k] - 6.44999999999999e-05) > 1e-12
print time[sar12_k]
echo expected_pause_time_s 6.44999999999999e-05
echo SAR12_PAUSE_FAILED
quit 1
end
print time[sar12_k] >> pause-times.txt
let sar12_k = length(time)-1
let sar12_cmp = v(COMP)[sar12_k]
let sar12_cmpn = v(COMPN)[sar12_k]
let sar12_p = v(TOPP)[sar12_k]
let sar12_n = v(TOPN)[sar12_k]
let sar12_decision = 0
if sar12_cmp >= 0.9
let sar12_code = sar12_trial
let sar12_decision = 1
end
echo 2 9 $&sar12_trial $&sar12_cmp $&sar12_cmpn $&sar12_p $&sar12_n -1.19994506835937 $&sar12_decision >> decisions.csv
let sar12_previous = @VD_EVAL[pwl]
let sar12_stimulus = vector(8)
let sar12_stimulus[0] = 0
let sar12_stimulus[1] = sar12_previous[length(sar12_previous)-1]
let sar12_stimulus[2] = 6.45009999999999e-05
let sar12_stimulus[3] = sar12_stimulus[1]
let sar12_stimulus[4] = 6.45029999999999e-05
let sar12_stimulus[5] = 0
let sar12_stimulus[6] = 0.000148
let sar12_stimulus[7] = sar12_stimulus[5]
alter @VD_EVAL[pwl] = sar12_stimulus
let sar12_trial = sar12_code + 256
let sar12_drive = (floor(sar12_trial / 1) - 2*floor(sar12_trial / 2))*1.8
let sar12_previous = @VD_B0[pwl]
let sar12_stimulus = vector(8)
let sar12_stimulus[0] = 0
let sar12_stimulus[1] = sar12_previous[length(sar12_previous)-1]
let sar12_stimulus[2] = 6.45009999999999e-05
let sar12_stimulus[3] = sar12_stimulus[1]
let sar12_stimulus[4] = 6.45029999999999e-05
let sar12_stimulus[5] = sar12_drive
let sar12_stimulus[6] = 0.000148
let sar12_stimulus[7] = sar12_stimulus[5]
alter @VD_B0[pwl] = sar12_stimulus
let sar12_drive = (floor(sar12_trial / 2) - 2*floor(sar12_trial / 4))*1.8
let sar12_previous = @VD_B1[pwl]
let sar12_stimulus = vector(8)
let sar12_stimulus[0] = 0
let sar12_stimulus[1] = sar12_previous[length(sar12_previous)-1]
let sar12_stimulus[2] = 6.45009999999999e-05
let sar12_stimulus[3] = sar12_stimulus[1]
let sar12_stimulus[4] = 6.45029999999999e-05
let sar12_stimulus[5] = sar12_drive
let sar12_stimulus[6] = 0.000148
let sar12_stimulus[7] = sar12_stimulus[5]
alter @VD_B1[pwl] = sar12_stimulus
let sar12_drive = (floor(sar12_trial / 4) - 2*floor(sar12_trial / 8))*1.8
let sar12_previous = @VD_B2[pwl]
let sar12_stimulus = vector(8)
let sar12_stimulus[0] = 0
let sar12_stimulus[1] = sar12_previous[length(sar12_previous)-1]
let sar12_stimulus[2] = 6.45009999999999e-05
let sar12_stimulus[3] = sar12_stimulus[1]
let sar12_stimulus[4] = 6.45029999999999e-05
let sar12_stimulus[5] = sar12_drive
let sar12_stimulus[6] = 0.000148
let sar12_stimulus[7] = sar12_stimulus[5]
alter @VD_B2[pwl] = sar12_stimulus
let sar12_drive = (floor(sar12_trial / 8) - 2*floor(sar12_trial / 16))*1.8
let sar12_previous = @VD_B3[pwl]
let sar12_stimulus = vector(8)
let sar12_stimulus[0] = 0
let sar12_stimulus[1] = sar12_previous[length(sar12_previous)-1]
let sar12_stimulus[2] = 6.45009999999999e-05
let sar12_stimulus[3] = sar12_stimulus[1]
let sar12_stimulus[4] = 6.45029999999999e-05
let sar12_stimulus[5] = sar12_drive
let sar12_stimulus[6] = 0.000148
let sar12_stimulus[7] = sar12_stimulus[5]
alter @VD_B3[pwl] = sar12_stimulus
let sar12_drive = (floor(sar12_trial / 16) - 2*floor(sar12_trial / 32))*1.8
let sar12_previous = @VD_B4[pwl]
let sar12_stimulus = vector(8)
let sar12_stimulus[0] = 0
let sar12_stimulus[1] = sar12_previous[length(sar12_previous)-1]
let sar12_stimulus[2] = 6.45009999999999e-05
let sar12_stimulus[3] = sar12_stimulus[1]
let sar12_stimulus[4] = 6.45029999999999e-05
let sar12_stimulus[5] = sar12_drive
let sar12_stimulus[6] = 0.000148
let sar12_stimulus[7] = sar12_stimulus[5]
alter @VD_B4[pwl] = sar12_stimulus
let sar12_drive = (floor(sar12_trial / 32) - 2*floor(sar12_trial / 64))*1.8
let sar12_previous = @VD_B5[pwl]
let sar12_stimulus = vector(8)
let sar12_stimulus[0] = 0
let sar12_stimulus[1] = sar12_previous[length(sar12_previous)-1]
let sar12_stimulus[2] = 6.45009999999999e-05
let sar12_stimulus[3] = sar12_stimulus[1]
let sar12_stimulus[4] = 6.45029999999999e-05
let sar12_stimulus[5] = sar12_drive
let sar12_stimulus[6] = 0.000148
let sar12_stimulus[7] = sar12_stimulus[5]
alter @VD_B5[pwl] = sar12_stimulus
let sar12_drive = (floor(sar12_trial / 64) - 2*floor(sar12_trial / 128))*1.8
let sar12_previous = @VD_B6[pwl]
let sar12_stimulus = vector(8)
let sar12_stimulus[0] = 0
let sar12_stimulus[1] = sar12_previous[length(sar12_previous)-1]
let sar12_stimulus[2] = 6.45009999999999e-05
let sar12_stimulus[3] = sar12_stimulus[1]
let sar12_stimulus[4] = 6.45029999999999e-05
let sar12_stimulus[5] = sar12_drive
let sar12_stimulus[6] = 0.000148
let sar12_stimulus[7] = sar12_stimulus[5]
alter @VD_B6[pwl] = sar12_stimulus
let sar12_drive = (floor(sar12_trial / 128) - 2*floor(sar12_trial / 256))*1.8
let sar12_previous = @VD_B7[pwl]
let sar12_stimulus = vector(8)
let sar12_stimulus[0] = 0
let sar12_stimulus[1] = sar12_previous[length(sar12_previous)-1]
let sar12_stimulus[2] = 6.45009999999999e-05
let sar12_stimulus[3] = sar12_stimulus[1]
let sar12_stimulus[4] = 6.45029999999999e-05
let sar12_stimulus[5] = sar12_drive
let sar12_stimulus[6] = 0.000148
let sar12_stimulus[7] = sar12_stimulus[5]
alter @VD_B7[pwl] = sar12_stimulus
let sar12_drive = (floor(sar12_trial / 256) - 2*floor(sar12_trial / 512))*1.8
let sar12_previous = @VD_B8[pwl]
let sar12_stimulus = vector(8)
let sar12_stimulus[0] = 0
let sar12_stimulus[1] = sar12_previous[length(sar12_previous)-1]
let sar12_stimulus[2] = 6.45009999999999e-05
let sar12_stimulus[3] = sar12_stimulus[1]
let sar12_stimulus[4] = 6.45029999999999e-05
let sar12_stimulus[5] = sar12_drive
let sar12_stimulus[6] = 0.000148
let sar12_stimulus[7] = sar12_stimulus[5]
alter @VD_B8[pwl] = sar12_stimulus
let sar12_drive = (floor(sar12_trial / 512) - 2*floor(sar12_trial / 1024))*1.8
let sar12_previous = @VD_B9[pwl]
let sar12_stimulus = vector(8)
let sar12_stimulus[0] = 0
let sar12_stimulus[1] = sar12_previous[length(sar12_previous)-1]
let sar12_stimulus[2] = 6.45009999999999e-05
let sar12_stimulus[3] = sar12_stimulus[1]
let sar12_stimulus[4] = 6.45029999999999e-05
let sar12_stimulus[5] = sar12_drive
let sar12_stimulus[6] = 0.000148
let sar12_stimulus[7] = sar12_stimulus[5]
alter @VD_B9[pwl] = sar12_stimulus
let sar12_drive = (floor(sar12_trial / 1024) - 2*floor(sar12_trial / 2048))*1.8
let sar12_previous = @VD_B10[pwl]
let sar12_stimulus = vector(8)
let sar12_stimulus[0] = 0
let sar12_stimulus[1] = sar12_previous[length(sar12_previous)-1]
let sar12_stimulus[2] = 6.45009999999999e-05
let sar12_stimulus[3] = sar12_stimulus[1]
let sar12_stimulus[4] = 6.45029999999999e-05
let sar12_stimulus[5] = sar12_drive
let sar12_stimulus[6] = 0.000148
let sar12_stimulus[7] = sar12_stimulus[5]
alter @VD_B10[pwl] = sar12_stimulus
let sar12_drive = (floor(sar12_trial / 2048) - 2*floor(sar12_trial / 4096))*1.8
let sar12_previous = @VD_B11[pwl]
let sar12_stimulus = vector(8)
let sar12_stimulus[0] = 0
let sar12_stimulus[1] = sar12_previous[length(sar12_previous)-1]
let sar12_stimulus[2] = 6.45009999999999e-05
let sar12_stimulus[3] = sar12_stimulus[1]
let sar12_stimulus[4] = 6.45029999999999e-05
let sar12_stimulus[5] = sar12_drive
let sar12_stimulus[6] = 0.000148
let sar12_stimulus[7] = sar12_stimulus[5]
alter @VD_B11[pwl] = sar12_stimulus
let sar12_drive = (floor(sar12_trial / 4096) - 2*floor(sar12_trial / 8192))*1.8
let sar12_previous = @VD_B12[pwl]
let sar12_stimulus = vector(8)
let sar12_stimulus[0] = 0
let sar12_stimulus[1] = sar12_previous[length(sar12_previous)-1]
let sar12_stimulus[2] = 6.45009999999999e-05
let sar12_stimulus[3] = sar12_stimulus[1]
let sar12_stimulus[4] = 6.45029999999999e-05
let sar12_stimulus[5] = sar12_drive
let sar12_stimulus[6] = 0.000148
let sar12_stimulus[7] = sar12_stimulus[5]
alter @VD_B12[pwl] = sar12_stimulus
let sar12_drive = (floor(sar12_trial / 8192) - 2*floor(sar12_trial / 16384))*1.8
let sar12_previous = @VD_B13[pwl]
let sar12_stimulus = vector(8)
let sar12_stimulus[0] = 0
let sar12_stimulus[1] = sar12_previous[length(sar12_previous)-1]
let sar12_stimulus[2] = 6.45009999999999e-05
let sar12_stimulus[3] = sar12_stimulus[1]
let sar12_stimulus[4] = 6.45029999999999e-05
let sar12_stimulus[5] = sar12_drive
let sar12_stimulus[6] = 0.000148
let sar12_stimulus[7] = sar12_stimulus[5]
alter @VD_B13[pwl] = sar12_stimulus
let sar12_drive = (floor(sar12_trial / 16384) - 2*floor(sar12_trial / 32768))*1.8
let sar12_previous = @VD_B14[pwl]
let sar12_stimulus = vector(8)
let sar12_stimulus[0] = 0
let sar12_stimulus[1] = sar12_previous[length(sar12_previous)-1]
let sar12_stimulus[2] = 6.45009999999999e-05
let sar12_stimulus[3] = sar12_stimulus[1]
let sar12_stimulus[4] = 6.45029999999999e-05
let sar12_stimulus[5] = sar12_drive
let sar12_stimulus[6] = 0.000148
let sar12_stimulus[7] = sar12_stimulus[5]
alter @VD_B14[pwl] = sar12_stimulus
let sar12_drive = (floor(sar12_trial / 32768) - 2*floor(sar12_trial / 65536))*1.8
let sar12_previous = @VD_B15[pwl]
let sar12_stimulus = vector(8)
let sar12_stimulus[0] = 0
let sar12_stimulus[1] = sar12_previous[length(sar12_previous)-1]
let sar12_stimulus[2] = 6.45009999999999e-05
let sar12_stimulus[3] = sar12_stimulus[1]
let sar12_stimulus[4] = 6.45029999999999e-05
let sar12_stimulus[5] = sar12_drive
let sar12_stimulus[6] = 0.000148
let sar12_stimulus[7] = sar12_stimulus[5]
alter @VD_B15[pwl] = sar12_stimulus
resume
let sar12_k = length(time)-1
if abs(time[sar12_k] - 6.49999999999999e-05) > 1e-12
print time[sar12_k]
echo expected_pause_time_s 6.49999999999999e-05
echo SAR12_PAUSE_FAILED
quit 1
end
print time[sar12_k] >> pause-times.txt
let sar12_previous = @VD_EVAL[pwl]
let sar12_stimulus = vector(8)
let sar12_stimulus[0] = 0
let sar12_stimulus[1] = sar12_previous[length(sar12_previous)-1]
let sar12_stimulus[2] = 6.50009999999999e-05
let sar12_stimulus[3] = sar12_stimulus[1]
let sar12_stimulus[4] = 6.50029999999999e-05
let sar12_stimulus[5] = 1.8
let sar12_stimulus[6] = 0.000148
let sar12_stimulus[7] = sar12_stimulus[5]
alter @VD_EVAL[pwl] = sar12_stimulus
resume
let sar12_k = length(time)-1
if abs(time[sar12_k] - 6.54999999999999e-05) > 1e-12
print time[sar12_k]
echo expected_pause_time_s 6.54999999999999e-05
echo SAR12_PAUSE_FAILED
quit 1
end
print time[sar12_k] >> pause-times.txt
let sar12_k = length(time)-1
let sar12_cmp = v(COMP)[sar12_k]
let sar12_cmpn = v(COMPN)[sar12_k]
let sar12_p = v(TOPP)[sar12_k]
let sar12_n = v(TOPN)[sar12_k]
let sar12_decision = 0
if sar12_cmp >= 0.9
let sar12_code = sar12_trial
let sar12_decision = 1
end
echo 2 8 $&sar12_trial $&sar12_cmp $&sar12_cmpn $&sar12_p $&sar12_n -1.19994506835937 $&sar12_decision >> decisions.csv
let sar12_previous = @VD_EVAL[pwl]
let sar12_stimulus = vector(8)
let sar12_stimulus[0] = 0
let sar12_stimulus[1] = sar12_previous[length(sar12_previous)-1]
let sar12_stimulus[2] = 6.55009999999999e-05
let sar12_stimulus[3] = sar12_stimulus[1]
let sar12_stimulus[4] = 6.55029999999999e-05
let sar12_stimulus[5] = 0
let sar12_stimulus[6] = 0.000148
let sar12_stimulus[7] = sar12_stimulus[5]
alter @VD_EVAL[pwl] = sar12_stimulus
let sar12_trial = sar12_code + 128
let sar12_drive = (floor(sar12_trial / 1) - 2*floor(sar12_trial / 2))*1.8
let sar12_previous = @VD_B0[pwl]
let sar12_stimulus = vector(8)
let sar12_stimulus[0] = 0
let sar12_stimulus[1] = sar12_previous[length(sar12_previous)-1]
let sar12_stimulus[2] = 6.55009999999999e-05
let sar12_stimulus[3] = sar12_stimulus[1]
let sar12_stimulus[4] = 6.55029999999999e-05
let sar12_stimulus[5] = sar12_drive
let sar12_stimulus[6] = 0.000148
let sar12_stimulus[7] = sar12_stimulus[5]
alter @VD_B0[pwl] = sar12_stimulus
let sar12_drive = (floor(sar12_trial / 2) - 2*floor(sar12_trial / 4))*1.8
let sar12_previous = @VD_B1[pwl]
let sar12_stimulus = vector(8)
let sar12_stimulus[0] = 0
let sar12_stimulus[1] = sar12_previous[length(sar12_previous)-1]
let sar12_stimulus[2] = 6.55009999999999e-05
let sar12_stimulus[3] = sar12_stimulus[1]
let sar12_stimulus[4] = 6.55029999999999e-05
let sar12_stimulus[5] = sar12_drive
let sar12_stimulus[6] = 0.000148
let sar12_stimulus[7] = sar12_stimulus[5]
alter @VD_B1[pwl] = sar12_stimulus
let sar12_drive = (floor(sar12_trial / 4) - 2*floor(sar12_trial / 8))*1.8
let sar12_previous = @VD_B2[pwl]
let sar12_stimulus = vector(8)
let sar12_stimulus[0] = 0
let sar12_stimulus[1] = sar12_previous[length(sar12_previous)-1]
let sar12_stimulus[2] = 6.55009999999999e-05
let sar12_stimulus[3] = sar12_stimulus[1]
let sar12_stimulus[4] = 6.55029999999999e-05
let sar12_stimulus[5] = sar12_drive
let sar12_stimulus[6] = 0.000148
let sar12_stimulus[7] = sar12_stimulus[5]
alter @VD_B2[pwl] = sar12_stimulus
let sar12_drive = (floor(sar12_trial / 8) - 2*floor(sar12_trial / 16))*1.8
let sar12_previous = @VD_B3[pwl]
let sar12_stimulus = vector(8)
let sar12_stimulus[0] = 0
let sar12_stimulus[1] = sar12_previous[length(sar12_previous)-1]
let sar12_stimulus[2] = 6.55009999999999e-05
let sar12_stimulus[3] = sar12_stimulus[1]
let sar12_stimulus[4] = 6.55029999999999e-05
let sar12_stimulus[5] = sar12_drive
let sar12_stimulus[6] = 0.000148
let sar12_stimulus[7] = sar12_stimulus[5]
alter @VD_B3[pwl] = sar12_stimulus
let sar12_drive = (floor(sar12_trial / 16) - 2*floor(sar12_trial / 32))*1.8
let sar12_previous = @VD_B4[pwl]
let sar12_stimulus = vector(8)
let sar12_stimulus[0] = 0
let sar12_stimulus[1] = sar12_previous[length(sar12_previous)-1]
let sar12_stimulus[2] = 6.55009999999999e-05
let sar12_stimulus[3] = sar12_stimulus[1]
let sar12_stimulus[4] = 6.55029999999999e-05
let sar12_stimulus[5] = sar12_drive
let sar12_stimulus[6] = 0.000148
let sar12_stimulus[7] = sar12_stimulus[5]
alter @VD_B4[pwl] = sar12_stimulus
let sar12_drive = (floor(sar12_trial / 32) - 2*floor(sar12_trial / 64))*1.8
let sar12_previous = @VD_B5[pwl]
let sar12_stimulus = vector(8)
let sar12_stimulus[0] = 0
let sar12_stimulus[1] = sar12_previous[length(sar12_previous)-1]
let sar12_stimulus[2] = 6.55009999999999e-05
let sar12_stimulus[3] = sar12_stimulus[1]
let sar12_stimulus[4] = 6.55029999999999e-05
let sar12_stimulus[5] = sar12_drive
let sar12_stimulus[6] = 0.000148
let sar12_stimulus[7] = sar12_stimulus[5]
alter @VD_B5[pwl] = sar12_stimulus
let sar12_drive = (floor(sar12_trial / 64) - 2*floor(sar12_trial / 128))*1.8
let sar12_previous = @VD_B6[pwl]
let sar12_stimulus = vector(8)
let sar12_stimulus[0] = 0
let sar12_stimulus[1] = sar12_previous[length(sar12_previous)-1]
let sar12_stimulus[2] = 6.55009999999999e-05
let sar12_stimulus[3] = sar12_stimulus[1]
let sar12_stimulus[4] = 6.55029999999999e-05
let sar12_stimulus[5] = sar12_drive
let sar12_stimulus[6] = 0.000148
let sar12_stimulus[7] = sar12_stimulus[5]
alter @VD_B6[pwl] = sar12_stimulus
let sar12_drive = (floor(sar12_trial / 128) - 2*floor(sar12_trial / 256))*1.8
let sar12_previous = @VD_B7[pwl]
let sar12_stimulus = vector(8)
let sar12_stimulus[0] = 0
let sar12_stimulus[1] = sar12_previous[length(sar12_previous)-1]
let sar12_stimulus[2] = 6.55009999999999e-05
let sar12_stimulus[3] = sar12_stimulus[1]
let sar12_stimulus[4] = 6.55029999999999e-05
let sar12_stimulus[5] = sar12_drive
let sar12_stimulus[6] = 0.000148
let sar12_stimulus[7] = sar12_stimulus[5]
alter @VD_B7[pwl] = sar12_stimulus
let sar12_drive = (floor(sar12_trial / 256) - 2*floor(sar12_trial / 512))*1.8
let sar12_previous = @VD_B8[pwl]
let sar12_stimulus = vector(8)
let sar12_stimulus[0] = 0
let sar12_stimulus[1] = sar12_previous[length(sar12_previous)-1]
let sar12_stimulus[2] = 6.55009999999999e-05
let sar12_stimulus[3] = sar12_stimulus[1]
let sar12_stimulus[4] = 6.55029999999999e-05
let sar12_stimulus[5] = sar12_drive
let sar12_stimulus[6] = 0.000148
let sar12_stimulus[7] = sar12_stimulus[5]
alter @VD_B8[pwl] = sar12_stimulus
let sar12_drive = (floor(sar12_trial / 512) - 2*floor(sar12_trial / 1024))*1.8
let sar12_previous = @VD_B9[pwl]
let sar12_stimulus = vector(8)
let sar12_stimulus[0] = 0
let sar12_stimulus[1] = sar12_previous[length(sar12_previous)-1]
let sar12_stimulus[2] = 6.55009999999999e-05
let sar12_stimulus[3] = sar12_stimulus[1]
let sar12_stimulus[4] = 6.55029999999999e-05
let sar12_stimulus[5] = sar12_drive
let sar12_stimulus[6] = 0.000148
let sar12_stimulus[7] = sar12_stimulus[5]
alter @VD_B9[pwl] = sar12_stimulus
let sar12_drive = (floor(sar12_trial / 1024) - 2*floor(sar12_trial / 2048))*1.8
let sar12_previous = @VD_B10[pwl]
let sar12_stimulus = vector(8)
let sar12_stimulus[0] = 0
let sar12_stimulus[1] = sar12_previous[length(sar12_previous)-1]
let sar12_stimulus[2] = 6.55009999999999e-05
let sar12_stimulus[3] = sar12_stimulus[1]
let sar12_stimulus[4] = 6.55029999999999e-05
let sar12_stimulus[5] = sar12_drive
let sar12_stimulus[6] = 0.000148
let sar12_stimulus[7] = sar12_stimulus[5]
alter @VD_B10[pwl] = sar12_stimulus
let sar12_drive = (floor(sar12_trial / 2048) - 2*floor(sar12_trial / 4096))*1.8
let sar12_previous = @VD_B11[pwl]
let sar12_stimulus = vector(8)
let sar12_stimulus[0] = 0
let sar12_stimulus[1] = sar12_previous[length(sar12_previous)-1]
let sar12_stimulus[2] = 6.55009999999999e-05
let sar12_stimulus[3] = sar12_stimulus[1]
let sar12_stimulus[4] = 6.55029999999999e-05
let sar12_stimulus[5] = sar12_drive
let sar12_stimulus[6] = 0.000148
let sar12_stimulus[7] = sar12_stimulus[5]
alter @VD_B11[pwl] = sar12_stimulus
let sar12_drive = (floor(sar12_trial / 4096) - 2*floor(sar12_trial / 8192))*1.8
let sar12_previous = @VD_B12[pwl]
let sar12_stimulus = vector(8)
let sar12_stimulus[0] = 0
let sar12_stimulus[1] = sar12_previous[length(sar12_previous)-1]
let sar12_stimulus[2] = 6.55009999999999e-05
let sar12_stimulus[3] = sar12_stimulus[1]
let sar12_stimulus[4] = 6.55029999999999e-05
let sar12_stimulus[5] = sar12_drive
let sar12_stimulus[6] = 0.000148
let sar12_stimulus[7] = sar12_stimulus[5]
alter @VD_B12[pwl] = sar12_stimulus
let sar12_drive = (floor(sar12_trial / 8192) - 2*floor(sar12_trial / 16384))*1.8
let sar12_previous = @VD_B13[pwl]
let sar12_stimulus = vector(8)
let sar12_stimulus[0] = 0
let sar12_stimulus[1] = sar12_previous[length(sar12_previous)-1]
let sar12_stimulus[2] = 6.55009999999999e-05
let sar12_stimulus[3] = sar12_stimulus[1]
let sar12_stimulus[4] = 6.55029999999999e-05
let sar12_stimulus[5] = sar12_drive
let sar12_stimulus[6] = 0.000148
let sar12_stimulus[7] = sar12_stimulus[5]
alter @VD_B13[pwl] = sar12_stimulus
let sar12_drive = (floor(sar12_trial / 16384) - 2*floor(sar12_trial / 32768))*1.8
let sar12_previous = @VD_B14[pwl]
let sar12_stimulus = vector(8)
let sar12_stimulus[0] = 0
let sar12_stimulus[1] = sar12_previous[length(sar12_previous)-1]
let sar12_stimulus[2] = 6.55009999999999e-05
let sar12_stimulus[3] = sar12_stimulus[1]
let sar12_stimulus[4] = 6.55029999999999e-05
let sar12_stimulus[5] = sar12_drive
let sar12_stimulus[6] = 0.000148
let sar12_stimulus[7] = sar12_stimulus[5]
alter @VD_B14[pwl] = sar12_stimulus
let sar12_drive = (floor(sar12_trial / 32768) - 2*floor(sar12_trial / 65536))*1.8
let sar12_previous = @VD_B15[pwl]
let sar12_stimulus = vector(8)
let sar12_stimulus[0] = 0
let sar12_stimulus[1] = sar12_previous[length(sar12_previous)-1]
let sar12_stimulus[2] = 6.55009999999999e-05
let sar12_stimulus[3] = sar12_stimulus[1]
let sar12_stimulus[4] = 6.55029999999999e-05
let sar12_stimulus[5] = sar12_drive
let sar12_stimulus[6] = 0.000148
let sar12_stimulus[7] = sar12_stimulus[5]
alter @VD_B15[pwl] = sar12_stimulus
resume
let sar12_k = length(time)-1
if abs(time[sar12_k] - 6.59999999999999e-05) > 1e-12
print time[sar12_k]
echo expected_pause_time_s 6.59999999999999e-05
echo SAR12_PAUSE_FAILED
quit 1
end
print time[sar12_k] >> pause-times.txt
let sar12_previous = @VD_EVAL[pwl]
let sar12_stimulus = vector(8)
let sar12_stimulus[0] = 0
let sar12_stimulus[1] = sar12_previous[length(sar12_previous)-1]
let sar12_stimulus[2] = 6.60009999999999e-05
let sar12_stimulus[3] = sar12_stimulus[1]
let sar12_stimulus[4] = 6.60029999999999e-05
let sar12_stimulus[5] = 1.8
let sar12_stimulus[6] = 0.000148
let sar12_stimulus[7] = sar12_stimulus[5]
alter @VD_EVAL[pwl] = sar12_stimulus
resume
let sar12_k = length(time)-1
if abs(time[sar12_k] - 6.64999999999999e-05) > 1e-12
print time[sar12_k]
echo expected_pause_time_s 6.64999999999999e-05
echo SAR12_PAUSE_FAILED
quit 1
end
print time[sar12_k] >> pause-times.txt
let sar12_k = length(time)-1
let sar12_cmp = v(COMP)[sar12_k]
let sar12_cmpn = v(COMPN)[sar12_k]
let sar12_p = v(TOPP)[sar12_k]
let sar12_n = v(TOPN)[sar12_k]
let sar12_decision = 0
if sar12_cmp >= 0.9
let sar12_code = sar12_trial
let sar12_decision = 1
end
echo 2 7 $&sar12_trial $&sar12_cmp $&sar12_cmpn $&sar12_p $&sar12_n -1.19994506835937 $&sar12_decision >> decisions.csv
let sar12_previous = @VD_EVAL[pwl]
let sar12_stimulus = vector(8)
let sar12_stimulus[0] = 0
let sar12_stimulus[1] = sar12_previous[length(sar12_previous)-1]
let sar12_stimulus[2] = 6.65009999999999e-05
let sar12_stimulus[3] = sar12_stimulus[1]
let sar12_stimulus[4] = 6.65029999999999e-05
let sar12_stimulus[5] = 0
let sar12_stimulus[6] = 0.000148
let sar12_stimulus[7] = sar12_stimulus[5]
alter @VD_EVAL[pwl] = sar12_stimulus
let sar12_trial = sar12_code + 64
let sar12_drive = (floor(sar12_trial / 1) - 2*floor(sar12_trial / 2))*1.8
let sar12_previous = @VD_B0[pwl]
let sar12_stimulus = vector(8)
let sar12_stimulus[0] = 0
let sar12_stimulus[1] = sar12_previous[length(sar12_previous)-1]
let sar12_stimulus[2] = 6.65009999999999e-05
let sar12_stimulus[3] = sar12_stimulus[1]
let sar12_stimulus[4] = 6.65029999999999e-05
let sar12_stimulus[5] = sar12_drive
let sar12_stimulus[6] = 0.000148
let sar12_stimulus[7] = sar12_stimulus[5]
alter @VD_B0[pwl] = sar12_stimulus
let sar12_drive = (floor(sar12_trial / 2) - 2*floor(sar12_trial / 4))*1.8
let sar12_previous = @VD_B1[pwl]
let sar12_stimulus = vector(8)
let sar12_stimulus[0] = 0
let sar12_stimulus[1] = sar12_previous[length(sar12_previous)-1]
let sar12_stimulus[2] = 6.65009999999999e-05
let sar12_stimulus[3] = sar12_stimulus[1]
let sar12_stimulus[4] = 6.65029999999999e-05
let sar12_stimulus[5] = sar12_drive
let sar12_stimulus[6] = 0.000148
let sar12_stimulus[7] = sar12_stimulus[5]
alter @VD_B1[pwl] = sar12_stimulus
let sar12_drive = (floor(sar12_trial / 4) - 2*floor(sar12_trial / 8))*1.8
let sar12_previous = @VD_B2[pwl]
let sar12_stimulus = vector(8)
let sar12_stimulus[0] = 0
let sar12_stimulus[1] = sar12_previous[length(sar12_previous)-1]
let sar12_stimulus[2] = 6.65009999999999e-05
let sar12_stimulus[3] = sar12_stimulus[1]
let sar12_stimulus[4] = 6.65029999999999e-05
let sar12_stimulus[5] = sar12_drive
let sar12_stimulus[6] = 0.000148
let sar12_stimulus[7] = sar12_stimulus[5]
alter @VD_B2[pwl] = sar12_stimulus
let sar12_drive = (floor(sar12_trial / 8) - 2*floor(sar12_trial / 16))*1.8
let sar12_previous = @VD_B3[pwl]
let sar12_stimulus = vector(8)
let sar12_stimulus[0] = 0
let sar12_stimulus[1] = sar12_previous[length(sar12_previous)-1]
let sar12_stimulus[2] = 6.65009999999999e-05
let sar12_stimulus[3] = sar12_stimulus[1]
let sar12_stimulus[4] = 6.65029999999999e-05
let sar12_stimulus[5] = sar12_drive
let sar12_stimulus[6] = 0.000148
let sar12_stimulus[7] = sar12_stimulus[5]
alter @VD_B3[pwl] = sar12_stimulus
let sar12_drive = (floor(sar12_trial / 16) - 2*floor(sar12_trial / 32))*1.8
let sar12_previous = @VD_B4[pwl]
let sar12_stimulus = vector(8)
let sar12_stimulus[0] = 0
let sar12_stimulus[1] = sar12_previous[length(sar12_previous)-1]
let sar12_stimulus[2] = 6.65009999999999e-05
let sar12_stimulus[3] = sar12_stimulus[1]
let sar12_stimulus[4] = 6.65029999999999e-05
let sar12_stimulus[5] = sar12_drive
let sar12_stimulus[6] = 0.000148
let sar12_stimulus[7] = sar12_stimulus[5]
alter @VD_B4[pwl] = sar12_stimulus
let sar12_drive = (floor(sar12_trial / 32) - 2*floor(sar12_trial / 64))*1.8
let sar12_previous = @VD_B5[pwl]
let sar12_stimulus = vector(8)
let sar12_stimulus[0] = 0
let sar12_stimulus[1] = sar12_previous[length(sar12_previous)-1]
let sar12_stimulus[2] = 6.65009999999999e-05
let sar12_stimulus[3] = sar12_stimulus[1]
let sar12_stimulus[4] = 6.65029999999999e-05
let sar12_stimulus[5] = sar12_drive
let sar12_stimulus[6] = 0.000148
let sar12_stimulus[7] = sar12_stimulus[5]
alter @VD_B5[pwl] = sar12_stimulus
let sar12_drive = (floor(sar12_trial / 64) - 2*floor(sar12_trial / 128))*1.8
let sar12_previous = @VD_B6[pwl]
let sar12_stimulus = vector(8)
let sar12_stimulus[0] = 0
let sar12_stimulus[1] = sar12_previous[length(sar12_previous)-1]
let sar12_stimulus[2] = 6.65009999999999e-05
let sar12_stimulus[3] = sar12_stimulus[1]
let sar12_stimulus[4] = 6.65029999999999e-05
let sar12_stimulus[5] = sar12_drive
let sar12_stimulus[6] = 0.000148
let sar12_stimulus[7] = sar12_stimulus[5]
alter @VD_B6[pwl] = sar12_stimulus
let sar12_drive = (floor(sar12_trial / 128) - 2*floor(sar12_trial / 256))*1.8
let sar12_previous = @VD_B7[pwl]
let sar12_stimulus = vector(8)
let sar12_stimulus[0] = 0
let sar12_stimulus[1] = sar12_previous[length(sar12_previous)-1]
let sar12_stimulus[2] = 6.65009999999999e-05
let sar12_stimulus[3] = sar12_stimulus[1]
let sar12_stimulus[4] = 6.65029999999999e-05
let sar12_stimulus[5] = sar12_drive
let sar12_stimulus[6] = 0.000148
let sar12_stimulus[7] = sar12_stimulus[5]
alter @VD_B7[pwl] = sar12_stimulus
let sar12_drive = (floor(sar12_trial / 256) - 2*floor(sar12_trial / 512))*1.8
let sar12_previous = @VD_B8[pwl]
let sar12_stimulus = vector(8)
let sar12_stimulus[0] = 0
let sar12_stimulus[1] = sar12_previous[length(sar12_previous)-1]
let sar12_stimulus[2] = 6.65009999999999e-05
let sar12_stimulus[3] = sar12_stimulus[1]
let sar12_stimulus[4] = 6.65029999999999e-05
let sar12_stimulus[5] = sar12_drive
let sar12_stimulus[6] = 0.000148
let sar12_stimulus[7] = sar12_stimulus[5]
alter @VD_B8[pwl] = sar12_stimulus
let sar12_drive = (floor(sar12_trial / 512) - 2*floor(sar12_trial / 1024))*1.8
let sar12_previous = @VD_B9[pwl]
let sar12_stimulus = vector(8)
let sar12_stimulus[0] = 0
let sar12_stimulus[1] = sar12_previous[length(sar12_previous)-1]
let sar12_stimulus[2] = 6.65009999999999e-05
let sar12_stimulus[3] = sar12_stimulus[1]
let sar12_stimulus[4] = 6.65029999999999e-05
let sar12_stimulus[5] = sar12_drive
let sar12_stimulus[6] = 0.000148
let sar12_stimulus[7] = sar12_stimulus[5]
alter @VD_B9[pwl] = sar12_stimulus
let sar12_drive = (floor(sar12_trial / 1024) - 2*floor(sar12_trial / 2048))*1.8
let sar12_previous = @VD_B10[pwl]
let sar12_stimulus = vector(8)
let sar12_stimulus[0] = 0
let sar12_stimulus[1] = sar12_previous[length(sar12_previous)-1]
let sar12_stimulus[2] = 6.65009999999999e-05
let sar12_stimulus[3] = sar12_stimulus[1]
let sar12_stimulus[4] = 6.65029999999999e-05
let sar12_stimulus[5] = sar12_drive
let sar12_stimulus[6] = 0.000148
let sar12_stimulus[7] = sar12_stimulus[5]
alter @VD_B10[pwl] = sar12_stimulus
let sar12_drive = (floor(sar12_trial / 2048) - 2*floor(sar12_trial / 4096))*1.8
let sar12_previous = @VD_B11[pwl]
let sar12_stimulus = vector(8)
let sar12_stimulus[0] = 0
let sar12_stimulus[1] = sar12_previous[length(sar12_previous)-1]
let sar12_stimulus[2] = 6.65009999999999e-05
let sar12_stimulus[3] = sar12_stimulus[1]
let sar12_stimulus[4] = 6.65029999999999e-05
let sar12_stimulus[5] = sar12_drive
let sar12_stimulus[6] = 0.000148
let sar12_stimulus[7] = sar12_stimulus[5]
alter @VD_B11[pwl] = sar12_stimulus
let sar12_drive = (floor(sar12_trial / 4096) - 2*floor(sar12_trial / 8192))*1.8
let sar12_previous = @VD_B12[pwl]
let sar12_stimulus = vector(8)
let sar12_stimulus[0] = 0
let sar12_stimulus[1] = sar12_previous[length(sar12_previous)-1]
let sar12_stimulus[2] = 6.65009999999999e-05
let sar12_stimulus[3] = sar12_stimulus[1]
let sar12_stimulus[4] = 6.65029999999999e-05
let sar12_stimulus[5] = sar12_drive
let sar12_stimulus[6] = 0.000148
let sar12_stimulus[7] = sar12_stimulus[5]
alter @VD_B12[pwl] = sar12_stimulus
let sar12_drive = (floor(sar12_trial / 8192) - 2*floor(sar12_trial / 16384))*1.8
let sar12_previous = @VD_B13[pwl]
let sar12_stimulus = vector(8)
let sar12_stimulus[0] = 0
let sar12_stimulus[1] = sar12_previous[length(sar12_previous)-1]
let sar12_stimulus[2] = 6.65009999999999e-05
let sar12_stimulus[3] = sar12_stimulus[1]
let sar12_stimulus[4] = 6.65029999999999e-05
let sar12_stimulus[5] = sar12_drive
let sar12_stimulus[6] = 0.000148
let sar12_stimulus[7] = sar12_stimulus[5]
alter @VD_B13[pwl] = sar12_stimulus
let sar12_drive = (floor(sar12_trial / 16384) - 2*floor(sar12_trial / 32768))*1.8
let sar12_previous = @VD_B14[pwl]
let sar12_stimulus = vector(8)
let sar12_stimulus[0] = 0
let sar12_stimulus[1] = sar12_previous[length(sar12_previous)-1]
let sar12_stimulus[2] = 6.65009999999999e-05
let sar12_stimulus[3] = sar12_stimulus[1]
let sar12_stimulus[4] = 6.65029999999999e-05
let sar12_stimulus[5] = sar12_drive
let sar12_stimulus[6] = 0.000148
let sar12_stimulus[7] = sar12_stimulus[5]
alter @VD_B14[pwl] = sar12_stimulus
let sar12_drive = (floor(sar12_trial / 32768) - 2*floor(sar12_trial / 65536))*1.8
let sar12_previous = @VD_B15[pwl]
let sar12_stimulus = vector(8)
let sar12_stimulus[0] = 0
let sar12_stimulus[1] = sar12_previous[length(sar12_previous)-1]
let sar12_stimulus[2] = 6.65009999999999e-05
let sar12_stimulus[3] = sar12_stimulus[1]
let sar12_stimulus[4] = 6.65029999999999e-05
let sar12_stimulus[5] = sar12_drive
let sar12_stimulus[6] = 0.000148
let sar12_stimulus[7] = sar12_stimulus[5]
alter @VD_B15[pwl] = sar12_stimulus
resume
let sar12_k = length(time)-1
if abs(time[sar12_k] - 6.69999999999999e-05) > 1e-12
print time[sar12_k]
echo expected_pause_time_s 6.69999999999999e-05
echo SAR12_PAUSE_FAILED
quit 1
end
print time[sar12_k] >> pause-times.txt
let sar12_previous = @VD_EVAL[pwl]
let sar12_stimulus = vector(8)
let sar12_stimulus[0] = 0
let sar12_stimulus[1] = sar12_previous[length(sar12_previous)-1]
let sar12_stimulus[2] = 6.70009999999999e-05
let sar12_stimulus[3] = sar12_stimulus[1]
let sar12_stimulus[4] = 6.70029999999999e-05
let sar12_stimulus[5] = 1.8
let sar12_stimulus[6] = 0.000148
let sar12_stimulus[7] = sar12_stimulus[5]
alter @VD_EVAL[pwl] = sar12_stimulus
resume
let sar12_k = length(time)-1
if abs(time[sar12_k] - 6.74999999999999e-05) > 1e-12
print time[sar12_k]
echo expected_pause_time_s 6.74999999999999e-05
echo SAR12_PAUSE_FAILED
quit 1
end
print time[sar12_k] >> pause-times.txt
let sar12_k = length(time)-1
let sar12_cmp = v(COMP)[sar12_k]
let sar12_cmpn = v(COMPN)[sar12_k]
let sar12_p = v(TOPP)[sar12_k]
let sar12_n = v(TOPN)[sar12_k]
let sar12_decision = 0
if sar12_cmp >= 0.9
let sar12_code = sar12_trial
let sar12_decision = 1
end
echo 2 6 $&sar12_trial $&sar12_cmp $&sar12_cmpn $&sar12_p $&sar12_n -1.19994506835937 $&sar12_decision >> decisions.csv
let sar12_previous = @VD_EVAL[pwl]
let sar12_stimulus = vector(8)
let sar12_stimulus[0] = 0
let sar12_stimulus[1] = sar12_previous[length(sar12_previous)-1]
let sar12_stimulus[2] = 6.75009999999999e-05
let sar12_stimulus[3] = sar12_stimulus[1]
let sar12_stimulus[4] = 6.75029999999999e-05
let sar12_stimulus[5] = 0
let sar12_stimulus[6] = 0.000148
let sar12_stimulus[7] = sar12_stimulus[5]
alter @VD_EVAL[pwl] = sar12_stimulus
let sar12_trial = sar12_code + 32
let sar12_drive = (floor(sar12_trial / 1) - 2*floor(sar12_trial / 2))*1.8
let sar12_previous = @VD_B0[pwl]
let sar12_stimulus = vector(8)
let sar12_stimulus[0] = 0
let sar12_stimulus[1] = sar12_previous[length(sar12_previous)-1]
let sar12_stimulus[2] = 6.75009999999999e-05
let sar12_stimulus[3] = sar12_stimulus[1]
let sar12_stimulus[4] = 6.75029999999999e-05
let sar12_stimulus[5] = sar12_drive
let sar12_stimulus[6] = 0.000148
let sar12_stimulus[7] = sar12_stimulus[5]
alter @VD_B0[pwl] = sar12_stimulus
let sar12_drive = (floor(sar12_trial / 2) - 2*floor(sar12_trial / 4))*1.8
let sar12_previous = @VD_B1[pwl]
let sar12_stimulus = vector(8)
let sar12_stimulus[0] = 0
let sar12_stimulus[1] = sar12_previous[length(sar12_previous)-1]
let sar12_stimulus[2] = 6.75009999999999e-05
let sar12_stimulus[3] = sar12_stimulus[1]
let sar12_stimulus[4] = 6.75029999999999e-05
let sar12_stimulus[5] = sar12_drive
let sar12_stimulus[6] = 0.000148
let sar12_stimulus[7] = sar12_stimulus[5]
alter @VD_B1[pwl] = sar12_stimulus
let sar12_drive = (floor(sar12_trial / 4) - 2*floor(sar12_trial / 8))*1.8
let sar12_previous = @VD_B2[pwl]
let sar12_stimulus = vector(8)
let sar12_stimulus[0] = 0
let sar12_stimulus[1] = sar12_previous[length(sar12_previous)-1]
let sar12_stimulus[2] = 6.75009999999999e-05
let sar12_stimulus[3] = sar12_stimulus[1]
let sar12_stimulus[4] = 6.75029999999999e-05
let sar12_stimulus[5] = sar12_drive
let sar12_stimulus[6] = 0.000148
let sar12_stimulus[7] = sar12_stimulus[5]
alter @VD_B2[pwl] = sar12_stimulus
let sar12_drive = (floor(sar12_trial / 8) - 2*floor(sar12_trial / 16))*1.8
let sar12_previous = @VD_B3[pwl]
let sar12_stimulus = vector(8)
let sar12_stimulus[0] = 0
let sar12_stimulus[1] = sar12_previous[length(sar12_previous)-1]
let sar12_stimulus[2] = 6.75009999999999e-05
let sar12_stimulus[3] = sar12_stimulus[1]
let sar12_stimulus[4] = 6.75029999999999e-05
let sar12_stimulus[5] = sar12_drive
let sar12_stimulus[6] = 0.000148
let sar12_stimulus[7] = sar12_stimulus[5]
alter @VD_B3[pwl] = sar12_stimulus
let sar12_drive = (floor(sar12_trial / 16) - 2*floor(sar12_trial / 32))*1.8
let sar12_previous = @VD_B4[pwl]
let sar12_stimulus = vector(8)
let sar12_stimulus[0] = 0
let sar12_stimulus[1] = sar12_previous[length(sar12_previous)-1]
let sar12_stimulus[2] = 6.75009999999999e-05
let sar12_stimulus[3] = sar12_stimulus[1]
let sar12_stimulus[4] = 6.75029999999999e-05
let sar12_stimulus[5] = sar12_drive
let sar12_stimulus[6] = 0.000148
let sar12_stimulus[7] = sar12_stimulus[5]
alter @VD_B4[pwl] = sar12_stimulus
let sar12_drive = (floor(sar12_trial / 32) - 2*floor(sar12_trial / 64))*1.8
let sar12_previous = @VD_B5[pwl]
let sar12_stimulus = vector(8)
let sar12_stimulus[0] = 0
let sar12_stimulus[1] = sar12_previous[length(sar12_previous)-1]
let sar12_stimulus[2] = 6.75009999999999e-05
let sar12_stimulus[3] = sar12_stimulus[1]
let sar12_stimulus[4] = 6.75029999999999e-05
let sar12_stimulus[5] = sar12_drive
let sar12_stimulus[6] = 0.000148
let sar12_stimulus[7] = sar12_stimulus[5]
alter @VD_B5[pwl] = sar12_stimulus
let sar12_drive = (floor(sar12_trial / 64) - 2*floor(sar12_trial / 128))*1.8
let sar12_previous = @VD_B6[pwl]
let sar12_stimulus = vector(8)
let sar12_stimulus[0] = 0
let sar12_stimulus[1] = sar12_previous[length(sar12_previous)-1]
let sar12_stimulus[2] = 6.75009999999999e-05
let sar12_stimulus[3] = sar12_stimulus[1]
let sar12_stimulus[4] = 6.75029999999999e-05
let sar12_stimulus[5] = sar12_drive
let sar12_stimulus[6] = 0.000148
let sar12_stimulus[7] = sar12_stimulus[5]
alter @VD_B6[pwl] = sar12_stimulus
let sar12_drive = (floor(sar12_trial / 128) - 2*floor(sar12_trial / 256))*1.8
let sar12_previous = @VD_B7[pwl]
let sar12_stimulus = vector(8)
let sar12_stimulus[0] = 0
let sar12_stimulus[1] = sar12_previous[length(sar12_previous)-1]
let sar12_stimulus[2] = 6.75009999999999e-05
let sar12_stimulus[3] = sar12_stimulus[1]
let sar12_stimulus[4] = 6.75029999999999e-05
let sar12_stimulus[5] = sar12_drive
let sar12_stimulus[6] = 0.000148
let sar12_stimulus[7] = sar12_stimulus[5]
alter @VD_B7[pwl] = sar12_stimulus
let sar12_drive = (floor(sar12_trial / 256) - 2*floor(sar12_trial / 512))*1.8
let sar12_previous = @VD_B8[pwl]
let sar12_stimulus = vector(8)
let sar12_stimulus[0] = 0
let sar12_stimulus[1] = sar12_previous[length(sar12_previous)-1]
let sar12_stimulus[2] = 6.75009999999999e-05
let sar12_stimulus[3] = sar12_stimulus[1]
let sar12_stimulus[4] = 6.75029999999999e-05
let sar12_stimulus[5] = sar12_drive
let sar12_stimulus[6] = 0.000148
let sar12_stimulus[7] = sar12_stimulus[5]
alter @VD_B8[pwl] = sar12_stimulus
let sar12_drive = (floor(sar12_trial / 512) - 2*floor(sar12_trial / 1024))*1.8
let sar12_previous = @VD_B9[pwl]
let sar12_stimulus = vector(8)
let sar12_stimulus[0] = 0
let sar12_stimulus[1] = sar12_previous[length(sar12_previous)-1]
let sar12_stimulus[2] = 6.75009999999999e-05
let sar12_stimulus[3] = sar12_stimulus[1]
let sar12_stimulus[4] = 6.75029999999999e-05
let sar12_stimulus[5] = sar12_drive
let sar12_stimulus[6] = 0.000148
let sar12_stimulus[7] = sar12_stimulus[5]
alter @VD_B9[pwl] = sar12_stimulus
let sar12_drive = (floor(sar12_trial / 1024) - 2*floor(sar12_trial / 2048))*1.8
let sar12_previous = @VD_B10[pwl]
let sar12_stimulus = vector(8)
let sar12_stimulus[0] = 0
let sar12_stimulus[1] = sar12_previous[length(sar12_previous)-1]
let sar12_stimulus[2] = 6.75009999999999e-05
let sar12_stimulus[3] = sar12_stimulus[1]
let sar12_stimulus[4] = 6.75029999999999e-05
let sar12_stimulus[5] = sar12_drive
let sar12_stimulus[6] = 0.000148
let sar12_stimulus[7] = sar12_stimulus[5]
alter @VD_B10[pwl] = sar12_stimulus
let sar12_drive = (floor(sar12_trial / 2048) - 2*floor(sar12_trial / 4096))*1.8
let sar12_previous = @VD_B11[pwl]
let sar12_stimulus = vector(8)
let sar12_stimulus[0] = 0
let sar12_stimulus[1] = sar12_previous[length(sar12_previous)-1]
let sar12_stimulus[2] = 6.75009999999999e-05
let sar12_stimulus[3] = sar12_stimulus[1]
let sar12_stimulus[4] = 6.75029999999999e-05
let sar12_stimulus[5] = sar12_drive
let sar12_stimulus[6] = 0.000148
let sar12_stimulus[7] = sar12_stimulus[5]
alter @VD_B11[pwl] = sar12_stimulus
let sar12_drive = (floor(sar12_trial / 4096) - 2*floor(sar12_trial / 8192))*1.8
let sar12_previous = @VD_B12[pwl]
let sar12_stimulus = vector(8)
let sar12_stimulus[0] = 0
let sar12_stimulus[1] = sar12_previous[length(sar12_previous)-1]
let sar12_stimulus[2] = 6.75009999999999e-05
let sar12_stimulus[3] = sar12_stimulus[1]
let sar12_stimulus[4] = 6.75029999999999e-05
let sar12_stimulus[5] = sar12_drive
let sar12_stimulus[6] = 0.000148
let sar12_stimulus[7] = sar12_stimulus[5]
alter @VD_B12[pwl] = sar12_stimulus
let sar12_drive = (floor(sar12_trial / 8192) - 2*floor(sar12_trial / 16384))*1.8
let sar12_previous = @VD_B13[pwl]
let sar12_stimulus = vector(8)
let sar12_stimulus[0] = 0
let sar12_stimulus[1] = sar12_previous[length(sar12_previous)-1]
let sar12_stimulus[2] = 6.75009999999999e-05
let sar12_stimulus[3] = sar12_stimulus[1]
let sar12_stimulus[4] = 6.75029999999999e-05
let sar12_stimulus[5] = sar12_drive
let sar12_stimulus[6] = 0.000148
let sar12_stimulus[7] = sar12_stimulus[5]
alter @VD_B13[pwl] = sar12_stimulus
let sar12_drive = (floor(sar12_trial / 16384) - 2*floor(sar12_trial / 32768))*1.8
let sar12_previous = @VD_B14[pwl]
let sar12_stimulus = vector(8)
let sar12_stimulus[0] = 0
let sar12_stimulus[1] = sar12_previous[length(sar12_previous)-1]
let sar12_stimulus[2] = 6.75009999999999e-05
let sar12_stimulus[3] = sar12_stimulus[1]
let sar12_stimulus[4] = 6.75029999999999e-05
let sar12_stimulus[5] = sar12_drive
let sar12_stimulus[6] = 0.000148
let sar12_stimulus[7] = sar12_stimulus[5]
alter @VD_B14[pwl] = sar12_stimulus
let sar12_drive = (floor(sar12_trial / 32768) - 2*floor(sar12_trial / 65536))*1.8
let sar12_previous = @VD_B15[pwl]
let sar12_stimulus = vector(8)
let sar12_stimulus[0] = 0
let sar12_stimulus[1] = sar12_previous[length(sar12_previous)-1]
let sar12_stimulus[2] = 6.75009999999999e-05
let sar12_stimulus[3] = sar12_stimulus[1]
let sar12_stimulus[4] = 6.75029999999999e-05
let sar12_stimulus[5] = sar12_drive
let sar12_stimulus[6] = 0.000148
let sar12_stimulus[7] = sar12_stimulus[5]
alter @VD_B15[pwl] = sar12_stimulus
resume
let sar12_k = length(time)-1
if abs(time[sar12_k] - 6.79999999999999e-05) > 1e-12
print time[sar12_k]
echo expected_pause_time_s 6.79999999999999e-05
echo SAR12_PAUSE_FAILED
quit 1
end
print time[sar12_k] >> pause-times.txt
let sar12_previous = @VD_EVAL[pwl]
let sar12_stimulus = vector(8)
let sar12_stimulus[0] = 0
let sar12_stimulus[1] = sar12_previous[length(sar12_previous)-1]
let sar12_stimulus[2] = 6.80009999999999e-05
let sar12_stimulus[3] = sar12_stimulus[1]
let sar12_stimulus[4] = 6.80029999999999e-05
let sar12_stimulus[5] = 1.8
let sar12_stimulus[6] = 0.000148
let sar12_stimulus[7] = sar12_stimulus[5]
alter @VD_EVAL[pwl] = sar12_stimulus
resume
let sar12_k = length(time)-1
if abs(time[sar12_k] - 6.84999999999999e-05) > 1e-12
print time[sar12_k]
echo expected_pause_time_s 6.84999999999999e-05
echo SAR12_PAUSE_FAILED
quit 1
end
print time[sar12_k] >> pause-times.txt
let sar12_k = length(time)-1
let sar12_cmp = v(COMP)[sar12_k]
let sar12_cmpn = v(COMPN)[sar12_k]
let sar12_p = v(TOPP)[sar12_k]
let sar12_n = v(TOPN)[sar12_k]
let sar12_decision = 0
if sar12_cmp >= 0.9
let sar12_code = sar12_trial
let sar12_decision = 1
end
echo 2 5 $&sar12_trial $&sar12_cmp $&sar12_cmpn $&sar12_p $&sar12_n -1.19994506835937 $&sar12_decision >> decisions.csv
let sar12_previous = @VD_EVAL[pwl]
let sar12_stimulus = vector(8)
let sar12_stimulus[0] = 0
let sar12_stimulus[1] = sar12_previous[length(sar12_previous)-1]
let sar12_stimulus[2] = 6.85009999999999e-05
let sar12_stimulus[3] = sar12_stimulus[1]
let sar12_stimulus[4] = 6.85029999999999e-05
let sar12_stimulus[5] = 0
let sar12_stimulus[6] = 0.000148
let sar12_stimulus[7] = sar12_stimulus[5]
alter @VD_EVAL[pwl] = sar12_stimulus
let sar12_trial = sar12_code + 16
let sar12_drive = (floor(sar12_trial / 1) - 2*floor(sar12_trial / 2))*1.8
let sar12_previous = @VD_B0[pwl]
let sar12_stimulus = vector(8)
let sar12_stimulus[0] = 0
let sar12_stimulus[1] = sar12_previous[length(sar12_previous)-1]
let sar12_stimulus[2] = 6.85009999999999e-05
let sar12_stimulus[3] = sar12_stimulus[1]
let sar12_stimulus[4] = 6.85029999999999e-05
let sar12_stimulus[5] = sar12_drive
let sar12_stimulus[6] = 0.000148
let sar12_stimulus[7] = sar12_stimulus[5]
alter @VD_B0[pwl] = sar12_stimulus
let sar12_drive = (floor(sar12_trial / 2) - 2*floor(sar12_trial / 4))*1.8
let sar12_previous = @VD_B1[pwl]
let sar12_stimulus = vector(8)
let sar12_stimulus[0] = 0
let sar12_stimulus[1] = sar12_previous[length(sar12_previous)-1]
let sar12_stimulus[2] = 6.85009999999999e-05
let sar12_stimulus[3] = sar12_stimulus[1]
let sar12_stimulus[4] = 6.85029999999999e-05
let sar12_stimulus[5] = sar12_drive
let sar12_stimulus[6] = 0.000148
let sar12_stimulus[7] = sar12_stimulus[5]
alter @VD_B1[pwl] = sar12_stimulus
let sar12_drive = (floor(sar12_trial / 4) - 2*floor(sar12_trial / 8))*1.8
let sar12_previous = @VD_B2[pwl]
let sar12_stimulus = vector(8)
let sar12_stimulus[0] = 0
let sar12_stimulus[1] = sar12_previous[length(sar12_previous)-1]
let sar12_stimulus[2] = 6.85009999999999e-05
let sar12_stimulus[3] = sar12_stimulus[1]
let sar12_stimulus[4] = 6.85029999999999e-05
let sar12_stimulus[5] = sar12_drive
let sar12_stimulus[6] = 0.000148
let sar12_stimulus[7] = sar12_stimulus[5]
alter @VD_B2[pwl] = sar12_stimulus
let sar12_drive = (floor(sar12_trial / 8) - 2*floor(sar12_trial / 16))*1.8
let sar12_previous = @VD_B3[pwl]
let sar12_stimulus = vector(8)
let sar12_stimulus[0] = 0
let sar12_stimulus[1] = sar12_previous[length(sar12_previous)-1]
let sar12_stimulus[2] = 6.85009999999999e-05
let sar12_stimulus[3] = sar12_stimulus[1]
let sar12_stimulus[4] = 6.85029999999999e-05
let sar12_stimulus[5] = sar12_drive
let sar12_stimulus[6] = 0.000148
let sar12_stimulus[7] = sar12_stimulus[5]
alter @VD_B3[pwl] = sar12_stimulus
let sar12_drive = (floor(sar12_trial / 16) - 2*floor(sar12_trial / 32))*1.8
let sar12_previous = @VD_B4[pwl]
let sar12_stimulus = vector(8)
let sar12_stimulus[0] = 0
let sar12_stimulus[1] = sar12_previous[length(sar12_previous)-1]
let sar12_stimulus[2] = 6.85009999999999e-05
let sar12_stimulus[3] = sar12_stimulus[1]
let sar12_stimulus[4] = 6.85029999999999e-05
let sar12_stimulus[5] = sar12_drive
let sar12_stimulus[6] = 0.000148
let sar12_stimulus[7] = sar12_stimulus[5]
alter @VD_B4[pwl] = sar12_stimulus
let sar12_drive = (floor(sar12_trial / 32) - 2*floor(sar12_trial / 64))*1.8
let sar12_previous = @VD_B5[pwl]
let sar12_stimulus = vector(8)
let sar12_stimulus[0] = 0
let sar12_stimulus[1] = sar12_previous[length(sar12_previous)-1]
let sar12_stimulus[2] = 6.85009999999999e-05
let sar12_stimulus[3] = sar12_stimulus[1]
let sar12_stimulus[4] = 6.85029999999999e-05
let sar12_stimulus[5] = sar12_drive
let sar12_stimulus[6] = 0.000148
let sar12_stimulus[7] = sar12_stimulus[5]
alter @VD_B5[pwl] = sar12_stimulus
let sar12_drive = (floor(sar12_trial / 64) - 2*floor(sar12_trial / 128))*1.8
let sar12_previous = @VD_B6[pwl]
let sar12_stimulus = vector(8)
let sar12_stimulus[0] = 0
let sar12_stimulus[1] = sar12_previous[length(sar12_previous)-1]
let sar12_stimulus[2] = 6.85009999999999e-05
let sar12_stimulus[3] = sar12_stimulus[1]
let sar12_stimulus[4] = 6.85029999999999e-05
let sar12_stimulus[5] = sar12_drive
let sar12_stimulus[6] = 0.000148
let sar12_stimulus[7] = sar12_stimulus[5]
alter @VD_B6[pwl] = sar12_stimulus
let sar12_drive = (floor(sar12_trial / 128) - 2*floor(sar12_trial / 256))*1.8
let sar12_previous = @VD_B7[pwl]
let sar12_stimulus = vector(8)
let sar12_stimulus[0] = 0
let sar12_stimulus[1] = sar12_previous[length(sar12_previous)-1]
let sar12_stimulus[2] = 6.85009999999999e-05
let sar12_stimulus[3] = sar12_stimulus[1]
let sar12_stimulus[4] = 6.85029999999999e-05
let sar12_stimulus[5] = sar12_drive
let sar12_stimulus[6] = 0.000148
let sar12_stimulus[7] = sar12_stimulus[5]
alter @VD_B7[pwl] = sar12_stimulus
let sar12_drive = (floor(sar12_trial / 256) - 2*floor(sar12_trial / 512))*1.8
let sar12_previous = @VD_B8[pwl]
let sar12_stimulus = vector(8)
let sar12_stimulus[0] = 0
let sar12_stimulus[1] = sar12_previous[length(sar12_previous)-1]
let sar12_stimulus[2] = 6.85009999999999e-05
let sar12_stimulus[3] = sar12_stimulus[1]
let sar12_stimulus[4] = 6.85029999999999e-05
let sar12_stimulus[5] = sar12_drive
let sar12_stimulus[6] = 0.000148
let sar12_stimulus[7] = sar12_stimulus[5]
alter @VD_B8[pwl] = sar12_stimulus
let sar12_drive = (floor(sar12_trial / 512) - 2*floor(sar12_trial / 1024))*1.8
let sar12_previous = @VD_B9[pwl]
let sar12_stimulus = vector(8)
let sar12_stimulus[0] = 0
let sar12_stimulus[1] = sar12_previous[length(sar12_previous)-1]
let sar12_stimulus[2] = 6.85009999999999e-05
let sar12_stimulus[3] = sar12_stimulus[1]
let sar12_stimulus[4] = 6.85029999999999e-05
let sar12_stimulus[5] = sar12_drive
let sar12_stimulus[6] = 0.000148
let sar12_stimulus[7] = sar12_stimulus[5]
alter @VD_B9[pwl] = sar12_stimulus
let sar12_drive = (floor(sar12_trial / 1024) - 2*floor(sar12_trial / 2048))*1.8
let sar12_previous = @VD_B10[pwl]
let sar12_stimulus = vector(8)
let sar12_stimulus[0] = 0
let sar12_stimulus[1] = sar12_previous[length(sar12_previous)-1]
let sar12_stimulus[2] = 6.85009999999999e-05
let sar12_stimulus[3] = sar12_stimulus[1]
let sar12_stimulus[4] = 6.85029999999999e-05
let sar12_stimulus[5] = sar12_drive
let sar12_stimulus[6] = 0.000148
let sar12_stimulus[7] = sar12_stimulus[5]
alter @VD_B10[pwl] = sar12_stimulus
let sar12_drive = (floor(sar12_trial / 2048) - 2*floor(sar12_trial / 4096))*1.8
let sar12_previous = @VD_B11[pwl]
let sar12_stimulus = vector(8)
let sar12_stimulus[0] = 0
let sar12_stimulus[1] = sar12_previous[length(sar12_previous)-1]
let sar12_stimulus[2] = 6.85009999999999e-05
let sar12_stimulus[3] = sar12_stimulus[1]
let sar12_stimulus[4] = 6.85029999999999e-05
let sar12_stimulus[5] = sar12_drive
let sar12_stimulus[6] = 0.000148
let sar12_stimulus[7] = sar12_stimulus[5]
alter @VD_B11[pwl] = sar12_stimulus
let sar12_drive = (floor(sar12_trial / 4096) - 2*floor(sar12_trial / 8192))*1.8
let sar12_previous = @VD_B12[pwl]
let sar12_stimulus = vector(8)
let sar12_stimulus[0] = 0
let sar12_stimulus[1] = sar12_previous[length(sar12_previous)-1]
let sar12_stimulus[2] = 6.85009999999999e-05
let sar12_stimulus[3] = sar12_stimulus[1]
let sar12_stimulus[4] = 6.85029999999999e-05
let sar12_stimulus[5] = sar12_drive
let sar12_stimulus[6] = 0.000148
let sar12_stimulus[7] = sar12_stimulus[5]
alter @VD_B12[pwl] = sar12_stimulus
let sar12_drive = (floor(sar12_trial / 8192) - 2*floor(sar12_trial / 16384))*1.8
let sar12_previous = @VD_B13[pwl]
let sar12_stimulus = vector(8)
let sar12_stimulus[0] = 0
let sar12_stimulus[1] = sar12_previous[length(sar12_previous)-1]
let sar12_stimulus[2] = 6.85009999999999e-05
let sar12_stimulus[3] = sar12_stimulus[1]
let sar12_stimulus[4] = 6.85029999999999e-05
let sar12_stimulus[5] = sar12_drive
let sar12_stimulus[6] = 0.000148
let sar12_stimulus[7] = sar12_stimulus[5]
alter @VD_B13[pwl] = sar12_stimulus
let sar12_drive = (floor(sar12_trial / 16384) - 2*floor(sar12_trial / 32768))*1.8
let sar12_previous = @VD_B14[pwl]
let sar12_stimulus = vector(8)
let sar12_stimulus[0] = 0
let sar12_stimulus[1] = sar12_previous[length(sar12_previous)-1]
let sar12_stimulus[2] = 6.85009999999999e-05
let sar12_stimulus[3] = sar12_stimulus[1]
let sar12_stimulus[4] = 6.85029999999999e-05
let sar12_stimulus[5] = sar12_drive
let sar12_stimulus[6] = 0.000148
let sar12_stimulus[7] = sar12_stimulus[5]
alter @VD_B14[pwl] = sar12_stimulus
let sar12_drive = (floor(sar12_trial / 32768) - 2*floor(sar12_trial / 65536))*1.8
let sar12_previous = @VD_B15[pwl]
let sar12_stimulus = vector(8)
let sar12_stimulus[0] = 0
let sar12_stimulus[1] = sar12_previous[length(sar12_previous)-1]
let sar12_stimulus[2] = 6.85009999999999e-05
let sar12_stimulus[3] = sar12_stimulus[1]
let sar12_stimulus[4] = 6.85029999999999e-05
let sar12_stimulus[5] = sar12_drive
let sar12_stimulus[6] = 0.000148
let sar12_stimulus[7] = sar12_stimulus[5]
alter @VD_B15[pwl] = sar12_stimulus
resume
let sar12_k = length(time)-1
if abs(time[sar12_k] - 6.89999999999999e-05) > 1e-12
print time[sar12_k]
echo expected_pause_time_s 6.89999999999999e-05
echo SAR12_PAUSE_FAILED
quit 1
end
print time[sar12_k] >> pause-times.txt
let sar12_previous = @VD_EVAL[pwl]
let sar12_stimulus = vector(8)
let sar12_stimulus[0] = 0
let sar12_stimulus[1] = sar12_previous[length(sar12_previous)-1]
let sar12_stimulus[2] = 6.90009999999999e-05
let sar12_stimulus[3] = sar12_stimulus[1]
let sar12_stimulus[4] = 6.90029999999999e-05
let sar12_stimulus[5] = 1.8
let sar12_stimulus[6] = 0.000148
let sar12_stimulus[7] = sar12_stimulus[5]
alter @VD_EVAL[pwl] = sar12_stimulus
resume
let sar12_k = length(time)-1
if abs(time[sar12_k] - 6.94999999999999e-05) > 1e-12
print time[sar12_k]
echo expected_pause_time_s 6.94999999999999e-05
echo SAR12_PAUSE_FAILED
quit 1
end
print time[sar12_k] >> pause-times.txt
let sar12_k = length(time)-1
let sar12_cmp = v(COMP)[sar12_k]
let sar12_cmpn = v(COMPN)[sar12_k]
let sar12_p = v(TOPP)[sar12_k]
let sar12_n = v(TOPN)[sar12_k]
let sar12_decision = 0
if sar12_cmp >= 0.9
let sar12_code = sar12_trial
let sar12_decision = 1
end
echo 2 4 $&sar12_trial $&sar12_cmp $&sar12_cmpn $&sar12_p $&sar12_n -1.19994506835937 $&sar12_decision >> decisions.csv
let sar12_previous = @VD_EVAL[pwl]
let sar12_stimulus = vector(8)
let sar12_stimulus[0] = 0
let sar12_stimulus[1] = sar12_previous[length(sar12_previous)-1]
let sar12_stimulus[2] = 6.95009999999999e-05
let sar12_stimulus[3] = sar12_stimulus[1]
let sar12_stimulus[4] = 6.95029999999999e-05
let sar12_stimulus[5] = 0
let sar12_stimulus[6] = 0.000148
let sar12_stimulus[7] = sar12_stimulus[5]
alter @VD_EVAL[pwl] = sar12_stimulus
let sar12_trial = sar12_code + 8
let sar12_drive = (floor(sar12_trial / 1) - 2*floor(sar12_trial / 2))*1.8
let sar12_previous = @VD_B0[pwl]
let sar12_stimulus = vector(8)
let sar12_stimulus[0] = 0
let sar12_stimulus[1] = sar12_previous[length(sar12_previous)-1]
let sar12_stimulus[2] = 6.95009999999999e-05
let sar12_stimulus[3] = sar12_stimulus[1]
let sar12_stimulus[4] = 6.95029999999999e-05
let sar12_stimulus[5] = sar12_drive
let sar12_stimulus[6] = 0.000148
let sar12_stimulus[7] = sar12_stimulus[5]
alter @VD_B0[pwl] = sar12_stimulus
let sar12_drive = (floor(sar12_trial / 2) - 2*floor(sar12_trial / 4))*1.8
let sar12_previous = @VD_B1[pwl]
let sar12_stimulus = vector(8)
let sar12_stimulus[0] = 0
let sar12_stimulus[1] = sar12_previous[length(sar12_previous)-1]
let sar12_stimulus[2] = 6.95009999999999e-05
let sar12_stimulus[3] = sar12_stimulus[1]
let sar12_stimulus[4] = 6.95029999999999e-05
let sar12_stimulus[5] = sar12_drive
let sar12_stimulus[6] = 0.000148
let sar12_stimulus[7] = sar12_stimulus[5]
alter @VD_B1[pwl] = sar12_stimulus
let sar12_drive = (floor(sar12_trial / 4) - 2*floor(sar12_trial / 8))*1.8
let sar12_previous = @VD_B2[pwl]
let sar12_stimulus = vector(8)
let sar12_stimulus[0] = 0
let sar12_stimulus[1] = sar12_previous[length(sar12_previous)-1]
let sar12_stimulus[2] = 6.95009999999999e-05
let sar12_stimulus[3] = sar12_stimulus[1]
let sar12_stimulus[4] = 6.95029999999999e-05
let sar12_stimulus[5] = sar12_drive
let sar12_stimulus[6] = 0.000148
let sar12_stimulus[7] = sar12_stimulus[5]
alter @VD_B2[pwl] = sar12_stimulus
let sar12_drive = (floor(sar12_trial / 8) - 2*floor(sar12_trial / 16))*1.8
let sar12_previous = @VD_B3[pwl]
let sar12_stimulus = vector(8)
let sar12_stimulus[0] = 0
let sar12_stimulus[1] = sar12_previous[length(sar12_previous)-1]
let sar12_stimulus[2] = 6.95009999999999e-05
let sar12_stimulus[3] = sar12_stimulus[1]
let sar12_stimulus[4] = 6.95029999999999e-05
let sar12_stimulus[5] = sar12_drive
let sar12_stimulus[6] = 0.000148
let sar12_stimulus[7] = sar12_stimulus[5]
alter @VD_B3[pwl] = sar12_stimulus
let sar12_drive = (floor(sar12_trial / 16) - 2*floor(sar12_trial / 32))*1.8
let sar12_previous = @VD_B4[pwl]
let sar12_stimulus = vector(8)
let sar12_stimulus[0] = 0
let sar12_stimulus[1] = sar12_previous[length(sar12_previous)-1]
let sar12_stimulus[2] = 6.95009999999999e-05
let sar12_stimulus[3] = sar12_stimulus[1]
let sar12_stimulus[4] = 6.95029999999999e-05
let sar12_stimulus[5] = sar12_drive
let sar12_stimulus[6] = 0.000148
let sar12_stimulus[7] = sar12_stimulus[5]
alter @VD_B4[pwl] = sar12_stimulus
let sar12_drive = (floor(sar12_trial / 32) - 2*floor(sar12_trial / 64))*1.8
let sar12_previous = @VD_B5[pwl]
let sar12_stimulus = vector(8)
let sar12_stimulus[0] = 0
let sar12_stimulus[1] = sar12_previous[length(sar12_previous)-1]
let sar12_stimulus[2] = 6.95009999999999e-05
let sar12_stimulus[3] = sar12_stimulus[1]
let sar12_stimulus[4] = 6.95029999999999e-05
let sar12_stimulus[5] = sar12_drive
let sar12_stimulus[6] = 0.000148
let sar12_stimulus[7] = sar12_stimulus[5]
alter @VD_B5[pwl] = sar12_stimulus
let sar12_drive = (floor(sar12_trial / 64) - 2*floor(sar12_trial / 128))*1.8
let sar12_previous = @VD_B6[pwl]
let sar12_stimulus = vector(8)
let sar12_stimulus[0] = 0
let sar12_stimulus[1] = sar12_previous[length(sar12_previous)-1]
let sar12_stimulus[2] = 6.95009999999999e-05
let sar12_stimulus[3] = sar12_stimulus[1]
let sar12_stimulus[4] = 6.95029999999999e-05
let sar12_stimulus[5] = sar12_drive
let sar12_stimulus[6] = 0.000148
let sar12_stimulus[7] = sar12_stimulus[5]
alter @VD_B6[pwl] = sar12_stimulus
let sar12_drive = (floor(sar12_trial / 128) - 2*floor(sar12_trial / 256))*1.8
let sar12_previous = @VD_B7[pwl]
let sar12_stimulus = vector(8)
let sar12_stimulus[0] = 0
let sar12_stimulus[1] = sar12_previous[length(sar12_previous)-1]
let sar12_stimulus[2] = 6.95009999999999e-05
let sar12_stimulus[3] = sar12_stimulus[1]
let sar12_stimulus[4] = 6.95029999999999e-05
let sar12_stimulus[5] = sar12_drive
let sar12_stimulus[6] = 0.000148
let sar12_stimulus[7] = sar12_stimulus[5]
alter @VD_B7[pwl] = sar12_stimulus
let sar12_drive = (floor(sar12_trial / 256) - 2*floor(sar12_trial / 512))*1.8
let sar12_previous = @VD_B8[pwl]
let sar12_stimulus = vector(8)
let sar12_stimulus[0] = 0
let sar12_stimulus[1] = sar12_previous[length(sar12_previous)-1]
let sar12_stimulus[2] = 6.95009999999999e-05
let sar12_stimulus[3] = sar12_stimulus[1]
let sar12_stimulus[4] = 6.95029999999999e-05
let sar12_stimulus[5] = sar12_drive
let sar12_stimulus[6] = 0.000148
let sar12_stimulus[7] = sar12_stimulus[5]
alter @VD_B8[pwl] = sar12_stimulus
let sar12_drive = (floor(sar12_trial / 512) - 2*floor(sar12_trial / 1024))*1.8
let sar12_previous = @VD_B9[pwl]
let sar12_stimulus = vector(8)
let sar12_stimulus[0] = 0
let sar12_stimulus[1] = sar12_previous[length(sar12_previous)-1]
let sar12_stimulus[2] = 6.95009999999999e-05
let sar12_stimulus[3] = sar12_stimulus[1]
let sar12_stimulus[4] = 6.95029999999999e-05
let sar12_stimulus[5] = sar12_drive
let sar12_stimulus[6] = 0.000148
let sar12_stimulus[7] = sar12_stimulus[5]
alter @VD_B9[pwl] = sar12_stimulus
let sar12_drive = (floor(sar12_trial / 1024) - 2*floor(sar12_trial / 2048))*1.8
let sar12_previous = @VD_B10[pwl]
let sar12_stimulus = vector(8)
let sar12_stimulus[0] = 0
let sar12_stimulus[1] = sar12_previous[length(sar12_previous)-1]
let sar12_stimulus[2] = 6.95009999999999e-05
let sar12_stimulus[3] = sar12_stimulus[1]
let sar12_stimulus[4] = 6.95029999999999e-05
let sar12_stimulus[5] = sar12_drive
let sar12_stimulus[6] = 0.000148
let sar12_stimulus[7] = sar12_stimulus[5]
alter @VD_B10[pwl] = sar12_stimulus
let sar12_drive = (floor(sar12_trial / 2048) - 2*floor(sar12_trial / 4096))*1.8
let sar12_previous = @VD_B11[pwl]
let sar12_stimulus = vector(8)
let sar12_stimulus[0] = 0
let sar12_stimulus[1] = sar12_previous[length(sar12_previous)-1]
let sar12_stimulus[2] = 6.95009999999999e-05
let sar12_stimulus[3] = sar12_stimulus[1]
let sar12_stimulus[4] = 6.95029999999999e-05
let sar12_stimulus[5] = sar12_drive
let sar12_stimulus[6] = 0.000148
let sar12_stimulus[7] = sar12_stimulus[5]
alter @VD_B11[pwl] = sar12_stimulus
let sar12_drive = (floor(sar12_trial / 4096) - 2*floor(sar12_trial / 8192))*1.8
let sar12_previous = @VD_B12[pwl]
let sar12_stimulus = vector(8)
let sar12_stimulus[0] = 0
let sar12_stimulus[1] = sar12_previous[length(sar12_previous)-1]
let sar12_stimulus[2] = 6.95009999999999e-05
let sar12_stimulus[3] = sar12_stimulus[1]
let sar12_stimulus[4] = 6.95029999999999e-05
let sar12_stimulus[5] = sar12_drive
let sar12_stimulus[6] = 0.000148
let sar12_stimulus[7] = sar12_stimulus[5]
alter @VD_B12[pwl] = sar12_stimulus
let sar12_drive = (floor(sar12_trial / 8192) - 2*floor(sar12_trial / 16384))*1.8
let sar12_previous = @VD_B13[pwl]
let sar12_stimulus = vector(8)
let sar12_stimulus[0] = 0
let sar12_stimulus[1] = sar12_previous[length(sar12_previous)-1]
let sar12_stimulus[2] = 6.95009999999999e-05
let sar12_stimulus[3] = sar12_stimulus[1]
let sar12_stimulus[4] = 6.95029999999999e-05
let sar12_stimulus[5] = sar12_drive
let sar12_stimulus[6] = 0.000148
let sar12_stimulus[7] = sar12_stimulus[5]
alter @VD_B13[pwl] = sar12_stimulus
let sar12_drive = (floor(sar12_trial / 16384) - 2*floor(sar12_trial / 32768))*1.8
let sar12_previous = @VD_B14[pwl]
let sar12_stimulus = vector(8)
let sar12_stimulus[0] = 0
let sar12_stimulus[1] = sar12_previous[length(sar12_previous)-1]
let sar12_stimulus[2] = 6.95009999999999e-05
let sar12_stimulus[3] = sar12_stimulus[1]
let sar12_stimulus[4] = 6.95029999999999e-05
let sar12_stimulus[5] = sar12_drive
let sar12_stimulus[6] = 0.000148
let sar12_stimulus[7] = sar12_stimulus[5]
alter @VD_B14[pwl] = sar12_stimulus
let sar12_drive = (floor(sar12_trial / 32768) - 2*floor(sar12_trial / 65536))*1.8
let sar12_previous = @VD_B15[pwl]
let sar12_stimulus = vector(8)
let sar12_stimulus[0] = 0
let sar12_stimulus[1] = sar12_previous[length(sar12_previous)-1]
let sar12_stimulus[2] = 6.95009999999999e-05
let sar12_stimulus[3] = sar12_stimulus[1]
let sar12_stimulus[4] = 6.95029999999999e-05
let sar12_stimulus[5] = sar12_drive
let sar12_stimulus[6] = 0.000148
let sar12_stimulus[7] = sar12_stimulus[5]
alter @VD_B15[pwl] = sar12_stimulus
resume
let sar12_k = length(time)-1
if abs(time[sar12_k] - 6.99999999999999e-05) > 1e-12
print time[sar12_k]
echo expected_pause_time_s 6.99999999999999e-05
echo SAR12_PAUSE_FAILED
quit 1
end
print time[sar12_k] >> pause-times.txt
let sar12_previous = @VD_EVAL[pwl]
let sar12_stimulus = vector(8)
let sar12_stimulus[0] = 0
let sar12_stimulus[1] = sar12_previous[length(sar12_previous)-1]
let sar12_stimulus[2] = 7.00009999999999e-05
let sar12_stimulus[3] = sar12_stimulus[1]
let sar12_stimulus[4] = 7.00029999999999e-05
let sar12_stimulus[5] = 1.8
let sar12_stimulus[6] = 0.000148
let sar12_stimulus[7] = sar12_stimulus[5]
alter @VD_EVAL[pwl] = sar12_stimulus
resume
let sar12_k = length(time)-1
if abs(time[sar12_k] - 7.04999999999999e-05) > 1e-12
print time[sar12_k]
echo expected_pause_time_s 7.04999999999999e-05
echo SAR12_PAUSE_FAILED
quit 1
end
print time[sar12_k] >> pause-times.txt
let sar12_k = length(time)-1
let sar12_cmp = v(COMP)[sar12_k]
let sar12_cmpn = v(COMPN)[sar12_k]
let sar12_p = v(TOPP)[sar12_k]
let sar12_n = v(TOPN)[sar12_k]
let sar12_decision = 0
if sar12_cmp >= 0.9
let sar12_code = sar12_trial
let sar12_decision = 1
end
echo 2 3 $&sar12_trial $&sar12_cmp $&sar12_cmpn $&sar12_p $&sar12_n -1.19994506835937 $&sar12_decision >> decisions.csv
let sar12_previous = @VD_EVAL[pwl]
let sar12_stimulus = vector(8)
let sar12_stimulus[0] = 0
let sar12_stimulus[1] = sar12_previous[length(sar12_previous)-1]
let sar12_stimulus[2] = 7.05009999999999e-05
let sar12_stimulus[3] = sar12_stimulus[1]
let sar12_stimulus[4] = 7.05029999999999e-05
let sar12_stimulus[5] = 0
let sar12_stimulus[6] = 0.000148
let sar12_stimulus[7] = sar12_stimulus[5]
alter @VD_EVAL[pwl] = sar12_stimulus
let sar12_trial = sar12_code + 4
let sar12_drive = (floor(sar12_trial / 1) - 2*floor(sar12_trial / 2))*1.8
let sar12_previous = @VD_B0[pwl]
let sar12_stimulus = vector(8)
let sar12_stimulus[0] = 0
let sar12_stimulus[1] = sar12_previous[length(sar12_previous)-1]
let sar12_stimulus[2] = 7.05009999999999e-05
let sar12_stimulus[3] = sar12_stimulus[1]
let sar12_stimulus[4] = 7.05029999999999e-05
let sar12_stimulus[5] = sar12_drive
let sar12_stimulus[6] = 0.000148
let sar12_stimulus[7] = sar12_stimulus[5]
alter @VD_B0[pwl] = sar12_stimulus
let sar12_drive = (floor(sar12_trial / 2) - 2*floor(sar12_trial / 4))*1.8
let sar12_previous = @VD_B1[pwl]
let sar12_stimulus = vector(8)
let sar12_stimulus[0] = 0
let sar12_stimulus[1] = sar12_previous[length(sar12_previous)-1]
let sar12_stimulus[2] = 7.05009999999999e-05
let sar12_stimulus[3] = sar12_stimulus[1]
let sar12_stimulus[4] = 7.05029999999999e-05
let sar12_stimulus[5] = sar12_drive
let sar12_stimulus[6] = 0.000148
let sar12_stimulus[7] = sar12_stimulus[5]
alter @VD_B1[pwl] = sar12_stimulus
let sar12_drive = (floor(sar12_trial / 4) - 2*floor(sar12_trial / 8))*1.8
let sar12_previous = @VD_B2[pwl]
let sar12_stimulus = vector(8)
let sar12_stimulus[0] = 0
let sar12_stimulus[1] = sar12_previous[length(sar12_previous)-1]
let sar12_stimulus[2] = 7.05009999999999e-05
let sar12_stimulus[3] = sar12_stimulus[1]
let sar12_stimulus[4] = 7.05029999999999e-05
let sar12_stimulus[5] = sar12_drive
let sar12_stimulus[6] = 0.000148
let sar12_stimulus[7] = sar12_stimulus[5]
alter @VD_B2[pwl] = sar12_stimulus
let sar12_drive = (floor(sar12_trial / 8) - 2*floor(sar12_trial / 16))*1.8
let sar12_previous = @VD_B3[pwl]
let sar12_stimulus = vector(8)
let sar12_stimulus[0] = 0
let sar12_stimulus[1] = sar12_previous[length(sar12_previous)-1]
let sar12_stimulus[2] = 7.05009999999999e-05
let sar12_stimulus[3] = sar12_stimulus[1]
let sar12_stimulus[4] = 7.05029999999999e-05
let sar12_stimulus[5] = sar12_drive
let sar12_stimulus[6] = 0.000148
let sar12_stimulus[7] = sar12_stimulus[5]
alter @VD_B3[pwl] = sar12_stimulus
let sar12_drive = (floor(sar12_trial / 16) - 2*floor(sar12_trial / 32))*1.8
let sar12_previous = @VD_B4[pwl]
let sar12_stimulus = vector(8)
let sar12_stimulus[0] = 0
let sar12_stimulus[1] = sar12_previous[length(sar12_previous)-1]
let sar12_stimulus[2] = 7.05009999999999e-05
let sar12_stimulus[3] = sar12_stimulus[1]
let sar12_stimulus[4] = 7.05029999999999e-05
let sar12_stimulus[5] = sar12_drive
let sar12_stimulus[6] = 0.000148
let sar12_stimulus[7] = sar12_stimulus[5]
alter @VD_B4[pwl] = sar12_stimulus
let sar12_drive = (floor(sar12_trial / 32) - 2*floor(sar12_trial / 64))*1.8
let sar12_previous = @VD_B5[pwl]
let sar12_stimulus = vector(8)
let sar12_stimulus[0] = 0
let sar12_stimulus[1] = sar12_previous[length(sar12_previous)-1]
let sar12_stimulus[2] = 7.05009999999999e-05
let sar12_stimulus[3] = sar12_stimulus[1]
let sar12_stimulus[4] = 7.05029999999999e-05
let sar12_stimulus[5] = sar12_drive
let sar12_stimulus[6] = 0.000148
let sar12_stimulus[7] = sar12_stimulus[5]
alter @VD_B5[pwl] = sar12_stimulus
let sar12_drive = (floor(sar12_trial / 64) - 2*floor(sar12_trial / 128))*1.8
let sar12_previous = @VD_B6[pwl]
let sar12_stimulus = vector(8)
let sar12_stimulus[0] = 0
let sar12_stimulus[1] = sar12_previous[length(sar12_previous)-1]
let sar12_stimulus[2] = 7.05009999999999e-05
let sar12_stimulus[3] = sar12_stimulus[1]
let sar12_stimulus[4] = 7.05029999999999e-05
let sar12_stimulus[5] = sar12_drive
let sar12_stimulus[6] = 0.000148
let sar12_stimulus[7] = sar12_stimulus[5]
alter @VD_B6[pwl] = sar12_stimulus
let sar12_drive = (floor(sar12_trial / 128) - 2*floor(sar12_trial / 256))*1.8
let sar12_previous = @VD_B7[pwl]
let sar12_stimulus = vector(8)
let sar12_stimulus[0] = 0
let sar12_stimulus[1] = sar12_previous[length(sar12_previous)-1]
let sar12_stimulus[2] = 7.05009999999999e-05
let sar12_stimulus[3] = sar12_stimulus[1]
let sar12_stimulus[4] = 7.05029999999999e-05
let sar12_stimulus[5] = sar12_drive
let sar12_stimulus[6] = 0.000148
let sar12_stimulus[7] = sar12_stimulus[5]
alter @VD_B7[pwl] = sar12_stimulus
let sar12_drive = (floor(sar12_trial / 256) - 2*floor(sar12_trial / 512))*1.8
let sar12_previous = @VD_B8[pwl]
let sar12_stimulus = vector(8)
let sar12_stimulus[0] = 0
let sar12_stimulus[1] = sar12_previous[length(sar12_previous)-1]
let sar12_stimulus[2] = 7.05009999999999e-05
let sar12_stimulus[3] = sar12_stimulus[1]
let sar12_stimulus[4] = 7.05029999999999e-05
let sar12_stimulus[5] = sar12_drive
let sar12_stimulus[6] = 0.000148
let sar12_stimulus[7] = sar12_stimulus[5]
alter @VD_B8[pwl] = sar12_stimulus
let sar12_drive = (floor(sar12_trial / 512) - 2*floor(sar12_trial / 1024))*1.8
let sar12_previous = @VD_B9[pwl]
let sar12_stimulus = vector(8)
let sar12_stimulus[0] = 0
let sar12_stimulus[1] = sar12_previous[length(sar12_previous)-1]
let sar12_stimulus[2] = 7.05009999999999e-05
let sar12_stimulus[3] = sar12_stimulus[1]
let sar12_stimulus[4] = 7.05029999999999e-05
let sar12_stimulus[5] = sar12_drive
let sar12_stimulus[6] = 0.000148
let sar12_stimulus[7] = sar12_stimulus[5]
alter @VD_B9[pwl] = sar12_stimulus
let sar12_drive = (floor(sar12_trial / 1024) - 2*floor(sar12_trial / 2048))*1.8
let sar12_previous = @VD_B10[pwl]
let sar12_stimulus = vector(8)
let sar12_stimulus[0] = 0
let sar12_stimulus[1] = sar12_previous[length(sar12_previous)-1]
let sar12_stimulus[2] = 7.05009999999999e-05
let sar12_stimulus[3] = sar12_stimulus[1]
let sar12_stimulus[4] = 7.05029999999999e-05
let sar12_stimulus[5] = sar12_drive
let sar12_stimulus[6] = 0.000148
let sar12_stimulus[7] = sar12_stimulus[5]
alter @VD_B10[pwl] = sar12_stimulus
let sar12_drive = (floor(sar12_trial / 2048) - 2*floor(sar12_trial / 4096))*1.8
let sar12_previous = @VD_B11[pwl]
let sar12_stimulus = vector(8)
let sar12_stimulus[0] = 0
let sar12_stimulus[1] = sar12_previous[length(sar12_previous)-1]
let sar12_stimulus[2] = 7.05009999999999e-05
let sar12_stimulus[3] = sar12_stimulus[1]
let sar12_stimulus[4] = 7.05029999999999e-05
let sar12_stimulus[5] = sar12_drive
let sar12_stimulus[6] = 0.000148
let sar12_stimulus[7] = sar12_stimulus[5]
alter @VD_B11[pwl] = sar12_stimulus
let sar12_drive = (floor(sar12_trial / 4096) - 2*floor(sar12_trial / 8192))*1.8
let sar12_previous = @VD_B12[pwl]
let sar12_stimulus = vector(8)
let sar12_stimulus[0] = 0
let sar12_stimulus[1] = sar12_previous[length(sar12_previous)-1]
let sar12_stimulus[2] = 7.05009999999999e-05
let sar12_stimulus[3] = sar12_stimulus[1]
let sar12_stimulus[4] = 7.05029999999999e-05
let sar12_stimulus[5] = sar12_drive
let sar12_stimulus[6] = 0.000148
let sar12_stimulus[7] = sar12_stimulus[5]
alter @VD_B12[pwl] = sar12_stimulus
let sar12_drive = (floor(sar12_trial / 8192) - 2*floor(sar12_trial / 16384))*1.8
let sar12_previous = @VD_B13[pwl]
let sar12_stimulus = vector(8)
let sar12_stimulus[0] = 0
let sar12_stimulus[1] = sar12_previous[length(sar12_previous)-1]
let sar12_stimulus[2] = 7.05009999999999e-05
let sar12_stimulus[3] = sar12_stimulus[1]
let sar12_stimulus[4] = 7.05029999999999e-05
let sar12_stimulus[5] = sar12_drive
let sar12_stimulus[6] = 0.000148
let sar12_stimulus[7] = sar12_stimulus[5]
alter @VD_B13[pwl] = sar12_stimulus
let sar12_drive = (floor(sar12_trial / 16384) - 2*floor(sar12_trial / 32768))*1.8
let sar12_previous = @VD_B14[pwl]
let sar12_stimulus = vector(8)
let sar12_stimulus[0] = 0
let sar12_stimulus[1] = sar12_previous[length(sar12_previous)-1]
let sar12_stimulus[2] = 7.05009999999999e-05
let sar12_stimulus[3] = sar12_stimulus[1]
let sar12_stimulus[4] = 7.05029999999999e-05
let sar12_stimulus[5] = sar12_drive
let sar12_stimulus[6] = 0.000148
let sar12_stimulus[7] = sar12_stimulus[5]
alter @VD_B14[pwl] = sar12_stimulus
let sar12_drive = (floor(sar12_trial / 32768) - 2*floor(sar12_trial / 65536))*1.8
let sar12_previous = @VD_B15[pwl]
let sar12_stimulus = vector(8)
let sar12_stimulus[0] = 0
let sar12_stimulus[1] = sar12_previous[length(sar12_previous)-1]
let sar12_stimulus[2] = 7.05009999999999e-05
let sar12_stimulus[3] = sar12_stimulus[1]
let sar12_stimulus[4] = 7.05029999999999e-05
let sar12_stimulus[5] = sar12_drive
let sar12_stimulus[6] = 0.000148
let sar12_stimulus[7] = sar12_stimulus[5]
alter @VD_B15[pwl] = sar12_stimulus
resume
let sar12_k = length(time)-1
if abs(time[sar12_k] - 7.09999999999999e-05) > 1e-12
print time[sar12_k]
echo expected_pause_time_s 7.09999999999999e-05
echo SAR12_PAUSE_FAILED
quit 1
end
print time[sar12_k] >> pause-times.txt
let sar12_previous = @VD_EVAL[pwl]
let sar12_stimulus = vector(8)
let sar12_stimulus[0] = 0
let sar12_stimulus[1] = sar12_previous[length(sar12_previous)-1]
let sar12_stimulus[2] = 7.10009999999999e-05
let sar12_stimulus[3] = sar12_stimulus[1]
let sar12_stimulus[4] = 7.10029999999999e-05
let sar12_stimulus[5] = 1.8
let sar12_stimulus[6] = 0.000148
let sar12_stimulus[7] = sar12_stimulus[5]
alter @VD_EVAL[pwl] = sar12_stimulus
resume
let sar12_k = length(time)-1
if abs(time[sar12_k] - 7.14999999999999e-05) > 1e-12
print time[sar12_k]
echo expected_pause_time_s 7.14999999999999e-05
echo SAR12_PAUSE_FAILED
quit 1
end
print time[sar12_k] >> pause-times.txt
let sar12_k = length(time)-1
let sar12_cmp = v(COMP)[sar12_k]
let sar12_cmpn = v(COMPN)[sar12_k]
let sar12_p = v(TOPP)[sar12_k]
let sar12_n = v(TOPN)[sar12_k]
let sar12_decision = 0
if sar12_cmp >= 0.9
let sar12_code = sar12_trial
let sar12_decision = 1
end
echo 2 2 $&sar12_trial $&sar12_cmp $&sar12_cmpn $&sar12_p $&sar12_n -1.19994506835937 $&sar12_decision >> decisions.csv
let sar12_previous = @VD_EVAL[pwl]
let sar12_stimulus = vector(8)
let sar12_stimulus[0] = 0
let sar12_stimulus[1] = sar12_previous[length(sar12_previous)-1]
let sar12_stimulus[2] = 7.15009999999999e-05
let sar12_stimulus[3] = sar12_stimulus[1]
let sar12_stimulus[4] = 7.15029999999999e-05
let sar12_stimulus[5] = 0
let sar12_stimulus[6] = 0.000148
let sar12_stimulus[7] = sar12_stimulus[5]
alter @VD_EVAL[pwl] = sar12_stimulus
let sar12_trial = sar12_code + 2
let sar12_drive = (floor(sar12_trial / 1) - 2*floor(sar12_trial / 2))*1.8
let sar12_previous = @VD_B0[pwl]
let sar12_stimulus = vector(8)
let sar12_stimulus[0] = 0
let sar12_stimulus[1] = sar12_previous[length(sar12_previous)-1]
let sar12_stimulus[2] = 7.15009999999999e-05
let sar12_stimulus[3] = sar12_stimulus[1]
let sar12_stimulus[4] = 7.15029999999999e-05
let sar12_stimulus[5] = sar12_drive
let sar12_stimulus[6] = 0.000148
let sar12_stimulus[7] = sar12_stimulus[5]
alter @VD_B0[pwl] = sar12_stimulus
let sar12_drive = (floor(sar12_trial / 2) - 2*floor(sar12_trial / 4))*1.8
let sar12_previous = @VD_B1[pwl]
let sar12_stimulus = vector(8)
let sar12_stimulus[0] = 0
let sar12_stimulus[1] = sar12_previous[length(sar12_previous)-1]
let sar12_stimulus[2] = 7.15009999999999e-05
let sar12_stimulus[3] = sar12_stimulus[1]
let sar12_stimulus[4] = 7.15029999999999e-05
let sar12_stimulus[5] = sar12_drive
let sar12_stimulus[6] = 0.000148
let sar12_stimulus[7] = sar12_stimulus[5]
alter @VD_B1[pwl] = sar12_stimulus
let sar12_drive = (floor(sar12_trial / 4) - 2*floor(sar12_trial / 8))*1.8
let sar12_previous = @VD_B2[pwl]
let sar12_stimulus = vector(8)
let sar12_stimulus[0] = 0
let sar12_stimulus[1] = sar12_previous[length(sar12_previous)-1]
let sar12_stimulus[2] = 7.15009999999999e-05
let sar12_stimulus[3] = sar12_stimulus[1]
let sar12_stimulus[4] = 7.15029999999999e-05
let sar12_stimulus[5] = sar12_drive
let sar12_stimulus[6] = 0.000148
let sar12_stimulus[7] = sar12_stimulus[5]
alter @VD_B2[pwl] = sar12_stimulus
let sar12_drive = (floor(sar12_trial / 8) - 2*floor(sar12_trial / 16))*1.8
let sar12_previous = @VD_B3[pwl]
let sar12_stimulus = vector(8)
let sar12_stimulus[0] = 0
let sar12_stimulus[1] = sar12_previous[length(sar12_previous)-1]
let sar12_stimulus[2] = 7.15009999999999e-05
let sar12_stimulus[3] = sar12_stimulus[1]
let sar12_stimulus[4] = 7.15029999999999e-05
let sar12_stimulus[5] = sar12_drive
let sar12_stimulus[6] = 0.000148
let sar12_stimulus[7] = sar12_stimulus[5]
alter @VD_B3[pwl] = sar12_stimulus
let sar12_drive = (floor(sar12_trial / 16) - 2*floor(sar12_trial / 32))*1.8
let sar12_previous = @VD_B4[pwl]
let sar12_stimulus = vector(8)
let sar12_stimulus[0] = 0
let sar12_stimulus[1] = sar12_previous[length(sar12_previous)-1]
let sar12_stimulus[2] = 7.15009999999999e-05
let sar12_stimulus[3] = sar12_stimulus[1]
let sar12_stimulus[4] = 7.15029999999999e-05
let sar12_stimulus[5] = sar12_drive
let sar12_stimulus[6] = 0.000148
let sar12_stimulus[7] = sar12_stimulus[5]
alter @VD_B4[pwl] = sar12_stimulus
let sar12_drive = (floor(sar12_trial / 32) - 2*floor(sar12_trial / 64))*1.8
let sar12_previous = @VD_B5[pwl]
let sar12_stimulus = vector(8)
let sar12_stimulus[0] = 0
let sar12_stimulus[1] = sar12_previous[length(sar12_previous)-1]
let sar12_stimulus[2] = 7.15009999999999e-05
let sar12_stimulus[3] = sar12_stimulus[1]
let sar12_stimulus[4] = 7.15029999999999e-05
let sar12_stimulus[5] = sar12_drive
let sar12_stimulus[6] = 0.000148
let sar12_stimulus[7] = sar12_stimulus[5]
alter @VD_B5[pwl] = sar12_stimulus
let sar12_drive = (floor(sar12_trial / 64) - 2*floor(sar12_trial / 128))*1.8
let sar12_previous = @VD_B6[pwl]
let sar12_stimulus = vector(8)
let sar12_stimulus[0] = 0
let sar12_stimulus[1] = sar12_previous[length(sar12_previous)-1]
let sar12_stimulus[2] = 7.15009999999999e-05
let sar12_stimulus[3] = sar12_stimulus[1]
let sar12_stimulus[4] = 7.15029999999999e-05
let sar12_stimulus[5] = sar12_drive
let sar12_stimulus[6] = 0.000148
let sar12_stimulus[7] = sar12_stimulus[5]
alter @VD_B6[pwl] = sar12_stimulus
let sar12_drive = (floor(sar12_trial / 128) - 2*floor(sar12_trial / 256))*1.8
let sar12_previous = @VD_B7[pwl]
let sar12_stimulus = vector(8)
let sar12_stimulus[0] = 0
let sar12_stimulus[1] = sar12_previous[length(sar12_previous)-1]
let sar12_stimulus[2] = 7.15009999999999e-05
let sar12_stimulus[3] = sar12_stimulus[1]
let sar12_stimulus[4] = 7.15029999999999e-05
let sar12_stimulus[5] = sar12_drive
let sar12_stimulus[6] = 0.000148
let sar12_stimulus[7] = sar12_stimulus[5]
alter @VD_B7[pwl] = sar12_stimulus
let sar12_drive = (floor(sar12_trial / 256) - 2*floor(sar12_trial / 512))*1.8
let sar12_previous = @VD_B8[pwl]
let sar12_stimulus = vector(8)
let sar12_stimulus[0] = 0
let sar12_stimulus[1] = sar12_previous[length(sar12_previous)-1]
let sar12_stimulus[2] = 7.15009999999999e-05
let sar12_stimulus[3] = sar12_stimulus[1]
let sar12_stimulus[4] = 7.15029999999999e-05
let sar12_stimulus[5] = sar12_drive
let sar12_stimulus[6] = 0.000148
let sar12_stimulus[7] = sar12_stimulus[5]
alter @VD_B8[pwl] = sar12_stimulus
let sar12_drive = (floor(sar12_trial / 512) - 2*floor(sar12_trial / 1024))*1.8
let sar12_previous = @VD_B9[pwl]
let sar12_stimulus = vector(8)
let sar12_stimulus[0] = 0
let sar12_stimulus[1] = sar12_previous[length(sar12_previous)-1]
let sar12_stimulus[2] = 7.15009999999999e-05
let sar12_stimulus[3] = sar12_stimulus[1]
let sar12_stimulus[4] = 7.15029999999999e-05
let sar12_stimulus[5] = sar12_drive
let sar12_stimulus[6] = 0.000148
let sar12_stimulus[7] = sar12_stimulus[5]
alter @VD_B9[pwl] = sar12_stimulus
let sar12_drive = (floor(sar12_trial / 1024) - 2*floor(sar12_trial / 2048))*1.8
let sar12_previous = @VD_B10[pwl]
let sar12_stimulus = vector(8)
let sar12_stimulus[0] = 0
let sar12_stimulus[1] = sar12_previous[length(sar12_previous)-1]
let sar12_stimulus[2] = 7.15009999999999e-05
let sar12_stimulus[3] = sar12_stimulus[1]
let sar12_stimulus[4] = 7.15029999999999e-05
let sar12_stimulus[5] = sar12_drive
let sar12_stimulus[6] = 0.000148
let sar12_stimulus[7] = sar12_stimulus[5]
alter @VD_B10[pwl] = sar12_stimulus
let sar12_drive = (floor(sar12_trial / 2048) - 2*floor(sar12_trial / 4096))*1.8
let sar12_previous = @VD_B11[pwl]
let sar12_stimulus = vector(8)
let sar12_stimulus[0] = 0
let sar12_stimulus[1] = sar12_previous[length(sar12_previous)-1]
let sar12_stimulus[2] = 7.15009999999999e-05
let sar12_stimulus[3] = sar12_stimulus[1]
let sar12_stimulus[4] = 7.15029999999999e-05
let sar12_stimulus[5] = sar12_drive
let sar12_stimulus[6] = 0.000148
let sar12_stimulus[7] = sar12_stimulus[5]
alter @VD_B11[pwl] = sar12_stimulus
let sar12_drive = (floor(sar12_trial / 4096) - 2*floor(sar12_trial / 8192))*1.8
let sar12_previous = @VD_B12[pwl]
let sar12_stimulus = vector(8)
let sar12_stimulus[0] = 0
let sar12_stimulus[1] = sar12_previous[length(sar12_previous)-1]
let sar12_stimulus[2] = 7.15009999999999e-05
let sar12_stimulus[3] = sar12_stimulus[1]
let sar12_stimulus[4] = 7.15029999999999e-05
let sar12_stimulus[5] = sar12_drive
let sar12_stimulus[6] = 0.000148
let sar12_stimulus[7] = sar12_stimulus[5]
alter @VD_B12[pwl] = sar12_stimulus
let sar12_drive = (floor(sar12_trial / 8192) - 2*floor(sar12_trial / 16384))*1.8
let sar12_previous = @VD_B13[pwl]
let sar12_stimulus = vector(8)
let sar12_stimulus[0] = 0
let sar12_stimulus[1] = sar12_previous[length(sar12_previous)-1]
let sar12_stimulus[2] = 7.15009999999999e-05
let sar12_stimulus[3] = sar12_stimulus[1]
let sar12_stimulus[4] = 7.15029999999999e-05
let sar12_stimulus[5] = sar12_drive
let sar12_stimulus[6] = 0.000148
let sar12_stimulus[7] = sar12_stimulus[5]
alter @VD_B13[pwl] = sar12_stimulus
let sar12_drive = (floor(sar12_trial / 16384) - 2*floor(sar12_trial / 32768))*1.8
let sar12_previous = @VD_B14[pwl]
let sar12_stimulus = vector(8)
let sar12_stimulus[0] = 0
let sar12_stimulus[1] = sar12_previous[length(sar12_previous)-1]
let sar12_stimulus[2] = 7.15009999999999e-05
let sar12_stimulus[3] = sar12_stimulus[1]
let sar12_stimulus[4] = 7.15029999999999e-05
let sar12_stimulus[5] = sar12_drive
let sar12_stimulus[6] = 0.000148
let sar12_stimulus[7] = sar12_stimulus[5]
alter @VD_B14[pwl] = sar12_stimulus
let sar12_drive = (floor(sar12_trial / 32768) - 2*floor(sar12_trial / 65536))*1.8
let sar12_previous = @VD_B15[pwl]
let sar12_stimulus = vector(8)
let sar12_stimulus[0] = 0
let sar12_stimulus[1] = sar12_previous[length(sar12_previous)-1]
let sar12_stimulus[2] = 7.15009999999999e-05
let sar12_stimulus[3] = sar12_stimulus[1]
let sar12_stimulus[4] = 7.15029999999999e-05
let sar12_stimulus[5] = sar12_drive
let sar12_stimulus[6] = 0.000148
let sar12_stimulus[7] = sar12_stimulus[5]
alter @VD_B15[pwl] = sar12_stimulus
resume
let sar12_k = length(time)-1
if abs(time[sar12_k] - 7.19999999999999e-05) > 1e-12
print time[sar12_k]
echo expected_pause_time_s 7.19999999999999e-05
echo SAR12_PAUSE_FAILED
quit 1
end
print time[sar12_k] >> pause-times.txt
let sar12_previous = @VD_EVAL[pwl]
let sar12_stimulus = vector(8)
let sar12_stimulus[0] = 0
let sar12_stimulus[1] = sar12_previous[length(sar12_previous)-1]
let sar12_stimulus[2] = 7.20009999999999e-05
let sar12_stimulus[3] = sar12_stimulus[1]
let sar12_stimulus[4] = 7.20029999999999e-05
let sar12_stimulus[5] = 1.8
let sar12_stimulus[6] = 0.000148
let sar12_stimulus[7] = sar12_stimulus[5]
alter @VD_EVAL[pwl] = sar12_stimulus
resume
let sar12_k = length(time)-1
if abs(time[sar12_k] - 7.24999999999999e-05) > 1e-12
print time[sar12_k]
echo expected_pause_time_s 7.24999999999999e-05
echo SAR12_PAUSE_FAILED
quit 1
end
print time[sar12_k] >> pause-times.txt
let sar12_k = length(time)-1
let sar12_cmp = v(COMP)[sar12_k]
let sar12_cmpn = v(COMPN)[sar12_k]
let sar12_p = v(TOPP)[sar12_k]
let sar12_n = v(TOPN)[sar12_k]
let sar12_decision = 0
if sar12_cmp >= 0.9
let sar12_code = sar12_trial
let sar12_decision = 1
end
echo 2 1 $&sar12_trial $&sar12_cmp $&sar12_cmpn $&sar12_p $&sar12_n -1.19994506835937 $&sar12_decision >> decisions.csv
let sar12_previous = @VD_EVAL[pwl]
let sar12_stimulus = vector(8)
let sar12_stimulus[0] = 0
let sar12_stimulus[1] = sar12_previous[length(sar12_previous)-1]
let sar12_stimulus[2] = 7.25009999999999e-05
let sar12_stimulus[3] = sar12_stimulus[1]
let sar12_stimulus[4] = 7.25029999999999e-05
let sar12_stimulus[5] = 0
let sar12_stimulus[6] = 0.000148
let sar12_stimulus[7] = sar12_stimulus[5]
alter @VD_EVAL[pwl] = sar12_stimulus
let sar12_trial = sar12_code + 1
let sar12_drive = (floor(sar12_trial / 1) - 2*floor(sar12_trial / 2))*1.8
let sar12_previous = @VD_B0[pwl]
let sar12_stimulus = vector(8)
let sar12_stimulus[0] = 0
let sar12_stimulus[1] = sar12_previous[length(sar12_previous)-1]
let sar12_stimulus[2] = 7.25009999999999e-05
let sar12_stimulus[3] = sar12_stimulus[1]
let sar12_stimulus[4] = 7.25029999999999e-05
let sar12_stimulus[5] = sar12_drive
let sar12_stimulus[6] = 0.000148
let sar12_stimulus[7] = sar12_stimulus[5]
alter @VD_B0[pwl] = sar12_stimulus
let sar12_drive = (floor(sar12_trial / 2) - 2*floor(sar12_trial / 4))*1.8
let sar12_previous = @VD_B1[pwl]
let sar12_stimulus = vector(8)
let sar12_stimulus[0] = 0
let sar12_stimulus[1] = sar12_previous[length(sar12_previous)-1]
let sar12_stimulus[2] = 7.25009999999999e-05
let sar12_stimulus[3] = sar12_stimulus[1]
let sar12_stimulus[4] = 7.25029999999999e-05
let sar12_stimulus[5] = sar12_drive
let sar12_stimulus[6] = 0.000148
let sar12_stimulus[7] = sar12_stimulus[5]
alter @VD_B1[pwl] = sar12_stimulus
let sar12_drive = (floor(sar12_trial / 4) - 2*floor(sar12_trial / 8))*1.8
let sar12_previous = @VD_B2[pwl]
let sar12_stimulus = vector(8)
let sar12_stimulus[0] = 0
let sar12_stimulus[1] = sar12_previous[length(sar12_previous)-1]
let sar12_stimulus[2] = 7.25009999999999e-05
let sar12_stimulus[3] = sar12_stimulus[1]
let sar12_stimulus[4] = 7.25029999999999e-05
let sar12_stimulus[5] = sar12_drive
let sar12_stimulus[6] = 0.000148
let sar12_stimulus[7] = sar12_stimulus[5]
alter @VD_B2[pwl] = sar12_stimulus
let sar12_drive = (floor(sar12_trial / 8) - 2*floor(sar12_trial / 16))*1.8
let sar12_previous = @VD_B3[pwl]
let sar12_stimulus = vector(8)
let sar12_stimulus[0] = 0
let sar12_stimulus[1] = sar12_previous[length(sar12_previous)-1]
let sar12_stimulus[2] = 7.25009999999999e-05
let sar12_stimulus[3] = sar12_stimulus[1]
let sar12_stimulus[4] = 7.25029999999999e-05
let sar12_stimulus[5] = sar12_drive
let sar12_stimulus[6] = 0.000148
let sar12_stimulus[7] = sar12_stimulus[5]
alter @VD_B3[pwl] = sar12_stimulus
let sar12_drive = (floor(sar12_trial / 16) - 2*floor(sar12_trial / 32))*1.8
let sar12_previous = @VD_B4[pwl]
let sar12_stimulus = vector(8)
let sar12_stimulus[0] = 0
let sar12_stimulus[1] = sar12_previous[length(sar12_previous)-1]
let sar12_stimulus[2] = 7.25009999999999e-05
let sar12_stimulus[3] = sar12_stimulus[1]
let sar12_stimulus[4] = 7.25029999999999e-05
let sar12_stimulus[5] = sar12_drive
let sar12_stimulus[6] = 0.000148
let sar12_stimulus[7] = sar12_stimulus[5]
alter @VD_B4[pwl] = sar12_stimulus
let sar12_drive = (floor(sar12_trial / 32) - 2*floor(sar12_trial / 64))*1.8
let sar12_previous = @VD_B5[pwl]
let sar12_stimulus = vector(8)
let sar12_stimulus[0] = 0
let sar12_stimulus[1] = sar12_previous[length(sar12_previous)-1]
let sar12_stimulus[2] = 7.25009999999999e-05
let sar12_stimulus[3] = sar12_stimulus[1]
let sar12_stimulus[4] = 7.25029999999999e-05
let sar12_stimulus[5] = sar12_drive
let sar12_stimulus[6] = 0.000148
let sar12_stimulus[7] = sar12_stimulus[5]
alter @VD_B5[pwl] = sar12_stimulus
let sar12_drive = (floor(sar12_trial / 64) - 2*floor(sar12_trial / 128))*1.8
let sar12_previous = @VD_B6[pwl]
let sar12_stimulus = vector(8)
let sar12_stimulus[0] = 0
let sar12_stimulus[1] = sar12_previous[length(sar12_previous)-1]
let sar12_stimulus[2] = 7.25009999999999e-05
let sar12_stimulus[3] = sar12_stimulus[1]
let sar12_stimulus[4] = 7.25029999999999e-05
let sar12_stimulus[5] = sar12_drive
let sar12_stimulus[6] = 0.000148
let sar12_stimulus[7] = sar12_stimulus[5]
alter @VD_B6[pwl] = sar12_stimulus
let sar12_drive = (floor(sar12_trial / 128) - 2*floor(sar12_trial / 256))*1.8
let sar12_previous = @VD_B7[pwl]
let sar12_stimulus = vector(8)
let sar12_stimulus[0] = 0
let sar12_stimulus[1] = sar12_previous[length(sar12_previous)-1]
let sar12_stimulus[2] = 7.25009999999999e-05
let sar12_stimulus[3] = sar12_stimulus[1]
let sar12_stimulus[4] = 7.25029999999999e-05
let sar12_stimulus[5] = sar12_drive
let sar12_stimulus[6] = 0.000148
let sar12_stimulus[7] = sar12_stimulus[5]
alter @VD_B7[pwl] = sar12_stimulus
let sar12_drive = (floor(sar12_trial / 256) - 2*floor(sar12_trial / 512))*1.8
let sar12_previous = @VD_B8[pwl]
let sar12_stimulus = vector(8)
let sar12_stimulus[0] = 0
let sar12_stimulus[1] = sar12_previous[length(sar12_previous)-1]
let sar12_stimulus[2] = 7.25009999999999e-05
let sar12_stimulus[3] = sar12_stimulus[1]
let sar12_stimulus[4] = 7.25029999999999e-05
let sar12_stimulus[5] = sar12_drive
let sar12_stimulus[6] = 0.000148
let sar12_stimulus[7] = sar12_stimulus[5]
alter @VD_B8[pwl] = sar12_stimulus
let sar12_drive = (floor(sar12_trial / 512) - 2*floor(sar12_trial / 1024))*1.8
let sar12_previous = @VD_B9[pwl]
let sar12_stimulus = vector(8)
let sar12_stimulus[0] = 0
let sar12_stimulus[1] = sar12_previous[length(sar12_previous)-1]
let sar12_stimulus[2] = 7.25009999999999e-05
let sar12_stimulus[3] = sar12_stimulus[1]
let sar12_stimulus[4] = 7.25029999999999e-05
let sar12_stimulus[5] = sar12_drive
let sar12_stimulus[6] = 0.000148
let sar12_stimulus[7] = sar12_stimulus[5]
alter @VD_B9[pwl] = sar12_stimulus
let sar12_drive = (floor(sar12_trial / 1024) - 2*floor(sar12_trial / 2048))*1.8
let sar12_previous = @VD_B10[pwl]
let sar12_stimulus = vector(8)
let sar12_stimulus[0] = 0
let sar12_stimulus[1] = sar12_previous[length(sar12_previous)-1]
let sar12_stimulus[2] = 7.25009999999999e-05
let sar12_stimulus[3] = sar12_stimulus[1]
let sar12_stimulus[4] = 7.25029999999999e-05
let sar12_stimulus[5] = sar12_drive
let sar12_stimulus[6] = 0.000148
let sar12_stimulus[7] = sar12_stimulus[5]
alter @VD_B10[pwl] = sar12_stimulus
let sar12_drive = (floor(sar12_trial / 2048) - 2*floor(sar12_trial / 4096))*1.8
let sar12_previous = @VD_B11[pwl]
let sar12_stimulus = vector(8)
let sar12_stimulus[0] = 0
let sar12_stimulus[1] = sar12_previous[length(sar12_previous)-1]
let sar12_stimulus[2] = 7.25009999999999e-05
let sar12_stimulus[3] = sar12_stimulus[1]
let sar12_stimulus[4] = 7.25029999999999e-05
let sar12_stimulus[5] = sar12_drive
let sar12_stimulus[6] = 0.000148
let sar12_stimulus[7] = sar12_stimulus[5]
alter @VD_B11[pwl] = sar12_stimulus
let sar12_drive = (floor(sar12_trial / 4096) - 2*floor(sar12_trial / 8192))*1.8
let sar12_previous = @VD_B12[pwl]
let sar12_stimulus = vector(8)
let sar12_stimulus[0] = 0
let sar12_stimulus[1] = sar12_previous[length(sar12_previous)-1]
let sar12_stimulus[2] = 7.25009999999999e-05
let sar12_stimulus[3] = sar12_stimulus[1]
let sar12_stimulus[4] = 7.25029999999999e-05
let sar12_stimulus[5] = sar12_drive
let sar12_stimulus[6] = 0.000148
let sar12_stimulus[7] = sar12_stimulus[5]
alter @VD_B12[pwl] = sar12_stimulus
let sar12_drive = (floor(sar12_trial / 8192) - 2*floor(sar12_trial / 16384))*1.8
let sar12_previous = @VD_B13[pwl]
let sar12_stimulus = vector(8)
let sar12_stimulus[0] = 0
let sar12_stimulus[1] = sar12_previous[length(sar12_previous)-1]
let sar12_stimulus[2] = 7.25009999999999e-05
let sar12_stimulus[3] = sar12_stimulus[1]
let sar12_stimulus[4] = 7.25029999999999e-05
let sar12_stimulus[5] = sar12_drive
let sar12_stimulus[6] = 0.000148
let sar12_stimulus[7] = sar12_stimulus[5]
alter @VD_B13[pwl] = sar12_stimulus
let sar12_drive = (floor(sar12_trial / 16384) - 2*floor(sar12_trial / 32768))*1.8
let sar12_previous = @VD_B14[pwl]
let sar12_stimulus = vector(8)
let sar12_stimulus[0] = 0
let sar12_stimulus[1] = sar12_previous[length(sar12_previous)-1]
let sar12_stimulus[2] = 7.25009999999999e-05
let sar12_stimulus[3] = sar12_stimulus[1]
let sar12_stimulus[4] = 7.25029999999999e-05
let sar12_stimulus[5] = sar12_drive
let sar12_stimulus[6] = 0.000148
let sar12_stimulus[7] = sar12_stimulus[5]
alter @VD_B14[pwl] = sar12_stimulus
let sar12_drive = (floor(sar12_trial / 32768) - 2*floor(sar12_trial / 65536))*1.8
let sar12_previous = @VD_B15[pwl]
let sar12_stimulus = vector(8)
let sar12_stimulus[0] = 0
let sar12_stimulus[1] = sar12_previous[length(sar12_previous)-1]
let sar12_stimulus[2] = 7.25009999999999e-05
let sar12_stimulus[3] = sar12_stimulus[1]
let sar12_stimulus[4] = 7.25029999999999e-05
let sar12_stimulus[5] = sar12_drive
let sar12_stimulus[6] = 0.000148
let sar12_stimulus[7] = sar12_stimulus[5]
alter @VD_B15[pwl] = sar12_stimulus
resume
let sar12_k = length(time)-1
if abs(time[sar12_k] - 7.29999999999999e-05) > 1e-12
print time[sar12_k]
echo expected_pause_time_s 7.29999999999999e-05
echo SAR12_PAUSE_FAILED
quit 1
end
print time[sar12_k] >> pause-times.txt
let sar12_previous = @VD_EVAL[pwl]
let sar12_stimulus = vector(8)
let sar12_stimulus[0] = 0
let sar12_stimulus[1] = sar12_previous[length(sar12_previous)-1]
let sar12_stimulus[2] = 7.30009999999999e-05
let sar12_stimulus[3] = sar12_stimulus[1]
let sar12_stimulus[4] = 7.30029999999999e-05
let sar12_stimulus[5] = 1.8
let sar12_stimulus[6] = 0.000148
let sar12_stimulus[7] = sar12_stimulus[5]
alter @VD_EVAL[pwl] = sar12_stimulus
resume
let sar12_k = length(time)-1
if abs(time[sar12_k] - 7.34999999999999e-05) > 1e-12
print time[sar12_k]
echo expected_pause_time_s 7.34999999999999e-05
echo SAR12_PAUSE_FAILED
quit 1
end
print time[sar12_k] >> pause-times.txt
let sar12_k = length(time)-1
let sar12_cmp = v(COMP)[sar12_k]
let sar12_cmpn = v(COMPN)[sar12_k]
let sar12_p = v(TOPP)[sar12_k]
let sar12_n = v(TOPN)[sar12_k]
let sar12_decision = 0
if sar12_cmp >= 0.9
let sar12_code = sar12_trial
let sar12_decision = 1
end
echo 2 0 $&sar12_trial $&sar12_cmp $&sar12_cmpn $&sar12_p $&sar12_n -1.19994506835937 $&sar12_decision >> decisions.csv
let sar12_previous = @VD_EVAL[pwl]
let sar12_stimulus = vector(8)
let sar12_stimulus[0] = 0
let sar12_stimulus[1] = sar12_previous[length(sar12_previous)-1]
let sar12_stimulus[2] = 7.35009999999999e-05
let sar12_stimulus[3] = sar12_stimulus[1]
let sar12_stimulus[4] = 7.35029999999999e-05
let sar12_stimulus[5] = 0
let sar12_stimulus[6] = 0.000148
let sar12_stimulus[7] = sar12_stimulus[5]
alter @VD_EVAL[pwl] = sar12_stimulus
let sar12_previous = @VINP[pwl]
let sar12_stimulus = vector(8)
let sar12_stimulus[0] = 0
let sar12_stimulus[1] = sar12_previous[length(sar12_previous)-1]
let sar12_stimulus[2] = 7.35009999999999e-05
let sar12_stimulus[3] = sar12_stimulus[1]
let sar12_stimulus[4] = 7.35029999999999e-05
let sar12_stimulus[5] = 0.899990844727
let sar12_stimulus[6] = 0.000148
let sar12_stimulus[7] = sar12_stimulus[5]
alter @VINP[pwl] = sar12_stimulus
let sar12_previous = @VINN[pwl]
let sar12_stimulus = vector(8)
let sar12_stimulus[0] = 0
let sar12_stimulus[1] = sar12_previous[length(sar12_previous)-1]
let sar12_stimulus[2] = 7.35009999999999e-05
let sar12_stimulus[3] = sar12_stimulus[1]
let sar12_stimulus[4] = 7.35029999999999e-05
let sar12_stimulus[5] = 0.900009155273
let sar12_stimulus[6] = 0.000148
let sar12_stimulus[7] = sar12_stimulus[5]
alter @VINN[pwl] = sar12_stimulus
let sar12_previous = @VD_SAMPLE[pwl]
let sar12_stimulus = vector(8)
let sar12_stimulus[0] = 0
let sar12_stimulus[1] = sar12_previous[length(sar12_previous)-1]
let sar12_stimulus[2] = 7.35009999999999e-05
let sar12_stimulus[3] = sar12_stimulus[1]
let sar12_stimulus[4] = 7.35029999999999e-05
let sar12_stimulus[5] = 1.8
let sar12_stimulus[6] = 0.000148
let sar12_stimulus[7] = sar12_stimulus[5]
alter @VD_SAMPLE[pwl] = sar12_stimulus
let sar12_previous = @VD_EVAL[pwl]
let sar12_stimulus = vector(8)
let sar12_stimulus[0] = 0
let sar12_stimulus[1] = sar12_previous[length(sar12_previous)-1]
let sar12_stimulus[2] = 7.35009999999999e-05
let sar12_stimulus[3] = sar12_stimulus[1]
let sar12_stimulus[4] = 7.35029999999999e-05
let sar12_stimulus[5] = 0
let sar12_stimulus[6] = 0.000148
let sar12_stimulus[7] = sar12_stimulus[5]
alter @VD_EVAL[pwl] = sar12_stimulus
let sar12_previous = @VD_B0[pwl]
let sar12_stimulus = vector(8)
let sar12_stimulus[0] = 0
let sar12_stimulus[1] = sar12_previous[length(sar12_previous)-1]
let sar12_stimulus[2] = 7.35009999999999e-05
let sar12_stimulus[3] = sar12_stimulus[1]
let sar12_stimulus[4] = 7.35029999999999e-05
let sar12_stimulus[5] = 0
let sar12_stimulus[6] = 0.000148
let sar12_stimulus[7] = sar12_stimulus[5]
alter @VD_B0[pwl] = sar12_stimulus
let sar12_previous = @VD_B1[pwl]
let sar12_stimulus = vector(8)
let sar12_stimulus[0] = 0
let sar12_stimulus[1] = sar12_previous[length(sar12_previous)-1]
let sar12_stimulus[2] = 7.35009999999999e-05
let sar12_stimulus[3] = sar12_stimulus[1]
let sar12_stimulus[4] = 7.35029999999999e-05
let sar12_stimulus[5] = 0
let sar12_stimulus[6] = 0.000148
let sar12_stimulus[7] = sar12_stimulus[5]
alter @VD_B1[pwl] = sar12_stimulus
let sar12_previous = @VD_B2[pwl]
let sar12_stimulus = vector(8)
let sar12_stimulus[0] = 0
let sar12_stimulus[1] = sar12_previous[length(sar12_previous)-1]
let sar12_stimulus[2] = 7.35009999999999e-05
let sar12_stimulus[3] = sar12_stimulus[1]
let sar12_stimulus[4] = 7.35029999999999e-05
let sar12_stimulus[5] = 0
let sar12_stimulus[6] = 0.000148
let sar12_stimulus[7] = sar12_stimulus[5]
alter @VD_B2[pwl] = sar12_stimulus
let sar12_previous = @VD_B3[pwl]
let sar12_stimulus = vector(8)
let sar12_stimulus[0] = 0
let sar12_stimulus[1] = sar12_previous[length(sar12_previous)-1]
let sar12_stimulus[2] = 7.35009999999999e-05
let sar12_stimulus[3] = sar12_stimulus[1]
let sar12_stimulus[4] = 7.35029999999999e-05
let sar12_stimulus[5] = 0
let sar12_stimulus[6] = 0.000148
let sar12_stimulus[7] = sar12_stimulus[5]
alter @VD_B3[pwl] = sar12_stimulus
let sar12_previous = @VD_B4[pwl]
let sar12_stimulus = vector(8)
let sar12_stimulus[0] = 0
let sar12_stimulus[1] = sar12_previous[length(sar12_previous)-1]
let sar12_stimulus[2] = 7.35009999999999e-05
let sar12_stimulus[3] = sar12_stimulus[1]
let sar12_stimulus[4] = 7.35029999999999e-05
let sar12_stimulus[5] = 0
let sar12_stimulus[6] = 0.000148
let sar12_stimulus[7] = sar12_stimulus[5]
alter @VD_B4[pwl] = sar12_stimulus
let sar12_previous = @VD_B5[pwl]
let sar12_stimulus = vector(8)
let sar12_stimulus[0] = 0
let sar12_stimulus[1] = sar12_previous[length(sar12_previous)-1]
let sar12_stimulus[2] = 7.35009999999999e-05
let sar12_stimulus[3] = sar12_stimulus[1]
let sar12_stimulus[4] = 7.35029999999999e-05
let sar12_stimulus[5] = 0
let sar12_stimulus[6] = 0.000148
let sar12_stimulus[7] = sar12_stimulus[5]
alter @VD_B5[pwl] = sar12_stimulus
let sar12_previous = @VD_B6[pwl]
let sar12_stimulus = vector(8)
let sar12_stimulus[0] = 0
let sar12_stimulus[1] = sar12_previous[length(sar12_previous)-1]
let sar12_stimulus[2] = 7.35009999999999e-05
let sar12_stimulus[3] = sar12_stimulus[1]
let sar12_stimulus[4] = 7.35029999999999e-05
let sar12_stimulus[5] = 0
let sar12_stimulus[6] = 0.000148
let sar12_stimulus[7] = sar12_stimulus[5]
alter @VD_B6[pwl] = sar12_stimulus
let sar12_previous = @VD_B7[pwl]
let sar12_stimulus = vector(8)
let sar12_stimulus[0] = 0
let sar12_stimulus[1] = sar12_previous[length(sar12_previous)-1]
let sar12_stimulus[2] = 7.35009999999999e-05
let sar12_stimulus[3] = sar12_stimulus[1]
let sar12_stimulus[4] = 7.35029999999999e-05
let sar12_stimulus[5] = 0
let sar12_stimulus[6] = 0.000148
let sar12_stimulus[7] = sar12_stimulus[5]
alter @VD_B7[pwl] = sar12_stimulus
let sar12_previous = @VD_B8[pwl]
let sar12_stimulus = vector(8)
let sar12_stimulus[0] = 0
let sar12_stimulus[1] = sar12_previous[length(sar12_previous)-1]
let sar12_stimulus[2] = 7.35009999999999e-05
let sar12_stimulus[3] = sar12_stimulus[1]
let sar12_stimulus[4] = 7.35029999999999e-05
let sar12_stimulus[5] = 0
let sar12_stimulus[6] = 0.000148
let sar12_stimulus[7] = sar12_stimulus[5]
alter @VD_B8[pwl] = sar12_stimulus
let sar12_previous = @VD_B9[pwl]
let sar12_stimulus = vector(8)
let sar12_stimulus[0] = 0
let sar12_stimulus[1] = sar12_previous[length(sar12_previous)-1]
let sar12_stimulus[2] = 7.35009999999999e-05
let sar12_stimulus[3] = sar12_stimulus[1]
let sar12_stimulus[4] = 7.35029999999999e-05
let sar12_stimulus[5] = 0
let sar12_stimulus[6] = 0.000148
let sar12_stimulus[7] = sar12_stimulus[5]
alter @VD_B9[pwl] = sar12_stimulus
let sar12_previous = @VD_B10[pwl]
let sar12_stimulus = vector(8)
let sar12_stimulus[0] = 0
let sar12_stimulus[1] = sar12_previous[length(sar12_previous)-1]
let sar12_stimulus[2] = 7.35009999999999e-05
let sar12_stimulus[3] = sar12_stimulus[1]
let sar12_stimulus[4] = 7.35029999999999e-05
let sar12_stimulus[5] = 0
let sar12_stimulus[6] = 0.000148
let sar12_stimulus[7] = sar12_stimulus[5]
alter @VD_B10[pwl] = sar12_stimulus
let sar12_previous = @VD_B11[pwl]
let sar12_stimulus = vector(8)
let sar12_stimulus[0] = 0
let sar12_stimulus[1] = sar12_previous[length(sar12_previous)-1]
let sar12_stimulus[2] = 7.35009999999999e-05
let sar12_stimulus[3] = sar12_stimulus[1]
let sar12_stimulus[4] = 7.35029999999999e-05
let sar12_stimulus[5] = 0
let sar12_stimulus[6] = 0.000148
let sar12_stimulus[7] = sar12_stimulus[5]
alter @VD_B11[pwl] = sar12_stimulus
let sar12_previous = @VD_B12[pwl]
let sar12_stimulus = vector(8)
let sar12_stimulus[0] = 0
let sar12_stimulus[1] = sar12_previous[length(sar12_previous)-1]
let sar12_stimulus[2] = 7.35009999999999e-05
let sar12_stimulus[3] = sar12_stimulus[1]
let sar12_stimulus[4] = 7.35029999999999e-05
let sar12_stimulus[5] = 0
let sar12_stimulus[6] = 0.000148
let sar12_stimulus[7] = sar12_stimulus[5]
alter @VD_B12[pwl] = sar12_stimulus
let sar12_previous = @VD_B13[pwl]
let sar12_stimulus = vector(8)
let sar12_stimulus[0] = 0
let sar12_stimulus[1] = sar12_previous[length(sar12_previous)-1]
let sar12_stimulus[2] = 7.35009999999999e-05
let sar12_stimulus[3] = sar12_stimulus[1]
let sar12_stimulus[4] = 7.35029999999999e-05
let sar12_stimulus[5] = 0
let sar12_stimulus[6] = 0.000148
let sar12_stimulus[7] = sar12_stimulus[5]
alter @VD_B13[pwl] = sar12_stimulus
let sar12_previous = @VD_B14[pwl]
let sar12_stimulus = vector(8)
let sar12_stimulus[0] = 0
let sar12_stimulus[1] = sar12_previous[length(sar12_previous)-1]
let sar12_stimulus[2] = 7.35009999999999e-05
let sar12_stimulus[3] = sar12_stimulus[1]
let sar12_stimulus[4] = 7.35029999999999e-05
let sar12_stimulus[5] = 0
let sar12_stimulus[6] = 0.000148
let sar12_stimulus[7] = sar12_stimulus[5]
alter @VD_B14[pwl] = sar12_stimulus
let sar12_previous = @VD_B15[pwl]
let sar12_stimulus = vector(8)
let sar12_stimulus[0] = 0
let sar12_stimulus[1] = sar12_previous[length(sar12_previous)-1]
let sar12_stimulus[2] = 7.35009999999999e-05
let sar12_stimulus[3] = sar12_stimulus[1]
let sar12_stimulus[4] = 7.35029999999999e-05
let sar12_stimulus[5] = 0
let sar12_stimulus[6] = 0.000148
let sar12_stimulus[7] = sar12_stimulus[5]
alter @VD_B15[pwl] = sar12_stimulus
let sar12_code = 0
resume
let sar12_k = length(time)-1
if abs(time[sar12_k] - 8.14999999999999e-05) > 1e-12
print time[sar12_k]
echo expected_pause_time_s 8.14999999999999e-05
echo SAR12_PAUSE_FAILED
quit 1
end
print time[sar12_k] >> pause-times.txt
let sar12_previous = @VD_SAMPLE[pwl]
let sar12_stimulus = vector(8)
let sar12_stimulus[0] = 0
let sar12_stimulus[1] = sar12_previous[length(sar12_previous)-1]
let sar12_stimulus[2] = 8.15009999999999e-05
let sar12_stimulus[3] = sar12_stimulus[1]
let sar12_stimulus[4] = 8.15029999999999e-05
let sar12_stimulus[5] = 0
let sar12_stimulus[6] = 0.000148
let sar12_stimulus[7] = sar12_stimulus[5]
alter @VD_SAMPLE[pwl] = sar12_stimulus
resume
let sar12_k = length(time)-1
if abs(time[sar12_k] - 8.19999999999999e-05) > 1e-12
print time[sar12_k]
echo expected_pause_time_s 8.19999999999999e-05
echo SAR12_PAUSE_FAILED
quit 1
end
print time[sar12_k] >> pause-times.txt
let sar12_previous = @VD_EVAL[pwl]
let sar12_stimulus = vector(8)
let sar12_stimulus[0] = 0
let sar12_stimulus[1] = sar12_previous[length(sar12_previous)-1]
let sar12_stimulus[2] = 8.20009999999999e-05
let sar12_stimulus[3] = sar12_stimulus[1]
let sar12_stimulus[4] = 8.20029999999999e-05
let sar12_stimulus[5] = 0
let sar12_stimulus[6] = 0.000148
let sar12_stimulus[7] = sar12_stimulus[5]
alter @VD_EVAL[pwl] = sar12_stimulus
let sar12_trial = sar12_code + 32768
let sar12_drive = (floor(sar12_trial / 1) - 2*floor(sar12_trial / 2))*1.8
let sar12_previous = @VD_B0[pwl]
let sar12_stimulus = vector(8)
let sar12_stimulus[0] = 0
let sar12_stimulus[1] = sar12_previous[length(sar12_previous)-1]
let sar12_stimulus[2] = 8.20009999999999e-05
let sar12_stimulus[3] = sar12_stimulus[1]
let sar12_stimulus[4] = 8.20029999999999e-05
let sar12_stimulus[5] = sar12_drive
let sar12_stimulus[6] = 0.000148
let sar12_stimulus[7] = sar12_stimulus[5]
alter @VD_B0[pwl] = sar12_stimulus
let sar12_drive = (floor(sar12_trial / 2) - 2*floor(sar12_trial / 4))*1.8
let sar12_previous = @VD_B1[pwl]
let sar12_stimulus = vector(8)
let sar12_stimulus[0] = 0
let sar12_stimulus[1] = sar12_previous[length(sar12_previous)-1]
let sar12_stimulus[2] = 8.20009999999999e-05
let sar12_stimulus[3] = sar12_stimulus[1]
let sar12_stimulus[4] = 8.20029999999999e-05
let sar12_stimulus[5] = sar12_drive
let sar12_stimulus[6] = 0.000148
let sar12_stimulus[7] = sar12_stimulus[5]
alter @VD_B1[pwl] = sar12_stimulus
let sar12_drive = (floor(sar12_trial / 4) - 2*floor(sar12_trial / 8))*1.8
let sar12_previous = @VD_B2[pwl]
let sar12_stimulus = vector(8)
let sar12_stimulus[0] = 0
let sar12_stimulus[1] = sar12_previous[length(sar12_previous)-1]
let sar12_stimulus[2] = 8.20009999999999e-05
let sar12_stimulus[3] = sar12_stimulus[1]
let sar12_stimulus[4] = 8.20029999999999e-05
let sar12_stimulus[5] = sar12_drive
let sar12_stimulus[6] = 0.000148
let sar12_stimulus[7] = sar12_stimulus[5]
alter @VD_B2[pwl] = sar12_stimulus
let sar12_drive = (floor(sar12_trial / 8) - 2*floor(sar12_trial / 16))*1.8
let sar12_previous = @VD_B3[pwl]
let sar12_stimulus = vector(8)
let sar12_stimulus[0] = 0
let sar12_stimulus[1] = sar12_previous[length(sar12_previous)-1]
let sar12_stimulus[2] = 8.20009999999999e-05
let sar12_stimulus[3] = sar12_stimulus[1]
let sar12_stimulus[4] = 8.20029999999999e-05
let sar12_stimulus[5] = sar12_drive
let sar12_stimulus[6] = 0.000148
let sar12_stimulus[7] = sar12_stimulus[5]
alter @VD_B3[pwl] = sar12_stimulus
let sar12_drive = (floor(sar12_trial / 16) - 2*floor(sar12_trial / 32))*1.8
let sar12_previous = @VD_B4[pwl]
let sar12_stimulus = vector(8)
let sar12_stimulus[0] = 0
let sar12_stimulus[1] = sar12_previous[length(sar12_previous)-1]
let sar12_stimulus[2] = 8.20009999999999e-05
let sar12_stimulus[3] = sar12_stimulus[1]
let sar12_stimulus[4] = 8.20029999999999e-05
let sar12_stimulus[5] = sar12_drive
let sar12_stimulus[6] = 0.000148
let sar12_stimulus[7] = sar12_stimulus[5]
alter @VD_B4[pwl] = sar12_stimulus
let sar12_drive = (floor(sar12_trial / 32) - 2*floor(sar12_trial / 64))*1.8
let sar12_previous = @VD_B5[pwl]
let sar12_stimulus = vector(8)
let sar12_stimulus[0] = 0
let sar12_stimulus[1] = sar12_previous[length(sar12_previous)-1]
let sar12_stimulus[2] = 8.20009999999999e-05
let sar12_stimulus[3] = sar12_stimulus[1]
let sar12_stimulus[4] = 8.20029999999999e-05
let sar12_stimulus[5] = sar12_drive
let sar12_stimulus[6] = 0.000148
let sar12_stimulus[7] = sar12_stimulus[5]
alter @VD_B5[pwl] = sar12_stimulus
let sar12_drive = (floor(sar12_trial / 64) - 2*floor(sar12_trial / 128))*1.8
let sar12_previous = @VD_B6[pwl]
let sar12_stimulus = vector(8)
let sar12_stimulus[0] = 0
let sar12_stimulus[1] = sar12_previous[length(sar12_previous)-1]
let sar12_stimulus[2] = 8.20009999999999e-05
let sar12_stimulus[3] = sar12_stimulus[1]
let sar12_stimulus[4] = 8.20029999999999e-05
let sar12_stimulus[5] = sar12_drive
let sar12_stimulus[6] = 0.000148
let sar12_stimulus[7] = sar12_stimulus[5]
alter @VD_B6[pwl] = sar12_stimulus
let sar12_drive = (floor(sar12_trial / 128) - 2*floor(sar12_trial / 256))*1.8
let sar12_previous = @VD_B7[pwl]
let sar12_stimulus = vector(8)
let sar12_stimulus[0] = 0
let sar12_stimulus[1] = sar12_previous[length(sar12_previous)-1]
let sar12_stimulus[2] = 8.20009999999999e-05
let sar12_stimulus[3] = sar12_stimulus[1]
let sar12_stimulus[4] = 8.20029999999999e-05
let sar12_stimulus[5] = sar12_drive
let sar12_stimulus[6] = 0.000148
let sar12_stimulus[7] = sar12_stimulus[5]
alter @VD_B7[pwl] = sar12_stimulus
let sar12_drive = (floor(sar12_trial / 256) - 2*floor(sar12_trial / 512))*1.8
let sar12_previous = @VD_B8[pwl]
let sar12_stimulus = vector(8)
let sar12_stimulus[0] = 0
let sar12_stimulus[1] = sar12_previous[length(sar12_previous)-1]
let sar12_stimulus[2] = 8.20009999999999e-05
let sar12_stimulus[3] = sar12_stimulus[1]
let sar12_stimulus[4] = 8.20029999999999e-05
let sar12_stimulus[5] = sar12_drive
let sar12_stimulus[6] = 0.000148
let sar12_stimulus[7] = sar12_stimulus[5]
alter @VD_B8[pwl] = sar12_stimulus
let sar12_drive = (floor(sar12_trial / 512) - 2*floor(sar12_trial / 1024))*1.8
let sar12_previous = @VD_B9[pwl]
let sar12_stimulus = vector(8)
let sar12_stimulus[0] = 0
let sar12_stimulus[1] = sar12_previous[length(sar12_previous)-1]
let sar12_stimulus[2] = 8.20009999999999e-05
let sar12_stimulus[3] = sar12_stimulus[1]
let sar12_stimulus[4] = 8.20029999999999e-05
let sar12_stimulus[5] = sar12_drive
let sar12_stimulus[6] = 0.000148
let sar12_stimulus[7] = sar12_stimulus[5]
alter @VD_B9[pwl] = sar12_stimulus
let sar12_drive = (floor(sar12_trial / 1024) - 2*floor(sar12_trial / 2048))*1.8
let sar12_previous = @VD_B10[pwl]
let sar12_stimulus = vector(8)
let sar12_stimulus[0] = 0
let sar12_stimulus[1] = sar12_previous[length(sar12_previous)-1]
let sar12_stimulus[2] = 8.20009999999999e-05
let sar12_stimulus[3] = sar12_stimulus[1]
let sar12_stimulus[4] = 8.20029999999999e-05
let sar12_stimulus[5] = sar12_drive
let sar12_stimulus[6] = 0.000148
let sar12_stimulus[7] = sar12_stimulus[5]
alter @VD_B10[pwl] = sar12_stimulus
let sar12_drive = (floor(sar12_trial / 2048) - 2*floor(sar12_trial / 4096))*1.8
let sar12_previous = @VD_B11[pwl]
let sar12_stimulus = vector(8)
let sar12_stimulus[0] = 0
let sar12_stimulus[1] = sar12_previous[length(sar12_previous)-1]
let sar12_stimulus[2] = 8.20009999999999e-05
let sar12_stimulus[3] = sar12_stimulus[1]
let sar12_stimulus[4] = 8.20029999999999e-05
let sar12_stimulus[5] = sar12_drive
let sar12_stimulus[6] = 0.000148
let sar12_stimulus[7] = sar12_stimulus[5]
alter @VD_B11[pwl] = sar12_stimulus
let sar12_drive = (floor(sar12_trial / 4096) - 2*floor(sar12_trial / 8192))*1.8
let sar12_previous = @VD_B12[pwl]
let sar12_stimulus = vector(8)
let sar12_stimulus[0] = 0
let sar12_stimulus[1] = sar12_previous[length(sar12_previous)-1]
let sar12_stimulus[2] = 8.20009999999999e-05
let sar12_stimulus[3] = sar12_stimulus[1]
let sar12_stimulus[4] = 8.20029999999999e-05
let sar12_stimulus[5] = sar12_drive
let sar12_stimulus[6] = 0.000148
let sar12_stimulus[7] = sar12_stimulus[5]
alter @VD_B12[pwl] = sar12_stimulus
let sar12_drive = (floor(sar12_trial / 8192) - 2*floor(sar12_trial / 16384))*1.8
let sar12_previous = @VD_B13[pwl]
let sar12_stimulus = vector(8)
let sar12_stimulus[0] = 0
let sar12_stimulus[1] = sar12_previous[length(sar12_previous)-1]
let sar12_stimulus[2] = 8.20009999999999e-05
let sar12_stimulus[3] = sar12_stimulus[1]
let sar12_stimulus[4] = 8.20029999999999e-05
let sar12_stimulus[5] = sar12_drive
let sar12_stimulus[6] = 0.000148
let sar12_stimulus[7] = sar12_stimulus[5]
alter @VD_B13[pwl] = sar12_stimulus
let sar12_drive = (floor(sar12_trial / 16384) - 2*floor(sar12_trial / 32768))*1.8
let sar12_previous = @VD_B14[pwl]
let sar12_stimulus = vector(8)
let sar12_stimulus[0] = 0
let sar12_stimulus[1] = sar12_previous[length(sar12_previous)-1]
let sar12_stimulus[2] = 8.20009999999999e-05
let sar12_stimulus[3] = sar12_stimulus[1]
let sar12_stimulus[4] = 8.20029999999999e-05
let sar12_stimulus[5] = sar12_drive
let sar12_stimulus[6] = 0.000148
let sar12_stimulus[7] = sar12_stimulus[5]
alter @VD_B14[pwl] = sar12_stimulus
let sar12_drive = (floor(sar12_trial / 32768) - 2*floor(sar12_trial / 65536))*1.8
let sar12_previous = @VD_B15[pwl]
let sar12_stimulus = vector(8)
let sar12_stimulus[0] = 0
let sar12_stimulus[1] = sar12_previous[length(sar12_previous)-1]
let sar12_stimulus[2] = 8.20009999999999e-05
let sar12_stimulus[3] = sar12_stimulus[1]
let sar12_stimulus[4] = 8.20029999999999e-05
let sar12_stimulus[5] = sar12_drive
let sar12_stimulus[6] = 0.000148
let sar12_stimulus[7] = sar12_stimulus[5]
alter @VD_B15[pwl] = sar12_stimulus
resume
let sar12_k = length(time)-1
if abs(time[sar12_k] - 8.24999999999999e-05) > 1e-12
print time[sar12_k]
echo expected_pause_time_s 8.24999999999999e-05
echo SAR12_PAUSE_FAILED
quit 1
end
print time[sar12_k] >> pause-times.txt
let sar12_previous = @VD_EVAL[pwl]
let sar12_stimulus = vector(8)
let sar12_stimulus[0] = 0
let sar12_stimulus[1] = sar12_previous[length(sar12_previous)-1]
let sar12_stimulus[2] = 8.25009999999999e-05
let sar12_stimulus[3] = sar12_stimulus[1]
let sar12_stimulus[4] = 8.25029999999999e-05
let sar12_stimulus[5] = 1.8
let sar12_stimulus[6] = 0.000148
let sar12_stimulus[7] = sar12_stimulus[5]
alter @VD_EVAL[pwl] = sar12_stimulus
resume
let sar12_k = length(time)-1
if abs(time[sar12_k] - 8.29999999999999e-05) > 1e-12
print time[sar12_k]
echo expected_pause_time_s 8.29999999999999e-05
echo SAR12_PAUSE_FAILED
quit 1
end
print time[sar12_k] >> pause-times.txt
let sar12_k = length(time)-1
let sar12_cmp = v(COMP)[sar12_k]
let sar12_cmpn = v(COMPN)[sar12_k]
let sar12_p = v(TOPP)[sar12_k]
let sar12_n = v(TOPN)[sar12_k]
let sar12_decision = 0
if sar12_cmp >= 0.9
let sar12_code = sar12_trial
let sar12_decision = 1
end
echo 3 15 $&sar12_trial $&sar12_cmp $&sar12_cmpn $&sar12_p $&sar12_n -1.8310546875e-05 $&sar12_decision >> decisions.csv
let sar12_previous = @VD_EVAL[pwl]
let sar12_stimulus = vector(8)
let sar12_stimulus[0] = 0
let sar12_stimulus[1] = sar12_previous[length(sar12_previous)-1]
let sar12_stimulus[2] = 8.30009999999999e-05
let sar12_stimulus[3] = sar12_stimulus[1]
let sar12_stimulus[4] = 8.30029999999999e-05
let sar12_stimulus[5] = 0
let sar12_stimulus[6] = 0.000148
let sar12_stimulus[7] = sar12_stimulus[5]
alter @VD_EVAL[pwl] = sar12_stimulus
let sar12_trial = sar12_code + 16384
let sar12_drive = (floor(sar12_trial / 1) - 2*floor(sar12_trial / 2))*1.8
let sar12_previous = @VD_B0[pwl]
let sar12_stimulus = vector(8)
let sar12_stimulus[0] = 0
let sar12_stimulus[1] = sar12_previous[length(sar12_previous)-1]
let sar12_stimulus[2] = 8.30009999999999e-05
let sar12_stimulus[3] = sar12_stimulus[1]
let sar12_stimulus[4] = 8.30029999999999e-05
let sar12_stimulus[5] = sar12_drive
let sar12_stimulus[6] = 0.000148
let sar12_stimulus[7] = sar12_stimulus[5]
alter @VD_B0[pwl] = sar12_stimulus
let sar12_drive = (floor(sar12_trial / 2) - 2*floor(sar12_trial / 4))*1.8
let sar12_previous = @VD_B1[pwl]
let sar12_stimulus = vector(8)
let sar12_stimulus[0] = 0
let sar12_stimulus[1] = sar12_previous[length(sar12_previous)-1]
let sar12_stimulus[2] = 8.30009999999999e-05
let sar12_stimulus[3] = sar12_stimulus[1]
let sar12_stimulus[4] = 8.30029999999999e-05
let sar12_stimulus[5] = sar12_drive
let sar12_stimulus[6] = 0.000148
let sar12_stimulus[7] = sar12_stimulus[5]
alter @VD_B1[pwl] = sar12_stimulus
let sar12_drive = (floor(sar12_trial / 4) - 2*floor(sar12_trial / 8))*1.8
let sar12_previous = @VD_B2[pwl]
let sar12_stimulus = vector(8)
let sar12_stimulus[0] = 0
let sar12_stimulus[1] = sar12_previous[length(sar12_previous)-1]
let sar12_stimulus[2] = 8.30009999999999e-05
let sar12_stimulus[3] = sar12_stimulus[1]
let sar12_stimulus[4] = 8.30029999999999e-05
let sar12_stimulus[5] = sar12_drive
let sar12_stimulus[6] = 0.000148
let sar12_stimulus[7] = sar12_stimulus[5]
alter @VD_B2[pwl] = sar12_stimulus
let sar12_drive = (floor(sar12_trial / 8) - 2*floor(sar12_trial / 16))*1.8
let sar12_previous = @VD_B3[pwl]
let sar12_stimulus = vector(8)
let sar12_stimulus[0] = 0
let sar12_stimulus[1] = sar12_previous[length(sar12_previous)-1]
let sar12_stimulus[2] = 8.30009999999999e-05
let sar12_stimulus[3] = sar12_stimulus[1]
let sar12_stimulus[4] = 8.30029999999999e-05
let sar12_stimulus[5] = sar12_drive
let sar12_stimulus[6] = 0.000148
let sar12_stimulus[7] = sar12_stimulus[5]
alter @VD_B3[pwl] = sar12_stimulus
let sar12_drive = (floor(sar12_trial / 16) - 2*floor(sar12_trial / 32))*1.8
let sar12_previous = @VD_B4[pwl]
let sar12_stimulus = vector(8)
let sar12_stimulus[0] = 0
let sar12_stimulus[1] = sar12_previous[length(sar12_previous)-1]
let sar12_stimulus[2] = 8.30009999999999e-05
let sar12_stimulus[3] = sar12_stimulus[1]
let sar12_stimulus[4] = 8.30029999999999e-05
let sar12_stimulus[5] = sar12_drive
let sar12_stimulus[6] = 0.000148
let sar12_stimulus[7] = sar12_stimulus[5]
alter @VD_B4[pwl] = sar12_stimulus
let sar12_drive = (floor(sar12_trial / 32) - 2*floor(sar12_trial / 64))*1.8
let sar12_previous = @VD_B5[pwl]
let sar12_stimulus = vector(8)
let sar12_stimulus[0] = 0
let sar12_stimulus[1] = sar12_previous[length(sar12_previous)-1]
let sar12_stimulus[2] = 8.30009999999999e-05
let sar12_stimulus[3] = sar12_stimulus[1]
let sar12_stimulus[4] = 8.30029999999999e-05
let sar12_stimulus[5] = sar12_drive
let sar12_stimulus[6] = 0.000148
let sar12_stimulus[7] = sar12_stimulus[5]
alter @VD_B5[pwl] = sar12_stimulus
let sar12_drive = (floor(sar12_trial / 64) - 2*floor(sar12_trial / 128))*1.8
let sar12_previous = @VD_B6[pwl]
let sar12_stimulus = vector(8)
let sar12_stimulus[0] = 0
let sar12_stimulus[1] = sar12_previous[length(sar12_previous)-1]
let sar12_stimulus[2] = 8.30009999999999e-05
let sar12_stimulus[3] = sar12_stimulus[1]
let sar12_stimulus[4] = 8.30029999999999e-05
let sar12_stimulus[5] = sar12_drive
let sar12_stimulus[6] = 0.000148
let sar12_stimulus[7] = sar12_stimulus[5]
alter @VD_B6[pwl] = sar12_stimulus
let sar12_drive = (floor(sar12_trial / 128) - 2*floor(sar12_trial / 256))*1.8
let sar12_previous = @VD_B7[pwl]
let sar12_stimulus = vector(8)
let sar12_stimulus[0] = 0
let sar12_stimulus[1] = sar12_previous[length(sar12_previous)-1]
let sar12_stimulus[2] = 8.30009999999999e-05
let sar12_stimulus[3] = sar12_stimulus[1]
let sar12_stimulus[4] = 8.30029999999999e-05
let sar12_stimulus[5] = sar12_drive
let sar12_stimulus[6] = 0.000148
let sar12_stimulus[7] = sar12_stimulus[5]
alter @VD_B7[pwl] = sar12_stimulus
let sar12_drive = (floor(sar12_trial / 256) - 2*floor(sar12_trial / 512))*1.8
let sar12_previous = @VD_B8[pwl]
let sar12_stimulus = vector(8)
let sar12_stimulus[0] = 0
let sar12_stimulus[1] = sar12_previous[length(sar12_previous)-1]
let sar12_stimulus[2] = 8.30009999999999e-05
let sar12_stimulus[3] = sar12_stimulus[1]
let sar12_stimulus[4] = 8.30029999999999e-05
let sar12_stimulus[5] = sar12_drive
let sar12_stimulus[6] = 0.000148
let sar12_stimulus[7] = sar12_stimulus[5]
alter @VD_B8[pwl] = sar12_stimulus
let sar12_drive = (floor(sar12_trial / 512) - 2*floor(sar12_trial / 1024))*1.8
let sar12_previous = @VD_B9[pwl]
let sar12_stimulus = vector(8)
let sar12_stimulus[0] = 0
let sar12_stimulus[1] = sar12_previous[length(sar12_previous)-1]
let sar12_stimulus[2] = 8.30009999999999e-05
let sar12_stimulus[3] = sar12_stimulus[1]
let sar12_stimulus[4] = 8.30029999999999e-05
let sar12_stimulus[5] = sar12_drive
let sar12_stimulus[6] = 0.000148
let sar12_stimulus[7] = sar12_stimulus[5]
alter @VD_B9[pwl] = sar12_stimulus
let sar12_drive = (floor(sar12_trial / 1024) - 2*floor(sar12_trial / 2048))*1.8
let sar12_previous = @VD_B10[pwl]
let sar12_stimulus = vector(8)
let sar12_stimulus[0] = 0
let sar12_stimulus[1] = sar12_previous[length(sar12_previous)-1]
let sar12_stimulus[2] = 8.30009999999999e-05
let sar12_stimulus[3] = sar12_stimulus[1]
let sar12_stimulus[4] = 8.30029999999999e-05
let sar12_stimulus[5] = sar12_drive
let sar12_stimulus[6] = 0.000148
let sar12_stimulus[7] = sar12_stimulus[5]
alter @VD_B10[pwl] = sar12_stimulus
let sar12_drive = (floor(sar12_trial / 2048) - 2*floor(sar12_trial / 4096))*1.8
let sar12_previous = @VD_B11[pwl]
let sar12_stimulus = vector(8)
let sar12_stimulus[0] = 0
let sar12_stimulus[1] = sar12_previous[length(sar12_previous)-1]
let sar12_stimulus[2] = 8.30009999999999e-05
let sar12_stimulus[3] = sar12_stimulus[1]
let sar12_stimulus[4] = 8.30029999999999e-05
let sar12_stimulus[5] = sar12_drive
let sar12_stimulus[6] = 0.000148
let sar12_stimulus[7] = sar12_stimulus[5]
alter @VD_B11[pwl] = sar12_stimulus
let sar12_drive = (floor(sar12_trial / 4096) - 2*floor(sar12_trial / 8192))*1.8
let sar12_previous = @VD_B12[pwl]
let sar12_stimulus = vector(8)
let sar12_stimulus[0] = 0
let sar12_stimulus[1] = sar12_previous[length(sar12_previous)-1]
let sar12_stimulus[2] = 8.30009999999999e-05
let sar12_stimulus[3] = sar12_stimulus[1]
let sar12_stimulus[4] = 8.30029999999999e-05
let sar12_stimulus[5] = sar12_drive
let sar12_stimulus[6] = 0.000148
let sar12_stimulus[7] = sar12_stimulus[5]
alter @VD_B12[pwl] = sar12_stimulus
let sar12_drive = (floor(sar12_trial / 8192) - 2*floor(sar12_trial / 16384))*1.8
let sar12_previous = @VD_B13[pwl]
let sar12_stimulus = vector(8)
let sar12_stimulus[0] = 0
let sar12_stimulus[1] = sar12_previous[length(sar12_previous)-1]
let sar12_stimulus[2] = 8.30009999999999e-05
let sar12_stimulus[3] = sar12_stimulus[1]
let sar12_stimulus[4] = 8.30029999999999e-05
let sar12_stimulus[5] = sar12_drive
let sar12_stimulus[6] = 0.000148
let sar12_stimulus[7] = sar12_stimulus[5]
alter @VD_B13[pwl] = sar12_stimulus
let sar12_drive = (floor(sar12_trial / 16384) - 2*floor(sar12_trial / 32768))*1.8
let sar12_previous = @VD_B14[pwl]
let sar12_stimulus = vector(8)
let sar12_stimulus[0] = 0
let sar12_stimulus[1] = sar12_previous[length(sar12_previous)-1]
let sar12_stimulus[2] = 8.30009999999999e-05
let sar12_stimulus[3] = sar12_stimulus[1]
let sar12_stimulus[4] = 8.30029999999999e-05
let sar12_stimulus[5] = sar12_drive
let sar12_stimulus[6] = 0.000148
let sar12_stimulus[7] = sar12_stimulus[5]
alter @VD_B14[pwl] = sar12_stimulus
let sar12_drive = (floor(sar12_trial / 32768) - 2*floor(sar12_trial / 65536))*1.8
let sar12_previous = @VD_B15[pwl]
let sar12_stimulus = vector(8)
let sar12_stimulus[0] = 0
let sar12_stimulus[1] = sar12_previous[length(sar12_previous)-1]
let sar12_stimulus[2] = 8.30009999999999e-05
let sar12_stimulus[3] = sar12_stimulus[1]
let sar12_stimulus[4] = 8.30029999999999e-05
let sar12_stimulus[5] = sar12_drive
let sar12_stimulus[6] = 0.000148
let sar12_stimulus[7] = sar12_stimulus[5]
alter @VD_B15[pwl] = sar12_stimulus
resume
let sar12_k = length(time)-1
if abs(time[sar12_k] - 8.34999999999999e-05) > 1e-12
print time[sar12_k]
echo expected_pause_time_s 8.34999999999999e-05
echo SAR12_PAUSE_FAILED
quit 1
end
print time[sar12_k] >> pause-times.txt
let sar12_previous = @VD_EVAL[pwl]
let sar12_stimulus = vector(8)
let sar12_stimulus[0] = 0
let sar12_stimulus[1] = sar12_previous[length(sar12_previous)-1]
let sar12_stimulus[2] = 8.35009999999999e-05
let sar12_stimulus[3] = sar12_stimulus[1]
let sar12_stimulus[4] = 8.35029999999999e-05
let sar12_stimulus[5] = 1.8
let sar12_stimulus[6] = 0.000148
let sar12_stimulus[7] = sar12_stimulus[5]
alter @VD_EVAL[pwl] = sar12_stimulus
resume
let sar12_k = length(time)-1
if abs(time[sar12_k] - 8.39999999999999e-05) > 1e-12
print time[sar12_k]
echo expected_pause_time_s 8.39999999999999e-05
echo SAR12_PAUSE_FAILED
quit 1
end
print time[sar12_k] >> pause-times.txt
let sar12_k = length(time)-1
let sar12_cmp = v(COMP)[sar12_k]
let sar12_cmpn = v(COMPN)[sar12_k]
let sar12_p = v(TOPP)[sar12_k]
let sar12_n = v(TOPN)[sar12_k]
let sar12_decision = 0
if sar12_cmp >= 0.9
let sar12_code = sar12_trial
let sar12_decision = 1
end
echo 3 14 $&sar12_trial $&sar12_cmp $&sar12_cmpn $&sar12_p $&sar12_n -1.8310546875e-05 $&sar12_decision >> decisions.csv
let sar12_previous = @VD_EVAL[pwl]
let sar12_stimulus = vector(8)
let sar12_stimulus[0] = 0
let sar12_stimulus[1] = sar12_previous[length(sar12_previous)-1]
let sar12_stimulus[2] = 8.40009999999999e-05
let sar12_stimulus[3] = sar12_stimulus[1]
let sar12_stimulus[4] = 8.40029999999999e-05
let sar12_stimulus[5] = 0
let sar12_stimulus[6] = 0.000148
let sar12_stimulus[7] = sar12_stimulus[5]
alter @VD_EVAL[pwl] = sar12_stimulus
let sar12_trial = sar12_code + 8192
let sar12_drive = (floor(sar12_trial / 1) - 2*floor(sar12_trial / 2))*1.8
let sar12_previous = @VD_B0[pwl]
let sar12_stimulus = vector(8)
let sar12_stimulus[0] = 0
let sar12_stimulus[1] = sar12_previous[length(sar12_previous)-1]
let sar12_stimulus[2] = 8.40009999999999e-05
let sar12_stimulus[3] = sar12_stimulus[1]
let sar12_stimulus[4] = 8.40029999999999e-05
let sar12_stimulus[5] = sar12_drive
let sar12_stimulus[6] = 0.000148
let sar12_stimulus[7] = sar12_stimulus[5]
alter @VD_B0[pwl] = sar12_stimulus
let sar12_drive = (floor(sar12_trial / 2) - 2*floor(sar12_trial / 4))*1.8
let sar12_previous = @VD_B1[pwl]
let sar12_stimulus = vector(8)
let sar12_stimulus[0] = 0
let sar12_stimulus[1] = sar12_previous[length(sar12_previous)-1]
let sar12_stimulus[2] = 8.40009999999999e-05
let sar12_stimulus[3] = sar12_stimulus[1]
let sar12_stimulus[4] = 8.40029999999999e-05
let sar12_stimulus[5] = sar12_drive
let sar12_stimulus[6] = 0.000148
let sar12_stimulus[7] = sar12_stimulus[5]
alter @VD_B1[pwl] = sar12_stimulus
let sar12_drive = (floor(sar12_trial / 4) - 2*floor(sar12_trial / 8))*1.8
let sar12_previous = @VD_B2[pwl]
let sar12_stimulus = vector(8)
let sar12_stimulus[0] = 0
let sar12_stimulus[1] = sar12_previous[length(sar12_previous)-1]
let sar12_stimulus[2] = 8.40009999999999e-05
let sar12_stimulus[3] = sar12_stimulus[1]
let sar12_stimulus[4] = 8.40029999999999e-05
let sar12_stimulus[5] = sar12_drive
let sar12_stimulus[6] = 0.000148
let sar12_stimulus[7] = sar12_stimulus[5]
alter @VD_B2[pwl] = sar12_stimulus
let sar12_drive = (floor(sar12_trial / 8) - 2*floor(sar12_trial / 16))*1.8
let sar12_previous = @VD_B3[pwl]
let sar12_stimulus = vector(8)
let sar12_stimulus[0] = 0
let sar12_stimulus[1] = sar12_previous[length(sar12_previous)-1]
let sar12_stimulus[2] = 8.40009999999999e-05
let sar12_stimulus[3] = sar12_stimulus[1]
let sar12_stimulus[4] = 8.40029999999999e-05
let sar12_stimulus[5] = sar12_drive
let sar12_stimulus[6] = 0.000148
let sar12_stimulus[7] = sar12_stimulus[5]
alter @VD_B3[pwl] = sar12_stimulus
let sar12_drive = (floor(sar12_trial / 16) - 2*floor(sar12_trial / 32))*1.8
let sar12_previous = @VD_B4[pwl]
let sar12_stimulus = vector(8)
let sar12_stimulus[0] = 0
let sar12_stimulus[1] = sar12_previous[length(sar12_previous)-1]
let sar12_stimulus[2] = 8.40009999999999e-05
let sar12_stimulus[3] = sar12_stimulus[1]
let sar12_stimulus[4] = 8.40029999999999e-05
let sar12_stimulus[5] = sar12_drive
let sar12_stimulus[6] = 0.000148
let sar12_stimulus[7] = sar12_stimulus[5]
alter @VD_B4[pwl] = sar12_stimulus
let sar12_drive = (floor(sar12_trial / 32) - 2*floor(sar12_trial / 64))*1.8
let sar12_previous = @VD_B5[pwl]
let sar12_stimulus = vector(8)
let sar12_stimulus[0] = 0
let sar12_stimulus[1] = sar12_previous[length(sar12_previous)-1]
let sar12_stimulus[2] = 8.40009999999999e-05
let sar12_stimulus[3] = sar12_stimulus[1]
let sar12_stimulus[4] = 8.40029999999999e-05
let sar12_stimulus[5] = sar12_drive
let sar12_stimulus[6] = 0.000148
let sar12_stimulus[7] = sar12_stimulus[5]
alter @VD_B5[pwl] = sar12_stimulus
let sar12_drive = (floor(sar12_trial / 64) - 2*floor(sar12_trial / 128))*1.8
let sar12_previous = @VD_B6[pwl]
let sar12_stimulus = vector(8)
let sar12_stimulus[0] = 0
let sar12_stimulus[1] = sar12_previous[length(sar12_previous)-1]
let sar12_stimulus[2] = 8.40009999999999e-05
let sar12_stimulus[3] = sar12_stimulus[1]
let sar12_stimulus[4] = 8.40029999999999e-05
let sar12_stimulus[5] = sar12_drive
let sar12_stimulus[6] = 0.000148
let sar12_stimulus[7] = sar12_stimulus[5]
alter @VD_B6[pwl] = sar12_stimulus
let sar12_drive = (floor(sar12_trial / 128) - 2*floor(sar12_trial / 256))*1.8
let sar12_previous = @VD_B7[pwl]
let sar12_stimulus = vector(8)
let sar12_stimulus[0] = 0
let sar12_stimulus[1] = sar12_previous[length(sar12_previous)-1]
let sar12_stimulus[2] = 8.40009999999999e-05
let sar12_stimulus[3] = sar12_stimulus[1]
let sar12_stimulus[4] = 8.40029999999999e-05
let sar12_stimulus[5] = sar12_drive
let sar12_stimulus[6] = 0.000148
let sar12_stimulus[7] = sar12_stimulus[5]
alter @VD_B7[pwl] = sar12_stimulus
let sar12_drive = (floor(sar12_trial / 256) - 2*floor(sar12_trial / 512))*1.8
let sar12_previous = @VD_B8[pwl]
let sar12_stimulus = vector(8)
let sar12_stimulus[0] = 0
let sar12_stimulus[1] = sar12_previous[length(sar12_previous)-1]
let sar12_stimulus[2] = 8.40009999999999e-05
let sar12_stimulus[3] = sar12_stimulus[1]
let sar12_stimulus[4] = 8.40029999999999e-05
let sar12_stimulus[5] = sar12_drive
let sar12_stimulus[6] = 0.000148
let sar12_stimulus[7] = sar12_stimulus[5]
alter @VD_B8[pwl] = sar12_stimulus
let sar12_drive = (floor(sar12_trial / 512) - 2*floor(sar12_trial / 1024))*1.8
let sar12_previous = @VD_B9[pwl]
let sar12_stimulus = vector(8)
let sar12_stimulus[0] = 0
let sar12_stimulus[1] = sar12_previous[length(sar12_previous)-1]
let sar12_stimulus[2] = 8.40009999999999e-05
let sar12_stimulus[3] = sar12_stimulus[1]
let sar12_stimulus[4] = 8.40029999999999e-05
let sar12_stimulus[5] = sar12_drive
let sar12_stimulus[6] = 0.000148
let sar12_stimulus[7] = sar12_stimulus[5]
alter @VD_B9[pwl] = sar12_stimulus
let sar12_drive = (floor(sar12_trial / 1024) - 2*floor(sar12_trial / 2048))*1.8
let sar12_previous = @VD_B10[pwl]
let sar12_stimulus = vector(8)
let sar12_stimulus[0] = 0
let sar12_stimulus[1] = sar12_previous[length(sar12_previous)-1]
let sar12_stimulus[2] = 8.40009999999999e-05
let sar12_stimulus[3] = sar12_stimulus[1]
let sar12_stimulus[4] = 8.40029999999999e-05
let sar12_stimulus[5] = sar12_drive
let sar12_stimulus[6] = 0.000148
let sar12_stimulus[7] = sar12_stimulus[5]
alter @VD_B10[pwl] = sar12_stimulus
let sar12_drive = (floor(sar12_trial / 2048) - 2*floor(sar12_trial / 4096))*1.8
let sar12_previous = @VD_B11[pwl]
let sar12_stimulus = vector(8)
let sar12_stimulus[0] = 0
let sar12_stimulus[1] = sar12_previous[length(sar12_previous)-1]
let sar12_stimulus[2] = 8.40009999999999e-05
let sar12_stimulus[3] = sar12_stimulus[1]
let sar12_stimulus[4] = 8.40029999999999e-05
let sar12_stimulus[5] = sar12_drive
let sar12_stimulus[6] = 0.000148
let sar12_stimulus[7] = sar12_stimulus[5]
alter @VD_B11[pwl] = sar12_stimulus
let sar12_drive = (floor(sar12_trial / 4096) - 2*floor(sar12_trial / 8192))*1.8
let sar12_previous = @VD_B12[pwl]
let sar12_stimulus = vector(8)
let sar12_stimulus[0] = 0
let sar12_stimulus[1] = sar12_previous[length(sar12_previous)-1]
let sar12_stimulus[2] = 8.40009999999999e-05
let sar12_stimulus[3] = sar12_stimulus[1]
let sar12_stimulus[4] = 8.40029999999999e-05
let sar12_stimulus[5] = sar12_drive
let sar12_stimulus[6] = 0.000148
let sar12_stimulus[7] = sar12_stimulus[5]
alter @VD_B12[pwl] = sar12_stimulus
let sar12_drive = (floor(sar12_trial / 8192) - 2*floor(sar12_trial / 16384))*1.8
let sar12_previous = @VD_B13[pwl]
let sar12_stimulus = vector(8)
let sar12_stimulus[0] = 0
let sar12_stimulus[1] = sar12_previous[length(sar12_previous)-1]
let sar12_stimulus[2] = 8.40009999999999e-05
let sar12_stimulus[3] = sar12_stimulus[1]
let sar12_stimulus[4] = 8.40029999999999e-05
let sar12_stimulus[5] = sar12_drive
let sar12_stimulus[6] = 0.000148
let sar12_stimulus[7] = sar12_stimulus[5]
alter @VD_B13[pwl] = sar12_stimulus
let sar12_drive = (floor(sar12_trial / 16384) - 2*floor(sar12_trial / 32768))*1.8
let sar12_previous = @VD_B14[pwl]
let sar12_stimulus = vector(8)
let sar12_stimulus[0] = 0
let sar12_stimulus[1] = sar12_previous[length(sar12_previous)-1]
let sar12_stimulus[2] = 8.40009999999999e-05
let sar12_stimulus[3] = sar12_stimulus[1]
let sar12_stimulus[4] = 8.40029999999999e-05
let sar12_stimulus[5] = sar12_drive
let sar12_stimulus[6] = 0.000148
let sar12_stimulus[7] = sar12_stimulus[5]
alter @VD_B14[pwl] = sar12_stimulus
let sar12_drive = (floor(sar12_trial / 32768) - 2*floor(sar12_trial / 65536))*1.8
let sar12_previous = @VD_B15[pwl]
let sar12_stimulus = vector(8)
let sar12_stimulus[0] = 0
let sar12_stimulus[1] = sar12_previous[length(sar12_previous)-1]
let sar12_stimulus[2] = 8.40009999999999e-05
let sar12_stimulus[3] = sar12_stimulus[1]
let sar12_stimulus[4] = 8.40029999999999e-05
let sar12_stimulus[5] = sar12_drive
let sar12_stimulus[6] = 0.000148
let sar12_stimulus[7] = sar12_stimulus[5]
alter @VD_B15[pwl] = sar12_stimulus
resume
let sar12_k = length(time)-1
if abs(time[sar12_k] - 8.44999999999999e-05) > 1e-12
print time[sar12_k]
echo expected_pause_time_s 8.44999999999999e-05
echo SAR12_PAUSE_FAILED
quit 1
end
print time[sar12_k] >> pause-times.txt
let sar12_previous = @VD_EVAL[pwl]
let sar12_stimulus = vector(8)
let sar12_stimulus[0] = 0
let sar12_stimulus[1] = sar12_previous[length(sar12_previous)-1]
let sar12_stimulus[2] = 8.45009999999999e-05
let sar12_stimulus[3] = sar12_stimulus[1]
let sar12_stimulus[4] = 8.45029999999999e-05
let sar12_stimulus[5] = 1.8
let sar12_stimulus[6] = 0.000148
let sar12_stimulus[7] = sar12_stimulus[5]
alter @VD_EVAL[pwl] = sar12_stimulus
resume
let sar12_k = length(time)-1
if abs(time[sar12_k] - 8.49999999999999e-05) > 1e-12
print time[sar12_k]
echo expected_pause_time_s 8.49999999999999e-05
echo SAR12_PAUSE_FAILED
quit 1
end
print time[sar12_k] >> pause-times.txt
let sar12_k = length(time)-1
let sar12_cmp = v(COMP)[sar12_k]
let sar12_cmpn = v(COMPN)[sar12_k]
let sar12_p = v(TOPP)[sar12_k]
let sar12_n = v(TOPN)[sar12_k]
let sar12_decision = 0
if sar12_cmp >= 0.9
let sar12_code = sar12_trial
let sar12_decision = 1
end
echo 3 13 $&sar12_trial $&sar12_cmp $&sar12_cmpn $&sar12_p $&sar12_n -1.8310546875e-05 $&sar12_decision >> decisions.csv
let sar12_previous = @VD_EVAL[pwl]
let sar12_stimulus = vector(8)
let sar12_stimulus[0] = 0
let sar12_stimulus[1] = sar12_previous[length(sar12_previous)-1]
let sar12_stimulus[2] = 8.50009999999999e-05
let sar12_stimulus[3] = sar12_stimulus[1]
let sar12_stimulus[4] = 8.50029999999999e-05
let sar12_stimulus[5] = 0
let sar12_stimulus[6] = 0.000148
let sar12_stimulus[7] = sar12_stimulus[5]
alter @VD_EVAL[pwl] = sar12_stimulus
let sar12_trial = sar12_code + 4096
let sar12_drive = (floor(sar12_trial / 1) - 2*floor(sar12_trial / 2))*1.8
let sar12_previous = @VD_B0[pwl]
let sar12_stimulus = vector(8)
let sar12_stimulus[0] = 0
let sar12_stimulus[1] = sar12_previous[length(sar12_previous)-1]
let sar12_stimulus[2] = 8.50009999999999e-05
let sar12_stimulus[3] = sar12_stimulus[1]
let sar12_stimulus[4] = 8.50029999999999e-05
let sar12_stimulus[5] = sar12_drive
let sar12_stimulus[6] = 0.000148
let sar12_stimulus[7] = sar12_stimulus[5]
alter @VD_B0[pwl] = sar12_stimulus
let sar12_drive = (floor(sar12_trial / 2) - 2*floor(sar12_trial / 4))*1.8
let sar12_previous = @VD_B1[pwl]
let sar12_stimulus = vector(8)
let sar12_stimulus[0] = 0
let sar12_stimulus[1] = sar12_previous[length(sar12_previous)-1]
let sar12_stimulus[2] = 8.50009999999999e-05
let sar12_stimulus[3] = sar12_stimulus[1]
let sar12_stimulus[4] = 8.50029999999999e-05
let sar12_stimulus[5] = sar12_drive
let sar12_stimulus[6] = 0.000148
let sar12_stimulus[7] = sar12_stimulus[5]
alter @VD_B1[pwl] = sar12_stimulus
let sar12_drive = (floor(sar12_trial / 4) - 2*floor(sar12_trial / 8))*1.8
let sar12_previous = @VD_B2[pwl]
let sar12_stimulus = vector(8)
let sar12_stimulus[0] = 0
let sar12_stimulus[1] = sar12_previous[length(sar12_previous)-1]
let sar12_stimulus[2] = 8.50009999999999e-05
let sar12_stimulus[3] = sar12_stimulus[1]
let sar12_stimulus[4] = 8.50029999999999e-05
let sar12_stimulus[5] = sar12_drive
let sar12_stimulus[6] = 0.000148
let sar12_stimulus[7] = sar12_stimulus[5]
alter @VD_B2[pwl] = sar12_stimulus
let sar12_drive = (floor(sar12_trial / 8) - 2*floor(sar12_trial / 16))*1.8
let sar12_previous = @VD_B3[pwl]
let sar12_stimulus = vector(8)
let sar12_stimulus[0] = 0
let sar12_stimulus[1] = sar12_previous[length(sar12_previous)-1]
let sar12_stimulus[2] = 8.50009999999999e-05
let sar12_stimulus[3] = sar12_stimulus[1]
let sar12_stimulus[4] = 8.50029999999999e-05
let sar12_stimulus[5] = sar12_drive
let sar12_stimulus[6] = 0.000148
let sar12_stimulus[7] = sar12_stimulus[5]
alter @VD_B3[pwl] = sar12_stimulus
let sar12_drive = (floor(sar12_trial / 16) - 2*floor(sar12_trial / 32))*1.8
let sar12_previous = @VD_B4[pwl]
let sar12_stimulus = vector(8)
let sar12_stimulus[0] = 0
let sar12_stimulus[1] = sar12_previous[length(sar12_previous)-1]
let sar12_stimulus[2] = 8.50009999999999e-05
let sar12_stimulus[3] = sar12_stimulus[1]
let sar12_stimulus[4] = 8.50029999999999e-05
let sar12_stimulus[5] = sar12_drive
let sar12_stimulus[6] = 0.000148
let sar12_stimulus[7] = sar12_stimulus[5]
alter @VD_B4[pwl] = sar12_stimulus
let sar12_drive = (floor(sar12_trial / 32) - 2*floor(sar12_trial / 64))*1.8
let sar12_previous = @VD_B5[pwl]
let sar12_stimulus = vector(8)
let sar12_stimulus[0] = 0
let sar12_stimulus[1] = sar12_previous[length(sar12_previous)-1]
let sar12_stimulus[2] = 8.50009999999999e-05
let sar12_stimulus[3] = sar12_stimulus[1]
let sar12_stimulus[4] = 8.50029999999999e-05
let sar12_stimulus[5] = sar12_drive
let sar12_stimulus[6] = 0.000148
let sar12_stimulus[7] = sar12_stimulus[5]
alter @VD_B5[pwl] = sar12_stimulus
let sar12_drive = (floor(sar12_trial / 64) - 2*floor(sar12_trial / 128))*1.8
let sar12_previous = @VD_B6[pwl]
let sar12_stimulus = vector(8)
let sar12_stimulus[0] = 0
let sar12_stimulus[1] = sar12_previous[length(sar12_previous)-1]
let sar12_stimulus[2] = 8.50009999999999e-05
let sar12_stimulus[3] = sar12_stimulus[1]
let sar12_stimulus[4] = 8.50029999999999e-05
let sar12_stimulus[5] = sar12_drive
let sar12_stimulus[6] = 0.000148
let sar12_stimulus[7] = sar12_stimulus[5]
alter @VD_B6[pwl] = sar12_stimulus
let sar12_drive = (floor(sar12_trial / 128) - 2*floor(sar12_trial / 256))*1.8
let sar12_previous = @VD_B7[pwl]
let sar12_stimulus = vector(8)
let sar12_stimulus[0] = 0
let sar12_stimulus[1] = sar12_previous[length(sar12_previous)-1]
let sar12_stimulus[2] = 8.50009999999999e-05
let sar12_stimulus[3] = sar12_stimulus[1]
let sar12_stimulus[4] = 8.50029999999999e-05
let sar12_stimulus[5] = sar12_drive
let sar12_stimulus[6] = 0.000148
let sar12_stimulus[7] = sar12_stimulus[5]
alter @VD_B7[pwl] = sar12_stimulus
let sar12_drive = (floor(sar12_trial / 256) - 2*floor(sar12_trial / 512))*1.8
let sar12_previous = @VD_B8[pwl]
let sar12_stimulus = vector(8)
let sar12_stimulus[0] = 0
let sar12_stimulus[1] = sar12_previous[length(sar12_previous)-1]
let sar12_stimulus[2] = 8.50009999999999e-05
let sar12_stimulus[3] = sar12_stimulus[1]
let sar12_stimulus[4] = 8.50029999999999e-05
let sar12_stimulus[5] = sar12_drive
let sar12_stimulus[6] = 0.000148
let sar12_stimulus[7] = sar12_stimulus[5]
alter @VD_B8[pwl] = sar12_stimulus
let sar12_drive = (floor(sar12_trial / 512) - 2*floor(sar12_trial / 1024))*1.8
let sar12_previous = @VD_B9[pwl]
let sar12_stimulus = vector(8)
let sar12_stimulus[0] = 0
let sar12_stimulus[1] = sar12_previous[length(sar12_previous)-1]
let sar12_stimulus[2] = 8.50009999999999e-05
let sar12_stimulus[3] = sar12_stimulus[1]
let sar12_stimulus[4] = 8.50029999999999e-05
let sar12_stimulus[5] = sar12_drive
let sar12_stimulus[6] = 0.000148
let sar12_stimulus[7] = sar12_stimulus[5]
alter @VD_B9[pwl] = sar12_stimulus
let sar12_drive = (floor(sar12_trial / 1024) - 2*floor(sar12_trial / 2048))*1.8
let sar12_previous = @VD_B10[pwl]
let sar12_stimulus = vector(8)
let sar12_stimulus[0] = 0
let sar12_stimulus[1] = sar12_previous[length(sar12_previous)-1]
let sar12_stimulus[2] = 8.50009999999999e-05
let sar12_stimulus[3] = sar12_stimulus[1]
let sar12_stimulus[4] = 8.50029999999999e-05
let sar12_stimulus[5] = sar12_drive
let sar12_stimulus[6] = 0.000148
let sar12_stimulus[7] = sar12_stimulus[5]
alter @VD_B10[pwl] = sar12_stimulus
let sar12_drive = (floor(sar12_trial / 2048) - 2*floor(sar12_trial / 4096))*1.8
let sar12_previous = @VD_B11[pwl]
let sar12_stimulus = vector(8)
let sar12_stimulus[0] = 0
let sar12_stimulus[1] = sar12_previous[length(sar12_previous)-1]
let sar12_stimulus[2] = 8.50009999999999e-05
let sar12_stimulus[3] = sar12_stimulus[1]
let sar12_stimulus[4] = 8.50029999999999e-05
let sar12_stimulus[5] = sar12_drive
let sar12_stimulus[6] = 0.000148
let sar12_stimulus[7] = sar12_stimulus[5]
alter @VD_B11[pwl] = sar12_stimulus
let sar12_drive = (floor(sar12_trial / 4096) - 2*floor(sar12_trial / 8192))*1.8
let sar12_previous = @VD_B12[pwl]
let sar12_stimulus = vector(8)
let sar12_stimulus[0] = 0
let sar12_stimulus[1] = sar12_previous[length(sar12_previous)-1]
let sar12_stimulus[2] = 8.50009999999999e-05
let sar12_stimulus[3] = sar12_stimulus[1]
let sar12_stimulus[4] = 8.50029999999999e-05
let sar12_stimulus[5] = sar12_drive
let sar12_stimulus[6] = 0.000148
let sar12_stimulus[7] = sar12_stimulus[5]
alter @VD_B12[pwl] = sar12_stimulus
let sar12_drive = (floor(sar12_trial / 8192) - 2*floor(sar12_trial / 16384))*1.8
let sar12_previous = @VD_B13[pwl]
let sar12_stimulus = vector(8)
let sar12_stimulus[0] = 0
let sar12_stimulus[1] = sar12_previous[length(sar12_previous)-1]
let sar12_stimulus[2] = 8.50009999999999e-05
let sar12_stimulus[3] = sar12_stimulus[1]
let sar12_stimulus[4] = 8.50029999999999e-05
let sar12_stimulus[5] = sar12_drive
let sar12_stimulus[6] = 0.000148
let sar12_stimulus[7] = sar12_stimulus[5]
alter @VD_B13[pwl] = sar12_stimulus
let sar12_drive = (floor(sar12_trial / 16384) - 2*floor(sar12_trial / 32768))*1.8
let sar12_previous = @VD_B14[pwl]
let sar12_stimulus = vector(8)
let sar12_stimulus[0] = 0
let sar12_stimulus[1] = sar12_previous[length(sar12_previous)-1]
let sar12_stimulus[2] = 8.50009999999999e-05
let sar12_stimulus[3] = sar12_stimulus[1]
let sar12_stimulus[4] = 8.50029999999999e-05
let sar12_stimulus[5] = sar12_drive
let sar12_stimulus[6] = 0.000148
let sar12_stimulus[7] = sar12_stimulus[5]
alter @VD_B14[pwl] = sar12_stimulus
let sar12_drive = (floor(sar12_trial / 32768) - 2*floor(sar12_trial / 65536))*1.8
let sar12_previous = @VD_B15[pwl]
let sar12_stimulus = vector(8)
let sar12_stimulus[0] = 0
let sar12_stimulus[1] = sar12_previous[length(sar12_previous)-1]
let sar12_stimulus[2] = 8.50009999999999e-05
let sar12_stimulus[3] = sar12_stimulus[1]
let sar12_stimulus[4] = 8.50029999999999e-05
let sar12_stimulus[5] = sar12_drive
let sar12_stimulus[6] = 0.000148
let sar12_stimulus[7] = sar12_stimulus[5]
alter @VD_B15[pwl] = sar12_stimulus
resume
let sar12_k = length(time)-1
if abs(time[sar12_k] - 8.54999999999999e-05) > 1e-12
print time[sar12_k]
echo expected_pause_time_s 8.54999999999999e-05
echo SAR12_PAUSE_FAILED
quit 1
end
print time[sar12_k] >> pause-times.txt
let sar12_previous = @VD_EVAL[pwl]
let sar12_stimulus = vector(8)
let sar12_stimulus[0] = 0
let sar12_stimulus[1] = sar12_previous[length(sar12_previous)-1]
let sar12_stimulus[2] = 8.55009999999999e-05
let sar12_stimulus[3] = sar12_stimulus[1]
let sar12_stimulus[4] = 8.55029999999999e-05
let sar12_stimulus[5] = 1.8
let sar12_stimulus[6] = 0.000148
let sar12_stimulus[7] = sar12_stimulus[5]
alter @VD_EVAL[pwl] = sar12_stimulus
resume
let sar12_k = length(time)-1
if abs(time[sar12_k] - 8.59999999999999e-05) > 1e-12
print time[sar12_k]
echo expected_pause_time_s 8.59999999999999e-05
echo SAR12_PAUSE_FAILED
quit 1
end
print time[sar12_k] >> pause-times.txt
let sar12_k = length(time)-1
let sar12_cmp = v(COMP)[sar12_k]
let sar12_cmpn = v(COMPN)[sar12_k]
let sar12_p = v(TOPP)[sar12_k]
let sar12_n = v(TOPN)[sar12_k]
let sar12_decision = 0
if sar12_cmp >= 0.9
let sar12_code = sar12_trial
let sar12_decision = 1
end
echo 3 12 $&sar12_trial $&sar12_cmp $&sar12_cmpn $&sar12_p $&sar12_n -1.8310546875e-05 $&sar12_decision >> decisions.csv
let sar12_previous = @VD_EVAL[pwl]
let sar12_stimulus = vector(8)
let sar12_stimulus[0] = 0
let sar12_stimulus[1] = sar12_previous[length(sar12_previous)-1]
let sar12_stimulus[2] = 8.60009999999999e-05
let sar12_stimulus[3] = sar12_stimulus[1]
let sar12_stimulus[4] = 8.60029999999999e-05
let sar12_stimulus[5] = 0
let sar12_stimulus[6] = 0.000148
let sar12_stimulus[7] = sar12_stimulus[5]
alter @VD_EVAL[pwl] = sar12_stimulus
let sar12_trial = sar12_code + 2048
let sar12_drive = (floor(sar12_trial / 1) - 2*floor(sar12_trial / 2))*1.8
let sar12_previous = @VD_B0[pwl]
let sar12_stimulus = vector(8)
let sar12_stimulus[0] = 0
let sar12_stimulus[1] = sar12_previous[length(sar12_previous)-1]
let sar12_stimulus[2] = 8.60009999999999e-05
let sar12_stimulus[3] = sar12_stimulus[1]
let sar12_stimulus[4] = 8.60029999999999e-05
let sar12_stimulus[5] = sar12_drive
let sar12_stimulus[6] = 0.000148
let sar12_stimulus[7] = sar12_stimulus[5]
alter @VD_B0[pwl] = sar12_stimulus
let sar12_drive = (floor(sar12_trial / 2) - 2*floor(sar12_trial / 4))*1.8
let sar12_previous = @VD_B1[pwl]
let sar12_stimulus = vector(8)
let sar12_stimulus[0] = 0
let sar12_stimulus[1] = sar12_previous[length(sar12_previous)-1]
let sar12_stimulus[2] = 8.60009999999999e-05
let sar12_stimulus[3] = sar12_stimulus[1]
let sar12_stimulus[4] = 8.60029999999999e-05
let sar12_stimulus[5] = sar12_drive
let sar12_stimulus[6] = 0.000148
let sar12_stimulus[7] = sar12_stimulus[5]
alter @VD_B1[pwl] = sar12_stimulus
let sar12_drive = (floor(sar12_trial / 4) - 2*floor(sar12_trial / 8))*1.8
let sar12_previous = @VD_B2[pwl]
let sar12_stimulus = vector(8)
let sar12_stimulus[0] = 0
let sar12_stimulus[1] = sar12_previous[length(sar12_previous)-1]
let sar12_stimulus[2] = 8.60009999999999e-05
let sar12_stimulus[3] = sar12_stimulus[1]
let sar12_stimulus[4] = 8.60029999999999e-05
let sar12_stimulus[5] = sar12_drive
let sar12_stimulus[6] = 0.000148
let sar12_stimulus[7] = sar12_stimulus[5]
alter @VD_B2[pwl] = sar12_stimulus
let sar12_drive = (floor(sar12_trial / 8) - 2*floor(sar12_trial / 16))*1.8
let sar12_previous = @VD_B3[pwl]
let sar12_stimulus = vector(8)
let sar12_stimulus[0] = 0
let sar12_stimulus[1] = sar12_previous[length(sar12_previous)-1]
let sar12_stimulus[2] = 8.60009999999999e-05
let sar12_stimulus[3] = sar12_stimulus[1]
let sar12_stimulus[4] = 8.60029999999999e-05
let sar12_stimulus[5] = sar12_drive
let sar12_stimulus[6] = 0.000148
let sar12_stimulus[7] = sar12_stimulus[5]
alter @VD_B3[pwl] = sar12_stimulus
let sar12_drive = (floor(sar12_trial / 16) - 2*floor(sar12_trial / 32))*1.8
let sar12_previous = @VD_B4[pwl]
let sar12_stimulus = vector(8)
let sar12_stimulus[0] = 0
let sar12_stimulus[1] = sar12_previous[length(sar12_previous)-1]
let sar12_stimulus[2] = 8.60009999999999e-05
let sar12_stimulus[3] = sar12_stimulus[1]
let sar12_stimulus[4] = 8.60029999999999e-05
let sar12_stimulus[5] = sar12_drive
let sar12_stimulus[6] = 0.000148
let sar12_stimulus[7] = sar12_stimulus[5]
alter @VD_B4[pwl] = sar12_stimulus
let sar12_drive = (floor(sar12_trial / 32) - 2*floor(sar12_trial / 64))*1.8
let sar12_previous = @VD_B5[pwl]
let sar12_stimulus = vector(8)
let sar12_stimulus[0] = 0
let sar12_stimulus[1] = sar12_previous[length(sar12_previous)-1]
let sar12_stimulus[2] = 8.60009999999999e-05
let sar12_stimulus[3] = sar12_stimulus[1]
let sar12_stimulus[4] = 8.60029999999999e-05
let sar12_stimulus[5] = sar12_drive
let sar12_stimulus[6] = 0.000148
let sar12_stimulus[7] = sar12_stimulus[5]
alter @VD_B5[pwl] = sar12_stimulus
let sar12_drive = (floor(sar12_trial / 64) - 2*floor(sar12_trial / 128))*1.8
let sar12_previous = @VD_B6[pwl]
let sar12_stimulus = vector(8)
let sar12_stimulus[0] = 0
let sar12_stimulus[1] = sar12_previous[length(sar12_previous)-1]
let sar12_stimulus[2] = 8.60009999999999e-05
let sar12_stimulus[3] = sar12_stimulus[1]
let sar12_stimulus[4] = 8.60029999999999e-05
let sar12_stimulus[5] = sar12_drive
let sar12_stimulus[6] = 0.000148
let sar12_stimulus[7] = sar12_stimulus[5]
alter @VD_B6[pwl] = sar12_stimulus
let sar12_drive = (floor(sar12_trial / 128) - 2*floor(sar12_trial / 256))*1.8
let sar12_previous = @VD_B7[pwl]
let sar12_stimulus = vector(8)
let sar12_stimulus[0] = 0
let sar12_stimulus[1] = sar12_previous[length(sar12_previous)-1]
let sar12_stimulus[2] = 8.60009999999999e-05
let sar12_stimulus[3] = sar12_stimulus[1]
let sar12_stimulus[4] = 8.60029999999999e-05
let sar12_stimulus[5] = sar12_drive
let sar12_stimulus[6] = 0.000148
let sar12_stimulus[7] = sar12_stimulus[5]
alter @VD_B7[pwl] = sar12_stimulus
let sar12_drive = (floor(sar12_trial / 256) - 2*floor(sar12_trial / 512))*1.8
let sar12_previous = @VD_B8[pwl]
let sar12_stimulus = vector(8)
let sar12_stimulus[0] = 0
let sar12_stimulus[1] = sar12_previous[length(sar12_previous)-1]
let sar12_stimulus[2] = 8.60009999999999e-05
let sar12_stimulus[3] = sar12_stimulus[1]
let sar12_stimulus[4] = 8.60029999999999e-05
let sar12_stimulus[5] = sar12_drive
let sar12_stimulus[6] = 0.000148
let sar12_stimulus[7] = sar12_stimulus[5]
alter @VD_B8[pwl] = sar12_stimulus
let sar12_drive = (floor(sar12_trial / 512) - 2*floor(sar12_trial / 1024))*1.8
let sar12_previous = @VD_B9[pwl]
let sar12_stimulus = vector(8)
let sar12_stimulus[0] = 0
let sar12_stimulus[1] = sar12_previous[length(sar12_previous)-1]
let sar12_stimulus[2] = 8.60009999999999e-05
let sar12_stimulus[3] = sar12_stimulus[1]
let sar12_stimulus[4] = 8.60029999999999e-05
let sar12_stimulus[5] = sar12_drive
let sar12_stimulus[6] = 0.000148
let sar12_stimulus[7] = sar12_stimulus[5]
alter @VD_B9[pwl] = sar12_stimulus
let sar12_drive = (floor(sar12_trial / 1024) - 2*floor(sar12_trial / 2048))*1.8
let sar12_previous = @VD_B10[pwl]
let sar12_stimulus = vector(8)
let sar12_stimulus[0] = 0
let sar12_stimulus[1] = sar12_previous[length(sar12_previous)-1]
let sar12_stimulus[2] = 8.60009999999999e-05
let sar12_stimulus[3] = sar12_stimulus[1]
let sar12_stimulus[4] = 8.60029999999999e-05
let sar12_stimulus[5] = sar12_drive
let sar12_stimulus[6] = 0.000148
let sar12_stimulus[7] = sar12_stimulus[5]
alter @VD_B10[pwl] = sar12_stimulus
let sar12_drive = (floor(sar12_trial / 2048) - 2*floor(sar12_trial / 4096))*1.8
let sar12_previous = @VD_B11[pwl]
let sar12_stimulus = vector(8)
let sar12_stimulus[0] = 0
let sar12_stimulus[1] = sar12_previous[length(sar12_previous)-1]
let sar12_stimulus[2] = 8.60009999999999e-05
let sar12_stimulus[3] = sar12_stimulus[1]
let sar12_stimulus[4] = 8.60029999999999e-05
let sar12_stimulus[5] = sar12_drive
let sar12_stimulus[6] = 0.000148
let sar12_stimulus[7] = sar12_stimulus[5]
alter @VD_B11[pwl] = sar12_stimulus
let sar12_drive = (floor(sar12_trial / 4096) - 2*floor(sar12_trial / 8192))*1.8
let sar12_previous = @VD_B12[pwl]
let sar12_stimulus = vector(8)
let sar12_stimulus[0] = 0
let sar12_stimulus[1] = sar12_previous[length(sar12_previous)-1]
let sar12_stimulus[2] = 8.60009999999999e-05
let sar12_stimulus[3] = sar12_stimulus[1]
let sar12_stimulus[4] = 8.60029999999999e-05
let sar12_stimulus[5] = sar12_drive
let sar12_stimulus[6] = 0.000148
let sar12_stimulus[7] = sar12_stimulus[5]
alter @VD_B12[pwl] = sar12_stimulus
let sar12_drive = (floor(sar12_trial / 8192) - 2*floor(sar12_trial / 16384))*1.8
let sar12_previous = @VD_B13[pwl]
let sar12_stimulus = vector(8)
let sar12_stimulus[0] = 0
let sar12_stimulus[1] = sar12_previous[length(sar12_previous)-1]
let sar12_stimulus[2] = 8.60009999999999e-05
let sar12_stimulus[3] = sar12_stimulus[1]
let sar12_stimulus[4] = 8.60029999999999e-05
let sar12_stimulus[5] = sar12_drive
let sar12_stimulus[6] = 0.000148
let sar12_stimulus[7] = sar12_stimulus[5]
alter @VD_B13[pwl] = sar12_stimulus
let sar12_drive = (floor(sar12_trial / 16384) - 2*floor(sar12_trial / 32768))*1.8
let sar12_previous = @VD_B14[pwl]
let sar12_stimulus = vector(8)
let sar12_stimulus[0] = 0
let sar12_stimulus[1] = sar12_previous[length(sar12_previous)-1]
let sar12_stimulus[2] = 8.60009999999999e-05
let sar12_stimulus[3] = sar12_stimulus[1]
let sar12_stimulus[4] = 8.60029999999999e-05
let sar12_stimulus[5] = sar12_drive
let sar12_stimulus[6] = 0.000148
let sar12_stimulus[7] = sar12_stimulus[5]
alter @VD_B14[pwl] = sar12_stimulus
let sar12_drive = (floor(sar12_trial / 32768) - 2*floor(sar12_trial / 65536))*1.8
let sar12_previous = @VD_B15[pwl]
let sar12_stimulus = vector(8)
let sar12_stimulus[0] = 0
let sar12_stimulus[1] = sar12_previous[length(sar12_previous)-1]
let sar12_stimulus[2] = 8.60009999999999e-05
let sar12_stimulus[3] = sar12_stimulus[1]
let sar12_stimulus[4] = 8.60029999999999e-05
let sar12_stimulus[5] = sar12_drive
let sar12_stimulus[6] = 0.000148
let sar12_stimulus[7] = sar12_stimulus[5]
alter @VD_B15[pwl] = sar12_stimulus
resume
let sar12_k = length(time)-1
if abs(time[sar12_k] - 8.64999999999999e-05) > 1e-12
print time[sar12_k]
echo expected_pause_time_s 8.64999999999999e-05
echo SAR12_PAUSE_FAILED
quit 1
end
print time[sar12_k] >> pause-times.txt
let sar12_previous = @VD_EVAL[pwl]
let sar12_stimulus = vector(8)
let sar12_stimulus[0] = 0
let sar12_stimulus[1] = sar12_previous[length(sar12_previous)-1]
let sar12_stimulus[2] = 8.65009999999999e-05
let sar12_stimulus[3] = sar12_stimulus[1]
let sar12_stimulus[4] = 8.65029999999999e-05
let sar12_stimulus[5] = 1.8
let sar12_stimulus[6] = 0.000148
let sar12_stimulus[7] = sar12_stimulus[5]
alter @VD_EVAL[pwl] = sar12_stimulus
resume
let sar12_k = length(time)-1
if abs(time[sar12_k] - 8.69999999999999e-05) > 1e-12
print time[sar12_k]
echo expected_pause_time_s 8.69999999999999e-05
echo SAR12_PAUSE_FAILED
quit 1
end
print time[sar12_k] >> pause-times.txt
let sar12_k = length(time)-1
let sar12_cmp = v(COMP)[sar12_k]
let sar12_cmpn = v(COMPN)[sar12_k]
let sar12_p = v(TOPP)[sar12_k]
let sar12_n = v(TOPN)[sar12_k]
let sar12_decision = 0
if sar12_cmp >= 0.9
let sar12_code = sar12_trial
let sar12_decision = 1
end
echo 3 11 $&sar12_trial $&sar12_cmp $&sar12_cmpn $&sar12_p $&sar12_n -1.8310546875e-05 $&sar12_decision >> decisions.csv
let sar12_previous = @VD_EVAL[pwl]
let sar12_stimulus = vector(8)
let sar12_stimulus[0] = 0
let sar12_stimulus[1] = sar12_previous[length(sar12_previous)-1]
let sar12_stimulus[2] = 8.70009999999999e-05
let sar12_stimulus[3] = sar12_stimulus[1]
let sar12_stimulus[4] = 8.70029999999999e-05
let sar12_stimulus[5] = 0
let sar12_stimulus[6] = 0.000148
let sar12_stimulus[7] = sar12_stimulus[5]
alter @VD_EVAL[pwl] = sar12_stimulus
let sar12_trial = sar12_code + 1024
let sar12_drive = (floor(sar12_trial / 1) - 2*floor(sar12_trial / 2))*1.8
let sar12_previous = @VD_B0[pwl]
let sar12_stimulus = vector(8)
let sar12_stimulus[0] = 0
let sar12_stimulus[1] = sar12_previous[length(sar12_previous)-1]
let sar12_stimulus[2] = 8.70009999999999e-05
let sar12_stimulus[3] = sar12_stimulus[1]
let sar12_stimulus[4] = 8.70029999999999e-05
let sar12_stimulus[5] = sar12_drive
let sar12_stimulus[6] = 0.000148
let sar12_stimulus[7] = sar12_stimulus[5]
alter @VD_B0[pwl] = sar12_stimulus
let sar12_drive = (floor(sar12_trial / 2) - 2*floor(sar12_trial / 4))*1.8
let sar12_previous = @VD_B1[pwl]
let sar12_stimulus = vector(8)
let sar12_stimulus[0] = 0
let sar12_stimulus[1] = sar12_previous[length(sar12_previous)-1]
let sar12_stimulus[2] = 8.70009999999999e-05
let sar12_stimulus[3] = sar12_stimulus[1]
let sar12_stimulus[4] = 8.70029999999999e-05
let sar12_stimulus[5] = sar12_drive
let sar12_stimulus[6] = 0.000148
let sar12_stimulus[7] = sar12_stimulus[5]
alter @VD_B1[pwl] = sar12_stimulus
let sar12_drive = (floor(sar12_trial / 4) - 2*floor(sar12_trial / 8))*1.8
let sar12_previous = @VD_B2[pwl]
let sar12_stimulus = vector(8)
let sar12_stimulus[0] = 0
let sar12_stimulus[1] = sar12_previous[length(sar12_previous)-1]
let sar12_stimulus[2] = 8.70009999999999e-05
let sar12_stimulus[3] = sar12_stimulus[1]
let sar12_stimulus[4] = 8.70029999999999e-05
let sar12_stimulus[5] = sar12_drive
let sar12_stimulus[6] = 0.000148
let sar12_stimulus[7] = sar12_stimulus[5]
alter @VD_B2[pwl] = sar12_stimulus
let sar12_drive = (floor(sar12_trial / 8) - 2*floor(sar12_trial / 16))*1.8
let sar12_previous = @VD_B3[pwl]
let sar12_stimulus = vector(8)
let sar12_stimulus[0] = 0
let sar12_stimulus[1] = sar12_previous[length(sar12_previous)-1]
let sar12_stimulus[2] = 8.70009999999999e-05
let sar12_stimulus[3] = sar12_stimulus[1]
let sar12_stimulus[4] = 8.70029999999999e-05
let sar12_stimulus[5] = sar12_drive
let sar12_stimulus[6] = 0.000148
let sar12_stimulus[7] = sar12_stimulus[5]
alter @VD_B3[pwl] = sar12_stimulus
let sar12_drive = (floor(sar12_trial / 16) - 2*floor(sar12_trial / 32))*1.8
let sar12_previous = @VD_B4[pwl]
let sar12_stimulus = vector(8)
let sar12_stimulus[0] = 0
let sar12_stimulus[1] = sar12_previous[length(sar12_previous)-1]
let sar12_stimulus[2] = 8.70009999999999e-05
let sar12_stimulus[3] = sar12_stimulus[1]
let sar12_stimulus[4] = 8.70029999999999e-05
let sar12_stimulus[5] = sar12_drive
let sar12_stimulus[6] = 0.000148
let sar12_stimulus[7] = sar12_stimulus[5]
alter @VD_B4[pwl] = sar12_stimulus
let sar12_drive = (floor(sar12_trial / 32) - 2*floor(sar12_trial / 64))*1.8
let sar12_previous = @VD_B5[pwl]
let sar12_stimulus = vector(8)
let sar12_stimulus[0] = 0
let sar12_stimulus[1] = sar12_previous[length(sar12_previous)-1]
let sar12_stimulus[2] = 8.70009999999999e-05
let sar12_stimulus[3] = sar12_stimulus[1]
let sar12_stimulus[4] = 8.70029999999999e-05
let sar12_stimulus[5] = sar12_drive
let sar12_stimulus[6] = 0.000148
let sar12_stimulus[7] = sar12_stimulus[5]
alter @VD_B5[pwl] = sar12_stimulus
let sar12_drive = (floor(sar12_trial / 64) - 2*floor(sar12_trial / 128))*1.8
let sar12_previous = @VD_B6[pwl]
let sar12_stimulus = vector(8)
let sar12_stimulus[0] = 0
let sar12_stimulus[1] = sar12_previous[length(sar12_previous)-1]
let sar12_stimulus[2] = 8.70009999999999e-05
let sar12_stimulus[3] = sar12_stimulus[1]
let sar12_stimulus[4] = 8.70029999999999e-05
let sar12_stimulus[5] = sar12_drive
let sar12_stimulus[6] = 0.000148
let sar12_stimulus[7] = sar12_stimulus[5]
alter @VD_B6[pwl] = sar12_stimulus
let sar12_drive = (floor(sar12_trial / 128) - 2*floor(sar12_trial / 256))*1.8
let sar12_previous = @VD_B7[pwl]
let sar12_stimulus = vector(8)
let sar12_stimulus[0] = 0
let sar12_stimulus[1] = sar12_previous[length(sar12_previous)-1]
let sar12_stimulus[2] = 8.70009999999999e-05
let sar12_stimulus[3] = sar12_stimulus[1]
let sar12_stimulus[4] = 8.70029999999999e-05
let sar12_stimulus[5] = sar12_drive
let sar12_stimulus[6] = 0.000148
let sar12_stimulus[7] = sar12_stimulus[5]
alter @VD_B7[pwl] = sar12_stimulus
let sar12_drive = (floor(sar12_trial / 256) - 2*floor(sar12_trial / 512))*1.8
let sar12_previous = @VD_B8[pwl]
let sar12_stimulus = vector(8)
let sar12_stimulus[0] = 0
let sar12_stimulus[1] = sar12_previous[length(sar12_previous)-1]
let sar12_stimulus[2] = 8.70009999999999e-05
let sar12_stimulus[3] = sar12_stimulus[1]
let sar12_stimulus[4] = 8.70029999999999e-05
let sar12_stimulus[5] = sar12_drive
let sar12_stimulus[6] = 0.000148
let sar12_stimulus[7] = sar12_stimulus[5]
alter @VD_B8[pwl] = sar12_stimulus
let sar12_drive = (floor(sar12_trial / 512) - 2*floor(sar12_trial / 1024))*1.8
let sar12_previous = @VD_B9[pwl]
let sar12_stimulus = vector(8)
let sar12_stimulus[0] = 0
let sar12_stimulus[1] = sar12_previous[length(sar12_previous)-1]
let sar12_stimulus[2] = 8.70009999999999e-05
let sar12_stimulus[3] = sar12_stimulus[1]
let sar12_stimulus[4] = 8.70029999999999e-05
let sar12_stimulus[5] = sar12_drive
let sar12_stimulus[6] = 0.000148
let sar12_stimulus[7] = sar12_stimulus[5]
alter @VD_B9[pwl] = sar12_stimulus
let sar12_drive = (floor(sar12_trial / 1024) - 2*floor(sar12_trial / 2048))*1.8
let sar12_previous = @VD_B10[pwl]
let sar12_stimulus = vector(8)
let sar12_stimulus[0] = 0
let sar12_stimulus[1] = sar12_previous[length(sar12_previous)-1]
let sar12_stimulus[2] = 8.70009999999999e-05
let sar12_stimulus[3] = sar12_stimulus[1]
let sar12_stimulus[4] = 8.70029999999999e-05
let sar12_stimulus[5] = sar12_drive
let sar12_stimulus[6] = 0.000148
let sar12_stimulus[7] = sar12_stimulus[5]
alter @VD_B10[pwl] = sar12_stimulus
let sar12_drive = (floor(sar12_trial / 2048) - 2*floor(sar12_trial / 4096))*1.8
let sar12_previous = @VD_B11[pwl]
let sar12_stimulus = vector(8)
let sar12_stimulus[0] = 0
let sar12_stimulus[1] = sar12_previous[length(sar12_previous)-1]
let sar12_stimulus[2] = 8.70009999999999e-05
let sar12_stimulus[3] = sar12_stimulus[1]
let sar12_stimulus[4] = 8.70029999999999e-05
let sar12_stimulus[5] = sar12_drive
let sar12_stimulus[6] = 0.000148
let sar12_stimulus[7] = sar12_stimulus[5]
alter @VD_B11[pwl] = sar12_stimulus
let sar12_drive = (floor(sar12_trial / 4096) - 2*floor(sar12_trial / 8192))*1.8
let sar12_previous = @VD_B12[pwl]
let sar12_stimulus = vector(8)
let sar12_stimulus[0] = 0
let sar12_stimulus[1] = sar12_previous[length(sar12_previous)-1]
let sar12_stimulus[2] = 8.70009999999999e-05
let sar12_stimulus[3] = sar12_stimulus[1]
let sar12_stimulus[4] = 8.70029999999999e-05
let sar12_stimulus[5] = sar12_drive
let sar12_stimulus[6] = 0.000148
let sar12_stimulus[7] = sar12_stimulus[5]
alter @VD_B12[pwl] = sar12_stimulus
let sar12_drive = (floor(sar12_trial / 8192) - 2*floor(sar12_trial / 16384))*1.8
let sar12_previous = @VD_B13[pwl]
let sar12_stimulus = vector(8)
let sar12_stimulus[0] = 0
let sar12_stimulus[1] = sar12_previous[length(sar12_previous)-1]
let sar12_stimulus[2] = 8.70009999999999e-05
let sar12_stimulus[3] = sar12_stimulus[1]
let sar12_stimulus[4] = 8.70029999999999e-05
let sar12_stimulus[5] = sar12_drive
let sar12_stimulus[6] = 0.000148
let sar12_stimulus[7] = sar12_stimulus[5]
alter @VD_B13[pwl] = sar12_stimulus
let sar12_drive = (floor(sar12_trial / 16384) - 2*floor(sar12_trial / 32768))*1.8
let sar12_previous = @VD_B14[pwl]
let sar12_stimulus = vector(8)
let sar12_stimulus[0] = 0
let sar12_stimulus[1] = sar12_previous[length(sar12_previous)-1]
let sar12_stimulus[2] = 8.70009999999999e-05
let sar12_stimulus[3] = sar12_stimulus[1]
let sar12_stimulus[4] = 8.70029999999999e-05
let sar12_stimulus[5] = sar12_drive
let sar12_stimulus[6] = 0.000148
let sar12_stimulus[7] = sar12_stimulus[5]
alter @VD_B14[pwl] = sar12_stimulus
let sar12_drive = (floor(sar12_trial / 32768) - 2*floor(sar12_trial / 65536))*1.8
let sar12_previous = @VD_B15[pwl]
let sar12_stimulus = vector(8)
let sar12_stimulus[0] = 0
let sar12_stimulus[1] = sar12_previous[length(sar12_previous)-1]
let sar12_stimulus[2] = 8.70009999999999e-05
let sar12_stimulus[3] = sar12_stimulus[1]
let sar12_stimulus[4] = 8.70029999999999e-05
let sar12_stimulus[5] = sar12_drive
let sar12_stimulus[6] = 0.000148
let sar12_stimulus[7] = sar12_stimulus[5]
alter @VD_B15[pwl] = sar12_stimulus
resume
let sar12_k = length(time)-1
if abs(time[sar12_k] - 8.74999999999999e-05) > 1e-12
print time[sar12_k]
echo expected_pause_time_s 8.74999999999999e-05
echo SAR12_PAUSE_FAILED
quit 1
end
print time[sar12_k] >> pause-times.txt
let sar12_previous = @VD_EVAL[pwl]
let sar12_stimulus = vector(8)
let sar12_stimulus[0] = 0
let sar12_stimulus[1] = sar12_previous[length(sar12_previous)-1]
let sar12_stimulus[2] = 8.75009999999999e-05
let sar12_stimulus[3] = sar12_stimulus[1]
let sar12_stimulus[4] = 8.75029999999999e-05
let sar12_stimulus[5] = 1.8
let sar12_stimulus[6] = 0.000148
let sar12_stimulus[7] = sar12_stimulus[5]
alter @VD_EVAL[pwl] = sar12_stimulus
resume
let sar12_k = length(time)-1
if abs(time[sar12_k] - 8.79999999999999e-05) > 1e-12
print time[sar12_k]
echo expected_pause_time_s 8.79999999999999e-05
echo SAR12_PAUSE_FAILED
quit 1
end
print time[sar12_k] >> pause-times.txt
let sar12_k = length(time)-1
let sar12_cmp = v(COMP)[sar12_k]
let sar12_cmpn = v(COMPN)[sar12_k]
let sar12_p = v(TOPP)[sar12_k]
let sar12_n = v(TOPN)[sar12_k]
let sar12_decision = 0
if sar12_cmp >= 0.9
let sar12_code = sar12_trial
let sar12_decision = 1
end
echo 3 10 $&sar12_trial $&sar12_cmp $&sar12_cmpn $&sar12_p $&sar12_n -1.8310546875e-05 $&sar12_decision >> decisions.csv
let sar12_previous = @VD_EVAL[pwl]
let sar12_stimulus = vector(8)
let sar12_stimulus[0] = 0
let sar12_stimulus[1] = sar12_previous[length(sar12_previous)-1]
let sar12_stimulus[2] = 8.80009999999999e-05
let sar12_stimulus[3] = sar12_stimulus[1]
let sar12_stimulus[4] = 8.80029999999999e-05
let sar12_stimulus[5] = 0
let sar12_stimulus[6] = 0.000148
let sar12_stimulus[7] = sar12_stimulus[5]
alter @VD_EVAL[pwl] = sar12_stimulus
let sar12_trial = sar12_code + 512
let sar12_drive = (floor(sar12_trial / 1) - 2*floor(sar12_trial / 2))*1.8
let sar12_previous = @VD_B0[pwl]
let sar12_stimulus = vector(8)
let sar12_stimulus[0] = 0
let sar12_stimulus[1] = sar12_previous[length(sar12_previous)-1]
let sar12_stimulus[2] = 8.80009999999999e-05
let sar12_stimulus[3] = sar12_stimulus[1]
let sar12_stimulus[4] = 8.80029999999999e-05
let sar12_stimulus[5] = sar12_drive
let sar12_stimulus[6] = 0.000148
let sar12_stimulus[7] = sar12_stimulus[5]
alter @VD_B0[pwl] = sar12_stimulus
let sar12_drive = (floor(sar12_trial / 2) - 2*floor(sar12_trial / 4))*1.8
let sar12_previous = @VD_B1[pwl]
let sar12_stimulus = vector(8)
let sar12_stimulus[0] = 0
let sar12_stimulus[1] = sar12_previous[length(sar12_previous)-1]
let sar12_stimulus[2] = 8.80009999999999e-05
let sar12_stimulus[3] = sar12_stimulus[1]
let sar12_stimulus[4] = 8.80029999999999e-05
let sar12_stimulus[5] = sar12_drive
let sar12_stimulus[6] = 0.000148
let sar12_stimulus[7] = sar12_stimulus[5]
alter @VD_B1[pwl] = sar12_stimulus
let sar12_drive = (floor(sar12_trial / 4) - 2*floor(sar12_trial / 8))*1.8
let sar12_previous = @VD_B2[pwl]
let sar12_stimulus = vector(8)
let sar12_stimulus[0] = 0
let sar12_stimulus[1] = sar12_previous[length(sar12_previous)-1]
let sar12_stimulus[2] = 8.80009999999999e-05
let sar12_stimulus[3] = sar12_stimulus[1]
let sar12_stimulus[4] = 8.80029999999999e-05
let sar12_stimulus[5] = sar12_drive
let sar12_stimulus[6] = 0.000148
let sar12_stimulus[7] = sar12_stimulus[5]
alter @VD_B2[pwl] = sar12_stimulus
let sar12_drive = (floor(sar12_trial / 8) - 2*floor(sar12_trial / 16))*1.8
let sar12_previous = @VD_B3[pwl]
let sar12_stimulus = vector(8)
let sar12_stimulus[0] = 0
let sar12_stimulus[1] = sar12_previous[length(sar12_previous)-1]
let sar12_stimulus[2] = 8.80009999999999e-05
let sar12_stimulus[3] = sar12_stimulus[1]
let sar12_stimulus[4] = 8.80029999999999e-05
let sar12_stimulus[5] = sar12_drive
let sar12_stimulus[6] = 0.000148
let sar12_stimulus[7] = sar12_stimulus[5]
alter @VD_B3[pwl] = sar12_stimulus
let sar12_drive = (floor(sar12_trial / 16) - 2*floor(sar12_trial / 32))*1.8
let sar12_previous = @VD_B4[pwl]
let sar12_stimulus = vector(8)
let sar12_stimulus[0] = 0
let sar12_stimulus[1] = sar12_previous[length(sar12_previous)-1]
let sar12_stimulus[2] = 8.80009999999999e-05
let sar12_stimulus[3] = sar12_stimulus[1]
let sar12_stimulus[4] = 8.80029999999999e-05
let sar12_stimulus[5] = sar12_drive
let sar12_stimulus[6] = 0.000148
let sar12_stimulus[7] = sar12_stimulus[5]
alter @VD_B4[pwl] = sar12_stimulus
let sar12_drive = (floor(sar12_trial / 32) - 2*floor(sar12_trial / 64))*1.8
let sar12_previous = @VD_B5[pwl]
let sar12_stimulus = vector(8)
let sar12_stimulus[0] = 0
let sar12_stimulus[1] = sar12_previous[length(sar12_previous)-1]
let sar12_stimulus[2] = 8.80009999999999e-05
let sar12_stimulus[3] = sar12_stimulus[1]
let sar12_stimulus[4] = 8.80029999999999e-05
let sar12_stimulus[5] = sar12_drive
let sar12_stimulus[6] = 0.000148
let sar12_stimulus[7] = sar12_stimulus[5]
alter @VD_B5[pwl] = sar12_stimulus
let sar12_drive = (floor(sar12_trial / 64) - 2*floor(sar12_trial / 128))*1.8
let sar12_previous = @VD_B6[pwl]
let sar12_stimulus = vector(8)
let sar12_stimulus[0] = 0
let sar12_stimulus[1] = sar12_previous[length(sar12_previous)-1]
let sar12_stimulus[2] = 8.80009999999999e-05
let sar12_stimulus[3] = sar12_stimulus[1]
let sar12_stimulus[4] = 8.80029999999999e-05
let sar12_stimulus[5] = sar12_drive
let sar12_stimulus[6] = 0.000148
let sar12_stimulus[7] = sar12_stimulus[5]
alter @VD_B6[pwl] = sar12_stimulus
let sar12_drive = (floor(sar12_trial / 128) - 2*floor(sar12_trial / 256))*1.8
let sar12_previous = @VD_B7[pwl]
let sar12_stimulus = vector(8)
let sar12_stimulus[0] = 0
let sar12_stimulus[1] = sar12_previous[length(sar12_previous)-1]
let sar12_stimulus[2] = 8.80009999999999e-05
let sar12_stimulus[3] = sar12_stimulus[1]
let sar12_stimulus[4] = 8.80029999999999e-05
let sar12_stimulus[5] = sar12_drive
let sar12_stimulus[6] = 0.000148
let sar12_stimulus[7] = sar12_stimulus[5]
alter @VD_B7[pwl] = sar12_stimulus
let sar12_drive = (floor(sar12_trial / 256) - 2*floor(sar12_trial / 512))*1.8
let sar12_previous = @VD_B8[pwl]
let sar12_stimulus = vector(8)
let sar12_stimulus[0] = 0
let sar12_stimulus[1] = sar12_previous[length(sar12_previous)-1]
let sar12_stimulus[2] = 8.80009999999999e-05
let sar12_stimulus[3] = sar12_stimulus[1]
let sar12_stimulus[4] = 8.80029999999999e-05
let sar12_stimulus[5] = sar12_drive
let sar12_stimulus[6] = 0.000148
let sar12_stimulus[7] = sar12_stimulus[5]
alter @VD_B8[pwl] = sar12_stimulus
let sar12_drive = (floor(sar12_trial / 512) - 2*floor(sar12_trial / 1024))*1.8
let sar12_previous = @VD_B9[pwl]
let sar12_stimulus = vector(8)
let sar12_stimulus[0] = 0
let sar12_stimulus[1] = sar12_previous[length(sar12_previous)-1]
let sar12_stimulus[2] = 8.80009999999999e-05
let sar12_stimulus[3] = sar12_stimulus[1]
let sar12_stimulus[4] = 8.80029999999999e-05
let sar12_stimulus[5] = sar12_drive
let sar12_stimulus[6] = 0.000148
let sar12_stimulus[7] = sar12_stimulus[5]
alter @VD_B9[pwl] = sar12_stimulus
let sar12_drive = (floor(sar12_trial / 1024) - 2*floor(sar12_trial / 2048))*1.8
let sar12_previous = @VD_B10[pwl]
let sar12_stimulus = vector(8)
let sar12_stimulus[0] = 0
let sar12_stimulus[1] = sar12_previous[length(sar12_previous)-1]
let sar12_stimulus[2] = 8.80009999999999e-05
let sar12_stimulus[3] = sar12_stimulus[1]
let sar12_stimulus[4] = 8.80029999999999e-05
let sar12_stimulus[5] = sar12_drive
let sar12_stimulus[6] = 0.000148
let sar12_stimulus[7] = sar12_stimulus[5]
alter @VD_B10[pwl] = sar12_stimulus
let sar12_drive = (floor(sar12_trial / 2048) - 2*floor(sar12_trial / 4096))*1.8
let sar12_previous = @VD_B11[pwl]
let sar12_stimulus = vector(8)
let sar12_stimulus[0] = 0
let sar12_stimulus[1] = sar12_previous[length(sar12_previous)-1]
let sar12_stimulus[2] = 8.80009999999999e-05
let sar12_stimulus[3] = sar12_stimulus[1]
let sar12_stimulus[4] = 8.80029999999999e-05
let sar12_stimulus[5] = sar12_drive
let sar12_stimulus[6] = 0.000148
let sar12_stimulus[7] = sar12_stimulus[5]
alter @VD_B11[pwl] = sar12_stimulus
let sar12_drive = (floor(sar12_trial / 4096) - 2*floor(sar12_trial / 8192))*1.8
let sar12_previous = @VD_B12[pwl]
let sar12_stimulus = vector(8)
let sar12_stimulus[0] = 0
let sar12_stimulus[1] = sar12_previous[length(sar12_previous)-1]
let sar12_stimulus[2] = 8.80009999999999e-05
let sar12_stimulus[3] = sar12_stimulus[1]
let sar12_stimulus[4] = 8.80029999999999e-05
let sar12_stimulus[5] = sar12_drive
let sar12_stimulus[6] = 0.000148
let sar12_stimulus[7] = sar12_stimulus[5]
alter @VD_B12[pwl] = sar12_stimulus
let sar12_drive = (floor(sar12_trial / 8192) - 2*floor(sar12_trial / 16384))*1.8
let sar12_previous = @VD_B13[pwl]
let sar12_stimulus = vector(8)
let sar12_stimulus[0] = 0
let sar12_stimulus[1] = sar12_previous[length(sar12_previous)-1]
let sar12_stimulus[2] = 8.80009999999999e-05
let sar12_stimulus[3] = sar12_stimulus[1]
let sar12_stimulus[4] = 8.80029999999999e-05
let sar12_stimulus[5] = sar12_drive
let sar12_stimulus[6] = 0.000148
let sar12_stimulus[7] = sar12_stimulus[5]
alter @VD_B13[pwl] = sar12_stimulus
let sar12_drive = (floor(sar12_trial / 16384) - 2*floor(sar12_trial / 32768))*1.8
let sar12_previous = @VD_B14[pwl]
let sar12_stimulus = vector(8)
let sar12_stimulus[0] = 0
let sar12_stimulus[1] = sar12_previous[length(sar12_previous)-1]
let sar12_stimulus[2] = 8.80009999999999e-05
let sar12_stimulus[3] = sar12_stimulus[1]
let sar12_stimulus[4] = 8.80029999999999e-05
let sar12_stimulus[5] = sar12_drive
let sar12_stimulus[6] = 0.000148
let sar12_stimulus[7] = sar12_stimulus[5]
alter @VD_B14[pwl] = sar12_stimulus
let sar12_drive = (floor(sar12_trial / 32768) - 2*floor(sar12_trial / 65536))*1.8
let sar12_previous = @VD_B15[pwl]
let sar12_stimulus = vector(8)
let sar12_stimulus[0] = 0
let sar12_stimulus[1] = sar12_previous[length(sar12_previous)-1]
let sar12_stimulus[2] = 8.80009999999999e-05
let sar12_stimulus[3] = sar12_stimulus[1]
let sar12_stimulus[4] = 8.80029999999999e-05
let sar12_stimulus[5] = sar12_drive
let sar12_stimulus[6] = 0.000148
let sar12_stimulus[7] = sar12_stimulus[5]
alter @VD_B15[pwl] = sar12_stimulus
resume
let sar12_k = length(time)-1
if abs(time[sar12_k] - 8.84999999999999e-05) > 1e-12
print time[sar12_k]
echo expected_pause_time_s 8.84999999999999e-05
echo SAR12_PAUSE_FAILED
quit 1
end
print time[sar12_k] >> pause-times.txt
let sar12_previous = @VD_EVAL[pwl]
let sar12_stimulus = vector(8)
let sar12_stimulus[0] = 0
let sar12_stimulus[1] = sar12_previous[length(sar12_previous)-1]
let sar12_stimulus[2] = 8.85009999999999e-05
let sar12_stimulus[3] = sar12_stimulus[1]
let sar12_stimulus[4] = 8.85029999999999e-05
let sar12_stimulus[5] = 1.8
let sar12_stimulus[6] = 0.000148
let sar12_stimulus[7] = sar12_stimulus[5]
alter @VD_EVAL[pwl] = sar12_stimulus
resume
let sar12_k = length(time)-1
if abs(time[sar12_k] - 8.89999999999999e-05) > 1e-12
print time[sar12_k]
echo expected_pause_time_s 8.89999999999999e-05
echo SAR12_PAUSE_FAILED
quit 1
end
print time[sar12_k] >> pause-times.txt
let sar12_k = length(time)-1
let sar12_cmp = v(COMP)[sar12_k]
let sar12_cmpn = v(COMPN)[sar12_k]
let sar12_p = v(TOPP)[sar12_k]
let sar12_n = v(TOPN)[sar12_k]
let sar12_decision = 0
if sar12_cmp >= 0.9
let sar12_code = sar12_trial
let sar12_decision = 1
end
echo 3 9 $&sar12_trial $&sar12_cmp $&sar12_cmpn $&sar12_p $&sar12_n -1.8310546875e-05 $&sar12_decision >> decisions.csv
let sar12_previous = @VD_EVAL[pwl]
let sar12_stimulus = vector(8)
let sar12_stimulus[0] = 0
let sar12_stimulus[1] = sar12_previous[length(sar12_previous)-1]
let sar12_stimulus[2] = 8.90009999999999e-05
let sar12_stimulus[3] = sar12_stimulus[1]
let sar12_stimulus[4] = 8.90029999999999e-05
let sar12_stimulus[5] = 0
let sar12_stimulus[6] = 0.000148
let sar12_stimulus[7] = sar12_stimulus[5]
alter @VD_EVAL[pwl] = sar12_stimulus
let sar12_trial = sar12_code + 256
let sar12_drive = (floor(sar12_trial / 1) - 2*floor(sar12_trial / 2))*1.8
let sar12_previous = @VD_B0[pwl]
let sar12_stimulus = vector(8)
let sar12_stimulus[0] = 0
let sar12_stimulus[1] = sar12_previous[length(sar12_previous)-1]
let sar12_stimulus[2] = 8.90009999999999e-05
let sar12_stimulus[3] = sar12_stimulus[1]
let sar12_stimulus[4] = 8.90029999999999e-05
let sar12_stimulus[5] = sar12_drive
let sar12_stimulus[6] = 0.000148
let sar12_stimulus[7] = sar12_stimulus[5]
alter @VD_B0[pwl] = sar12_stimulus
let sar12_drive = (floor(sar12_trial / 2) - 2*floor(sar12_trial / 4))*1.8
let sar12_previous = @VD_B1[pwl]
let sar12_stimulus = vector(8)
let sar12_stimulus[0] = 0
let sar12_stimulus[1] = sar12_previous[length(sar12_previous)-1]
let sar12_stimulus[2] = 8.90009999999999e-05
let sar12_stimulus[3] = sar12_stimulus[1]
let sar12_stimulus[4] = 8.90029999999999e-05
let sar12_stimulus[5] = sar12_drive
let sar12_stimulus[6] = 0.000148
let sar12_stimulus[7] = sar12_stimulus[5]
alter @VD_B1[pwl] = sar12_stimulus
let sar12_drive = (floor(sar12_trial / 4) - 2*floor(sar12_trial / 8))*1.8
let sar12_previous = @VD_B2[pwl]
let sar12_stimulus = vector(8)
let sar12_stimulus[0] = 0
let sar12_stimulus[1] = sar12_previous[length(sar12_previous)-1]
let sar12_stimulus[2] = 8.90009999999999e-05
let sar12_stimulus[3] = sar12_stimulus[1]
let sar12_stimulus[4] = 8.90029999999999e-05
let sar12_stimulus[5] = sar12_drive
let sar12_stimulus[6] = 0.000148
let sar12_stimulus[7] = sar12_stimulus[5]
alter @VD_B2[pwl] = sar12_stimulus
let sar12_drive = (floor(sar12_trial / 8) - 2*floor(sar12_trial / 16))*1.8
let sar12_previous = @VD_B3[pwl]
let sar12_stimulus = vector(8)
let sar12_stimulus[0] = 0
let sar12_stimulus[1] = sar12_previous[length(sar12_previous)-1]
let sar12_stimulus[2] = 8.90009999999999e-05
let sar12_stimulus[3] = sar12_stimulus[1]
let sar12_stimulus[4] = 8.90029999999999e-05
let sar12_stimulus[5] = sar12_drive
let sar12_stimulus[6] = 0.000148
let sar12_stimulus[7] = sar12_stimulus[5]
alter @VD_B3[pwl] = sar12_stimulus
let sar12_drive = (floor(sar12_trial / 16) - 2*floor(sar12_trial / 32))*1.8
let sar12_previous = @VD_B4[pwl]
let sar12_stimulus = vector(8)
let sar12_stimulus[0] = 0
let sar12_stimulus[1] = sar12_previous[length(sar12_previous)-1]
let sar12_stimulus[2] = 8.90009999999999e-05
let sar12_stimulus[3] = sar12_stimulus[1]
let sar12_stimulus[4] = 8.90029999999999e-05
let sar12_stimulus[5] = sar12_drive
let sar12_stimulus[6] = 0.000148
let sar12_stimulus[7] = sar12_stimulus[5]
alter @VD_B4[pwl] = sar12_stimulus
let sar12_drive = (floor(sar12_trial / 32) - 2*floor(sar12_trial / 64))*1.8
let sar12_previous = @VD_B5[pwl]
let sar12_stimulus = vector(8)
let sar12_stimulus[0] = 0
let sar12_stimulus[1] = sar12_previous[length(sar12_previous)-1]
let sar12_stimulus[2] = 8.90009999999999e-05
let sar12_stimulus[3] = sar12_stimulus[1]
let sar12_stimulus[4] = 8.90029999999999e-05
let sar12_stimulus[5] = sar12_drive
let sar12_stimulus[6] = 0.000148
let sar12_stimulus[7] = sar12_stimulus[5]
alter @VD_B5[pwl] = sar12_stimulus
let sar12_drive = (floor(sar12_trial / 64) - 2*floor(sar12_trial / 128))*1.8
let sar12_previous = @VD_B6[pwl]
let sar12_stimulus = vector(8)
let sar12_stimulus[0] = 0
let sar12_stimulus[1] = sar12_previous[length(sar12_previous)-1]
let sar12_stimulus[2] = 8.90009999999999e-05
let sar12_stimulus[3] = sar12_stimulus[1]
let sar12_stimulus[4] = 8.90029999999999e-05
let sar12_stimulus[5] = sar12_drive
let sar12_stimulus[6] = 0.000148
let sar12_stimulus[7] = sar12_stimulus[5]
alter @VD_B6[pwl] = sar12_stimulus
let sar12_drive = (floor(sar12_trial / 128) - 2*floor(sar12_trial / 256))*1.8
let sar12_previous = @VD_B7[pwl]
let sar12_stimulus = vector(8)
let sar12_stimulus[0] = 0
let sar12_stimulus[1] = sar12_previous[length(sar12_previous)-1]
let sar12_stimulus[2] = 8.90009999999999e-05
let sar12_stimulus[3] = sar12_stimulus[1]
let sar12_stimulus[4] = 8.90029999999999e-05
let sar12_stimulus[5] = sar12_drive
let sar12_stimulus[6] = 0.000148
let sar12_stimulus[7] = sar12_stimulus[5]
alter @VD_B7[pwl] = sar12_stimulus
let sar12_drive = (floor(sar12_trial / 256) - 2*floor(sar12_trial / 512))*1.8
let sar12_previous = @VD_B8[pwl]
let sar12_stimulus = vector(8)
let sar12_stimulus[0] = 0
let sar12_stimulus[1] = sar12_previous[length(sar12_previous)-1]
let sar12_stimulus[2] = 8.90009999999999e-05
let sar12_stimulus[3] = sar12_stimulus[1]
let sar12_stimulus[4] = 8.90029999999999e-05
let sar12_stimulus[5] = sar12_drive
let sar12_stimulus[6] = 0.000148
let sar12_stimulus[7] = sar12_stimulus[5]
alter @VD_B8[pwl] = sar12_stimulus
let sar12_drive = (floor(sar12_trial / 512) - 2*floor(sar12_trial / 1024))*1.8
let sar12_previous = @VD_B9[pwl]
let sar12_stimulus = vector(8)
let sar12_stimulus[0] = 0
let sar12_stimulus[1] = sar12_previous[length(sar12_previous)-1]
let sar12_stimulus[2] = 8.90009999999999e-05
let sar12_stimulus[3] = sar12_stimulus[1]
let sar12_stimulus[4] = 8.90029999999999e-05
let sar12_stimulus[5] = sar12_drive
let sar12_stimulus[6] = 0.000148
let sar12_stimulus[7] = sar12_stimulus[5]
alter @VD_B9[pwl] = sar12_stimulus
let sar12_drive = (floor(sar12_trial / 1024) - 2*floor(sar12_trial / 2048))*1.8
let sar12_previous = @VD_B10[pwl]
let sar12_stimulus = vector(8)
let sar12_stimulus[0] = 0
let sar12_stimulus[1] = sar12_previous[length(sar12_previous)-1]
let sar12_stimulus[2] = 8.90009999999999e-05
let sar12_stimulus[3] = sar12_stimulus[1]
let sar12_stimulus[4] = 8.90029999999999e-05
let sar12_stimulus[5] = sar12_drive
let sar12_stimulus[6] = 0.000148
let sar12_stimulus[7] = sar12_stimulus[5]
alter @VD_B10[pwl] = sar12_stimulus
let sar12_drive = (floor(sar12_trial / 2048) - 2*floor(sar12_trial / 4096))*1.8
let sar12_previous = @VD_B11[pwl]
let sar12_stimulus = vector(8)
let sar12_stimulus[0] = 0
let sar12_stimulus[1] = sar12_previous[length(sar12_previous)-1]
let sar12_stimulus[2] = 8.90009999999999e-05
let sar12_stimulus[3] = sar12_stimulus[1]
let sar12_stimulus[4] = 8.90029999999999e-05
let sar12_stimulus[5] = sar12_drive
let sar12_stimulus[6] = 0.000148
let sar12_stimulus[7] = sar12_stimulus[5]
alter @VD_B11[pwl] = sar12_stimulus
let sar12_drive = (floor(sar12_trial / 4096) - 2*floor(sar12_trial / 8192))*1.8
let sar12_previous = @VD_B12[pwl]
let sar12_stimulus = vector(8)
let sar12_stimulus[0] = 0
let sar12_stimulus[1] = sar12_previous[length(sar12_previous)-1]
let sar12_stimulus[2] = 8.90009999999999e-05
let sar12_stimulus[3] = sar12_stimulus[1]
let sar12_stimulus[4] = 8.90029999999999e-05
let sar12_stimulus[5] = sar12_drive
let sar12_stimulus[6] = 0.000148
let sar12_stimulus[7] = sar12_stimulus[5]
alter @VD_B12[pwl] = sar12_stimulus
let sar12_drive = (floor(sar12_trial / 8192) - 2*floor(sar12_trial / 16384))*1.8
let sar12_previous = @VD_B13[pwl]
let sar12_stimulus = vector(8)
let sar12_stimulus[0] = 0
let sar12_stimulus[1] = sar12_previous[length(sar12_previous)-1]
let sar12_stimulus[2] = 8.90009999999999e-05
let sar12_stimulus[3] = sar12_stimulus[1]
let sar12_stimulus[4] = 8.90029999999999e-05
let sar12_stimulus[5] = sar12_drive
let sar12_stimulus[6] = 0.000148
let sar12_stimulus[7] = sar12_stimulus[5]
alter @VD_B13[pwl] = sar12_stimulus
let sar12_drive = (floor(sar12_trial / 16384) - 2*floor(sar12_trial / 32768))*1.8
let sar12_previous = @VD_B14[pwl]
let sar12_stimulus = vector(8)
let sar12_stimulus[0] = 0
let sar12_stimulus[1] = sar12_previous[length(sar12_previous)-1]
let sar12_stimulus[2] = 8.90009999999999e-05
let sar12_stimulus[3] = sar12_stimulus[1]
let sar12_stimulus[4] = 8.90029999999999e-05
let sar12_stimulus[5] = sar12_drive
let sar12_stimulus[6] = 0.000148
let sar12_stimulus[7] = sar12_stimulus[5]
alter @VD_B14[pwl] = sar12_stimulus
let sar12_drive = (floor(sar12_trial / 32768) - 2*floor(sar12_trial / 65536))*1.8
let sar12_previous = @VD_B15[pwl]
let sar12_stimulus = vector(8)
let sar12_stimulus[0] = 0
let sar12_stimulus[1] = sar12_previous[length(sar12_previous)-1]
let sar12_stimulus[2] = 8.90009999999999e-05
let sar12_stimulus[3] = sar12_stimulus[1]
let sar12_stimulus[4] = 8.90029999999999e-05
let sar12_stimulus[5] = sar12_drive
let sar12_stimulus[6] = 0.000148
let sar12_stimulus[7] = sar12_stimulus[5]
alter @VD_B15[pwl] = sar12_stimulus
resume
let sar12_k = length(time)-1
if abs(time[sar12_k] - 8.94999999999999e-05) > 1e-12
print time[sar12_k]
echo expected_pause_time_s 8.94999999999999e-05
echo SAR12_PAUSE_FAILED
quit 1
end
print time[sar12_k] >> pause-times.txt
let sar12_previous = @VD_EVAL[pwl]
let sar12_stimulus = vector(8)
let sar12_stimulus[0] = 0
let sar12_stimulus[1] = sar12_previous[length(sar12_previous)-1]
let sar12_stimulus[2] = 8.95009999999999e-05
let sar12_stimulus[3] = sar12_stimulus[1]
let sar12_stimulus[4] = 8.95029999999999e-05
let sar12_stimulus[5] = 1.8
let sar12_stimulus[6] = 0.000148
let sar12_stimulus[7] = sar12_stimulus[5]
alter @VD_EVAL[pwl] = sar12_stimulus
resume
let sar12_k = length(time)-1
if abs(time[sar12_k] - 8.99999999999999e-05) > 1e-12
print time[sar12_k]
echo expected_pause_time_s 8.99999999999999e-05
echo SAR12_PAUSE_FAILED
quit 1
end
print time[sar12_k] >> pause-times.txt
let sar12_k = length(time)-1
let sar12_cmp = v(COMP)[sar12_k]
let sar12_cmpn = v(COMPN)[sar12_k]
let sar12_p = v(TOPP)[sar12_k]
let sar12_n = v(TOPN)[sar12_k]
let sar12_decision = 0
if sar12_cmp >= 0.9
let sar12_code = sar12_trial
let sar12_decision = 1
end
echo 3 8 $&sar12_trial $&sar12_cmp $&sar12_cmpn $&sar12_p $&sar12_n -1.8310546875e-05 $&sar12_decision >> decisions.csv
let sar12_previous = @VD_EVAL[pwl]
let sar12_stimulus = vector(8)
let sar12_stimulus[0] = 0
let sar12_stimulus[1] = sar12_previous[length(sar12_previous)-1]
let sar12_stimulus[2] = 9.00009999999999e-05
let sar12_stimulus[3] = sar12_stimulus[1]
let sar12_stimulus[4] = 9.00029999999999e-05
let sar12_stimulus[5] = 0
let sar12_stimulus[6] = 0.000148
let sar12_stimulus[7] = sar12_stimulus[5]
alter @VD_EVAL[pwl] = sar12_stimulus
let sar12_trial = sar12_code + 128
let sar12_drive = (floor(sar12_trial / 1) - 2*floor(sar12_trial / 2))*1.8
let sar12_previous = @VD_B0[pwl]
let sar12_stimulus = vector(8)
let sar12_stimulus[0] = 0
let sar12_stimulus[1] = sar12_previous[length(sar12_previous)-1]
let sar12_stimulus[2] = 9.00009999999999e-05
let sar12_stimulus[3] = sar12_stimulus[1]
let sar12_stimulus[4] = 9.00029999999999e-05
let sar12_stimulus[5] = sar12_drive
let sar12_stimulus[6] = 0.000148
let sar12_stimulus[7] = sar12_stimulus[5]
alter @VD_B0[pwl] = sar12_stimulus
let sar12_drive = (floor(sar12_trial / 2) - 2*floor(sar12_trial / 4))*1.8
let sar12_previous = @VD_B1[pwl]
let sar12_stimulus = vector(8)
let sar12_stimulus[0] = 0
let sar12_stimulus[1] = sar12_previous[length(sar12_previous)-1]
let sar12_stimulus[2] = 9.00009999999999e-05
let sar12_stimulus[3] = sar12_stimulus[1]
let sar12_stimulus[4] = 9.00029999999999e-05
let sar12_stimulus[5] = sar12_drive
let sar12_stimulus[6] = 0.000148
let sar12_stimulus[7] = sar12_stimulus[5]
alter @VD_B1[pwl] = sar12_stimulus
let sar12_drive = (floor(sar12_trial / 4) - 2*floor(sar12_trial / 8))*1.8
let sar12_previous = @VD_B2[pwl]
let sar12_stimulus = vector(8)
let sar12_stimulus[0] = 0
let sar12_stimulus[1] = sar12_previous[length(sar12_previous)-1]
let sar12_stimulus[2] = 9.00009999999999e-05
let sar12_stimulus[3] = sar12_stimulus[1]
let sar12_stimulus[4] = 9.00029999999999e-05
let sar12_stimulus[5] = sar12_drive
let sar12_stimulus[6] = 0.000148
let sar12_stimulus[7] = sar12_stimulus[5]
alter @VD_B2[pwl] = sar12_stimulus
let sar12_drive = (floor(sar12_trial / 8) - 2*floor(sar12_trial / 16))*1.8
let sar12_previous = @VD_B3[pwl]
let sar12_stimulus = vector(8)
let sar12_stimulus[0] = 0
let sar12_stimulus[1] = sar12_previous[length(sar12_previous)-1]
let sar12_stimulus[2] = 9.00009999999999e-05
let sar12_stimulus[3] = sar12_stimulus[1]
let sar12_stimulus[4] = 9.00029999999999e-05
let sar12_stimulus[5] = sar12_drive
let sar12_stimulus[6] = 0.000148
let sar12_stimulus[7] = sar12_stimulus[5]
alter @VD_B3[pwl] = sar12_stimulus
let sar12_drive = (floor(sar12_trial / 16) - 2*floor(sar12_trial / 32))*1.8
let sar12_previous = @VD_B4[pwl]
let sar12_stimulus = vector(8)
let sar12_stimulus[0] = 0
let sar12_stimulus[1] = sar12_previous[length(sar12_previous)-1]
let sar12_stimulus[2] = 9.00009999999999e-05
let sar12_stimulus[3] = sar12_stimulus[1]
let sar12_stimulus[4] = 9.00029999999999e-05
let sar12_stimulus[5] = sar12_drive
let sar12_stimulus[6] = 0.000148
let sar12_stimulus[7] = sar12_stimulus[5]
alter @VD_B4[pwl] = sar12_stimulus
let sar12_drive = (floor(sar12_trial / 32) - 2*floor(sar12_trial / 64))*1.8
let sar12_previous = @VD_B5[pwl]
let sar12_stimulus = vector(8)
let sar12_stimulus[0] = 0
let sar12_stimulus[1] = sar12_previous[length(sar12_previous)-1]
let sar12_stimulus[2] = 9.00009999999999e-05
let sar12_stimulus[3] = sar12_stimulus[1]
let sar12_stimulus[4] = 9.00029999999999e-05
let sar12_stimulus[5] = sar12_drive
let sar12_stimulus[6] = 0.000148
let sar12_stimulus[7] = sar12_stimulus[5]
alter @VD_B5[pwl] = sar12_stimulus
let sar12_drive = (floor(sar12_trial / 64) - 2*floor(sar12_trial / 128))*1.8
let sar12_previous = @VD_B6[pwl]
let sar12_stimulus = vector(8)
let sar12_stimulus[0] = 0
let sar12_stimulus[1] = sar12_previous[length(sar12_previous)-1]
let sar12_stimulus[2] = 9.00009999999999e-05
let sar12_stimulus[3] = sar12_stimulus[1]
let sar12_stimulus[4] = 9.00029999999999e-05
let sar12_stimulus[5] = sar12_drive
let sar12_stimulus[6] = 0.000148
let sar12_stimulus[7] = sar12_stimulus[5]
alter @VD_B6[pwl] = sar12_stimulus
let sar12_drive = (floor(sar12_trial / 128) - 2*floor(sar12_trial / 256))*1.8
let sar12_previous = @VD_B7[pwl]
let sar12_stimulus = vector(8)
let sar12_stimulus[0] = 0
let sar12_stimulus[1] = sar12_previous[length(sar12_previous)-1]
let sar12_stimulus[2] = 9.00009999999999e-05
let sar12_stimulus[3] = sar12_stimulus[1]
let sar12_stimulus[4] = 9.00029999999999e-05
let sar12_stimulus[5] = sar12_drive
let sar12_stimulus[6] = 0.000148
let sar12_stimulus[7] = sar12_stimulus[5]
alter @VD_B7[pwl] = sar12_stimulus
let sar12_drive = (floor(sar12_trial / 256) - 2*floor(sar12_trial / 512))*1.8
let sar12_previous = @VD_B8[pwl]
let sar12_stimulus = vector(8)
let sar12_stimulus[0] = 0
let sar12_stimulus[1] = sar12_previous[length(sar12_previous)-1]
let sar12_stimulus[2] = 9.00009999999999e-05
let sar12_stimulus[3] = sar12_stimulus[1]
let sar12_stimulus[4] = 9.00029999999999e-05
let sar12_stimulus[5] = sar12_drive
let sar12_stimulus[6] = 0.000148
let sar12_stimulus[7] = sar12_stimulus[5]
alter @VD_B8[pwl] = sar12_stimulus
let sar12_drive = (floor(sar12_trial / 512) - 2*floor(sar12_trial / 1024))*1.8
let sar12_previous = @VD_B9[pwl]
let sar12_stimulus = vector(8)
let sar12_stimulus[0] = 0
let sar12_stimulus[1] = sar12_previous[length(sar12_previous)-1]
let sar12_stimulus[2] = 9.00009999999999e-05
let sar12_stimulus[3] = sar12_stimulus[1]
let sar12_stimulus[4] = 9.00029999999999e-05
let sar12_stimulus[5] = sar12_drive
let sar12_stimulus[6] = 0.000148
let sar12_stimulus[7] = sar12_stimulus[5]
alter @VD_B9[pwl] = sar12_stimulus
let sar12_drive = (floor(sar12_trial / 1024) - 2*floor(sar12_trial / 2048))*1.8
let sar12_previous = @VD_B10[pwl]
let sar12_stimulus = vector(8)
let sar12_stimulus[0] = 0
let sar12_stimulus[1] = sar12_previous[length(sar12_previous)-1]
let sar12_stimulus[2] = 9.00009999999999e-05
let sar12_stimulus[3] = sar12_stimulus[1]
let sar12_stimulus[4] = 9.00029999999999e-05
let sar12_stimulus[5] = sar12_drive
let sar12_stimulus[6] = 0.000148
let sar12_stimulus[7] = sar12_stimulus[5]
alter @VD_B10[pwl] = sar12_stimulus
let sar12_drive = (floor(sar12_trial / 2048) - 2*floor(sar12_trial / 4096))*1.8
let sar12_previous = @VD_B11[pwl]
let sar12_stimulus = vector(8)
let sar12_stimulus[0] = 0
let sar12_stimulus[1] = sar12_previous[length(sar12_previous)-1]
let sar12_stimulus[2] = 9.00009999999999e-05
let sar12_stimulus[3] = sar12_stimulus[1]
let sar12_stimulus[4] = 9.00029999999999e-05
let sar12_stimulus[5] = sar12_drive
let sar12_stimulus[6] = 0.000148
let sar12_stimulus[7] = sar12_stimulus[5]
alter @VD_B11[pwl] = sar12_stimulus
let sar12_drive = (floor(sar12_trial / 4096) - 2*floor(sar12_trial / 8192))*1.8
let sar12_previous = @VD_B12[pwl]
let sar12_stimulus = vector(8)
let sar12_stimulus[0] = 0
let sar12_stimulus[1] = sar12_previous[length(sar12_previous)-1]
let sar12_stimulus[2] = 9.00009999999999e-05
let sar12_stimulus[3] = sar12_stimulus[1]
let sar12_stimulus[4] = 9.00029999999999e-05
let sar12_stimulus[5] = sar12_drive
let sar12_stimulus[6] = 0.000148
let sar12_stimulus[7] = sar12_stimulus[5]
alter @VD_B12[pwl] = sar12_stimulus
let sar12_drive = (floor(sar12_trial / 8192) - 2*floor(sar12_trial / 16384))*1.8
let sar12_previous = @VD_B13[pwl]
let sar12_stimulus = vector(8)
let sar12_stimulus[0] = 0
let sar12_stimulus[1] = sar12_previous[length(sar12_previous)-1]
let sar12_stimulus[2] = 9.00009999999999e-05
let sar12_stimulus[3] = sar12_stimulus[1]
let sar12_stimulus[4] = 9.00029999999999e-05
let sar12_stimulus[5] = sar12_drive
let sar12_stimulus[6] = 0.000148
let sar12_stimulus[7] = sar12_stimulus[5]
alter @VD_B13[pwl] = sar12_stimulus
let sar12_drive = (floor(sar12_trial / 16384) - 2*floor(sar12_trial / 32768))*1.8
let sar12_previous = @VD_B14[pwl]
let sar12_stimulus = vector(8)
let sar12_stimulus[0] = 0
let sar12_stimulus[1] = sar12_previous[length(sar12_previous)-1]
let sar12_stimulus[2] = 9.00009999999999e-05
let sar12_stimulus[3] = sar12_stimulus[1]
let sar12_stimulus[4] = 9.00029999999999e-05
let sar12_stimulus[5] = sar12_drive
let sar12_stimulus[6] = 0.000148
let sar12_stimulus[7] = sar12_stimulus[5]
alter @VD_B14[pwl] = sar12_stimulus
let sar12_drive = (floor(sar12_trial / 32768) - 2*floor(sar12_trial / 65536))*1.8
let sar12_previous = @VD_B15[pwl]
let sar12_stimulus = vector(8)
let sar12_stimulus[0] = 0
let sar12_stimulus[1] = sar12_previous[length(sar12_previous)-1]
let sar12_stimulus[2] = 9.00009999999999e-05
let sar12_stimulus[3] = sar12_stimulus[1]
let sar12_stimulus[4] = 9.00029999999999e-05
let sar12_stimulus[5] = sar12_drive
let sar12_stimulus[6] = 0.000148
let sar12_stimulus[7] = sar12_stimulus[5]
alter @VD_B15[pwl] = sar12_stimulus
resume
let sar12_k = length(time)-1
if abs(time[sar12_k] - 9.04999999999999e-05) > 1e-12
print time[sar12_k]
echo expected_pause_time_s 9.04999999999999e-05
echo SAR12_PAUSE_FAILED
quit 1
end
print time[sar12_k] >> pause-times.txt
let sar12_previous = @VD_EVAL[pwl]
let sar12_stimulus = vector(8)
let sar12_stimulus[0] = 0
let sar12_stimulus[1] = sar12_previous[length(sar12_previous)-1]
let sar12_stimulus[2] = 9.05009999999999e-05
let sar12_stimulus[3] = sar12_stimulus[1]
let sar12_stimulus[4] = 9.05029999999999e-05
let sar12_stimulus[5] = 1.8
let sar12_stimulus[6] = 0.000148
let sar12_stimulus[7] = sar12_stimulus[5]
alter @VD_EVAL[pwl] = sar12_stimulus
resume
let sar12_k = length(time)-1
if abs(time[sar12_k] - 9.09999999999999e-05) > 1e-12
print time[sar12_k]
echo expected_pause_time_s 9.09999999999999e-05
echo SAR12_PAUSE_FAILED
quit 1
end
print time[sar12_k] >> pause-times.txt
let sar12_k = length(time)-1
let sar12_cmp = v(COMP)[sar12_k]
let sar12_cmpn = v(COMPN)[sar12_k]
let sar12_p = v(TOPP)[sar12_k]
let sar12_n = v(TOPN)[sar12_k]
let sar12_decision = 0
if sar12_cmp >= 0.9
let sar12_code = sar12_trial
let sar12_decision = 1
end
echo 3 7 $&sar12_trial $&sar12_cmp $&sar12_cmpn $&sar12_p $&sar12_n -1.8310546875e-05 $&sar12_decision >> decisions.csv
let sar12_previous = @VD_EVAL[pwl]
let sar12_stimulus = vector(8)
let sar12_stimulus[0] = 0
let sar12_stimulus[1] = sar12_previous[length(sar12_previous)-1]
let sar12_stimulus[2] = 9.10009999999999e-05
let sar12_stimulus[3] = sar12_stimulus[1]
let sar12_stimulus[4] = 9.10029999999999e-05
let sar12_stimulus[5] = 0
let sar12_stimulus[6] = 0.000148
let sar12_stimulus[7] = sar12_stimulus[5]
alter @VD_EVAL[pwl] = sar12_stimulus
let sar12_trial = sar12_code + 64
let sar12_drive = (floor(sar12_trial / 1) - 2*floor(sar12_trial / 2))*1.8
let sar12_previous = @VD_B0[pwl]
let sar12_stimulus = vector(8)
let sar12_stimulus[0] = 0
let sar12_stimulus[1] = sar12_previous[length(sar12_previous)-1]
let sar12_stimulus[2] = 9.10009999999999e-05
let sar12_stimulus[3] = sar12_stimulus[1]
let sar12_stimulus[4] = 9.10029999999999e-05
let sar12_stimulus[5] = sar12_drive
let sar12_stimulus[6] = 0.000148
let sar12_stimulus[7] = sar12_stimulus[5]
alter @VD_B0[pwl] = sar12_stimulus
let sar12_drive = (floor(sar12_trial / 2) - 2*floor(sar12_trial / 4))*1.8
let sar12_previous = @VD_B1[pwl]
let sar12_stimulus = vector(8)
let sar12_stimulus[0] = 0
let sar12_stimulus[1] = sar12_previous[length(sar12_previous)-1]
let sar12_stimulus[2] = 9.10009999999999e-05
let sar12_stimulus[3] = sar12_stimulus[1]
let sar12_stimulus[4] = 9.10029999999999e-05
let sar12_stimulus[5] = sar12_drive
let sar12_stimulus[6] = 0.000148
let sar12_stimulus[7] = sar12_stimulus[5]
alter @VD_B1[pwl] = sar12_stimulus
let sar12_drive = (floor(sar12_trial / 4) - 2*floor(sar12_trial / 8))*1.8
let sar12_previous = @VD_B2[pwl]
let sar12_stimulus = vector(8)
let sar12_stimulus[0] = 0
let sar12_stimulus[1] = sar12_previous[length(sar12_previous)-1]
let sar12_stimulus[2] = 9.10009999999999e-05
let sar12_stimulus[3] = sar12_stimulus[1]
let sar12_stimulus[4] = 9.10029999999999e-05
let sar12_stimulus[5] = sar12_drive
let sar12_stimulus[6] = 0.000148
let sar12_stimulus[7] = sar12_stimulus[5]
alter @VD_B2[pwl] = sar12_stimulus
let sar12_drive = (floor(sar12_trial / 8) - 2*floor(sar12_trial / 16))*1.8
let sar12_previous = @VD_B3[pwl]
let sar12_stimulus = vector(8)
let sar12_stimulus[0] = 0
let sar12_stimulus[1] = sar12_previous[length(sar12_previous)-1]
let sar12_stimulus[2] = 9.10009999999999e-05
let sar12_stimulus[3] = sar12_stimulus[1]
let sar12_stimulus[4] = 9.10029999999999e-05
let sar12_stimulus[5] = sar12_drive
let sar12_stimulus[6] = 0.000148
let sar12_stimulus[7] = sar12_stimulus[5]
alter @VD_B3[pwl] = sar12_stimulus
let sar12_drive = (floor(sar12_trial / 16) - 2*floor(sar12_trial / 32))*1.8
let sar12_previous = @VD_B4[pwl]
let sar12_stimulus = vector(8)
let sar12_stimulus[0] = 0
let sar12_stimulus[1] = sar12_previous[length(sar12_previous)-1]
let sar12_stimulus[2] = 9.10009999999999e-05
let sar12_stimulus[3] = sar12_stimulus[1]
let sar12_stimulus[4] = 9.10029999999999e-05
let sar12_stimulus[5] = sar12_drive
let sar12_stimulus[6] = 0.000148
let sar12_stimulus[7] = sar12_stimulus[5]
alter @VD_B4[pwl] = sar12_stimulus
let sar12_drive = (floor(sar12_trial / 32) - 2*floor(sar12_trial / 64))*1.8
let sar12_previous = @VD_B5[pwl]
let sar12_stimulus = vector(8)
let sar12_stimulus[0] = 0
let sar12_stimulus[1] = sar12_previous[length(sar12_previous)-1]
let sar12_stimulus[2] = 9.10009999999999e-05
let sar12_stimulus[3] = sar12_stimulus[1]
let sar12_stimulus[4] = 9.10029999999999e-05
let sar12_stimulus[5] = sar12_drive
let sar12_stimulus[6] = 0.000148
let sar12_stimulus[7] = sar12_stimulus[5]
alter @VD_B5[pwl] = sar12_stimulus
let sar12_drive = (floor(sar12_trial / 64) - 2*floor(sar12_trial / 128))*1.8
let sar12_previous = @VD_B6[pwl]
let sar12_stimulus = vector(8)
let sar12_stimulus[0] = 0
let sar12_stimulus[1] = sar12_previous[length(sar12_previous)-1]
let sar12_stimulus[2] = 9.10009999999999e-05
let sar12_stimulus[3] = sar12_stimulus[1]
let sar12_stimulus[4] = 9.10029999999999e-05
let sar12_stimulus[5] = sar12_drive
let sar12_stimulus[6] = 0.000148
let sar12_stimulus[7] = sar12_stimulus[5]
alter @VD_B6[pwl] = sar12_stimulus
let sar12_drive = (floor(sar12_trial / 128) - 2*floor(sar12_trial / 256))*1.8
let sar12_previous = @VD_B7[pwl]
let sar12_stimulus = vector(8)
let sar12_stimulus[0] = 0
let sar12_stimulus[1] = sar12_previous[length(sar12_previous)-1]
let sar12_stimulus[2] = 9.10009999999999e-05
let sar12_stimulus[3] = sar12_stimulus[1]
let sar12_stimulus[4] = 9.10029999999999e-05
let sar12_stimulus[5] = sar12_drive
let sar12_stimulus[6] = 0.000148
let sar12_stimulus[7] = sar12_stimulus[5]
alter @VD_B7[pwl] = sar12_stimulus
let sar12_drive = (floor(sar12_trial / 256) - 2*floor(sar12_trial / 512))*1.8
let sar12_previous = @VD_B8[pwl]
let sar12_stimulus = vector(8)
let sar12_stimulus[0] = 0
let sar12_stimulus[1] = sar12_previous[length(sar12_previous)-1]
let sar12_stimulus[2] = 9.10009999999999e-05
let sar12_stimulus[3] = sar12_stimulus[1]
let sar12_stimulus[4] = 9.10029999999999e-05
let sar12_stimulus[5] = sar12_drive
let sar12_stimulus[6] = 0.000148
let sar12_stimulus[7] = sar12_stimulus[5]
alter @VD_B8[pwl] = sar12_stimulus
let sar12_drive = (floor(sar12_trial / 512) - 2*floor(sar12_trial / 1024))*1.8
let sar12_previous = @VD_B9[pwl]
let sar12_stimulus = vector(8)
let sar12_stimulus[0] = 0
let sar12_stimulus[1] = sar12_previous[length(sar12_previous)-1]
let sar12_stimulus[2] = 9.10009999999999e-05
let sar12_stimulus[3] = sar12_stimulus[1]
let sar12_stimulus[4] = 9.10029999999999e-05
let sar12_stimulus[5] = sar12_drive
let sar12_stimulus[6] = 0.000148
let sar12_stimulus[7] = sar12_stimulus[5]
alter @VD_B9[pwl] = sar12_stimulus
let sar12_drive = (floor(sar12_trial / 1024) - 2*floor(sar12_trial / 2048))*1.8
let sar12_previous = @VD_B10[pwl]
let sar12_stimulus = vector(8)
let sar12_stimulus[0] = 0
let sar12_stimulus[1] = sar12_previous[length(sar12_previous)-1]
let sar12_stimulus[2] = 9.10009999999999e-05
let sar12_stimulus[3] = sar12_stimulus[1]
let sar12_stimulus[4] = 9.10029999999999e-05
let sar12_stimulus[5] = sar12_drive
let sar12_stimulus[6] = 0.000148
let sar12_stimulus[7] = sar12_stimulus[5]
alter @VD_B10[pwl] = sar12_stimulus
let sar12_drive = (floor(sar12_trial / 2048) - 2*floor(sar12_trial / 4096))*1.8
let sar12_previous = @VD_B11[pwl]
let sar12_stimulus = vector(8)
let sar12_stimulus[0] = 0
let sar12_stimulus[1] = sar12_previous[length(sar12_previous)-1]
let sar12_stimulus[2] = 9.10009999999999e-05
let sar12_stimulus[3] = sar12_stimulus[1]
let sar12_stimulus[4] = 9.10029999999999e-05
let sar12_stimulus[5] = sar12_drive
let sar12_stimulus[6] = 0.000148
let sar12_stimulus[7] = sar12_stimulus[5]
alter @VD_B11[pwl] = sar12_stimulus
let sar12_drive = (floor(sar12_trial / 4096) - 2*floor(sar12_trial / 8192))*1.8
let sar12_previous = @VD_B12[pwl]
let sar12_stimulus = vector(8)
let sar12_stimulus[0] = 0
let sar12_stimulus[1] = sar12_previous[length(sar12_previous)-1]
let sar12_stimulus[2] = 9.10009999999999e-05
let sar12_stimulus[3] = sar12_stimulus[1]
let sar12_stimulus[4] = 9.10029999999999e-05
let sar12_stimulus[5] = sar12_drive
let sar12_stimulus[6] = 0.000148
let sar12_stimulus[7] = sar12_stimulus[5]
alter @VD_B12[pwl] = sar12_stimulus
let sar12_drive = (floor(sar12_trial / 8192) - 2*floor(sar12_trial / 16384))*1.8
let sar12_previous = @VD_B13[pwl]
let sar12_stimulus = vector(8)
let sar12_stimulus[0] = 0
let sar12_stimulus[1] = sar12_previous[length(sar12_previous)-1]
let sar12_stimulus[2] = 9.10009999999999e-05
let sar12_stimulus[3] = sar12_stimulus[1]
let sar12_stimulus[4] = 9.10029999999999e-05
let sar12_stimulus[5] = sar12_drive
let sar12_stimulus[6] = 0.000148
let sar12_stimulus[7] = sar12_stimulus[5]
alter @VD_B13[pwl] = sar12_stimulus
let sar12_drive = (floor(sar12_trial / 16384) - 2*floor(sar12_trial / 32768))*1.8
let sar12_previous = @VD_B14[pwl]
let sar12_stimulus = vector(8)
let sar12_stimulus[0] = 0
let sar12_stimulus[1] = sar12_previous[length(sar12_previous)-1]
let sar12_stimulus[2] = 9.10009999999999e-05
let sar12_stimulus[3] = sar12_stimulus[1]
let sar12_stimulus[4] = 9.10029999999999e-05
let sar12_stimulus[5] = sar12_drive
let sar12_stimulus[6] = 0.000148
let sar12_stimulus[7] = sar12_stimulus[5]
alter @VD_B14[pwl] = sar12_stimulus
let sar12_drive = (floor(sar12_trial / 32768) - 2*floor(sar12_trial / 65536))*1.8
let sar12_previous = @VD_B15[pwl]
let sar12_stimulus = vector(8)
let sar12_stimulus[0] = 0
let sar12_stimulus[1] = sar12_previous[length(sar12_previous)-1]
let sar12_stimulus[2] = 9.10009999999999e-05
let sar12_stimulus[3] = sar12_stimulus[1]
let sar12_stimulus[4] = 9.10029999999999e-05
let sar12_stimulus[5] = sar12_drive
let sar12_stimulus[6] = 0.000148
let sar12_stimulus[7] = sar12_stimulus[5]
alter @VD_B15[pwl] = sar12_stimulus
resume
let sar12_k = length(time)-1
if abs(time[sar12_k] - 9.14999999999999e-05) > 1e-12
print time[sar12_k]
echo expected_pause_time_s 9.14999999999999e-05
echo SAR12_PAUSE_FAILED
quit 1
end
print time[sar12_k] >> pause-times.txt
let sar12_previous = @VD_EVAL[pwl]
let sar12_stimulus = vector(8)
let sar12_stimulus[0] = 0
let sar12_stimulus[1] = sar12_previous[length(sar12_previous)-1]
let sar12_stimulus[2] = 9.15009999999999e-05
let sar12_stimulus[3] = sar12_stimulus[1]
let sar12_stimulus[4] = 9.15029999999999e-05
let sar12_stimulus[5] = 1.8
let sar12_stimulus[6] = 0.000148
let sar12_stimulus[7] = sar12_stimulus[5]
alter @VD_EVAL[pwl] = sar12_stimulus
resume
let sar12_k = length(time)-1
if abs(time[sar12_k] - 9.19999999999999e-05) > 1e-12
print time[sar12_k]
echo expected_pause_time_s 9.19999999999999e-05
echo SAR12_PAUSE_FAILED
quit 1
end
print time[sar12_k] >> pause-times.txt
let sar12_k = length(time)-1
let sar12_cmp = v(COMP)[sar12_k]
let sar12_cmpn = v(COMPN)[sar12_k]
let sar12_p = v(TOPP)[sar12_k]
let sar12_n = v(TOPN)[sar12_k]
let sar12_decision = 0
if sar12_cmp >= 0.9
let sar12_code = sar12_trial
let sar12_decision = 1
end
echo 3 6 $&sar12_trial $&sar12_cmp $&sar12_cmpn $&sar12_p $&sar12_n -1.8310546875e-05 $&sar12_decision >> decisions.csv
let sar12_previous = @VD_EVAL[pwl]
let sar12_stimulus = vector(8)
let sar12_stimulus[0] = 0
let sar12_stimulus[1] = sar12_previous[length(sar12_previous)-1]
let sar12_stimulus[2] = 9.20009999999999e-05
let sar12_stimulus[3] = sar12_stimulus[1]
let sar12_stimulus[4] = 9.20029999999999e-05
let sar12_stimulus[5] = 0
let sar12_stimulus[6] = 0.000148
let sar12_stimulus[7] = sar12_stimulus[5]
alter @VD_EVAL[pwl] = sar12_stimulus
let sar12_trial = sar12_code + 32
let sar12_drive = (floor(sar12_trial / 1) - 2*floor(sar12_trial / 2))*1.8
let sar12_previous = @VD_B0[pwl]
let sar12_stimulus = vector(8)
let sar12_stimulus[0] = 0
let sar12_stimulus[1] = sar12_previous[length(sar12_previous)-1]
let sar12_stimulus[2] = 9.20009999999999e-05
let sar12_stimulus[3] = sar12_stimulus[1]
let sar12_stimulus[4] = 9.20029999999999e-05
let sar12_stimulus[5] = sar12_drive
let sar12_stimulus[6] = 0.000148
let sar12_stimulus[7] = sar12_stimulus[5]
alter @VD_B0[pwl] = sar12_stimulus
let sar12_drive = (floor(sar12_trial / 2) - 2*floor(sar12_trial / 4))*1.8
let sar12_previous = @VD_B1[pwl]
let sar12_stimulus = vector(8)
let sar12_stimulus[0] = 0
let sar12_stimulus[1] = sar12_previous[length(sar12_previous)-1]
let sar12_stimulus[2] = 9.20009999999999e-05
let sar12_stimulus[3] = sar12_stimulus[1]
let sar12_stimulus[4] = 9.20029999999999e-05
let sar12_stimulus[5] = sar12_drive
let sar12_stimulus[6] = 0.000148
let sar12_stimulus[7] = sar12_stimulus[5]
alter @VD_B1[pwl] = sar12_stimulus
let sar12_drive = (floor(sar12_trial / 4) - 2*floor(sar12_trial / 8))*1.8
let sar12_previous = @VD_B2[pwl]
let sar12_stimulus = vector(8)
let sar12_stimulus[0] = 0
let sar12_stimulus[1] = sar12_previous[length(sar12_previous)-1]
let sar12_stimulus[2] = 9.20009999999999e-05
let sar12_stimulus[3] = sar12_stimulus[1]
let sar12_stimulus[4] = 9.20029999999999e-05
let sar12_stimulus[5] = sar12_drive
let sar12_stimulus[6] = 0.000148
let sar12_stimulus[7] = sar12_stimulus[5]
alter @VD_B2[pwl] = sar12_stimulus
let sar12_drive = (floor(sar12_trial / 8) - 2*floor(sar12_trial / 16))*1.8
let sar12_previous = @VD_B3[pwl]
let sar12_stimulus = vector(8)
let sar12_stimulus[0] = 0
let sar12_stimulus[1] = sar12_previous[length(sar12_previous)-1]
let sar12_stimulus[2] = 9.20009999999999e-05
let sar12_stimulus[3] = sar12_stimulus[1]
let sar12_stimulus[4] = 9.20029999999999e-05
let sar12_stimulus[5] = sar12_drive
let sar12_stimulus[6] = 0.000148
let sar12_stimulus[7] = sar12_stimulus[5]
alter @VD_B3[pwl] = sar12_stimulus
let sar12_drive = (floor(sar12_trial / 16) - 2*floor(sar12_trial / 32))*1.8
let sar12_previous = @VD_B4[pwl]
let sar12_stimulus = vector(8)
let sar12_stimulus[0] = 0
let sar12_stimulus[1] = sar12_previous[length(sar12_previous)-1]
let sar12_stimulus[2] = 9.20009999999999e-05
let sar12_stimulus[3] = sar12_stimulus[1]
let sar12_stimulus[4] = 9.20029999999999e-05
let sar12_stimulus[5] = sar12_drive
let sar12_stimulus[6] = 0.000148
let sar12_stimulus[7] = sar12_stimulus[5]
alter @VD_B4[pwl] = sar12_stimulus
let sar12_drive = (floor(sar12_trial / 32) - 2*floor(sar12_trial / 64))*1.8
let sar12_previous = @VD_B5[pwl]
let sar12_stimulus = vector(8)
let sar12_stimulus[0] = 0
let sar12_stimulus[1] = sar12_previous[length(sar12_previous)-1]
let sar12_stimulus[2] = 9.20009999999999e-05
let sar12_stimulus[3] = sar12_stimulus[1]
let sar12_stimulus[4] = 9.20029999999999e-05
let sar12_stimulus[5] = sar12_drive
let sar12_stimulus[6] = 0.000148
let sar12_stimulus[7] = sar12_stimulus[5]
alter @VD_B5[pwl] = sar12_stimulus
let sar12_drive = (floor(sar12_trial / 64) - 2*floor(sar12_trial / 128))*1.8
let sar12_previous = @VD_B6[pwl]
let sar12_stimulus = vector(8)
let sar12_stimulus[0] = 0
let sar12_stimulus[1] = sar12_previous[length(sar12_previous)-1]
let sar12_stimulus[2] = 9.20009999999999e-05
let sar12_stimulus[3] = sar12_stimulus[1]
let sar12_stimulus[4] = 9.20029999999999e-05
let sar12_stimulus[5] = sar12_drive
let sar12_stimulus[6] = 0.000148
let sar12_stimulus[7] = sar12_stimulus[5]
alter @VD_B6[pwl] = sar12_stimulus
let sar12_drive = (floor(sar12_trial / 128) - 2*floor(sar12_trial / 256))*1.8
let sar12_previous = @VD_B7[pwl]
let sar12_stimulus = vector(8)
let sar12_stimulus[0] = 0
let sar12_stimulus[1] = sar12_previous[length(sar12_previous)-1]
let sar12_stimulus[2] = 9.20009999999999e-05
let sar12_stimulus[3] = sar12_stimulus[1]
let sar12_stimulus[4] = 9.20029999999999e-05
let sar12_stimulus[5] = sar12_drive
let sar12_stimulus[6] = 0.000148
let sar12_stimulus[7] = sar12_stimulus[5]
alter @VD_B7[pwl] = sar12_stimulus
let sar12_drive = (floor(sar12_trial / 256) - 2*floor(sar12_trial / 512))*1.8
let sar12_previous = @VD_B8[pwl]
let sar12_stimulus = vector(8)
let sar12_stimulus[0] = 0
let sar12_stimulus[1] = sar12_previous[length(sar12_previous)-1]
let sar12_stimulus[2] = 9.20009999999999e-05
let sar12_stimulus[3] = sar12_stimulus[1]
let sar12_stimulus[4] = 9.20029999999999e-05
let sar12_stimulus[5] = sar12_drive
let sar12_stimulus[6] = 0.000148
let sar12_stimulus[7] = sar12_stimulus[5]
alter @VD_B8[pwl] = sar12_stimulus
let sar12_drive = (floor(sar12_trial / 512) - 2*floor(sar12_trial / 1024))*1.8
let sar12_previous = @VD_B9[pwl]
let sar12_stimulus = vector(8)
let sar12_stimulus[0] = 0
let sar12_stimulus[1] = sar12_previous[length(sar12_previous)-1]
let sar12_stimulus[2] = 9.20009999999999e-05
let sar12_stimulus[3] = sar12_stimulus[1]
let sar12_stimulus[4] = 9.20029999999999e-05
let sar12_stimulus[5] = sar12_drive
let sar12_stimulus[6] = 0.000148
let sar12_stimulus[7] = sar12_stimulus[5]
alter @VD_B9[pwl] = sar12_stimulus
let sar12_drive = (floor(sar12_trial / 1024) - 2*floor(sar12_trial / 2048))*1.8
let sar12_previous = @VD_B10[pwl]
let sar12_stimulus = vector(8)
let sar12_stimulus[0] = 0
let sar12_stimulus[1] = sar12_previous[length(sar12_previous)-1]
let sar12_stimulus[2] = 9.20009999999999e-05
let sar12_stimulus[3] = sar12_stimulus[1]
let sar12_stimulus[4] = 9.20029999999999e-05
let sar12_stimulus[5] = sar12_drive
let sar12_stimulus[6] = 0.000148
let sar12_stimulus[7] = sar12_stimulus[5]
alter @VD_B10[pwl] = sar12_stimulus
let sar12_drive = (floor(sar12_trial / 2048) - 2*floor(sar12_trial / 4096))*1.8
let sar12_previous = @VD_B11[pwl]
let sar12_stimulus = vector(8)
let sar12_stimulus[0] = 0
let sar12_stimulus[1] = sar12_previous[length(sar12_previous)-1]
let sar12_stimulus[2] = 9.20009999999999e-05
let sar12_stimulus[3] = sar12_stimulus[1]
let sar12_stimulus[4] = 9.20029999999999e-05
let sar12_stimulus[5] = sar12_drive
let sar12_stimulus[6] = 0.000148
let sar12_stimulus[7] = sar12_stimulus[5]
alter @VD_B11[pwl] = sar12_stimulus
let sar12_drive = (floor(sar12_trial / 4096) - 2*floor(sar12_trial / 8192))*1.8
let sar12_previous = @VD_B12[pwl]
let sar12_stimulus = vector(8)
let sar12_stimulus[0] = 0
let sar12_stimulus[1] = sar12_previous[length(sar12_previous)-1]
let sar12_stimulus[2] = 9.20009999999999e-05
let sar12_stimulus[3] = sar12_stimulus[1]
let sar12_stimulus[4] = 9.20029999999999e-05
let sar12_stimulus[5] = sar12_drive
let sar12_stimulus[6] = 0.000148
let sar12_stimulus[7] = sar12_stimulus[5]
alter @VD_B12[pwl] = sar12_stimulus
let sar12_drive = (floor(sar12_trial / 8192) - 2*floor(sar12_trial / 16384))*1.8
let sar12_previous = @VD_B13[pwl]
let sar12_stimulus = vector(8)
let sar12_stimulus[0] = 0
let sar12_stimulus[1] = sar12_previous[length(sar12_previous)-1]
let sar12_stimulus[2] = 9.20009999999999e-05
let sar12_stimulus[3] = sar12_stimulus[1]
let sar12_stimulus[4] = 9.20029999999999e-05
let sar12_stimulus[5] = sar12_drive
let sar12_stimulus[6] = 0.000148
let sar12_stimulus[7] = sar12_stimulus[5]
alter @VD_B13[pwl] = sar12_stimulus
let sar12_drive = (floor(sar12_trial / 16384) - 2*floor(sar12_trial / 32768))*1.8
let sar12_previous = @VD_B14[pwl]
let sar12_stimulus = vector(8)
let sar12_stimulus[0] = 0
let sar12_stimulus[1] = sar12_previous[length(sar12_previous)-1]
let sar12_stimulus[2] = 9.20009999999999e-05
let sar12_stimulus[3] = sar12_stimulus[1]
let sar12_stimulus[4] = 9.20029999999999e-05
let sar12_stimulus[5] = sar12_drive
let sar12_stimulus[6] = 0.000148
let sar12_stimulus[7] = sar12_stimulus[5]
alter @VD_B14[pwl] = sar12_stimulus
let sar12_drive = (floor(sar12_trial / 32768) - 2*floor(sar12_trial / 65536))*1.8
let sar12_previous = @VD_B15[pwl]
let sar12_stimulus = vector(8)
let sar12_stimulus[0] = 0
let sar12_stimulus[1] = sar12_previous[length(sar12_previous)-1]
let sar12_stimulus[2] = 9.20009999999999e-05
let sar12_stimulus[3] = sar12_stimulus[1]
let sar12_stimulus[4] = 9.20029999999999e-05
let sar12_stimulus[5] = sar12_drive
let sar12_stimulus[6] = 0.000148
let sar12_stimulus[7] = sar12_stimulus[5]
alter @VD_B15[pwl] = sar12_stimulus
resume
let sar12_k = length(time)-1
if abs(time[sar12_k] - 9.24999999999999e-05) > 1e-12
print time[sar12_k]
echo expected_pause_time_s 9.24999999999999e-05
echo SAR12_PAUSE_FAILED
quit 1
end
print time[sar12_k] >> pause-times.txt
let sar12_previous = @VD_EVAL[pwl]
let sar12_stimulus = vector(8)
let sar12_stimulus[0] = 0
let sar12_stimulus[1] = sar12_previous[length(sar12_previous)-1]
let sar12_stimulus[2] = 9.25009999999999e-05
let sar12_stimulus[3] = sar12_stimulus[1]
let sar12_stimulus[4] = 9.25029999999999e-05
let sar12_stimulus[5] = 1.8
let sar12_stimulus[6] = 0.000148
let sar12_stimulus[7] = sar12_stimulus[5]
alter @VD_EVAL[pwl] = sar12_stimulus
resume
let sar12_k = length(time)-1
if abs(time[sar12_k] - 9.29999999999999e-05) > 1e-12
print time[sar12_k]
echo expected_pause_time_s 9.29999999999999e-05
echo SAR12_PAUSE_FAILED
quit 1
end
print time[sar12_k] >> pause-times.txt
let sar12_k = length(time)-1
let sar12_cmp = v(COMP)[sar12_k]
let sar12_cmpn = v(COMPN)[sar12_k]
let sar12_p = v(TOPP)[sar12_k]
let sar12_n = v(TOPN)[sar12_k]
let sar12_decision = 0
if sar12_cmp >= 0.9
let sar12_code = sar12_trial
let sar12_decision = 1
end
echo 3 5 $&sar12_trial $&sar12_cmp $&sar12_cmpn $&sar12_p $&sar12_n -1.8310546875e-05 $&sar12_decision >> decisions.csv
let sar12_previous = @VD_EVAL[pwl]
let sar12_stimulus = vector(8)
let sar12_stimulus[0] = 0
let sar12_stimulus[1] = sar12_previous[length(sar12_previous)-1]
let sar12_stimulus[2] = 9.30009999999999e-05
let sar12_stimulus[3] = sar12_stimulus[1]
let sar12_stimulus[4] = 9.30029999999999e-05
let sar12_stimulus[5] = 0
let sar12_stimulus[6] = 0.000148
let sar12_stimulus[7] = sar12_stimulus[5]
alter @VD_EVAL[pwl] = sar12_stimulus
let sar12_trial = sar12_code + 16
let sar12_drive = (floor(sar12_trial / 1) - 2*floor(sar12_trial / 2))*1.8
let sar12_previous = @VD_B0[pwl]
let sar12_stimulus = vector(8)
let sar12_stimulus[0] = 0
let sar12_stimulus[1] = sar12_previous[length(sar12_previous)-1]
let sar12_stimulus[2] = 9.30009999999999e-05
let sar12_stimulus[3] = sar12_stimulus[1]
let sar12_stimulus[4] = 9.30029999999999e-05
let sar12_stimulus[5] = sar12_drive
let sar12_stimulus[6] = 0.000148
let sar12_stimulus[7] = sar12_stimulus[5]
alter @VD_B0[pwl] = sar12_stimulus
let sar12_drive = (floor(sar12_trial / 2) - 2*floor(sar12_trial / 4))*1.8
let sar12_previous = @VD_B1[pwl]
let sar12_stimulus = vector(8)
let sar12_stimulus[0] = 0
let sar12_stimulus[1] = sar12_previous[length(sar12_previous)-1]
let sar12_stimulus[2] = 9.30009999999999e-05
let sar12_stimulus[3] = sar12_stimulus[1]
let sar12_stimulus[4] = 9.30029999999999e-05
let sar12_stimulus[5] = sar12_drive
let sar12_stimulus[6] = 0.000148
let sar12_stimulus[7] = sar12_stimulus[5]
alter @VD_B1[pwl] = sar12_stimulus
let sar12_drive = (floor(sar12_trial / 4) - 2*floor(sar12_trial / 8))*1.8
let sar12_previous = @VD_B2[pwl]
let sar12_stimulus = vector(8)
let sar12_stimulus[0] = 0
let sar12_stimulus[1] = sar12_previous[length(sar12_previous)-1]
let sar12_stimulus[2] = 9.30009999999999e-05
let sar12_stimulus[3] = sar12_stimulus[1]
let sar12_stimulus[4] = 9.30029999999999e-05
let sar12_stimulus[5] = sar12_drive
let sar12_stimulus[6] = 0.000148
let sar12_stimulus[7] = sar12_stimulus[5]
alter @VD_B2[pwl] = sar12_stimulus
let sar12_drive = (floor(sar12_trial / 8) - 2*floor(sar12_trial / 16))*1.8
let sar12_previous = @VD_B3[pwl]
let sar12_stimulus = vector(8)
let sar12_stimulus[0] = 0
let sar12_stimulus[1] = sar12_previous[length(sar12_previous)-1]
let sar12_stimulus[2] = 9.30009999999999e-05
let sar12_stimulus[3] = sar12_stimulus[1]
let sar12_stimulus[4] = 9.30029999999999e-05
let sar12_stimulus[5] = sar12_drive
let sar12_stimulus[6] = 0.000148
let sar12_stimulus[7] = sar12_stimulus[5]
alter @VD_B3[pwl] = sar12_stimulus
let sar12_drive = (floor(sar12_trial / 16) - 2*floor(sar12_trial / 32))*1.8
let sar12_previous = @VD_B4[pwl]
let sar12_stimulus = vector(8)
let sar12_stimulus[0] = 0
let sar12_stimulus[1] = sar12_previous[length(sar12_previous)-1]
let sar12_stimulus[2] = 9.30009999999999e-05
let sar12_stimulus[3] = sar12_stimulus[1]
let sar12_stimulus[4] = 9.30029999999999e-05
let sar12_stimulus[5] = sar12_drive
let sar12_stimulus[6] = 0.000148
let sar12_stimulus[7] = sar12_stimulus[5]
alter @VD_B4[pwl] = sar12_stimulus
let sar12_drive = (floor(sar12_trial / 32) - 2*floor(sar12_trial / 64))*1.8
let sar12_previous = @VD_B5[pwl]
let sar12_stimulus = vector(8)
let sar12_stimulus[0] = 0
let sar12_stimulus[1] = sar12_previous[length(sar12_previous)-1]
let sar12_stimulus[2] = 9.30009999999999e-05
let sar12_stimulus[3] = sar12_stimulus[1]
let sar12_stimulus[4] = 9.30029999999999e-05
let sar12_stimulus[5] = sar12_drive
let sar12_stimulus[6] = 0.000148
let sar12_stimulus[7] = sar12_stimulus[5]
alter @VD_B5[pwl] = sar12_stimulus
let sar12_drive = (floor(sar12_trial / 64) - 2*floor(sar12_trial / 128))*1.8
let sar12_previous = @VD_B6[pwl]
let sar12_stimulus = vector(8)
let sar12_stimulus[0] = 0
let sar12_stimulus[1] = sar12_previous[length(sar12_previous)-1]
let sar12_stimulus[2] = 9.30009999999999e-05
let sar12_stimulus[3] = sar12_stimulus[1]
let sar12_stimulus[4] = 9.30029999999999e-05
let sar12_stimulus[5] = sar12_drive
let sar12_stimulus[6] = 0.000148
let sar12_stimulus[7] = sar12_stimulus[5]
alter @VD_B6[pwl] = sar12_stimulus
let sar12_drive = (floor(sar12_trial / 128) - 2*floor(sar12_trial / 256))*1.8
let sar12_previous = @VD_B7[pwl]
let sar12_stimulus = vector(8)
let sar12_stimulus[0] = 0
let sar12_stimulus[1] = sar12_previous[length(sar12_previous)-1]
let sar12_stimulus[2] = 9.30009999999999e-05
let sar12_stimulus[3] = sar12_stimulus[1]
let sar12_stimulus[4] = 9.30029999999999e-05
let sar12_stimulus[5] = sar12_drive
let sar12_stimulus[6] = 0.000148
let sar12_stimulus[7] = sar12_stimulus[5]
alter @VD_B7[pwl] = sar12_stimulus
let sar12_drive = (floor(sar12_trial / 256) - 2*floor(sar12_trial / 512))*1.8
let sar12_previous = @VD_B8[pwl]
let sar12_stimulus = vector(8)
let sar12_stimulus[0] = 0
let sar12_stimulus[1] = sar12_previous[length(sar12_previous)-1]
let sar12_stimulus[2] = 9.30009999999999e-05
let sar12_stimulus[3] = sar12_stimulus[1]
let sar12_stimulus[4] = 9.30029999999999e-05
let sar12_stimulus[5] = sar12_drive
let sar12_stimulus[6] = 0.000148
let sar12_stimulus[7] = sar12_stimulus[5]
alter @VD_B8[pwl] = sar12_stimulus
let sar12_drive = (floor(sar12_trial / 512) - 2*floor(sar12_trial / 1024))*1.8
let sar12_previous = @VD_B9[pwl]
let sar12_stimulus = vector(8)
let sar12_stimulus[0] = 0
let sar12_stimulus[1] = sar12_previous[length(sar12_previous)-1]
let sar12_stimulus[2] = 9.30009999999999e-05
let sar12_stimulus[3] = sar12_stimulus[1]
let sar12_stimulus[4] = 9.30029999999999e-05
let sar12_stimulus[5] = sar12_drive
let sar12_stimulus[6] = 0.000148
let sar12_stimulus[7] = sar12_stimulus[5]
alter @VD_B9[pwl] = sar12_stimulus
let sar12_drive = (floor(sar12_trial / 1024) - 2*floor(sar12_trial / 2048))*1.8
let sar12_previous = @VD_B10[pwl]
let sar12_stimulus = vector(8)
let sar12_stimulus[0] = 0
let sar12_stimulus[1] = sar12_previous[length(sar12_previous)-1]
let sar12_stimulus[2] = 9.30009999999999e-05
let sar12_stimulus[3] = sar12_stimulus[1]
let sar12_stimulus[4] = 9.30029999999999e-05
let sar12_stimulus[5] = sar12_drive
let sar12_stimulus[6] = 0.000148
let sar12_stimulus[7] = sar12_stimulus[5]
alter @VD_B10[pwl] = sar12_stimulus
let sar12_drive = (floor(sar12_trial / 2048) - 2*floor(sar12_trial / 4096))*1.8
let sar12_previous = @VD_B11[pwl]
let sar12_stimulus = vector(8)
let sar12_stimulus[0] = 0
let sar12_stimulus[1] = sar12_previous[length(sar12_previous)-1]
let sar12_stimulus[2] = 9.30009999999999e-05
let sar12_stimulus[3] = sar12_stimulus[1]
let sar12_stimulus[4] = 9.30029999999999e-05
let sar12_stimulus[5] = sar12_drive
let sar12_stimulus[6] = 0.000148
let sar12_stimulus[7] = sar12_stimulus[5]
alter @VD_B11[pwl] = sar12_stimulus
let sar12_drive = (floor(sar12_trial / 4096) - 2*floor(sar12_trial / 8192))*1.8
let sar12_previous = @VD_B12[pwl]
let sar12_stimulus = vector(8)
let sar12_stimulus[0] = 0
let sar12_stimulus[1] = sar12_previous[length(sar12_previous)-1]
let sar12_stimulus[2] = 9.30009999999999e-05
let sar12_stimulus[3] = sar12_stimulus[1]
let sar12_stimulus[4] = 9.30029999999999e-05
let sar12_stimulus[5] = sar12_drive
let sar12_stimulus[6] = 0.000148
let sar12_stimulus[7] = sar12_stimulus[5]
alter @VD_B12[pwl] = sar12_stimulus
let sar12_drive = (floor(sar12_trial / 8192) - 2*floor(sar12_trial / 16384))*1.8
let sar12_previous = @VD_B13[pwl]
let sar12_stimulus = vector(8)
let sar12_stimulus[0] = 0
let sar12_stimulus[1] = sar12_previous[length(sar12_previous)-1]
let sar12_stimulus[2] = 9.30009999999999e-05
let sar12_stimulus[3] = sar12_stimulus[1]
let sar12_stimulus[4] = 9.30029999999999e-05
let sar12_stimulus[5] = sar12_drive
let sar12_stimulus[6] = 0.000148
let sar12_stimulus[7] = sar12_stimulus[5]
alter @VD_B13[pwl] = sar12_stimulus
let sar12_drive = (floor(sar12_trial / 16384) - 2*floor(sar12_trial / 32768))*1.8
let sar12_previous = @VD_B14[pwl]
let sar12_stimulus = vector(8)
let sar12_stimulus[0] = 0
let sar12_stimulus[1] = sar12_previous[length(sar12_previous)-1]
let sar12_stimulus[2] = 9.30009999999999e-05
let sar12_stimulus[3] = sar12_stimulus[1]
let sar12_stimulus[4] = 9.30029999999999e-05
let sar12_stimulus[5] = sar12_drive
let sar12_stimulus[6] = 0.000148
let sar12_stimulus[7] = sar12_stimulus[5]
alter @VD_B14[pwl] = sar12_stimulus
let sar12_drive = (floor(sar12_trial / 32768) - 2*floor(sar12_trial / 65536))*1.8
let sar12_previous = @VD_B15[pwl]
let sar12_stimulus = vector(8)
let sar12_stimulus[0] = 0
let sar12_stimulus[1] = sar12_previous[length(sar12_previous)-1]
let sar12_stimulus[2] = 9.30009999999999e-05
let sar12_stimulus[3] = sar12_stimulus[1]
let sar12_stimulus[4] = 9.30029999999999e-05
let sar12_stimulus[5] = sar12_drive
let sar12_stimulus[6] = 0.000148
let sar12_stimulus[7] = sar12_stimulus[5]
alter @VD_B15[pwl] = sar12_stimulus
resume
let sar12_k = length(time)-1
if abs(time[sar12_k] - 9.34999999999999e-05) > 1e-12
print time[sar12_k]
echo expected_pause_time_s 9.34999999999999e-05
echo SAR12_PAUSE_FAILED
quit 1
end
print time[sar12_k] >> pause-times.txt
let sar12_previous = @VD_EVAL[pwl]
let sar12_stimulus = vector(8)
let sar12_stimulus[0] = 0
let sar12_stimulus[1] = sar12_previous[length(sar12_previous)-1]
let sar12_stimulus[2] = 9.35009999999999e-05
let sar12_stimulus[3] = sar12_stimulus[1]
let sar12_stimulus[4] = 9.35029999999999e-05
let sar12_stimulus[5] = 1.8
let sar12_stimulus[6] = 0.000148
let sar12_stimulus[7] = sar12_stimulus[5]
alter @VD_EVAL[pwl] = sar12_stimulus
resume
let sar12_k = length(time)-1
if abs(time[sar12_k] - 9.39999999999999e-05) > 1e-12
print time[sar12_k]
echo expected_pause_time_s 9.39999999999999e-05
echo SAR12_PAUSE_FAILED
quit 1
end
print time[sar12_k] >> pause-times.txt
let sar12_k = length(time)-1
let sar12_cmp = v(COMP)[sar12_k]
let sar12_cmpn = v(COMPN)[sar12_k]
let sar12_p = v(TOPP)[sar12_k]
let sar12_n = v(TOPN)[sar12_k]
let sar12_decision = 0
if sar12_cmp >= 0.9
let sar12_code = sar12_trial
let sar12_decision = 1
end
echo 3 4 $&sar12_trial $&sar12_cmp $&sar12_cmpn $&sar12_p $&sar12_n -1.8310546875e-05 $&sar12_decision >> decisions.csv
let sar12_previous = @VD_EVAL[pwl]
let sar12_stimulus = vector(8)
let sar12_stimulus[0] = 0
let sar12_stimulus[1] = sar12_previous[length(sar12_previous)-1]
let sar12_stimulus[2] = 9.40009999999999e-05
let sar12_stimulus[3] = sar12_stimulus[1]
let sar12_stimulus[4] = 9.40029999999999e-05
let sar12_stimulus[5] = 0
let sar12_stimulus[6] = 0.000148
let sar12_stimulus[7] = sar12_stimulus[5]
alter @VD_EVAL[pwl] = sar12_stimulus
let sar12_trial = sar12_code + 8
let sar12_drive = (floor(sar12_trial / 1) - 2*floor(sar12_trial / 2))*1.8
let sar12_previous = @VD_B0[pwl]
let sar12_stimulus = vector(8)
let sar12_stimulus[0] = 0
let sar12_stimulus[1] = sar12_previous[length(sar12_previous)-1]
let sar12_stimulus[2] = 9.40009999999999e-05
let sar12_stimulus[3] = sar12_stimulus[1]
let sar12_stimulus[4] = 9.40029999999999e-05
let sar12_stimulus[5] = sar12_drive
let sar12_stimulus[6] = 0.000148
let sar12_stimulus[7] = sar12_stimulus[5]
alter @VD_B0[pwl] = sar12_stimulus
let sar12_drive = (floor(sar12_trial / 2) - 2*floor(sar12_trial / 4))*1.8
let sar12_previous = @VD_B1[pwl]
let sar12_stimulus = vector(8)
let sar12_stimulus[0] = 0
let sar12_stimulus[1] = sar12_previous[length(sar12_previous)-1]
let sar12_stimulus[2] = 9.40009999999999e-05
let sar12_stimulus[3] = sar12_stimulus[1]
let sar12_stimulus[4] = 9.40029999999999e-05
let sar12_stimulus[5] = sar12_drive
let sar12_stimulus[6] = 0.000148
let sar12_stimulus[7] = sar12_stimulus[5]
alter @VD_B1[pwl] = sar12_stimulus
let sar12_drive = (floor(sar12_trial / 4) - 2*floor(sar12_trial / 8))*1.8
let sar12_previous = @VD_B2[pwl]
let sar12_stimulus = vector(8)
let sar12_stimulus[0] = 0
let sar12_stimulus[1] = sar12_previous[length(sar12_previous)-1]
let sar12_stimulus[2] = 9.40009999999999e-05
let sar12_stimulus[3] = sar12_stimulus[1]
let sar12_stimulus[4] = 9.40029999999999e-05
let sar12_stimulus[5] = sar12_drive
let sar12_stimulus[6] = 0.000148
let sar12_stimulus[7] = sar12_stimulus[5]
alter @VD_B2[pwl] = sar12_stimulus
let sar12_drive = (floor(sar12_trial / 8) - 2*floor(sar12_trial / 16))*1.8
let sar12_previous = @VD_B3[pwl]
let sar12_stimulus = vector(8)
let sar12_stimulus[0] = 0
let sar12_stimulus[1] = sar12_previous[length(sar12_previous)-1]
let sar12_stimulus[2] = 9.40009999999999e-05
let sar12_stimulus[3] = sar12_stimulus[1]
let sar12_stimulus[4] = 9.40029999999999e-05
let sar12_stimulus[5] = sar12_drive
let sar12_stimulus[6] = 0.000148
let sar12_stimulus[7] = sar12_stimulus[5]
alter @VD_B3[pwl] = sar12_stimulus
let sar12_drive = (floor(sar12_trial / 16) - 2*floor(sar12_trial / 32))*1.8
let sar12_previous = @VD_B4[pwl]
let sar12_stimulus = vector(8)
let sar12_stimulus[0] = 0
let sar12_stimulus[1] = sar12_previous[length(sar12_previous)-1]
let sar12_stimulus[2] = 9.40009999999999e-05
let sar12_stimulus[3] = sar12_stimulus[1]
let sar12_stimulus[4] = 9.40029999999999e-05
let sar12_stimulus[5] = sar12_drive
let sar12_stimulus[6] = 0.000148
let sar12_stimulus[7] = sar12_stimulus[5]
alter @VD_B4[pwl] = sar12_stimulus
let sar12_drive = (floor(sar12_trial / 32) - 2*floor(sar12_trial / 64))*1.8
let sar12_previous = @VD_B5[pwl]
let sar12_stimulus = vector(8)
let sar12_stimulus[0] = 0
let sar12_stimulus[1] = sar12_previous[length(sar12_previous)-1]
let sar12_stimulus[2] = 9.40009999999999e-05
let sar12_stimulus[3] = sar12_stimulus[1]
let sar12_stimulus[4] = 9.40029999999999e-05
let sar12_stimulus[5] = sar12_drive
let sar12_stimulus[6] = 0.000148
let sar12_stimulus[7] = sar12_stimulus[5]
alter @VD_B5[pwl] = sar12_stimulus
let sar12_drive = (floor(sar12_trial / 64) - 2*floor(sar12_trial / 128))*1.8
let sar12_previous = @VD_B6[pwl]
let sar12_stimulus = vector(8)
let sar12_stimulus[0] = 0
let sar12_stimulus[1] = sar12_previous[length(sar12_previous)-1]
let sar12_stimulus[2] = 9.40009999999999e-05
let sar12_stimulus[3] = sar12_stimulus[1]
let sar12_stimulus[4] = 9.40029999999999e-05
let sar12_stimulus[5] = sar12_drive
let sar12_stimulus[6] = 0.000148
let sar12_stimulus[7] = sar12_stimulus[5]
alter @VD_B6[pwl] = sar12_stimulus
let sar12_drive = (floor(sar12_trial / 128) - 2*floor(sar12_trial / 256))*1.8
let sar12_previous = @VD_B7[pwl]
let sar12_stimulus = vector(8)
let sar12_stimulus[0] = 0
let sar12_stimulus[1] = sar12_previous[length(sar12_previous)-1]
let sar12_stimulus[2] = 9.40009999999999e-05
let sar12_stimulus[3] = sar12_stimulus[1]
let sar12_stimulus[4] = 9.40029999999999e-05
let sar12_stimulus[5] = sar12_drive
let sar12_stimulus[6] = 0.000148
let sar12_stimulus[7] = sar12_stimulus[5]
alter @VD_B7[pwl] = sar12_stimulus
let sar12_drive = (floor(sar12_trial / 256) - 2*floor(sar12_trial / 512))*1.8
let sar12_previous = @VD_B8[pwl]
let sar12_stimulus = vector(8)
let sar12_stimulus[0] = 0
let sar12_stimulus[1] = sar12_previous[length(sar12_previous)-1]
let sar12_stimulus[2] = 9.40009999999999e-05
let sar12_stimulus[3] = sar12_stimulus[1]
let sar12_stimulus[4] = 9.40029999999999e-05
let sar12_stimulus[5] = sar12_drive
let sar12_stimulus[6] = 0.000148
let sar12_stimulus[7] = sar12_stimulus[5]
alter @VD_B8[pwl] = sar12_stimulus
let sar12_drive = (floor(sar12_trial / 512) - 2*floor(sar12_trial / 1024))*1.8
let sar12_previous = @VD_B9[pwl]
let sar12_stimulus = vector(8)
let sar12_stimulus[0] = 0
let sar12_stimulus[1] = sar12_previous[length(sar12_previous)-1]
let sar12_stimulus[2] = 9.40009999999999e-05
let sar12_stimulus[3] = sar12_stimulus[1]
let sar12_stimulus[4] = 9.40029999999999e-05
let sar12_stimulus[5] = sar12_drive
let sar12_stimulus[6] = 0.000148
let sar12_stimulus[7] = sar12_stimulus[5]
alter @VD_B9[pwl] = sar12_stimulus
let sar12_drive = (floor(sar12_trial / 1024) - 2*floor(sar12_trial / 2048))*1.8
let sar12_previous = @VD_B10[pwl]
let sar12_stimulus = vector(8)
let sar12_stimulus[0] = 0
let sar12_stimulus[1] = sar12_previous[length(sar12_previous)-1]
let sar12_stimulus[2] = 9.40009999999999e-05
let sar12_stimulus[3] = sar12_stimulus[1]
let sar12_stimulus[4] = 9.40029999999999e-05
let sar12_stimulus[5] = sar12_drive
let sar12_stimulus[6] = 0.000148
let sar12_stimulus[7] = sar12_stimulus[5]
alter @VD_B10[pwl] = sar12_stimulus
let sar12_drive = (floor(sar12_trial / 2048) - 2*floor(sar12_trial / 4096))*1.8
let sar12_previous = @VD_B11[pwl]
let sar12_stimulus = vector(8)
let sar12_stimulus[0] = 0
let sar12_stimulus[1] = sar12_previous[length(sar12_previous)-1]
let sar12_stimulus[2] = 9.40009999999999e-05
let sar12_stimulus[3] = sar12_stimulus[1]
let sar12_stimulus[4] = 9.40029999999999e-05
let sar12_stimulus[5] = sar12_drive
let sar12_stimulus[6] = 0.000148
let sar12_stimulus[7] = sar12_stimulus[5]
alter @VD_B11[pwl] = sar12_stimulus
let sar12_drive = (floor(sar12_trial / 4096) - 2*floor(sar12_trial / 8192))*1.8
let sar12_previous = @VD_B12[pwl]
let sar12_stimulus = vector(8)
let sar12_stimulus[0] = 0
let sar12_stimulus[1] = sar12_previous[length(sar12_previous)-1]
let sar12_stimulus[2] = 9.40009999999999e-05
let sar12_stimulus[3] = sar12_stimulus[1]
let sar12_stimulus[4] = 9.40029999999999e-05
let sar12_stimulus[5] = sar12_drive
let sar12_stimulus[6] = 0.000148
let sar12_stimulus[7] = sar12_stimulus[5]
alter @VD_B12[pwl] = sar12_stimulus
let sar12_drive = (floor(sar12_trial / 8192) - 2*floor(sar12_trial / 16384))*1.8
let sar12_previous = @VD_B13[pwl]
let sar12_stimulus = vector(8)
let sar12_stimulus[0] = 0
let sar12_stimulus[1] = sar12_previous[length(sar12_previous)-1]
let sar12_stimulus[2] = 9.40009999999999e-05
let sar12_stimulus[3] = sar12_stimulus[1]
let sar12_stimulus[4] = 9.40029999999999e-05
let sar12_stimulus[5] = sar12_drive
let sar12_stimulus[6] = 0.000148
let sar12_stimulus[7] = sar12_stimulus[5]
alter @VD_B13[pwl] = sar12_stimulus
let sar12_drive = (floor(sar12_trial / 16384) - 2*floor(sar12_trial / 32768))*1.8
let sar12_previous = @VD_B14[pwl]
let sar12_stimulus = vector(8)
let sar12_stimulus[0] = 0
let sar12_stimulus[1] = sar12_previous[length(sar12_previous)-1]
let sar12_stimulus[2] = 9.40009999999999e-05
let sar12_stimulus[3] = sar12_stimulus[1]
let sar12_stimulus[4] = 9.40029999999999e-05
let sar12_stimulus[5] = sar12_drive
let sar12_stimulus[6] = 0.000148
let sar12_stimulus[7] = sar12_stimulus[5]
alter @VD_B14[pwl] = sar12_stimulus
let sar12_drive = (floor(sar12_trial / 32768) - 2*floor(sar12_trial / 65536))*1.8
let sar12_previous = @VD_B15[pwl]
let sar12_stimulus = vector(8)
let sar12_stimulus[0] = 0
let sar12_stimulus[1] = sar12_previous[length(sar12_previous)-1]
let sar12_stimulus[2] = 9.40009999999999e-05
let sar12_stimulus[3] = sar12_stimulus[1]
let sar12_stimulus[4] = 9.40029999999999e-05
let sar12_stimulus[5] = sar12_drive
let sar12_stimulus[6] = 0.000148
let sar12_stimulus[7] = sar12_stimulus[5]
alter @VD_B15[pwl] = sar12_stimulus
resume
let sar12_k = length(time)-1
if abs(time[sar12_k] - 9.44999999999999e-05) > 1e-12
print time[sar12_k]
echo expected_pause_time_s 9.44999999999999e-05
echo SAR12_PAUSE_FAILED
quit 1
end
print time[sar12_k] >> pause-times.txt
let sar12_previous = @VD_EVAL[pwl]
let sar12_stimulus = vector(8)
let sar12_stimulus[0] = 0
let sar12_stimulus[1] = sar12_previous[length(sar12_previous)-1]
let sar12_stimulus[2] = 9.45009999999999e-05
let sar12_stimulus[3] = sar12_stimulus[1]
let sar12_stimulus[4] = 9.45029999999999e-05
let sar12_stimulus[5] = 1.8
let sar12_stimulus[6] = 0.000148
let sar12_stimulus[7] = sar12_stimulus[5]
alter @VD_EVAL[pwl] = sar12_stimulus
resume
let sar12_k = length(time)-1
if abs(time[sar12_k] - 9.49999999999999e-05) > 1e-12
print time[sar12_k]
echo expected_pause_time_s 9.49999999999999e-05
echo SAR12_PAUSE_FAILED
quit 1
end
print time[sar12_k] >> pause-times.txt
let sar12_k = length(time)-1
let sar12_cmp = v(COMP)[sar12_k]
let sar12_cmpn = v(COMPN)[sar12_k]
let sar12_p = v(TOPP)[sar12_k]
let sar12_n = v(TOPN)[sar12_k]
let sar12_decision = 0
if sar12_cmp >= 0.9
let sar12_code = sar12_trial
let sar12_decision = 1
end
echo 3 3 $&sar12_trial $&sar12_cmp $&sar12_cmpn $&sar12_p $&sar12_n -1.8310546875e-05 $&sar12_decision >> decisions.csv
let sar12_previous = @VD_EVAL[pwl]
let sar12_stimulus = vector(8)
let sar12_stimulus[0] = 0
let sar12_stimulus[1] = sar12_previous[length(sar12_previous)-1]
let sar12_stimulus[2] = 9.50009999999999e-05
let sar12_stimulus[3] = sar12_stimulus[1]
let sar12_stimulus[4] = 9.50029999999999e-05
let sar12_stimulus[5] = 0
let sar12_stimulus[6] = 0.000148
let sar12_stimulus[7] = sar12_stimulus[5]
alter @VD_EVAL[pwl] = sar12_stimulus
let sar12_trial = sar12_code + 4
let sar12_drive = (floor(sar12_trial / 1) - 2*floor(sar12_trial / 2))*1.8
let sar12_previous = @VD_B0[pwl]
let sar12_stimulus = vector(8)
let sar12_stimulus[0] = 0
let sar12_stimulus[1] = sar12_previous[length(sar12_previous)-1]
let sar12_stimulus[2] = 9.50009999999999e-05
let sar12_stimulus[3] = sar12_stimulus[1]
let sar12_stimulus[4] = 9.50029999999999e-05
let sar12_stimulus[5] = sar12_drive
let sar12_stimulus[6] = 0.000148
let sar12_stimulus[7] = sar12_stimulus[5]
alter @VD_B0[pwl] = sar12_stimulus
let sar12_drive = (floor(sar12_trial / 2) - 2*floor(sar12_trial / 4))*1.8
let sar12_previous = @VD_B1[pwl]
let sar12_stimulus = vector(8)
let sar12_stimulus[0] = 0
let sar12_stimulus[1] = sar12_previous[length(sar12_previous)-1]
let sar12_stimulus[2] = 9.50009999999999e-05
let sar12_stimulus[3] = sar12_stimulus[1]
let sar12_stimulus[4] = 9.50029999999999e-05
let sar12_stimulus[5] = sar12_drive
let sar12_stimulus[6] = 0.000148
let sar12_stimulus[7] = sar12_stimulus[5]
alter @VD_B1[pwl] = sar12_stimulus
let sar12_drive = (floor(sar12_trial / 4) - 2*floor(sar12_trial / 8))*1.8
let sar12_previous = @VD_B2[pwl]
let sar12_stimulus = vector(8)
let sar12_stimulus[0] = 0
let sar12_stimulus[1] = sar12_previous[length(sar12_previous)-1]
let sar12_stimulus[2] = 9.50009999999999e-05
let sar12_stimulus[3] = sar12_stimulus[1]
let sar12_stimulus[4] = 9.50029999999999e-05
let sar12_stimulus[5] = sar12_drive
let sar12_stimulus[6] = 0.000148
let sar12_stimulus[7] = sar12_stimulus[5]
alter @VD_B2[pwl] = sar12_stimulus
let sar12_drive = (floor(sar12_trial / 8) - 2*floor(sar12_trial / 16))*1.8
let sar12_previous = @VD_B3[pwl]
let sar12_stimulus = vector(8)
let sar12_stimulus[0] = 0
let sar12_stimulus[1] = sar12_previous[length(sar12_previous)-1]
let sar12_stimulus[2] = 9.50009999999999e-05
let sar12_stimulus[3] = sar12_stimulus[1]
let sar12_stimulus[4] = 9.50029999999999e-05
let sar12_stimulus[5] = sar12_drive
let sar12_stimulus[6] = 0.000148
let sar12_stimulus[7] = sar12_stimulus[5]
alter @VD_B3[pwl] = sar12_stimulus
let sar12_drive = (floor(sar12_trial / 16) - 2*floor(sar12_trial / 32))*1.8
let sar12_previous = @VD_B4[pwl]
let sar12_stimulus = vector(8)
let sar12_stimulus[0] = 0
let sar12_stimulus[1] = sar12_previous[length(sar12_previous)-1]
let sar12_stimulus[2] = 9.50009999999999e-05
let sar12_stimulus[3] = sar12_stimulus[1]
let sar12_stimulus[4] = 9.50029999999999e-05
let sar12_stimulus[5] = sar12_drive
let sar12_stimulus[6] = 0.000148
let sar12_stimulus[7] = sar12_stimulus[5]
alter @VD_B4[pwl] = sar12_stimulus
let sar12_drive = (floor(sar12_trial / 32) - 2*floor(sar12_trial / 64))*1.8
let sar12_previous = @VD_B5[pwl]
let sar12_stimulus = vector(8)
let sar12_stimulus[0] = 0
let sar12_stimulus[1] = sar12_previous[length(sar12_previous)-1]
let sar12_stimulus[2] = 9.50009999999999e-05
let sar12_stimulus[3] = sar12_stimulus[1]
let sar12_stimulus[4] = 9.50029999999999e-05
let sar12_stimulus[5] = sar12_drive
let sar12_stimulus[6] = 0.000148
let sar12_stimulus[7] = sar12_stimulus[5]
alter @VD_B5[pwl] = sar12_stimulus
let sar12_drive = (floor(sar12_trial / 64) - 2*floor(sar12_trial / 128))*1.8
let sar12_previous = @VD_B6[pwl]
let sar12_stimulus = vector(8)
let sar12_stimulus[0] = 0
let sar12_stimulus[1] = sar12_previous[length(sar12_previous)-1]
let sar12_stimulus[2] = 9.50009999999999e-05
let sar12_stimulus[3] = sar12_stimulus[1]
let sar12_stimulus[4] = 9.50029999999999e-05
let sar12_stimulus[5] = sar12_drive
let sar12_stimulus[6] = 0.000148
let sar12_stimulus[7] = sar12_stimulus[5]
alter @VD_B6[pwl] = sar12_stimulus
let sar12_drive = (floor(sar12_trial / 128) - 2*floor(sar12_trial / 256))*1.8
let sar12_previous = @VD_B7[pwl]
let sar12_stimulus = vector(8)
let sar12_stimulus[0] = 0
let sar12_stimulus[1] = sar12_previous[length(sar12_previous)-1]
let sar12_stimulus[2] = 9.50009999999999e-05
let sar12_stimulus[3] = sar12_stimulus[1]
let sar12_stimulus[4] = 9.50029999999999e-05
let sar12_stimulus[5] = sar12_drive
let sar12_stimulus[6] = 0.000148
let sar12_stimulus[7] = sar12_stimulus[5]
alter @VD_B7[pwl] = sar12_stimulus
let sar12_drive = (floor(sar12_trial / 256) - 2*floor(sar12_trial / 512))*1.8
let sar12_previous = @VD_B8[pwl]
let sar12_stimulus = vector(8)
let sar12_stimulus[0] = 0
let sar12_stimulus[1] = sar12_previous[length(sar12_previous)-1]
let sar12_stimulus[2] = 9.50009999999999e-05
let sar12_stimulus[3] = sar12_stimulus[1]
let sar12_stimulus[4] = 9.50029999999999e-05
let sar12_stimulus[5] = sar12_drive
let sar12_stimulus[6] = 0.000148
let sar12_stimulus[7] = sar12_stimulus[5]
alter @VD_B8[pwl] = sar12_stimulus
let sar12_drive = (floor(sar12_trial / 512) - 2*floor(sar12_trial / 1024))*1.8
let sar12_previous = @VD_B9[pwl]
let sar12_stimulus = vector(8)
let sar12_stimulus[0] = 0
let sar12_stimulus[1] = sar12_previous[length(sar12_previous)-1]
let sar12_stimulus[2] = 9.50009999999999e-05
let sar12_stimulus[3] = sar12_stimulus[1]
let sar12_stimulus[4] = 9.50029999999999e-05
let sar12_stimulus[5] = sar12_drive
let sar12_stimulus[6] = 0.000148
let sar12_stimulus[7] = sar12_stimulus[5]
alter @VD_B9[pwl] = sar12_stimulus
let sar12_drive = (floor(sar12_trial / 1024) - 2*floor(sar12_trial / 2048))*1.8
let sar12_previous = @VD_B10[pwl]
let sar12_stimulus = vector(8)
let sar12_stimulus[0] = 0
let sar12_stimulus[1] = sar12_previous[length(sar12_previous)-1]
let sar12_stimulus[2] = 9.50009999999999e-05
let sar12_stimulus[3] = sar12_stimulus[1]
let sar12_stimulus[4] = 9.50029999999999e-05
let sar12_stimulus[5] = sar12_drive
let sar12_stimulus[6] = 0.000148
let sar12_stimulus[7] = sar12_stimulus[5]
alter @VD_B10[pwl] = sar12_stimulus
let sar12_drive = (floor(sar12_trial / 2048) - 2*floor(sar12_trial / 4096))*1.8
let sar12_previous = @VD_B11[pwl]
let sar12_stimulus = vector(8)
let sar12_stimulus[0] = 0
let sar12_stimulus[1] = sar12_previous[length(sar12_previous)-1]
let sar12_stimulus[2] = 9.50009999999999e-05
let sar12_stimulus[3] = sar12_stimulus[1]
let sar12_stimulus[4] = 9.50029999999999e-05
let sar12_stimulus[5] = sar12_drive
let sar12_stimulus[6] = 0.000148
let sar12_stimulus[7] = sar12_stimulus[5]
alter @VD_B11[pwl] = sar12_stimulus
let sar12_drive = (floor(sar12_trial / 4096) - 2*floor(sar12_trial / 8192))*1.8
let sar12_previous = @VD_B12[pwl]
let sar12_stimulus = vector(8)
let sar12_stimulus[0] = 0
let sar12_stimulus[1] = sar12_previous[length(sar12_previous)-1]
let sar12_stimulus[2] = 9.50009999999999e-05
let sar12_stimulus[3] = sar12_stimulus[1]
let sar12_stimulus[4] = 9.50029999999999e-05
let sar12_stimulus[5] = sar12_drive
let sar12_stimulus[6] = 0.000148
let sar12_stimulus[7] = sar12_stimulus[5]
alter @VD_B12[pwl] = sar12_stimulus
let sar12_drive = (floor(sar12_trial / 8192) - 2*floor(sar12_trial / 16384))*1.8
let sar12_previous = @VD_B13[pwl]
let sar12_stimulus = vector(8)
let sar12_stimulus[0] = 0
let sar12_stimulus[1] = sar12_previous[length(sar12_previous)-1]
let sar12_stimulus[2] = 9.50009999999999e-05
let sar12_stimulus[3] = sar12_stimulus[1]
let sar12_stimulus[4] = 9.50029999999999e-05
let sar12_stimulus[5] = sar12_drive
let sar12_stimulus[6] = 0.000148
let sar12_stimulus[7] = sar12_stimulus[5]
alter @VD_B13[pwl] = sar12_stimulus
let sar12_drive = (floor(sar12_trial / 16384) - 2*floor(sar12_trial / 32768))*1.8
let sar12_previous = @VD_B14[pwl]
let sar12_stimulus = vector(8)
let sar12_stimulus[0] = 0
let sar12_stimulus[1] = sar12_previous[length(sar12_previous)-1]
let sar12_stimulus[2] = 9.50009999999999e-05
let sar12_stimulus[3] = sar12_stimulus[1]
let sar12_stimulus[4] = 9.50029999999999e-05
let sar12_stimulus[5] = sar12_drive
let sar12_stimulus[6] = 0.000148
let sar12_stimulus[7] = sar12_stimulus[5]
alter @VD_B14[pwl] = sar12_stimulus
let sar12_drive = (floor(sar12_trial / 32768) - 2*floor(sar12_trial / 65536))*1.8
let sar12_previous = @VD_B15[pwl]
let sar12_stimulus = vector(8)
let sar12_stimulus[0] = 0
let sar12_stimulus[1] = sar12_previous[length(sar12_previous)-1]
let sar12_stimulus[2] = 9.50009999999999e-05
let sar12_stimulus[3] = sar12_stimulus[1]
let sar12_stimulus[4] = 9.50029999999999e-05
let sar12_stimulus[5] = sar12_drive
let sar12_stimulus[6] = 0.000148
let sar12_stimulus[7] = sar12_stimulus[5]
alter @VD_B15[pwl] = sar12_stimulus
resume
let sar12_k = length(time)-1
if abs(time[sar12_k] - 9.54999999999999e-05) > 1e-12
print time[sar12_k]
echo expected_pause_time_s 9.54999999999999e-05
echo SAR12_PAUSE_FAILED
quit 1
end
print time[sar12_k] >> pause-times.txt
let sar12_previous = @VD_EVAL[pwl]
let sar12_stimulus = vector(8)
let sar12_stimulus[0] = 0
let sar12_stimulus[1] = sar12_previous[length(sar12_previous)-1]
let sar12_stimulus[2] = 9.55009999999999e-05
let sar12_stimulus[3] = sar12_stimulus[1]
let sar12_stimulus[4] = 9.55029999999999e-05
let sar12_stimulus[5] = 1.8
let sar12_stimulus[6] = 0.000148
let sar12_stimulus[7] = sar12_stimulus[5]
alter @VD_EVAL[pwl] = sar12_stimulus
resume
let sar12_k = length(time)-1
if abs(time[sar12_k] - 9.59999999999999e-05) > 1e-12
print time[sar12_k]
echo expected_pause_time_s 9.59999999999999e-05
echo SAR12_PAUSE_FAILED
quit 1
end
print time[sar12_k] >> pause-times.txt
let sar12_k = length(time)-1
let sar12_cmp = v(COMP)[sar12_k]
let sar12_cmpn = v(COMPN)[sar12_k]
let sar12_p = v(TOPP)[sar12_k]
let sar12_n = v(TOPN)[sar12_k]
let sar12_decision = 0
if sar12_cmp >= 0.9
let sar12_code = sar12_trial
let sar12_decision = 1
end
echo 3 2 $&sar12_trial $&sar12_cmp $&sar12_cmpn $&sar12_p $&sar12_n -1.8310546875e-05 $&sar12_decision >> decisions.csv
let sar12_previous = @VD_EVAL[pwl]
let sar12_stimulus = vector(8)
let sar12_stimulus[0] = 0
let sar12_stimulus[1] = sar12_previous[length(sar12_previous)-1]
let sar12_stimulus[2] = 9.60009999999999e-05
let sar12_stimulus[3] = sar12_stimulus[1]
let sar12_stimulus[4] = 9.60029999999999e-05
let sar12_stimulus[5] = 0
let sar12_stimulus[6] = 0.000148
let sar12_stimulus[7] = sar12_stimulus[5]
alter @VD_EVAL[pwl] = sar12_stimulus
let sar12_trial = sar12_code + 2
let sar12_drive = (floor(sar12_trial / 1) - 2*floor(sar12_trial / 2))*1.8
let sar12_previous = @VD_B0[pwl]
let sar12_stimulus = vector(8)
let sar12_stimulus[0] = 0
let sar12_stimulus[1] = sar12_previous[length(sar12_previous)-1]
let sar12_stimulus[2] = 9.60009999999999e-05
let sar12_stimulus[3] = sar12_stimulus[1]
let sar12_stimulus[4] = 9.60029999999999e-05
let sar12_stimulus[5] = sar12_drive
let sar12_stimulus[6] = 0.000148
let sar12_stimulus[7] = sar12_stimulus[5]
alter @VD_B0[pwl] = sar12_stimulus
let sar12_drive = (floor(sar12_trial / 2) - 2*floor(sar12_trial / 4))*1.8
let sar12_previous = @VD_B1[pwl]
let sar12_stimulus = vector(8)
let sar12_stimulus[0] = 0
let sar12_stimulus[1] = sar12_previous[length(sar12_previous)-1]
let sar12_stimulus[2] = 9.60009999999999e-05
let sar12_stimulus[3] = sar12_stimulus[1]
let sar12_stimulus[4] = 9.60029999999999e-05
let sar12_stimulus[5] = sar12_drive
let sar12_stimulus[6] = 0.000148
let sar12_stimulus[7] = sar12_stimulus[5]
alter @VD_B1[pwl] = sar12_stimulus
let sar12_drive = (floor(sar12_trial / 4) - 2*floor(sar12_trial / 8))*1.8
let sar12_previous = @VD_B2[pwl]
let sar12_stimulus = vector(8)
let sar12_stimulus[0] = 0
let sar12_stimulus[1] = sar12_previous[length(sar12_previous)-1]
let sar12_stimulus[2] = 9.60009999999999e-05
let sar12_stimulus[3] = sar12_stimulus[1]
let sar12_stimulus[4] = 9.60029999999999e-05
let sar12_stimulus[5] = sar12_drive
let sar12_stimulus[6] = 0.000148
let sar12_stimulus[7] = sar12_stimulus[5]
alter @VD_B2[pwl] = sar12_stimulus
let sar12_drive = (floor(sar12_trial / 8) - 2*floor(sar12_trial / 16))*1.8
let sar12_previous = @VD_B3[pwl]
let sar12_stimulus = vector(8)
let sar12_stimulus[0] = 0
let sar12_stimulus[1] = sar12_previous[length(sar12_previous)-1]
let sar12_stimulus[2] = 9.60009999999999e-05
let sar12_stimulus[3] = sar12_stimulus[1]
let sar12_stimulus[4] = 9.60029999999999e-05
let sar12_stimulus[5] = sar12_drive
let sar12_stimulus[6] = 0.000148
let sar12_stimulus[7] = sar12_stimulus[5]
alter @VD_B3[pwl] = sar12_stimulus
let sar12_drive = (floor(sar12_trial / 16) - 2*floor(sar12_trial / 32))*1.8
let sar12_previous = @VD_B4[pwl]
let sar12_stimulus = vector(8)
let sar12_stimulus[0] = 0
let sar12_stimulus[1] = sar12_previous[length(sar12_previous)-1]
let sar12_stimulus[2] = 9.60009999999999e-05
let sar12_stimulus[3] = sar12_stimulus[1]
let sar12_stimulus[4] = 9.60029999999999e-05
let sar12_stimulus[5] = sar12_drive
let sar12_stimulus[6] = 0.000148
let sar12_stimulus[7] = sar12_stimulus[5]
alter @VD_B4[pwl] = sar12_stimulus
let sar12_drive = (floor(sar12_trial / 32) - 2*floor(sar12_trial / 64))*1.8
let sar12_previous = @VD_B5[pwl]
let sar12_stimulus = vector(8)
let sar12_stimulus[0] = 0
let sar12_stimulus[1] = sar12_previous[length(sar12_previous)-1]
let sar12_stimulus[2] = 9.60009999999999e-05
let sar12_stimulus[3] = sar12_stimulus[1]
let sar12_stimulus[4] = 9.60029999999999e-05
let sar12_stimulus[5] = sar12_drive
let sar12_stimulus[6] = 0.000148
let sar12_stimulus[7] = sar12_stimulus[5]
alter @VD_B5[pwl] = sar12_stimulus
let sar12_drive = (floor(sar12_trial / 64) - 2*floor(sar12_trial / 128))*1.8
let sar12_previous = @VD_B6[pwl]
let sar12_stimulus = vector(8)
let sar12_stimulus[0] = 0
let sar12_stimulus[1] = sar12_previous[length(sar12_previous)-1]
let sar12_stimulus[2] = 9.60009999999999e-05
let sar12_stimulus[3] = sar12_stimulus[1]
let sar12_stimulus[4] = 9.60029999999999e-05
let sar12_stimulus[5] = sar12_drive
let sar12_stimulus[6] = 0.000148
let sar12_stimulus[7] = sar12_stimulus[5]
alter @VD_B6[pwl] = sar12_stimulus
let sar12_drive = (floor(sar12_trial / 128) - 2*floor(sar12_trial / 256))*1.8
let sar12_previous = @VD_B7[pwl]
let sar12_stimulus = vector(8)
let sar12_stimulus[0] = 0
let sar12_stimulus[1] = sar12_previous[length(sar12_previous)-1]
let sar12_stimulus[2] = 9.60009999999999e-05
let sar12_stimulus[3] = sar12_stimulus[1]
let sar12_stimulus[4] = 9.60029999999999e-05
let sar12_stimulus[5] = sar12_drive
let sar12_stimulus[6] = 0.000148
let sar12_stimulus[7] = sar12_stimulus[5]
alter @VD_B7[pwl] = sar12_stimulus
let sar12_drive = (floor(sar12_trial / 256) - 2*floor(sar12_trial / 512))*1.8
let sar12_previous = @VD_B8[pwl]
let sar12_stimulus = vector(8)
let sar12_stimulus[0] = 0
let sar12_stimulus[1] = sar12_previous[length(sar12_previous)-1]
let sar12_stimulus[2] = 9.60009999999999e-05
let sar12_stimulus[3] = sar12_stimulus[1]
let sar12_stimulus[4] = 9.60029999999999e-05
let sar12_stimulus[5] = sar12_drive
let sar12_stimulus[6] = 0.000148
let sar12_stimulus[7] = sar12_stimulus[5]
alter @VD_B8[pwl] = sar12_stimulus
let sar12_drive = (floor(sar12_trial / 512) - 2*floor(sar12_trial / 1024))*1.8
let sar12_previous = @VD_B9[pwl]
let sar12_stimulus = vector(8)
let sar12_stimulus[0] = 0
let sar12_stimulus[1] = sar12_previous[length(sar12_previous)-1]
let sar12_stimulus[2] = 9.60009999999999e-05
let sar12_stimulus[3] = sar12_stimulus[1]
let sar12_stimulus[4] = 9.60029999999999e-05
let sar12_stimulus[5] = sar12_drive
let sar12_stimulus[6] = 0.000148
let sar12_stimulus[7] = sar12_stimulus[5]
alter @VD_B9[pwl] = sar12_stimulus
let sar12_drive = (floor(sar12_trial / 1024) - 2*floor(sar12_trial / 2048))*1.8
let sar12_previous = @VD_B10[pwl]
let sar12_stimulus = vector(8)
let sar12_stimulus[0] = 0
let sar12_stimulus[1] = sar12_previous[length(sar12_previous)-1]
let sar12_stimulus[2] = 9.60009999999999e-05
let sar12_stimulus[3] = sar12_stimulus[1]
let sar12_stimulus[4] = 9.60029999999999e-05
let sar12_stimulus[5] = sar12_drive
let sar12_stimulus[6] = 0.000148
let sar12_stimulus[7] = sar12_stimulus[5]
alter @VD_B10[pwl] = sar12_stimulus
let sar12_drive = (floor(sar12_trial / 2048) - 2*floor(sar12_trial / 4096))*1.8
let sar12_previous = @VD_B11[pwl]
let sar12_stimulus = vector(8)
let sar12_stimulus[0] = 0
let sar12_stimulus[1] = sar12_previous[length(sar12_previous)-1]
let sar12_stimulus[2] = 9.60009999999999e-05
let sar12_stimulus[3] = sar12_stimulus[1]
let sar12_stimulus[4] = 9.60029999999999e-05
let sar12_stimulus[5] = sar12_drive
let sar12_stimulus[6] = 0.000148
let sar12_stimulus[7] = sar12_stimulus[5]
alter @VD_B11[pwl] = sar12_stimulus
let sar12_drive = (floor(sar12_trial / 4096) - 2*floor(sar12_trial / 8192))*1.8
let sar12_previous = @VD_B12[pwl]
let sar12_stimulus = vector(8)
let sar12_stimulus[0] = 0
let sar12_stimulus[1] = sar12_previous[length(sar12_previous)-1]
let sar12_stimulus[2] = 9.60009999999999e-05
let sar12_stimulus[3] = sar12_stimulus[1]
let sar12_stimulus[4] = 9.60029999999999e-05
let sar12_stimulus[5] = sar12_drive
let sar12_stimulus[6] = 0.000148
let sar12_stimulus[7] = sar12_stimulus[5]
alter @VD_B12[pwl] = sar12_stimulus
let sar12_drive = (floor(sar12_trial / 8192) - 2*floor(sar12_trial / 16384))*1.8
let sar12_previous = @VD_B13[pwl]
let sar12_stimulus = vector(8)
let sar12_stimulus[0] = 0
let sar12_stimulus[1] = sar12_previous[length(sar12_previous)-1]
let sar12_stimulus[2] = 9.60009999999999e-05
let sar12_stimulus[3] = sar12_stimulus[1]
let sar12_stimulus[4] = 9.60029999999999e-05
let sar12_stimulus[5] = sar12_drive
let sar12_stimulus[6] = 0.000148
let sar12_stimulus[7] = sar12_stimulus[5]
alter @VD_B13[pwl] = sar12_stimulus
let sar12_drive = (floor(sar12_trial / 16384) - 2*floor(sar12_trial / 32768))*1.8
let sar12_previous = @VD_B14[pwl]
let sar12_stimulus = vector(8)
let sar12_stimulus[0] = 0
let sar12_stimulus[1] = sar12_previous[length(sar12_previous)-1]
let sar12_stimulus[2] = 9.60009999999999e-05
let sar12_stimulus[3] = sar12_stimulus[1]
let sar12_stimulus[4] = 9.60029999999999e-05
let sar12_stimulus[5] = sar12_drive
let sar12_stimulus[6] = 0.000148
let sar12_stimulus[7] = sar12_stimulus[5]
alter @VD_B14[pwl] = sar12_stimulus
let sar12_drive = (floor(sar12_trial / 32768) - 2*floor(sar12_trial / 65536))*1.8
let sar12_previous = @VD_B15[pwl]
let sar12_stimulus = vector(8)
let sar12_stimulus[0] = 0
let sar12_stimulus[1] = sar12_previous[length(sar12_previous)-1]
let sar12_stimulus[2] = 9.60009999999999e-05
let sar12_stimulus[3] = sar12_stimulus[1]
let sar12_stimulus[4] = 9.60029999999999e-05
let sar12_stimulus[5] = sar12_drive
let sar12_stimulus[6] = 0.000148
let sar12_stimulus[7] = sar12_stimulus[5]
alter @VD_B15[pwl] = sar12_stimulus
resume
let sar12_k = length(time)-1
if abs(time[sar12_k] - 9.64999999999999e-05) > 1e-12
print time[sar12_k]
echo expected_pause_time_s 9.64999999999999e-05
echo SAR12_PAUSE_FAILED
quit 1
end
print time[sar12_k] >> pause-times.txt
let sar12_previous = @VD_EVAL[pwl]
let sar12_stimulus = vector(8)
let sar12_stimulus[0] = 0
let sar12_stimulus[1] = sar12_previous[length(sar12_previous)-1]
let sar12_stimulus[2] = 9.65009999999999e-05
let sar12_stimulus[3] = sar12_stimulus[1]
let sar12_stimulus[4] = 9.65029999999999e-05
let sar12_stimulus[5] = 1.8
let sar12_stimulus[6] = 0.000148
let sar12_stimulus[7] = sar12_stimulus[5]
alter @VD_EVAL[pwl] = sar12_stimulus
resume
let sar12_k = length(time)-1
if abs(time[sar12_k] - 9.69999999999999e-05) > 1e-12
print time[sar12_k]
echo expected_pause_time_s 9.69999999999999e-05
echo SAR12_PAUSE_FAILED
quit 1
end
print time[sar12_k] >> pause-times.txt
let sar12_k = length(time)-1
let sar12_cmp = v(COMP)[sar12_k]
let sar12_cmpn = v(COMPN)[sar12_k]
let sar12_p = v(TOPP)[sar12_k]
let sar12_n = v(TOPN)[sar12_k]
let sar12_decision = 0
if sar12_cmp >= 0.9
let sar12_code = sar12_trial
let sar12_decision = 1
end
echo 3 1 $&sar12_trial $&sar12_cmp $&sar12_cmpn $&sar12_p $&sar12_n -1.8310546875e-05 $&sar12_decision >> decisions.csv
let sar12_previous = @VD_EVAL[pwl]
let sar12_stimulus = vector(8)
let sar12_stimulus[0] = 0
let sar12_stimulus[1] = sar12_previous[length(sar12_previous)-1]
let sar12_stimulus[2] = 9.70009999999999e-05
let sar12_stimulus[3] = sar12_stimulus[1]
let sar12_stimulus[4] = 9.70029999999999e-05
let sar12_stimulus[5] = 0
let sar12_stimulus[6] = 0.000148
let sar12_stimulus[7] = sar12_stimulus[5]
alter @VD_EVAL[pwl] = sar12_stimulus
let sar12_trial = sar12_code + 1
let sar12_drive = (floor(sar12_trial / 1) - 2*floor(sar12_trial / 2))*1.8
let sar12_previous = @VD_B0[pwl]
let sar12_stimulus = vector(8)
let sar12_stimulus[0] = 0
let sar12_stimulus[1] = sar12_previous[length(sar12_previous)-1]
let sar12_stimulus[2] = 9.70009999999999e-05
let sar12_stimulus[3] = sar12_stimulus[1]
let sar12_stimulus[4] = 9.70029999999999e-05
let sar12_stimulus[5] = sar12_drive
let sar12_stimulus[6] = 0.000148
let sar12_stimulus[7] = sar12_stimulus[5]
alter @VD_B0[pwl] = sar12_stimulus
let sar12_drive = (floor(sar12_trial / 2) - 2*floor(sar12_trial / 4))*1.8
let sar12_previous = @VD_B1[pwl]
let sar12_stimulus = vector(8)
let sar12_stimulus[0] = 0
let sar12_stimulus[1] = sar12_previous[length(sar12_previous)-1]
let sar12_stimulus[2] = 9.70009999999999e-05
let sar12_stimulus[3] = sar12_stimulus[1]
let sar12_stimulus[4] = 9.70029999999999e-05
let sar12_stimulus[5] = sar12_drive
let sar12_stimulus[6] = 0.000148
let sar12_stimulus[7] = sar12_stimulus[5]
alter @VD_B1[pwl] = sar12_stimulus
let sar12_drive = (floor(sar12_trial / 4) - 2*floor(sar12_trial / 8))*1.8
let sar12_previous = @VD_B2[pwl]
let sar12_stimulus = vector(8)
let sar12_stimulus[0] = 0
let sar12_stimulus[1] = sar12_previous[length(sar12_previous)-1]
let sar12_stimulus[2] = 9.70009999999999e-05
let sar12_stimulus[3] = sar12_stimulus[1]
let sar12_stimulus[4] = 9.70029999999999e-05
let sar12_stimulus[5] = sar12_drive
let sar12_stimulus[6] = 0.000148
let sar12_stimulus[7] = sar12_stimulus[5]
alter @VD_B2[pwl] = sar12_stimulus
let sar12_drive = (floor(sar12_trial / 8) - 2*floor(sar12_trial / 16))*1.8
let sar12_previous = @VD_B3[pwl]
let sar12_stimulus = vector(8)
let sar12_stimulus[0] = 0
let sar12_stimulus[1] = sar12_previous[length(sar12_previous)-1]
let sar12_stimulus[2] = 9.70009999999999e-05
let sar12_stimulus[3] = sar12_stimulus[1]
let sar12_stimulus[4] = 9.70029999999999e-05
let sar12_stimulus[5] = sar12_drive
let sar12_stimulus[6] = 0.000148
let sar12_stimulus[7] = sar12_stimulus[5]
alter @VD_B3[pwl] = sar12_stimulus
let sar12_drive = (floor(sar12_trial / 16) - 2*floor(sar12_trial / 32))*1.8
let sar12_previous = @VD_B4[pwl]
let sar12_stimulus = vector(8)
let sar12_stimulus[0] = 0
let sar12_stimulus[1] = sar12_previous[length(sar12_previous)-1]
let sar12_stimulus[2] = 9.70009999999999e-05
let sar12_stimulus[3] = sar12_stimulus[1]
let sar12_stimulus[4] = 9.70029999999999e-05
let sar12_stimulus[5] = sar12_drive
let sar12_stimulus[6] = 0.000148
let sar12_stimulus[7] = sar12_stimulus[5]
alter @VD_B4[pwl] = sar12_stimulus
let sar12_drive = (floor(sar12_trial / 32) - 2*floor(sar12_trial / 64))*1.8
let sar12_previous = @VD_B5[pwl]
let sar12_stimulus = vector(8)
let sar12_stimulus[0] = 0
let sar12_stimulus[1] = sar12_previous[length(sar12_previous)-1]
let sar12_stimulus[2] = 9.70009999999999e-05
let sar12_stimulus[3] = sar12_stimulus[1]
let sar12_stimulus[4] = 9.70029999999999e-05
let sar12_stimulus[5] = sar12_drive
let sar12_stimulus[6] = 0.000148
let sar12_stimulus[7] = sar12_stimulus[5]
alter @VD_B5[pwl] = sar12_stimulus
let sar12_drive = (floor(sar12_trial / 64) - 2*floor(sar12_trial / 128))*1.8
let sar12_previous = @VD_B6[pwl]
let sar12_stimulus = vector(8)
let sar12_stimulus[0] = 0
let sar12_stimulus[1] = sar12_previous[length(sar12_previous)-1]
let sar12_stimulus[2] = 9.70009999999999e-05
let sar12_stimulus[3] = sar12_stimulus[1]
let sar12_stimulus[4] = 9.70029999999999e-05
let sar12_stimulus[5] = sar12_drive
let sar12_stimulus[6] = 0.000148
let sar12_stimulus[7] = sar12_stimulus[5]
alter @VD_B6[pwl] = sar12_stimulus
let sar12_drive = (floor(sar12_trial / 128) - 2*floor(sar12_trial / 256))*1.8
let sar12_previous = @VD_B7[pwl]
let sar12_stimulus = vector(8)
let sar12_stimulus[0] = 0
let sar12_stimulus[1] = sar12_previous[length(sar12_previous)-1]
let sar12_stimulus[2] = 9.70009999999999e-05
let sar12_stimulus[3] = sar12_stimulus[1]
let sar12_stimulus[4] = 9.70029999999999e-05
let sar12_stimulus[5] = sar12_drive
let sar12_stimulus[6] = 0.000148
let sar12_stimulus[7] = sar12_stimulus[5]
alter @VD_B7[pwl] = sar12_stimulus
let sar12_drive = (floor(sar12_trial / 256) - 2*floor(sar12_trial / 512))*1.8
let sar12_previous = @VD_B8[pwl]
let sar12_stimulus = vector(8)
let sar12_stimulus[0] = 0
let sar12_stimulus[1] = sar12_previous[length(sar12_previous)-1]
let sar12_stimulus[2] = 9.70009999999999e-05
let sar12_stimulus[3] = sar12_stimulus[1]
let sar12_stimulus[4] = 9.70029999999999e-05
let sar12_stimulus[5] = sar12_drive
let sar12_stimulus[6] = 0.000148
let sar12_stimulus[7] = sar12_stimulus[5]
alter @VD_B8[pwl] = sar12_stimulus
let sar12_drive = (floor(sar12_trial / 512) - 2*floor(sar12_trial / 1024))*1.8
let sar12_previous = @VD_B9[pwl]
let sar12_stimulus = vector(8)
let sar12_stimulus[0] = 0
let sar12_stimulus[1] = sar12_previous[length(sar12_previous)-1]
let sar12_stimulus[2] = 9.70009999999999e-05
let sar12_stimulus[3] = sar12_stimulus[1]
let sar12_stimulus[4] = 9.70029999999999e-05
let sar12_stimulus[5] = sar12_drive
let sar12_stimulus[6] = 0.000148
let sar12_stimulus[7] = sar12_stimulus[5]
alter @VD_B9[pwl] = sar12_stimulus
let sar12_drive = (floor(sar12_trial / 1024) - 2*floor(sar12_trial / 2048))*1.8
let sar12_previous = @VD_B10[pwl]
let sar12_stimulus = vector(8)
let sar12_stimulus[0] = 0
let sar12_stimulus[1] = sar12_previous[length(sar12_previous)-1]
let sar12_stimulus[2] = 9.70009999999999e-05
let sar12_stimulus[3] = sar12_stimulus[1]
let sar12_stimulus[4] = 9.70029999999999e-05
let sar12_stimulus[5] = sar12_drive
let sar12_stimulus[6] = 0.000148
let sar12_stimulus[7] = sar12_stimulus[5]
alter @VD_B10[pwl] = sar12_stimulus
let sar12_drive = (floor(sar12_trial / 2048) - 2*floor(sar12_trial / 4096))*1.8
let sar12_previous = @VD_B11[pwl]
let sar12_stimulus = vector(8)
let sar12_stimulus[0] = 0
let sar12_stimulus[1] = sar12_previous[length(sar12_previous)-1]
let sar12_stimulus[2] = 9.70009999999999e-05
let sar12_stimulus[3] = sar12_stimulus[1]
let sar12_stimulus[4] = 9.70029999999999e-05
let sar12_stimulus[5] = sar12_drive
let sar12_stimulus[6] = 0.000148
let sar12_stimulus[7] = sar12_stimulus[5]
alter @VD_B11[pwl] = sar12_stimulus
let sar12_drive = (floor(sar12_trial / 4096) - 2*floor(sar12_trial / 8192))*1.8
let sar12_previous = @VD_B12[pwl]
let sar12_stimulus = vector(8)
let sar12_stimulus[0] = 0
let sar12_stimulus[1] = sar12_previous[length(sar12_previous)-1]
let sar12_stimulus[2] = 9.70009999999999e-05
let sar12_stimulus[3] = sar12_stimulus[1]
let sar12_stimulus[4] = 9.70029999999999e-05
let sar12_stimulus[5] = sar12_drive
let sar12_stimulus[6] = 0.000148
let sar12_stimulus[7] = sar12_stimulus[5]
alter @VD_B12[pwl] = sar12_stimulus
let sar12_drive = (floor(sar12_trial / 8192) - 2*floor(sar12_trial / 16384))*1.8
let sar12_previous = @VD_B13[pwl]
let sar12_stimulus = vector(8)
let sar12_stimulus[0] = 0
let sar12_stimulus[1] = sar12_previous[length(sar12_previous)-1]
let sar12_stimulus[2] = 9.70009999999999e-05
let sar12_stimulus[3] = sar12_stimulus[1]
let sar12_stimulus[4] = 9.70029999999999e-05
let sar12_stimulus[5] = sar12_drive
let sar12_stimulus[6] = 0.000148
let sar12_stimulus[7] = sar12_stimulus[5]
alter @VD_B13[pwl] = sar12_stimulus
let sar12_drive = (floor(sar12_trial / 16384) - 2*floor(sar12_trial / 32768))*1.8
let sar12_previous = @VD_B14[pwl]
let sar12_stimulus = vector(8)
let sar12_stimulus[0] = 0
let sar12_stimulus[1] = sar12_previous[length(sar12_previous)-1]
let sar12_stimulus[2] = 9.70009999999999e-05
let sar12_stimulus[3] = sar12_stimulus[1]
let sar12_stimulus[4] = 9.70029999999999e-05
let sar12_stimulus[5] = sar12_drive
let sar12_stimulus[6] = 0.000148
let sar12_stimulus[7] = sar12_stimulus[5]
alter @VD_B14[pwl] = sar12_stimulus
let sar12_drive = (floor(sar12_trial / 32768) - 2*floor(sar12_trial / 65536))*1.8
let sar12_previous = @VD_B15[pwl]
let sar12_stimulus = vector(8)
let sar12_stimulus[0] = 0
let sar12_stimulus[1] = sar12_previous[length(sar12_previous)-1]
let sar12_stimulus[2] = 9.70009999999999e-05
let sar12_stimulus[3] = sar12_stimulus[1]
let sar12_stimulus[4] = 9.70029999999999e-05
let sar12_stimulus[5] = sar12_drive
let sar12_stimulus[6] = 0.000148
let sar12_stimulus[7] = sar12_stimulus[5]
alter @VD_B15[pwl] = sar12_stimulus
resume
let sar12_k = length(time)-1
if abs(time[sar12_k] - 9.74999999999998e-05) > 1e-12
print time[sar12_k]
echo expected_pause_time_s 9.74999999999998e-05
echo SAR12_PAUSE_FAILED
quit 1
end
print time[sar12_k] >> pause-times.txt
let sar12_previous = @VD_EVAL[pwl]
let sar12_stimulus = vector(8)
let sar12_stimulus[0] = 0
let sar12_stimulus[1] = sar12_previous[length(sar12_previous)-1]
let sar12_stimulus[2] = 9.75009999999999e-05
let sar12_stimulus[3] = sar12_stimulus[1]
let sar12_stimulus[4] = 9.75029999999999e-05
let sar12_stimulus[5] = 1.8
let sar12_stimulus[6] = 0.000148
let sar12_stimulus[7] = sar12_stimulus[5]
alter @VD_EVAL[pwl] = sar12_stimulus
resume
let sar12_k = length(time)-1
if abs(time[sar12_k] - 9.79999999999998e-05) > 1e-12
print time[sar12_k]
echo expected_pause_time_s 9.79999999999998e-05
echo SAR12_PAUSE_FAILED
quit 1
end
print time[sar12_k] >> pause-times.txt
let sar12_k = length(time)-1
let sar12_cmp = v(COMP)[sar12_k]
let sar12_cmpn = v(COMPN)[sar12_k]
let sar12_p = v(TOPP)[sar12_k]
let sar12_n = v(TOPN)[sar12_k]
let sar12_decision = 0
if sar12_cmp >= 0.9
let sar12_code = sar12_trial
let sar12_decision = 1
end
echo 3 0 $&sar12_trial $&sar12_cmp $&sar12_cmpn $&sar12_p $&sar12_n -1.8310546875e-05 $&sar12_decision >> decisions.csv
let sar12_previous = @VD_EVAL[pwl]
let sar12_stimulus = vector(8)
let sar12_stimulus[0] = 0
let sar12_stimulus[1] = sar12_previous[length(sar12_previous)-1]
let sar12_stimulus[2] = 9.80009999999998e-05
let sar12_stimulus[3] = sar12_stimulus[1]
let sar12_stimulus[4] = 9.80029999999999e-05
let sar12_stimulus[5] = 0
let sar12_stimulus[6] = 0.000148
let sar12_stimulus[7] = sar12_stimulus[5]
alter @VD_EVAL[pwl] = sar12_stimulus
let sar12_previous = @VINP[pwl]
let sar12_stimulus = vector(8)
let sar12_stimulus[0] = 0
let sar12_stimulus[1] = sar12_previous[length(sar12_previous)-1]
let sar12_stimulus[2] = 9.80009999999998e-05
let sar12_stimulus[3] = sar12_stimulus[1]
let sar12_stimulus[4] = 9.80029999999999e-05
let sar12_stimulus[5] = 1.49997253418
let sar12_stimulus[6] = 0.000148
let sar12_stimulus[7] = sar12_stimulus[5]
alter @VINP[pwl] = sar12_stimulus
let sar12_previous = @VINN[pwl]
let sar12_stimulus = vector(8)
let sar12_stimulus[0] = 0
let sar12_stimulus[1] = sar12_previous[length(sar12_previous)-1]
let sar12_stimulus[2] = 9.80009999999998e-05
let sar12_stimulus[3] = sar12_stimulus[1]
let sar12_stimulus[4] = 9.80029999999999e-05
let sar12_stimulus[5] = 0.30002746582
let sar12_stimulus[6] = 0.000148
let sar12_stimulus[7] = sar12_stimulus[5]
alter @VINN[pwl] = sar12_stimulus
let sar12_previous = @VD_SAMPLE[pwl]
let sar12_stimulus = vector(8)
let sar12_stimulus[0] = 0
let sar12_stimulus[1] = sar12_previous[length(sar12_previous)-1]
let sar12_stimulus[2] = 9.80009999999998e-05
let sar12_stimulus[3] = sar12_stimulus[1]
let sar12_stimulus[4] = 9.80029999999999e-05
let sar12_stimulus[5] = 1.8
let sar12_stimulus[6] = 0.000148
let sar12_stimulus[7] = sar12_stimulus[5]
alter @VD_SAMPLE[pwl] = sar12_stimulus
let sar12_previous = @VD_EVAL[pwl]
let sar12_stimulus = vector(8)
let sar12_stimulus[0] = 0
let sar12_stimulus[1] = sar12_previous[length(sar12_previous)-1]
let sar12_stimulus[2] = 9.80009999999998e-05
let sar12_stimulus[3] = sar12_stimulus[1]
let sar12_stimulus[4] = 9.80029999999999e-05
let sar12_stimulus[5] = 0
let sar12_stimulus[6] = 0.000148
let sar12_stimulus[7] = sar12_stimulus[5]
alter @VD_EVAL[pwl] = sar12_stimulus
let sar12_previous = @VD_B0[pwl]
let sar12_stimulus = vector(8)
let sar12_stimulus[0] = 0
let sar12_stimulus[1] = sar12_previous[length(sar12_previous)-1]
let sar12_stimulus[2] = 9.80009999999998e-05
let sar12_stimulus[3] = sar12_stimulus[1]
let sar12_stimulus[4] = 9.80029999999999e-05
let sar12_stimulus[5] = 0
let sar12_stimulus[6] = 0.000148
let sar12_stimulus[7] = sar12_stimulus[5]
alter @VD_B0[pwl] = sar12_stimulus
let sar12_previous = @VD_B1[pwl]
let sar12_stimulus = vector(8)
let sar12_stimulus[0] = 0
let sar12_stimulus[1] = sar12_previous[length(sar12_previous)-1]
let sar12_stimulus[2] = 9.80009999999998e-05
let sar12_stimulus[3] = sar12_stimulus[1]
let sar12_stimulus[4] = 9.80029999999999e-05
let sar12_stimulus[5] = 0
let sar12_stimulus[6] = 0.000148
let sar12_stimulus[7] = sar12_stimulus[5]
alter @VD_B1[pwl] = sar12_stimulus
let sar12_previous = @VD_B2[pwl]
let sar12_stimulus = vector(8)
let sar12_stimulus[0] = 0
let sar12_stimulus[1] = sar12_previous[length(sar12_previous)-1]
let sar12_stimulus[2] = 9.80009999999998e-05
let sar12_stimulus[3] = sar12_stimulus[1]
let sar12_stimulus[4] = 9.80029999999999e-05
let sar12_stimulus[5] = 0
let sar12_stimulus[6] = 0.000148
let sar12_stimulus[7] = sar12_stimulus[5]
alter @VD_B2[pwl] = sar12_stimulus
let sar12_previous = @VD_B3[pwl]
let sar12_stimulus = vector(8)
let sar12_stimulus[0] = 0
let sar12_stimulus[1] = sar12_previous[length(sar12_previous)-1]
let sar12_stimulus[2] = 9.80009999999998e-05
let sar12_stimulus[3] = sar12_stimulus[1]
let sar12_stimulus[4] = 9.80029999999999e-05
let sar12_stimulus[5] = 0
let sar12_stimulus[6] = 0.000148
let sar12_stimulus[7] = sar12_stimulus[5]
alter @VD_B3[pwl] = sar12_stimulus
let sar12_previous = @VD_B4[pwl]
let sar12_stimulus = vector(8)
let sar12_stimulus[0] = 0
let sar12_stimulus[1] = sar12_previous[length(sar12_previous)-1]
let sar12_stimulus[2] = 9.80009999999998e-05
let sar12_stimulus[3] = sar12_stimulus[1]
let sar12_stimulus[4] = 9.80029999999999e-05
let sar12_stimulus[5] = 0
let sar12_stimulus[6] = 0.000148
let sar12_stimulus[7] = sar12_stimulus[5]
alter @VD_B4[pwl] = sar12_stimulus
let sar12_previous = @VD_B5[pwl]
let sar12_stimulus = vector(8)
let sar12_stimulus[0] = 0
let sar12_stimulus[1] = sar12_previous[length(sar12_previous)-1]
let sar12_stimulus[2] = 9.80009999999998e-05
let sar12_stimulus[3] = sar12_stimulus[1]
let sar12_stimulus[4] = 9.80029999999999e-05
let sar12_stimulus[5] = 0
let sar12_stimulus[6] = 0.000148
let sar12_stimulus[7] = sar12_stimulus[5]
alter @VD_B5[pwl] = sar12_stimulus
let sar12_previous = @VD_B6[pwl]
let sar12_stimulus = vector(8)
let sar12_stimulus[0] = 0
let sar12_stimulus[1] = sar12_previous[length(sar12_previous)-1]
let sar12_stimulus[2] = 9.80009999999998e-05
let sar12_stimulus[3] = sar12_stimulus[1]
let sar12_stimulus[4] = 9.80029999999999e-05
let sar12_stimulus[5] = 0
let sar12_stimulus[6] = 0.000148
let sar12_stimulus[7] = sar12_stimulus[5]
alter @VD_B6[pwl] = sar12_stimulus
let sar12_previous = @VD_B7[pwl]
let sar12_stimulus = vector(8)
let sar12_stimulus[0] = 0
let sar12_stimulus[1] = sar12_previous[length(sar12_previous)-1]
let sar12_stimulus[2] = 9.80009999999998e-05
let sar12_stimulus[3] = sar12_stimulus[1]
let sar12_stimulus[4] = 9.80029999999999e-05
let sar12_stimulus[5] = 0
let sar12_stimulus[6] = 0.000148
let sar12_stimulus[7] = sar12_stimulus[5]
alter @VD_B7[pwl] = sar12_stimulus
let sar12_previous = @VD_B8[pwl]
let sar12_stimulus = vector(8)
let sar12_stimulus[0] = 0
let sar12_stimulus[1] = sar12_previous[length(sar12_previous)-1]
let sar12_stimulus[2] = 9.80009999999998e-05
let sar12_stimulus[3] = sar12_stimulus[1]
let sar12_stimulus[4] = 9.80029999999999e-05
let sar12_stimulus[5] = 0
let sar12_stimulus[6] = 0.000148
let sar12_stimulus[7] = sar12_stimulus[5]
alter @VD_B8[pwl] = sar12_stimulus
let sar12_previous = @VD_B9[pwl]
let sar12_stimulus = vector(8)
let sar12_stimulus[0] = 0
let sar12_stimulus[1] = sar12_previous[length(sar12_previous)-1]
let sar12_stimulus[2] = 9.80009999999998e-05
let sar12_stimulus[3] = sar12_stimulus[1]
let sar12_stimulus[4] = 9.80029999999999e-05
let sar12_stimulus[5] = 0
let sar12_stimulus[6] = 0.000148
let sar12_stimulus[7] = sar12_stimulus[5]
alter @VD_B9[pwl] = sar12_stimulus
let sar12_previous = @VD_B10[pwl]
let sar12_stimulus = vector(8)
let sar12_stimulus[0] = 0
let sar12_stimulus[1] = sar12_previous[length(sar12_previous)-1]
let sar12_stimulus[2] = 9.80009999999998e-05
let sar12_stimulus[3] = sar12_stimulus[1]
let sar12_stimulus[4] = 9.80029999999999e-05
let sar12_stimulus[5] = 0
let sar12_stimulus[6] = 0.000148
let sar12_stimulus[7] = sar12_stimulus[5]
alter @VD_B10[pwl] = sar12_stimulus
let sar12_previous = @VD_B11[pwl]
let sar12_stimulus = vector(8)
let sar12_stimulus[0] = 0
let sar12_stimulus[1] = sar12_previous[length(sar12_previous)-1]
let sar12_stimulus[2] = 9.80009999999998e-05
let sar12_stimulus[3] = sar12_stimulus[1]
let sar12_stimulus[4] = 9.80029999999999e-05
let sar12_stimulus[5] = 0
let sar12_stimulus[6] = 0.000148
let sar12_stimulus[7] = sar12_stimulus[5]
alter @VD_B11[pwl] = sar12_stimulus
let sar12_previous = @VD_B12[pwl]
let sar12_stimulus = vector(8)
let sar12_stimulus[0] = 0
let sar12_stimulus[1] = sar12_previous[length(sar12_previous)-1]
let sar12_stimulus[2] = 9.80009999999998e-05
let sar12_stimulus[3] = sar12_stimulus[1]
let sar12_stimulus[4] = 9.80029999999999e-05
let sar12_stimulus[5] = 0
let sar12_stimulus[6] = 0.000148
let sar12_stimulus[7] = sar12_stimulus[5]
alter @VD_B12[pwl] = sar12_stimulus
let sar12_previous = @VD_B13[pwl]
let sar12_stimulus = vector(8)
let sar12_stimulus[0] = 0
let sar12_stimulus[1] = sar12_previous[length(sar12_previous)-1]
let sar12_stimulus[2] = 9.80009999999998e-05
let sar12_stimulus[3] = sar12_stimulus[1]
let sar12_stimulus[4] = 9.80029999999999e-05
let sar12_stimulus[5] = 0
let sar12_stimulus[6] = 0.000148
let sar12_stimulus[7] = sar12_stimulus[5]
alter @VD_B13[pwl] = sar12_stimulus
let sar12_previous = @VD_B14[pwl]
let sar12_stimulus = vector(8)
let sar12_stimulus[0] = 0
let sar12_stimulus[1] = sar12_previous[length(sar12_previous)-1]
let sar12_stimulus[2] = 9.80009999999998e-05
let sar12_stimulus[3] = sar12_stimulus[1]
let sar12_stimulus[4] = 9.80029999999999e-05
let sar12_stimulus[5] = 0
let sar12_stimulus[6] = 0.000148
let sar12_stimulus[7] = sar12_stimulus[5]
alter @VD_B14[pwl] = sar12_stimulus
let sar12_previous = @VD_B15[pwl]
let sar12_stimulus = vector(8)
let sar12_stimulus[0] = 0
let sar12_stimulus[1] = sar12_previous[length(sar12_previous)-1]
let sar12_stimulus[2] = 9.80009999999998e-05
let sar12_stimulus[3] = sar12_stimulus[1]
let sar12_stimulus[4] = 9.80029999999999e-05
let sar12_stimulus[5] = 0
let sar12_stimulus[6] = 0.000148
let sar12_stimulus[7] = sar12_stimulus[5]
alter @VD_B15[pwl] = sar12_stimulus
let sar12_code = 0
resume
let sar12_k = length(time)-1
if abs(time[sar12_k] - 0.000106) > 1e-12
print time[sar12_k]
echo expected_pause_time_s 0.000106
echo SAR12_PAUSE_FAILED
quit 1
end
print time[sar12_k] >> pause-times.txt
let sar12_previous = @VD_SAMPLE[pwl]
let sar12_stimulus = vector(8)
let sar12_stimulus[0] = 0
let sar12_stimulus[1] = sar12_previous[length(sar12_previous)-1]
let sar12_stimulus[2] = 0.000106001
let sar12_stimulus[3] = sar12_stimulus[1]
let sar12_stimulus[4] = 0.000106003
let sar12_stimulus[5] = 0
let sar12_stimulus[6] = 0.000148
let sar12_stimulus[7] = sar12_stimulus[5]
alter @VD_SAMPLE[pwl] = sar12_stimulus
resume
let sar12_k = length(time)-1
if abs(time[sar12_k] - 0.0001065) > 1e-12
print time[sar12_k]
echo expected_pause_time_s 0.0001065
echo SAR12_PAUSE_FAILED
quit 1
end
print time[sar12_k] >> pause-times.txt
let sar12_previous = @VD_EVAL[pwl]
let sar12_stimulus = vector(8)
let sar12_stimulus[0] = 0
let sar12_stimulus[1] = sar12_previous[length(sar12_previous)-1]
let sar12_stimulus[2] = 0.000106501
let sar12_stimulus[3] = sar12_stimulus[1]
let sar12_stimulus[4] = 0.000106503
let sar12_stimulus[5] = 0
let sar12_stimulus[6] = 0.000148
let sar12_stimulus[7] = sar12_stimulus[5]
alter @VD_EVAL[pwl] = sar12_stimulus
let sar12_trial = sar12_code + 32768
let sar12_drive = (floor(sar12_trial / 1) - 2*floor(sar12_trial / 2))*1.8
let sar12_previous = @VD_B0[pwl]
let sar12_stimulus = vector(8)
let sar12_stimulus[0] = 0
let sar12_stimulus[1] = sar12_previous[length(sar12_previous)-1]
let sar12_stimulus[2] = 0.000106501
let sar12_stimulus[3] = sar12_stimulus[1]
let sar12_stimulus[4] = 0.000106503
let sar12_stimulus[5] = sar12_drive
let sar12_stimulus[6] = 0.000148
let sar12_stimulus[7] = sar12_stimulus[5]
alter @VD_B0[pwl] = sar12_stimulus
let sar12_drive = (floor(sar12_trial / 2) - 2*floor(sar12_trial / 4))*1.8
let sar12_previous = @VD_B1[pwl]
let sar12_stimulus = vector(8)
let sar12_stimulus[0] = 0
let sar12_stimulus[1] = sar12_previous[length(sar12_previous)-1]
let sar12_stimulus[2] = 0.000106501
let sar12_stimulus[3] = sar12_stimulus[1]
let sar12_stimulus[4] = 0.000106503
let sar12_stimulus[5] = sar12_drive
let sar12_stimulus[6] = 0.000148
let sar12_stimulus[7] = sar12_stimulus[5]
alter @VD_B1[pwl] = sar12_stimulus
let sar12_drive = (floor(sar12_trial / 4) - 2*floor(sar12_trial / 8))*1.8
let sar12_previous = @VD_B2[pwl]
let sar12_stimulus = vector(8)
let sar12_stimulus[0] = 0
let sar12_stimulus[1] = sar12_previous[length(sar12_previous)-1]
let sar12_stimulus[2] = 0.000106501
let sar12_stimulus[3] = sar12_stimulus[1]
let sar12_stimulus[4] = 0.000106503
let sar12_stimulus[5] = sar12_drive
let sar12_stimulus[6] = 0.000148
let sar12_stimulus[7] = sar12_stimulus[5]
alter @VD_B2[pwl] = sar12_stimulus
let sar12_drive = (floor(sar12_trial / 8) - 2*floor(sar12_trial / 16))*1.8
let sar12_previous = @VD_B3[pwl]
let sar12_stimulus = vector(8)
let sar12_stimulus[0] = 0
let sar12_stimulus[1] = sar12_previous[length(sar12_previous)-1]
let sar12_stimulus[2] = 0.000106501
let sar12_stimulus[3] = sar12_stimulus[1]
let sar12_stimulus[4] = 0.000106503
let sar12_stimulus[5] = sar12_drive
let sar12_stimulus[6] = 0.000148
let sar12_stimulus[7] = sar12_stimulus[5]
alter @VD_B3[pwl] = sar12_stimulus
let sar12_drive = (floor(sar12_trial / 16) - 2*floor(sar12_trial / 32))*1.8
let sar12_previous = @VD_B4[pwl]
let sar12_stimulus = vector(8)
let sar12_stimulus[0] = 0
let sar12_stimulus[1] = sar12_previous[length(sar12_previous)-1]
let sar12_stimulus[2] = 0.000106501
let sar12_stimulus[3] = sar12_stimulus[1]
let sar12_stimulus[4] = 0.000106503
let sar12_stimulus[5] = sar12_drive
let sar12_stimulus[6] = 0.000148
let sar12_stimulus[7] = sar12_stimulus[5]
alter @VD_B4[pwl] = sar12_stimulus
let sar12_drive = (floor(sar12_trial / 32) - 2*floor(sar12_trial / 64))*1.8
let sar12_previous = @VD_B5[pwl]
let sar12_stimulus = vector(8)
let sar12_stimulus[0] = 0
let sar12_stimulus[1] = sar12_previous[length(sar12_previous)-1]
let sar12_stimulus[2] = 0.000106501
let sar12_stimulus[3] = sar12_stimulus[1]
let sar12_stimulus[4] = 0.000106503
let sar12_stimulus[5] = sar12_drive
let sar12_stimulus[6] = 0.000148
let sar12_stimulus[7] = sar12_stimulus[5]
alter @VD_B5[pwl] = sar12_stimulus
let sar12_drive = (floor(sar12_trial / 64) - 2*floor(sar12_trial / 128))*1.8
let sar12_previous = @VD_B6[pwl]
let sar12_stimulus = vector(8)
let sar12_stimulus[0] = 0
let sar12_stimulus[1] = sar12_previous[length(sar12_previous)-1]
let sar12_stimulus[2] = 0.000106501
let sar12_stimulus[3] = sar12_stimulus[1]
let sar12_stimulus[4] = 0.000106503
let sar12_stimulus[5] = sar12_drive
let sar12_stimulus[6] = 0.000148
let sar12_stimulus[7] = sar12_stimulus[5]
alter @VD_B6[pwl] = sar12_stimulus
let sar12_drive = (floor(sar12_trial / 128) - 2*floor(sar12_trial / 256))*1.8
let sar12_previous = @VD_B7[pwl]
let sar12_stimulus = vector(8)
let sar12_stimulus[0] = 0
let sar12_stimulus[1] = sar12_previous[length(sar12_previous)-1]
let sar12_stimulus[2] = 0.000106501
let sar12_stimulus[3] = sar12_stimulus[1]
let sar12_stimulus[4] = 0.000106503
let sar12_stimulus[5] = sar12_drive
let sar12_stimulus[6] = 0.000148
let sar12_stimulus[7] = sar12_stimulus[5]
alter @VD_B7[pwl] = sar12_stimulus
let sar12_drive = (floor(sar12_trial / 256) - 2*floor(sar12_trial / 512))*1.8
let sar12_previous = @VD_B8[pwl]
let sar12_stimulus = vector(8)
let sar12_stimulus[0] = 0
let sar12_stimulus[1] = sar12_previous[length(sar12_previous)-1]
let sar12_stimulus[2] = 0.000106501
let sar12_stimulus[3] = sar12_stimulus[1]
let sar12_stimulus[4] = 0.000106503
let sar12_stimulus[5] = sar12_drive
let sar12_stimulus[6] = 0.000148
let sar12_stimulus[7] = sar12_stimulus[5]
alter @VD_B8[pwl] = sar12_stimulus
let sar12_drive = (floor(sar12_trial / 512) - 2*floor(sar12_trial / 1024))*1.8
let sar12_previous = @VD_B9[pwl]
let sar12_stimulus = vector(8)
let sar12_stimulus[0] = 0
let sar12_stimulus[1] = sar12_previous[length(sar12_previous)-1]
let sar12_stimulus[2] = 0.000106501
let sar12_stimulus[3] = sar12_stimulus[1]
let sar12_stimulus[4] = 0.000106503
let sar12_stimulus[5] = sar12_drive
let sar12_stimulus[6] = 0.000148
let sar12_stimulus[7] = sar12_stimulus[5]
alter @VD_B9[pwl] = sar12_stimulus
let sar12_drive = (floor(sar12_trial / 1024) - 2*floor(sar12_trial / 2048))*1.8
let sar12_previous = @VD_B10[pwl]
let sar12_stimulus = vector(8)
let sar12_stimulus[0] = 0
let sar12_stimulus[1] = sar12_previous[length(sar12_previous)-1]
let sar12_stimulus[2] = 0.000106501
let sar12_stimulus[3] = sar12_stimulus[1]
let sar12_stimulus[4] = 0.000106503
let sar12_stimulus[5] = sar12_drive
let sar12_stimulus[6] = 0.000148
let sar12_stimulus[7] = sar12_stimulus[5]
alter @VD_B10[pwl] = sar12_stimulus
let sar12_drive = (floor(sar12_trial / 2048) - 2*floor(sar12_trial / 4096))*1.8
let sar12_previous = @VD_B11[pwl]
let sar12_stimulus = vector(8)
let sar12_stimulus[0] = 0
let sar12_stimulus[1] = sar12_previous[length(sar12_previous)-1]
let sar12_stimulus[2] = 0.000106501
let sar12_stimulus[3] = sar12_stimulus[1]
let sar12_stimulus[4] = 0.000106503
let sar12_stimulus[5] = sar12_drive
let sar12_stimulus[6] = 0.000148
let sar12_stimulus[7] = sar12_stimulus[5]
alter @VD_B11[pwl] = sar12_stimulus
let sar12_drive = (floor(sar12_trial / 4096) - 2*floor(sar12_trial / 8192))*1.8
let sar12_previous = @VD_B12[pwl]
let sar12_stimulus = vector(8)
let sar12_stimulus[0] = 0
let sar12_stimulus[1] = sar12_previous[length(sar12_previous)-1]
let sar12_stimulus[2] = 0.000106501
let sar12_stimulus[3] = sar12_stimulus[1]
let sar12_stimulus[4] = 0.000106503
let sar12_stimulus[5] = sar12_drive
let sar12_stimulus[6] = 0.000148
let sar12_stimulus[7] = sar12_stimulus[5]
alter @VD_B12[pwl] = sar12_stimulus
let sar12_drive = (floor(sar12_trial / 8192) - 2*floor(sar12_trial / 16384))*1.8
let sar12_previous = @VD_B13[pwl]
let sar12_stimulus = vector(8)
let sar12_stimulus[0] = 0
let sar12_stimulus[1] = sar12_previous[length(sar12_previous)-1]
let sar12_stimulus[2] = 0.000106501
let sar12_stimulus[3] = sar12_stimulus[1]
let sar12_stimulus[4] = 0.000106503
let sar12_stimulus[5] = sar12_drive
let sar12_stimulus[6] = 0.000148
let sar12_stimulus[7] = sar12_stimulus[5]
alter @VD_B13[pwl] = sar12_stimulus
let sar12_drive = (floor(sar12_trial / 16384) - 2*floor(sar12_trial / 32768))*1.8
let sar12_previous = @VD_B14[pwl]
let sar12_stimulus = vector(8)
let sar12_stimulus[0] = 0
let sar12_stimulus[1] = sar12_previous[length(sar12_previous)-1]
let sar12_stimulus[2] = 0.000106501
let sar12_stimulus[3] = sar12_stimulus[1]
let sar12_stimulus[4] = 0.000106503
let sar12_stimulus[5] = sar12_drive
let sar12_stimulus[6] = 0.000148
let sar12_stimulus[7] = sar12_stimulus[5]
alter @VD_B14[pwl] = sar12_stimulus
let sar12_drive = (floor(sar12_trial / 32768) - 2*floor(sar12_trial / 65536))*1.8
let sar12_previous = @VD_B15[pwl]
let sar12_stimulus = vector(8)
let sar12_stimulus[0] = 0
let sar12_stimulus[1] = sar12_previous[length(sar12_previous)-1]
let sar12_stimulus[2] = 0.000106501
let sar12_stimulus[3] = sar12_stimulus[1]
let sar12_stimulus[4] = 0.000106503
let sar12_stimulus[5] = sar12_drive
let sar12_stimulus[6] = 0.000148
let sar12_stimulus[7] = sar12_stimulus[5]
alter @VD_B15[pwl] = sar12_stimulus
resume
let sar12_k = length(time)-1
if abs(time[sar12_k] - 0.000107) > 1e-12
print time[sar12_k]
echo expected_pause_time_s 0.000107
echo SAR12_PAUSE_FAILED
quit 1
end
print time[sar12_k] >> pause-times.txt
let sar12_previous = @VD_EVAL[pwl]
let sar12_stimulus = vector(8)
let sar12_stimulus[0] = 0
let sar12_stimulus[1] = sar12_previous[length(sar12_previous)-1]
let sar12_stimulus[2] = 0.000107001
let sar12_stimulus[3] = sar12_stimulus[1]
let sar12_stimulus[4] = 0.000107003
let sar12_stimulus[5] = 1.8
let sar12_stimulus[6] = 0.000148
let sar12_stimulus[7] = sar12_stimulus[5]
alter @VD_EVAL[pwl] = sar12_stimulus
resume
let sar12_k = length(time)-1
if abs(time[sar12_k] - 0.0001075) > 1e-12
print time[sar12_k]
echo expected_pause_time_s 0.0001075
echo SAR12_PAUSE_FAILED
quit 1
end
print time[sar12_k] >> pause-times.txt
let sar12_k = length(time)-1
let sar12_cmp = v(COMP)[sar12_k]
let sar12_cmpn = v(COMPN)[sar12_k]
let sar12_p = v(TOPP)[sar12_k]
let sar12_n = v(TOPN)[sar12_k]
let sar12_decision = 0
if sar12_cmp >= 0.9
let sar12_code = sar12_trial
let sar12_decision = 1
end
echo 4 15 $&sar12_trial $&sar12_cmp $&sar12_cmpn $&sar12_p $&sar12_n 1.19994506835937 $&sar12_decision >> decisions.csv
let sar12_previous = @VD_EVAL[pwl]
let sar12_stimulus = vector(8)
let sar12_stimulus[0] = 0
let sar12_stimulus[1] = sar12_previous[length(sar12_previous)-1]
let sar12_stimulus[2] = 0.000107501
let sar12_stimulus[3] = sar12_stimulus[1]
let sar12_stimulus[4] = 0.000107503
let sar12_stimulus[5] = 0
let sar12_stimulus[6] = 0.000148
let sar12_stimulus[7] = sar12_stimulus[5]
alter @VD_EVAL[pwl] = sar12_stimulus
let sar12_trial = sar12_code + 16384
let sar12_drive = (floor(sar12_trial / 1) - 2*floor(sar12_trial / 2))*1.8
let sar12_previous = @VD_B0[pwl]
let sar12_stimulus = vector(8)
let sar12_stimulus[0] = 0
let sar12_stimulus[1] = sar12_previous[length(sar12_previous)-1]
let sar12_stimulus[2] = 0.000107501
let sar12_stimulus[3] = sar12_stimulus[1]
let sar12_stimulus[4] = 0.000107503
let sar12_stimulus[5] = sar12_drive
let sar12_stimulus[6] = 0.000148
let sar12_stimulus[7] = sar12_stimulus[5]
alter @VD_B0[pwl] = sar12_stimulus
let sar12_drive = (floor(sar12_trial / 2) - 2*floor(sar12_trial / 4))*1.8
let sar12_previous = @VD_B1[pwl]
let sar12_stimulus = vector(8)
let sar12_stimulus[0] = 0
let sar12_stimulus[1] = sar12_previous[length(sar12_previous)-1]
let sar12_stimulus[2] = 0.000107501
let sar12_stimulus[3] = sar12_stimulus[1]
let sar12_stimulus[4] = 0.000107503
let sar12_stimulus[5] = sar12_drive
let sar12_stimulus[6] = 0.000148
let sar12_stimulus[7] = sar12_stimulus[5]
alter @VD_B1[pwl] = sar12_stimulus
let sar12_drive = (floor(sar12_trial / 4) - 2*floor(sar12_trial / 8))*1.8
let sar12_previous = @VD_B2[pwl]
let sar12_stimulus = vector(8)
let sar12_stimulus[0] = 0
let sar12_stimulus[1] = sar12_previous[length(sar12_previous)-1]
let sar12_stimulus[2] = 0.000107501
let sar12_stimulus[3] = sar12_stimulus[1]
let sar12_stimulus[4] = 0.000107503
let sar12_stimulus[5] = sar12_drive
let sar12_stimulus[6] = 0.000148
let sar12_stimulus[7] = sar12_stimulus[5]
alter @VD_B2[pwl] = sar12_stimulus
let sar12_drive = (floor(sar12_trial / 8) - 2*floor(sar12_trial / 16))*1.8
let sar12_previous = @VD_B3[pwl]
let sar12_stimulus = vector(8)
let sar12_stimulus[0] = 0
let sar12_stimulus[1] = sar12_previous[length(sar12_previous)-1]
let sar12_stimulus[2] = 0.000107501
let sar12_stimulus[3] = sar12_stimulus[1]
let sar12_stimulus[4] = 0.000107503
let sar12_stimulus[5] = sar12_drive
let sar12_stimulus[6] = 0.000148
let sar12_stimulus[7] = sar12_stimulus[5]
alter @VD_B3[pwl] = sar12_stimulus
let sar12_drive = (floor(sar12_trial / 16) - 2*floor(sar12_trial / 32))*1.8
let sar12_previous = @VD_B4[pwl]
let sar12_stimulus = vector(8)
let sar12_stimulus[0] = 0
let sar12_stimulus[1] = sar12_previous[length(sar12_previous)-1]
let sar12_stimulus[2] = 0.000107501
let sar12_stimulus[3] = sar12_stimulus[1]
let sar12_stimulus[4] = 0.000107503
let sar12_stimulus[5] = sar12_drive
let sar12_stimulus[6] = 0.000148
let sar12_stimulus[7] = sar12_stimulus[5]
alter @VD_B4[pwl] = sar12_stimulus
let sar12_drive = (floor(sar12_trial / 32) - 2*floor(sar12_trial / 64))*1.8
let sar12_previous = @VD_B5[pwl]
let sar12_stimulus = vector(8)
let sar12_stimulus[0] = 0
let sar12_stimulus[1] = sar12_previous[length(sar12_previous)-1]
let sar12_stimulus[2] = 0.000107501
let sar12_stimulus[3] = sar12_stimulus[1]
let sar12_stimulus[4] = 0.000107503
let sar12_stimulus[5] = sar12_drive
let sar12_stimulus[6] = 0.000148
let sar12_stimulus[7] = sar12_stimulus[5]
alter @VD_B5[pwl] = sar12_stimulus
let sar12_drive = (floor(sar12_trial / 64) - 2*floor(sar12_trial / 128))*1.8
let sar12_previous = @VD_B6[pwl]
let sar12_stimulus = vector(8)
let sar12_stimulus[0] = 0
let sar12_stimulus[1] = sar12_previous[length(sar12_previous)-1]
let sar12_stimulus[2] = 0.000107501
let sar12_stimulus[3] = sar12_stimulus[1]
let sar12_stimulus[4] = 0.000107503
let sar12_stimulus[5] = sar12_drive
let sar12_stimulus[6] = 0.000148
let sar12_stimulus[7] = sar12_stimulus[5]
alter @VD_B6[pwl] = sar12_stimulus
let sar12_drive = (floor(sar12_trial / 128) - 2*floor(sar12_trial / 256))*1.8
let sar12_previous = @VD_B7[pwl]
let sar12_stimulus = vector(8)
let sar12_stimulus[0] = 0
let sar12_stimulus[1] = sar12_previous[length(sar12_previous)-1]
let sar12_stimulus[2] = 0.000107501
let sar12_stimulus[3] = sar12_stimulus[1]
let sar12_stimulus[4] = 0.000107503
let sar12_stimulus[5] = sar12_drive
let sar12_stimulus[6] = 0.000148
let sar12_stimulus[7] = sar12_stimulus[5]
alter @VD_B7[pwl] = sar12_stimulus
let sar12_drive = (floor(sar12_trial / 256) - 2*floor(sar12_trial / 512))*1.8
let sar12_previous = @VD_B8[pwl]
let sar12_stimulus = vector(8)
let sar12_stimulus[0] = 0
let sar12_stimulus[1] = sar12_previous[length(sar12_previous)-1]
let sar12_stimulus[2] = 0.000107501
let sar12_stimulus[3] = sar12_stimulus[1]
let sar12_stimulus[4] = 0.000107503
let sar12_stimulus[5] = sar12_drive
let sar12_stimulus[6] = 0.000148
let sar12_stimulus[7] = sar12_stimulus[5]
alter @VD_B8[pwl] = sar12_stimulus
let sar12_drive = (floor(sar12_trial / 512) - 2*floor(sar12_trial / 1024))*1.8
let sar12_previous = @VD_B9[pwl]
let sar12_stimulus = vector(8)
let sar12_stimulus[0] = 0
let sar12_stimulus[1] = sar12_previous[length(sar12_previous)-1]
let sar12_stimulus[2] = 0.000107501
let sar12_stimulus[3] = sar12_stimulus[1]
let sar12_stimulus[4] = 0.000107503
let sar12_stimulus[5] = sar12_drive
let sar12_stimulus[6] = 0.000148
let sar12_stimulus[7] = sar12_stimulus[5]
alter @VD_B9[pwl] = sar12_stimulus
let sar12_drive = (floor(sar12_trial / 1024) - 2*floor(sar12_trial / 2048))*1.8
let sar12_previous = @VD_B10[pwl]
let sar12_stimulus = vector(8)
let sar12_stimulus[0] = 0
let sar12_stimulus[1] = sar12_previous[length(sar12_previous)-1]
let sar12_stimulus[2] = 0.000107501
let sar12_stimulus[3] = sar12_stimulus[1]
let sar12_stimulus[4] = 0.000107503
let sar12_stimulus[5] = sar12_drive
let sar12_stimulus[6] = 0.000148
let sar12_stimulus[7] = sar12_stimulus[5]
alter @VD_B10[pwl] = sar12_stimulus
let sar12_drive = (floor(sar12_trial / 2048) - 2*floor(sar12_trial / 4096))*1.8
let sar12_previous = @VD_B11[pwl]
let sar12_stimulus = vector(8)
let sar12_stimulus[0] = 0
let sar12_stimulus[1] = sar12_previous[length(sar12_previous)-1]
let sar12_stimulus[2] = 0.000107501
let sar12_stimulus[3] = sar12_stimulus[1]
let sar12_stimulus[4] = 0.000107503
let sar12_stimulus[5] = sar12_drive
let sar12_stimulus[6] = 0.000148
let sar12_stimulus[7] = sar12_stimulus[5]
alter @VD_B11[pwl] = sar12_stimulus
let sar12_drive = (floor(sar12_trial / 4096) - 2*floor(sar12_trial / 8192))*1.8
let sar12_previous = @VD_B12[pwl]
let sar12_stimulus = vector(8)
let sar12_stimulus[0] = 0
let sar12_stimulus[1] = sar12_previous[length(sar12_previous)-1]
let sar12_stimulus[2] = 0.000107501
let sar12_stimulus[3] = sar12_stimulus[1]
let sar12_stimulus[4] = 0.000107503
let sar12_stimulus[5] = sar12_drive
let sar12_stimulus[6] = 0.000148
let sar12_stimulus[7] = sar12_stimulus[5]
alter @VD_B12[pwl] = sar12_stimulus
let sar12_drive = (floor(sar12_trial / 8192) - 2*floor(sar12_trial / 16384))*1.8
let sar12_previous = @VD_B13[pwl]
let sar12_stimulus = vector(8)
let sar12_stimulus[0] = 0
let sar12_stimulus[1] = sar12_previous[length(sar12_previous)-1]
let sar12_stimulus[2] = 0.000107501
let sar12_stimulus[3] = sar12_stimulus[1]
let sar12_stimulus[4] = 0.000107503
let sar12_stimulus[5] = sar12_drive
let sar12_stimulus[6] = 0.000148
let sar12_stimulus[7] = sar12_stimulus[5]
alter @VD_B13[pwl] = sar12_stimulus
let sar12_drive = (floor(sar12_trial / 16384) - 2*floor(sar12_trial / 32768))*1.8
let sar12_previous = @VD_B14[pwl]
let sar12_stimulus = vector(8)
let sar12_stimulus[0] = 0
let sar12_stimulus[1] = sar12_previous[length(sar12_previous)-1]
let sar12_stimulus[2] = 0.000107501
let sar12_stimulus[3] = sar12_stimulus[1]
let sar12_stimulus[4] = 0.000107503
let sar12_stimulus[5] = sar12_drive
let sar12_stimulus[6] = 0.000148
let sar12_stimulus[7] = sar12_stimulus[5]
alter @VD_B14[pwl] = sar12_stimulus
let sar12_drive = (floor(sar12_trial / 32768) - 2*floor(sar12_trial / 65536))*1.8
let sar12_previous = @VD_B15[pwl]
let sar12_stimulus = vector(8)
let sar12_stimulus[0] = 0
let sar12_stimulus[1] = sar12_previous[length(sar12_previous)-1]
let sar12_stimulus[2] = 0.000107501
let sar12_stimulus[3] = sar12_stimulus[1]
let sar12_stimulus[4] = 0.000107503
let sar12_stimulus[5] = sar12_drive
let sar12_stimulus[6] = 0.000148
let sar12_stimulus[7] = sar12_stimulus[5]
alter @VD_B15[pwl] = sar12_stimulus
resume
let sar12_k = length(time)-1
if abs(time[sar12_k] - 0.000108) > 1e-12
print time[sar12_k]
echo expected_pause_time_s 0.000108
echo SAR12_PAUSE_FAILED
quit 1
end
print time[sar12_k] >> pause-times.txt
let sar12_previous = @VD_EVAL[pwl]
let sar12_stimulus = vector(8)
let sar12_stimulus[0] = 0
let sar12_stimulus[1] = sar12_previous[length(sar12_previous)-1]
let sar12_stimulus[2] = 0.000108001
let sar12_stimulus[3] = sar12_stimulus[1]
let sar12_stimulus[4] = 0.000108003
let sar12_stimulus[5] = 1.8
let sar12_stimulus[6] = 0.000148
let sar12_stimulus[7] = sar12_stimulus[5]
alter @VD_EVAL[pwl] = sar12_stimulus
resume
let sar12_k = length(time)-1
if abs(time[sar12_k] - 0.0001085) > 1e-12
print time[sar12_k]
echo expected_pause_time_s 0.0001085
echo SAR12_PAUSE_FAILED
quit 1
end
print time[sar12_k] >> pause-times.txt
let sar12_k = length(time)-1
let sar12_cmp = v(COMP)[sar12_k]
let sar12_cmpn = v(COMPN)[sar12_k]
let sar12_p = v(TOPP)[sar12_k]
let sar12_n = v(TOPN)[sar12_k]
let sar12_decision = 0
if sar12_cmp >= 0.9
let sar12_code = sar12_trial
let sar12_decision = 1
end
echo 4 14 $&sar12_trial $&sar12_cmp $&sar12_cmpn $&sar12_p $&sar12_n 1.19994506835937 $&sar12_decision >> decisions.csv
let sar12_previous = @VD_EVAL[pwl]
let sar12_stimulus = vector(8)
let sar12_stimulus[0] = 0
let sar12_stimulus[1] = sar12_previous[length(sar12_previous)-1]
let sar12_stimulus[2] = 0.000108501
let sar12_stimulus[3] = sar12_stimulus[1]
let sar12_stimulus[4] = 0.000108503
let sar12_stimulus[5] = 0
let sar12_stimulus[6] = 0.000148
let sar12_stimulus[7] = sar12_stimulus[5]
alter @VD_EVAL[pwl] = sar12_stimulus
let sar12_trial = sar12_code + 8192
let sar12_drive = (floor(sar12_trial / 1) - 2*floor(sar12_trial / 2))*1.8
let sar12_previous = @VD_B0[pwl]
let sar12_stimulus = vector(8)
let sar12_stimulus[0] = 0
let sar12_stimulus[1] = sar12_previous[length(sar12_previous)-1]
let sar12_stimulus[2] = 0.000108501
let sar12_stimulus[3] = sar12_stimulus[1]
let sar12_stimulus[4] = 0.000108503
let sar12_stimulus[5] = sar12_drive
let sar12_stimulus[6] = 0.000148
let sar12_stimulus[7] = sar12_stimulus[5]
alter @VD_B0[pwl] = sar12_stimulus
let sar12_drive = (floor(sar12_trial / 2) - 2*floor(sar12_trial / 4))*1.8
let sar12_previous = @VD_B1[pwl]
let sar12_stimulus = vector(8)
let sar12_stimulus[0] = 0
let sar12_stimulus[1] = sar12_previous[length(sar12_previous)-1]
let sar12_stimulus[2] = 0.000108501
let sar12_stimulus[3] = sar12_stimulus[1]
let sar12_stimulus[4] = 0.000108503
let sar12_stimulus[5] = sar12_drive
let sar12_stimulus[6] = 0.000148
let sar12_stimulus[7] = sar12_stimulus[5]
alter @VD_B1[pwl] = sar12_stimulus
let sar12_drive = (floor(sar12_trial / 4) - 2*floor(sar12_trial / 8))*1.8
let sar12_previous = @VD_B2[pwl]
let sar12_stimulus = vector(8)
let sar12_stimulus[0] = 0
let sar12_stimulus[1] = sar12_previous[length(sar12_previous)-1]
let sar12_stimulus[2] = 0.000108501
let sar12_stimulus[3] = sar12_stimulus[1]
let sar12_stimulus[4] = 0.000108503
let sar12_stimulus[5] = sar12_drive
let sar12_stimulus[6] = 0.000148
let sar12_stimulus[7] = sar12_stimulus[5]
alter @VD_B2[pwl] = sar12_stimulus
let sar12_drive = (floor(sar12_trial / 8) - 2*floor(sar12_trial / 16))*1.8
let sar12_previous = @VD_B3[pwl]
let sar12_stimulus = vector(8)
let sar12_stimulus[0] = 0
let sar12_stimulus[1] = sar12_previous[length(sar12_previous)-1]
let sar12_stimulus[2] = 0.000108501
let sar12_stimulus[3] = sar12_stimulus[1]
let sar12_stimulus[4] = 0.000108503
let sar12_stimulus[5] = sar12_drive
let sar12_stimulus[6] = 0.000148
let sar12_stimulus[7] = sar12_stimulus[5]
alter @VD_B3[pwl] = sar12_stimulus
let sar12_drive = (floor(sar12_trial / 16) - 2*floor(sar12_trial / 32))*1.8
let sar12_previous = @VD_B4[pwl]
let sar12_stimulus = vector(8)
let sar12_stimulus[0] = 0
let sar12_stimulus[1] = sar12_previous[length(sar12_previous)-1]
let sar12_stimulus[2] = 0.000108501
let sar12_stimulus[3] = sar12_stimulus[1]
let sar12_stimulus[4] = 0.000108503
let sar12_stimulus[5] = sar12_drive
let sar12_stimulus[6] = 0.000148
let sar12_stimulus[7] = sar12_stimulus[5]
alter @VD_B4[pwl] = sar12_stimulus
let sar12_drive = (floor(sar12_trial / 32) - 2*floor(sar12_trial / 64))*1.8
let sar12_previous = @VD_B5[pwl]
let sar12_stimulus = vector(8)
let sar12_stimulus[0] = 0
let sar12_stimulus[1] = sar12_previous[length(sar12_previous)-1]
let sar12_stimulus[2] = 0.000108501
let sar12_stimulus[3] = sar12_stimulus[1]
let sar12_stimulus[4] = 0.000108503
let sar12_stimulus[5] = sar12_drive
let sar12_stimulus[6] = 0.000148
let sar12_stimulus[7] = sar12_stimulus[5]
alter @VD_B5[pwl] = sar12_stimulus
let sar12_drive = (floor(sar12_trial / 64) - 2*floor(sar12_trial / 128))*1.8
let sar12_previous = @VD_B6[pwl]
let sar12_stimulus = vector(8)
let sar12_stimulus[0] = 0
let sar12_stimulus[1] = sar12_previous[length(sar12_previous)-1]
let sar12_stimulus[2] = 0.000108501
let sar12_stimulus[3] = sar12_stimulus[1]
let sar12_stimulus[4] = 0.000108503
let sar12_stimulus[5] = sar12_drive
let sar12_stimulus[6] = 0.000148
let sar12_stimulus[7] = sar12_stimulus[5]
alter @VD_B6[pwl] = sar12_stimulus
let sar12_drive = (floor(sar12_trial / 128) - 2*floor(sar12_trial / 256))*1.8
let sar12_previous = @VD_B7[pwl]
let sar12_stimulus = vector(8)
let sar12_stimulus[0] = 0
let sar12_stimulus[1] = sar12_previous[length(sar12_previous)-1]
let sar12_stimulus[2] = 0.000108501
let sar12_stimulus[3] = sar12_stimulus[1]
let sar12_stimulus[4] = 0.000108503
let sar12_stimulus[5] = sar12_drive
let sar12_stimulus[6] = 0.000148
let sar12_stimulus[7] = sar12_stimulus[5]
alter @VD_B7[pwl] = sar12_stimulus
let sar12_drive = (floor(sar12_trial / 256) - 2*floor(sar12_trial / 512))*1.8
let sar12_previous = @VD_B8[pwl]
let sar12_stimulus = vector(8)
let sar12_stimulus[0] = 0
let sar12_stimulus[1] = sar12_previous[length(sar12_previous)-1]
let sar12_stimulus[2] = 0.000108501
let sar12_stimulus[3] = sar12_stimulus[1]
let sar12_stimulus[4] = 0.000108503
let sar12_stimulus[5] = sar12_drive
let sar12_stimulus[6] = 0.000148
let sar12_stimulus[7] = sar12_stimulus[5]
alter @VD_B8[pwl] = sar12_stimulus
let sar12_drive = (floor(sar12_trial / 512) - 2*floor(sar12_trial / 1024))*1.8
let sar12_previous = @VD_B9[pwl]
let sar12_stimulus = vector(8)
let sar12_stimulus[0] = 0
let sar12_stimulus[1] = sar12_previous[length(sar12_previous)-1]
let sar12_stimulus[2] = 0.000108501
let sar12_stimulus[3] = sar12_stimulus[1]
let sar12_stimulus[4] = 0.000108503
let sar12_stimulus[5] = sar12_drive
let sar12_stimulus[6] = 0.000148
let sar12_stimulus[7] = sar12_stimulus[5]
alter @VD_B9[pwl] = sar12_stimulus
let sar12_drive = (floor(sar12_trial / 1024) - 2*floor(sar12_trial / 2048))*1.8
let sar12_previous = @VD_B10[pwl]
let sar12_stimulus = vector(8)
let sar12_stimulus[0] = 0
let sar12_stimulus[1] = sar12_previous[length(sar12_previous)-1]
let sar12_stimulus[2] = 0.000108501
let sar12_stimulus[3] = sar12_stimulus[1]
let sar12_stimulus[4] = 0.000108503
let sar12_stimulus[5] = sar12_drive
let sar12_stimulus[6] = 0.000148
let sar12_stimulus[7] = sar12_stimulus[5]
alter @VD_B10[pwl] = sar12_stimulus
let sar12_drive = (floor(sar12_trial / 2048) - 2*floor(sar12_trial / 4096))*1.8
let sar12_previous = @VD_B11[pwl]
let sar12_stimulus = vector(8)
let sar12_stimulus[0] = 0
let sar12_stimulus[1] = sar12_previous[length(sar12_previous)-1]
let sar12_stimulus[2] = 0.000108501
let sar12_stimulus[3] = sar12_stimulus[1]
let sar12_stimulus[4] = 0.000108503
let sar12_stimulus[5] = sar12_drive
let sar12_stimulus[6] = 0.000148
let sar12_stimulus[7] = sar12_stimulus[5]
alter @VD_B11[pwl] = sar12_stimulus
let sar12_drive = (floor(sar12_trial / 4096) - 2*floor(sar12_trial / 8192))*1.8
let sar12_previous = @VD_B12[pwl]
let sar12_stimulus = vector(8)
let sar12_stimulus[0] = 0
let sar12_stimulus[1] = sar12_previous[length(sar12_previous)-1]
let sar12_stimulus[2] = 0.000108501
let sar12_stimulus[3] = sar12_stimulus[1]
let sar12_stimulus[4] = 0.000108503
let sar12_stimulus[5] = sar12_drive
let sar12_stimulus[6] = 0.000148
let sar12_stimulus[7] = sar12_stimulus[5]
alter @VD_B12[pwl] = sar12_stimulus
let sar12_drive = (floor(sar12_trial / 8192) - 2*floor(sar12_trial / 16384))*1.8
let sar12_previous = @VD_B13[pwl]
let sar12_stimulus = vector(8)
let sar12_stimulus[0] = 0
let sar12_stimulus[1] = sar12_previous[length(sar12_previous)-1]
let sar12_stimulus[2] = 0.000108501
let sar12_stimulus[3] = sar12_stimulus[1]
let sar12_stimulus[4] = 0.000108503
let sar12_stimulus[5] = sar12_drive
let sar12_stimulus[6] = 0.000148
let sar12_stimulus[7] = sar12_stimulus[5]
alter @VD_B13[pwl] = sar12_stimulus
let sar12_drive = (floor(sar12_trial / 16384) - 2*floor(sar12_trial / 32768))*1.8
let sar12_previous = @VD_B14[pwl]
let sar12_stimulus = vector(8)
let sar12_stimulus[0] = 0
let sar12_stimulus[1] = sar12_previous[length(sar12_previous)-1]
let sar12_stimulus[2] = 0.000108501
let sar12_stimulus[3] = sar12_stimulus[1]
let sar12_stimulus[4] = 0.000108503
let sar12_stimulus[5] = sar12_drive
let sar12_stimulus[6] = 0.000148
let sar12_stimulus[7] = sar12_stimulus[5]
alter @VD_B14[pwl] = sar12_stimulus
let sar12_drive = (floor(sar12_trial / 32768) - 2*floor(sar12_trial / 65536))*1.8
let sar12_previous = @VD_B15[pwl]
let sar12_stimulus = vector(8)
let sar12_stimulus[0] = 0
let sar12_stimulus[1] = sar12_previous[length(sar12_previous)-1]
let sar12_stimulus[2] = 0.000108501
let sar12_stimulus[3] = sar12_stimulus[1]
let sar12_stimulus[4] = 0.000108503
let sar12_stimulus[5] = sar12_drive
let sar12_stimulus[6] = 0.000148
let sar12_stimulus[7] = sar12_stimulus[5]
alter @VD_B15[pwl] = sar12_stimulus
resume
let sar12_k = length(time)-1
if abs(time[sar12_k] - 0.000109) > 1e-12
print time[sar12_k]
echo expected_pause_time_s 0.000109
echo SAR12_PAUSE_FAILED
quit 1
end
print time[sar12_k] >> pause-times.txt
let sar12_previous = @VD_EVAL[pwl]
let sar12_stimulus = vector(8)
let sar12_stimulus[0] = 0
let sar12_stimulus[1] = sar12_previous[length(sar12_previous)-1]
let sar12_stimulus[2] = 0.000109001
let sar12_stimulus[3] = sar12_stimulus[1]
let sar12_stimulus[4] = 0.000109003
let sar12_stimulus[5] = 1.8
let sar12_stimulus[6] = 0.000148
let sar12_stimulus[7] = sar12_stimulus[5]
alter @VD_EVAL[pwl] = sar12_stimulus
resume
let sar12_k = length(time)-1
if abs(time[sar12_k] - 0.0001095) > 1e-12
print time[sar12_k]
echo expected_pause_time_s 0.0001095
echo SAR12_PAUSE_FAILED
quit 1
end
print time[sar12_k] >> pause-times.txt
let sar12_k = length(time)-1
let sar12_cmp = v(COMP)[sar12_k]
let sar12_cmpn = v(COMPN)[sar12_k]
let sar12_p = v(TOPP)[sar12_k]
let sar12_n = v(TOPN)[sar12_k]
let sar12_decision = 0
if sar12_cmp >= 0.9
let sar12_code = sar12_trial
let sar12_decision = 1
end
echo 4 13 $&sar12_trial $&sar12_cmp $&sar12_cmpn $&sar12_p $&sar12_n 1.19994506835937 $&sar12_decision >> decisions.csv
let sar12_previous = @VD_EVAL[pwl]
let sar12_stimulus = vector(8)
let sar12_stimulus[0] = 0
let sar12_stimulus[1] = sar12_previous[length(sar12_previous)-1]
let sar12_stimulus[2] = 0.000109501
let sar12_stimulus[3] = sar12_stimulus[1]
let sar12_stimulus[4] = 0.000109503
let sar12_stimulus[5] = 0
let sar12_stimulus[6] = 0.000148
let sar12_stimulus[7] = sar12_stimulus[5]
alter @VD_EVAL[pwl] = sar12_stimulus
let sar12_trial = sar12_code + 4096
let sar12_drive = (floor(sar12_trial / 1) - 2*floor(sar12_trial / 2))*1.8
let sar12_previous = @VD_B0[pwl]
let sar12_stimulus = vector(8)
let sar12_stimulus[0] = 0
let sar12_stimulus[1] = sar12_previous[length(sar12_previous)-1]
let sar12_stimulus[2] = 0.000109501
let sar12_stimulus[3] = sar12_stimulus[1]
let sar12_stimulus[4] = 0.000109503
let sar12_stimulus[5] = sar12_drive
let sar12_stimulus[6] = 0.000148
let sar12_stimulus[7] = sar12_stimulus[5]
alter @VD_B0[pwl] = sar12_stimulus
let sar12_drive = (floor(sar12_trial / 2) - 2*floor(sar12_trial / 4))*1.8
let sar12_previous = @VD_B1[pwl]
let sar12_stimulus = vector(8)
let sar12_stimulus[0] = 0
let sar12_stimulus[1] = sar12_previous[length(sar12_previous)-1]
let sar12_stimulus[2] = 0.000109501
let sar12_stimulus[3] = sar12_stimulus[1]
let sar12_stimulus[4] = 0.000109503
let sar12_stimulus[5] = sar12_drive
let sar12_stimulus[6] = 0.000148
let sar12_stimulus[7] = sar12_stimulus[5]
alter @VD_B1[pwl] = sar12_stimulus
let sar12_drive = (floor(sar12_trial / 4) - 2*floor(sar12_trial / 8))*1.8
let sar12_previous = @VD_B2[pwl]
let sar12_stimulus = vector(8)
let sar12_stimulus[0] = 0
let sar12_stimulus[1] = sar12_previous[length(sar12_previous)-1]
let sar12_stimulus[2] = 0.000109501
let sar12_stimulus[3] = sar12_stimulus[1]
let sar12_stimulus[4] = 0.000109503
let sar12_stimulus[5] = sar12_drive
let sar12_stimulus[6] = 0.000148
let sar12_stimulus[7] = sar12_stimulus[5]
alter @VD_B2[pwl] = sar12_stimulus
let sar12_drive = (floor(sar12_trial / 8) - 2*floor(sar12_trial / 16))*1.8
let sar12_previous = @VD_B3[pwl]
let sar12_stimulus = vector(8)
let sar12_stimulus[0] = 0
let sar12_stimulus[1] = sar12_previous[length(sar12_previous)-1]
let sar12_stimulus[2] = 0.000109501
let sar12_stimulus[3] = sar12_stimulus[1]
let sar12_stimulus[4] = 0.000109503
let sar12_stimulus[5] = sar12_drive
let sar12_stimulus[6] = 0.000148
let sar12_stimulus[7] = sar12_stimulus[5]
alter @VD_B3[pwl] = sar12_stimulus
let sar12_drive = (floor(sar12_trial / 16) - 2*floor(sar12_trial / 32))*1.8
let sar12_previous = @VD_B4[pwl]
let sar12_stimulus = vector(8)
let sar12_stimulus[0] = 0
let sar12_stimulus[1] = sar12_previous[length(sar12_previous)-1]
let sar12_stimulus[2] = 0.000109501
let sar12_stimulus[3] = sar12_stimulus[1]
let sar12_stimulus[4] = 0.000109503
let sar12_stimulus[5] = sar12_drive
let sar12_stimulus[6] = 0.000148
let sar12_stimulus[7] = sar12_stimulus[5]
alter @VD_B4[pwl] = sar12_stimulus
let sar12_drive = (floor(sar12_trial / 32) - 2*floor(sar12_trial / 64))*1.8
let sar12_previous = @VD_B5[pwl]
let sar12_stimulus = vector(8)
let sar12_stimulus[0] = 0
let sar12_stimulus[1] = sar12_previous[length(sar12_previous)-1]
let sar12_stimulus[2] = 0.000109501
let sar12_stimulus[3] = sar12_stimulus[1]
let sar12_stimulus[4] = 0.000109503
let sar12_stimulus[5] = sar12_drive
let sar12_stimulus[6] = 0.000148
let sar12_stimulus[7] = sar12_stimulus[5]
alter @VD_B5[pwl] = sar12_stimulus
let sar12_drive = (floor(sar12_trial / 64) - 2*floor(sar12_trial / 128))*1.8
let sar12_previous = @VD_B6[pwl]
let sar12_stimulus = vector(8)
let sar12_stimulus[0] = 0
let sar12_stimulus[1] = sar12_previous[length(sar12_previous)-1]
let sar12_stimulus[2] = 0.000109501
let sar12_stimulus[3] = sar12_stimulus[1]
let sar12_stimulus[4] = 0.000109503
let sar12_stimulus[5] = sar12_drive
let sar12_stimulus[6] = 0.000148
let sar12_stimulus[7] = sar12_stimulus[5]
alter @VD_B6[pwl] = sar12_stimulus
let sar12_drive = (floor(sar12_trial / 128) - 2*floor(sar12_trial / 256))*1.8
let sar12_previous = @VD_B7[pwl]
let sar12_stimulus = vector(8)
let sar12_stimulus[0] = 0
let sar12_stimulus[1] = sar12_previous[length(sar12_previous)-1]
let sar12_stimulus[2] = 0.000109501
let sar12_stimulus[3] = sar12_stimulus[1]
let sar12_stimulus[4] = 0.000109503
let sar12_stimulus[5] = sar12_drive
let sar12_stimulus[6] = 0.000148
let sar12_stimulus[7] = sar12_stimulus[5]
alter @VD_B7[pwl] = sar12_stimulus
let sar12_drive = (floor(sar12_trial / 256) - 2*floor(sar12_trial / 512))*1.8
let sar12_previous = @VD_B8[pwl]
let sar12_stimulus = vector(8)
let sar12_stimulus[0] = 0
let sar12_stimulus[1] = sar12_previous[length(sar12_previous)-1]
let sar12_stimulus[2] = 0.000109501
let sar12_stimulus[3] = sar12_stimulus[1]
let sar12_stimulus[4] = 0.000109503
let sar12_stimulus[5] = sar12_drive
let sar12_stimulus[6] = 0.000148
let sar12_stimulus[7] = sar12_stimulus[5]
alter @VD_B8[pwl] = sar12_stimulus
let sar12_drive = (floor(sar12_trial / 512) - 2*floor(sar12_trial / 1024))*1.8
let sar12_previous = @VD_B9[pwl]
let sar12_stimulus = vector(8)
let sar12_stimulus[0] = 0
let sar12_stimulus[1] = sar12_previous[length(sar12_previous)-1]
let sar12_stimulus[2] = 0.000109501
let sar12_stimulus[3] = sar12_stimulus[1]
let sar12_stimulus[4] = 0.000109503
let sar12_stimulus[5] = sar12_drive
let sar12_stimulus[6] = 0.000148
let sar12_stimulus[7] = sar12_stimulus[5]
alter @VD_B9[pwl] = sar12_stimulus
let sar12_drive = (floor(sar12_trial / 1024) - 2*floor(sar12_trial / 2048))*1.8
let sar12_previous = @VD_B10[pwl]
let sar12_stimulus = vector(8)
let sar12_stimulus[0] = 0
let sar12_stimulus[1] = sar12_previous[length(sar12_previous)-1]
let sar12_stimulus[2] = 0.000109501
let sar12_stimulus[3] = sar12_stimulus[1]
let sar12_stimulus[4] = 0.000109503
let sar12_stimulus[5] = sar12_drive
let sar12_stimulus[6] = 0.000148
let sar12_stimulus[7] = sar12_stimulus[5]
alter @VD_B10[pwl] = sar12_stimulus
let sar12_drive = (floor(sar12_trial / 2048) - 2*floor(sar12_trial / 4096))*1.8
let sar12_previous = @VD_B11[pwl]
let sar12_stimulus = vector(8)
let sar12_stimulus[0] = 0
let sar12_stimulus[1] = sar12_previous[length(sar12_previous)-1]
let sar12_stimulus[2] = 0.000109501
let sar12_stimulus[3] = sar12_stimulus[1]
let sar12_stimulus[4] = 0.000109503
let sar12_stimulus[5] = sar12_drive
let sar12_stimulus[6] = 0.000148
let sar12_stimulus[7] = sar12_stimulus[5]
alter @VD_B11[pwl] = sar12_stimulus
let sar12_drive = (floor(sar12_trial / 4096) - 2*floor(sar12_trial / 8192))*1.8
let sar12_previous = @VD_B12[pwl]
let sar12_stimulus = vector(8)
let sar12_stimulus[0] = 0
let sar12_stimulus[1] = sar12_previous[length(sar12_previous)-1]
let sar12_stimulus[2] = 0.000109501
let sar12_stimulus[3] = sar12_stimulus[1]
let sar12_stimulus[4] = 0.000109503
let sar12_stimulus[5] = sar12_drive
let sar12_stimulus[6] = 0.000148
let sar12_stimulus[7] = sar12_stimulus[5]
alter @VD_B12[pwl] = sar12_stimulus
let sar12_drive = (floor(sar12_trial / 8192) - 2*floor(sar12_trial / 16384))*1.8
let sar12_previous = @VD_B13[pwl]
let sar12_stimulus = vector(8)
let sar12_stimulus[0] = 0
let sar12_stimulus[1] = sar12_previous[length(sar12_previous)-1]
let sar12_stimulus[2] = 0.000109501
let sar12_stimulus[3] = sar12_stimulus[1]
let sar12_stimulus[4] = 0.000109503
let sar12_stimulus[5] = sar12_drive
let sar12_stimulus[6] = 0.000148
let sar12_stimulus[7] = sar12_stimulus[5]
alter @VD_B13[pwl] = sar12_stimulus
let sar12_drive = (floor(sar12_trial / 16384) - 2*floor(sar12_trial / 32768))*1.8
let sar12_previous = @VD_B14[pwl]
let sar12_stimulus = vector(8)
let sar12_stimulus[0] = 0
let sar12_stimulus[1] = sar12_previous[length(sar12_previous)-1]
let sar12_stimulus[2] = 0.000109501
let sar12_stimulus[3] = sar12_stimulus[1]
let sar12_stimulus[4] = 0.000109503
let sar12_stimulus[5] = sar12_drive
let sar12_stimulus[6] = 0.000148
let sar12_stimulus[7] = sar12_stimulus[5]
alter @VD_B14[pwl] = sar12_stimulus
let sar12_drive = (floor(sar12_trial / 32768) - 2*floor(sar12_trial / 65536))*1.8
let sar12_previous = @VD_B15[pwl]
let sar12_stimulus = vector(8)
let sar12_stimulus[0] = 0
let sar12_stimulus[1] = sar12_previous[length(sar12_previous)-1]
let sar12_stimulus[2] = 0.000109501
let sar12_stimulus[3] = sar12_stimulus[1]
let sar12_stimulus[4] = 0.000109503
let sar12_stimulus[5] = sar12_drive
let sar12_stimulus[6] = 0.000148
let sar12_stimulus[7] = sar12_stimulus[5]
alter @VD_B15[pwl] = sar12_stimulus
resume
let sar12_k = length(time)-1
if abs(time[sar12_k] - 0.00011) > 1e-12
print time[sar12_k]
echo expected_pause_time_s 0.00011
echo SAR12_PAUSE_FAILED
quit 1
end
print time[sar12_k] >> pause-times.txt
let sar12_previous = @VD_EVAL[pwl]
let sar12_stimulus = vector(8)
let sar12_stimulus[0] = 0
let sar12_stimulus[1] = sar12_previous[length(sar12_previous)-1]
let sar12_stimulus[2] = 0.000110001
let sar12_stimulus[3] = sar12_stimulus[1]
let sar12_stimulus[4] = 0.000110003
let sar12_stimulus[5] = 1.8
let sar12_stimulus[6] = 0.000148
let sar12_stimulus[7] = sar12_stimulus[5]
alter @VD_EVAL[pwl] = sar12_stimulus
resume
let sar12_k = length(time)-1
if abs(time[sar12_k] - 0.0001105) > 1e-12
print time[sar12_k]
echo expected_pause_time_s 0.0001105
echo SAR12_PAUSE_FAILED
quit 1
end
print time[sar12_k] >> pause-times.txt
let sar12_k = length(time)-1
let sar12_cmp = v(COMP)[sar12_k]
let sar12_cmpn = v(COMPN)[sar12_k]
let sar12_p = v(TOPP)[sar12_k]
let sar12_n = v(TOPN)[sar12_k]
let sar12_decision = 0
if sar12_cmp >= 0.9
let sar12_code = sar12_trial
let sar12_decision = 1
end
echo 4 12 $&sar12_trial $&sar12_cmp $&sar12_cmpn $&sar12_p $&sar12_n 1.19994506835937 $&sar12_decision >> decisions.csv
let sar12_previous = @VD_EVAL[pwl]
let sar12_stimulus = vector(8)
let sar12_stimulus[0] = 0
let sar12_stimulus[1] = sar12_previous[length(sar12_previous)-1]
let sar12_stimulus[2] = 0.000110501
let sar12_stimulus[3] = sar12_stimulus[1]
let sar12_stimulus[4] = 0.000110503
let sar12_stimulus[5] = 0
let sar12_stimulus[6] = 0.000148
let sar12_stimulus[7] = sar12_stimulus[5]
alter @VD_EVAL[pwl] = sar12_stimulus
let sar12_trial = sar12_code + 2048
let sar12_drive = (floor(sar12_trial / 1) - 2*floor(sar12_trial / 2))*1.8
let sar12_previous = @VD_B0[pwl]
let sar12_stimulus = vector(8)
let sar12_stimulus[0] = 0
let sar12_stimulus[1] = sar12_previous[length(sar12_previous)-1]
let sar12_stimulus[2] = 0.000110501
let sar12_stimulus[3] = sar12_stimulus[1]
let sar12_stimulus[4] = 0.000110503
let sar12_stimulus[5] = sar12_drive
let sar12_stimulus[6] = 0.000148
let sar12_stimulus[7] = sar12_stimulus[5]
alter @VD_B0[pwl] = sar12_stimulus
let sar12_drive = (floor(sar12_trial / 2) - 2*floor(sar12_trial / 4))*1.8
let sar12_previous = @VD_B1[pwl]
let sar12_stimulus = vector(8)
let sar12_stimulus[0] = 0
let sar12_stimulus[1] = sar12_previous[length(sar12_previous)-1]
let sar12_stimulus[2] = 0.000110501
let sar12_stimulus[3] = sar12_stimulus[1]
let sar12_stimulus[4] = 0.000110503
let sar12_stimulus[5] = sar12_drive
let sar12_stimulus[6] = 0.000148
let sar12_stimulus[7] = sar12_stimulus[5]
alter @VD_B1[pwl] = sar12_stimulus
let sar12_drive = (floor(sar12_trial / 4) - 2*floor(sar12_trial / 8))*1.8
let sar12_previous = @VD_B2[pwl]
let sar12_stimulus = vector(8)
let sar12_stimulus[0] = 0
let sar12_stimulus[1] = sar12_previous[length(sar12_previous)-1]
let sar12_stimulus[2] = 0.000110501
let sar12_stimulus[3] = sar12_stimulus[1]
let sar12_stimulus[4] = 0.000110503
let sar12_stimulus[5] = sar12_drive
let sar12_stimulus[6] = 0.000148
let sar12_stimulus[7] = sar12_stimulus[5]
alter @VD_B2[pwl] = sar12_stimulus
let sar12_drive = (floor(sar12_trial / 8) - 2*floor(sar12_trial / 16))*1.8
let sar12_previous = @VD_B3[pwl]
let sar12_stimulus = vector(8)
let sar12_stimulus[0] = 0
let sar12_stimulus[1] = sar12_previous[length(sar12_previous)-1]
let sar12_stimulus[2] = 0.000110501
let sar12_stimulus[3] = sar12_stimulus[1]
let sar12_stimulus[4] = 0.000110503
let sar12_stimulus[5] = sar12_drive
let sar12_stimulus[6] = 0.000148
let sar12_stimulus[7] = sar12_stimulus[5]
alter @VD_B3[pwl] = sar12_stimulus
let sar12_drive = (floor(sar12_trial / 16) - 2*floor(sar12_trial / 32))*1.8
let sar12_previous = @VD_B4[pwl]
let sar12_stimulus = vector(8)
let sar12_stimulus[0] = 0
let sar12_stimulus[1] = sar12_previous[length(sar12_previous)-1]
let sar12_stimulus[2] = 0.000110501
let sar12_stimulus[3] = sar12_stimulus[1]
let sar12_stimulus[4] = 0.000110503
let sar12_stimulus[5] = sar12_drive
let sar12_stimulus[6] = 0.000148
let sar12_stimulus[7] = sar12_stimulus[5]
alter @VD_B4[pwl] = sar12_stimulus
let sar12_drive = (floor(sar12_trial / 32) - 2*floor(sar12_trial / 64))*1.8
let sar12_previous = @VD_B5[pwl]
let sar12_stimulus = vector(8)
let sar12_stimulus[0] = 0
let sar12_stimulus[1] = sar12_previous[length(sar12_previous)-1]
let sar12_stimulus[2] = 0.000110501
let sar12_stimulus[3] = sar12_stimulus[1]
let sar12_stimulus[4] = 0.000110503
let sar12_stimulus[5] = sar12_drive
let sar12_stimulus[6] = 0.000148
let sar12_stimulus[7] = sar12_stimulus[5]
alter @VD_B5[pwl] = sar12_stimulus
let sar12_drive = (floor(sar12_trial / 64) - 2*floor(sar12_trial / 128))*1.8
let sar12_previous = @VD_B6[pwl]
let sar12_stimulus = vector(8)
let sar12_stimulus[0] = 0
let sar12_stimulus[1] = sar12_previous[length(sar12_previous)-1]
let sar12_stimulus[2] = 0.000110501
let sar12_stimulus[3] = sar12_stimulus[1]
let sar12_stimulus[4] = 0.000110503
let sar12_stimulus[5] = sar12_drive
let sar12_stimulus[6] = 0.000148
let sar12_stimulus[7] = sar12_stimulus[5]
alter @VD_B6[pwl] = sar12_stimulus
let sar12_drive = (floor(sar12_trial / 128) - 2*floor(sar12_trial / 256))*1.8
let sar12_previous = @VD_B7[pwl]
let sar12_stimulus = vector(8)
let sar12_stimulus[0] = 0
let sar12_stimulus[1] = sar12_previous[length(sar12_previous)-1]
let sar12_stimulus[2] = 0.000110501
let sar12_stimulus[3] = sar12_stimulus[1]
let sar12_stimulus[4] = 0.000110503
let sar12_stimulus[5] = sar12_drive
let sar12_stimulus[6] = 0.000148
let sar12_stimulus[7] = sar12_stimulus[5]
alter @VD_B7[pwl] = sar12_stimulus
let sar12_drive = (floor(sar12_trial / 256) - 2*floor(sar12_trial / 512))*1.8
let sar12_previous = @VD_B8[pwl]
let sar12_stimulus = vector(8)
let sar12_stimulus[0] = 0
let sar12_stimulus[1] = sar12_previous[length(sar12_previous)-1]
let sar12_stimulus[2] = 0.000110501
let sar12_stimulus[3] = sar12_stimulus[1]
let sar12_stimulus[4] = 0.000110503
let sar12_stimulus[5] = sar12_drive
let sar12_stimulus[6] = 0.000148
let sar12_stimulus[7] = sar12_stimulus[5]
alter @VD_B8[pwl] = sar12_stimulus
let sar12_drive = (floor(sar12_trial / 512) - 2*floor(sar12_trial / 1024))*1.8
let sar12_previous = @VD_B9[pwl]
let sar12_stimulus = vector(8)
let sar12_stimulus[0] = 0
let sar12_stimulus[1] = sar12_previous[length(sar12_previous)-1]
let sar12_stimulus[2] = 0.000110501
let sar12_stimulus[3] = sar12_stimulus[1]
let sar12_stimulus[4] = 0.000110503
let sar12_stimulus[5] = sar12_drive
let sar12_stimulus[6] = 0.000148
let sar12_stimulus[7] = sar12_stimulus[5]
alter @VD_B9[pwl] = sar12_stimulus
let sar12_drive = (floor(sar12_trial / 1024) - 2*floor(sar12_trial / 2048))*1.8
let sar12_previous = @VD_B10[pwl]
let sar12_stimulus = vector(8)
let sar12_stimulus[0] = 0
let sar12_stimulus[1] = sar12_previous[length(sar12_previous)-1]
let sar12_stimulus[2] = 0.000110501
let sar12_stimulus[3] = sar12_stimulus[1]
let sar12_stimulus[4] = 0.000110503
let sar12_stimulus[5] = sar12_drive
let sar12_stimulus[6] = 0.000148
let sar12_stimulus[7] = sar12_stimulus[5]
alter @VD_B10[pwl] = sar12_stimulus
let sar12_drive = (floor(sar12_trial / 2048) - 2*floor(sar12_trial / 4096))*1.8
let sar12_previous = @VD_B11[pwl]
let sar12_stimulus = vector(8)
let sar12_stimulus[0] = 0
let sar12_stimulus[1] = sar12_previous[length(sar12_previous)-1]
let sar12_stimulus[2] = 0.000110501
let sar12_stimulus[3] = sar12_stimulus[1]
let sar12_stimulus[4] = 0.000110503
let sar12_stimulus[5] = sar12_drive
let sar12_stimulus[6] = 0.000148
let sar12_stimulus[7] = sar12_stimulus[5]
alter @VD_B11[pwl] = sar12_stimulus
let sar12_drive = (floor(sar12_trial / 4096) - 2*floor(sar12_trial / 8192))*1.8
let sar12_previous = @VD_B12[pwl]
let sar12_stimulus = vector(8)
let sar12_stimulus[0] = 0
let sar12_stimulus[1] = sar12_previous[length(sar12_previous)-1]
let sar12_stimulus[2] = 0.000110501
let sar12_stimulus[3] = sar12_stimulus[1]
let sar12_stimulus[4] = 0.000110503
let sar12_stimulus[5] = sar12_drive
let sar12_stimulus[6] = 0.000148
let sar12_stimulus[7] = sar12_stimulus[5]
alter @VD_B12[pwl] = sar12_stimulus
let sar12_drive = (floor(sar12_trial / 8192) - 2*floor(sar12_trial / 16384))*1.8
let sar12_previous = @VD_B13[pwl]
let sar12_stimulus = vector(8)
let sar12_stimulus[0] = 0
let sar12_stimulus[1] = sar12_previous[length(sar12_previous)-1]
let sar12_stimulus[2] = 0.000110501
let sar12_stimulus[3] = sar12_stimulus[1]
let sar12_stimulus[4] = 0.000110503
let sar12_stimulus[5] = sar12_drive
let sar12_stimulus[6] = 0.000148
let sar12_stimulus[7] = sar12_stimulus[5]
alter @VD_B13[pwl] = sar12_stimulus
let sar12_drive = (floor(sar12_trial / 16384) - 2*floor(sar12_trial / 32768))*1.8
let sar12_previous = @VD_B14[pwl]
let sar12_stimulus = vector(8)
let sar12_stimulus[0] = 0
let sar12_stimulus[1] = sar12_previous[length(sar12_previous)-1]
let sar12_stimulus[2] = 0.000110501
let sar12_stimulus[3] = sar12_stimulus[1]
let sar12_stimulus[4] = 0.000110503
let sar12_stimulus[5] = sar12_drive
let sar12_stimulus[6] = 0.000148
let sar12_stimulus[7] = sar12_stimulus[5]
alter @VD_B14[pwl] = sar12_stimulus
let sar12_drive = (floor(sar12_trial / 32768) - 2*floor(sar12_trial / 65536))*1.8
let sar12_previous = @VD_B15[pwl]
let sar12_stimulus = vector(8)
let sar12_stimulus[0] = 0
let sar12_stimulus[1] = sar12_previous[length(sar12_previous)-1]
let sar12_stimulus[2] = 0.000110501
let sar12_stimulus[3] = sar12_stimulus[1]
let sar12_stimulus[4] = 0.000110503
let sar12_stimulus[5] = sar12_drive
let sar12_stimulus[6] = 0.000148
let sar12_stimulus[7] = sar12_stimulus[5]
alter @VD_B15[pwl] = sar12_stimulus
resume
let sar12_k = length(time)-1
if abs(time[sar12_k] - 0.000111) > 1e-12
print time[sar12_k]
echo expected_pause_time_s 0.000111
echo SAR12_PAUSE_FAILED
quit 1
end
print time[sar12_k] >> pause-times.txt
let sar12_previous = @VD_EVAL[pwl]
let sar12_stimulus = vector(8)
let sar12_stimulus[0] = 0
let sar12_stimulus[1] = sar12_previous[length(sar12_previous)-1]
let sar12_stimulus[2] = 0.000111001
let sar12_stimulus[3] = sar12_stimulus[1]
let sar12_stimulus[4] = 0.000111003
let sar12_stimulus[5] = 1.8
let sar12_stimulus[6] = 0.000148
let sar12_stimulus[7] = sar12_stimulus[5]
alter @VD_EVAL[pwl] = sar12_stimulus
resume
let sar12_k = length(time)-1
if abs(time[sar12_k] - 0.0001115) > 1e-12
print time[sar12_k]
echo expected_pause_time_s 0.0001115
echo SAR12_PAUSE_FAILED
quit 1
end
print time[sar12_k] >> pause-times.txt
let sar12_k = length(time)-1
let sar12_cmp = v(COMP)[sar12_k]
let sar12_cmpn = v(COMPN)[sar12_k]
let sar12_p = v(TOPP)[sar12_k]
let sar12_n = v(TOPN)[sar12_k]
let sar12_decision = 0
if sar12_cmp >= 0.9
let sar12_code = sar12_trial
let sar12_decision = 1
end
echo 4 11 $&sar12_trial $&sar12_cmp $&sar12_cmpn $&sar12_p $&sar12_n 1.19994506835937 $&sar12_decision >> decisions.csv
let sar12_previous = @VD_EVAL[pwl]
let sar12_stimulus = vector(8)
let sar12_stimulus[0] = 0
let sar12_stimulus[1] = sar12_previous[length(sar12_previous)-1]
let sar12_stimulus[2] = 0.000111501
let sar12_stimulus[3] = sar12_stimulus[1]
let sar12_stimulus[4] = 0.000111503
let sar12_stimulus[5] = 0
let sar12_stimulus[6] = 0.000148
let sar12_stimulus[7] = sar12_stimulus[5]
alter @VD_EVAL[pwl] = sar12_stimulus
let sar12_trial = sar12_code + 1024
let sar12_drive = (floor(sar12_trial / 1) - 2*floor(sar12_trial / 2))*1.8
let sar12_previous = @VD_B0[pwl]
let sar12_stimulus = vector(8)
let sar12_stimulus[0] = 0
let sar12_stimulus[1] = sar12_previous[length(sar12_previous)-1]
let sar12_stimulus[2] = 0.000111501
let sar12_stimulus[3] = sar12_stimulus[1]
let sar12_stimulus[4] = 0.000111503
let sar12_stimulus[5] = sar12_drive
let sar12_stimulus[6] = 0.000148
let sar12_stimulus[7] = sar12_stimulus[5]
alter @VD_B0[pwl] = sar12_stimulus
let sar12_drive = (floor(sar12_trial / 2) - 2*floor(sar12_trial / 4))*1.8
let sar12_previous = @VD_B1[pwl]
let sar12_stimulus = vector(8)
let sar12_stimulus[0] = 0
let sar12_stimulus[1] = sar12_previous[length(sar12_previous)-1]
let sar12_stimulus[2] = 0.000111501
let sar12_stimulus[3] = sar12_stimulus[1]
let sar12_stimulus[4] = 0.000111503
let sar12_stimulus[5] = sar12_drive
let sar12_stimulus[6] = 0.000148
let sar12_stimulus[7] = sar12_stimulus[5]
alter @VD_B1[pwl] = sar12_stimulus
let sar12_drive = (floor(sar12_trial / 4) - 2*floor(sar12_trial / 8))*1.8
let sar12_previous = @VD_B2[pwl]
let sar12_stimulus = vector(8)
let sar12_stimulus[0] = 0
let sar12_stimulus[1] = sar12_previous[length(sar12_previous)-1]
let sar12_stimulus[2] = 0.000111501
let sar12_stimulus[3] = sar12_stimulus[1]
let sar12_stimulus[4] = 0.000111503
let sar12_stimulus[5] = sar12_drive
let sar12_stimulus[6] = 0.000148
let sar12_stimulus[7] = sar12_stimulus[5]
alter @VD_B2[pwl] = sar12_stimulus
let sar12_drive = (floor(sar12_trial / 8) - 2*floor(sar12_trial / 16))*1.8
let sar12_previous = @VD_B3[pwl]
let sar12_stimulus = vector(8)
let sar12_stimulus[0] = 0
let sar12_stimulus[1] = sar12_previous[length(sar12_previous)-1]
let sar12_stimulus[2] = 0.000111501
let sar12_stimulus[3] = sar12_stimulus[1]
let sar12_stimulus[4] = 0.000111503
let sar12_stimulus[5] = sar12_drive
let sar12_stimulus[6] = 0.000148
let sar12_stimulus[7] = sar12_stimulus[5]
alter @VD_B3[pwl] = sar12_stimulus
let sar12_drive = (floor(sar12_trial / 16) - 2*floor(sar12_trial / 32))*1.8
let sar12_previous = @VD_B4[pwl]
let sar12_stimulus = vector(8)
let sar12_stimulus[0] = 0
let sar12_stimulus[1] = sar12_previous[length(sar12_previous)-1]
let sar12_stimulus[2] = 0.000111501
let sar12_stimulus[3] = sar12_stimulus[1]
let sar12_stimulus[4] = 0.000111503
let sar12_stimulus[5] = sar12_drive
let sar12_stimulus[6] = 0.000148
let sar12_stimulus[7] = sar12_stimulus[5]
alter @VD_B4[pwl] = sar12_stimulus
let sar12_drive = (floor(sar12_trial / 32) - 2*floor(sar12_trial / 64))*1.8
let sar12_previous = @VD_B5[pwl]
let sar12_stimulus = vector(8)
let sar12_stimulus[0] = 0
let sar12_stimulus[1] = sar12_previous[length(sar12_previous)-1]
let sar12_stimulus[2] = 0.000111501
let sar12_stimulus[3] = sar12_stimulus[1]
let sar12_stimulus[4] = 0.000111503
let sar12_stimulus[5] = sar12_drive
let sar12_stimulus[6] = 0.000148
let sar12_stimulus[7] = sar12_stimulus[5]
alter @VD_B5[pwl] = sar12_stimulus
let sar12_drive = (floor(sar12_trial / 64) - 2*floor(sar12_trial / 128))*1.8
let sar12_previous = @VD_B6[pwl]
let sar12_stimulus = vector(8)
let sar12_stimulus[0] = 0
let sar12_stimulus[1] = sar12_previous[length(sar12_previous)-1]
let sar12_stimulus[2] = 0.000111501
let sar12_stimulus[3] = sar12_stimulus[1]
let sar12_stimulus[4] = 0.000111503
let sar12_stimulus[5] = sar12_drive
let sar12_stimulus[6] = 0.000148
let sar12_stimulus[7] = sar12_stimulus[5]
alter @VD_B6[pwl] = sar12_stimulus
let sar12_drive = (floor(sar12_trial / 128) - 2*floor(sar12_trial / 256))*1.8
let sar12_previous = @VD_B7[pwl]
let sar12_stimulus = vector(8)
let sar12_stimulus[0] = 0
let sar12_stimulus[1] = sar12_previous[length(sar12_previous)-1]
let sar12_stimulus[2] = 0.000111501
let sar12_stimulus[3] = sar12_stimulus[1]
let sar12_stimulus[4] = 0.000111503
let sar12_stimulus[5] = sar12_drive
let sar12_stimulus[6] = 0.000148
let sar12_stimulus[7] = sar12_stimulus[5]
alter @VD_B7[pwl] = sar12_stimulus
let sar12_drive = (floor(sar12_trial / 256) - 2*floor(sar12_trial / 512))*1.8
let sar12_previous = @VD_B8[pwl]
let sar12_stimulus = vector(8)
let sar12_stimulus[0] = 0
let sar12_stimulus[1] = sar12_previous[length(sar12_previous)-1]
let sar12_stimulus[2] = 0.000111501
let sar12_stimulus[3] = sar12_stimulus[1]
let sar12_stimulus[4] = 0.000111503
let sar12_stimulus[5] = sar12_drive
let sar12_stimulus[6] = 0.000148
let sar12_stimulus[7] = sar12_stimulus[5]
alter @VD_B8[pwl] = sar12_stimulus
let sar12_drive = (floor(sar12_trial / 512) - 2*floor(sar12_trial / 1024))*1.8
let sar12_previous = @VD_B9[pwl]
let sar12_stimulus = vector(8)
let sar12_stimulus[0] = 0
let sar12_stimulus[1] = sar12_previous[length(sar12_previous)-1]
let sar12_stimulus[2] = 0.000111501
let sar12_stimulus[3] = sar12_stimulus[1]
let sar12_stimulus[4] = 0.000111503
let sar12_stimulus[5] = sar12_drive
let sar12_stimulus[6] = 0.000148
let sar12_stimulus[7] = sar12_stimulus[5]
alter @VD_B9[pwl] = sar12_stimulus
let sar12_drive = (floor(sar12_trial / 1024) - 2*floor(sar12_trial / 2048))*1.8
let sar12_previous = @VD_B10[pwl]
let sar12_stimulus = vector(8)
let sar12_stimulus[0] = 0
let sar12_stimulus[1] = sar12_previous[length(sar12_previous)-1]
let sar12_stimulus[2] = 0.000111501
let sar12_stimulus[3] = sar12_stimulus[1]
let sar12_stimulus[4] = 0.000111503
let sar12_stimulus[5] = sar12_drive
let sar12_stimulus[6] = 0.000148
let sar12_stimulus[7] = sar12_stimulus[5]
alter @VD_B10[pwl] = sar12_stimulus
let sar12_drive = (floor(sar12_trial / 2048) - 2*floor(sar12_trial / 4096))*1.8
let sar12_previous = @VD_B11[pwl]
let sar12_stimulus = vector(8)
let sar12_stimulus[0] = 0
let sar12_stimulus[1] = sar12_previous[length(sar12_previous)-1]
let sar12_stimulus[2] = 0.000111501
let sar12_stimulus[3] = sar12_stimulus[1]
let sar12_stimulus[4] = 0.000111503
let sar12_stimulus[5] = sar12_drive
let sar12_stimulus[6] = 0.000148
let sar12_stimulus[7] = sar12_stimulus[5]
alter @VD_B11[pwl] = sar12_stimulus
let sar12_drive = (floor(sar12_trial / 4096) - 2*floor(sar12_trial / 8192))*1.8
let sar12_previous = @VD_B12[pwl]
let sar12_stimulus = vector(8)
let sar12_stimulus[0] = 0
let sar12_stimulus[1] = sar12_previous[length(sar12_previous)-1]
let sar12_stimulus[2] = 0.000111501
let sar12_stimulus[3] = sar12_stimulus[1]
let sar12_stimulus[4] = 0.000111503
let sar12_stimulus[5] = sar12_drive
let sar12_stimulus[6] = 0.000148
let sar12_stimulus[7] = sar12_stimulus[5]
alter @VD_B12[pwl] = sar12_stimulus
let sar12_drive = (floor(sar12_trial / 8192) - 2*floor(sar12_trial / 16384))*1.8
let sar12_previous = @VD_B13[pwl]
let sar12_stimulus = vector(8)
let sar12_stimulus[0] = 0
let sar12_stimulus[1] = sar12_previous[length(sar12_previous)-1]
let sar12_stimulus[2] = 0.000111501
let sar12_stimulus[3] = sar12_stimulus[1]
let sar12_stimulus[4] = 0.000111503
let sar12_stimulus[5] = sar12_drive
let sar12_stimulus[6] = 0.000148
let sar12_stimulus[7] = sar12_stimulus[5]
alter @VD_B13[pwl] = sar12_stimulus
let sar12_drive = (floor(sar12_trial / 16384) - 2*floor(sar12_trial / 32768))*1.8
let sar12_previous = @VD_B14[pwl]
let sar12_stimulus = vector(8)
let sar12_stimulus[0] = 0
let sar12_stimulus[1] = sar12_previous[length(sar12_previous)-1]
let sar12_stimulus[2] = 0.000111501
let sar12_stimulus[3] = sar12_stimulus[1]
let sar12_stimulus[4] = 0.000111503
let sar12_stimulus[5] = sar12_drive
let sar12_stimulus[6] = 0.000148
let sar12_stimulus[7] = sar12_stimulus[5]
alter @VD_B14[pwl] = sar12_stimulus
let sar12_drive = (floor(sar12_trial / 32768) - 2*floor(sar12_trial / 65536))*1.8
let sar12_previous = @VD_B15[pwl]
let sar12_stimulus = vector(8)
let sar12_stimulus[0] = 0
let sar12_stimulus[1] = sar12_previous[length(sar12_previous)-1]
let sar12_stimulus[2] = 0.000111501
let sar12_stimulus[3] = sar12_stimulus[1]
let sar12_stimulus[4] = 0.000111503
let sar12_stimulus[5] = sar12_drive
let sar12_stimulus[6] = 0.000148
let sar12_stimulus[7] = sar12_stimulus[5]
alter @VD_B15[pwl] = sar12_stimulus
resume
let sar12_k = length(time)-1
if abs(time[sar12_k] - 0.000112) > 1e-12
print time[sar12_k]
echo expected_pause_time_s 0.000112
echo SAR12_PAUSE_FAILED
quit 1
end
print time[sar12_k] >> pause-times.txt
let sar12_previous = @VD_EVAL[pwl]
let sar12_stimulus = vector(8)
let sar12_stimulus[0] = 0
let sar12_stimulus[1] = sar12_previous[length(sar12_previous)-1]
let sar12_stimulus[2] = 0.000112001
let sar12_stimulus[3] = sar12_stimulus[1]
let sar12_stimulus[4] = 0.000112003
let sar12_stimulus[5] = 1.8
let sar12_stimulus[6] = 0.000148
let sar12_stimulus[7] = sar12_stimulus[5]
alter @VD_EVAL[pwl] = sar12_stimulus
resume
let sar12_k = length(time)-1
if abs(time[sar12_k] - 0.0001125) > 1e-12
print time[sar12_k]
echo expected_pause_time_s 0.0001125
echo SAR12_PAUSE_FAILED
quit 1
end
print time[sar12_k] >> pause-times.txt
let sar12_k = length(time)-1
let sar12_cmp = v(COMP)[sar12_k]
let sar12_cmpn = v(COMPN)[sar12_k]
let sar12_p = v(TOPP)[sar12_k]
let sar12_n = v(TOPN)[sar12_k]
let sar12_decision = 0
if sar12_cmp >= 0.9
let sar12_code = sar12_trial
let sar12_decision = 1
end
echo 4 10 $&sar12_trial $&sar12_cmp $&sar12_cmpn $&sar12_p $&sar12_n 1.19994506835937 $&sar12_decision >> decisions.csv
let sar12_previous = @VD_EVAL[pwl]
let sar12_stimulus = vector(8)
let sar12_stimulus[0] = 0
let sar12_stimulus[1] = sar12_previous[length(sar12_previous)-1]
let sar12_stimulus[2] = 0.000112501
let sar12_stimulus[3] = sar12_stimulus[1]
let sar12_stimulus[4] = 0.000112503
let sar12_stimulus[5] = 0
let sar12_stimulus[6] = 0.000148
let sar12_stimulus[7] = sar12_stimulus[5]
alter @VD_EVAL[pwl] = sar12_stimulus
let sar12_trial = sar12_code + 512
let sar12_drive = (floor(sar12_trial / 1) - 2*floor(sar12_trial / 2))*1.8
let sar12_previous = @VD_B0[pwl]
let sar12_stimulus = vector(8)
let sar12_stimulus[0] = 0
let sar12_stimulus[1] = sar12_previous[length(sar12_previous)-1]
let sar12_stimulus[2] = 0.000112501
let sar12_stimulus[3] = sar12_stimulus[1]
let sar12_stimulus[4] = 0.000112503
let sar12_stimulus[5] = sar12_drive
let sar12_stimulus[6] = 0.000148
let sar12_stimulus[7] = sar12_stimulus[5]
alter @VD_B0[pwl] = sar12_stimulus
let sar12_drive = (floor(sar12_trial / 2) - 2*floor(sar12_trial / 4))*1.8
let sar12_previous = @VD_B1[pwl]
let sar12_stimulus = vector(8)
let sar12_stimulus[0] = 0
let sar12_stimulus[1] = sar12_previous[length(sar12_previous)-1]
let sar12_stimulus[2] = 0.000112501
let sar12_stimulus[3] = sar12_stimulus[1]
let sar12_stimulus[4] = 0.000112503
let sar12_stimulus[5] = sar12_drive
let sar12_stimulus[6] = 0.000148
let sar12_stimulus[7] = sar12_stimulus[5]
alter @VD_B1[pwl] = sar12_stimulus
let sar12_drive = (floor(sar12_trial / 4) - 2*floor(sar12_trial / 8))*1.8
let sar12_previous = @VD_B2[pwl]
let sar12_stimulus = vector(8)
let sar12_stimulus[0] = 0
let sar12_stimulus[1] = sar12_previous[length(sar12_previous)-1]
let sar12_stimulus[2] = 0.000112501
let sar12_stimulus[3] = sar12_stimulus[1]
let sar12_stimulus[4] = 0.000112503
let sar12_stimulus[5] = sar12_drive
let sar12_stimulus[6] = 0.000148
let sar12_stimulus[7] = sar12_stimulus[5]
alter @VD_B2[pwl] = sar12_stimulus
let sar12_drive = (floor(sar12_trial / 8) - 2*floor(sar12_trial / 16))*1.8
let sar12_previous = @VD_B3[pwl]
let sar12_stimulus = vector(8)
let sar12_stimulus[0] = 0
let sar12_stimulus[1] = sar12_previous[length(sar12_previous)-1]
let sar12_stimulus[2] = 0.000112501
let sar12_stimulus[3] = sar12_stimulus[1]
let sar12_stimulus[4] = 0.000112503
let sar12_stimulus[5] = sar12_drive
let sar12_stimulus[6] = 0.000148
let sar12_stimulus[7] = sar12_stimulus[5]
alter @VD_B3[pwl] = sar12_stimulus
let sar12_drive = (floor(sar12_trial / 16) - 2*floor(sar12_trial / 32))*1.8
let sar12_previous = @VD_B4[pwl]
let sar12_stimulus = vector(8)
let sar12_stimulus[0] = 0
let sar12_stimulus[1] = sar12_previous[length(sar12_previous)-1]
let sar12_stimulus[2] = 0.000112501
let sar12_stimulus[3] = sar12_stimulus[1]
let sar12_stimulus[4] = 0.000112503
let sar12_stimulus[5] = sar12_drive
let sar12_stimulus[6] = 0.000148
let sar12_stimulus[7] = sar12_stimulus[5]
alter @VD_B4[pwl] = sar12_stimulus
let sar12_drive = (floor(sar12_trial / 32) - 2*floor(sar12_trial / 64))*1.8
let sar12_previous = @VD_B5[pwl]
let sar12_stimulus = vector(8)
let sar12_stimulus[0] = 0
let sar12_stimulus[1] = sar12_previous[length(sar12_previous)-1]
let sar12_stimulus[2] = 0.000112501
let sar12_stimulus[3] = sar12_stimulus[1]
let sar12_stimulus[4] = 0.000112503
let sar12_stimulus[5] = sar12_drive
let sar12_stimulus[6] = 0.000148
let sar12_stimulus[7] = sar12_stimulus[5]
alter @VD_B5[pwl] = sar12_stimulus
let sar12_drive = (floor(sar12_trial / 64) - 2*floor(sar12_trial / 128))*1.8
let sar12_previous = @VD_B6[pwl]
let sar12_stimulus = vector(8)
let sar12_stimulus[0] = 0
let sar12_stimulus[1] = sar12_previous[length(sar12_previous)-1]
let sar12_stimulus[2] = 0.000112501
let sar12_stimulus[3] = sar12_stimulus[1]
let sar12_stimulus[4] = 0.000112503
let sar12_stimulus[5] = sar12_drive
let sar12_stimulus[6] = 0.000148
let sar12_stimulus[7] = sar12_stimulus[5]
alter @VD_B6[pwl] = sar12_stimulus
let sar12_drive = (floor(sar12_trial / 128) - 2*floor(sar12_trial / 256))*1.8
let sar12_previous = @VD_B7[pwl]
let sar12_stimulus = vector(8)
let sar12_stimulus[0] = 0
let sar12_stimulus[1] = sar12_previous[length(sar12_previous)-1]
let sar12_stimulus[2] = 0.000112501
let sar12_stimulus[3] = sar12_stimulus[1]
let sar12_stimulus[4] = 0.000112503
let sar12_stimulus[5] = sar12_drive
let sar12_stimulus[6] = 0.000148
let sar12_stimulus[7] = sar12_stimulus[5]
alter @VD_B7[pwl] = sar12_stimulus
let sar12_drive = (floor(sar12_trial / 256) - 2*floor(sar12_trial / 512))*1.8
let sar12_previous = @VD_B8[pwl]
let sar12_stimulus = vector(8)
let sar12_stimulus[0] = 0
let sar12_stimulus[1] = sar12_previous[length(sar12_previous)-1]
let sar12_stimulus[2] = 0.000112501
let sar12_stimulus[3] = sar12_stimulus[1]
let sar12_stimulus[4] = 0.000112503
let sar12_stimulus[5] = sar12_drive
let sar12_stimulus[6] = 0.000148
let sar12_stimulus[7] = sar12_stimulus[5]
alter @VD_B8[pwl] = sar12_stimulus
let sar12_drive = (floor(sar12_trial / 512) - 2*floor(sar12_trial / 1024))*1.8
let sar12_previous = @VD_B9[pwl]
let sar12_stimulus = vector(8)
let sar12_stimulus[0] = 0
let sar12_stimulus[1] = sar12_previous[length(sar12_previous)-1]
let sar12_stimulus[2] = 0.000112501
let sar12_stimulus[3] = sar12_stimulus[1]
let sar12_stimulus[4] = 0.000112503
let sar12_stimulus[5] = sar12_drive
let sar12_stimulus[6] = 0.000148
let sar12_stimulus[7] = sar12_stimulus[5]
alter @VD_B9[pwl] = sar12_stimulus
let sar12_drive = (floor(sar12_trial / 1024) - 2*floor(sar12_trial / 2048))*1.8
let sar12_previous = @VD_B10[pwl]
let sar12_stimulus = vector(8)
let sar12_stimulus[0] = 0
let sar12_stimulus[1] = sar12_previous[length(sar12_previous)-1]
let sar12_stimulus[2] = 0.000112501
let sar12_stimulus[3] = sar12_stimulus[1]
let sar12_stimulus[4] = 0.000112503
let sar12_stimulus[5] = sar12_drive
let sar12_stimulus[6] = 0.000148
let sar12_stimulus[7] = sar12_stimulus[5]
alter @VD_B10[pwl] = sar12_stimulus
let sar12_drive = (floor(sar12_trial / 2048) - 2*floor(sar12_trial / 4096))*1.8
let sar12_previous = @VD_B11[pwl]
let sar12_stimulus = vector(8)
let sar12_stimulus[0] = 0
let sar12_stimulus[1] = sar12_previous[length(sar12_previous)-1]
let sar12_stimulus[2] = 0.000112501
let sar12_stimulus[3] = sar12_stimulus[1]
let sar12_stimulus[4] = 0.000112503
let sar12_stimulus[5] = sar12_drive
let sar12_stimulus[6] = 0.000148
let sar12_stimulus[7] = sar12_stimulus[5]
alter @VD_B11[pwl] = sar12_stimulus
let sar12_drive = (floor(sar12_trial / 4096) - 2*floor(sar12_trial / 8192))*1.8
let sar12_previous = @VD_B12[pwl]
let sar12_stimulus = vector(8)
let sar12_stimulus[0] = 0
let sar12_stimulus[1] = sar12_previous[length(sar12_previous)-1]
let sar12_stimulus[2] = 0.000112501
let sar12_stimulus[3] = sar12_stimulus[1]
let sar12_stimulus[4] = 0.000112503
let sar12_stimulus[5] = sar12_drive
let sar12_stimulus[6] = 0.000148
let sar12_stimulus[7] = sar12_stimulus[5]
alter @VD_B12[pwl] = sar12_stimulus
let sar12_drive = (floor(sar12_trial / 8192) - 2*floor(sar12_trial / 16384))*1.8
let sar12_previous = @VD_B13[pwl]
let sar12_stimulus = vector(8)
let sar12_stimulus[0] = 0
let sar12_stimulus[1] = sar12_previous[length(sar12_previous)-1]
let sar12_stimulus[2] = 0.000112501
let sar12_stimulus[3] = sar12_stimulus[1]
let sar12_stimulus[4] = 0.000112503
let sar12_stimulus[5] = sar12_drive
let sar12_stimulus[6] = 0.000148
let sar12_stimulus[7] = sar12_stimulus[5]
alter @VD_B13[pwl] = sar12_stimulus
let sar12_drive = (floor(sar12_trial / 16384) - 2*floor(sar12_trial / 32768))*1.8
let sar12_previous = @VD_B14[pwl]
let sar12_stimulus = vector(8)
let sar12_stimulus[0] = 0
let sar12_stimulus[1] = sar12_previous[length(sar12_previous)-1]
let sar12_stimulus[2] = 0.000112501
let sar12_stimulus[3] = sar12_stimulus[1]
let sar12_stimulus[4] = 0.000112503
let sar12_stimulus[5] = sar12_drive
let sar12_stimulus[6] = 0.000148
let sar12_stimulus[7] = sar12_stimulus[5]
alter @VD_B14[pwl] = sar12_stimulus
let sar12_drive = (floor(sar12_trial / 32768) - 2*floor(sar12_trial / 65536))*1.8
let sar12_previous = @VD_B15[pwl]
let sar12_stimulus = vector(8)
let sar12_stimulus[0] = 0
let sar12_stimulus[1] = sar12_previous[length(sar12_previous)-1]
let sar12_stimulus[2] = 0.000112501
let sar12_stimulus[3] = sar12_stimulus[1]
let sar12_stimulus[4] = 0.000112503
let sar12_stimulus[5] = sar12_drive
let sar12_stimulus[6] = 0.000148
let sar12_stimulus[7] = sar12_stimulus[5]
alter @VD_B15[pwl] = sar12_stimulus
resume
let sar12_k = length(time)-1
if abs(time[sar12_k] - 0.000113) > 1e-12
print time[sar12_k]
echo expected_pause_time_s 0.000113
echo SAR12_PAUSE_FAILED
quit 1
end
print time[sar12_k] >> pause-times.txt
let sar12_previous = @VD_EVAL[pwl]
let sar12_stimulus = vector(8)
let sar12_stimulus[0] = 0
let sar12_stimulus[1] = sar12_previous[length(sar12_previous)-1]
let sar12_stimulus[2] = 0.000113001
let sar12_stimulus[3] = sar12_stimulus[1]
let sar12_stimulus[4] = 0.000113003
let sar12_stimulus[5] = 1.8
let sar12_stimulus[6] = 0.000148
let sar12_stimulus[7] = sar12_stimulus[5]
alter @VD_EVAL[pwl] = sar12_stimulus
resume
let sar12_k = length(time)-1
if abs(time[sar12_k] - 0.0001135) > 1e-12
print time[sar12_k]
echo expected_pause_time_s 0.0001135
echo SAR12_PAUSE_FAILED
quit 1
end
print time[sar12_k] >> pause-times.txt
let sar12_k = length(time)-1
let sar12_cmp = v(COMP)[sar12_k]
let sar12_cmpn = v(COMPN)[sar12_k]
let sar12_p = v(TOPP)[sar12_k]
let sar12_n = v(TOPN)[sar12_k]
let sar12_decision = 0
if sar12_cmp >= 0.9
let sar12_code = sar12_trial
let sar12_decision = 1
end
echo 4 9 $&sar12_trial $&sar12_cmp $&sar12_cmpn $&sar12_p $&sar12_n 1.19994506835937 $&sar12_decision >> decisions.csv
let sar12_previous = @VD_EVAL[pwl]
let sar12_stimulus = vector(8)
let sar12_stimulus[0] = 0
let sar12_stimulus[1] = sar12_previous[length(sar12_previous)-1]
let sar12_stimulus[2] = 0.000113501
let sar12_stimulus[3] = sar12_stimulus[1]
let sar12_stimulus[4] = 0.000113503
let sar12_stimulus[5] = 0
let sar12_stimulus[6] = 0.000148
let sar12_stimulus[7] = sar12_stimulus[5]
alter @VD_EVAL[pwl] = sar12_stimulus
let sar12_trial = sar12_code + 256
let sar12_drive = (floor(sar12_trial / 1) - 2*floor(sar12_trial / 2))*1.8
let sar12_previous = @VD_B0[pwl]
let sar12_stimulus = vector(8)
let sar12_stimulus[0] = 0
let sar12_stimulus[1] = sar12_previous[length(sar12_previous)-1]
let sar12_stimulus[2] = 0.000113501
let sar12_stimulus[3] = sar12_stimulus[1]
let sar12_stimulus[4] = 0.000113503
let sar12_stimulus[5] = sar12_drive
let sar12_stimulus[6] = 0.000148
let sar12_stimulus[7] = sar12_stimulus[5]
alter @VD_B0[pwl] = sar12_stimulus
let sar12_drive = (floor(sar12_trial / 2) - 2*floor(sar12_trial / 4))*1.8
let sar12_previous = @VD_B1[pwl]
let sar12_stimulus = vector(8)
let sar12_stimulus[0] = 0
let sar12_stimulus[1] = sar12_previous[length(sar12_previous)-1]
let sar12_stimulus[2] = 0.000113501
let sar12_stimulus[3] = sar12_stimulus[1]
let sar12_stimulus[4] = 0.000113503
let sar12_stimulus[5] = sar12_drive
let sar12_stimulus[6] = 0.000148
let sar12_stimulus[7] = sar12_stimulus[5]
alter @VD_B1[pwl] = sar12_stimulus
let sar12_drive = (floor(sar12_trial / 4) - 2*floor(sar12_trial / 8))*1.8
let sar12_previous = @VD_B2[pwl]
let sar12_stimulus = vector(8)
let sar12_stimulus[0] = 0
let sar12_stimulus[1] = sar12_previous[length(sar12_previous)-1]
let sar12_stimulus[2] = 0.000113501
let sar12_stimulus[3] = sar12_stimulus[1]
let sar12_stimulus[4] = 0.000113503
let sar12_stimulus[5] = sar12_drive
let sar12_stimulus[6] = 0.000148
let sar12_stimulus[7] = sar12_stimulus[5]
alter @VD_B2[pwl] = sar12_stimulus
let sar12_drive = (floor(sar12_trial / 8) - 2*floor(sar12_trial / 16))*1.8
let sar12_previous = @VD_B3[pwl]
let sar12_stimulus = vector(8)
let sar12_stimulus[0] = 0
let sar12_stimulus[1] = sar12_previous[length(sar12_previous)-1]
let sar12_stimulus[2] = 0.000113501
let sar12_stimulus[3] = sar12_stimulus[1]
let sar12_stimulus[4] = 0.000113503
let sar12_stimulus[5] = sar12_drive
let sar12_stimulus[6] = 0.000148
let sar12_stimulus[7] = sar12_stimulus[5]
alter @VD_B3[pwl] = sar12_stimulus
let sar12_drive = (floor(sar12_trial / 16) - 2*floor(sar12_trial / 32))*1.8
let sar12_previous = @VD_B4[pwl]
let sar12_stimulus = vector(8)
let sar12_stimulus[0] = 0
let sar12_stimulus[1] = sar12_previous[length(sar12_previous)-1]
let sar12_stimulus[2] = 0.000113501
let sar12_stimulus[3] = sar12_stimulus[1]
let sar12_stimulus[4] = 0.000113503
let sar12_stimulus[5] = sar12_drive
let sar12_stimulus[6] = 0.000148
let sar12_stimulus[7] = sar12_stimulus[5]
alter @VD_B4[pwl] = sar12_stimulus
let sar12_drive = (floor(sar12_trial / 32) - 2*floor(sar12_trial / 64))*1.8
let sar12_previous = @VD_B5[pwl]
let sar12_stimulus = vector(8)
let sar12_stimulus[0] = 0
let sar12_stimulus[1] = sar12_previous[length(sar12_previous)-1]
let sar12_stimulus[2] = 0.000113501
let sar12_stimulus[3] = sar12_stimulus[1]
let sar12_stimulus[4] = 0.000113503
let sar12_stimulus[5] = sar12_drive
let sar12_stimulus[6] = 0.000148
let sar12_stimulus[7] = sar12_stimulus[5]
alter @VD_B5[pwl] = sar12_stimulus
let sar12_drive = (floor(sar12_trial / 64) - 2*floor(sar12_trial / 128))*1.8
let sar12_previous = @VD_B6[pwl]
let sar12_stimulus = vector(8)
let sar12_stimulus[0] = 0
let sar12_stimulus[1] = sar12_previous[length(sar12_previous)-1]
let sar12_stimulus[2] = 0.000113501
let sar12_stimulus[3] = sar12_stimulus[1]
let sar12_stimulus[4] = 0.000113503
let sar12_stimulus[5] = sar12_drive
let sar12_stimulus[6] = 0.000148
let sar12_stimulus[7] = sar12_stimulus[5]
alter @VD_B6[pwl] = sar12_stimulus
let sar12_drive = (floor(sar12_trial / 128) - 2*floor(sar12_trial / 256))*1.8
let sar12_previous = @VD_B7[pwl]
let sar12_stimulus = vector(8)
let sar12_stimulus[0] = 0
let sar12_stimulus[1] = sar12_previous[length(sar12_previous)-1]
let sar12_stimulus[2] = 0.000113501
let sar12_stimulus[3] = sar12_stimulus[1]
let sar12_stimulus[4] = 0.000113503
let sar12_stimulus[5] = sar12_drive
let sar12_stimulus[6] = 0.000148
let sar12_stimulus[7] = sar12_stimulus[5]
alter @VD_B7[pwl] = sar12_stimulus
let sar12_drive = (floor(sar12_trial / 256) - 2*floor(sar12_trial / 512))*1.8
let sar12_previous = @VD_B8[pwl]
let sar12_stimulus = vector(8)
let sar12_stimulus[0] = 0
let sar12_stimulus[1] = sar12_previous[length(sar12_previous)-1]
let sar12_stimulus[2] = 0.000113501
let sar12_stimulus[3] = sar12_stimulus[1]
let sar12_stimulus[4] = 0.000113503
let sar12_stimulus[5] = sar12_drive
let sar12_stimulus[6] = 0.000148
let sar12_stimulus[7] = sar12_stimulus[5]
alter @VD_B8[pwl] = sar12_stimulus
let sar12_drive = (floor(sar12_trial / 512) - 2*floor(sar12_trial / 1024))*1.8
let sar12_previous = @VD_B9[pwl]
let sar12_stimulus = vector(8)
let sar12_stimulus[0] = 0
let sar12_stimulus[1] = sar12_previous[length(sar12_previous)-1]
let sar12_stimulus[2] = 0.000113501
let sar12_stimulus[3] = sar12_stimulus[1]
let sar12_stimulus[4] = 0.000113503
let sar12_stimulus[5] = sar12_drive
let sar12_stimulus[6] = 0.000148
let sar12_stimulus[7] = sar12_stimulus[5]
alter @VD_B9[pwl] = sar12_stimulus
let sar12_drive = (floor(sar12_trial / 1024) - 2*floor(sar12_trial / 2048))*1.8
let sar12_previous = @VD_B10[pwl]
let sar12_stimulus = vector(8)
let sar12_stimulus[0] = 0
let sar12_stimulus[1] = sar12_previous[length(sar12_previous)-1]
let sar12_stimulus[2] = 0.000113501
let sar12_stimulus[3] = sar12_stimulus[1]
let sar12_stimulus[4] = 0.000113503
let sar12_stimulus[5] = sar12_drive
let sar12_stimulus[6] = 0.000148
let sar12_stimulus[7] = sar12_stimulus[5]
alter @VD_B10[pwl] = sar12_stimulus
let sar12_drive = (floor(sar12_trial / 2048) - 2*floor(sar12_trial / 4096))*1.8
let sar12_previous = @VD_B11[pwl]
let sar12_stimulus = vector(8)
let sar12_stimulus[0] = 0
let sar12_stimulus[1] = sar12_previous[length(sar12_previous)-1]
let sar12_stimulus[2] = 0.000113501
let sar12_stimulus[3] = sar12_stimulus[1]
let sar12_stimulus[4] = 0.000113503
let sar12_stimulus[5] = sar12_drive
let sar12_stimulus[6] = 0.000148
let sar12_stimulus[7] = sar12_stimulus[5]
alter @VD_B11[pwl] = sar12_stimulus
let sar12_drive = (floor(sar12_trial / 4096) - 2*floor(sar12_trial / 8192))*1.8
let sar12_previous = @VD_B12[pwl]
let sar12_stimulus = vector(8)
let sar12_stimulus[0] = 0
let sar12_stimulus[1] = sar12_previous[length(sar12_previous)-1]
let sar12_stimulus[2] = 0.000113501
let sar12_stimulus[3] = sar12_stimulus[1]
let sar12_stimulus[4] = 0.000113503
let sar12_stimulus[5] = sar12_drive
let sar12_stimulus[6] = 0.000148
let sar12_stimulus[7] = sar12_stimulus[5]
alter @VD_B12[pwl] = sar12_stimulus
let sar12_drive = (floor(sar12_trial / 8192) - 2*floor(sar12_trial / 16384))*1.8
let sar12_previous = @VD_B13[pwl]
let sar12_stimulus = vector(8)
let sar12_stimulus[0] = 0
let sar12_stimulus[1] = sar12_previous[length(sar12_previous)-1]
let sar12_stimulus[2] = 0.000113501
let sar12_stimulus[3] = sar12_stimulus[1]
let sar12_stimulus[4] = 0.000113503
let sar12_stimulus[5] = sar12_drive
let sar12_stimulus[6] = 0.000148
let sar12_stimulus[7] = sar12_stimulus[5]
alter @VD_B13[pwl] = sar12_stimulus
let sar12_drive = (floor(sar12_trial / 16384) - 2*floor(sar12_trial / 32768))*1.8
let sar12_previous = @VD_B14[pwl]
let sar12_stimulus = vector(8)
let sar12_stimulus[0] = 0
let sar12_stimulus[1] = sar12_previous[length(sar12_previous)-1]
let sar12_stimulus[2] = 0.000113501
let sar12_stimulus[3] = sar12_stimulus[1]
let sar12_stimulus[4] = 0.000113503
let sar12_stimulus[5] = sar12_drive
let sar12_stimulus[6] = 0.000148
let sar12_stimulus[7] = sar12_stimulus[5]
alter @VD_B14[pwl] = sar12_stimulus
let sar12_drive = (floor(sar12_trial / 32768) - 2*floor(sar12_trial / 65536))*1.8
let sar12_previous = @VD_B15[pwl]
let sar12_stimulus = vector(8)
let sar12_stimulus[0] = 0
let sar12_stimulus[1] = sar12_previous[length(sar12_previous)-1]
let sar12_stimulus[2] = 0.000113501
let sar12_stimulus[3] = sar12_stimulus[1]
let sar12_stimulus[4] = 0.000113503
let sar12_stimulus[5] = sar12_drive
let sar12_stimulus[6] = 0.000148
let sar12_stimulus[7] = sar12_stimulus[5]
alter @VD_B15[pwl] = sar12_stimulus
resume
let sar12_k = length(time)-1
if abs(time[sar12_k] - 0.000114) > 1e-12
print time[sar12_k]
echo expected_pause_time_s 0.000114
echo SAR12_PAUSE_FAILED
quit 1
end
print time[sar12_k] >> pause-times.txt
let sar12_previous = @VD_EVAL[pwl]
let sar12_stimulus = vector(8)
let sar12_stimulus[0] = 0
let sar12_stimulus[1] = sar12_previous[length(sar12_previous)-1]
let sar12_stimulus[2] = 0.000114001
let sar12_stimulus[3] = sar12_stimulus[1]
let sar12_stimulus[4] = 0.000114003
let sar12_stimulus[5] = 1.8
let sar12_stimulus[6] = 0.000148
let sar12_stimulus[7] = sar12_stimulus[5]
alter @VD_EVAL[pwl] = sar12_stimulus
resume
let sar12_k = length(time)-1
if abs(time[sar12_k] - 0.0001145) > 1e-12
print time[sar12_k]
echo expected_pause_time_s 0.0001145
echo SAR12_PAUSE_FAILED
quit 1
end
print time[sar12_k] >> pause-times.txt
let sar12_k = length(time)-1
let sar12_cmp = v(COMP)[sar12_k]
let sar12_cmpn = v(COMPN)[sar12_k]
let sar12_p = v(TOPP)[sar12_k]
let sar12_n = v(TOPN)[sar12_k]
let sar12_decision = 0
if sar12_cmp >= 0.9
let sar12_code = sar12_trial
let sar12_decision = 1
end
echo 4 8 $&sar12_trial $&sar12_cmp $&sar12_cmpn $&sar12_p $&sar12_n 1.19994506835937 $&sar12_decision >> decisions.csv
let sar12_previous = @VD_EVAL[pwl]
let sar12_stimulus = vector(8)
let sar12_stimulus[0] = 0
let sar12_stimulus[1] = sar12_previous[length(sar12_previous)-1]
let sar12_stimulus[2] = 0.000114501
let sar12_stimulus[3] = sar12_stimulus[1]
let sar12_stimulus[4] = 0.000114503
let sar12_stimulus[5] = 0
let sar12_stimulus[6] = 0.000148
let sar12_stimulus[7] = sar12_stimulus[5]
alter @VD_EVAL[pwl] = sar12_stimulus
let sar12_trial = sar12_code + 128
let sar12_drive = (floor(sar12_trial / 1) - 2*floor(sar12_trial / 2))*1.8
let sar12_previous = @VD_B0[pwl]
let sar12_stimulus = vector(8)
let sar12_stimulus[0] = 0
let sar12_stimulus[1] = sar12_previous[length(sar12_previous)-1]
let sar12_stimulus[2] = 0.000114501
let sar12_stimulus[3] = sar12_stimulus[1]
let sar12_stimulus[4] = 0.000114503
let sar12_stimulus[5] = sar12_drive
let sar12_stimulus[6] = 0.000148
let sar12_stimulus[7] = sar12_stimulus[5]
alter @VD_B0[pwl] = sar12_stimulus
let sar12_drive = (floor(sar12_trial / 2) - 2*floor(sar12_trial / 4))*1.8
let sar12_previous = @VD_B1[pwl]
let sar12_stimulus = vector(8)
let sar12_stimulus[0] = 0
let sar12_stimulus[1] = sar12_previous[length(sar12_previous)-1]
let sar12_stimulus[2] = 0.000114501
let sar12_stimulus[3] = sar12_stimulus[1]
let sar12_stimulus[4] = 0.000114503
let sar12_stimulus[5] = sar12_drive
let sar12_stimulus[6] = 0.000148
let sar12_stimulus[7] = sar12_stimulus[5]
alter @VD_B1[pwl] = sar12_stimulus
let sar12_drive = (floor(sar12_trial / 4) - 2*floor(sar12_trial / 8))*1.8
let sar12_previous = @VD_B2[pwl]
let sar12_stimulus = vector(8)
let sar12_stimulus[0] = 0
let sar12_stimulus[1] = sar12_previous[length(sar12_previous)-1]
let sar12_stimulus[2] = 0.000114501
let sar12_stimulus[3] = sar12_stimulus[1]
let sar12_stimulus[4] = 0.000114503
let sar12_stimulus[5] = sar12_drive
let sar12_stimulus[6] = 0.000148
let sar12_stimulus[7] = sar12_stimulus[5]
alter @VD_B2[pwl] = sar12_stimulus
let sar12_drive = (floor(sar12_trial / 8) - 2*floor(sar12_trial / 16))*1.8
let sar12_previous = @VD_B3[pwl]
let sar12_stimulus = vector(8)
let sar12_stimulus[0] = 0
let sar12_stimulus[1] = sar12_previous[length(sar12_previous)-1]
let sar12_stimulus[2] = 0.000114501
let sar12_stimulus[3] = sar12_stimulus[1]
let sar12_stimulus[4] = 0.000114503
let sar12_stimulus[5] = sar12_drive
let sar12_stimulus[6] = 0.000148
let sar12_stimulus[7] = sar12_stimulus[5]
alter @VD_B3[pwl] = sar12_stimulus
let sar12_drive = (floor(sar12_trial / 16) - 2*floor(sar12_trial / 32))*1.8
let sar12_previous = @VD_B4[pwl]
let sar12_stimulus = vector(8)
let sar12_stimulus[0] = 0
let sar12_stimulus[1] = sar12_previous[length(sar12_previous)-1]
let sar12_stimulus[2] = 0.000114501
let sar12_stimulus[3] = sar12_stimulus[1]
let sar12_stimulus[4] = 0.000114503
let sar12_stimulus[5] = sar12_drive
let sar12_stimulus[6] = 0.000148
let sar12_stimulus[7] = sar12_stimulus[5]
alter @VD_B4[pwl] = sar12_stimulus
let sar12_drive = (floor(sar12_trial / 32) - 2*floor(sar12_trial / 64))*1.8
let sar12_previous = @VD_B5[pwl]
let sar12_stimulus = vector(8)
let sar12_stimulus[0] = 0
let sar12_stimulus[1] = sar12_previous[length(sar12_previous)-1]
let sar12_stimulus[2] = 0.000114501
let sar12_stimulus[3] = sar12_stimulus[1]
let sar12_stimulus[4] = 0.000114503
let sar12_stimulus[5] = sar12_drive
let sar12_stimulus[6] = 0.000148
let sar12_stimulus[7] = sar12_stimulus[5]
alter @VD_B5[pwl] = sar12_stimulus
let sar12_drive = (floor(sar12_trial / 64) - 2*floor(sar12_trial / 128))*1.8
let sar12_previous = @VD_B6[pwl]
let sar12_stimulus = vector(8)
let sar12_stimulus[0] = 0
let sar12_stimulus[1] = sar12_previous[length(sar12_previous)-1]
let sar12_stimulus[2] = 0.000114501
let sar12_stimulus[3] = sar12_stimulus[1]
let sar12_stimulus[4] = 0.000114503
let sar12_stimulus[5] = sar12_drive
let sar12_stimulus[6] = 0.000148
let sar12_stimulus[7] = sar12_stimulus[5]
alter @VD_B6[pwl] = sar12_stimulus
let sar12_drive = (floor(sar12_trial / 128) - 2*floor(sar12_trial / 256))*1.8
let sar12_previous = @VD_B7[pwl]
let sar12_stimulus = vector(8)
let sar12_stimulus[0] = 0
let sar12_stimulus[1] = sar12_previous[length(sar12_previous)-1]
let sar12_stimulus[2] = 0.000114501
let sar12_stimulus[3] = sar12_stimulus[1]
let sar12_stimulus[4] = 0.000114503
let sar12_stimulus[5] = sar12_drive
let sar12_stimulus[6] = 0.000148
let sar12_stimulus[7] = sar12_stimulus[5]
alter @VD_B7[pwl] = sar12_stimulus
let sar12_drive = (floor(sar12_trial / 256) - 2*floor(sar12_trial / 512))*1.8
let sar12_previous = @VD_B8[pwl]
let sar12_stimulus = vector(8)
let sar12_stimulus[0] = 0
let sar12_stimulus[1] = sar12_previous[length(sar12_previous)-1]
let sar12_stimulus[2] = 0.000114501
let sar12_stimulus[3] = sar12_stimulus[1]
let sar12_stimulus[4] = 0.000114503
let sar12_stimulus[5] = sar12_drive
let sar12_stimulus[6] = 0.000148
let sar12_stimulus[7] = sar12_stimulus[5]
alter @VD_B8[pwl] = sar12_stimulus
let sar12_drive = (floor(sar12_trial / 512) - 2*floor(sar12_trial / 1024))*1.8
let sar12_previous = @VD_B9[pwl]
let sar12_stimulus = vector(8)
let sar12_stimulus[0] = 0
let sar12_stimulus[1] = sar12_previous[length(sar12_previous)-1]
let sar12_stimulus[2] = 0.000114501
let sar12_stimulus[3] = sar12_stimulus[1]
let sar12_stimulus[4] = 0.000114503
let sar12_stimulus[5] = sar12_drive
let sar12_stimulus[6] = 0.000148
let sar12_stimulus[7] = sar12_stimulus[5]
alter @VD_B9[pwl] = sar12_stimulus
let sar12_drive = (floor(sar12_trial / 1024) - 2*floor(sar12_trial / 2048))*1.8
let sar12_previous = @VD_B10[pwl]
let sar12_stimulus = vector(8)
let sar12_stimulus[0] = 0
let sar12_stimulus[1] = sar12_previous[length(sar12_previous)-1]
let sar12_stimulus[2] = 0.000114501
let sar12_stimulus[3] = sar12_stimulus[1]
let sar12_stimulus[4] = 0.000114503
let sar12_stimulus[5] = sar12_drive
let sar12_stimulus[6] = 0.000148
let sar12_stimulus[7] = sar12_stimulus[5]
alter @VD_B10[pwl] = sar12_stimulus
let sar12_drive = (floor(sar12_trial / 2048) - 2*floor(sar12_trial / 4096))*1.8
let sar12_previous = @VD_B11[pwl]
let sar12_stimulus = vector(8)
let sar12_stimulus[0] = 0
let sar12_stimulus[1] = sar12_previous[length(sar12_previous)-1]
let sar12_stimulus[2] = 0.000114501
let sar12_stimulus[3] = sar12_stimulus[1]
let sar12_stimulus[4] = 0.000114503
let sar12_stimulus[5] = sar12_drive
let sar12_stimulus[6] = 0.000148
let sar12_stimulus[7] = sar12_stimulus[5]
alter @VD_B11[pwl] = sar12_stimulus
let sar12_drive = (floor(sar12_trial / 4096) - 2*floor(sar12_trial / 8192))*1.8
let sar12_previous = @VD_B12[pwl]
let sar12_stimulus = vector(8)
let sar12_stimulus[0] = 0
let sar12_stimulus[1] = sar12_previous[length(sar12_previous)-1]
let sar12_stimulus[2] = 0.000114501
let sar12_stimulus[3] = sar12_stimulus[1]
let sar12_stimulus[4] = 0.000114503
let sar12_stimulus[5] = sar12_drive
let sar12_stimulus[6] = 0.000148
let sar12_stimulus[7] = sar12_stimulus[5]
alter @VD_B12[pwl] = sar12_stimulus
let sar12_drive = (floor(sar12_trial / 8192) - 2*floor(sar12_trial / 16384))*1.8
let sar12_previous = @VD_B13[pwl]
let sar12_stimulus = vector(8)
let sar12_stimulus[0] = 0
let sar12_stimulus[1] = sar12_previous[length(sar12_previous)-1]
let sar12_stimulus[2] = 0.000114501
let sar12_stimulus[3] = sar12_stimulus[1]
let sar12_stimulus[4] = 0.000114503
let sar12_stimulus[5] = sar12_drive
let sar12_stimulus[6] = 0.000148
let sar12_stimulus[7] = sar12_stimulus[5]
alter @VD_B13[pwl] = sar12_stimulus
let sar12_drive = (floor(sar12_trial / 16384) - 2*floor(sar12_trial / 32768))*1.8
let sar12_previous = @VD_B14[pwl]
let sar12_stimulus = vector(8)
let sar12_stimulus[0] = 0
let sar12_stimulus[1] = sar12_previous[length(sar12_previous)-1]
let sar12_stimulus[2] = 0.000114501
let sar12_stimulus[3] = sar12_stimulus[1]
let sar12_stimulus[4] = 0.000114503
let sar12_stimulus[5] = sar12_drive
let sar12_stimulus[6] = 0.000148
let sar12_stimulus[7] = sar12_stimulus[5]
alter @VD_B14[pwl] = sar12_stimulus
let sar12_drive = (floor(sar12_trial / 32768) - 2*floor(sar12_trial / 65536))*1.8
let sar12_previous = @VD_B15[pwl]
let sar12_stimulus = vector(8)
let sar12_stimulus[0] = 0
let sar12_stimulus[1] = sar12_previous[length(sar12_previous)-1]
let sar12_stimulus[2] = 0.000114501
let sar12_stimulus[3] = sar12_stimulus[1]
let sar12_stimulus[4] = 0.000114503
let sar12_stimulus[5] = sar12_drive
let sar12_stimulus[6] = 0.000148
let sar12_stimulus[7] = sar12_stimulus[5]
alter @VD_B15[pwl] = sar12_stimulus
resume
let sar12_k = length(time)-1
if abs(time[sar12_k] - 0.000115) > 1e-12
print time[sar12_k]
echo expected_pause_time_s 0.000115
echo SAR12_PAUSE_FAILED
quit 1
end
print time[sar12_k] >> pause-times.txt
let sar12_previous = @VD_EVAL[pwl]
let sar12_stimulus = vector(8)
let sar12_stimulus[0] = 0
let sar12_stimulus[1] = sar12_previous[length(sar12_previous)-1]
let sar12_stimulus[2] = 0.000115001
let sar12_stimulus[3] = sar12_stimulus[1]
let sar12_stimulus[4] = 0.000115003
let sar12_stimulus[5] = 1.8
let sar12_stimulus[6] = 0.000148
let sar12_stimulus[7] = sar12_stimulus[5]
alter @VD_EVAL[pwl] = sar12_stimulus
resume
let sar12_k = length(time)-1
if abs(time[sar12_k] - 0.0001155) > 1e-12
print time[sar12_k]
echo expected_pause_time_s 0.0001155
echo SAR12_PAUSE_FAILED
quit 1
end
print time[sar12_k] >> pause-times.txt
let sar12_k = length(time)-1
let sar12_cmp = v(COMP)[sar12_k]
let sar12_cmpn = v(COMPN)[sar12_k]
let sar12_p = v(TOPP)[sar12_k]
let sar12_n = v(TOPN)[sar12_k]
let sar12_decision = 0
if sar12_cmp >= 0.9
let sar12_code = sar12_trial
let sar12_decision = 1
end
echo 4 7 $&sar12_trial $&sar12_cmp $&sar12_cmpn $&sar12_p $&sar12_n 1.19994506835937 $&sar12_decision >> decisions.csv
let sar12_previous = @VD_EVAL[pwl]
let sar12_stimulus = vector(8)
let sar12_stimulus[0] = 0
let sar12_stimulus[1] = sar12_previous[length(sar12_previous)-1]
let sar12_stimulus[2] = 0.000115501
let sar12_stimulus[3] = sar12_stimulus[1]
let sar12_stimulus[4] = 0.000115503
let sar12_stimulus[5] = 0
let sar12_stimulus[6] = 0.000148
let sar12_stimulus[7] = sar12_stimulus[5]
alter @VD_EVAL[pwl] = sar12_stimulus
let sar12_trial = sar12_code + 64
let sar12_drive = (floor(sar12_trial / 1) - 2*floor(sar12_trial / 2))*1.8
let sar12_previous = @VD_B0[pwl]
let sar12_stimulus = vector(8)
let sar12_stimulus[0] = 0
let sar12_stimulus[1] = sar12_previous[length(sar12_previous)-1]
let sar12_stimulus[2] = 0.000115501
let sar12_stimulus[3] = sar12_stimulus[1]
let sar12_stimulus[4] = 0.000115503
let sar12_stimulus[5] = sar12_drive
let sar12_stimulus[6] = 0.000148
let sar12_stimulus[7] = sar12_stimulus[5]
alter @VD_B0[pwl] = sar12_stimulus
let sar12_drive = (floor(sar12_trial / 2) - 2*floor(sar12_trial / 4))*1.8
let sar12_previous = @VD_B1[pwl]
let sar12_stimulus = vector(8)
let sar12_stimulus[0] = 0
let sar12_stimulus[1] = sar12_previous[length(sar12_previous)-1]
let sar12_stimulus[2] = 0.000115501
let sar12_stimulus[3] = sar12_stimulus[1]
let sar12_stimulus[4] = 0.000115503
let sar12_stimulus[5] = sar12_drive
let sar12_stimulus[6] = 0.000148
let sar12_stimulus[7] = sar12_stimulus[5]
alter @VD_B1[pwl] = sar12_stimulus
let sar12_drive = (floor(sar12_trial / 4) - 2*floor(sar12_trial / 8))*1.8
let sar12_previous = @VD_B2[pwl]
let sar12_stimulus = vector(8)
let sar12_stimulus[0] = 0
let sar12_stimulus[1] = sar12_previous[length(sar12_previous)-1]
let sar12_stimulus[2] = 0.000115501
let sar12_stimulus[3] = sar12_stimulus[1]
let sar12_stimulus[4] = 0.000115503
let sar12_stimulus[5] = sar12_drive
let sar12_stimulus[6] = 0.000148
let sar12_stimulus[7] = sar12_stimulus[5]
alter @VD_B2[pwl] = sar12_stimulus
let sar12_drive = (floor(sar12_trial / 8) - 2*floor(sar12_trial / 16))*1.8
let sar12_previous = @VD_B3[pwl]
let sar12_stimulus = vector(8)
let sar12_stimulus[0] = 0
let sar12_stimulus[1] = sar12_previous[length(sar12_previous)-1]
let sar12_stimulus[2] = 0.000115501
let sar12_stimulus[3] = sar12_stimulus[1]
let sar12_stimulus[4] = 0.000115503
let sar12_stimulus[5] = sar12_drive
let sar12_stimulus[6] = 0.000148
let sar12_stimulus[7] = sar12_stimulus[5]
alter @VD_B3[pwl] = sar12_stimulus
let sar12_drive = (floor(sar12_trial / 16) - 2*floor(sar12_trial / 32))*1.8
let sar12_previous = @VD_B4[pwl]
let sar12_stimulus = vector(8)
let sar12_stimulus[0] = 0
let sar12_stimulus[1] = sar12_previous[length(sar12_previous)-1]
let sar12_stimulus[2] = 0.000115501
let sar12_stimulus[3] = sar12_stimulus[1]
let sar12_stimulus[4] = 0.000115503
let sar12_stimulus[5] = sar12_drive
let sar12_stimulus[6] = 0.000148
let sar12_stimulus[7] = sar12_stimulus[5]
alter @VD_B4[pwl] = sar12_stimulus
let sar12_drive = (floor(sar12_trial / 32) - 2*floor(sar12_trial / 64))*1.8
let sar12_previous = @VD_B5[pwl]
let sar12_stimulus = vector(8)
let sar12_stimulus[0] = 0
let sar12_stimulus[1] = sar12_previous[length(sar12_previous)-1]
let sar12_stimulus[2] = 0.000115501
let sar12_stimulus[3] = sar12_stimulus[1]
let sar12_stimulus[4] = 0.000115503
let sar12_stimulus[5] = sar12_drive
let sar12_stimulus[6] = 0.000148
let sar12_stimulus[7] = sar12_stimulus[5]
alter @VD_B5[pwl] = sar12_stimulus
let sar12_drive = (floor(sar12_trial / 64) - 2*floor(sar12_trial / 128))*1.8
let sar12_previous = @VD_B6[pwl]
let sar12_stimulus = vector(8)
let sar12_stimulus[0] = 0
let sar12_stimulus[1] = sar12_previous[length(sar12_previous)-1]
let sar12_stimulus[2] = 0.000115501
let sar12_stimulus[3] = sar12_stimulus[1]
let sar12_stimulus[4] = 0.000115503
let sar12_stimulus[5] = sar12_drive
let sar12_stimulus[6] = 0.000148
let sar12_stimulus[7] = sar12_stimulus[5]
alter @VD_B6[pwl] = sar12_stimulus
let sar12_drive = (floor(sar12_trial / 128) - 2*floor(sar12_trial / 256))*1.8
let sar12_previous = @VD_B7[pwl]
let sar12_stimulus = vector(8)
let sar12_stimulus[0] = 0
let sar12_stimulus[1] = sar12_previous[length(sar12_previous)-1]
let sar12_stimulus[2] = 0.000115501
let sar12_stimulus[3] = sar12_stimulus[1]
let sar12_stimulus[4] = 0.000115503
let sar12_stimulus[5] = sar12_drive
let sar12_stimulus[6] = 0.000148
let sar12_stimulus[7] = sar12_stimulus[5]
alter @VD_B7[pwl] = sar12_stimulus
let sar12_drive = (floor(sar12_trial / 256) - 2*floor(sar12_trial / 512))*1.8
let sar12_previous = @VD_B8[pwl]
let sar12_stimulus = vector(8)
let sar12_stimulus[0] = 0
let sar12_stimulus[1] = sar12_previous[length(sar12_previous)-1]
let sar12_stimulus[2] = 0.000115501
let sar12_stimulus[3] = sar12_stimulus[1]
let sar12_stimulus[4] = 0.000115503
let sar12_stimulus[5] = sar12_drive
let sar12_stimulus[6] = 0.000148
let sar12_stimulus[7] = sar12_stimulus[5]
alter @VD_B8[pwl] = sar12_stimulus
let sar12_drive = (floor(sar12_trial / 512) - 2*floor(sar12_trial / 1024))*1.8
let sar12_previous = @VD_B9[pwl]
let sar12_stimulus = vector(8)
let sar12_stimulus[0] = 0
let sar12_stimulus[1] = sar12_previous[length(sar12_previous)-1]
let sar12_stimulus[2] = 0.000115501
let sar12_stimulus[3] = sar12_stimulus[1]
let sar12_stimulus[4] = 0.000115503
let sar12_stimulus[5] = sar12_drive
let sar12_stimulus[6] = 0.000148
let sar12_stimulus[7] = sar12_stimulus[5]
alter @VD_B9[pwl] = sar12_stimulus
let sar12_drive = (floor(sar12_trial / 1024) - 2*floor(sar12_trial / 2048))*1.8
let sar12_previous = @VD_B10[pwl]
let sar12_stimulus = vector(8)
let sar12_stimulus[0] = 0
let sar12_stimulus[1] = sar12_previous[length(sar12_previous)-1]
let sar12_stimulus[2] = 0.000115501
let sar12_stimulus[3] = sar12_stimulus[1]
let sar12_stimulus[4] = 0.000115503
let sar12_stimulus[5] = sar12_drive
let sar12_stimulus[6] = 0.000148
let sar12_stimulus[7] = sar12_stimulus[5]
alter @VD_B10[pwl] = sar12_stimulus
let sar12_drive = (floor(sar12_trial / 2048) - 2*floor(sar12_trial / 4096))*1.8
let sar12_previous = @VD_B11[pwl]
let sar12_stimulus = vector(8)
let sar12_stimulus[0] = 0
let sar12_stimulus[1] = sar12_previous[length(sar12_previous)-1]
let sar12_stimulus[2] = 0.000115501
let sar12_stimulus[3] = sar12_stimulus[1]
let sar12_stimulus[4] = 0.000115503
let sar12_stimulus[5] = sar12_drive
let sar12_stimulus[6] = 0.000148
let sar12_stimulus[7] = sar12_stimulus[5]
alter @VD_B11[pwl] = sar12_stimulus
let sar12_drive = (floor(sar12_trial / 4096) - 2*floor(sar12_trial / 8192))*1.8
let sar12_previous = @VD_B12[pwl]
let sar12_stimulus = vector(8)
let sar12_stimulus[0] = 0
let sar12_stimulus[1] = sar12_previous[length(sar12_previous)-1]
let sar12_stimulus[2] = 0.000115501
let sar12_stimulus[3] = sar12_stimulus[1]
let sar12_stimulus[4] = 0.000115503
let sar12_stimulus[5] = sar12_drive
let sar12_stimulus[6] = 0.000148
let sar12_stimulus[7] = sar12_stimulus[5]
alter @VD_B12[pwl] = sar12_stimulus
let sar12_drive = (floor(sar12_trial / 8192) - 2*floor(sar12_trial / 16384))*1.8
let sar12_previous = @VD_B13[pwl]
let sar12_stimulus = vector(8)
let sar12_stimulus[0] = 0
let sar12_stimulus[1] = sar12_previous[length(sar12_previous)-1]
let sar12_stimulus[2] = 0.000115501
let sar12_stimulus[3] = sar12_stimulus[1]
let sar12_stimulus[4] = 0.000115503
let sar12_stimulus[5] = sar12_drive
let sar12_stimulus[6] = 0.000148
let sar12_stimulus[7] = sar12_stimulus[5]
alter @VD_B13[pwl] = sar12_stimulus
let sar12_drive = (floor(sar12_trial / 16384) - 2*floor(sar12_trial / 32768))*1.8
let sar12_previous = @VD_B14[pwl]
let sar12_stimulus = vector(8)
let sar12_stimulus[0] = 0
let sar12_stimulus[1] = sar12_previous[length(sar12_previous)-1]
let sar12_stimulus[2] = 0.000115501
let sar12_stimulus[3] = sar12_stimulus[1]
let sar12_stimulus[4] = 0.000115503
let sar12_stimulus[5] = sar12_drive
let sar12_stimulus[6] = 0.000148
let sar12_stimulus[7] = sar12_stimulus[5]
alter @VD_B14[pwl] = sar12_stimulus
let sar12_drive = (floor(sar12_trial / 32768) - 2*floor(sar12_trial / 65536))*1.8
let sar12_previous = @VD_B15[pwl]
let sar12_stimulus = vector(8)
let sar12_stimulus[0] = 0
let sar12_stimulus[1] = sar12_previous[length(sar12_previous)-1]
let sar12_stimulus[2] = 0.000115501
let sar12_stimulus[3] = sar12_stimulus[1]
let sar12_stimulus[4] = 0.000115503
let sar12_stimulus[5] = sar12_drive
let sar12_stimulus[6] = 0.000148
let sar12_stimulus[7] = sar12_stimulus[5]
alter @VD_B15[pwl] = sar12_stimulus
resume
let sar12_k = length(time)-1
if abs(time[sar12_k] - 0.000116) > 1e-12
print time[sar12_k]
echo expected_pause_time_s 0.000116
echo SAR12_PAUSE_FAILED
quit 1
end
print time[sar12_k] >> pause-times.txt
let sar12_previous = @VD_EVAL[pwl]
let sar12_stimulus = vector(8)
let sar12_stimulus[0] = 0
let sar12_stimulus[1] = sar12_previous[length(sar12_previous)-1]
let sar12_stimulus[2] = 0.000116001
let sar12_stimulus[3] = sar12_stimulus[1]
let sar12_stimulus[4] = 0.000116003
let sar12_stimulus[5] = 1.8
let sar12_stimulus[6] = 0.000148
let sar12_stimulus[7] = sar12_stimulus[5]
alter @VD_EVAL[pwl] = sar12_stimulus
resume
let sar12_k = length(time)-1
if abs(time[sar12_k] - 0.0001165) > 1e-12
print time[sar12_k]
echo expected_pause_time_s 0.0001165
echo SAR12_PAUSE_FAILED
quit 1
end
print time[sar12_k] >> pause-times.txt
let sar12_k = length(time)-1
let sar12_cmp = v(COMP)[sar12_k]
let sar12_cmpn = v(COMPN)[sar12_k]
let sar12_p = v(TOPP)[sar12_k]
let sar12_n = v(TOPN)[sar12_k]
let sar12_decision = 0
if sar12_cmp >= 0.9
let sar12_code = sar12_trial
let sar12_decision = 1
end
echo 4 6 $&sar12_trial $&sar12_cmp $&sar12_cmpn $&sar12_p $&sar12_n 1.19994506835937 $&sar12_decision >> decisions.csv
let sar12_previous = @VD_EVAL[pwl]
let sar12_stimulus = vector(8)
let sar12_stimulus[0] = 0
let sar12_stimulus[1] = sar12_previous[length(sar12_previous)-1]
let sar12_stimulus[2] = 0.000116501
let sar12_stimulus[3] = sar12_stimulus[1]
let sar12_stimulus[4] = 0.000116503
let sar12_stimulus[5] = 0
let sar12_stimulus[6] = 0.000148
let sar12_stimulus[7] = sar12_stimulus[5]
alter @VD_EVAL[pwl] = sar12_stimulus
let sar12_trial = sar12_code + 32
let sar12_drive = (floor(sar12_trial / 1) - 2*floor(sar12_trial / 2))*1.8
let sar12_previous = @VD_B0[pwl]
let sar12_stimulus = vector(8)
let sar12_stimulus[0] = 0
let sar12_stimulus[1] = sar12_previous[length(sar12_previous)-1]
let sar12_stimulus[2] = 0.000116501
let sar12_stimulus[3] = sar12_stimulus[1]
let sar12_stimulus[4] = 0.000116503
let sar12_stimulus[5] = sar12_drive
let sar12_stimulus[6] = 0.000148
let sar12_stimulus[7] = sar12_stimulus[5]
alter @VD_B0[pwl] = sar12_stimulus
let sar12_drive = (floor(sar12_trial / 2) - 2*floor(sar12_trial / 4))*1.8
let sar12_previous = @VD_B1[pwl]
let sar12_stimulus = vector(8)
let sar12_stimulus[0] = 0
let sar12_stimulus[1] = sar12_previous[length(sar12_previous)-1]
let sar12_stimulus[2] = 0.000116501
let sar12_stimulus[3] = sar12_stimulus[1]
let sar12_stimulus[4] = 0.000116503
let sar12_stimulus[5] = sar12_drive
let sar12_stimulus[6] = 0.000148
let sar12_stimulus[7] = sar12_stimulus[5]
alter @VD_B1[pwl] = sar12_stimulus
let sar12_drive = (floor(sar12_trial / 4) - 2*floor(sar12_trial / 8))*1.8
let sar12_previous = @VD_B2[pwl]
let sar12_stimulus = vector(8)
let sar12_stimulus[0] = 0
let sar12_stimulus[1] = sar12_previous[length(sar12_previous)-1]
let sar12_stimulus[2] = 0.000116501
let sar12_stimulus[3] = sar12_stimulus[1]
let sar12_stimulus[4] = 0.000116503
let sar12_stimulus[5] = sar12_drive
let sar12_stimulus[6] = 0.000148
let sar12_stimulus[7] = sar12_stimulus[5]
alter @VD_B2[pwl] = sar12_stimulus
let sar12_drive = (floor(sar12_trial / 8) - 2*floor(sar12_trial / 16))*1.8
let sar12_previous = @VD_B3[pwl]
let sar12_stimulus = vector(8)
let sar12_stimulus[0] = 0
let sar12_stimulus[1] = sar12_previous[length(sar12_previous)-1]
let sar12_stimulus[2] = 0.000116501
let sar12_stimulus[3] = sar12_stimulus[1]
let sar12_stimulus[4] = 0.000116503
let sar12_stimulus[5] = sar12_drive
let sar12_stimulus[6] = 0.000148
let sar12_stimulus[7] = sar12_stimulus[5]
alter @VD_B3[pwl] = sar12_stimulus
let sar12_drive = (floor(sar12_trial / 16) - 2*floor(sar12_trial / 32))*1.8
let sar12_previous = @VD_B4[pwl]
let sar12_stimulus = vector(8)
let sar12_stimulus[0] = 0
let sar12_stimulus[1] = sar12_previous[length(sar12_previous)-1]
let sar12_stimulus[2] = 0.000116501
let sar12_stimulus[3] = sar12_stimulus[1]
let sar12_stimulus[4] = 0.000116503
let sar12_stimulus[5] = sar12_drive
let sar12_stimulus[6] = 0.000148
let sar12_stimulus[7] = sar12_stimulus[5]
alter @VD_B4[pwl] = sar12_stimulus
let sar12_drive = (floor(sar12_trial / 32) - 2*floor(sar12_trial / 64))*1.8
let sar12_previous = @VD_B5[pwl]
let sar12_stimulus = vector(8)
let sar12_stimulus[0] = 0
let sar12_stimulus[1] = sar12_previous[length(sar12_previous)-1]
let sar12_stimulus[2] = 0.000116501
let sar12_stimulus[3] = sar12_stimulus[1]
let sar12_stimulus[4] = 0.000116503
let sar12_stimulus[5] = sar12_drive
let sar12_stimulus[6] = 0.000148
let sar12_stimulus[7] = sar12_stimulus[5]
alter @VD_B5[pwl] = sar12_stimulus
let sar12_drive = (floor(sar12_trial / 64) - 2*floor(sar12_trial / 128))*1.8
let sar12_previous = @VD_B6[pwl]
let sar12_stimulus = vector(8)
let sar12_stimulus[0] = 0
let sar12_stimulus[1] = sar12_previous[length(sar12_previous)-1]
let sar12_stimulus[2] = 0.000116501
let sar12_stimulus[3] = sar12_stimulus[1]
let sar12_stimulus[4] = 0.000116503
let sar12_stimulus[5] = sar12_drive
let sar12_stimulus[6] = 0.000148
let sar12_stimulus[7] = sar12_stimulus[5]
alter @VD_B6[pwl] = sar12_stimulus
let sar12_drive = (floor(sar12_trial / 128) - 2*floor(sar12_trial / 256))*1.8
let sar12_previous = @VD_B7[pwl]
let sar12_stimulus = vector(8)
let sar12_stimulus[0] = 0
let sar12_stimulus[1] = sar12_previous[length(sar12_previous)-1]
let sar12_stimulus[2] = 0.000116501
let sar12_stimulus[3] = sar12_stimulus[1]
let sar12_stimulus[4] = 0.000116503
let sar12_stimulus[5] = sar12_drive
let sar12_stimulus[6] = 0.000148
let sar12_stimulus[7] = sar12_stimulus[5]
alter @VD_B7[pwl] = sar12_stimulus
let sar12_drive = (floor(sar12_trial / 256) - 2*floor(sar12_trial / 512))*1.8
let sar12_previous = @VD_B8[pwl]
let sar12_stimulus = vector(8)
let sar12_stimulus[0] = 0
let sar12_stimulus[1] = sar12_previous[length(sar12_previous)-1]
let sar12_stimulus[2] = 0.000116501
let sar12_stimulus[3] = sar12_stimulus[1]
let sar12_stimulus[4] = 0.000116503
let sar12_stimulus[5] = sar12_drive
let sar12_stimulus[6] = 0.000148
let sar12_stimulus[7] = sar12_stimulus[5]
alter @VD_B8[pwl] = sar12_stimulus
let sar12_drive = (floor(sar12_trial / 512) - 2*floor(sar12_trial / 1024))*1.8
let sar12_previous = @VD_B9[pwl]
let sar12_stimulus = vector(8)
let sar12_stimulus[0] = 0
let sar12_stimulus[1] = sar12_previous[length(sar12_previous)-1]
let sar12_stimulus[2] = 0.000116501
let sar12_stimulus[3] = sar12_stimulus[1]
let sar12_stimulus[4] = 0.000116503
let sar12_stimulus[5] = sar12_drive
let sar12_stimulus[6] = 0.000148
let sar12_stimulus[7] = sar12_stimulus[5]
alter @VD_B9[pwl] = sar12_stimulus
let sar12_drive = (floor(sar12_trial / 1024) - 2*floor(sar12_trial / 2048))*1.8
let sar12_previous = @VD_B10[pwl]
let sar12_stimulus = vector(8)
let sar12_stimulus[0] = 0
let sar12_stimulus[1] = sar12_previous[length(sar12_previous)-1]
let sar12_stimulus[2] = 0.000116501
let sar12_stimulus[3] = sar12_stimulus[1]
let sar12_stimulus[4] = 0.000116503
let sar12_stimulus[5] = sar12_drive
let sar12_stimulus[6] = 0.000148
let sar12_stimulus[7] = sar12_stimulus[5]
alter @VD_B10[pwl] = sar12_stimulus
let sar12_drive = (floor(sar12_trial / 2048) - 2*floor(sar12_trial / 4096))*1.8
let sar12_previous = @VD_B11[pwl]
let sar12_stimulus = vector(8)
let sar12_stimulus[0] = 0
let sar12_stimulus[1] = sar12_previous[length(sar12_previous)-1]
let sar12_stimulus[2] = 0.000116501
let sar12_stimulus[3] = sar12_stimulus[1]
let sar12_stimulus[4] = 0.000116503
let sar12_stimulus[5] = sar12_drive
let sar12_stimulus[6] = 0.000148
let sar12_stimulus[7] = sar12_stimulus[5]
alter @VD_B11[pwl] = sar12_stimulus
let sar12_drive = (floor(sar12_trial / 4096) - 2*floor(sar12_trial / 8192))*1.8
let sar12_previous = @VD_B12[pwl]
let sar12_stimulus = vector(8)
let sar12_stimulus[0] = 0
let sar12_stimulus[1] = sar12_previous[length(sar12_previous)-1]
let sar12_stimulus[2] = 0.000116501
let sar12_stimulus[3] = sar12_stimulus[1]
let sar12_stimulus[4] = 0.000116503
let sar12_stimulus[5] = sar12_drive
let sar12_stimulus[6] = 0.000148
let sar12_stimulus[7] = sar12_stimulus[5]
alter @VD_B12[pwl] = sar12_stimulus
let sar12_drive = (floor(sar12_trial / 8192) - 2*floor(sar12_trial / 16384))*1.8
let sar12_previous = @VD_B13[pwl]
let sar12_stimulus = vector(8)
let sar12_stimulus[0] = 0
let sar12_stimulus[1] = sar12_previous[length(sar12_previous)-1]
let sar12_stimulus[2] = 0.000116501
let sar12_stimulus[3] = sar12_stimulus[1]
let sar12_stimulus[4] = 0.000116503
let sar12_stimulus[5] = sar12_drive
let sar12_stimulus[6] = 0.000148
let sar12_stimulus[7] = sar12_stimulus[5]
alter @VD_B13[pwl] = sar12_stimulus
let sar12_drive = (floor(sar12_trial / 16384) - 2*floor(sar12_trial / 32768))*1.8
let sar12_previous = @VD_B14[pwl]
let sar12_stimulus = vector(8)
let sar12_stimulus[0] = 0
let sar12_stimulus[1] = sar12_previous[length(sar12_previous)-1]
let sar12_stimulus[2] = 0.000116501
let sar12_stimulus[3] = sar12_stimulus[1]
let sar12_stimulus[4] = 0.000116503
let sar12_stimulus[5] = sar12_drive
let sar12_stimulus[6] = 0.000148
let sar12_stimulus[7] = sar12_stimulus[5]
alter @VD_B14[pwl] = sar12_stimulus
let sar12_drive = (floor(sar12_trial / 32768) - 2*floor(sar12_trial / 65536))*1.8
let sar12_previous = @VD_B15[pwl]
let sar12_stimulus = vector(8)
let sar12_stimulus[0] = 0
let sar12_stimulus[1] = sar12_previous[length(sar12_previous)-1]
let sar12_stimulus[2] = 0.000116501
let sar12_stimulus[3] = sar12_stimulus[1]
let sar12_stimulus[4] = 0.000116503
let sar12_stimulus[5] = sar12_drive
let sar12_stimulus[6] = 0.000148
let sar12_stimulus[7] = sar12_stimulus[5]
alter @VD_B15[pwl] = sar12_stimulus
resume
let sar12_k = length(time)-1
if abs(time[sar12_k] - 0.000117) > 1e-12
print time[sar12_k]
echo expected_pause_time_s 0.000117
echo SAR12_PAUSE_FAILED
quit 1
end
print time[sar12_k] >> pause-times.txt
let sar12_previous = @VD_EVAL[pwl]
let sar12_stimulus = vector(8)
let sar12_stimulus[0] = 0
let sar12_stimulus[1] = sar12_previous[length(sar12_previous)-1]
let sar12_stimulus[2] = 0.000117001
let sar12_stimulus[3] = sar12_stimulus[1]
let sar12_stimulus[4] = 0.000117003
let sar12_stimulus[5] = 1.8
let sar12_stimulus[6] = 0.000148
let sar12_stimulus[7] = sar12_stimulus[5]
alter @VD_EVAL[pwl] = sar12_stimulus
resume
let sar12_k = length(time)-1
if abs(time[sar12_k] - 0.0001175) > 1e-12
print time[sar12_k]
echo expected_pause_time_s 0.0001175
echo SAR12_PAUSE_FAILED
quit 1
end
print time[sar12_k] >> pause-times.txt
let sar12_k = length(time)-1
let sar12_cmp = v(COMP)[sar12_k]
let sar12_cmpn = v(COMPN)[sar12_k]
let sar12_p = v(TOPP)[sar12_k]
let sar12_n = v(TOPN)[sar12_k]
let sar12_decision = 0
if sar12_cmp >= 0.9
let sar12_code = sar12_trial
let sar12_decision = 1
end
echo 4 5 $&sar12_trial $&sar12_cmp $&sar12_cmpn $&sar12_p $&sar12_n 1.19994506835937 $&sar12_decision >> decisions.csv
let sar12_previous = @VD_EVAL[pwl]
let sar12_stimulus = vector(8)
let sar12_stimulus[0] = 0
let sar12_stimulus[1] = sar12_previous[length(sar12_previous)-1]
let sar12_stimulus[2] = 0.000117501
let sar12_stimulus[3] = sar12_stimulus[1]
let sar12_stimulus[4] = 0.000117503
let sar12_stimulus[5] = 0
let sar12_stimulus[6] = 0.000148
let sar12_stimulus[7] = sar12_stimulus[5]
alter @VD_EVAL[pwl] = sar12_stimulus
let sar12_trial = sar12_code + 16
let sar12_drive = (floor(sar12_trial / 1) - 2*floor(sar12_trial / 2))*1.8
let sar12_previous = @VD_B0[pwl]
let sar12_stimulus = vector(8)
let sar12_stimulus[0] = 0
let sar12_stimulus[1] = sar12_previous[length(sar12_previous)-1]
let sar12_stimulus[2] = 0.000117501
let sar12_stimulus[3] = sar12_stimulus[1]
let sar12_stimulus[4] = 0.000117503
let sar12_stimulus[5] = sar12_drive
let sar12_stimulus[6] = 0.000148
let sar12_stimulus[7] = sar12_stimulus[5]
alter @VD_B0[pwl] = sar12_stimulus
let sar12_drive = (floor(sar12_trial / 2) - 2*floor(sar12_trial / 4))*1.8
let sar12_previous = @VD_B1[pwl]
let sar12_stimulus = vector(8)
let sar12_stimulus[0] = 0
let sar12_stimulus[1] = sar12_previous[length(sar12_previous)-1]
let sar12_stimulus[2] = 0.000117501
let sar12_stimulus[3] = sar12_stimulus[1]
let sar12_stimulus[4] = 0.000117503
let sar12_stimulus[5] = sar12_drive
let sar12_stimulus[6] = 0.000148
let sar12_stimulus[7] = sar12_stimulus[5]
alter @VD_B1[pwl] = sar12_stimulus
let sar12_drive = (floor(sar12_trial / 4) - 2*floor(sar12_trial / 8))*1.8
let sar12_previous = @VD_B2[pwl]
let sar12_stimulus = vector(8)
let sar12_stimulus[0] = 0
let sar12_stimulus[1] = sar12_previous[length(sar12_previous)-1]
let sar12_stimulus[2] = 0.000117501
let sar12_stimulus[3] = sar12_stimulus[1]
let sar12_stimulus[4] = 0.000117503
let sar12_stimulus[5] = sar12_drive
let sar12_stimulus[6] = 0.000148
let sar12_stimulus[7] = sar12_stimulus[5]
alter @VD_B2[pwl] = sar12_stimulus
let sar12_drive = (floor(sar12_trial / 8) - 2*floor(sar12_trial / 16))*1.8
let sar12_previous = @VD_B3[pwl]
let sar12_stimulus = vector(8)
let sar12_stimulus[0] = 0
let sar12_stimulus[1] = sar12_previous[length(sar12_previous)-1]
let sar12_stimulus[2] = 0.000117501
let sar12_stimulus[3] = sar12_stimulus[1]
let sar12_stimulus[4] = 0.000117503
let sar12_stimulus[5] = sar12_drive
let sar12_stimulus[6] = 0.000148
let sar12_stimulus[7] = sar12_stimulus[5]
alter @VD_B3[pwl] = sar12_stimulus
let sar12_drive = (floor(sar12_trial / 16) - 2*floor(sar12_trial / 32))*1.8
let sar12_previous = @VD_B4[pwl]
let sar12_stimulus = vector(8)
let sar12_stimulus[0] = 0
let sar12_stimulus[1] = sar12_previous[length(sar12_previous)-1]
let sar12_stimulus[2] = 0.000117501
let sar12_stimulus[3] = sar12_stimulus[1]
let sar12_stimulus[4] = 0.000117503
let sar12_stimulus[5] = sar12_drive
let sar12_stimulus[6] = 0.000148
let sar12_stimulus[7] = sar12_stimulus[5]
alter @VD_B4[pwl] = sar12_stimulus
let sar12_drive = (floor(sar12_trial / 32) - 2*floor(sar12_trial / 64))*1.8
let sar12_previous = @VD_B5[pwl]
let sar12_stimulus = vector(8)
let sar12_stimulus[0] = 0
let sar12_stimulus[1] = sar12_previous[length(sar12_previous)-1]
let sar12_stimulus[2] = 0.000117501
let sar12_stimulus[3] = sar12_stimulus[1]
let sar12_stimulus[4] = 0.000117503
let sar12_stimulus[5] = sar12_drive
let sar12_stimulus[6] = 0.000148
let sar12_stimulus[7] = sar12_stimulus[5]
alter @VD_B5[pwl] = sar12_stimulus
let sar12_drive = (floor(sar12_trial / 64) - 2*floor(sar12_trial / 128))*1.8
let sar12_previous = @VD_B6[pwl]
let sar12_stimulus = vector(8)
let sar12_stimulus[0] = 0
let sar12_stimulus[1] = sar12_previous[length(sar12_previous)-1]
let sar12_stimulus[2] = 0.000117501
let sar12_stimulus[3] = sar12_stimulus[1]
let sar12_stimulus[4] = 0.000117503
let sar12_stimulus[5] = sar12_drive
let sar12_stimulus[6] = 0.000148
let sar12_stimulus[7] = sar12_stimulus[5]
alter @VD_B6[pwl] = sar12_stimulus
let sar12_drive = (floor(sar12_trial / 128) - 2*floor(sar12_trial / 256))*1.8
let sar12_previous = @VD_B7[pwl]
let sar12_stimulus = vector(8)
let sar12_stimulus[0] = 0
let sar12_stimulus[1] = sar12_previous[length(sar12_previous)-1]
let sar12_stimulus[2] = 0.000117501
let sar12_stimulus[3] = sar12_stimulus[1]
let sar12_stimulus[4] = 0.000117503
let sar12_stimulus[5] = sar12_drive
let sar12_stimulus[6] = 0.000148
let sar12_stimulus[7] = sar12_stimulus[5]
alter @VD_B7[pwl] = sar12_stimulus
let sar12_drive = (floor(sar12_trial / 256) - 2*floor(sar12_trial / 512))*1.8
let sar12_previous = @VD_B8[pwl]
let sar12_stimulus = vector(8)
let sar12_stimulus[0] = 0
let sar12_stimulus[1] = sar12_previous[length(sar12_previous)-1]
let sar12_stimulus[2] = 0.000117501
let sar12_stimulus[3] = sar12_stimulus[1]
let sar12_stimulus[4] = 0.000117503
let sar12_stimulus[5] = sar12_drive
let sar12_stimulus[6] = 0.000148
let sar12_stimulus[7] = sar12_stimulus[5]
alter @VD_B8[pwl] = sar12_stimulus
let sar12_drive = (floor(sar12_trial / 512) - 2*floor(sar12_trial / 1024))*1.8
let sar12_previous = @VD_B9[pwl]
let sar12_stimulus = vector(8)
let sar12_stimulus[0] = 0
let sar12_stimulus[1] = sar12_previous[length(sar12_previous)-1]
let sar12_stimulus[2] = 0.000117501
let sar12_stimulus[3] = sar12_stimulus[1]
let sar12_stimulus[4] = 0.000117503
let sar12_stimulus[5] = sar12_drive
let sar12_stimulus[6] = 0.000148
let sar12_stimulus[7] = sar12_stimulus[5]
alter @VD_B9[pwl] = sar12_stimulus
let sar12_drive = (floor(sar12_trial / 1024) - 2*floor(sar12_trial / 2048))*1.8
let sar12_previous = @VD_B10[pwl]
let sar12_stimulus = vector(8)
let sar12_stimulus[0] = 0
let sar12_stimulus[1] = sar12_previous[length(sar12_previous)-1]
let sar12_stimulus[2] = 0.000117501
let sar12_stimulus[3] = sar12_stimulus[1]
let sar12_stimulus[4] = 0.000117503
let sar12_stimulus[5] = sar12_drive
let sar12_stimulus[6] = 0.000148
let sar12_stimulus[7] = sar12_stimulus[5]
alter @VD_B10[pwl] = sar12_stimulus
let sar12_drive = (floor(sar12_trial / 2048) - 2*floor(sar12_trial / 4096))*1.8
let sar12_previous = @VD_B11[pwl]
let sar12_stimulus = vector(8)
let sar12_stimulus[0] = 0
let sar12_stimulus[1] = sar12_previous[length(sar12_previous)-1]
let sar12_stimulus[2] = 0.000117501
let sar12_stimulus[3] = sar12_stimulus[1]
let sar12_stimulus[4] = 0.000117503
let sar12_stimulus[5] = sar12_drive
let sar12_stimulus[6] = 0.000148
let sar12_stimulus[7] = sar12_stimulus[5]
alter @VD_B11[pwl] = sar12_stimulus
let sar12_drive = (floor(sar12_trial / 4096) - 2*floor(sar12_trial / 8192))*1.8
let sar12_previous = @VD_B12[pwl]
let sar12_stimulus = vector(8)
let sar12_stimulus[0] = 0
let sar12_stimulus[1] = sar12_previous[length(sar12_previous)-1]
let sar12_stimulus[2] = 0.000117501
let sar12_stimulus[3] = sar12_stimulus[1]
let sar12_stimulus[4] = 0.000117503
let sar12_stimulus[5] = sar12_drive
let sar12_stimulus[6] = 0.000148
let sar12_stimulus[7] = sar12_stimulus[5]
alter @VD_B12[pwl] = sar12_stimulus
let sar12_drive = (floor(sar12_trial / 8192) - 2*floor(sar12_trial / 16384))*1.8
let sar12_previous = @VD_B13[pwl]
let sar12_stimulus = vector(8)
let sar12_stimulus[0] = 0
let sar12_stimulus[1] = sar12_previous[length(sar12_previous)-1]
let sar12_stimulus[2] = 0.000117501
let sar12_stimulus[3] = sar12_stimulus[1]
let sar12_stimulus[4] = 0.000117503
let sar12_stimulus[5] = sar12_drive
let sar12_stimulus[6] = 0.000148
let sar12_stimulus[7] = sar12_stimulus[5]
alter @VD_B13[pwl] = sar12_stimulus
let sar12_drive = (floor(sar12_trial / 16384) - 2*floor(sar12_trial / 32768))*1.8
let sar12_previous = @VD_B14[pwl]
let sar12_stimulus = vector(8)
let sar12_stimulus[0] = 0
let sar12_stimulus[1] = sar12_previous[length(sar12_previous)-1]
let sar12_stimulus[2] = 0.000117501
let sar12_stimulus[3] = sar12_stimulus[1]
let sar12_stimulus[4] = 0.000117503
let sar12_stimulus[5] = sar12_drive
let sar12_stimulus[6] = 0.000148
let sar12_stimulus[7] = sar12_stimulus[5]
alter @VD_B14[pwl] = sar12_stimulus
let sar12_drive = (floor(sar12_trial / 32768) - 2*floor(sar12_trial / 65536))*1.8
let sar12_previous = @VD_B15[pwl]
let sar12_stimulus = vector(8)
let sar12_stimulus[0] = 0
let sar12_stimulus[1] = sar12_previous[length(sar12_previous)-1]
let sar12_stimulus[2] = 0.000117501
let sar12_stimulus[3] = sar12_stimulus[1]
let sar12_stimulus[4] = 0.000117503
let sar12_stimulus[5] = sar12_drive
let sar12_stimulus[6] = 0.000148
let sar12_stimulus[7] = sar12_stimulus[5]
alter @VD_B15[pwl] = sar12_stimulus
resume
let sar12_k = length(time)-1
if abs(time[sar12_k] - 0.000118) > 1e-12
print time[sar12_k]
echo expected_pause_time_s 0.000118
echo SAR12_PAUSE_FAILED
quit 1
end
print time[sar12_k] >> pause-times.txt
let sar12_previous = @VD_EVAL[pwl]
let sar12_stimulus = vector(8)
let sar12_stimulus[0] = 0
let sar12_stimulus[1] = sar12_previous[length(sar12_previous)-1]
let sar12_stimulus[2] = 0.000118001
let sar12_stimulus[3] = sar12_stimulus[1]
let sar12_stimulus[4] = 0.000118003
let sar12_stimulus[5] = 1.8
let sar12_stimulus[6] = 0.000148
let sar12_stimulus[7] = sar12_stimulus[5]
alter @VD_EVAL[pwl] = sar12_stimulus
resume
let sar12_k = length(time)-1
if abs(time[sar12_k] - 0.0001185) > 1e-12
print time[sar12_k]
echo expected_pause_time_s 0.0001185
echo SAR12_PAUSE_FAILED
quit 1
end
print time[sar12_k] >> pause-times.txt
let sar12_k = length(time)-1
let sar12_cmp = v(COMP)[sar12_k]
let sar12_cmpn = v(COMPN)[sar12_k]
let sar12_p = v(TOPP)[sar12_k]
let sar12_n = v(TOPN)[sar12_k]
let sar12_decision = 0
if sar12_cmp >= 0.9
let sar12_code = sar12_trial
let sar12_decision = 1
end
echo 4 4 $&sar12_trial $&sar12_cmp $&sar12_cmpn $&sar12_p $&sar12_n 1.19994506835937 $&sar12_decision >> decisions.csv
let sar12_previous = @VD_EVAL[pwl]
let sar12_stimulus = vector(8)
let sar12_stimulus[0] = 0
let sar12_stimulus[1] = sar12_previous[length(sar12_previous)-1]
let sar12_stimulus[2] = 0.000118501
let sar12_stimulus[3] = sar12_stimulus[1]
let sar12_stimulus[4] = 0.000118503
let sar12_stimulus[5] = 0
let sar12_stimulus[6] = 0.000148
let sar12_stimulus[7] = sar12_stimulus[5]
alter @VD_EVAL[pwl] = sar12_stimulus
let sar12_trial = sar12_code + 8
let sar12_drive = (floor(sar12_trial / 1) - 2*floor(sar12_trial / 2))*1.8
let sar12_previous = @VD_B0[pwl]
let sar12_stimulus = vector(8)
let sar12_stimulus[0] = 0
let sar12_stimulus[1] = sar12_previous[length(sar12_previous)-1]
let sar12_stimulus[2] = 0.000118501
let sar12_stimulus[3] = sar12_stimulus[1]
let sar12_stimulus[4] = 0.000118503
let sar12_stimulus[5] = sar12_drive
let sar12_stimulus[6] = 0.000148
let sar12_stimulus[7] = sar12_stimulus[5]
alter @VD_B0[pwl] = sar12_stimulus
let sar12_drive = (floor(sar12_trial / 2) - 2*floor(sar12_trial / 4))*1.8
let sar12_previous = @VD_B1[pwl]
let sar12_stimulus = vector(8)
let sar12_stimulus[0] = 0
let sar12_stimulus[1] = sar12_previous[length(sar12_previous)-1]
let sar12_stimulus[2] = 0.000118501
let sar12_stimulus[3] = sar12_stimulus[1]
let sar12_stimulus[4] = 0.000118503
let sar12_stimulus[5] = sar12_drive
let sar12_stimulus[6] = 0.000148
let sar12_stimulus[7] = sar12_stimulus[5]
alter @VD_B1[pwl] = sar12_stimulus
let sar12_drive = (floor(sar12_trial / 4) - 2*floor(sar12_trial / 8))*1.8
let sar12_previous = @VD_B2[pwl]
let sar12_stimulus = vector(8)
let sar12_stimulus[0] = 0
let sar12_stimulus[1] = sar12_previous[length(sar12_previous)-1]
let sar12_stimulus[2] = 0.000118501
let sar12_stimulus[3] = sar12_stimulus[1]
let sar12_stimulus[4] = 0.000118503
let sar12_stimulus[5] = sar12_drive
let sar12_stimulus[6] = 0.000148
let sar12_stimulus[7] = sar12_stimulus[5]
alter @VD_B2[pwl] = sar12_stimulus
let sar12_drive = (floor(sar12_trial / 8) - 2*floor(sar12_trial / 16))*1.8
let sar12_previous = @VD_B3[pwl]
let sar12_stimulus = vector(8)
let sar12_stimulus[0] = 0
let sar12_stimulus[1] = sar12_previous[length(sar12_previous)-1]
let sar12_stimulus[2] = 0.000118501
let sar12_stimulus[3] = sar12_stimulus[1]
let sar12_stimulus[4] = 0.000118503
let sar12_stimulus[5] = sar12_drive
let sar12_stimulus[6] = 0.000148
let sar12_stimulus[7] = sar12_stimulus[5]
alter @VD_B3[pwl] = sar12_stimulus
let sar12_drive = (floor(sar12_trial / 16) - 2*floor(sar12_trial / 32))*1.8
let sar12_previous = @VD_B4[pwl]
let sar12_stimulus = vector(8)
let sar12_stimulus[0] = 0
let sar12_stimulus[1] = sar12_previous[length(sar12_previous)-1]
let sar12_stimulus[2] = 0.000118501
let sar12_stimulus[3] = sar12_stimulus[1]
let sar12_stimulus[4] = 0.000118503
let sar12_stimulus[5] = sar12_drive
let sar12_stimulus[6] = 0.000148
let sar12_stimulus[7] = sar12_stimulus[5]
alter @VD_B4[pwl] = sar12_stimulus
let sar12_drive = (floor(sar12_trial / 32) - 2*floor(sar12_trial / 64))*1.8
let sar12_previous = @VD_B5[pwl]
let sar12_stimulus = vector(8)
let sar12_stimulus[0] = 0
let sar12_stimulus[1] = sar12_previous[length(sar12_previous)-1]
let sar12_stimulus[2] = 0.000118501
let sar12_stimulus[3] = sar12_stimulus[1]
let sar12_stimulus[4] = 0.000118503
let sar12_stimulus[5] = sar12_drive
let sar12_stimulus[6] = 0.000148
let sar12_stimulus[7] = sar12_stimulus[5]
alter @VD_B5[pwl] = sar12_stimulus
let sar12_drive = (floor(sar12_trial / 64) - 2*floor(sar12_trial / 128))*1.8
let sar12_previous = @VD_B6[pwl]
let sar12_stimulus = vector(8)
let sar12_stimulus[0] = 0
let sar12_stimulus[1] = sar12_previous[length(sar12_previous)-1]
let sar12_stimulus[2] = 0.000118501
let sar12_stimulus[3] = sar12_stimulus[1]
let sar12_stimulus[4] = 0.000118503
let sar12_stimulus[5] = sar12_drive
let sar12_stimulus[6] = 0.000148
let sar12_stimulus[7] = sar12_stimulus[5]
alter @VD_B6[pwl] = sar12_stimulus
let sar12_drive = (floor(sar12_trial / 128) - 2*floor(sar12_trial / 256))*1.8
let sar12_previous = @VD_B7[pwl]
let sar12_stimulus = vector(8)
let sar12_stimulus[0] = 0
let sar12_stimulus[1] = sar12_previous[length(sar12_previous)-1]
let sar12_stimulus[2] = 0.000118501
let sar12_stimulus[3] = sar12_stimulus[1]
let sar12_stimulus[4] = 0.000118503
let sar12_stimulus[5] = sar12_drive
let sar12_stimulus[6] = 0.000148
let sar12_stimulus[7] = sar12_stimulus[5]
alter @VD_B7[pwl] = sar12_stimulus
let sar12_drive = (floor(sar12_trial / 256) - 2*floor(sar12_trial / 512))*1.8
let sar12_previous = @VD_B8[pwl]
let sar12_stimulus = vector(8)
let sar12_stimulus[0] = 0
let sar12_stimulus[1] = sar12_previous[length(sar12_previous)-1]
let sar12_stimulus[2] = 0.000118501
let sar12_stimulus[3] = sar12_stimulus[1]
let sar12_stimulus[4] = 0.000118503
let sar12_stimulus[5] = sar12_drive
let sar12_stimulus[6] = 0.000148
let sar12_stimulus[7] = sar12_stimulus[5]
alter @VD_B8[pwl] = sar12_stimulus
let sar12_drive = (floor(sar12_trial / 512) - 2*floor(sar12_trial / 1024))*1.8
let sar12_previous = @VD_B9[pwl]
let sar12_stimulus = vector(8)
let sar12_stimulus[0] = 0
let sar12_stimulus[1] = sar12_previous[length(sar12_previous)-1]
let sar12_stimulus[2] = 0.000118501
let sar12_stimulus[3] = sar12_stimulus[1]
let sar12_stimulus[4] = 0.000118503
let sar12_stimulus[5] = sar12_drive
let sar12_stimulus[6] = 0.000148
let sar12_stimulus[7] = sar12_stimulus[5]
alter @VD_B9[pwl] = sar12_stimulus
let sar12_drive = (floor(sar12_trial / 1024) - 2*floor(sar12_trial / 2048))*1.8
let sar12_previous = @VD_B10[pwl]
let sar12_stimulus = vector(8)
let sar12_stimulus[0] = 0
let sar12_stimulus[1] = sar12_previous[length(sar12_previous)-1]
let sar12_stimulus[2] = 0.000118501
let sar12_stimulus[3] = sar12_stimulus[1]
let sar12_stimulus[4] = 0.000118503
let sar12_stimulus[5] = sar12_drive
let sar12_stimulus[6] = 0.000148
let sar12_stimulus[7] = sar12_stimulus[5]
alter @VD_B10[pwl] = sar12_stimulus
let sar12_drive = (floor(sar12_trial / 2048) - 2*floor(sar12_trial / 4096))*1.8
let sar12_previous = @VD_B11[pwl]
let sar12_stimulus = vector(8)
let sar12_stimulus[0] = 0
let sar12_stimulus[1] = sar12_previous[length(sar12_previous)-1]
let sar12_stimulus[2] = 0.000118501
let sar12_stimulus[3] = sar12_stimulus[1]
let sar12_stimulus[4] = 0.000118503
let sar12_stimulus[5] = sar12_drive
let sar12_stimulus[6] = 0.000148
let sar12_stimulus[7] = sar12_stimulus[5]
alter @VD_B11[pwl] = sar12_stimulus
let sar12_drive = (floor(sar12_trial / 4096) - 2*floor(sar12_trial / 8192))*1.8
let sar12_previous = @VD_B12[pwl]
let sar12_stimulus = vector(8)
let sar12_stimulus[0] = 0
let sar12_stimulus[1] = sar12_previous[length(sar12_previous)-1]
let sar12_stimulus[2] = 0.000118501
let sar12_stimulus[3] = sar12_stimulus[1]
let sar12_stimulus[4] = 0.000118503
let sar12_stimulus[5] = sar12_drive
let sar12_stimulus[6] = 0.000148
let sar12_stimulus[7] = sar12_stimulus[5]
alter @VD_B12[pwl] = sar12_stimulus
let sar12_drive = (floor(sar12_trial / 8192) - 2*floor(sar12_trial / 16384))*1.8
let sar12_previous = @VD_B13[pwl]
let sar12_stimulus = vector(8)
let sar12_stimulus[0] = 0
let sar12_stimulus[1] = sar12_previous[length(sar12_previous)-1]
let sar12_stimulus[2] = 0.000118501
let sar12_stimulus[3] = sar12_stimulus[1]
let sar12_stimulus[4] = 0.000118503
let sar12_stimulus[5] = sar12_drive
let sar12_stimulus[6] = 0.000148
let sar12_stimulus[7] = sar12_stimulus[5]
alter @VD_B13[pwl] = sar12_stimulus
let sar12_drive = (floor(sar12_trial / 16384) - 2*floor(sar12_trial / 32768))*1.8
let sar12_previous = @VD_B14[pwl]
let sar12_stimulus = vector(8)
let sar12_stimulus[0] = 0
let sar12_stimulus[1] = sar12_previous[length(sar12_previous)-1]
let sar12_stimulus[2] = 0.000118501
let sar12_stimulus[3] = sar12_stimulus[1]
let sar12_stimulus[4] = 0.000118503
let sar12_stimulus[5] = sar12_drive
let sar12_stimulus[6] = 0.000148
let sar12_stimulus[7] = sar12_stimulus[5]
alter @VD_B14[pwl] = sar12_stimulus
let sar12_drive = (floor(sar12_trial / 32768) - 2*floor(sar12_trial / 65536))*1.8
let sar12_previous = @VD_B15[pwl]
let sar12_stimulus = vector(8)
let sar12_stimulus[0] = 0
let sar12_stimulus[1] = sar12_previous[length(sar12_previous)-1]
let sar12_stimulus[2] = 0.000118501
let sar12_stimulus[3] = sar12_stimulus[1]
let sar12_stimulus[4] = 0.000118503
let sar12_stimulus[5] = sar12_drive
let sar12_stimulus[6] = 0.000148
let sar12_stimulus[7] = sar12_stimulus[5]
alter @VD_B15[pwl] = sar12_stimulus
resume
let sar12_k = length(time)-1
if abs(time[sar12_k] - 0.000119) > 1e-12
print time[sar12_k]
echo expected_pause_time_s 0.000119
echo SAR12_PAUSE_FAILED
quit 1
end
print time[sar12_k] >> pause-times.txt
let sar12_previous = @VD_EVAL[pwl]
let sar12_stimulus = vector(8)
let sar12_stimulus[0] = 0
let sar12_stimulus[1] = sar12_previous[length(sar12_previous)-1]
let sar12_stimulus[2] = 0.000119001
let sar12_stimulus[3] = sar12_stimulus[1]
let sar12_stimulus[4] = 0.000119003
let sar12_stimulus[5] = 1.8
let sar12_stimulus[6] = 0.000148
let sar12_stimulus[7] = sar12_stimulus[5]
alter @VD_EVAL[pwl] = sar12_stimulus
resume
let sar12_k = length(time)-1
if abs(time[sar12_k] - 0.0001195) > 1e-12
print time[sar12_k]
echo expected_pause_time_s 0.0001195
echo SAR12_PAUSE_FAILED
quit 1
end
print time[sar12_k] >> pause-times.txt
let sar12_k = length(time)-1
let sar12_cmp = v(COMP)[sar12_k]
let sar12_cmpn = v(COMPN)[sar12_k]
let sar12_p = v(TOPP)[sar12_k]
let sar12_n = v(TOPN)[sar12_k]
let sar12_decision = 0
if sar12_cmp >= 0.9
let sar12_code = sar12_trial
let sar12_decision = 1
end
echo 4 3 $&sar12_trial $&sar12_cmp $&sar12_cmpn $&sar12_p $&sar12_n 1.19994506835937 $&sar12_decision >> decisions.csv
let sar12_previous = @VD_EVAL[pwl]
let sar12_stimulus = vector(8)
let sar12_stimulus[0] = 0
let sar12_stimulus[1] = sar12_previous[length(sar12_previous)-1]
let sar12_stimulus[2] = 0.000119501
let sar12_stimulus[3] = sar12_stimulus[1]
let sar12_stimulus[4] = 0.000119503
let sar12_stimulus[5] = 0
let sar12_stimulus[6] = 0.000148
let sar12_stimulus[7] = sar12_stimulus[5]
alter @VD_EVAL[pwl] = sar12_stimulus
let sar12_trial = sar12_code + 4
let sar12_drive = (floor(sar12_trial / 1) - 2*floor(sar12_trial / 2))*1.8
let sar12_previous = @VD_B0[pwl]
let sar12_stimulus = vector(8)
let sar12_stimulus[0] = 0
let sar12_stimulus[1] = sar12_previous[length(sar12_previous)-1]
let sar12_stimulus[2] = 0.000119501
let sar12_stimulus[3] = sar12_stimulus[1]
let sar12_stimulus[4] = 0.000119503
let sar12_stimulus[5] = sar12_drive
let sar12_stimulus[6] = 0.000148
let sar12_stimulus[7] = sar12_stimulus[5]
alter @VD_B0[pwl] = sar12_stimulus
let sar12_drive = (floor(sar12_trial / 2) - 2*floor(sar12_trial / 4))*1.8
let sar12_previous = @VD_B1[pwl]
let sar12_stimulus = vector(8)
let sar12_stimulus[0] = 0
let sar12_stimulus[1] = sar12_previous[length(sar12_previous)-1]
let sar12_stimulus[2] = 0.000119501
let sar12_stimulus[3] = sar12_stimulus[1]
let sar12_stimulus[4] = 0.000119503
let sar12_stimulus[5] = sar12_drive
let sar12_stimulus[6] = 0.000148
let sar12_stimulus[7] = sar12_stimulus[5]
alter @VD_B1[pwl] = sar12_stimulus
let sar12_drive = (floor(sar12_trial / 4) - 2*floor(sar12_trial / 8))*1.8
let sar12_previous = @VD_B2[pwl]
let sar12_stimulus = vector(8)
let sar12_stimulus[0] = 0
let sar12_stimulus[1] = sar12_previous[length(sar12_previous)-1]
let sar12_stimulus[2] = 0.000119501
let sar12_stimulus[3] = sar12_stimulus[1]
let sar12_stimulus[4] = 0.000119503
let sar12_stimulus[5] = sar12_drive
let sar12_stimulus[6] = 0.000148
let sar12_stimulus[7] = sar12_stimulus[5]
alter @VD_B2[pwl] = sar12_stimulus
let sar12_drive = (floor(sar12_trial / 8) - 2*floor(sar12_trial / 16))*1.8
let sar12_previous = @VD_B3[pwl]
let sar12_stimulus = vector(8)
let sar12_stimulus[0] = 0
let sar12_stimulus[1] = sar12_previous[length(sar12_previous)-1]
let sar12_stimulus[2] = 0.000119501
let sar12_stimulus[3] = sar12_stimulus[1]
let sar12_stimulus[4] = 0.000119503
let sar12_stimulus[5] = sar12_drive
let sar12_stimulus[6] = 0.000148
let sar12_stimulus[7] = sar12_stimulus[5]
alter @VD_B3[pwl] = sar12_stimulus
let sar12_drive = (floor(sar12_trial / 16) - 2*floor(sar12_trial / 32))*1.8
let sar12_previous = @VD_B4[pwl]
let sar12_stimulus = vector(8)
let sar12_stimulus[0] = 0
let sar12_stimulus[1] = sar12_previous[length(sar12_previous)-1]
let sar12_stimulus[2] = 0.000119501
let sar12_stimulus[3] = sar12_stimulus[1]
let sar12_stimulus[4] = 0.000119503
let sar12_stimulus[5] = sar12_drive
let sar12_stimulus[6] = 0.000148
let sar12_stimulus[7] = sar12_stimulus[5]
alter @VD_B4[pwl] = sar12_stimulus
let sar12_drive = (floor(sar12_trial / 32) - 2*floor(sar12_trial / 64))*1.8
let sar12_previous = @VD_B5[pwl]
let sar12_stimulus = vector(8)
let sar12_stimulus[0] = 0
let sar12_stimulus[1] = sar12_previous[length(sar12_previous)-1]
let sar12_stimulus[2] = 0.000119501
let sar12_stimulus[3] = sar12_stimulus[1]
let sar12_stimulus[4] = 0.000119503
let sar12_stimulus[5] = sar12_drive
let sar12_stimulus[6] = 0.000148
let sar12_stimulus[7] = sar12_stimulus[5]
alter @VD_B5[pwl] = sar12_stimulus
let sar12_drive = (floor(sar12_trial / 64) - 2*floor(sar12_trial / 128))*1.8
let sar12_previous = @VD_B6[pwl]
let sar12_stimulus = vector(8)
let sar12_stimulus[0] = 0
let sar12_stimulus[1] = sar12_previous[length(sar12_previous)-1]
let sar12_stimulus[2] = 0.000119501
let sar12_stimulus[3] = sar12_stimulus[1]
let sar12_stimulus[4] = 0.000119503
let sar12_stimulus[5] = sar12_drive
let sar12_stimulus[6] = 0.000148
let sar12_stimulus[7] = sar12_stimulus[5]
alter @VD_B6[pwl] = sar12_stimulus
let sar12_drive = (floor(sar12_trial / 128) - 2*floor(sar12_trial / 256))*1.8
let sar12_previous = @VD_B7[pwl]
let sar12_stimulus = vector(8)
let sar12_stimulus[0] = 0
let sar12_stimulus[1] = sar12_previous[length(sar12_previous)-1]
let sar12_stimulus[2] = 0.000119501
let sar12_stimulus[3] = sar12_stimulus[1]
let sar12_stimulus[4] = 0.000119503
let sar12_stimulus[5] = sar12_drive
let sar12_stimulus[6] = 0.000148
let sar12_stimulus[7] = sar12_stimulus[5]
alter @VD_B7[pwl] = sar12_stimulus
let sar12_drive = (floor(sar12_trial / 256) - 2*floor(sar12_trial / 512))*1.8
let sar12_previous = @VD_B8[pwl]
let sar12_stimulus = vector(8)
let sar12_stimulus[0] = 0
let sar12_stimulus[1] = sar12_previous[length(sar12_previous)-1]
let sar12_stimulus[2] = 0.000119501
let sar12_stimulus[3] = sar12_stimulus[1]
let sar12_stimulus[4] = 0.000119503
let sar12_stimulus[5] = sar12_drive
let sar12_stimulus[6] = 0.000148
let sar12_stimulus[7] = sar12_stimulus[5]
alter @VD_B8[pwl] = sar12_stimulus
let sar12_drive = (floor(sar12_trial / 512) - 2*floor(sar12_trial / 1024))*1.8
let sar12_previous = @VD_B9[pwl]
let sar12_stimulus = vector(8)
let sar12_stimulus[0] = 0
let sar12_stimulus[1] = sar12_previous[length(sar12_previous)-1]
let sar12_stimulus[2] = 0.000119501
let sar12_stimulus[3] = sar12_stimulus[1]
let sar12_stimulus[4] = 0.000119503
let sar12_stimulus[5] = sar12_drive
let sar12_stimulus[6] = 0.000148
let sar12_stimulus[7] = sar12_stimulus[5]
alter @VD_B9[pwl] = sar12_stimulus
let sar12_drive = (floor(sar12_trial / 1024) - 2*floor(sar12_trial / 2048))*1.8
let sar12_previous = @VD_B10[pwl]
let sar12_stimulus = vector(8)
let sar12_stimulus[0] = 0
let sar12_stimulus[1] = sar12_previous[length(sar12_previous)-1]
let sar12_stimulus[2] = 0.000119501
let sar12_stimulus[3] = sar12_stimulus[1]
let sar12_stimulus[4] = 0.000119503
let sar12_stimulus[5] = sar12_drive
let sar12_stimulus[6] = 0.000148
let sar12_stimulus[7] = sar12_stimulus[5]
alter @VD_B10[pwl] = sar12_stimulus
let sar12_drive = (floor(sar12_trial / 2048) - 2*floor(sar12_trial / 4096))*1.8
let sar12_previous = @VD_B11[pwl]
let sar12_stimulus = vector(8)
let sar12_stimulus[0] = 0
let sar12_stimulus[1] = sar12_previous[length(sar12_previous)-1]
let sar12_stimulus[2] = 0.000119501
let sar12_stimulus[3] = sar12_stimulus[1]
let sar12_stimulus[4] = 0.000119503
let sar12_stimulus[5] = sar12_drive
let sar12_stimulus[6] = 0.000148
let sar12_stimulus[7] = sar12_stimulus[5]
alter @VD_B11[pwl] = sar12_stimulus
let sar12_drive = (floor(sar12_trial / 4096) - 2*floor(sar12_trial / 8192))*1.8
let sar12_previous = @VD_B12[pwl]
let sar12_stimulus = vector(8)
let sar12_stimulus[0] = 0
let sar12_stimulus[1] = sar12_previous[length(sar12_previous)-1]
let sar12_stimulus[2] = 0.000119501
let sar12_stimulus[3] = sar12_stimulus[1]
let sar12_stimulus[4] = 0.000119503
let sar12_stimulus[5] = sar12_drive
let sar12_stimulus[6] = 0.000148
let sar12_stimulus[7] = sar12_stimulus[5]
alter @VD_B12[pwl] = sar12_stimulus
let sar12_drive = (floor(sar12_trial / 8192) - 2*floor(sar12_trial / 16384))*1.8
let sar12_previous = @VD_B13[pwl]
let sar12_stimulus = vector(8)
let sar12_stimulus[0] = 0
let sar12_stimulus[1] = sar12_previous[length(sar12_previous)-1]
let sar12_stimulus[2] = 0.000119501
let sar12_stimulus[3] = sar12_stimulus[1]
let sar12_stimulus[4] = 0.000119503
let sar12_stimulus[5] = sar12_drive
let sar12_stimulus[6] = 0.000148
let sar12_stimulus[7] = sar12_stimulus[5]
alter @VD_B13[pwl] = sar12_stimulus
let sar12_drive = (floor(sar12_trial / 16384) - 2*floor(sar12_trial / 32768))*1.8
let sar12_previous = @VD_B14[pwl]
let sar12_stimulus = vector(8)
let sar12_stimulus[0] = 0
let sar12_stimulus[1] = sar12_previous[length(sar12_previous)-1]
let sar12_stimulus[2] = 0.000119501
let sar12_stimulus[3] = sar12_stimulus[1]
let sar12_stimulus[4] = 0.000119503
let sar12_stimulus[5] = sar12_drive
let sar12_stimulus[6] = 0.000148
let sar12_stimulus[7] = sar12_stimulus[5]
alter @VD_B14[pwl] = sar12_stimulus
let sar12_drive = (floor(sar12_trial / 32768) - 2*floor(sar12_trial / 65536))*1.8
let sar12_previous = @VD_B15[pwl]
let sar12_stimulus = vector(8)
let sar12_stimulus[0] = 0
let sar12_stimulus[1] = sar12_previous[length(sar12_previous)-1]
let sar12_stimulus[2] = 0.000119501
let sar12_stimulus[3] = sar12_stimulus[1]
let sar12_stimulus[4] = 0.000119503
let sar12_stimulus[5] = sar12_drive
let sar12_stimulus[6] = 0.000148
let sar12_stimulus[7] = sar12_stimulus[5]
alter @VD_B15[pwl] = sar12_stimulus
resume
let sar12_k = length(time)-1
if abs(time[sar12_k] - 0.00012) > 1e-12
print time[sar12_k]
echo expected_pause_time_s 0.00012
echo SAR12_PAUSE_FAILED
quit 1
end
print time[sar12_k] >> pause-times.txt
let sar12_previous = @VD_EVAL[pwl]
let sar12_stimulus = vector(8)
let sar12_stimulus[0] = 0
let sar12_stimulus[1] = sar12_previous[length(sar12_previous)-1]
let sar12_stimulus[2] = 0.000120001
let sar12_stimulus[3] = sar12_stimulus[1]
let sar12_stimulus[4] = 0.000120003
let sar12_stimulus[5] = 1.8
let sar12_stimulus[6] = 0.000148
let sar12_stimulus[7] = sar12_stimulus[5]
alter @VD_EVAL[pwl] = sar12_stimulus
resume
let sar12_k = length(time)-1
if abs(time[sar12_k] - 0.0001205) > 1e-12
print time[sar12_k]
echo expected_pause_time_s 0.0001205
echo SAR12_PAUSE_FAILED
quit 1
end
print time[sar12_k] >> pause-times.txt
let sar12_k = length(time)-1
let sar12_cmp = v(COMP)[sar12_k]
let sar12_cmpn = v(COMPN)[sar12_k]
let sar12_p = v(TOPP)[sar12_k]
let sar12_n = v(TOPN)[sar12_k]
let sar12_decision = 0
if sar12_cmp >= 0.9
let sar12_code = sar12_trial
let sar12_decision = 1
end
echo 4 2 $&sar12_trial $&sar12_cmp $&sar12_cmpn $&sar12_p $&sar12_n 1.19994506835937 $&sar12_decision >> decisions.csv
let sar12_previous = @VD_EVAL[pwl]
let sar12_stimulus = vector(8)
let sar12_stimulus[0] = 0
let sar12_stimulus[1] = sar12_previous[length(sar12_previous)-1]
let sar12_stimulus[2] = 0.000120501
let sar12_stimulus[3] = sar12_stimulus[1]
let sar12_stimulus[4] = 0.000120503
let sar12_stimulus[5] = 0
let sar12_stimulus[6] = 0.000148
let sar12_stimulus[7] = sar12_stimulus[5]
alter @VD_EVAL[pwl] = sar12_stimulus
let sar12_trial = sar12_code + 2
let sar12_drive = (floor(sar12_trial / 1) - 2*floor(sar12_trial / 2))*1.8
let sar12_previous = @VD_B0[pwl]
let sar12_stimulus = vector(8)
let sar12_stimulus[0] = 0
let sar12_stimulus[1] = sar12_previous[length(sar12_previous)-1]
let sar12_stimulus[2] = 0.000120501
let sar12_stimulus[3] = sar12_stimulus[1]
let sar12_stimulus[4] = 0.000120503
let sar12_stimulus[5] = sar12_drive
let sar12_stimulus[6] = 0.000148
let sar12_stimulus[7] = sar12_stimulus[5]
alter @VD_B0[pwl] = sar12_stimulus
let sar12_drive = (floor(sar12_trial / 2) - 2*floor(sar12_trial / 4))*1.8
let sar12_previous = @VD_B1[pwl]
let sar12_stimulus = vector(8)
let sar12_stimulus[0] = 0
let sar12_stimulus[1] = sar12_previous[length(sar12_previous)-1]
let sar12_stimulus[2] = 0.000120501
let sar12_stimulus[3] = sar12_stimulus[1]
let sar12_stimulus[4] = 0.000120503
let sar12_stimulus[5] = sar12_drive
let sar12_stimulus[6] = 0.000148
let sar12_stimulus[7] = sar12_stimulus[5]
alter @VD_B1[pwl] = sar12_stimulus
let sar12_drive = (floor(sar12_trial / 4) - 2*floor(sar12_trial / 8))*1.8
let sar12_previous = @VD_B2[pwl]
let sar12_stimulus = vector(8)
let sar12_stimulus[0] = 0
let sar12_stimulus[1] = sar12_previous[length(sar12_previous)-1]
let sar12_stimulus[2] = 0.000120501
let sar12_stimulus[3] = sar12_stimulus[1]
let sar12_stimulus[4] = 0.000120503
let sar12_stimulus[5] = sar12_drive
let sar12_stimulus[6] = 0.000148
let sar12_stimulus[7] = sar12_stimulus[5]
alter @VD_B2[pwl] = sar12_stimulus
let sar12_drive = (floor(sar12_trial / 8) - 2*floor(sar12_trial / 16))*1.8
let sar12_previous = @VD_B3[pwl]
let sar12_stimulus = vector(8)
let sar12_stimulus[0] = 0
let sar12_stimulus[1] = sar12_previous[length(sar12_previous)-1]
let sar12_stimulus[2] = 0.000120501
let sar12_stimulus[3] = sar12_stimulus[1]
let sar12_stimulus[4] = 0.000120503
let sar12_stimulus[5] = sar12_drive
let sar12_stimulus[6] = 0.000148
let sar12_stimulus[7] = sar12_stimulus[5]
alter @VD_B3[pwl] = sar12_stimulus
let sar12_drive = (floor(sar12_trial / 16) - 2*floor(sar12_trial / 32))*1.8
let sar12_previous = @VD_B4[pwl]
let sar12_stimulus = vector(8)
let sar12_stimulus[0] = 0
let sar12_stimulus[1] = sar12_previous[length(sar12_previous)-1]
let sar12_stimulus[2] = 0.000120501
let sar12_stimulus[3] = sar12_stimulus[1]
let sar12_stimulus[4] = 0.000120503
let sar12_stimulus[5] = sar12_drive
let sar12_stimulus[6] = 0.000148
let sar12_stimulus[7] = sar12_stimulus[5]
alter @VD_B4[pwl] = sar12_stimulus
let sar12_drive = (floor(sar12_trial / 32) - 2*floor(sar12_trial / 64))*1.8
let sar12_previous = @VD_B5[pwl]
let sar12_stimulus = vector(8)
let sar12_stimulus[0] = 0
let sar12_stimulus[1] = sar12_previous[length(sar12_previous)-1]
let sar12_stimulus[2] = 0.000120501
let sar12_stimulus[3] = sar12_stimulus[1]
let sar12_stimulus[4] = 0.000120503
let sar12_stimulus[5] = sar12_drive
let sar12_stimulus[6] = 0.000148
let sar12_stimulus[7] = sar12_stimulus[5]
alter @VD_B5[pwl] = sar12_stimulus
let sar12_drive = (floor(sar12_trial / 64) - 2*floor(sar12_trial / 128))*1.8
let sar12_previous = @VD_B6[pwl]
let sar12_stimulus = vector(8)
let sar12_stimulus[0] = 0
let sar12_stimulus[1] = sar12_previous[length(sar12_previous)-1]
let sar12_stimulus[2] = 0.000120501
let sar12_stimulus[3] = sar12_stimulus[1]
let sar12_stimulus[4] = 0.000120503
let sar12_stimulus[5] = sar12_drive
let sar12_stimulus[6] = 0.000148
let sar12_stimulus[7] = sar12_stimulus[5]
alter @VD_B6[pwl] = sar12_stimulus
let sar12_drive = (floor(sar12_trial / 128) - 2*floor(sar12_trial / 256))*1.8
let sar12_previous = @VD_B7[pwl]
let sar12_stimulus = vector(8)
let sar12_stimulus[0] = 0
let sar12_stimulus[1] = sar12_previous[length(sar12_previous)-1]
let sar12_stimulus[2] = 0.000120501
let sar12_stimulus[3] = sar12_stimulus[1]
let sar12_stimulus[4] = 0.000120503
let sar12_stimulus[5] = sar12_drive
let sar12_stimulus[6] = 0.000148
let sar12_stimulus[7] = sar12_stimulus[5]
alter @VD_B7[pwl] = sar12_stimulus
let sar12_drive = (floor(sar12_trial / 256) - 2*floor(sar12_trial / 512))*1.8
let sar12_previous = @VD_B8[pwl]
let sar12_stimulus = vector(8)
let sar12_stimulus[0] = 0
let sar12_stimulus[1] = sar12_previous[length(sar12_previous)-1]
let sar12_stimulus[2] = 0.000120501
let sar12_stimulus[3] = sar12_stimulus[1]
let sar12_stimulus[4] = 0.000120503
let sar12_stimulus[5] = sar12_drive
let sar12_stimulus[6] = 0.000148
let sar12_stimulus[7] = sar12_stimulus[5]
alter @VD_B8[pwl] = sar12_stimulus
let sar12_drive = (floor(sar12_trial / 512) - 2*floor(sar12_trial / 1024))*1.8
let sar12_previous = @VD_B9[pwl]
let sar12_stimulus = vector(8)
let sar12_stimulus[0] = 0
let sar12_stimulus[1] = sar12_previous[length(sar12_previous)-1]
let sar12_stimulus[2] = 0.000120501
let sar12_stimulus[3] = sar12_stimulus[1]
let sar12_stimulus[4] = 0.000120503
let sar12_stimulus[5] = sar12_drive
let sar12_stimulus[6] = 0.000148
let sar12_stimulus[7] = sar12_stimulus[5]
alter @VD_B9[pwl] = sar12_stimulus
let sar12_drive = (floor(sar12_trial / 1024) - 2*floor(sar12_trial / 2048))*1.8
let sar12_previous = @VD_B10[pwl]
let sar12_stimulus = vector(8)
let sar12_stimulus[0] = 0
let sar12_stimulus[1] = sar12_previous[length(sar12_previous)-1]
let sar12_stimulus[2] = 0.000120501
let sar12_stimulus[3] = sar12_stimulus[1]
let sar12_stimulus[4] = 0.000120503
let sar12_stimulus[5] = sar12_drive
let sar12_stimulus[6] = 0.000148
let sar12_stimulus[7] = sar12_stimulus[5]
alter @VD_B10[pwl] = sar12_stimulus
let sar12_drive = (floor(sar12_trial / 2048) - 2*floor(sar12_trial / 4096))*1.8
let sar12_previous = @VD_B11[pwl]
let sar12_stimulus = vector(8)
let sar12_stimulus[0] = 0
let sar12_stimulus[1] = sar12_previous[length(sar12_previous)-1]
let sar12_stimulus[2] = 0.000120501
let sar12_stimulus[3] = sar12_stimulus[1]
let sar12_stimulus[4] = 0.000120503
let sar12_stimulus[5] = sar12_drive
let sar12_stimulus[6] = 0.000148
let sar12_stimulus[7] = sar12_stimulus[5]
alter @VD_B11[pwl] = sar12_stimulus
let sar12_drive = (floor(sar12_trial / 4096) - 2*floor(sar12_trial / 8192))*1.8
let sar12_previous = @VD_B12[pwl]
let sar12_stimulus = vector(8)
let sar12_stimulus[0] = 0
let sar12_stimulus[1] = sar12_previous[length(sar12_previous)-1]
let sar12_stimulus[2] = 0.000120501
let sar12_stimulus[3] = sar12_stimulus[1]
let sar12_stimulus[4] = 0.000120503
let sar12_stimulus[5] = sar12_drive
let sar12_stimulus[6] = 0.000148
let sar12_stimulus[7] = sar12_stimulus[5]
alter @VD_B12[pwl] = sar12_stimulus
let sar12_drive = (floor(sar12_trial / 8192) - 2*floor(sar12_trial / 16384))*1.8
let sar12_previous = @VD_B13[pwl]
let sar12_stimulus = vector(8)
let sar12_stimulus[0] = 0
let sar12_stimulus[1] = sar12_previous[length(sar12_previous)-1]
let sar12_stimulus[2] = 0.000120501
let sar12_stimulus[3] = sar12_stimulus[1]
let sar12_stimulus[4] = 0.000120503
let sar12_stimulus[5] = sar12_drive
let sar12_stimulus[6] = 0.000148
let sar12_stimulus[7] = sar12_stimulus[5]
alter @VD_B13[pwl] = sar12_stimulus
let sar12_drive = (floor(sar12_trial / 16384) - 2*floor(sar12_trial / 32768))*1.8
let sar12_previous = @VD_B14[pwl]
let sar12_stimulus = vector(8)
let sar12_stimulus[0] = 0
let sar12_stimulus[1] = sar12_previous[length(sar12_previous)-1]
let sar12_stimulus[2] = 0.000120501
let sar12_stimulus[3] = sar12_stimulus[1]
let sar12_stimulus[4] = 0.000120503
let sar12_stimulus[5] = sar12_drive
let sar12_stimulus[6] = 0.000148
let sar12_stimulus[7] = sar12_stimulus[5]
alter @VD_B14[pwl] = sar12_stimulus
let sar12_drive = (floor(sar12_trial / 32768) - 2*floor(sar12_trial / 65536))*1.8
let sar12_previous = @VD_B15[pwl]
let sar12_stimulus = vector(8)
let sar12_stimulus[0] = 0
let sar12_stimulus[1] = sar12_previous[length(sar12_previous)-1]
let sar12_stimulus[2] = 0.000120501
let sar12_stimulus[3] = sar12_stimulus[1]
let sar12_stimulus[4] = 0.000120503
let sar12_stimulus[5] = sar12_drive
let sar12_stimulus[6] = 0.000148
let sar12_stimulus[7] = sar12_stimulus[5]
alter @VD_B15[pwl] = sar12_stimulus
resume
let sar12_k = length(time)-1
if abs(time[sar12_k] - 0.000121) > 1e-12
print time[sar12_k]
echo expected_pause_time_s 0.000121
echo SAR12_PAUSE_FAILED
quit 1
end
print time[sar12_k] >> pause-times.txt
let sar12_previous = @VD_EVAL[pwl]
let sar12_stimulus = vector(8)
let sar12_stimulus[0] = 0
let sar12_stimulus[1] = sar12_previous[length(sar12_previous)-1]
let sar12_stimulus[2] = 0.000121001
let sar12_stimulus[3] = sar12_stimulus[1]
let sar12_stimulus[4] = 0.000121003
let sar12_stimulus[5] = 1.8
let sar12_stimulus[6] = 0.000148
let sar12_stimulus[7] = sar12_stimulus[5]
alter @VD_EVAL[pwl] = sar12_stimulus
resume
let sar12_k = length(time)-1
if abs(time[sar12_k] - 0.0001215) > 1e-12
print time[sar12_k]
echo expected_pause_time_s 0.0001215
echo SAR12_PAUSE_FAILED
quit 1
end
print time[sar12_k] >> pause-times.txt
let sar12_k = length(time)-1
let sar12_cmp = v(COMP)[sar12_k]
let sar12_cmpn = v(COMPN)[sar12_k]
let sar12_p = v(TOPP)[sar12_k]
let sar12_n = v(TOPN)[sar12_k]
let sar12_decision = 0
if sar12_cmp >= 0.9
let sar12_code = sar12_trial
let sar12_decision = 1
end
echo 4 1 $&sar12_trial $&sar12_cmp $&sar12_cmpn $&sar12_p $&sar12_n 1.19994506835937 $&sar12_decision >> decisions.csv
let sar12_previous = @VD_EVAL[pwl]
let sar12_stimulus = vector(8)
let sar12_stimulus[0] = 0
let sar12_stimulus[1] = sar12_previous[length(sar12_previous)-1]
let sar12_stimulus[2] = 0.000121501
let sar12_stimulus[3] = sar12_stimulus[1]
let sar12_stimulus[4] = 0.000121503
let sar12_stimulus[5] = 0
let sar12_stimulus[6] = 0.000148
let sar12_stimulus[7] = sar12_stimulus[5]
alter @VD_EVAL[pwl] = sar12_stimulus
let sar12_trial = sar12_code + 1
let sar12_drive = (floor(sar12_trial / 1) - 2*floor(sar12_trial / 2))*1.8
let sar12_previous = @VD_B0[pwl]
let sar12_stimulus = vector(8)
let sar12_stimulus[0] = 0
let sar12_stimulus[1] = sar12_previous[length(sar12_previous)-1]
let sar12_stimulus[2] = 0.000121501
let sar12_stimulus[3] = sar12_stimulus[1]
let sar12_stimulus[4] = 0.000121503
let sar12_stimulus[5] = sar12_drive
let sar12_stimulus[6] = 0.000148
let sar12_stimulus[7] = sar12_stimulus[5]
alter @VD_B0[pwl] = sar12_stimulus
let sar12_drive = (floor(sar12_trial / 2) - 2*floor(sar12_trial / 4))*1.8
let sar12_previous = @VD_B1[pwl]
let sar12_stimulus = vector(8)
let sar12_stimulus[0] = 0
let sar12_stimulus[1] = sar12_previous[length(sar12_previous)-1]
let sar12_stimulus[2] = 0.000121501
let sar12_stimulus[3] = sar12_stimulus[1]
let sar12_stimulus[4] = 0.000121503
let sar12_stimulus[5] = sar12_drive
let sar12_stimulus[6] = 0.000148
let sar12_stimulus[7] = sar12_stimulus[5]
alter @VD_B1[pwl] = sar12_stimulus
let sar12_drive = (floor(sar12_trial / 4) - 2*floor(sar12_trial / 8))*1.8
let sar12_previous = @VD_B2[pwl]
let sar12_stimulus = vector(8)
let sar12_stimulus[0] = 0
let sar12_stimulus[1] = sar12_previous[length(sar12_previous)-1]
let sar12_stimulus[2] = 0.000121501
let sar12_stimulus[3] = sar12_stimulus[1]
let sar12_stimulus[4] = 0.000121503
let sar12_stimulus[5] = sar12_drive
let sar12_stimulus[6] = 0.000148
let sar12_stimulus[7] = sar12_stimulus[5]
alter @VD_B2[pwl] = sar12_stimulus
let sar12_drive = (floor(sar12_trial / 8) - 2*floor(sar12_trial / 16))*1.8
let sar12_previous = @VD_B3[pwl]
let sar12_stimulus = vector(8)
let sar12_stimulus[0] = 0
let sar12_stimulus[1] = sar12_previous[length(sar12_previous)-1]
let sar12_stimulus[2] = 0.000121501
let sar12_stimulus[3] = sar12_stimulus[1]
let sar12_stimulus[4] = 0.000121503
let sar12_stimulus[5] = sar12_drive
let sar12_stimulus[6] = 0.000148
let sar12_stimulus[7] = sar12_stimulus[5]
alter @VD_B3[pwl] = sar12_stimulus
let sar12_drive = (floor(sar12_trial / 16) - 2*floor(sar12_trial / 32))*1.8
let sar12_previous = @VD_B4[pwl]
let sar12_stimulus = vector(8)
let sar12_stimulus[0] = 0
let sar12_stimulus[1] = sar12_previous[length(sar12_previous)-1]
let sar12_stimulus[2] = 0.000121501
let sar12_stimulus[3] = sar12_stimulus[1]
let sar12_stimulus[4] = 0.000121503
let sar12_stimulus[5] = sar12_drive
let sar12_stimulus[6] = 0.000148
let sar12_stimulus[7] = sar12_stimulus[5]
alter @VD_B4[pwl] = sar12_stimulus
let sar12_drive = (floor(sar12_trial / 32) - 2*floor(sar12_trial / 64))*1.8
let sar12_previous = @VD_B5[pwl]
let sar12_stimulus = vector(8)
let sar12_stimulus[0] = 0
let sar12_stimulus[1] = sar12_previous[length(sar12_previous)-1]
let sar12_stimulus[2] = 0.000121501
let sar12_stimulus[3] = sar12_stimulus[1]
let sar12_stimulus[4] = 0.000121503
let sar12_stimulus[5] = sar12_drive
let sar12_stimulus[6] = 0.000148
let sar12_stimulus[7] = sar12_stimulus[5]
alter @VD_B5[pwl] = sar12_stimulus
let sar12_drive = (floor(sar12_trial / 64) - 2*floor(sar12_trial / 128))*1.8
let sar12_previous = @VD_B6[pwl]
let sar12_stimulus = vector(8)
let sar12_stimulus[0] = 0
let sar12_stimulus[1] = sar12_previous[length(sar12_previous)-1]
let sar12_stimulus[2] = 0.000121501
let sar12_stimulus[3] = sar12_stimulus[1]
let sar12_stimulus[4] = 0.000121503
let sar12_stimulus[5] = sar12_drive
let sar12_stimulus[6] = 0.000148
let sar12_stimulus[7] = sar12_stimulus[5]
alter @VD_B6[pwl] = sar12_stimulus
let sar12_drive = (floor(sar12_trial / 128) - 2*floor(sar12_trial / 256))*1.8
let sar12_previous = @VD_B7[pwl]
let sar12_stimulus = vector(8)
let sar12_stimulus[0] = 0
let sar12_stimulus[1] = sar12_previous[length(sar12_previous)-1]
let sar12_stimulus[2] = 0.000121501
let sar12_stimulus[3] = sar12_stimulus[1]
let sar12_stimulus[4] = 0.000121503
let sar12_stimulus[5] = sar12_drive
let sar12_stimulus[6] = 0.000148
let sar12_stimulus[7] = sar12_stimulus[5]
alter @VD_B7[pwl] = sar12_stimulus
let sar12_drive = (floor(sar12_trial / 256) - 2*floor(sar12_trial / 512))*1.8
let sar12_previous = @VD_B8[pwl]
let sar12_stimulus = vector(8)
let sar12_stimulus[0] = 0
let sar12_stimulus[1] = sar12_previous[length(sar12_previous)-1]
let sar12_stimulus[2] = 0.000121501
let sar12_stimulus[3] = sar12_stimulus[1]
let sar12_stimulus[4] = 0.000121503
let sar12_stimulus[5] = sar12_drive
let sar12_stimulus[6] = 0.000148
let sar12_stimulus[7] = sar12_stimulus[5]
alter @VD_B8[pwl] = sar12_stimulus
let sar12_drive = (floor(sar12_trial / 512) - 2*floor(sar12_trial / 1024))*1.8
let sar12_previous = @VD_B9[pwl]
let sar12_stimulus = vector(8)
let sar12_stimulus[0] = 0
let sar12_stimulus[1] = sar12_previous[length(sar12_previous)-1]
let sar12_stimulus[2] = 0.000121501
let sar12_stimulus[3] = sar12_stimulus[1]
let sar12_stimulus[4] = 0.000121503
let sar12_stimulus[5] = sar12_drive
let sar12_stimulus[6] = 0.000148
let sar12_stimulus[7] = sar12_stimulus[5]
alter @VD_B9[pwl] = sar12_stimulus
let sar12_drive = (floor(sar12_trial / 1024) - 2*floor(sar12_trial / 2048))*1.8
let sar12_previous = @VD_B10[pwl]
let sar12_stimulus = vector(8)
let sar12_stimulus[0] = 0
let sar12_stimulus[1] = sar12_previous[length(sar12_previous)-1]
let sar12_stimulus[2] = 0.000121501
let sar12_stimulus[3] = sar12_stimulus[1]
let sar12_stimulus[4] = 0.000121503
let sar12_stimulus[5] = sar12_drive
let sar12_stimulus[6] = 0.000148
let sar12_stimulus[7] = sar12_stimulus[5]
alter @VD_B10[pwl] = sar12_stimulus
let sar12_drive = (floor(sar12_trial / 2048) - 2*floor(sar12_trial / 4096))*1.8
let sar12_previous = @VD_B11[pwl]
let sar12_stimulus = vector(8)
let sar12_stimulus[0] = 0
let sar12_stimulus[1] = sar12_previous[length(sar12_previous)-1]
let sar12_stimulus[2] = 0.000121501
let sar12_stimulus[3] = sar12_stimulus[1]
let sar12_stimulus[4] = 0.000121503
let sar12_stimulus[5] = sar12_drive
let sar12_stimulus[6] = 0.000148
let sar12_stimulus[7] = sar12_stimulus[5]
alter @VD_B11[pwl] = sar12_stimulus
let sar12_drive = (floor(sar12_trial / 4096) - 2*floor(sar12_trial / 8192))*1.8
let sar12_previous = @VD_B12[pwl]
let sar12_stimulus = vector(8)
let sar12_stimulus[0] = 0
let sar12_stimulus[1] = sar12_previous[length(sar12_previous)-1]
let sar12_stimulus[2] = 0.000121501
let sar12_stimulus[3] = sar12_stimulus[1]
let sar12_stimulus[4] = 0.000121503
let sar12_stimulus[5] = sar12_drive
let sar12_stimulus[6] = 0.000148
let sar12_stimulus[7] = sar12_stimulus[5]
alter @VD_B12[pwl] = sar12_stimulus
let sar12_drive = (floor(sar12_trial / 8192) - 2*floor(sar12_trial / 16384))*1.8
let sar12_previous = @VD_B13[pwl]
let sar12_stimulus = vector(8)
let sar12_stimulus[0] = 0
let sar12_stimulus[1] = sar12_previous[length(sar12_previous)-1]
let sar12_stimulus[2] = 0.000121501
let sar12_stimulus[3] = sar12_stimulus[1]
let sar12_stimulus[4] = 0.000121503
let sar12_stimulus[5] = sar12_drive
let sar12_stimulus[6] = 0.000148
let sar12_stimulus[7] = sar12_stimulus[5]
alter @VD_B13[pwl] = sar12_stimulus
let sar12_drive = (floor(sar12_trial / 16384) - 2*floor(sar12_trial / 32768))*1.8
let sar12_previous = @VD_B14[pwl]
let sar12_stimulus = vector(8)
let sar12_stimulus[0] = 0
let sar12_stimulus[1] = sar12_previous[length(sar12_previous)-1]
let sar12_stimulus[2] = 0.000121501
let sar12_stimulus[3] = sar12_stimulus[1]
let sar12_stimulus[4] = 0.000121503
let sar12_stimulus[5] = sar12_drive
let sar12_stimulus[6] = 0.000148
let sar12_stimulus[7] = sar12_stimulus[5]
alter @VD_B14[pwl] = sar12_stimulus
let sar12_drive = (floor(sar12_trial / 32768) - 2*floor(sar12_trial / 65536))*1.8
let sar12_previous = @VD_B15[pwl]
let sar12_stimulus = vector(8)
let sar12_stimulus[0] = 0
let sar12_stimulus[1] = sar12_previous[length(sar12_previous)-1]
let sar12_stimulus[2] = 0.000121501
let sar12_stimulus[3] = sar12_stimulus[1]
let sar12_stimulus[4] = 0.000121503
let sar12_stimulus[5] = sar12_drive
let sar12_stimulus[6] = 0.000148
let sar12_stimulus[7] = sar12_stimulus[5]
alter @VD_B15[pwl] = sar12_stimulus
resume
let sar12_k = length(time)-1
if abs(time[sar12_k] - 0.000122) > 1e-12
print time[sar12_k]
echo expected_pause_time_s 0.000122
echo SAR12_PAUSE_FAILED
quit 1
end
print time[sar12_k] >> pause-times.txt
let sar12_previous = @VD_EVAL[pwl]
let sar12_stimulus = vector(8)
let sar12_stimulus[0] = 0
let sar12_stimulus[1] = sar12_previous[length(sar12_previous)-1]
let sar12_stimulus[2] = 0.000122001
let sar12_stimulus[3] = sar12_stimulus[1]
let sar12_stimulus[4] = 0.000122003
let sar12_stimulus[5] = 1.8
let sar12_stimulus[6] = 0.000148
let sar12_stimulus[7] = sar12_stimulus[5]
alter @VD_EVAL[pwl] = sar12_stimulus
resume
let sar12_k = length(time)-1
if abs(time[sar12_k] - 0.0001225) > 1e-12
print time[sar12_k]
echo expected_pause_time_s 0.0001225
echo SAR12_PAUSE_FAILED
quit 1
end
print time[sar12_k] >> pause-times.txt
let sar12_k = length(time)-1
let sar12_cmp = v(COMP)[sar12_k]
let sar12_cmpn = v(COMPN)[sar12_k]
let sar12_p = v(TOPP)[sar12_k]
let sar12_n = v(TOPN)[sar12_k]
let sar12_decision = 0
if sar12_cmp >= 0.9
let sar12_code = sar12_trial
let sar12_decision = 1
end
echo 4 0 $&sar12_trial $&sar12_cmp $&sar12_cmpn $&sar12_p $&sar12_n 1.19994506835937 $&sar12_decision >> decisions.csv
let sar12_previous = @VD_EVAL[pwl]
let sar12_stimulus = vector(8)
let sar12_stimulus[0] = 0
let sar12_stimulus[1] = sar12_previous[length(sar12_previous)-1]
let sar12_stimulus[2] = 0.000122501
let sar12_stimulus[3] = sar12_stimulus[1]
let sar12_stimulus[4] = 0.000122503
let sar12_stimulus[5] = 0
let sar12_stimulus[6] = 0.000148
let sar12_stimulus[7] = sar12_stimulus[5]
alter @VD_EVAL[pwl] = sar12_stimulus
let sar12_previous = @VINP[pwl]
let sar12_stimulus = vector(8)
let sar12_stimulus[0] = 0
let sar12_stimulus[1] = sar12_previous[length(sar12_previous)-1]
let sar12_stimulus[2] = 0.000122501
let sar12_stimulus[3] = sar12_stimulus[1]
let sar12_stimulus[4] = 0.000122503
let sar12_stimulus[5] = 1.49999084473
let sar12_stimulus[6] = 0.000148
let sar12_stimulus[7] = sar12_stimulus[5]
alter @VINP[pwl] = sar12_stimulus
let sar12_previous = @VINN[pwl]
let sar12_stimulus = vector(8)
let sar12_stimulus[0] = 0
let sar12_stimulus[1] = sar12_previous[length(sar12_previous)-1]
let sar12_stimulus[2] = 0.000122501
let sar12_stimulus[3] = sar12_stimulus[1]
let sar12_stimulus[4] = 0.000122503
let sar12_stimulus[5] = 0.300009155273
let sar12_stimulus[6] = 0.000148
let sar12_stimulus[7] = sar12_stimulus[5]
alter @VINN[pwl] = sar12_stimulus
let sar12_previous = @VD_SAMPLE[pwl]
let sar12_stimulus = vector(8)
let sar12_stimulus[0] = 0
let sar12_stimulus[1] = sar12_previous[length(sar12_previous)-1]
let sar12_stimulus[2] = 0.000122501
let sar12_stimulus[3] = sar12_stimulus[1]
let sar12_stimulus[4] = 0.000122503
let sar12_stimulus[5] = 1.8
let sar12_stimulus[6] = 0.000148
let sar12_stimulus[7] = sar12_stimulus[5]
alter @VD_SAMPLE[pwl] = sar12_stimulus
let sar12_previous = @VD_EVAL[pwl]
let sar12_stimulus = vector(8)
let sar12_stimulus[0] = 0
let sar12_stimulus[1] = sar12_previous[length(sar12_previous)-1]
let sar12_stimulus[2] = 0.000122501
let sar12_stimulus[3] = sar12_stimulus[1]
let sar12_stimulus[4] = 0.000122503
let sar12_stimulus[5] = 0
let sar12_stimulus[6] = 0.000148
let sar12_stimulus[7] = sar12_stimulus[5]
alter @VD_EVAL[pwl] = sar12_stimulus
let sar12_previous = @VD_B0[pwl]
let sar12_stimulus = vector(8)
let sar12_stimulus[0] = 0
let sar12_stimulus[1] = sar12_previous[length(sar12_previous)-1]
let sar12_stimulus[2] = 0.000122501
let sar12_stimulus[3] = sar12_stimulus[1]
let sar12_stimulus[4] = 0.000122503
let sar12_stimulus[5] = 0
let sar12_stimulus[6] = 0.000148
let sar12_stimulus[7] = sar12_stimulus[5]
alter @VD_B0[pwl] = sar12_stimulus
let sar12_previous = @VD_B1[pwl]
let sar12_stimulus = vector(8)
let sar12_stimulus[0] = 0
let sar12_stimulus[1] = sar12_previous[length(sar12_previous)-1]
let sar12_stimulus[2] = 0.000122501
let sar12_stimulus[3] = sar12_stimulus[1]
let sar12_stimulus[4] = 0.000122503
let sar12_stimulus[5] = 0
let sar12_stimulus[6] = 0.000148
let sar12_stimulus[7] = sar12_stimulus[5]
alter @VD_B1[pwl] = sar12_stimulus
let sar12_previous = @VD_B2[pwl]
let sar12_stimulus = vector(8)
let sar12_stimulus[0] = 0
let sar12_stimulus[1] = sar12_previous[length(sar12_previous)-1]
let sar12_stimulus[2] = 0.000122501
let sar12_stimulus[3] = sar12_stimulus[1]
let sar12_stimulus[4] = 0.000122503
let sar12_stimulus[5] = 0
let sar12_stimulus[6] = 0.000148
let sar12_stimulus[7] = sar12_stimulus[5]
alter @VD_B2[pwl] = sar12_stimulus
let sar12_previous = @VD_B3[pwl]
let sar12_stimulus = vector(8)
let sar12_stimulus[0] = 0
let sar12_stimulus[1] = sar12_previous[length(sar12_previous)-1]
let sar12_stimulus[2] = 0.000122501
let sar12_stimulus[3] = sar12_stimulus[1]
let sar12_stimulus[4] = 0.000122503
let sar12_stimulus[5] = 0
let sar12_stimulus[6] = 0.000148
let sar12_stimulus[7] = sar12_stimulus[5]
alter @VD_B3[pwl] = sar12_stimulus
let sar12_previous = @VD_B4[pwl]
let sar12_stimulus = vector(8)
let sar12_stimulus[0] = 0
let sar12_stimulus[1] = sar12_previous[length(sar12_previous)-1]
let sar12_stimulus[2] = 0.000122501
let sar12_stimulus[3] = sar12_stimulus[1]
let sar12_stimulus[4] = 0.000122503
let sar12_stimulus[5] = 0
let sar12_stimulus[6] = 0.000148
let sar12_stimulus[7] = sar12_stimulus[5]
alter @VD_B4[pwl] = sar12_stimulus
let sar12_previous = @VD_B5[pwl]
let sar12_stimulus = vector(8)
let sar12_stimulus[0] = 0
let sar12_stimulus[1] = sar12_previous[length(sar12_previous)-1]
let sar12_stimulus[2] = 0.000122501
let sar12_stimulus[3] = sar12_stimulus[1]
let sar12_stimulus[4] = 0.000122503
let sar12_stimulus[5] = 0
let sar12_stimulus[6] = 0.000148
let sar12_stimulus[7] = sar12_stimulus[5]
alter @VD_B5[pwl] = sar12_stimulus
let sar12_previous = @VD_B6[pwl]
let sar12_stimulus = vector(8)
let sar12_stimulus[0] = 0
let sar12_stimulus[1] = sar12_previous[length(sar12_previous)-1]
let sar12_stimulus[2] = 0.000122501
let sar12_stimulus[3] = sar12_stimulus[1]
let sar12_stimulus[4] = 0.000122503
let sar12_stimulus[5] = 0
let sar12_stimulus[6] = 0.000148
let sar12_stimulus[7] = sar12_stimulus[5]
alter @VD_B6[pwl] = sar12_stimulus
let sar12_previous = @VD_B7[pwl]
let sar12_stimulus = vector(8)
let sar12_stimulus[0] = 0
let sar12_stimulus[1] = sar12_previous[length(sar12_previous)-1]
let sar12_stimulus[2] = 0.000122501
let sar12_stimulus[3] = sar12_stimulus[1]
let sar12_stimulus[4] = 0.000122503
let sar12_stimulus[5] = 0
let sar12_stimulus[6] = 0.000148
let sar12_stimulus[7] = sar12_stimulus[5]
alter @VD_B7[pwl] = sar12_stimulus
let sar12_previous = @VD_B8[pwl]
let sar12_stimulus = vector(8)
let sar12_stimulus[0] = 0
let sar12_stimulus[1] = sar12_previous[length(sar12_previous)-1]
let sar12_stimulus[2] = 0.000122501
let sar12_stimulus[3] = sar12_stimulus[1]
let sar12_stimulus[4] = 0.000122503
let sar12_stimulus[5] = 0
let sar12_stimulus[6] = 0.000148
let sar12_stimulus[7] = sar12_stimulus[5]
alter @VD_B8[pwl] = sar12_stimulus
let sar12_previous = @VD_B9[pwl]
let sar12_stimulus = vector(8)
let sar12_stimulus[0] = 0
let sar12_stimulus[1] = sar12_previous[length(sar12_previous)-1]
let sar12_stimulus[2] = 0.000122501
let sar12_stimulus[3] = sar12_stimulus[1]
let sar12_stimulus[4] = 0.000122503
let sar12_stimulus[5] = 0
let sar12_stimulus[6] = 0.000148
let sar12_stimulus[7] = sar12_stimulus[5]
alter @VD_B9[pwl] = sar12_stimulus
let sar12_previous = @VD_B10[pwl]
let sar12_stimulus = vector(8)
let sar12_stimulus[0] = 0
let sar12_stimulus[1] = sar12_previous[length(sar12_previous)-1]
let sar12_stimulus[2] = 0.000122501
let sar12_stimulus[3] = sar12_stimulus[1]
let sar12_stimulus[4] = 0.000122503
let sar12_stimulus[5] = 0
let sar12_stimulus[6] = 0.000148
let sar12_stimulus[7] = sar12_stimulus[5]
alter @VD_B10[pwl] = sar12_stimulus
let sar12_previous = @VD_B11[pwl]
let sar12_stimulus = vector(8)
let sar12_stimulus[0] = 0
let sar12_stimulus[1] = sar12_previous[length(sar12_previous)-1]
let sar12_stimulus[2] = 0.000122501
let sar12_stimulus[3] = sar12_stimulus[1]
let sar12_stimulus[4] = 0.000122503
let sar12_stimulus[5] = 0
let sar12_stimulus[6] = 0.000148
let sar12_stimulus[7] = sar12_stimulus[5]
alter @VD_B11[pwl] = sar12_stimulus
let sar12_previous = @VD_B12[pwl]
let sar12_stimulus = vector(8)
let sar12_stimulus[0] = 0
let sar12_stimulus[1] = sar12_previous[length(sar12_previous)-1]
let sar12_stimulus[2] = 0.000122501
let sar12_stimulus[3] = sar12_stimulus[1]
let sar12_stimulus[4] = 0.000122503
let sar12_stimulus[5] = 0
let sar12_stimulus[6] = 0.000148
let sar12_stimulus[7] = sar12_stimulus[5]
alter @VD_B12[pwl] = sar12_stimulus
let sar12_previous = @VD_B13[pwl]
let sar12_stimulus = vector(8)
let sar12_stimulus[0] = 0
let sar12_stimulus[1] = sar12_previous[length(sar12_previous)-1]
let sar12_stimulus[2] = 0.000122501
let sar12_stimulus[3] = sar12_stimulus[1]
let sar12_stimulus[4] = 0.000122503
let sar12_stimulus[5] = 0
let sar12_stimulus[6] = 0.000148
let sar12_stimulus[7] = sar12_stimulus[5]
alter @VD_B13[pwl] = sar12_stimulus
let sar12_previous = @VD_B14[pwl]
let sar12_stimulus = vector(8)
let sar12_stimulus[0] = 0
let sar12_stimulus[1] = sar12_previous[length(sar12_previous)-1]
let sar12_stimulus[2] = 0.000122501
let sar12_stimulus[3] = sar12_stimulus[1]
let sar12_stimulus[4] = 0.000122503
let sar12_stimulus[5] = 0
let sar12_stimulus[6] = 0.000148
let sar12_stimulus[7] = sar12_stimulus[5]
alter @VD_B14[pwl] = sar12_stimulus
let sar12_previous = @VD_B15[pwl]
let sar12_stimulus = vector(8)
let sar12_stimulus[0] = 0
let sar12_stimulus[1] = sar12_previous[length(sar12_previous)-1]
let sar12_stimulus[2] = 0.000122501
let sar12_stimulus[3] = sar12_stimulus[1]
let sar12_stimulus[4] = 0.000122503
let sar12_stimulus[5] = 0
let sar12_stimulus[6] = 0.000148
let sar12_stimulus[7] = sar12_stimulus[5]
alter @VD_B15[pwl] = sar12_stimulus
let sar12_code = 0
resume
let sar12_k = length(time)-1
if abs(time[sar12_k] - 0.0001305) > 1e-12
print time[sar12_k]
echo expected_pause_time_s 0.0001305
echo SAR12_PAUSE_FAILED
quit 1
end
print time[sar12_k] >> pause-times.txt
let sar12_previous = @VD_SAMPLE[pwl]
let sar12_stimulus = vector(8)
let sar12_stimulus[0] = 0
let sar12_stimulus[1] = sar12_previous[length(sar12_previous)-1]
let sar12_stimulus[2] = 0.000130501
let sar12_stimulus[3] = sar12_stimulus[1]
let sar12_stimulus[4] = 0.000130503
let sar12_stimulus[5] = 0
let sar12_stimulus[6] = 0.000148
let sar12_stimulus[7] = sar12_stimulus[5]
alter @VD_SAMPLE[pwl] = sar12_stimulus
resume
let sar12_k = length(time)-1
if abs(time[sar12_k] - 0.000131) > 1e-12
print time[sar12_k]
echo expected_pause_time_s 0.000131
echo SAR12_PAUSE_FAILED
quit 1
end
print time[sar12_k] >> pause-times.txt
let sar12_previous = @VD_EVAL[pwl]
let sar12_stimulus = vector(8)
let sar12_stimulus[0] = 0
let sar12_stimulus[1] = sar12_previous[length(sar12_previous)-1]
let sar12_stimulus[2] = 0.000131001
let sar12_stimulus[3] = sar12_stimulus[1]
let sar12_stimulus[4] = 0.000131003
let sar12_stimulus[5] = 0
let sar12_stimulus[6] = 0.000148
let sar12_stimulus[7] = sar12_stimulus[5]
alter @VD_EVAL[pwl] = sar12_stimulus
let sar12_trial = sar12_code + 32768
let sar12_drive = (floor(sar12_trial / 1) - 2*floor(sar12_trial / 2))*1.8
let sar12_previous = @VD_B0[pwl]
let sar12_stimulus = vector(8)
let sar12_stimulus[0] = 0
let sar12_stimulus[1] = sar12_previous[length(sar12_previous)-1]
let sar12_stimulus[2] = 0.000131001
let sar12_stimulus[3] = sar12_stimulus[1]
let sar12_stimulus[4] = 0.000131003
let sar12_stimulus[5] = sar12_drive
let sar12_stimulus[6] = 0.000148
let sar12_stimulus[7] = sar12_stimulus[5]
alter @VD_B0[pwl] = sar12_stimulus
let sar12_drive = (floor(sar12_trial / 2) - 2*floor(sar12_trial / 4))*1.8
let sar12_previous = @VD_B1[pwl]
let sar12_stimulus = vector(8)
let sar12_stimulus[0] = 0
let sar12_stimulus[1] = sar12_previous[length(sar12_previous)-1]
let sar12_stimulus[2] = 0.000131001
let sar12_stimulus[3] = sar12_stimulus[1]
let sar12_stimulus[4] = 0.000131003
let sar12_stimulus[5] = sar12_drive
let sar12_stimulus[6] = 0.000148
let sar12_stimulus[7] = sar12_stimulus[5]
alter @VD_B1[pwl] = sar12_stimulus
let sar12_drive = (floor(sar12_trial / 4) - 2*floor(sar12_trial / 8))*1.8
let sar12_previous = @VD_B2[pwl]
let sar12_stimulus = vector(8)
let sar12_stimulus[0] = 0
let sar12_stimulus[1] = sar12_previous[length(sar12_previous)-1]
let sar12_stimulus[2] = 0.000131001
let sar12_stimulus[3] = sar12_stimulus[1]
let sar12_stimulus[4] = 0.000131003
let sar12_stimulus[5] = sar12_drive
let sar12_stimulus[6] = 0.000148
let sar12_stimulus[7] = sar12_stimulus[5]
alter @VD_B2[pwl] = sar12_stimulus
let sar12_drive = (floor(sar12_trial / 8) - 2*floor(sar12_trial / 16))*1.8
let sar12_previous = @VD_B3[pwl]
let sar12_stimulus = vector(8)
let sar12_stimulus[0] = 0
let sar12_stimulus[1] = sar12_previous[length(sar12_previous)-1]
let sar12_stimulus[2] = 0.000131001
let sar12_stimulus[3] = sar12_stimulus[1]
let sar12_stimulus[4] = 0.000131003
let sar12_stimulus[5] = sar12_drive
let sar12_stimulus[6] = 0.000148
let sar12_stimulus[7] = sar12_stimulus[5]
alter @VD_B3[pwl] = sar12_stimulus
let sar12_drive = (floor(sar12_trial / 16) - 2*floor(sar12_trial / 32))*1.8
let sar12_previous = @VD_B4[pwl]
let sar12_stimulus = vector(8)
let sar12_stimulus[0] = 0
let sar12_stimulus[1] = sar12_previous[length(sar12_previous)-1]
let sar12_stimulus[2] = 0.000131001
let sar12_stimulus[3] = sar12_stimulus[1]
let sar12_stimulus[4] = 0.000131003
let sar12_stimulus[5] = sar12_drive
let sar12_stimulus[6] = 0.000148
let sar12_stimulus[7] = sar12_stimulus[5]
alter @VD_B4[pwl] = sar12_stimulus
let sar12_drive = (floor(sar12_trial / 32) - 2*floor(sar12_trial / 64))*1.8
let sar12_previous = @VD_B5[pwl]
let sar12_stimulus = vector(8)
let sar12_stimulus[0] = 0
let sar12_stimulus[1] = sar12_previous[length(sar12_previous)-1]
let sar12_stimulus[2] = 0.000131001
let sar12_stimulus[3] = sar12_stimulus[1]
let sar12_stimulus[4] = 0.000131003
let sar12_stimulus[5] = sar12_drive
let sar12_stimulus[6] = 0.000148
let sar12_stimulus[7] = sar12_stimulus[5]
alter @VD_B5[pwl] = sar12_stimulus
let sar12_drive = (floor(sar12_trial / 64) - 2*floor(sar12_trial / 128))*1.8
let sar12_previous = @VD_B6[pwl]
let sar12_stimulus = vector(8)
let sar12_stimulus[0] = 0
let sar12_stimulus[1] = sar12_previous[length(sar12_previous)-1]
let sar12_stimulus[2] = 0.000131001
let sar12_stimulus[3] = sar12_stimulus[1]
let sar12_stimulus[4] = 0.000131003
let sar12_stimulus[5] = sar12_drive
let sar12_stimulus[6] = 0.000148
let sar12_stimulus[7] = sar12_stimulus[5]
alter @VD_B6[pwl] = sar12_stimulus
let sar12_drive = (floor(sar12_trial / 128) - 2*floor(sar12_trial / 256))*1.8
let sar12_previous = @VD_B7[pwl]
let sar12_stimulus = vector(8)
let sar12_stimulus[0] = 0
let sar12_stimulus[1] = sar12_previous[length(sar12_previous)-1]
let sar12_stimulus[2] = 0.000131001
let sar12_stimulus[3] = sar12_stimulus[1]
let sar12_stimulus[4] = 0.000131003
let sar12_stimulus[5] = sar12_drive
let sar12_stimulus[6] = 0.000148
let sar12_stimulus[7] = sar12_stimulus[5]
alter @VD_B7[pwl] = sar12_stimulus
let sar12_drive = (floor(sar12_trial / 256) - 2*floor(sar12_trial / 512))*1.8
let sar12_previous = @VD_B8[pwl]
let sar12_stimulus = vector(8)
let sar12_stimulus[0] = 0
let sar12_stimulus[1] = sar12_previous[length(sar12_previous)-1]
let sar12_stimulus[2] = 0.000131001
let sar12_stimulus[3] = sar12_stimulus[1]
let sar12_stimulus[4] = 0.000131003
let sar12_stimulus[5] = sar12_drive
let sar12_stimulus[6] = 0.000148
let sar12_stimulus[7] = sar12_stimulus[5]
alter @VD_B8[pwl] = sar12_stimulus
let sar12_drive = (floor(sar12_trial / 512) - 2*floor(sar12_trial / 1024))*1.8
let sar12_previous = @VD_B9[pwl]
let sar12_stimulus = vector(8)
let sar12_stimulus[0] = 0
let sar12_stimulus[1] = sar12_previous[length(sar12_previous)-1]
let sar12_stimulus[2] = 0.000131001
let sar12_stimulus[3] = sar12_stimulus[1]
let sar12_stimulus[4] = 0.000131003
let sar12_stimulus[5] = sar12_drive
let sar12_stimulus[6] = 0.000148
let sar12_stimulus[7] = sar12_stimulus[5]
alter @VD_B9[pwl] = sar12_stimulus
let sar12_drive = (floor(sar12_trial / 1024) - 2*floor(sar12_trial / 2048))*1.8
let sar12_previous = @VD_B10[pwl]
let sar12_stimulus = vector(8)
let sar12_stimulus[0] = 0
let sar12_stimulus[1] = sar12_previous[length(sar12_previous)-1]
let sar12_stimulus[2] = 0.000131001
let sar12_stimulus[3] = sar12_stimulus[1]
let sar12_stimulus[4] = 0.000131003
let sar12_stimulus[5] = sar12_drive
let sar12_stimulus[6] = 0.000148
let sar12_stimulus[7] = sar12_stimulus[5]
alter @VD_B10[pwl] = sar12_stimulus
let sar12_drive = (floor(sar12_trial / 2048) - 2*floor(sar12_trial / 4096))*1.8
let sar12_previous = @VD_B11[pwl]
let sar12_stimulus = vector(8)
let sar12_stimulus[0] = 0
let sar12_stimulus[1] = sar12_previous[length(sar12_previous)-1]
let sar12_stimulus[2] = 0.000131001
let sar12_stimulus[3] = sar12_stimulus[1]
let sar12_stimulus[4] = 0.000131003
let sar12_stimulus[5] = sar12_drive
let sar12_stimulus[6] = 0.000148
let sar12_stimulus[7] = sar12_stimulus[5]
alter @VD_B11[pwl] = sar12_stimulus
let sar12_drive = (floor(sar12_trial / 4096) - 2*floor(sar12_trial / 8192))*1.8
let sar12_previous = @VD_B12[pwl]
let sar12_stimulus = vector(8)
let sar12_stimulus[0] = 0
let sar12_stimulus[1] = sar12_previous[length(sar12_previous)-1]
let sar12_stimulus[2] = 0.000131001
let sar12_stimulus[3] = sar12_stimulus[1]
let sar12_stimulus[4] = 0.000131003
let sar12_stimulus[5] = sar12_drive
let sar12_stimulus[6] = 0.000148
let sar12_stimulus[7] = sar12_stimulus[5]
alter @VD_B12[pwl] = sar12_stimulus
let sar12_drive = (floor(sar12_trial / 8192) - 2*floor(sar12_trial / 16384))*1.8
let sar12_previous = @VD_B13[pwl]
let sar12_stimulus = vector(8)
let sar12_stimulus[0] = 0
let sar12_stimulus[1] = sar12_previous[length(sar12_previous)-1]
let sar12_stimulus[2] = 0.000131001
let sar12_stimulus[3] = sar12_stimulus[1]
let sar12_stimulus[4] = 0.000131003
let sar12_stimulus[5] = sar12_drive
let sar12_stimulus[6] = 0.000148
let sar12_stimulus[7] = sar12_stimulus[5]
alter @VD_B13[pwl] = sar12_stimulus
let sar12_drive = (floor(sar12_trial / 16384) - 2*floor(sar12_trial / 32768))*1.8
let sar12_previous = @VD_B14[pwl]
let sar12_stimulus = vector(8)
let sar12_stimulus[0] = 0
let sar12_stimulus[1] = sar12_previous[length(sar12_previous)-1]
let sar12_stimulus[2] = 0.000131001
let sar12_stimulus[3] = sar12_stimulus[1]
let sar12_stimulus[4] = 0.000131003
let sar12_stimulus[5] = sar12_drive
let sar12_stimulus[6] = 0.000148
let sar12_stimulus[7] = sar12_stimulus[5]
alter @VD_B14[pwl] = sar12_stimulus
let sar12_drive = (floor(sar12_trial / 32768) - 2*floor(sar12_trial / 65536))*1.8
let sar12_previous = @VD_B15[pwl]
let sar12_stimulus = vector(8)
let sar12_stimulus[0] = 0
let sar12_stimulus[1] = sar12_previous[length(sar12_previous)-1]
let sar12_stimulus[2] = 0.000131001
let sar12_stimulus[3] = sar12_stimulus[1]
let sar12_stimulus[4] = 0.000131003
let sar12_stimulus[5] = sar12_drive
let sar12_stimulus[6] = 0.000148
let sar12_stimulus[7] = sar12_stimulus[5]
alter @VD_B15[pwl] = sar12_stimulus
resume
let sar12_k = length(time)-1
if abs(time[sar12_k] - 0.0001315) > 1e-12
print time[sar12_k]
echo expected_pause_time_s 0.0001315
echo SAR12_PAUSE_FAILED
quit 1
end
print time[sar12_k] >> pause-times.txt
let sar12_previous = @VD_EVAL[pwl]
let sar12_stimulus = vector(8)
let sar12_stimulus[0] = 0
let sar12_stimulus[1] = sar12_previous[length(sar12_previous)-1]
let sar12_stimulus[2] = 0.000131501
let sar12_stimulus[3] = sar12_stimulus[1]
let sar12_stimulus[4] = 0.000131503
let sar12_stimulus[5] = 1.8
let sar12_stimulus[6] = 0.000148
let sar12_stimulus[7] = sar12_stimulus[5]
alter @VD_EVAL[pwl] = sar12_stimulus
resume
let sar12_k = length(time)-1
if abs(time[sar12_k] - 0.000132) > 1e-12
print time[sar12_k]
echo expected_pause_time_s 0.000132
echo SAR12_PAUSE_FAILED
quit 1
end
print time[sar12_k] >> pause-times.txt
let sar12_k = length(time)-1
let sar12_cmp = v(COMP)[sar12_k]
let sar12_cmpn = v(COMPN)[sar12_k]
let sar12_p = v(TOPP)[sar12_k]
let sar12_n = v(TOPN)[sar12_k]
let sar12_decision = 0
if sar12_cmp >= 0.9
let sar12_code = sar12_trial
let sar12_decision = 1
end
echo 5 15 $&sar12_trial $&sar12_cmp $&sar12_cmpn $&sar12_p $&sar12_n 1.19998168945312 $&sar12_decision >> decisions.csv
let sar12_previous = @VD_EVAL[pwl]
let sar12_stimulus = vector(8)
let sar12_stimulus[0] = 0
let sar12_stimulus[1] = sar12_previous[length(sar12_previous)-1]
let sar12_stimulus[2] = 0.000132001
let sar12_stimulus[3] = sar12_stimulus[1]
let sar12_stimulus[4] = 0.000132003
let sar12_stimulus[5] = 0
let sar12_stimulus[6] = 0.000148
let sar12_stimulus[7] = sar12_stimulus[5]
alter @VD_EVAL[pwl] = sar12_stimulus
let sar12_trial = sar12_code + 16384
let sar12_drive = (floor(sar12_trial / 1) - 2*floor(sar12_trial / 2))*1.8
let sar12_previous = @VD_B0[pwl]
let sar12_stimulus = vector(8)
let sar12_stimulus[0] = 0
let sar12_stimulus[1] = sar12_previous[length(sar12_previous)-1]
let sar12_stimulus[2] = 0.000132001
let sar12_stimulus[3] = sar12_stimulus[1]
let sar12_stimulus[4] = 0.000132003
let sar12_stimulus[5] = sar12_drive
let sar12_stimulus[6] = 0.000148
let sar12_stimulus[7] = sar12_stimulus[5]
alter @VD_B0[pwl] = sar12_stimulus
let sar12_drive = (floor(sar12_trial / 2) - 2*floor(sar12_trial / 4))*1.8
let sar12_previous = @VD_B1[pwl]
let sar12_stimulus = vector(8)
let sar12_stimulus[0] = 0
let sar12_stimulus[1] = sar12_previous[length(sar12_previous)-1]
let sar12_stimulus[2] = 0.000132001
let sar12_stimulus[3] = sar12_stimulus[1]
let sar12_stimulus[4] = 0.000132003
let sar12_stimulus[5] = sar12_drive
let sar12_stimulus[6] = 0.000148
let sar12_stimulus[7] = sar12_stimulus[5]
alter @VD_B1[pwl] = sar12_stimulus
let sar12_drive = (floor(sar12_trial / 4) - 2*floor(sar12_trial / 8))*1.8
let sar12_previous = @VD_B2[pwl]
let sar12_stimulus = vector(8)
let sar12_stimulus[0] = 0
let sar12_stimulus[1] = sar12_previous[length(sar12_previous)-1]
let sar12_stimulus[2] = 0.000132001
let sar12_stimulus[3] = sar12_stimulus[1]
let sar12_stimulus[4] = 0.000132003
let sar12_stimulus[5] = sar12_drive
let sar12_stimulus[6] = 0.000148
let sar12_stimulus[7] = sar12_stimulus[5]
alter @VD_B2[pwl] = sar12_stimulus
let sar12_drive = (floor(sar12_trial / 8) - 2*floor(sar12_trial / 16))*1.8
let sar12_previous = @VD_B3[pwl]
let sar12_stimulus = vector(8)
let sar12_stimulus[0] = 0
let sar12_stimulus[1] = sar12_previous[length(sar12_previous)-1]
let sar12_stimulus[2] = 0.000132001
let sar12_stimulus[3] = sar12_stimulus[1]
let sar12_stimulus[4] = 0.000132003
let sar12_stimulus[5] = sar12_drive
let sar12_stimulus[6] = 0.000148
let sar12_stimulus[7] = sar12_stimulus[5]
alter @VD_B3[pwl] = sar12_stimulus
let sar12_drive = (floor(sar12_trial / 16) - 2*floor(sar12_trial / 32))*1.8
let sar12_previous = @VD_B4[pwl]
let sar12_stimulus = vector(8)
let sar12_stimulus[0] = 0
let sar12_stimulus[1] = sar12_previous[length(sar12_previous)-1]
let sar12_stimulus[2] = 0.000132001
let sar12_stimulus[3] = sar12_stimulus[1]
let sar12_stimulus[4] = 0.000132003
let sar12_stimulus[5] = sar12_drive
let sar12_stimulus[6] = 0.000148
let sar12_stimulus[7] = sar12_stimulus[5]
alter @VD_B4[pwl] = sar12_stimulus
let sar12_drive = (floor(sar12_trial / 32) - 2*floor(sar12_trial / 64))*1.8
let sar12_previous = @VD_B5[pwl]
let sar12_stimulus = vector(8)
let sar12_stimulus[0] = 0
let sar12_stimulus[1] = sar12_previous[length(sar12_previous)-1]
let sar12_stimulus[2] = 0.000132001
let sar12_stimulus[3] = sar12_stimulus[1]
let sar12_stimulus[4] = 0.000132003
let sar12_stimulus[5] = sar12_drive
let sar12_stimulus[6] = 0.000148
let sar12_stimulus[7] = sar12_stimulus[5]
alter @VD_B5[pwl] = sar12_stimulus
let sar12_drive = (floor(sar12_trial / 64) - 2*floor(sar12_trial / 128))*1.8
let sar12_previous = @VD_B6[pwl]
let sar12_stimulus = vector(8)
let sar12_stimulus[0] = 0
let sar12_stimulus[1] = sar12_previous[length(sar12_previous)-1]
let sar12_stimulus[2] = 0.000132001
let sar12_stimulus[3] = sar12_stimulus[1]
let sar12_stimulus[4] = 0.000132003
let sar12_stimulus[5] = sar12_drive
let sar12_stimulus[6] = 0.000148
let sar12_stimulus[7] = sar12_stimulus[5]
alter @VD_B6[pwl] = sar12_stimulus
let sar12_drive = (floor(sar12_trial / 128) - 2*floor(sar12_trial / 256))*1.8
let sar12_previous = @VD_B7[pwl]
let sar12_stimulus = vector(8)
let sar12_stimulus[0] = 0
let sar12_stimulus[1] = sar12_previous[length(sar12_previous)-1]
let sar12_stimulus[2] = 0.000132001
let sar12_stimulus[3] = sar12_stimulus[1]
let sar12_stimulus[4] = 0.000132003
let sar12_stimulus[5] = sar12_drive
let sar12_stimulus[6] = 0.000148
let sar12_stimulus[7] = sar12_stimulus[5]
alter @VD_B7[pwl] = sar12_stimulus
let sar12_drive = (floor(sar12_trial / 256) - 2*floor(sar12_trial / 512))*1.8
let sar12_previous = @VD_B8[pwl]
let sar12_stimulus = vector(8)
let sar12_stimulus[0] = 0
let sar12_stimulus[1] = sar12_previous[length(sar12_previous)-1]
let sar12_stimulus[2] = 0.000132001
let sar12_stimulus[3] = sar12_stimulus[1]
let sar12_stimulus[4] = 0.000132003
let sar12_stimulus[5] = sar12_drive
let sar12_stimulus[6] = 0.000148
let sar12_stimulus[7] = sar12_stimulus[5]
alter @VD_B8[pwl] = sar12_stimulus
let sar12_drive = (floor(sar12_trial / 512) - 2*floor(sar12_trial / 1024))*1.8
let sar12_previous = @VD_B9[pwl]
let sar12_stimulus = vector(8)
let sar12_stimulus[0] = 0
let sar12_stimulus[1] = sar12_previous[length(sar12_previous)-1]
let sar12_stimulus[2] = 0.000132001
let sar12_stimulus[3] = sar12_stimulus[1]
let sar12_stimulus[4] = 0.000132003
let sar12_stimulus[5] = sar12_drive
let sar12_stimulus[6] = 0.000148
let sar12_stimulus[7] = sar12_stimulus[5]
alter @VD_B9[pwl] = sar12_stimulus
let sar12_drive = (floor(sar12_trial / 1024) - 2*floor(sar12_trial / 2048))*1.8
let sar12_previous = @VD_B10[pwl]
let sar12_stimulus = vector(8)
let sar12_stimulus[0] = 0
let sar12_stimulus[1] = sar12_previous[length(sar12_previous)-1]
let sar12_stimulus[2] = 0.000132001
let sar12_stimulus[3] = sar12_stimulus[1]
let sar12_stimulus[4] = 0.000132003
let sar12_stimulus[5] = sar12_drive
let sar12_stimulus[6] = 0.000148
let sar12_stimulus[7] = sar12_stimulus[5]
alter @VD_B10[pwl] = sar12_stimulus
let sar12_drive = (floor(sar12_trial / 2048) - 2*floor(sar12_trial / 4096))*1.8
let sar12_previous = @VD_B11[pwl]
let sar12_stimulus = vector(8)
let sar12_stimulus[0] = 0
let sar12_stimulus[1] = sar12_previous[length(sar12_previous)-1]
let sar12_stimulus[2] = 0.000132001
let sar12_stimulus[3] = sar12_stimulus[1]
let sar12_stimulus[4] = 0.000132003
let sar12_stimulus[5] = sar12_drive
let sar12_stimulus[6] = 0.000148
let sar12_stimulus[7] = sar12_stimulus[5]
alter @VD_B11[pwl] = sar12_stimulus
let sar12_drive = (floor(sar12_trial / 4096) - 2*floor(sar12_trial / 8192))*1.8
let sar12_previous = @VD_B12[pwl]
let sar12_stimulus = vector(8)
let sar12_stimulus[0] = 0
let sar12_stimulus[1] = sar12_previous[length(sar12_previous)-1]
let sar12_stimulus[2] = 0.000132001
let sar12_stimulus[3] = sar12_stimulus[1]
let sar12_stimulus[4] = 0.000132003
let sar12_stimulus[5] = sar12_drive
let sar12_stimulus[6] = 0.000148
let sar12_stimulus[7] = sar12_stimulus[5]
alter @VD_B12[pwl] = sar12_stimulus
let sar12_drive = (floor(sar12_trial / 8192) - 2*floor(sar12_trial / 16384))*1.8
let sar12_previous = @VD_B13[pwl]
let sar12_stimulus = vector(8)
let sar12_stimulus[0] = 0
let sar12_stimulus[1] = sar12_previous[length(sar12_previous)-1]
let sar12_stimulus[2] = 0.000132001
let sar12_stimulus[3] = sar12_stimulus[1]
let sar12_stimulus[4] = 0.000132003
let sar12_stimulus[5] = sar12_drive
let sar12_stimulus[6] = 0.000148
let sar12_stimulus[7] = sar12_stimulus[5]
alter @VD_B13[pwl] = sar12_stimulus
let sar12_drive = (floor(sar12_trial / 16384) - 2*floor(sar12_trial / 32768))*1.8
let sar12_previous = @VD_B14[pwl]
let sar12_stimulus = vector(8)
let sar12_stimulus[0] = 0
let sar12_stimulus[1] = sar12_previous[length(sar12_previous)-1]
let sar12_stimulus[2] = 0.000132001
let sar12_stimulus[3] = sar12_stimulus[1]
let sar12_stimulus[4] = 0.000132003
let sar12_stimulus[5] = sar12_drive
let sar12_stimulus[6] = 0.000148
let sar12_stimulus[7] = sar12_stimulus[5]
alter @VD_B14[pwl] = sar12_stimulus
let sar12_drive = (floor(sar12_trial / 32768) - 2*floor(sar12_trial / 65536))*1.8
let sar12_previous = @VD_B15[pwl]
let sar12_stimulus = vector(8)
let sar12_stimulus[0] = 0
let sar12_stimulus[1] = sar12_previous[length(sar12_previous)-1]
let sar12_stimulus[2] = 0.000132001
let sar12_stimulus[3] = sar12_stimulus[1]
let sar12_stimulus[4] = 0.000132003
let sar12_stimulus[5] = sar12_drive
let sar12_stimulus[6] = 0.000148
let sar12_stimulus[7] = sar12_stimulus[5]
alter @VD_B15[pwl] = sar12_stimulus
resume
let sar12_k = length(time)-1
if abs(time[sar12_k] - 0.0001325) > 1e-12
print time[sar12_k]
echo expected_pause_time_s 0.0001325
echo SAR12_PAUSE_FAILED
quit 1
end
print time[sar12_k] >> pause-times.txt
let sar12_previous = @VD_EVAL[pwl]
let sar12_stimulus = vector(8)
let sar12_stimulus[0] = 0
let sar12_stimulus[1] = sar12_previous[length(sar12_previous)-1]
let sar12_stimulus[2] = 0.000132501
let sar12_stimulus[3] = sar12_stimulus[1]
let sar12_stimulus[4] = 0.000132503
let sar12_stimulus[5] = 1.8
let sar12_stimulus[6] = 0.000148
let sar12_stimulus[7] = sar12_stimulus[5]
alter @VD_EVAL[pwl] = sar12_stimulus
resume
let sar12_k = length(time)-1
if abs(time[sar12_k] - 0.000133) > 1e-12
print time[sar12_k]
echo expected_pause_time_s 0.000133
echo SAR12_PAUSE_FAILED
quit 1
end
print time[sar12_k] >> pause-times.txt
let sar12_k = length(time)-1
let sar12_cmp = v(COMP)[sar12_k]
let sar12_cmpn = v(COMPN)[sar12_k]
let sar12_p = v(TOPP)[sar12_k]
let sar12_n = v(TOPN)[sar12_k]
let sar12_decision = 0
if sar12_cmp >= 0.9
let sar12_code = sar12_trial
let sar12_decision = 1
end
echo 5 14 $&sar12_trial $&sar12_cmp $&sar12_cmpn $&sar12_p $&sar12_n 1.19998168945312 $&sar12_decision >> decisions.csv
let sar12_previous = @VD_EVAL[pwl]
let sar12_stimulus = vector(8)
let sar12_stimulus[0] = 0
let sar12_stimulus[1] = sar12_previous[length(sar12_previous)-1]
let sar12_stimulus[2] = 0.000133001
let sar12_stimulus[3] = sar12_stimulus[1]
let sar12_stimulus[4] = 0.000133003
let sar12_stimulus[5] = 0
let sar12_stimulus[6] = 0.000148
let sar12_stimulus[7] = sar12_stimulus[5]
alter @VD_EVAL[pwl] = sar12_stimulus
let sar12_trial = sar12_code + 8192
let sar12_drive = (floor(sar12_trial / 1) - 2*floor(sar12_trial / 2))*1.8
let sar12_previous = @VD_B0[pwl]
let sar12_stimulus = vector(8)
let sar12_stimulus[0] = 0
let sar12_stimulus[1] = sar12_previous[length(sar12_previous)-1]
let sar12_stimulus[2] = 0.000133001
let sar12_stimulus[3] = sar12_stimulus[1]
let sar12_stimulus[4] = 0.000133003
let sar12_stimulus[5] = sar12_drive
let sar12_stimulus[6] = 0.000148
let sar12_stimulus[7] = sar12_stimulus[5]
alter @VD_B0[pwl] = sar12_stimulus
let sar12_drive = (floor(sar12_trial / 2) - 2*floor(sar12_trial / 4))*1.8
let sar12_previous = @VD_B1[pwl]
let sar12_stimulus = vector(8)
let sar12_stimulus[0] = 0
let sar12_stimulus[1] = sar12_previous[length(sar12_previous)-1]
let sar12_stimulus[2] = 0.000133001
let sar12_stimulus[3] = sar12_stimulus[1]
let sar12_stimulus[4] = 0.000133003
let sar12_stimulus[5] = sar12_drive
let sar12_stimulus[6] = 0.000148
let sar12_stimulus[7] = sar12_stimulus[5]
alter @VD_B1[pwl] = sar12_stimulus
let sar12_drive = (floor(sar12_trial / 4) - 2*floor(sar12_trial / 8))*1.8
let sar12_previous = @VD_B2[pwl]
let sar12_stimulus = vector(8)
let sar12_stimulus[0] = 0
let sar12_stimulus[1] = sar12_previous[length(sar12_previous)-1]
let sar12_stimulus[2] = 0.000133001
let sar12_stimulus[3] = sar12_stimulus[1]
let sar12_stimulus[4] = 0.000133003
let sar12_stimulus[5] = sar12_drive
let sar12_stimulus[6] = 0.000148
let sar12_stimulus[7] = sar12_stimulus[5]
alter @VD_B2[pwl] = sar12_stimulus
let sar12_drive = (floor(sar12_trial / 8) - 2*floor(sar12_trial / 16))*1.8
let sar12_previous = @VD_B3[pwl]
let sar12_stimulus = vector(8)
let sar12_stimulus[0] = 0
let sar12_stimulus[1] = sar12_previous[length(sar12_previous)-1]
let sar12_stimulus[2] = 0.000133001
let sar12_stimulus[3] = sar12_stimulus[1]
let sar12_stimulus[4] = 0.000133003
let sar12_stimulus[5] = sar12_drive
let sar12_stimulus[6] = 0.000148
let sar12_stimulus[7] = sar12_stimulus[5]
alter @VD_B3[pwl] = sar12_stimulus
let sar12_drive = (floor(sar12_trial / 16) - 2*floor(sar12_trial / 32))*1.8
let sar12_previous = @VD_B4[pwl]
let sar12_stimulus = vector(8)
let sar12_stimulus[0] = 0
let sar12_stimulus[1] = sar12_previous[length(sar12_previous)-1]
let sar12_stimulus[2] = 0.000133001
let sar12_stimulus[3] = sar12_stimulus[1]
let sar12_stimulus[4] = 0.000133003
let sar12_stimulus[5] = sar12_drive
let sar12_stimulus[6] = 0.000148
let sar12_stimulus[7] = sar12_stimulus[5]
alter @VD_B4[pwl] = sar12_stimulus
let sar12_drive = (floor(sar12_trial / 32) - 2*floor(sar12_trial / 64))*1.8
let sar12_previous = @VD_B5[pwl]
let sar12_stimulus = vector(8)
let sar12_stimulus[0] = 0
let sar12_stimulus[1] = sar12_previous[length(sar12_previous)-1]
let sar12_stimulus[2] = 0.000133001
let sar12_stimulus[3] = sar12_stimulus[1]
let sar12_stimulus[4] = 0.000133003
let sar12_stimulus[5] = sar12_drive
let sar12_stimulus[6] = 0.000148
let sar12_stimulus[7] = sar12_stimulus[5]
alter @VD_B5[pwl] = sar12_stimulus
let sar12_drive = (floor(sar12_trial / 64) - 2*floor(sar12_trial / 128))*1.8
let sar12_previous = @VD_B6[pwl]
let sar12_stimulus = vector(8)
let sar12_stimulus[0] = 0
let sar12_stimulus[1] = sar12_previous[length(sar12_previous)-1]
let sar12_stimulus[2] = 0.000133001
let sar12_stimulus[3] = sar12_stimulus[1]
let sar12_stimulus[4] = 0.000133003
let sar12_stimulus[5] = sar12_drive
let sar12_stimulus[6] = 0.000148
let sar12_stimulus[7] = sar12_stimulus[5]
alter @VD_B6[pwl] = sar12_stimulus
let sar12_drive = (floor(sar12_trial / 128) - 2*floor(sar12_trial / 256))*1.8
let sar12_previous = @VD_B7[pwl]
let sar12_stimulus = vector(8)
let sar12_stimulus[0] = 0
let sar12_stimulus[1] = sar12_previous[length(sar12_previous)-1]
let sar12_stimulus[2] = 0.000133001
let sar12_stimulus[3] = sar12_stimulus[1]
let sar12_stimulus[4] = 0.000133003
let sar12_stimulus[5] = sar12_drive
let sar12_stimulus[6] = 0.000148
let sar12_stimulus[7] = sar12_stimulus[5]
alter @VD_B7[pwl] = sar12_stimulus
let sar12_drive = (floor(sar12_trial / 256) - 2*floor(sar12_trial / 512))*1.8
let sar12_previous = @VD_B8[pwl]
let sar12_stimulus = vector(8)
let sar12_stimulus[0] = 0
let sar12_stimulus[1] = sar12_previous[length(sar12_previous)-1]
let sar12_stimulus[2] = 0.000133001
let sar12_stimulus[3] = sar12_stimulus[1]
let sar12_stimulus[4] = 0.000133003
let sar12_stimulus[5] = sar12_drive
let sar12_stimulus[6] = 0.000148
let sar12_stimulus[7] = sar12_stimulus[5]
alter @VD_B8[pwl] = sar12_stimulus
let sar12_drive = (floor(sar12_trial / 512) - 2*floor(sar12_trial / 1024))*1.8
let sar12_previous = @VD_B9[pwl]
let sar12_stimulus = vector(8)
let sar12_stimulus[0] = 0
let sar12_stimulus[1] = sar12_previous[length(sar12_previous)-1]
let sar12_stimulus[2] = 0.000133001
let sar12_stimulus[3] = sar12_stimulus[1]
let sar12_stimulus[4] = 0.000133003
let sar12_stimulus[5] = sar12_drive
let sar12_stimulus[6] = 0.000148
let sar12_stimulus[7] = sar12_stimulus[5]
alter @VD_B9[pwl] = sar12_stimulus
let sar12_drive = (floor(sar12_trial / 1024) - 2*floor(sar12_trial / 2048))*1.8
let sar12_previous = @VD_B10[pwl]
let sar12_stimulus = vector(8)
let sar12_stimulus[0] = 0
let sar12_stimulus[1] = sar12_previous[length(sar12_previous)-1]
let sar12_stimulus[2] = 0.000133001
let sar12_stimulus[3] = sar12_stimulus[1]
let sar12_stimulus[4] = 0.000133003
let sar12_stimulus[5] = sar12_drive
let sar12_stimulus[6] = 0.000148
let sar12_stimulus[7] = sar12_stimulus[5]
alter @VD_B10[pwl] = sar12_stimulus
let sar12_drive = (floor(sar12_trial / 2048) - 2*floor(sar12_trial / 4096))*1.8
let sar12_previous = @VD_B11[pwl]
let sar12_stimulus = vector(8)
let sar12_stimulus[0] = 0
let sar12_stimulus[1] = sar12_previous[length(sar12_previous)-1]
let sar12_stimulus[2] = 0.000133001
let sar12_stimulus[3] = sar12_stimulus[1]
let sar12_stimulus[4] = 0.000133003
let sar12_stimulus[5] = sar12_drive
let sar12_stimulus[6] = 0.000148
let sar12_stimulus[7] = sar12_stimulus[5]
alter @VD_B11[pwl] = sar12_stimulus
let sar12_drive = (floor(sar12_trial / 4096) - 2*floor(sar12_trial / 8192))*1.8
let sar12_previous = @VD_B12[pwl]
let sar12_stimulus = vector(8)
let sar12_stimulus[0] = 0
let sar12_stimulus[1] = sar12_previous[length(sar12_previous)-1]
let sar12_stimulus[2] = 0.000133001
let sar12_stimulus[3] = sar12_stimulus[1]
let sar12_stimulus[4] = 0.000133003
let sar12_stimulus[5] = sar12_drive
let sar12_stimulus[6] = 0.000148
let sar12_stimulus[7] = sar12_stimulus[5]
alter @VD_B12[pwl] = sar12_stimulus
let sar12_drive = (floor(sar12_trial / 8192) - 2*floor(sar12_trial / 16384))*1.8
let sar12_previous = @VD_B13[pwl]
let sar12_stimulus = vector(8)
let sar12_stimulus[0] = 0
let sar12_stimulus[1] = sar12_previous[length(sar12_previous)-1]
let sar12_stimulus[2] = 0.000133001
let sar12_stimulus[3] = sar12_stimulus[1]
let sar12_stimulus[4] = 0.000133003
let sar12_stimulus[5] = sar12_drive
let sar12_stimulus[6] = 0.000148
let sar12_stimulus[7] = sar12_stimulus[5]
alter @VD_B13[pwl] = sar12_stimulus
let sar12_drive = (floor(sar12_trial / 16384) - 2*floor(sar12_trial / 32768))*1.8
let sar12_previous = @VD_B14[pwl]
let sar12_stimulus = vector(8)
let sar12_stimulus[0] = 0
let sar12_stimulus[1] = sar12_previous[length(sar12_previous)-1]
let sar12_stimulus[2] = 0.000133001
let sar12_stimulus[3] = sar12_stimulus[1]
let sar12_stimulus[4] = 0.000133003
let sar12_stimulus[5] = sar12_drive
let sar12_stimulus[6] = 0.000148
let sar12_stimulus[7] = sar12_stimulus[5]
alter @VD_B14[pwl] = sar12_stimulus
let sar12_drive = (floor(sar12_trial / 32768) - 2*floor(sar12_trial / 65536))*1.8
let sar12_previous = @VD_B15[pwl]
let sar12_stimulus = vector(8)
let sar12_stimulus[0] = 0
let sar12_stimulus[1] = sar12_previous[length(sar12_previous)-1]
let sar12_stimulus[2] = 0.000133001
let sar12_stimulus[3] = sar12_stimulus[1]
let sar12_stimulus[4] = 0.000133003
let sar12_stimulus[5] = sar12_drive
let sar12_stimulus[6] = 0.000148
let sar12_stimulus[7] = sar12_stimulus[5]
alter @VD_B15[pwl] = sar12_stimulus
resume
let sar12_k = length(time)-1
if abs(time[sar12_k] - 0.0001335) > 1e-12
print time[sar12_k]
echo expected_pause_time_s 0.0001335
echo SAR12_PAUSE_FAILED
quit 1
end
print time[sar12_k] >> pause-times.txt
let sar12_previous = @VD_EVAL[pwl]
let sar12_stimulus = vector(8)
let sar12_stimulus[0] = 0
let sar12_stimulus[1] = sar12_previous[length(sar12_previous)-1]
let sar12_stimulus[2] = 0.000133501
let sar12_stimulus[3] = sar12_stimulus[1]
let sar12_stimulus[4] = 0.000133503
let sar12_stimulus[5] = 1.8
let sar12_stimulus[6] = 0.000148
let sar12_stimulus[7] = sar12_stimulus[5]
alter @VD_EVAL[pwl] = sar12_stimulus
resume
let sar12_k = length(time)-1
if abs(time[sar12_k] - 0.000134) > 1e-12
print time[sar12_k]
echo expected_pause_time_s 0.000134
echo SAR12_PAUSE_FAILED
quit 1
end
print time[sar12_k] >> pause-times.txt
let sar12_k = length(time)-1
let sar12_cmp = v(COMP)[sar12_k]
let sar12_cmpn = v(COMPN)[sar12_k]
let sar12_p = v(TOPP)[sar12_k]
let sar12_n = v(TOPN)[sar12_k]
let sar12_decision = 0
if sar12_cmp >= 0.9
let sar12_code = sar12_trial
let sar12_decision = 1
end
echo 5 13 $&sar12_trial $&sar12_cmp $&sar12_cmpn $&sar12_p $&sar12_n 1.19998168945312 $&sar12_decision >> decisions.csv
let sar12_previous = @VD_EVAL[pwl]
let sar12_stimulus = vector(8)
let sar12_stimulus[0] = 0
let sar12_stimulus[1] = sar12_previous[length(sar12_previous)-1]
let sar12_stimulus[2] = 0.000134001
let sar12_stimulus[3] = sar12_stimulus[1]
let sar12_stimulus[4] = 0.000134003
let sar12_stimulus[5] = 0
let sar12_stimulus[6] = 0.000148
let sar12_stimulus[7] = sar12_stimulus[5]
alter @VD_EVAL[pwl] = sar12_stimulus
let sar12_trial = sar12_code + 4096
let sar12_drive = (floor(sar12_trial / 1) - 2*floor(sar12_trial / 2))*1.8
let sar12_previous = @VD_B0[pwl]
let sar12_stimulus = vector(8)
let sar12_stimulus[0] = 0
let sar12_stimulus[1] = sar12_previous[length(sar12_previous)-1]
let sar12_stimulus[2] = 0.000134001
let sar12_stimulus[3] = sar12_stimulus[1]
let sar12_stimulus[4] = 0.000134003
let sar12_stimulus[5] = sar12_drive
let sar12_stimulus[6] = 0.000148
let sar12_stimulus[7] = sar12_stimulus[5]
alter @VD_B0[pwl] = sar12_stimulus
let sar12_drive = (floor(sar12_trial / 2) - 2*floor(sar12_trial / 4))*1.8
let sar12_previous = @VD_B1[pwl]
let sar12_stimulus = vector(8)
let sar12_stimulus[0] = 0
let sar12_stimulus[1] = sar12_previous[length(sar12_previous)-1]
let sar12_stimulus[2] = 0.000134001
let sar12_stimulus[3] = sar12_stimulus[1]
let sar12_stimulus[4] = 0.000134003
let sar12_stimulus[5] = sar12_drive
let sar12_stimulus[6] = 0.000148
let sar12_stimulus[7] = sar12_stimulus[5]
alter @VD_B1[pwl] = sar12_stimulus
let sar12_drive = (floor(sar12_trial / 4) - 2*floor(sar12_trial / 8))*1.8
let sar12_previous = @VD_B2[pwl]
let sar12_stimulus = vector(8)
let sar12_stimulus[0] = 0
let sar12_stimulus[1] = sar12_previous[length(sar12_previous)-1]
let sar12_stimulus[2] = 0.000134001
let sar12_stimulus[3] = sar12_stimulus[1]
let sar12_stimulus[4] = 0.000134003
let sar12_stimulus[5] = sar12_drive
let sar12_stimulus[6] = 0.000148
let sar12_stimulus[7] = sar12_stimulus[5]
alter @VD_B2[pwl] = sar12_stimulus
let sar12_drive = (floor(sar12_trial / 8) - 2*floor(sar12_trial / 16))*1.8
let sar12_previous = @VD_B3[pwl]
let sar12_stimulus = vector(8)
let sar12_stimulus[0] = 0
let sar12_stimulus[1] = sar12_previous[length(sar12_previous)-1]
let sar12_stimulus[2] = 0.000134001
let sar12_stimulus[3] = sar12_stimulus[1]
let sar12_stimulus[4] = 0.000134003
let sar12_stimulus[5] = sar12_drive
let sar12_stimulus[6] = 0.000148
let sar12_stimulus[7] = sar12_stimulus[5]
alter @VD_B3[pwl] = sar12_stimulus
let sar12_drive = (floor(sar12_trial / 16) - 2*floor(sar12_trial / 32))*1.8
let sar12_previous = @VD_B4[pwl]
let sar12_stimulus = vector(8)
let sar12_stimulus[0] = 0
let sar12_stimulus[1] = sar12_previous[length(sar12_previous)-1]
let sar12_stimulus[2] = 0.000134001
let sar12_stimulus[3] = sar12_stimulus[1]
let sar12_stimulus[4] = 0.000134003
let sar12_stimulus[5] = sar12_drive
let sar12_stimulus[6] = 0.000148
let sar12_stimulus[7] = sar12_stimulus[5]
alter @VD_B4[pwl] = sar12_stimulus
let sar12_drive = (floor(sar12_trial / 32) - 2*floor(sar12_trial / 64))*1.8
let sar12_previous = @VD_B5[pwl]
let sar12_stimulus = vector(8)
let sar12_stimulus[0] = 0
let sar12_stimulus[1] = sar12_previous[length(sar12_previous)-1]
let sar12_stimulus[2] = 0.000134001
let sar12_stimulus[3] = sar12_stimulus[1]
let sar12_stimulus[4] = 0.000134003
let sar12_stimulus[5] = sar12_drive
let sar12_stimulus[6] = 0.000148
let sar12_stimulus[7] = sar12_stimulus[5]
alter @VD_B5[pwl] = sar12_stimulus
let sar12_drive = (floor(sar12_trial / 64) - 2*floor(sar12_trial / 128))*1.8
let sar12_previous = @VD_B6[pwl]
let sar12_stimulus = vector(8)
let sar12_stimulus[0] = 0
let sar12_stimulus[1] = sar12_previous[length(sar12_previous)-1]
let sar12_stimulus[2] = 0.000134001
let sar12_stimulus[3] = sar12_stimulus[1]
let sar12_stimulus[4] = 0.000134003
let sar12_stimulus[5] = sar12_drive
let sar12_stimulus[6] = 0.000148
let sar12_stimulus[7] = sar12_stimulus[5]
alter @VD_B6[pwl] = sar12_stimulus
let sar12_drive = (floor(sar12_trial / 128) - 2*floor(sar12_trial / 256))*1.8
let sar12_previous = @VD_B7[pwl]
let sar12_stimulus = vector(8)
let sar12_stimulus[0] = 0
let sar12_stimulus[1] = sar12_previous[length(sar12_previous)-1]
let sar12_stimulus[2] = 0.000134001
let sar12_stimulus[3] = sar12_stimulus[1]
let sar12_stimulus[4] = 0.000134003
let sar12_stimulus[5] = sar12_drive
let sar12_stimulus[6] = 0.000148
let sar12_stimulus[7] = sar12_stimulus[5]
alter @VD_B7[pwl] = sar12_stimulus
let sar12_drive = (floor(sar12_trial / 256) - 2*floor(sar12_trial / 512))*1.8
let sar12_previous = @VD_B8[pwl]
let sar12_stimulus = vector(8)
let sar12_stimulus[0] = 0
let sar12_stimulus[1] = sar12_previous[length(sar12_previous)-1]
let sar12_stimulus[2] = 0.000134001
let sar12_stimulus[3] = sar12_stimulus[1]
let sar12_stimulus[4] = 0.000134003
let sar12_stimulus[5] = sar12_drive
let sar12_stimulus[6] = 0.000148
let sar12_stimulus[7] = sar12_stimulus[5]
alter @VD_B8[pwl] = sar12_stimulus
let sar12_drive = (floor(sar12_trial / 512) - 2*floor(sar12_trial / 1024))*1.8
let sar12_previous = @VD_B9[pwl]
let sar12_stimulus = vector(8)
let sar12_stimulus[0] = 0
let sar12_stimulus[1] = sar12_previous[length(sar12_previous)-1]
let sar12_stimulus[2] = 0.000134001
let sar12_stimulus[3] = sar12_stimulus[1]
let sar12_stimulus[4] = 0.000134003
let sar12_stimulus[5] = sar12_drive
let sar12_stimulus[6] = 0.000148
let sar12_stimulus[7] = sar12_stimulus[5]
alter @VD_B9[pwl] = sar12_stimulus
let sar12_drive = (floor(sar12_trial / 1024) - 2*floor(sar12_trial / 2048))*1.8
let sar12_previous = @VD_B10[pwl]
let sar12_stimulus = vector(8)
let sar12_stimulus[0] = 0
let sar12_stimulus[1] = sar12_previous[length(sar12_previous)-1]
let sar12_stimulus[2] = 0.000134001
let sar12_stimulus[3] = sar12_stimulus[1]
let sar12_stimulus[4] = 0.000134003
let sar12_stimulus[5] = sar12_drive
let sar12_stimulus[6] = 0.000148
let sar12_stimulus[7] = sar12_stimulus[5]
alter @VD_B10[pwl] = sar12_stimulus
let sar12_drive = (floor(sar12_trial / 2048) - 2*floor(sar12_trial / 4096))*1.8
let sar12_previous = @VD_B11[pwl]
let sar12_stimulus = vector(8)
let sar12_stimulus[0] = 0
let sar12_stimulus[1] = sar12_previous[length(sar12_previous)-1]
let sar12_stimulus[2] = 0.000134001
let sar12_stimulus[3] = sar12_stimulus[1]
let sar12_stimulus[4] = 0.000134003
let sar12_stimulus[5] = sar12_drive
let sar12_stimulus[6] = 0.000148
let sar12_stimulus[7] = sar12_stimulus[5]
alter @VD_B11[pwl] = sar12_stimulus
let sar12_drive = (floor(sar12_trial / 4096) - 2*floor(sar12_trial / 8192))*1.8
let sar12_previous = @VD_B12[pwl]
let sar12_stimulus = vector(8)
let sar12_stimulus[0] = 0
let sar12_stimulus[1] = sar12_previous[length(sar12_previous)-1]
let sar12_stimulus[2] = 0.000134001
let sar12_stimulus[3] = sar12_stimulus[1]
let sar12_stimulus[4] = 0.000134003
let sar12_stimulus[5] = sar12_drive
let sar12_stimulus[6] = 0.000148
let sar12_stimulus[7] = sar12_stimulus[5]
alter @VD_B12[pwl] = sar12_stimulus
let sar12_drive = (floor(sar12_trial / 8192) - 2*floor(sar12_trial / 16384))*1.8
let sar12_previous = @VD_B13[pwl]
let sar12_stimulus = vector(8)
let sar12_stimulus[0] = 0
let sar12_stimulus[1] = sar12_previous[length(sar12_previous)-1]
let sar12_stimulus[2] = 0.000134001
let sar12_stimulus[3] = sar12_stimulus[1]
let sar12_stimulus[4] = 0.000134003
let sar12_stimulus[5] = sar12_drive
let sar12_stimulus[6] = 0.000148
let sar12_stimulus[7] = sar12_stimulus[5]
alter @VD_B13[pwl] = sar12_stimulus
let sar12_drive = (floor(sar12_trial / 16384) - 2*floor(sar12_trial / 32768))*1.8
let sar12_previous = @VD_B14[pwl]
let sar12_stimulus = vector(8)
let sar12_stimulus[0] = 0
let sar12_stimulus[1] = sar12_previous[length(sar12_previous)-1]
let sar12_stimulus[2] = 0.000134001
let sar12_stimulus[3] = sar12_stimulus[1]
let sar12_stimulus[4] = 0.000134003
let sar12_stimulus[5] = sar12_drive
let sar12_stimulus[6] = 0.000148
let sar12_stimulus[7] = sar12_stimulus[5]
alter @VD_B14[pwl] = sar12_stimulus
let sar12_drive = (floor(sar12_trial / 32768) - 2*floor(sar12_trial / 65536))*1.8
let sar12_previous = @VD_B15[pwl]
let sar12_stimulus = vector(8)
let sar12_stimulus[0] = 0
let sar12_stimulus[1] = sar12_previous[length(sar12_previous)-1]
let sar12_stimulus[2] = 0.000134001
let sar12_stimulus[3] = sar12_stimulus[1]
let sar12_stimulus[4] = 0.000134003
let sar12_stimulus[5] = sar12_drive
let sar12_stimulus[6] = 0.000148
let sar12_stimulus[7] = sar12_stimulus[5]
alter @VD_B15[pwl] = sar12_stimulus
resume
let sar12_k = length(time)-1
if abs(time[sar12_k] - 0.0001345) > 1e-12
print time[sar12_k]
echo expected_pause_time_s 0.0001345
echo SAR12_PAUSE_FAILED
quit 1
end
print time[sar12_k] >> pause-times.txt
let sar12_previous = @VD_EVAL[pwl]
let sar12_stimulus = vector(8)
let sar12_stimulus[0] = 0
let sar12_stimulus[1] = sar12_previous[length(sar12_previous)-1]
let sar12_stimulus[2] = 0.000134501
let sar12_stimulus[3] = sar12_stimulus[1]
let sar12_stimulus[4] = 0.000134503
let sar12_stimulus[5] = 1.8
let sar12_stimulus[6] = 0.000148
let sar12_stimulus[7] = sar12_stimulus[5]
alter @VD_EVAL[pwl] = sar12_stimulus
resume
let sar12_k = length(time)-1
if abs(time[sar12_k] - 0.000135) > 1e-12
print time[sar12_k]
echo expected_pause_time_s 0.000135
echo SAR12_PAUSE_FAILED
quit 1
end
print time[sar12_k] >> pause-times.txt
let sar12_k = length(time)-1
let sar12_cmp = v(COMP)[sar12_k]
let sar12_cmpn = v(COMPN)[sar12_k]
let sar12_p = v(TOPP)[sar12_k]
let sar12_n = v(TOPN)[sar12_k]
let sar12_decision = 0
if sar12_cmp >= 0.9
let sar12_code = sar12_trial
let sar12_decision = 1
end
echo 5 12 $&sar12_trial $&sar12_cmp $&sar12_cmpn $&sar12_p $&sar12_n 1.19998168945312 $&sar12_decision >> decisions.csv
let sar12_previous = @VD_EVAL[pwl]
let sar12_stimulus = vector(8)
let sar12_stimulus[0] = 0
let sar12_stimulus[1] = sar12_previous[length(sar12_previous)-1]
let sar12_stimulus[2] = 0.000135001
let sar12_stimulus[3] = sar12_stimulus[1]
let sar12_stimulus[4] = 0.000135003
let sar12_stimulus[5] = 0
let sar12_stimulus[6] = 0.000148
let sar12_stimulus[7] = sar12_stimulus[5]
alter @VD_EVAL[pwl] = sar12_stimulus
let sar12_trial = sar12_code + 2048
let sar12_drive = (floor(sar12_trial / 1) - 2*floor(sar12_trial / 2))*1.8
let sar12_previous = @VD_B0[pwl]
let sar12_stimulus = vector(8)
let sar12_stimulus[0] = 0
let sar12_stimulus[1] = sar12_previous[length(sar12_previous)-1]
let sar12_stimulus[2] = 0.000135001
let sar12_stimulus[3] = sar12_stimulus[1]
let sar12_stimulus[4] = 0.000135003
let sar12_stimulus[5] = sar12_drive
let sar12_stimulus[6] = 0.000148
let sar12_stimulus[7] = sar12_stimulus[5]
alter @VD_B0[pwl] = sar12_stimulus
let sar12_drive = (floor(sar12_trial / 2) - 2*floor(sar12_trial / 4))*1.8
let sar12_previous = @VD_B1[pwl]
let sar12_stimulus = vector(8)
let sar12_stimulus[0] = 0
let sar12_stimulus[1] = sar12_previous[length(sar12_previous)-1]
let sar12_stimulus[2] = 0.000135001
let sar12_stimulus[3] = sar12_stimulus[1]
let sar12_stimulus[4] = 0.000135003
let sar12_stimulus[5] = sar12_drive
let sar12_stimulus[6] = 0.000148
let sar12_stimulus[7] = sar12_stimulus[5]
alter @VD_B1[pwl] = sar12_stimulus
let sar12_drive = (floor(sar12_trial / 4) - 2*floor(sar12_trial / 8))*1.8
let sar12_previous = @VD_B2[pwl]
let sar12_stimulus = vector(8)
let sar12_stimulus[0] = 0
let sar12_stimulus[1] = sar12_previous[length(sar12_previous)-1]
let sar12_stimulus[2] = 0.000135001
let sar12_stimulus[3] = sar12_stimulus[1]
let sar12_stimulus[4] = 0.000135003
let sar12_stimulus[5] = sar12_drive
let sar12_stimulus[6] = 0.000148
let sar12_stimulus[7] = sar12_stimulus[5]
alter @VD_B2[pwl] = sar12_stimulus
let sar12_drive = (floor(sar12_trial / 8) - 2*floor(sar12_trial / 16))*1.8
let sar12_previous = @VD_B3[pwl]
let sar12_stimulus = vector(8)
let sar12_stimulus[0] = 0
let sar12_stimulus[1] = sar12_previous[length(sar12_previous)-1]
let sar12_stimulus[2] = 0.000135001
let sar12_stimulus[3] = sar12_stimulus[1]
let sar12_stimulus[4] = 0.000135003
let sar12_stimulus[5] = sar12_drive
let sar12_stimulus[6] = 0.000148
let sar12_stimulus[7] = sar12_stimulus[5]
alter @VD_B3[pwl] = sar12_stimulus
let sar12_drive = (floor(sar12_trial / 16) - 2*floor(sar12_trial / 32))*1.8
let sar12_previous = @VD_B4[pwl]
let sar12_stimulus = vector(8)
let sar12_stimulus[0] = 0
let sar12_stimulus[1] = sar12_previous[length(sar12_previous)-1]
let sar12_stimulus[2] = 0.000135001
let sar12_stimulus[3] = sar12_stimulus[1]
let sar12_stimulus[4] = 0.000135003
let sar12_stimulus[5] = sar12_drive
let sar12_stimulus[6] = 0.000148
let sar12_stimulus[7] = sar12_stimulus[5]
alter @VD_B4[pwl] = sar12_stimulus
let sar12_drive = (floor(sar12_trial / 32) - 2*floor(sar12_trial / 64))*1.8
let sar12_previous = @VD_B5[pwl]
let sar12_stimulus = vector(8)
let sar12_stimulus[0] = 0
let sar12_stimulus[1] = sar12_previous[length(sar12_previous)-1]
let sar12_stimulus[2] = 0.000135001
let sar12_stimulus[3] = sar12_stimulus[1]
let sar12_stimulus[4] = 0.000135003
let sar12_stimulus[5] = sar12_drive
let sar12_stimulus[6] = 0.000148
let sar12_stimulus[7] = sar12_stimulus[5]
alter @VD_B5[pwl] = sar12_stimulus
let sar12_drive = (floor(sar12_trial / 64) - 2*floor(sar12_trial / 128))*1.8
let sar12_previous = @VD_B6[pwl]
let sar12_stimulus = vector(8)
let sar12_stimulus[0] = 0
let sar12_stimulus[1] = sar12_previous[length(sar12_previous)-1]
let sar12_stimulus[2] = 0.000135001
let sar12_stimulus[3] = sar12_stimulus[1]
let sar12_stimulus[4] = 0.000135003
let sar12_stimulus[5] = sar12_drive
let sar12_stimulus[6] = 0.000148
let sar12_stimulus[7] = sar12_stimulus[5]
alter @VD_B6[pwl] = sar12_stimulus
let sar12_drive = (floor(sar12_trial / 128) - 2*floor(sar12_trial / 256))*1.8
let sar12_previous = @VD_B7[pwl]
let sar12_stimulus = vector(8)
let sar12_stimulus[0] = 0
let sar12_stimulus[1] = sar12_previous[length(sar12_previous)-1]
let sar12_stimulus[2] = 0.000135001
let sar12_stimulus[3] = sar12_stimulus[1]
let sar12_stimulus[4] = 0.000135003
let sar12_stimulus[5] = sar12_drive
let sar12_stimulus[6] = 0.000148
let sar12_stimulus[7] = sar12_stimulus[5]
alter @VD_B7[pwl] = sar12_stimulus
let sar12_drive = (floor(sar12_trial / 256) - 2*floor(sar12_trial / 512))*1.8
let sar12_previous = @VD_B8[pwl]
let sar12_stimulus = vector(8)
let sar12_stimulus[0] = 0
let sar12_stimulus[1] = sar12_previous[length(sar12_previous)-1]
let sar12_stimulus[2] = 0.000135001
let sar12_stimulus[3] = sar12_stimulus[1]
let sar12_stimulus[4] = 0.000135003
let sar12_stimulus[5] = sar12_drive
let sar12_stimulus[6] = 0.000148
let sar12_stimulus[7] = sar12_stimulus[5]
alter @VD_B8[pwl] = sar12_stimulus
let sar12_drive = (floor(sar12_trial / 512) - 2*floor(sar12_trial / 1024))*1.8
let sar12_previous = @VD_B9[pwl]
let sar12_stimulus = vector(8)
let sar12_stimulus[0] = 0
let sar12_stimulus[1] = sar12_previous[length(sar12_previous)-1]
let sar12_stimulus[2] = 0.000135001
let sar12_stimulus[3] = sar12_stimulus[1]
let sar12_stimulus[4] = 0.000135003
let sar12_stimulus[5] = sar12_drive
let sar12_stimulus[6] = 0.000148
let sar12_stimulus[7] = sar12_stimulus[5]
alter @VD_B9[pwl] = sar12_stimulus
let sar12_drive = (floor(sar12_trial / 1024) - 2*floor(sar12_trial / 2048))*1.8
let sar12_previous = @VD_B10[pwl]
let sar12_stimulus = vector(8)
let sar12_stimulus[0] = 0
let sar12_stimulus[1] = sar12_previous[length(sar12_previous)-1]
let sar12_stimulus[2] = 0.000135001
let sar12_stimulus[3] = sar12_stimulus[1]
let sar12_stimulus[4] = 0.000135003
let sar12_stimulus[5] = sar12_drive
let sar12_stimulus[6] = 0.000148
let sar12_stimulus[7] = sar12_stimulus[5]
alter @VD_B10[pwl] = sar12_stimulus
let sar12_drive = (floor(sar12_trial / 2048) - 2*floor(sar12_trial / 4096))*1.8
let sar12_previous = @VD_B11[pwl]
let sar12_stimulus = vector(8)
let sar12_stimulus[0] = 0
let sar12_stimulus[1] = sar12_previous[length(sar12_previous)-1]
let sar12_stimulus[2] = 0.000135001
let sar12_stimulus[3] = sar12_stimulus[1]
let sar12_stimulus[4] = 0.000135003
let sar12_stimulus[5] = sar12_drive
let sar12_stimulus[6] = 0.000148
let sar12_stimulus[7] = sar12_stimulus[5]
alter @VD_B11[pwl] = sar12_stimulus
let sar12_drive = (floor(sar12_trial / 4096) - 2*floor(sar12_trial / 8192))*1.8
let sar12_previous = @VD_B12[pwl]
let sar12_stimulus = vector(8)
let sar12_stimulus[0] = 0
let sar12_stimulus[1] = sar12_previous[length(sar12_previous)-1]
let sar12_stimulus[2] = 0.000135001
let sar12_stimulus[3] = sar12_stimulus[1]
let sar12_stimulus[4] = 0.000135003
let sar12_stimulus[5] = sar12_drive
let sar12_stimulus[6] = 0.000148
let sar12_stimulus[7] = sar12_stimulus[5]
alter @VD_B12[pwl] = sar12_stimulus
let sar12_drive = (floor(sar12_trial / 8192) - 2*floor(sar12_trial / 16384))*1.8
let sar12_previous = @VD_B13[pwl]
let sar12_stimulus = vector(8)
let sar12_stimulus[0] = 0
let sar12_stimulus[1] = sar12_previous[length(sar12_previous)-1]
let sar12_stimulus[2] = 0.000135001
let sar12_stimulus[3] = sar12_stimulus[1]
let sar12_stimulus[4] = 0.000135003
let sar12_stimulus[5] = sar12_drive
let sar12_stimulus[6] = 0.000148
let sar12_stimulus[7] = sar12_stimulus[5]
alter @VD_B13[pwl] = sar12_stimulus
let sar12_drive = (floor(sar12_trial / 16384) - 2*floor(sar12_trial / 32768))*1.8
let sar12_previous = @VD_B14[pwl]
let sar12_stimulus = vector(8)
let sar12_stimulus[0] = 0
let sar12_stimulus[1] = sar12_previous[length(sar12_previous)-1]
let sar12_stimulus[2] = 0.000135001
let sar12_stimulus[3] = sar12_stimulus[1]
let sar12_stimulus[4] = 0.000135003
let sar12_stimulus[5] = sar12_drive
let sar12_stimulus[6] = 0.000148
let sar12_stimulus[7] = sar12_stimulus[5]
alter @VD_B14[pwl] = sar12_stimulus
let sar12_drive = (floor(sar12_trial / 32768) - 2*floor(sar12_trial / 65536))*1.8
let sar12_previous = @VD_B15[pwl]
let sar12_stimulus = vector(8)
let sar12_stimulus[0] = 0
let sar12_stimulus[1] = sar12_previous[length(sar12_previous)-1]
let sar12_stimulus[2] = 0.000135001
let sar12_stimulus[3] = sar12_stimulus[1]
let sar12_stimulus[4] = 0.000135003
let sar12_stimulus[5] = sar12_drive
let sar12_stimulus[6] = 0.000148
let sar12_stimulus[7] = sar12_stimulus[5]
alter @VD_B15[pwl] = sar12_stimulus
resume
let sar12_k = length(time)-1
if abs(time[sar12_k] - 0.0001355) > 1e-12
print time[sar12_k]
echo expected_pause_time_s 0.0001355
echo SAR12_PAUSE_FAILED
quit 1
end
print time[sar12_k] >> pause-times.txt
let sar12_previous = @VD_EVAL[pwl]
let sar12_stimulus = vector(8)
let sar12_stimulus[0] = 0
let sar12_stimulus[1] = sar12_previous[length(sar12_previous)-1]
let sar12_stimulus[2] = 0.000135501
let sar12_stimulus[3] = sar12_stimulus[1]
let sar12_stimulus[4] = 0.000135503
let sar12_stimulus[5] = 1.8
let sar12_stimulus[6] = 0.000148
let sar12_stimulus[7] = sar12_stimulus[5]
alter @VD_EVAL[pwl] = sar12_stimulus
resume
let sar12_k = length(time)-1
if abs(time[sar12_k] - 0.000136) > 1e-12
print time[sar12_k]
echo expected_pause_time_s 0.000136
echo SAR12_PAUSE_FAILED
quit 1
end
print time[sar12_k] >> pause-times.txt
let sar12_k = length(time)-1
let sar12_cmp = v(COMP)[sar12_k]
let sar12_cmpn = v(COMPN)[sar12_k]
let sar12_p = v(TOPP)[sar12_k]
let sar12_n = v(TOPN)[sar12_k]
let sar12_decision = 0
if sar12_cmp >= 0.9
let sar12_code = sar12_trial
let sar12_decision = 1
end
echo 5 11 $&sar12_trial $&sar12_cmp $&sar12_cmpn $&sar12_p $&sar12_n 1.19998168945312 $&sar12_decision >> decisions.csv
let sar12_previous = @VD_EVAL[pwl]
let sar12_stimulus = vector(8)
let sar12_stimulus[0] = 0
let sar12_stimulus[1] = sar12_previous[length(sar12_previous)-1]
let sar12_stimulus[2] = 0.000136001
let sar12_stimulus[3] = sar12_stimulus[1]
let sar12_stimulus[4] = 0.000136003
let sar12_stimulus[5] = 0
let sar12_stimulus[6] = 0.000148
let sar12_stimulus[7] = sar12_stimulus[5]
alter @VD_EVAL[pwl] = sar12_stimulus
let sar12_trial = sar12_code + 1024
let sar12_drive = (floor(sar12_trial / 1) - 2*floor(sar12_trial / 2))*1.8
let sar12_previous = @VD_B0[pwl]
let sar12_stimulus = vector(8)
let sar12_stimulus[0] = 0
let sar12_stimulus[1] = sar12_previous[length(sar12_previous)-1]
let sar12_stimulus[2] = 0.000136001
let sar12_stimulus[3] = sar12_stimulus[1]
let sar12_stimulus[4] = 0.000136003
let sar12_stimulus[5] = sar12_drive
let sar12_stimulus[6] = 0.000148
let sar12_stimulus[7] = sar12_stimulus[5]
alter @VD_B0[pwl] = sar12_stimulus
let sar12_drive = (floor(sar12_trial / 2) - 2*floor(sar12_trial / 4))*1.8
let sar12_previous = @VD_B1[pwl]
let sar12_stimulus = vector(8)
let sar12_stimulus[0] = 0
let sar12_stimulus[1] = sar12_previous[length(sar12_previous)-1]
let sar12_stimulus[2] = 0.000136001
let sar12_stimulus[3] = sar12_stimulus[1]
let sar12_stimulus[4] = 0.000136003
let sar12_stimulus[5] = sar12_drive
let sar12_stimulus[6] = 0.000148
let sar12_stimulus[7] = sar12_stimulus[5]
alter @VD_B1[pwl] = sar12_stimulus
let sar12_drive = (floor(sar12_trial / 4) - 2*floor(sar12_trial / 8))*1.8
let sar12_previous = @VD_B2[pwl]
let sar12_stimulus = vector(8)
let sar12_stimulus[0] = 0
let sar12_stimulus[1] = sar12_previous[length(sar12_previous)-1]
let sar12_stimulus[2] = 0.000136001
let sar12_stimulus[3] = sar12_stimulus[1]
let sar12_stimulus[4] = 0.000136003
let sar12_stimulus[5] = sar12_drive
let sar12_stimulus[6] = 0.000148
let sar12_stimulus[7] = sar12_stimulus[5]
alter @VD_B2[pwl] = sar12_stimulus
let sar12_drive = (floor(sar12_trial / 8) - 2*floor(sar12_trial / 16))*1.8
let sar12_previous = @VD_B3[pwl]
let sar12_stimulus = vector(8)
let sar12_stimulus[0] = 0
let sar12_stimulus[1] = sar12_previous[length(sar12_previous)-1]
let sar12_stimulus[2] = 0.000136001
let sar12_stimulus[3] = sar12_stimulus[1]
let sar12_stimulus[4] = 0.000136003
let sar12_stimulus[5] = sar12_drive
let sar12_stimulus[6] = 0.000148
let sar12_stimulus[7] = sar12_stimulus[5]
alter @VD_B3[pwl] = sar12_stimulus
let sar12_drive = (floor(sar12_trial / 16) - 2*floor(sar12_trial / 32))*1.8
let sar12_previous = @VD_B4[pwl]
let sar12_stimulus = vector(8)
let sar12_stimulus[0] = 0
let sar12_stimulus[1] = sar12_previous[length(sar12_previous)-1]
let sar12_stimulus[2] = 0.000136001
let sar12_stimulus[3] = sar12_stimulus[1]
let sar12_stimulus[4] = 0.000136003
let sar12_stimulus[5] = sar12_drive
let sar12_stimulus[6] = 0.000148
let sar12_stimulus[7] = sar12_stimulus[5]
alter @VD_B4[pwl] = sar12_stimulus
let sar12_drive = (floor(sar12_trial / 32) - 2*floor(sar12_trial / 64))*1.8
let sar12_previous = @VD_B5[pwl]
let sar12_stimulus = vector(8)
let sar12_stimulus[0] = 0
let sar12_stimulus[1] = sar12_previous[length(sar12_previous)-1]
let sar12_stimulus[2] = 0.000136001
let sar12_stimulus[3] = sar12_stimulus[1]
let sar12_stimulus[4] = 0.000136003
let sar12_stimulus[5] = sar12_drive
let sar12_stimulus[6] = 0.000148
let sar12_stimulus[7] = sar12_stimulus[5]
alter @VD_B5[pwl] = sar12_stimulus
let sar12_drive = (floor(sar12_trial / 64) - 2*floor(sar12_trial / 128))*1.8
let sar12_previous = @VD_B6[pwl]
let sar12_stimulus = vector(8)
let sar12_stimulus[0] = 0
let sar12_stimulus[1] = sar12_previous[length(sar12_previous)-1]
let sar12_stimulus[2] = 0.000136001
let sar12_stimulus[3] = sar12_stimulus[1]
let sar12_stimulus[4] = 0.000136003
let sar12_stimulus[5] = sar12_drive
let sar12_stimulus[6] = 0.000148
let sar12_stimulus[7] = sar12_stimulus[5]
alter @VD_B6[pwl] = sar12_stimulus
let sar12_drive = (floor(sar12_trial / 128) - 2*floor(sar12_trial / 256))*1.8
let sar12_previous = @VD_B7[pwl]
let sar12_stimulus = vector(8)
let sar12_stimulus[0] = 0
let sar12_stimulus[1] = sar12_previous[length(sar12_previous)-1]
let sar12_stimulus[2] = 0.000136001
let sar12_stimulus[3] = sar12_stimulus[1]
let sar12_stimulus[4] = 0.000136003
let sar12_stimulus[5] = sar12_drive
let sar12_stimulus[6] = 0.000148
let sar12_stimulus[7] = sar12_stimulus[5]
alter @VD_B7[pwl] = sar12_stimulus
let sar12_drive = (floor(sar12_trial / 256) - 2*floor(sar12_trial / 512))*1.8
let sar12_previous = @VD_B8[pwl]
let sar12_stimulus = vector(8)
let sar12_stimulus[0] = 0
let sar12_stimulus[1] = sar12_previous[length(sar12_previous)-1]
let sar12_stimulus[2] = 0.000136001
let sar12_stimulus[3] = sar12_stimulus[1]
let sar12_stimulus[4] = 0.000136003
let sar12_stimulus[5] = sar12_drive
let sar12_stimulus[6] = 0.000148
let sar12_stimulus[7] = sar12_stimulus[5]
alter @VD_B8[pwl] = sar12_stimulus
let sar12_drive = (floor(sar12_trial / 512) - 2*floor(sar12_trial / 1024))*1.8
let sar12_previous = @VD_B9[pwl]
let sar12_stimulus = vector(8)
let sar12_stimulus[0] = 0
let sar12_stimulus[1] = sar12_previous[length(sar12_previous)-1]
let sar12_stimulus[2] = 0.000136001
let sar12_stimulus[3] = sar12_stimulus[1]
let sar12_stimulus[4] = 0.000136003
let sar12_stimulus[5] = sar12_drive
let sar12_stimulus[6] = 0.000148
let sar12_stimulus[7] = sar12_stimulus[5]
alter @VD_B9[pwl] = sar12_stimulus
let sar12_drive = (floor(sar12_trial / 1024) - 2*floor(sar12_trial / 2048))*1.8
let sar12_previous = @VD_B10[pwl]
let sar12_stimulus = vector(8)
let sar12_stimulus[0] = 0
let sar12_stimulus[1] = sar12_previous[length(sar12_previous)-1]
let sar12_stimulus[2] = 0.000136001
let sar12_stimulus[3] = sar12_stimulus[1]
let sar12_stimulus[4] = 0.000136003
let sar12_stimulus[5] = sar12_drive
let sar12_stimulus[6] = 0.000148
let sar12_stimulus[7] = sar12_stimulus[5]
alter @VD_B10[pwl] = sar12_stimulus
let sar12_drive = (floor(sar12_trial / 2048) - 2*floor(sar12_trial / 4096))*1.8
let sar12_previous = @VD_B11[pwl]
let sar12_stimulus = vector(8)
let sar12_stimulus[0] = 0
let sar12_stimulus[1] = sar12_previous[length(sar12_previous)-1]
let sar12_stimulus[2] = 0.000136001
let sar12_stimulus[3] = sar12_stimulus[1]
let sar12_stimulus[4] = 0.000136003
let sar12_stimulus[5] = sar12_drive
let sar12_stimulus[6] = 0.000148
let sar12_stimulus[7] = sar12_stimulus[5]
alter @VD_B11[pwl] = sar12_stimulus
let sar12_drive = (floor(sar12_trial / 4096) - 2*floor(sar12_trial / 8192))*1.8
let sar12_previous = @VD_B12[pwl]
let sar12_stimulus = vector(8)
let sar12_stimulus[0] = 0
let sar12_stimulus[1] = sar12_previous[length(sar12_previous)-1]
let sar12_stimulus[2] = 0.000136001
let sar12_stimulus[3] = sar12_stimulus[1]
let sar12_stimulus[4] = 0.000136003
let sar12_stimulus[5] = sar12_drive
let sar12_stimulus[6] = 0.000148
let sar12_stimulus[7] = sar12_stimulus[5]
alter @VD_B12[pwl] = sar12_stimulus
let sar12_drive = (floor(sar12_trial / 8192) - 2*floor(sar12_trial / 16384))*1.8
let sar12_previous = @VD_B13[pwl]
let sar12_stimulus = vector(8)
let sar12_stimulus[0] = 0
let sar12_stimulus[1] = sar12_previous[length(sar12_previous)-1]
let sar12_stimulus[2] = 0.000136001
let sar12_stimulus[3] = sar12_stimulus[1]
let sar12_stimulus[4] = 0.000136003
let sar12_stimulus[5] = sar12_drive
let sar12_stimulus[6] = 0.000148
let sar12_stimulus[7] = sar12_stimulus[5]
alter @VD_B13[pwl] = sar12_stimulus
let sar12_drive = (floor(sar12_trial / 16384) - 2*floor(sar12_trial / 32768))*1.8
let sar12_previous = @VD_B14[pwl]
let sar12_stimulus = vector(8)
let sar12_stimulus[0] = 0
let sar12_stimulus[1] = sar12_previous[length(sar12_previous)-1]
let sar12_stimulus[2] = 0.000136001
let sar12_stimulus[3] = sar12_stimulus[1]
let sar12_stimulus[4] = 0.000136003
let sar12_stimulus[5] = sar12_drive
let sar12_stimulus[6] = 0.000148
let sar12_stimulus[7] = sar12_stimulus[5]
alter @VD_B14[pwl] = sar12_stimulus
let sar12_drive = (floor(sar12_trial / 32768) - 2*floor(sar12_trial / 65536))*1.8
let sar12_previous = @VD_B15[pwl]
let sar12_stimulus = vector(8)
let sar12_stimulus[0] = 0
let sar12_stimulus[1] = sar12_previous[length(sar12_previous)-1]
let sar12_stimulus[2] = 0.000136001
let sar12_stimulus[3] = sar12_stimulus[1]
let sar12_stimulus[4] = 0.000136003
let sar12_stimulus[5] = sar12_drive
let sar12_stimulus[6] = 0.000148
let sar12_stimulus[7] = sar12_stimulus[5]
alter @VD_B15[pwl] = sar12_stimulus
resume
let sar12_k = length(time)-1
if abs(time[sar12_k] - 0.0001365) > 1e-12
print time[sar12_k]
echo expected_pause_time_s 0.0001365
echo SAR12_PAUSE_FAILED
quit 1
end
print time[sar12_k] >> pause-times.txt
let sar12_previous = @VD_EVAL[pwl]
let sar12_stimulus = vector(8)
let sar12_stimulus[0] = 0
let sar12_stimulus[1] = sar12_previous[length(sar12_previous)-1]
let sar12_stimulus[2] = 0.000136501
let sar12_stimulus[3] = sar12_stimulus[1]
let sar12_stimulus[4] = 0.000136503
let sar12_stimulus[5] = 1.8
let sar12_stimulus[6] = 0.000148
let sar12_stimulus[7] = sar12_stimulus[5]
alter @VD_EVAL[pwl] = sar12_stimulus
resume
let sar12_k = length(time)-1
if abs(time[sar12_k] - 0.000137) > 1e-12
print time[sar12_k]
echo expected_pause_time_s 0.000137
echo SAR12_PAUSE_FAILED
quit 1
end
print time[sar12_k] >> pause-times.txt
let sar12_k = length(time)-1
let sar12_cmp = v(COMP)[sar12_k]
let sar12_cmpn = v(COMPN)[sar12_k]
let sar12_p = v(TOPP)[sar12_k]
let sar12_n = v(TOPN)[sar12_k]
let sar12_decision = 0
if sar12_cmp >= 0.9
let sar12_code = sar12_trial
let sar12_decision = 1
end
echo 5 10 $&sar12_trial $&sar12_cmp $&sar12_cmpn $&sar12_p $&sar12_n 1.19998168945312 $&sar12_decision >> decisions.csv
let sar12_previous = @VD_EVAL[pwl]
let sar12_stimulus = vector(8)
let sar12_stimulus[0] = 0
let sar12_stimulus[1] = sar12_previous[length(sar12_previous)-1]
let sar12_stimulus[2] = 0.000137001
let sar12_stimulus[3] = sar12_stimulus[1]
let sar12_stimulus[4] = 0.000137003
let sar12_stimulus[5] = 0
let sar12_stimulus[6] = 0.000148
let sar12_stimulus[7] = sar12_stimulus[5]
alter @VD_EVAL[pwl] = sar12_stimulus
let sar12_trial = sar12_code + 512
let sar12_drive = (floor(sar12_trial / 1) - 2*floor(sar12_trial / 2))*1.8
let sar12_previous = @VD_B0[pwl]
let sar12_stimulus = vector(8)
let sar12_stimulus[0] = 0
let sar12_stimulus[1] = sar12_previous[length(sar12_previous)-1]
let sar12_stimulus[2] = 0.000137001
let sar12_stimulus[3] = sar12_stimulus[1]
let sar12_stimulus[4] = 0.000137003
let sar12_stimulus[5] = sar12_drive
let sar12_stimulus[6] = 0.000148
let sar12_stimulus[7] = sar12_stimulus[5]
alter @VD_B0[pwl] = sar12_stimulus
let sar12_drive = (floor(sar12_trial / 2) - 2*floor(sar12_trial / 4))*1.8
let sar12_previous = @VD_B1[pwl]
let sar12_stimulus = vector(8)
let sar12_stimulus[0] = 0
let sar12_stimulus[1] = sar12_previous[length(sar12_previous)-1]
let sar12_stimulus[2] = 0.000137001
let sar12_stimulus[3] = sar12_stimulus[1]
let sar12_stimulus[4] = 0.000137003
let sar12_stimulus[5] = sar12_drive
let sar12_stimulus[6] = 0.000148
let sar12_stimulus[7] = sar12_stimulus[5]
alter @VD_B1[pwl] = sar12_stimulus
let sar12_drive = (floor(sar12_trial / 4) - 2*floor(sar12_trial / 8))*1.8
let sar12_previous = @VD_B2[pwl]
let sar12_stimulus = vector(8)
let sar12_stimulus[0] = 0
let sar12_stimulus[1] = sar12_previous[length(sar12_previous)-1]
let sar12_stimulus[2] = 0.000137001
let sar12_stimulus[3] = sar12_stimulus[1]
let sar12_stimulus[4] = 0.000137003
let sar12_stimulus[5] = sar12_drive
let sar12_stimulus[6] = 0.000148
let sar12_stimulus[7] = sar12_stimulus[5]
alter @VD_B2[pwl] = sar12_stimulus
let sar12_drive = (floor(sar12_trial / 8) - 2*floor(sar12_trial / 16))*1.8
let sar12_previous = @VD_B3[pwl]
let sar12_stimulus = vector(8)
let sar12_stimulus[0] = 0
let sar12_stimulus[1] = sar12_previous[length(sar12_previous)-1]
let sar12_stimulus[2] = 0.000137001
let sar12_stimulus[3] = sar12_stimulus[1]
let sar12_stimulus[4] = 0.000137003
let sar12_stimulus[5] = sar12_drive
let sar12_stimulus[6] = 0.000148
let sar12_stimulus[7] = sar12_stimulus[5]
alter @VD_B3[pwl] = sar12_stimulus
let sar12_drive = (floor(sar12_trial / 16) - 2*floor(sar12_trial / 32))*1.8
let sar12_previous = @VD_B4[pwl]
let sar12_stimulus = vector(8)
let sar12_stimulus[0] = 0
let sar12_stimulus[1] = sar12_previous[length(sar12_previous)-1]
let sar12_stimulus[2] = 0.000137001
let sar12_stimulus[3] = sar12_stimulus[1]
let sar12_stimulus[4] = 0.000137003
let sar12_stimulus[5] = sar12_drive
let sar12_stimulus[6] = 0.000148
let sar12_stimulus[7] = sar12_stimulus[5]
alter @VD_B4[pwl] = sar12_stimulus
let sar12_drive = (floor(sar12_trial / 32) - 2*floor(sar12_trial / 64))*1.8
let sar12_previous = @VD_B5[pwl]
let sar12_stimulus = vector(8)
let sar12_stimulus[0] = 0
let sar12_stimulus[1] = sar12_previous[length(sar12_previous)-1]
let sar12_stimulus[2] = 0.000137001
let sar12_stimulus[3] = sar12_stimulus[1]
let sar12_stimulus[4] = 0.000137003
let sar12_stimulus[5] = sar12_drive
let sar12_stimulus[6] = 0.000148
let sar12_stimulus[7] = sar12_stimulus[5]
alter @VD_B5[pwl] = sar12_stimulus
let sar12_drive = (floor(sar12_trial / 64) - 2*floor(sar12_trial / 128))*1.8
let sar12_previous = @VD_B6[pwl]
let sar12_stimulus = vector(8)
let sar12_stimulus[0] = 0
let sar12_stimulus[1] = sar12_previous[length(sar12_previous)-1]
let sar12_stimulus[2] = 0.000137001
let sar12_stimulus[3] = sar12_stimulus[1]
let sar12_stimulus[4] = 0.000137003
let sar12_stimulus[5] = sar12_drive
let sar12_stimulus[6] = 0.000148
let sar12_stimulus[7] = sar12_stimulus[5]
alter @VD_B6[pwl] = sar12_stimulus
let sar12_drive = (floor(sar12_trial / 128) - 2*floor(sar12_trial / 256))*1.8
let sar12_previous = @VD_B7[pwl]
let sar12_stimulus = vector(8)
let sar12_stimulus[0] = 0
let sar12_stimulus[1] = sar12_previous[length(sar12_previous)-1]
let sar12_stimulus[2] = 0.000137001
let sar12_stimulus[3] = sar12_stimulus[1]
let sar12_stimulus[4] = 0.000137003
let sar12_stimulus[5] = sar12_drive
let sar12_stimulus[6] = 0.000148
let sar12_stimulus[7] = sar12_stimulus[5]
alter @VD_B7[pwl] = sar12_stimulus
let sar12_drive = (floor(sar12_trial / 256) - 2*floor(sar12_trial / 512))*1.8
let sar12_previous = @VD_B8[pwl]
let sar12_stimulus = vector(8)
let sar12_stimulus[0] = 0
let sar12_stimulus[1] = sar12_previous[length(sar12_previous)-1]
let sar12_stimulus[2] = 0.000137001
let sar12_stimulus[3] = sar12_stimulus[1]
let sar12_stimulus[4] = 0.000137003
let sar12_stimulus[5] = sar12_drive
let sar12_stimulus[6] = 0.000148
let sar12_stimulus[7] = sar12_stimulus[5]
alter @VD_B8[pwl] = sar12_stimulus
let sar12_drive = (floor(sar12_trial / 512) - 2*floor(sar12_trial / 1024))*1.8
let sar12_previous = @VD_B9[pwl]
let sar12_stimulus = vector(8)
let sar12_stimulus[0] = 0
let sar12_stimulus[1] = sar12_previous[length(sar12_previous)-1]
let sar12_stimulus[2] = 0.000137001
let sar12_stimulus[3] = sar12_stimulus[1]
let sar12_stimulus[4] = 0.000137003
let sar12_stimulus[5] = sar12_drive
let sar12_stimulus[6] = 0.000148
let sar12_stimulus[7] = sar12_stimulus[5]
alter @VD_B9[pwl] = sar12_stimulus
let sar12_drive = (floor(sar12_trial / 1024) - 2*floor(sar12_trial / 2048))*1.8
let sar12_previous = @VD_B10[pwl]
let sar12_stimulus = vector(8)
let sar12_stimulus[0] = 0
let sar12_stimulus[1] = sar12_previous[length(sar12_previous)-1]
let sar12_stimulus[2] = 0.000137001
let sar12_stimulus[3] = sar12_stimulus[1]
let sar12_stimulus[4] = 0.000137003
let sar12_stimulus[5] = sar12_drive
let sar12_stimulus[6] = 0.000148
let sar12_stimulus[7] = sar12_stimulus[5]
alter @VD_B10[pwl] = sar12_stimulus
let sar12_drive = (floor(sar12_trial / 2048) - 2*floor(sar12_trial / 4096))*1.8
let sar12_previous = @VD_B11[pwl]
let sar12_stimulus = vector(8)
let sar12_stimulus[0] = 0
let sar12_stimulus[1] = sar12_previous[length(sar12_previous)-1]
let sar12_stimulus[2] = 0.000137001
let sar12_stimulus[3] = sar12_stimulus[1]
let sar12_stimulus[4] = 0.000137003
let sar12_stimulus[5] = sar12_drive
let sar12_stimulus[6] = 0.000148
let sar12_stimulus[7] = sar12_stimulus[5]
alter @VD_B11[pwl] = sar12_stimulus
let sar12_drive = (floor(sar12_trial / 4096) - 2*floor(sar12_trial / 8192))*1.8
let sar12_previous = @VD_B12[pwl]
let sar12_stimulus = vector(8)
let sar12_stimulus[0] = 0
let sar12_stimulus[1] = sar12_previous[length(sar12_previous)-1]
let sar12_stimulus[2] = 0.000137001
let sar12_stimulus[3] = sar12_stimulus[1]
let sar12_stimulus[4] = 0.000137003
let sar12_stimulus[5] = sar12_drive
let sar12_stimulus[6] = 0.000148
let sar12_stimulus[7] = sar12_stimulus[5]
alter @VD_B12[pwl] = sar12_stimulus
let sar12_drive = (floor(sar12_trial / 8192) - 2*floor(sar12_trial / 16384))*1.8
let sar12_previous = @VD_B13[pwl]
let sar12_stimulus = vector(8)
let sar12_stimulus[0] = 0
let sar12_stimulus[1] = sar12_previous[length(sar12_previous)-1]
let sar12_stimulus[2] = 0.000137001
let sar12_stimulus[3] = sar12_stimulus[1]
let sar12_stimulus[4] = 0.000137003
let sar12_stimulus[5] = sar12_drive
let sar12_stimulus[6] = 0.000148
let sar12_stimulus[7] = sar12_stimulus[5]
alter @VD_B13[pwl] = sar12_stimulus
let sar12_drive = (floor(sar12_trial / 16384) - 2*floor(sar12_trial / 32768))*1.8
let sar12_previous = @VD_B14[pwl]
let sar12_stimulus = vector(8)
let sar12_stimulus[0] = 0
let sar12_stimulus[1] = sar12_previous[length(sar12_previous)-1]
let sar12_stimulus[2] = 0.000137001
let sar12_stimulus[3] = sar12_stimulus[1]
let sar12_stimulus[4] = 0.000137003
let sar12_stimulus[5] = sar12_drive
let sar12_stimulus[6] = 0.000148
let sar12_stimulus[7] = sar12_stimulus[5]
alter @VD_B14[pwl] = sar12_stimulus
let sar12_drive = (floor(sar12_trial / 32768) - 2*floor(sar12_trial / 65536))*1.8
let sar12_previous = @VD_B15[pwl]
let sar12_stimulus = vector(8)
let sar12_stimulus[0] = 0
let sar12_stimulus[1] = sar12_previous[length(sar12_previous)-1]
let sar12_stimulus[2] = 0.000137001
let sar12_stimulus[3] = sar12_stimulus[1]
let sar12_stimulus[4] = 0.000137003
let sar12_stimulus[5] = sar12_drive
let sar12_stimulus[6] = 0.000148
let sar12_stimulus[7] = sar12_stimulus[5]
alter @VD_B15[pwl] = sar12_stimulus
resume
let sar12_k = length(time)-1
if abs(time[sar12_k] - 0.0001375) > 1e-12
print time[sar12_k]
echo expected_pause_time_s 0.0001375
echo SAR12_PAUSE_FAILED
quit 1
end
print time[sar12_k] >> pause-times.txt
let sar12_previous = @VD_EVAL[pwl]
let sar12_stimulus = vector(8)
let sar12_stimulus[0] = 0
let sar12_stimulus[1] = sar12_previous[length(sar12_previous)-1]
let sar12_stimulus[2] = 0.000137501
let sar12_stimulus[3] = sar12_stimulus[1]
let sar12_stimulus[4] = 0.000137503
let sar12_stimulus[5] = 1.8
let sar12_stimulus[6] = 0.000148
let sar12_stimulus[7] = sar12_stimulus[5]
alter @VD_EVAL[pwl] = sar12_stimulus
resume
let sar12_k = length(time)-1
if abs(time[sar12_k] - 0.000138) > 1e-12
print time[sar12_k]
echo expected_pause_time_s 0.000138
echo SAR12_PAUSE_FAILED
quit 1
end
print time[sar12_k] >> pause-times.txt
let sar12_k = length(time)-1
let sar12_cmp = v(COMP)[sar12_k]
let sar12_cmpn = v(COMPN)[sar12_k]
let sar12_p = v(TOPP)[sar12_k]
let sar12_n = v(TOPN)[sar12_k]
let sar12_decision = 0
if sar12_cmp >= 0.9
let sar12_code = sar12_trial
let sar12_decision = 1
end
echo 5 9 $&sar12_trial $&sar12_cmp $&sar12_cmpn $&sar12_p $&sar12_n 1.19998168945312 $&sar12_decision >> decisions.csv
let sar12_previous = @VD_EVAL[pwl]
let sar12_stimulus = vector(8)
let sar12_stimulus[0] = 0
let sar12_stimulus[1] = sar12_previous[length(sar12_previous)-1]
let sar12_stimulus[2] = 0.000138001
let sar12_stimulus[3] = sar12_stimulus[1]
let sar12_stimulus[4] = 0.000138003
let sar12_stimulus[5] = 0
let sar12_stimulus[6] = 0.000148
let sar12_stimulus[7] = sar12_stimulus[5]
alter @VD_EVAL[pwl] = sar12_stimulus
let sar12_trial = sar12_code + 256
let sar12_drive = (floor(sar12_trial / 1) - 2*floor(sar12_trial / 2))*1.8
let sar12_previous = @VD_B0[pwl]
let sar12_stimulus = vector(8)
let sar12_stimulus[0] = 0
let sar12_stimulus[1] = sar12_previous[length(sar12_previous)-1]
let sar12_stimulus[2] = 0.000138001
let sar12_stimulus[3] = sar12_stimulus[1]
let sar12_stimulus[4] = 0.000138003
let sar12_stimulus[5] = sar12_drive
let sar12_stimulus[6] = 0.000148
let sar12_stimulus[7] = sar12_stimulus[5]
alter @VD_B0[pwl] = sar12_stimulus
let sar12_drive = (floor(sar12_trial / 2) - 2*floor(sar12_trial / 4))*1.8
let sar12_previous = @VD_B1[pwl]
let sar12_stimulus = vector(8)
let sar12_stimulus[0] = 0
let sar12_stimulus[1] = sar12_previous[length(sar12_previous)-1]
let sar12_stimulus[2] = 0.000138001
let sar12_stimulus[3] = sar12_stimulus[1]
let sar12_stimulus[4] = 0.000138003
let sar12_stimulus[5] = sar12_drive
let sar12_stimulus[6] = 0.000148
let sar12_stimulus[7] = sar12_stimulus[5]
alter @VD_B1[pwl] = sar12_stimulus
let sar12_drive = (floor(sar12_trial / 4) - 2*floor(sar12_trial / 8))*1.8
let sar12_previous = @VD_B2[pwl]
let sar12_stimulus = vector(8)
let sar12_stimulus[0] = 0
let sar12_stimulus[1] = sar12_previous[length(sar12_previous)-1]
let sar12_stimulus[2] = 0.000138001
let sar12_stimulus[3] = sar12_stimulus[1]
let sar12_stimulus[4] = 0.000138003
let sar12_stimulus[5] = sar12_drive
let sar12_stimulus[6] = 0.000148
let sar12_stimulus[7] = sar12_stimulus[5]
alter @VD_B2[pwl] = sar12_stimulus
let sar12_drive = (floor(sar12_trial / 8) - 2*floor(sar12_trial / 16))*1.8
let sar12_previous = @VD_B3[pwl]
let sar12_stimulus = vector(8)
let sar12_stimulus[0] = 0
let sar12_stimulus[1] = sar12_previous[length(sar12_previous)-1]
let sar12_stimulus[2] = 0.000138001
let sar12_stimulus[3] = sar12_stimulus[1]
let sar12_stimulus[4] = 0.000138003
let sar12_stimulus[5] = sar12_drive
let sar12_stimulus[6] = 0.000148
let sar12_stimulus[7] = sar12_stimulus[5]
alter @VD_B3[pwl] = sar12_stimulus
let sar12_drive = (floor(sar12_trial / 16) - 2*floor(sar12_trial / 32))*1.8
let sar12_previous = @VD_B4[pwl]
let sar12_stimulus = vector(8)
let sar12_stimulus[0] = 0
let sar12_stimulus[1] = sar12_previous[length(sar12_previous)-1]
let sar12_stimulus[2] = 0.000138001
let sar12_stimulus[3] = sar12_stimulus[1]
let sar12_stimulus[4] = 0.000138003
let sar12_stimulus[5] = sar12_drive
let sar12_stimulus[6] = 0.000148
let sar12_stimulus[7] = sar12_stimulus[5]
alter @VD_B4[pwl] = sar12_stimulus
let sar12_drive = (floor(sar12_trial / 32) - 2*floor(sar12_trial / 64))*1.8
let sar12_previous = @VD_B5[pwl]
let sar12_stimulus = vector(8)
let sar12_stimulus[0] = 0
let sar12_stimulus[1] = sar12_previous[length(sar12_previous)-1]
let sar12_stimulus[2] = 0.000138001
let sar12_stimulus[3] = sar12_stimulus[1]
let sar12_stimulus[4] = 0.000138003
let sar12_stimulus[5] = sar12_drive
let sar12_stimulus[6] = 0.000148
let sar12_stimulus[7] = sar12_stimulus[5]
alter @VD_B5[pwl] = sar12_stimulus
let sar12_drive = (floor(sar12_trial / 64) - 2*floor(sar12_trial / 128))*1.8
let sar12_previous = @VD_B6[pwl]
let sar12_stimulus = vector(8)
let sar12_stimulus[0] = 0
let sar12_stimulus[1] = sar12_previous[length(sar12_previous)-1]
let sar12_stimulus[2] = 0.000138001
let sar12_stimulus[3] = sar12_stimulus[1]
let sar12_stimulus[4] = 0.000138003
let sar12_stimulus[5] = sar12_drive
let sar12_stimulus[6] = 0.000148
let sar12_stimulus[7] = sar12_stimulus[5]
alter @VD_B6[pwl] = sar12_stimulus
let sar12_drive = (floor(sar12_trial / 128) - 2*floor(sar12_trial / 256))*1.8
let sar12_previous = @VD_B7[pwl]
let sar12_stimulus = vector(8)
let sar12_stimulus[0] = 0
let sar12_stimulus[1] = sar12_previous[length(sar12_previous)-1]
let sar12_stimulus[2] = 0.000138001
let sar12_stimulus[3] = sar12_stimulus[1]
let sar12_stimulus[4] = 0.000138003
let sar12_stimulus[5] = sar12_drive
let sar12_stimulus[6] = 0.000148
let sar12_stimulus[7] = sar12_stimulus[5]
alter @VD_B7[pwl] = sar12_stimulus
let sar12_drive = (floor(sar12_trial / 256) - 2*floor(sar12_trial / 512))*1.8
let sar12_previous = @VD_B8[pwl]
let sar12_stimulus = vector(8)
let sar12_stimulus[0] = 0
let sar12_stimulus[1] = sar12_previous[length(sar12_previous)-1]
let sar12_stimulus[2] = 0.000138001
let sar12_stimulus[3] = sar12_stimulus[1]
let sar12_stimulus[4] = 0.000138003
let sar12_stimulus[5] = sar12_drive
let sar12_stimulus[6] = 0.000148
let sar12_stimulus[7] = sar12_stimulus[5]
alter @VD_B8[pwl] = sar12_stimulus
let sar12_drive = (floor(sar12_trial / 512) - 2*floor(sar12_trial / 1024))*1.8
let sar12_previous = @VD_B9[pwl]
let sar12_stimulus = vector(8)
let sar12_stimulus[0] = 0
let sar12_stimulus[1] = sar12_previous[length(sar12_previous)-1]
let sar12_stimulus[2] = 0.000138001
let sar12_stimulus[3] = sar12_stimulus[1]
let sar12_stimulus[4] = 0.000138003
let sar12_stimulus[5] = sar12_drive
let sar12_stimulus[6] = 0.000148
let sar12_stimulus[7] = sar12_stimulus[5]
alter @VD_B9[pwl] = sar12_stimulus
let sar12_drive = (floor(sar12_trial / 1024) - 2*floor(sar12_trial / 2048))*1.8
let sar12_previous = @VD_B10[pwl]
let sar12_stimulus = vector(8)
let sar12_stimulus[0] = 0
let sar12_stimulus[1] = sar12_previous[length(sar12_previous)-1]
let sar12_stimulus[2] = 0.000138001
let sar12_stimulus[3] = sar12_stimulus[1]
let sar12_stimulus[4] = 0.000138003
let sar12_stimulus[5] = sar12_drive
let sar12_stimulus[6] = 0.000148
let sar12_stimulus[7] = sar12_stimulus[5]
alter @VD_B10[pwl] = sar12_stimulus
let sar12_drive = (floor(sar12_trial / 2048) - 2*floor(sar12_trial / 4096))*1.8
let sar12_previous = @VD_B11[pwl]
let sar12_stimulus = vector(8)
let sar12_stimulus[0] = 0
let sar12_stimulus[1] = sar12_previous[length(sar12_previous)-1]
let sar12_stimulus[2] = 0.000138001
let sar12_stimulus[3] = sar12_stimulus[1]
let sar12_stimulus[4] = 0.000138003
let sar12_stimulus[5] = sar12_drive
let sar12_stimulus[6] = 0.000148
let sar12_stimulus[7] = sar12_stimulus[5]
alter @VD_B11[pwl] = sar12_stimulus
let sar12_drive = (floor(sar12_trial / 4096) - 2*floor(sar12_trial / 8192))*1.8
let sar12_previous = @VD_B12[pwl]
let sar12_stimulus = vector(8)
let sar12_stimulus[0] = 0
let sar12_stimulus[1] = sar12_previous[length(sar12_previous)-1]
let sar12_stimulus[2] = 0.000138001
let sar12_stimulus[3] = sar12_stimulus[1]
let sar12_stimulus[4] = 0.000138003
let sar12_stimulus[5] = sar12_drive
let sar12_stimulus[6] = 0.000148
let sar12_stimulus[7] = sar12_stimulus[5]
alter @VD_B12[pwl] = sar12_stimulus
let sar12_drive = (floor(sar12_trial / 8192) - 2*floor(sar12_trial / 16384))*1.8
let sar12_previous = @VD_B13[pwl]
let sar12_stimulus = vector(8)
let sar12_stimulus[0] = 0
let sar12_stimulus[1] = sar12_previous[length(sar12_previous)-1]
let sar12_stimulus[2] = 0.000138001
let sar12_stimulus[3] = sar12_stimulus[1]
let sar12_stimulus[4] = 0.000138003
let sar12_stimulus[5] = sar12_drive
let sar12_stimulus[6] = 0.000148
let sar12_stimulus[7] = sar12_stimulus[5]
alter @VD_B13[pwl] = sar12_stimulus
let sar12_drive = (floor(sar12_trial / 16384) - 2*floor(sar12_trial / 32768))*1.8
let sar12_previous = @VD_B14[pwl]
let sar12_stimulus = vector(8)
let sar12_stimulus[0] = 0
let sar12_stimulus[1] = sar12_previous[length(sar12_previous)-1]
let sar12_stimulus[2] = 0.000138001
let sar12_stimulus[3] = sar12_stimulus[1]
let sar12_stimulus[4] = 0.000138003
let sar12_stimulus[5] = sar12_drive
let sar12_stimulus[6] = 0.000148
let sar12_stimulus[7] = sar12_stimulus[5]
alter @VD_B14[pwl] = sar12_stimulus
let sar12_drive = (floor(sar12_trial / 32768) - 2*floor(sar12_trial / 65536))*1.8
let sar12_previous = @VD_B15[pwl]
let sar12_stimulus = vector(8)
let sar12_stimulus[0] = 0
let sar12_stimulus[1] = sar12_previous[length(sar12_previous)-1]
let sar12_stimulus[2] = 0.000138001
let sar12_stimulus[3] = sar12_stimulus[1]
let sar12_stimulus[4] = 0.000138003
let sar12_stimulus[5] = sar12_drive
let sar12_stimulus[6] = 0.000148
let sar12_stimulus[7] = sar12_stimulus[5]
alter @VD_B15[pwl] = sar12_stimulus
resume
let sar12_k = length(time)-1
if abs(time[sar12_k] - 0.0001385) > 1e-12
print time[sar12_k]
echo expected_pause_time_s 0.0001385
echo SAR12_PAUSE_FAILED
quit 1
end
print time[sar12_k] >> pause-times.txt
let sar12_previous = @VD_EVAL[pwl]
let sar12_stimulus = vector(8)
let sar12_stimulus[0] = 0
let sar12_stimulus[1] = sar12_previous[length(sar12_previous)-1]
let sar12_stimulus[2] = 0.000138501
let sar12_stimulus[3] = sar12_stimulus[1]
let sar12_stimulus[4] = 0.000138503
let sar12_stimulus[5] = 1.8
let sar12_stimulus[6] = 0.000148
let sar12_stimulus[7] = sar12_stimulus[5]
alter @VD_EVAL[pwl] = sar12_stimulus
resume
let sar12_k = length(time)-1
if abs(time[sar12_k] - 0.000139) > 1e-12
print time[sar12_k]
echo expected_pause_time_s 0.000139
echo SAR12_PAUSE_FAILED
quit 1
end
print time[sar12_k] >> pause-times.txt
let sar12_k = length(time)-1
let sar12_cmp = v(COMP)[sar12_k]
let sar12_cmpn = v(COMPN)[sar12_k]
let sar12_p = v(TOPP)[sar12_k]
let sar12_n = v(TOPN)[sar12_k]
let sar12_decision = 0
if sar12_cmp >= 0.9
let sar12_code = sar12_trial
let sar12_decision = 1
end
echo 5 8 $&sar12_trial $&sar12_cmp $&sar12_cmpn $&sar12_p $&sar12_n 1.19998168945312 $&sar12_decision >> decisions.csv
let sar12_previous = @VD_EVAL[pwl]
let sar12_stimulus = vector(8)
let sar12_stimulus[0] = 0
let sar12_stimulus[1] = sar12_previous[length(sar12_previous)-1]
let sar12_stimulus[2] = 0.000139001
let sar12_stimulus[3] = sar12_stimulus[1]
let sar12_stimulus[4] = 0.000139003
let sar12_stimulus[5] = 0
let sar12_stimulus[6] = 0.000148
let sar12_stimulus[7] = sar12_stimulus[5]
alter @VD_EVAL[pwl] = sar12_stimulus
let sar12_trial = sar12_code + 128
let sar12_drive = (floor(sar12_trial / 1) - 2*floor(sar12_trial / 2))*1.8
let sar12_previous = @VD_B0[pwl]
let sar12_stimulus = vector(8)
let sar12_stimulus[0] = 0
let sar12_stimulus[1] = sar12_previous[length(sar12_previous)-1]
let sar12_stimulus[2] = 0.000139001
let sar12_stimulus[3] = sar12_stimulus[1]
let sar12_stimulus[4] = 0.000139003
let sar12_stimulus[5] = sar12_drive
let sar12_stimulus[6] = 0.000148
let sar12_stimulus[7] = sar12_stimulus[5]
alter @VD_B0[pwl] = sar12_stimulus
let sar12_drive = (floor(sar12_trial / 2) - 2*floor(sar12_trial / 4))*1.8
let sar12_previous = @VD_B1[pwl]
let sar12_stimulus = vector(8)
let sar12_stimulus[0] = 0
let sar12_stimulus[1] = sar12_previous[length(sar12_previous)-1]
let sar12_stimulus[2] = 0.000139001
let sar12_stimulus[3] = sar12_stimulus[1]
let sar12_stimulus[4] = 0.000139003
let sar12_stimulus[5] = sar12_drive
let sar12_stimulus[6] = 0.000148
let sar12_stimulus[7] = sar12_stimulus[5]
alter @VD_B1[pwl] = sar12_stimulus
let sar12_drive = (floor(sar12_trial / 4) - 2*floor(sar12_trial / 8))*1.8
let sar12_previous = @VD_B2[pwl]
let sar12_stimulus = vector(8)
let sar12_stimulus[0] = 0
let sar12_stimulus[1] = sar12_previous[length(sar12_previous)-1]
let sar12_stimulus[2] = 0.000139001
let sar12_stimulus[3] = sar12_stimulus[1]
let sar12_stimulus[4] = 0.000139003
let sar12_stimulus[5] = sar12_drive
let sar12_stimulus[6] = 0.000148
let sar12_stimulus[7] = sar12_stimulus[5]
alter @VD_B2[pwl] = sar12_stimulus
let sar12_drive = (floor(sar12_trial / 8) - 2*floor(sar12_trial / 16))*1.8
let sar12_previous = @VD_B3[pwl]
let sar12_stimulus = vector(8)
let sar12_stimulus[0] = 0
let sar12_stimulus[1] = sar12_previous[length(sar12_previous)-1]
let sar12_stimulus[2] = 0.000139001
let sar12_stimulus[3] = sar12_stimulus[1]
let sar12_stimulus[4] = 0.000139003
let sar12_stimulus[5] = sar12_drive
let sar12_stimulus[6] = 0.000148
let sar12_stimulus[7] = sar12_stimulus[5]
alter @VD_B3[pwl] = sar12_stimulus
let sar12_drive = (floor(sar12_trial / 16) - 2*floor(sar12_trial / 32))*1.8
let sar12_previous = @VD_B4[pwl]
let sar12_stimulus = vector(8)
let sar12_stimulus[0] = 0
let sar12_stimulus[1] = sar12_previous[length(sar12_previous)-1]
let sar12_stimulus[2] = 0.000139001
let sar12_stimulus[3] = sar12_stimulus[1]
let sar12_stimulus[4] = 0.000139003
let sar12_stimulus[5] = sar12_drive
let sar12_stimulus[6] = 0.000148
let sar12_stimulus[7] = sar12_stimulus[5]
alter @VD_B4[pwl] = sar12_stimulus
let sar12_drive = (floor(sar12_trial / 32) - 2*floor(sar12_trial / 64))*1.8
let sar12_previous = @VD_B5[pwl]
let sar12_stimulus = vector(8)
let sar12_stimulus[0] = 0
let sar12_stimulus[1] = sar12_previous[length(sar12_previous)-1]
let sar12_stimulus[2] = 0.000139001
let sar12_stimulus[3] = sar12_stimulus[1]
let sar12_stimulus[4] = 0.000139003
let sar12_stimulus[5] = sar12_drive
let sar12_stimulus[6] = 0.000148
let sar12_stimulus[7] = sar12_stimulus[5]
alter @VD_B5[pwl] = sar12_stimulus
let sar12_drive = (floor(sar12_trial / 64) - 2*floor(sar12_trial / 128))*1.8
let sar12_previous = @VD_B6[pwl]
let sar12_stimulus = vector(8)
let sar12_stimulus[0] = 0
let sar12_stimulus[1] = sar12_previous[length(sar12_previous)-1]
let sar12_stimulus[2] = 0.000139001
let sar12_stimulus[3] = sar12_stimulus[1]
let sar12_stimulus[4] = 0.000139003
let sar12_stimulus[5] = sar12_drive
let sar12_stimulus[6] = 0.000148
let sar12_stimulus[7] = sar12_stimulus[5]
alter @VD_B6[pwl] = sar12_stimulus
let sar12_drive = (floor(sar12_trial / 128) - 2*floor(sar12_trial / 256))*1.8
let sar12_previous = @VD_B7[pwl]
let sar12_stimulus = vector(8)
let sar12_stimulus[0] = 0
let sar12_stimulus[1] = sar12_previous[length(sar12_previous)-1]
let sar12_stimulus[2] = 0.000139001
let sar12_stimulus[3] = sar12_stimulus[1]
let sar12_stimulus[4] = 0.000139003
let sar12_stimulus[5] = sar12_drive
let sar12_stimulus[6] = 0.000148
let sar12_stimulus[7] = sar12_stimulus[5]
alter @VD_B7[pwl] = sar12_stimulus
let sar12_drive = (floor(sar12_trial / 256) - 2*floor(sar12_trial / 512))*1.8
let sar12_previous = @VD_B8[pwl]
let sar12_stimulus = vector(8)
let sar12_stimulus[0] = 0
let sar12_stimulus[1] = sar12_previous[length(sar12_previous)-1]
let sar12_stimulus[2] = 0.000139001
let sar12_stimulus[3] = sar12_stimulus[1]
let sar12_stimulus[4] = 0.000139003
let sar12_stimulus[5] = sar12_drive
let sar12_stimulus[6] = 0.000148
let sar12_stimulus[7] = sar12_stimulus[5]
alter @VD_B8[pwl] = sar12_stimulus
let sar12_drive = (floor(sar12_trial / 512) - 2*floor(sar12_trial / 1024))*1.8
let sar12_previous = @VD_B9[pwl]
let sar12_stimulus = vector(8)
let sar12_stimulus[0] = 0
let sar12_stimulus[1] = sar12_previous[length(sar12_previous)-1]
let sar12_stimulus[2] = 0.000139001
let sar12_stimulus[3] = sar12_stimulus[1]
let sar12_stimulus[4] = 0.000139003
let sar12_stimulus[5] = sar12_drive
let sar12_stimulus[6] = 0.000148
let sar12_stimulus[7] = sar12_stimulus[5]
alter @VD_B9[pwl] = sar12_stimulus
let sar12_drive = (floor(sar12_trial / 1024) - 2*floor(sar12_trial / 2048))*1.8
let sar12_previous = @VD_B10[pwl]
let sar12_stimulus = vector(8)
let sar12_stimulus[0] = 0
let sar12_stimulus[1] = sar12_previous[length(sar12_previous)-1]
let sar12_stimulus[2] = 0.000139001
let sar12_stimulus[3] = sar12_stimulus[1]
let sar12_stimulus[4] = 0.000139003
let sar12_stimulus[5] = sar12_drive
let sar12_stimulus[6] = 0.000148
let sar12_stimulus[7] = sar12_stimulus[5]
alter @VD_B10[pwl] = sar12_stimulus
let sar12_drive = (floor(sar12_trial / 2048) - 2*floor(sar12_trial / 4096))*1.8
let sar12_previous = @VD_B11[pwl]
let sar12_stimulus = vector(8)
let sar12_stimulus[0] = 0
let sar12_stimulus[1] = sar12_previous[length(sar12_previous)-1]
let sar12_stimulus[2] = 0.000139001
let sar12_stimulus[3] = sar12_stimulus[1]
let sar12_stimulus[4] = 0.000139003
let sar12_stimulus[5] = sar12_drive
let sar12_stimulus[6] = 0.000148
let sar12_stimulus[7] = sar12_stimulus[5]
alter @VD_B11[pwl] = sar12_stimulus
let sar12_drive = (floor(sar12_trial / 4096) - 2*floor(sar12_trial / 8192))*1.8
let sar12_previous = @VD_B12[pwl]
let sar12_stimulus = vector(8)
let sar12_stimulus[0] = 0
let sar12_stimulus[1] = sar12_previous[length(sar12_previous)-1]
let sar12_stimulus[2] = 0.000139001
let sar12_stimulus[3] = sar12_stimulus[1]
let sar12_stimulus[4] = 0.000139003
let sar12_stimulus[5] = sar12_drive
let sar12_stimulus[6] = 0.000148
let sar12_stimulus[7] = sar12_stimulus[5]
alter @VD_B12[pwl] = sar12_stimulus
let sar12_drive = (floor(sar12_trial / 8192) - 2*floor(sar12_trial / 16384))*1.8
let sar12_previous = @VD_B13[pwl]
let sar12_stimulus = vector(8)
let sar12_stimulus[0] = 0
let sar12_stimulus[1] = sar12_previous[length(sar12_previous)-1]
let sar12_stimulus[2] = 0.000139001
let sar12_stimulus[3] = sar12_stimulus[1]
let sar12_stimulus[4] = 0.000139003
let sar12_stimulus[5] = sar12_drive
let sar12_stimulus[6] = 0.000148
let sar12_stimulus[7] = sar12_stimulus[5]
alter @VD_B13[pwl] = sar12_stimulus
let sar12_drive = (floor(sar12_trial / 16384) - 2*floor(sar12_trial / 32768))*1.8
let sar12_previous = @VD_B14[pwl]
let sar12_stimulus = vector(8)
let sar12_stimulus[0] = 0
let sar12_stimulus[1] = sar12_previous[length(sar12_previous)-1]
let sar12_stimulus[2] = 0.000139001
let sar12_stimulus[3] = sar12_stimulus[1]
let sar12_stimulus[4] = 0.000139003
let sar12_stimulus[5] = sar12_drive
let sar12_stimulus[6] = 0.000148
let sar12_stimulus[7] = sar12_stimulus[5]
alter @VD_B14[pwl] = sar12_stimulus
let sar12_drive = (floor(sar12_trial / 32768) - 2*floor(sar12_trial / 65536))*1.8
let sar12_previous = @VD_B15[pwl]
let sar12_stimulus = vector(8)
let sar12_stimulus[0] = 0
let sar12_stimulus[1] = sar12_previous[length(sar12_previous)-1]
let sar12_stimulus[2] = 0.000139001
let sar12_stimulus[3] = sar12_stimulus[1]
let sar12_stimulus[4] = 0.000139003
let sar12_stimulus[5] = sar12_drive
let sar12_stimulus[6] = 0.000148
let sar12_stimulus[7] = sar12_stimulus[5]
alter @VD_B15[pwl] = sar12_stimulus
resume
let sar12_k = length(time)-1
if abs(time[sar12_k] - 0.0001395) > 1e-12
print time[sar12_k]
echo expected_pause_time_s 0.0001395
echo SAR12_PAUSE_FAILED
quit 1
end
print time[sar12_k] >> pause-times.txt
let sar12_previous = @VD_EVAL[pwl]
let sar12_stimulus = vector(8)
let sar12_stimulus[0] = 0
let sar12_stimulus[1] = sar12_previous[length(sar12_previous)-1]
let sar12_stimulus[2] = 0.000139501
let sar12_stimulus[3] = sar12_stimulus[1]
let sar12_stimulus[4] = 0.000139503
let sar12_stimulus[5] = 1.8
let sar12_stimulus[6] = 0.000148
let sar12_stimulus[7] = sar12_stimulus[5]
alter @VD_EVAL[pwl] = sar12_stimulus
resume
let sar12_k = length(time)-1
if abs(time[sar12_k] - 0.00014) > 1e-12
print time[sar12_k]
echo expected_pause_time_s 0.00014
echo SAR12_PAUSE_FAILED
quit 1
end
print time[sar12_k] >> pause-times.txt
let sar12_k = length(time)-1
let sar12_cmp = v(COMP)[sar12_k]
let sar12_cmpn = v(COMPN)[sar12_k]
let sar12_p = v(TOPP)[sar12_k]
let sar12_n = v(TOPN)[sar12_k]
let sar12_decision = 0
if sar12_cmp >= 0.9
let sar12_code = sar12_trial
let sar12_decision = 1
end
echo 5 7 $&sar12_trial $&sar12_cmp $&sar12_cmpn $&sar12_p $&sar12_n 1.19998168945312 $&sar12_decision >> decisions.csv
let sar12_previous = @VD_EVAL[pwl]
let sar12_stimulus = vector(8)
let sar12_stimulus[0] = 0
let sar12_stimulus[1] = sar12_previous[length(sar12_previous)-1]
let sar12_stimulus[2] = 0.000140001
let sar12_stimulus[3] = sar12_stimulus[1]
let sar12_stimulus[4] = 0.000140003
let sar12_stimulus[5] = 0
let sar12_stimulus[6] = 0.000148
let sar12_stimulus[7] = sar12_stimulus[5]
alter @VD_EVAL[pwl] = sar12_stimulus
let sar12_trial = sar12_code + 64
let sar12_drive = (floor(sar12_trial / 1) - 2*floor(sar12_trial / 2))*1.8
let sar12_previous = @VD_B0[pwl]
let sar12_stimulus = vector(8)
let sar12_stimulus[0] = 0
let sar12_stimulus[1] = sar12_previous[length(sar12_previous)-1]
let sar12_stimulus[2] = 0.000140001
let sar12_stimulus[3] = sar12_stimulus[1]
let sar12_stimulus[4] = 0.000140003
let sar12_stimulus[5] = sar12_drive
let sar12_stimulus[6] = 0.000148
let sar12_stimulus[7] = sar12_stimulus[5]
alter @VD_B0[pwl] = sar12_stimulus
let sar12_drive = (floor(sar12_trial / 2) - 2*floor(sar12_trial / 4))*1.8
let sar12_previous = @VD_B1[pwl]
let sar12_stimulus = vector(8)
let sar12_stimulus[0] = 0
let sar12_stimulus[1] = sar12_previous[length(sar12_previous)-1]
let sar12_stimulus[2] = 0.000140001
let sar12_stimulus[3] = sar12_stimulus[1]
let sar12_stimulus[4] = 0.000140003
let sar12_stimulus[5] = sar12_drive
let sar12_stimulus[6] = 0.000148
let sar12_stimulus[7] = sar12_stimulus[5]
alter @VD_B1[pwl] = sar12_stimulus
let sar12_drive = (floor(sar12_trial / 4) - 2*floor(sar12_trial / 8))*1.8
let sar12_previous = @VD_B2[pwl]
let sar12_stimulus = vector(8)
let sar12_stimulus[0] = 0
let sar12_stimulus[1] = sar12_previous[length(sar12_previous)-1]
let sar12_stimulus[2] = 0.000140001
let sar12_stimulus[3] = sar12_stimulus[1]
let sar12_stimulus[4] = 0.000140003
let sar12_stimulus[5] = sar12_drive
let sar12_stimulus[6] = 0.000148
let sar12_stimulus[7] = sar12_stimulus[5]
alter @VD_B2[pwl] = sar12_stimulus
let sar12_drive = (floor(sar12_trial / 8) - 2*floor(sar12_trial / 16))*1.8
let sar12_previous = @VD_B3[pwl]
let sar12_stimulus = vector(8)
let sar12_stimulus[0] = 0
let sar12_stimulus[1] = sar12_previous[length(sar12_previous)-1]
let sar12_stimulus[2] = 0.000140001
let sar12_stimulus[3] = sar12_stimulus[1]
let sar12_stimulus[4] = 0.000140003
let sar12_stimulus[5] = sar12_drive
let sar12_stimulus[6] = 0.000148
let sar12_stimulus[7] = sar12_stimulus[5]
alter @VD_B3[pwl] = sar12_stimulus
let sar12_drive = (floor(sar12_trial / 16) - 2*floor(sar12_trial / 32))*1.8
let sar12_previous = @VD_B4[pwl]
let sar12_stimulus = vector(8)
let sar12_stimulus[0] = 0
let sar12_stimulus[1] = sar12_previous[length(sar12_previous)-1]
let sar12_stimulus[2] = 0.000140001
let sar12_stimulus[3] = sar12_stimulus[1]
let sar12_stimulus[4] = 0.000140003
let sar12_stimulus[5] = sar12_drive
let sar12_stimulus[6] = 0.000148
let sar12_stimulus[7] = sar12_stimulus[5]
alter @VD_B4[pwl] = sar12_stimulus
let sar12_drive = (floor(sar12_trial / 32) - 2*floor(sar12_trial / 64))*1.8
let sar12_previous = @VD_B5[pwl]
let sar12_stimulus = vector(8)
let sar12_stimulus[0] = 0
let sar12_stimulus[1] = sar12_previous[length(sar12_previous)-1]
let sar12_stimulus[2] = 0.000140001
let sar12_stimulus[3] = sar12_stimulus[1]
let sar12_stimulus[4] = 0.000140003
let sar12_stimulus[5] = sar12_drive
let sar12_stimulus[6] = 0.000148
let sar12_stimulus[7] = sar12_stimulus[5]
alter @VD_B5[pwl] = sar12_stimulus
let sar12_drive = (floor(sar12_trial / 64) - 2*floor(sar12_trial / 128))*1.8
let sar12_previous = @VD_B6[pwl]
let sar12_stimulus = vector(8)
let sar12_stimulus[0] = 0
let sar12_stimulus[1] = sar12_previous[length(sar12_previous)-1]
let sar12_stimulus[2] = 0.000140001
let sar12_stimulus[3] = sar12_stimulus[1]
let sar12_stimulus[4] = 0.000140003
let sar12_stimulus[5] = sar12_drive
let sar12_stimulus[6] = 0.000148
let sar12_stimulus[7] = sar12_stimulus[5]
alter @VD_B6[pwl] = sar12_stimulus
let sar12_drive = (floor(sar12_trial / 128) - 2*floor(sar12_trial / 256))*1.8
let sar12_previous = @VD_B7[pwl]
let sar12_stimulus = vector(8)
let sar12_stimulus[0] = 0
let sar12_stimulus[1] = sar12_previous[length(sar12_previous)-1]
let sar12_stimulus[2] = 0.000140001
let sar12_stimulus[3] = sar12_stimulus[1]
let sar12_stimulus[4] = 0.000140003
let sar12_stimulus[5] = sar12_drive
let sar12_stimulus[6] = 0.000148
let sar12_stimulus[7] = sar12_stimulus[5]
alter @VD_B7[pwl] = sar12_stimulus
let sar12_drive = (floor(sar12_trial / 256) - 2*floor(sar12_trial / 512))*1.8
let sar12_previous = @VD_B8[pwl]
let sar12_stimulus = vector(8)
let sar12_stimulus[0] = 0
let sar12_stimulus[1] = sar12_previous[length(sar12_previous)-1]
let sar12_stimulus[2] = 0.000140001
let sar12_stimulus[3] = sar12_stimulus[1]
let sar12_stimulus[4] = 0.000140003
let sar12_stimulus[5] = sar12_drive
let sar12_stimulus[6] = 0.000148
let sar12_stimulus[7] = sar12_stimulus[5]
alter @VD_B8[pwl] = sar12_stimulus
let sar12_drive = (floor(sar12_trial / 512) - 2*floor(sar12_trial / 1024))*1.8
let sar12_previous = @VD_B9[pwl]
let sar12_stimulus = vector(8)
let sar12_stimulus[0] = 0
let sar12_stimulus[1] = sar12_previous[length(sar12_previous)-1]
let sar12_stimulus[2] = 0.000140001
let sar12_stimulus[3] = sar12_stimulus[1]
let sar12_stimulus[4] = 0.000140003
let sar12_stimulus[5] = sar12_drive
let sar12_stimulus[6] = 0.000148
let sar12_stimulus[7] = sar12_stimulus[5]
alter @VD_B9[pwl] = sar12_stimulus
let sar12_drive = (floor(sar12_trial / 1024) - 2*floor(sar12_trial / 2048))*1.8
let sar12_previous = @VD_B10[pwl]
let sar12_stimulus = vector(8)
let sar12_stimulus[0] = 0
let sar12_stimulus[1] = sar12_previous[length(sar12_previous)-1]
let sar12_stimulus[2] = 0.000140001
let sar12_stimulus[3] = sar12_stimulus[1]
let sar12_stimulus[4] = 0.000140003
let sar12_stimulus[5] = sar12_drive
let sar12_stimulus[6] = 0.000148
let sar12_stimulus[7] = sar12_stimulus[5]
alter @VD_B10[pwl] = sar12_stimulus
let sar12_drive = (floor(sar12_trial / 2048) - 2*floor(sar12_trial / 4096))*1.8
let sar12_previous = @VD_B11[pwl]
let sar12_stimulus = vector(8)
let sar12_stimulus[0] = 0
let sar12_stimulus[1] = sar12_previous[length(sar12_previous)-1]
let sar12_stimulus[2] = 0.000140001
let sar12_stimulus[3] = sar12_stimulus[1]
let sar12_stimulus[4] = 0.000140003
let sar12_stimulus[5] = sar12_drive
let sar12_stimulus[6] = 0.000148
let sar12_stimulus[7] = sar12_stimulus[5]
alter @VD_B11[pwl] = sar12_stimulus
let sar12_drive = (floor(sar12_trial / 4096) - 2*floor(sar12_trial / 8192))*1.8
let sar12_previous = @VD_B12[pwl]
let sar12_stimulus = vector(8)
let sar12_stimulus[0] = 0
let sar12_stimulus[1] = sar12_previous[length(sar12_previous)-1]
let sar12_stimulus[2] = 0.000140001
let sar12_stimulus[3] = sar12_stimulus[1]
let sar12_stimulus[4] = 0.000140003
let sar12_stimulus[5] = sar12_drive
let sar12_stimulus[6] = 0.000148
let sar12_stimulus[7] = sar12_stimulus[5]
alter @VD_B12[pwl] = sar12_stimulus
let sar12_drive = (floor(sar12_trial / 8192) - 2*floor(sar12_trial / 16384))*1.8
let sar12_previous = @VD_B13[pwl]
let sar12_stimulus = vector(8)
let sar12_stimulus[0] = 0
let sar12_stimulus[1] = sar12_previous[length(sar12_previous)-1]
let sar12_stimulus[2] = 0.000140001
let sar12_stimulus[3] = sar12_stimulus[1]
let sar12_stimulus[4] = 0.000140003
let sar12_stimulus[5] = sar12_drive
let sar12_stimulus[6] = 0.000148
let sar12_stimulus[7] = sar12_stimulus[5]
alter @VD_B13[pwl] = sar12_stimulus
let sar12_drive = (floor(sar12_trial / 16384) - 2*floor(sar12_trial / 32768))*1.8
let sar12_previous = @VD_B14[pwl]
let sar12_stimulus = vector(8)
let sar12_stimulus[0] = 0
let sar12_stimulus[1] = sar12_previous[length(sar12_previous)-1]
let sar12_stimulus[2] = 0.000140001
let sar12_stimulus[3] = sar12_stimulus[1]
let sar12_stimulus[4] = 0.000140003
let sar12_stimulus[5] = sar12_drive
let sar12_stimulus[6] = 0.000148
let sar12_stimulus[7] = sar12_stimulus[5]
alter @VD_B14[pwl] = sar12_stimulus
let sar12_drive = (floor(sar12_trial / 32768) - 2*floor(sar12_trial / 65536))*1.8
let sar12_previous = @VD_B15[pwl]
let sar12_stimulus = vector(8)
let sar12_stimulus[0] = 0
let sar12_stimulus[1] = sar12_previous[length(sar12_previous)-1]
let sar12_stimulus[2] = 0.000140001
let sar12_stimulus[3] = sar12_stimulus[1]
let sar12_stimulus[4] = 0.000140003
let sar12_stimulus[5] = sar12_drive
let sar12_stimulus[6] = 0.000148
let sar12_stimulus[7] = sar12_stimulus[5]
alter @VD_B15[pwl] = sar12_stimulus
resume
let sar12_k = length(time)-1
if abs(time[sar12_k] - 0.0001405) > 1e-12
print time[sar12_k]
echo expected_pause_time_s 0.0001405
echo SAR12_PAUSE_FAILED
quit 1
end
print time[sar12_k] >> pause-times.txt
let sar12_previous = @VD_EVAL[pwl]
let sar12_stimulus = vector(8)
let sar12_stimulus[0] = 0
let sar12_stimulus[1] = sar12_previous[length(sar12_previous)-1]
let sar12_stimulus[2] = 0.000140501
let sar12_stimulus[3] = sar12_stimulus[1]
let sar12_stimulus[4] = 0.000140503
let sar12_stimulus[5] = 1.8
let sar12_stimulus[6] = 0.000148
let sar12_stimulus[7] = sar12_stimulus[5]
alter @VD_EVAL[pwl] = sar12_stimulus
resume
let sar12_k = length(time)-1
if abs(time[sar12_k] - 0.000141) > 1e-12
print time[sar12_k]
echo expected_pause_time_s 0.000141
echo SAR12_PAUSE_FAILED
quit 1
end
print time[sar12_k] >> pause-times.txt
let sar12_k = length(time)-1
let sar12_cmp = v(COMP)[sar12_k]
let sar12_cmpn = v(COMPN)[sar12_k]
let sar12_p = v(TOPP)[sar12_k]
let sar12_n = v(TOPN)[sar12_k]
let sar12_decision = 0
if sar12_cmp >= 0.9
let sar12_code = sar12_trial
let sar12_decision = 1
end
echo 5 6 $&sar12_trial $&sar12_cmp $&sar12_cmpn $&sar12_p $&sar12_n 1.19998168945312 $&sar12_decision >> decisions.csv
let sar12_previous = @VD_EVAL[pwl]
let sar12_stimulus = vector(8)
let sar12_stimulus[0] = 0
let sar12_stimulus[1] = sar12_previous[length(sar12_previous)-1]
let sar12_stimulus[2] = 0.000141001
let sar12_stimulus[3] = sar12_stimulus[1]
let sar12_stimulus[4] = 0.000141003
let sar12_stimulus[5] = 0
let sar12_stimulus[6] = 0.000148
let sar12_stimulus[7] = sar12_stimulus[5]
alter @VD_EVAL[pwl] = sar12_stimulus
let sar12_trial = sar12_code + 32
let sar12_drive = (floor(sar12_trial / 1) - 2*floor(sar12_trial / 2))*1.8
let sar12_previous = @VD_B0[pwl]
let sar12_stimulus = vector(8)
let sar12_stimulus[0] = 0
let sar12_stimulus[1] = sar12_previous[length(sar12_previous)-1]
let sar12_stimulus[2] = 0.000141001
let sar12_stimulus[3] = sar12_stimulus[1]
let sar12_stimulus[4] = 0.000141003
let sar12_stimulus[5] = sar12_drive
let sar12_stimulus[6] = 0.000148
let sar12_stimulus[7] = sar12_stimulus[5]
alter @VD_B0[pwl] = sar12_stimulus
let sar12_drive = (floor(sar12_trial / 2) - 2*floor(sar12_trial / 4))*1.8
let sar12_previous = @VD_B1[pwl]
let sar12_stimulus = vector(8)
let sar12_stimulus[0] = 0
let sar12_stimulus[1] = sar12_previous[length(sar12_previous)-1]
let sar12_stimulus[2] = 0.000141001
let sar12_stimulus[3] = sar12_stimulus[1]
let sar12_stimulus[4] = 0.000141003
let sar12_stimulus[5] = sar12_drive
let sar12_stimulus[6] = 0.000148
let sar12_stimulus[7] = sar12_stimulus[5]
alter @VD_B1[pwl] = sar12_stimulus
let sar12_drive = (floor(sar12_trial / 4) - 2*floor(sar12_trial / 8))*1.8
let sar12_previous = @VD_B2[pwl]
let sar12_stimulus = vector(8)
let sar12_stimulus[0] = 0
let sar12_stimulus[1] = sar12_previous[length(sar12_previous)-1]
let sar12_stimulus[2] = 0.000141001
let sar12_stimulus[3] = sar12_stimulus[1]
let sar12_stimulus[4] = 0.000141003
let sar12_stimulus[5] = sar12_drive
let sar12_stimulus[6] = 0.000148
let sar12_stimulus[7] = sar12_stimulus[5]
alter @VD_B2[pwl] = sar12_stimulus
let sar12_drive = (floor(sar12_trial / 8) - 2*floor(sar12_trial / 16))*1.8
let sar12_previous = @VD_B3[pwl]
let sar12_stimulus = vector(8)
let sar12_stimulus[0] = 0
let sar12_stimulus[1] = sar12_previous[length(sar12_previous)-1]
let sar12_stimulus[2] = 0.000141001
let sar12_stimulus[3] = sar12_stimulus[1]
let sar12_stimulus[4] = 0.000141003
let sar12_stimulus[5] = sar12_drive
let sar12_stimulus[6] = 0.000148
let sar12_stimulus[7] = sar12_stimulus[5]
alter @VD_B3[pwl] = sar12_stimulus
let sar12_drive = (floor(sar12_trial / 16) - 2*floor(sar12_trial / 32))*1.8
let sar12_previous = @VD_B4[pwl]
let sar12_stimulus = vector(8)
let sar12_stimulus[0] = 0
let sar12_stimulus[1] = sar12_previous[length(sar12_previous)-1]
let sar12_stimulus[2] = 0.000141001
let sar12_stimulus[3] = sar12_stimulus[1]
let sar12_stimulus[4] = 0.000141003
let sar12_stimulus[5] = sar12_drive
let sar12_stimulus[6] = 0.000148
let sar12_stimulus[7] = sar12_stimulus[5]
alter @VD_B4[pwl] = sar12_stimulus
let sar12_drive = (floor(sar12_trial / 32) - 2*floor(sar12_trial / 64))*1.8
let sar12_previous = @VD_B5[pwl]
let sar12_stimulus = vector(8)
let sar12_stimulus[0] = 0
let sar12_stimulus[1] = sar12_previous[length(sar12_previous)-1]
let sar12_stimulus[2] = 0.000141001
let sar12_stimulus[3] = sar12_stimulus[1]
let sar12_stimulus[4] = 0.000141003
let sar12_stimulus[5] = sar12_drive
let sar12_stimulus[6] = 0.000148
let sar12_stimulus[7] = sar12_stimulus[5]
alter @VD_B5[pwl] = sar12_stimulus
let sar12_drive = (floor(sar12_trial / 64) - 2*floor(sar12_trial / 128))*1.8
let sar12_previous = @VD_B6[pwl]
let sar12_stimulus = vector(8)
let sar12_stimulus[0] = 0
let sar12_stimulus[1] = sar12_previous[length(sar12_previous)-1]
let sar12_stimulus[2] = 0.000141001
let sar12_stimulus[3] = sar12_stimulus[1]
let sar12_stimulus[4] = 0.000141003
let sar12_stimulus[5] = sar12_drive
let sar12_stimulus[6] = 0.000148
let sar12_stimulus[7] = sar12_stimulus[5]
alter @VD_B6[pwl] = sar12_stimulus
let sar12_drive = (floor(sar12_trial / 128) - 2*floor(sar12_trial / 256))*1.8
let sar12_previous = @VD_B7[pwl]
let sar12_stimulus = vector(8)
let sar12_stimulus[0] = 0
let sar12_stimulus[1] = sar12_previous[length(sar12_previous)-1]
let sar12_stimulus[2] = 0.000141001
let sar12_stimulus[3] = sar12_stimulus[1]
let sar12_stimulus[4] = 0.000141003
let sar12_stimulus[5] = sar12_drive
let sar12_stimulus[6] = 0.000148
let sar12_stimulus[7] = sar12_stimulus[5]
alter @VD_B7[pwl] = sar12_stimulus
let sar12_drive = (floor(sar12_trial / 256) - 2*floor(sar12_trial / 512))*1.8
let sar12_previous = @VD_B8[pwl]
let sar12_stimulus = vector(8)
let sar12_stimulus[0] = 0
let sar12_stimulus[1] = sar12_previous[length(sar12_previous)-1]
let sar12_stimulus[2] = 0.000141001
let sar12_stimulus[3] = sar12_stimulus[1]
let sar12_stimulus[4] = 0.000141003
let sar12_stimulus[5] = sar12_drive
let sar12_stimulus[6] = 0.000148
let sar12_stimulus[7] = sar12_stimulus[5]
alter @VD_B8[pwl] = sar12_stimulus
let sar12_drive = (floor(sar12_trial / 512) - 2*floor(sar12_trial / 1024))*1.8
let sar12_previous = @VD_B9[pwl]
let sar12_stimulus = vector(8)
let sar12_stimulus[0] = 0
let sar12_stimulus[1] = sar12_previous[length(sar12_previous)-1]
let sar12_stimulus[2] = 0.000141001
let sar12_stimulus[3] = sar12_stimulus[1]
let sar12_stimulus[4] = 0.000141003
let sar12_stimulus[5] = sar12_drive
let sar12_stimulus[6] = 0.000148
let sar12_stimulus[7] = sar12_stimulus[5]
alter @VD_B9[pwl] = sar12_stimulus
let sar12_drive = (floor(sar12_trial / 1024) - 2*floor(sar12_trial / 2048))*1.8
let sar12_previous = @VD_B10[pwl]
let sar12_stimulus = vector(8)
let sar12_stimulus[0] = 0
let sar12_stimulus[1] = sar12_previous[length(sar12_previous)-1]
let sar12_stimulus[2] = 0.000141001
let sar12_stimulus[3] = sar12_stimulus[1]
let sar12_stimulus[4] = 0.000141003
let sar12_stimulus[5] = sar12_drive
let sar12_stimulus[6] = 0.000148
let sar12_stimulus[7] = sar12_stimulus[5]
alter @VD_B10[pwl] = sar12_stimulus
let sar12_drive = (floor(sar12_trial / 2048) - 2*floor(sar12_trial / 4096))*1.8
let sar12_previous = @VD_B11[pwl]
let sar12_stimulus = vector(8)
let sar12_stimulus[0] = 0
let sar12_stimulus[1] = sar12_previous[length(sar12_previous)-1]
let sar12_stimulus[2] = 0.000141001
let sar12_stimulus[3] = sar12_stimulus[1]
let sar12_stimulus[4] = 0.000141003
let sar12_stimulus[5] = sar12_drive
let sar12_stimulus[6] = 0.000148
let sar12_stimulus[7] = sar12_stimulus[5]
alter @VD_B11[pwl] = sar12_stimulus
let sar12_drive = (floor(sar12_trial / 4096) - 2*floor(sar12_trial / 8192))*1.8
let sar12_previous = @VD_B12[pwl]
let sar12_stimulus = vector(8)
let sar12_stimulus[0] = 0
let sar12_stimulus[1] = sar12_previous[length(sar12_previous)-1]
let sar12_stimulus[2] = 0.000141001
let sar12_stimulus[3] = sar12_stimulus[1]
let sar12_stimulus[4] = 0.000141003
let sar12_stimulus[5] = sar12_drive
let sar12_stimulus[6] = 0.000148
let sar12_stimulus[7] = sar12_stimulus[5]
alter @VD_B12[pwl] = sar12_stimulus
let sar12_drive = (floor(sar12_trial / 8192) - 2*floor(sar12_trial / 16384))*1.8
let sar12_previous = @VD_B13[pwl]
let sar12_stimulus = vector(8)
let sar12_stimulus[0] = 0
let sar12_stimulus[1] = sar12_previous[length(sar12_previous)-1]
let sar12_stimulus[2] = 0.000141001
let sar12_stimulus[3] = sar12_stimulus[1]
let sar12_stimulus[4] = 0.000141003
let sar12_stimulus[5] = sar12_drive
let sar12_stimulus[6] = 0.000148
let sar12_stimulus[7] = sar12_stimulus[5]
alter @VD_B13[pwl] = sar12_stimulus
let sar12_drive = (floor(sar12_trial / 16384) - 2*floor(sar12_trial / 32768))*1.8
let sar12_previous = @VD_B14[pwl]
let sar12_stimulus = vector(8)
let sar12_stimulus[0] = 0
let sar12_stimulus[1] = sar12_previous[length(sar12_previous)-1]
let sar12_stimulus[2] = 0.000141001
let sar12_stimulus[3] = sar12_stimulus[1]
let sar12_stimulus[4] = 0.000141003
let sar12_stimulus[5] = sar12_drive
let sar12_stimulus[6] = 0.000148
let sar12_stimulus[7] = sar12_stimulus[5]
alter @VD_B14[pwl] = sar12_stimulus
let sar12_drive = (floor(sar12_trial / 32768) - 2*floor(sar12_trial / 65536))*1.8
let sar12_previous = @VD_B15[pwl]
let sar12_stimulus = vector(8)
let sar12_stimulus[0] = 0
let sar12_stimulus[1] = sar12_previous[length(sar12_previous)-1]
let sar12_stimulus[2] = 0.000141001
let sar12_stimulus[3] = sar12_stimulus[1]
let sar12_stimulus[4] = 0.000141003
let sar12_stimulus[5] = sar12_drive
let sar12_stimulus[6] = 0.000148
let sar12_stimulus[7] = sar12_stimulus[5]
alter @VD_B15[pwl] = sar12_stimulus
resume
let sar12_k = length(time)-1
if abs(time[sar12_k] - 0.0001415) > 1e-12
print time[sar12_k]
echo expected_pause_time_s 0.0001415
echo SAR12_PAUSE_FAILED
quit 1
end
print time[sar12_k] >> pause-times.txt
let sar12_previous = @VD_EVAL[pwl]
let sar12_stimulus = vector(8)
let sar12_stimulus[0] = 0
let sar12_stimulus[1] = sar12_previous[length(sar12_previous)-1]
let sar12_stimulus[2] = 0.000141501
let sar12_stimulus[3] = sar12_stimulus[1]
let sar12_stimulus[4] = 0.000141503
let sar12_stimulus[5] = 1.8
let sar12_stimulus[6] = 0.000148
let sar12_stimulus[7] = sar12_stimulus[5]
alter @VD_EVAL[pwl] = sar12_stimulus
resume
let sar12_k = length(time)-1
if abs(time[sar12_k] - 0.000142) > 1e-12
print time[sar12_k]
echo expected_pause_time_s 0.000142
echo SAR12_PAUSE_FAILED
quit 1
end
print time[sar12_k] >> pause-times.txt
let sar12_k = length(time)-1
let sar12_cmp = v(COMP)[sar12_k]
let sar12_cmpn = v(COMPN)[sar12_k]
let sar12_p = v(TOPP)[sar12_k]
let sar12_n = v(TOPN)[sar12_k]
let sar12_decision = 0
if sar12_cmp >= 0.9
let sar12_code = sar12_trial
let sar12_decision = 1
end
echo 5 5 $&sar12_trial $&sar12_cmp $&sar12_cmpn $&sar12_p $&sar12_n 1.19998168945312 $&sar12_decision >> decisions.csv
let sar12_previous = @VD_EVAL[pwl]
let sar12_stimulus = vector(8)
let sar12_stimulus[0] = 0
let sar12_stimulus[1] = sar12_previous[length(sar12_previous)-1]
let sar12_stimulus[2] = 0.000142001
let sar12_stimulus[3] = sar12_stimulus[1]
let sar12_stimulus[4] = 0.000142003
let sar12_stimulus[5] = 0
let sar12_stimulus[6] = 0.000148
let sar12_stimulus[7] = sar12_stimulus[5]
alter @VD_EVAL[pwl] = sar12_stimulus
let sar12_trial = sar12_code + 16
let sar12_drive = (floor(sar12_trial / 1) - 2*floor(sar12_trial / 2))*1.8
let sar12_previous = @VD_B0[pwl]
let sar12_stimulus = vector(8)
let sar12_stimulus[0] = 0
let sar12_stimulus[1] = sar12_previous[length(sar12_previous)-1]
let sar12_stimulus[2] = 0.000142001
let sar12_stimulus[3] = sar12_stimulus[1]
let sar12_stimulus[4] = 0.000142003
let sar12_stimulus[5] = sar12_drive
let sar12_stimulus[6] = 0.000148
let sar12_stimulus[7] = sar12_stimulus[5]
alter @VD_B0[pwl] = sar12_stimulus
let sar12_drive = (floor(sar12_trial / 2) - 2*floor(sar12_trial / 4))*1.8
let sar12_previous = @VD_B1[pwl]
let sar12_stimulus = vector(8)
let sar12_stimulus[0] = 0
let sar12_stimulus[1] = sar12_previous[length(sar12_previous)-1]
let sar12_stimulus[2] = 0.000142001
let sar12_stimulus[3] = sar12_stimulus[1]
let sar12_stimulus[4] = 0.000142003
let sar12_stimulus[5] = sar12_drive
let sar12_stimulus[6] = 0.000148
let sar12_stimulus[7] = sar12_stimulus[5]
alter @VD_B1[pwl] = sar12_stimulus
let sar12_drive = (floor(sar12_trial / 4) - 2*floor(sar12_trial / 8))*1.8
let sar12_previous = @VD_B2[pwl]
let sar12_stimulus = vector(8)
let sar12_stimulus[0] = 0
let sar12_stimulus[1] = sar12_previous[length(sar12_previous)-1]
let sar12_stimulus[2] = 0.000142001
let sar12_stimulus[3] = sar12_stimulus[1]
let sar12_stimulus[4] = 0.000142003
let sar12_stimulus[5] = sar12_drive
let sar12_stimulus[6] = 0.000148
let sar12_stimulus[7] = sar12_stimulus[5]
alter @VD_B2[pwl] = sar12_stimulus
let sar12_drive = (floor(sar12_trial / 8) - 2*floor(sar12_trial / 16))*1.8
let sar12_previous = @VD_B3[pwl]
let sar12_stimulus = vector(8)
let sar12_stimulus[0] = 0
let sar12_stimulus[1] = sar12_previous[length(sar12_previous)-1]
let sar12_stimulus[2] = 0.000142001
let sar12_stimulus[3] = sar12_stimulus[1]
let sar12_stimulus[4] = 0.000142003
let sar12_stimulus[5] = sar12_drive
let sar12_stimulus[6] = 0.000148
let sar12_stimulus[7] = sar12_stimulus[5]
alter @VD_B3[pwl] = sar12_stimulus
let sar12_drive = (floor(sar12_trial / 16) - 2*floor(sar12_trial / 32))*1.8
let sar12_previous = @VD_B4[pwl]
let sar12_stimulus = vector(8)
let sar12_stimulus[0] = 0
let sar12_stimulus[1] = sar12_previous[length(sar12_previous)-1]
let sar12_stimulus[2] = 0.000142001
let sar12_stimulus[3] = sar12_stimulus[1]
let sar12_stimulus[4] = 0.000142003
let sar12_stimulus[5] = sar12_drive
let sar12_stimulus[6] = 0.000148
let sar12_stimulus[7] = sar12_stimulus[5]
alter @VD_B4[pwl] = sar12_stimulus
let sar12_drive = (floor(sar12_trial / 32) - 2*floor(sar12_trial / 64))*1.8
let sar12_previous = @VD_B5[pwl]
let sar12_stimulus = vector(8)
let sar12_stimulus[0] = 0
let sar12_stimulus[1] = sar12_previous[length(sar12_previous)-1]
let sar12_stimulus[2] = 0.000142001
let sar12_stimulus[3] = sar12_stimulus[1]
let sar12_stimulus[4] = 0.000142003
let sar12_stimulus[5] = sar12_drive
let sar12_stimulus[6] = 0.000148
let sar12_stimulus[7] = sar12_stimulus[5]
alter @VD_B5[pwl] = sar12_stimulus
let sar12_drive = (floor(sar12_trial / 64) - 2*floor(sar12_trial / 128))*1.8
let sar12_previous = @VD_B6[pwl]
let sar12_stimulus = vector(8)
let sar12_stimulus[0] = 0
let sar12_stimulus[1] = sar12_previous[length(sar12_previous)-1]
let sar12_stimulus[2] = 0.000142001
let sar12_stimulus[3] = sar12_stimulus[1]
let sar12_stimulus[4] = 0.000142003
let sar12_stimulus[5] = sar12_drive
let sar12_stimulus[6] = 0.000148
let sar12_stimulus[7] = sar12_stimulus[5]
alter @VD_B6[pwl] = sar12_stimulus
let sar12_drive = (floor(sar12_trial / 128) - 2*floor(sar12_trial / 256))*1.8
let sar12_previous = @VD_B7[pwl]
let sar12_stimulus = vector(8)
let sar12_stimulus[0] = 0
let sar12_stimulus[1] = sar12_previous[length(sar12_previous)-1]
let sar12_stimulus[2] = 0.000142001
let sar12_stimulus[3] = sar12_stimulus[1]
let sar12_stimulus[4] = 0.000142003
let sar12_stimulus[5] = sar12_drive
let sar12_stimulus[6] = 0.000148
let sar12_stimulus[7] = sar12_stimulus[5]
alter @VD_B7[pwl] = sar12_stimulus
let sar12_drive = (floor(sar12_trial / 256) - 2*floor(sar12_trial / 512))*1.8
let sar12_previous = @VD_B8[pwl]
let sar12_stimulus = vector(8)
let sar12_stimulus[0] = 0
let sar12_stimulus[1] = sar12_previous[length(sar12_previous)-1]
let sar12_stimulus[2] = 0.000142001
let sar12_stimulus[3] = sar12_stimulus[1]
let sar12_stimulus[4] = 0.000142003
let sar12_stimulus[5] = sar12_drive
let sar12_stimulus[6] = 0.000148
let sar12_stimulus[7] = sar12_stimulus[5]
alter @VD_B8[pwl] = sar12_stimulus
let sar12_drive = (floor(sar12_trial / 512) - 2*floor(sar12_trial / 1024))*1.8
let sar12_previous = @VD_B9[pwl]
let sar12_stimulus = vector(8)
let sar12_stimulus[0] = 0
let sar12_stimulus[1] = sar12_previous[length(sar12_previous)-1]
let sar12_stimulus[2] = 0.000142001
let sar12_stimulus[3] = sar12_stimulus[1]
let sar12_stimulus[4] = 0.000142003
let sar12_stimulus[5] = sar12_drive
let sar12_stimulus[6] = 0.000148
let sar12_stimulus[7] = sar12_stimulus[5]
alter @VD_B9[pwl] = sar12_stimulus
let sar12_drive = (floor(sar12_trial / 1024) - 2*floor(sar12_trial / 2048))*1.8
let sar12_previous = @VD_B10[pwl]
let sar12_stimulus = vector(8)
let sar12_stimulus[0] = 0
let sar12_stimulus[1] = sar12_previous[length(sar12_previous)-1]
let sar12_stimulus[2] = 0.000142001
let sar12_stimulus[3] = sar12_stimulus[1]
let sar12_stimulus[4] = 0.000142003
let sar12_stimulus[5] = sar12_drive
let sar12_stimulus[6] = 0.000148
let sar12_stimulus[7] = sar12_stimulus[5]
alter @VD_B10[pwl] = sar12_stimulus
let sar12_drive = (floor(sar12_trial / 2048) - 2*floor(sar12_trial / 4096))*1.8
let sar12_previous = @VD_B11[pwl]
let sar12_stimulus = vector(8)
let sar12_stimulus[0] = 0
let sar12_stimulus[1] = sar12_previous[length(sar12_previous)-1]
let sar12_stimulus[2] = 0.000142001
let sar12_stimulus[3] = sar12_stimulus[1]
let sar12_stimulus[4] = 0.000142003
let sar12_stimulus[5] = sar12_drive
let sar12_stimulus[6] = 0.000148
let sar12_stimulus[7] = sar12_stimulus[5]
alter @VD_B11[pwl] = sar12_stimulus
let sar12_drive = (floor(sar12_trial / 4096) - 2*floor(sar12_trial / 8192))*1.8
let sar12_previous = @VD_B12[pwl]
let sar12_stimulus = vector(8)
let sar12_stimulus[0] = 0
let sar12_stimulus[1] = sar12_previous[length(sar12_previous)-1]
let sar12_stimulus[2] = 0.000142001
let sar12_stimulus[3] = sar12_stimulus[1]
let sar12_stimulus[4] = 0.000142003
let sar12_stimulus[5] = sar12_drive
let sar12_stimulus[6] = 0.000148
let sar12_stimulus[7] = sar12_stimulus[5]
alter @VD_B12[pwl] = sar12_stimulus
let sar12_drive = (floor(sar12_trial / 8192) - 2*floor(sar12_trial / 16384))*1.8
let sar12_previous = @VD_B13[pwl]
let sar12_stimulus = vector(8)
let sar12_stimulus[0] = 0
let sar12_stimulus[1] = sar12_previous[length(sar12_previous)-1]
let sar12_stimulus[2] = 0.000142001
let sar12_stimulus[3] = sar12_stimulus[1]
let sar12_stimulus[4] = 0.000142003
let sar12_stimulus[5] = sar12_drive
let sar12_stimulus[6] = 0.000148
let sar12_stimulus[7] = sar12_stimulus[5]
alter @VD_B13[pwl] = sar12_stimulus
let sar12_drive = (floor(sar12_trial / 16384) - 2*floor(sar12_trial / 32768))*1.8
let sar12_previous = @VD_B14[pwl]
let sar12_stimulus = vector(8)
let sar12_stimulus[0] = 0
let sar12_stimulus[1] = sar12_previous[length(sar12_previous)-1]
let sar12_stimulus[2] = 0.000142001
let sar12_stimulus[3] = sar12_stimulus[1]
let sar12_stimulus[4] = 0.000142003
let sar12_stimulus[5] = sar12_drive
let sar12_stimulus[6] = 0.000148
let sar12_stimulus[7] = sar12_stimulus[5]
alter @VD_B14[pwl] = sar12_stimulus
let sar12_drive = (floor(sar12_trial / 32768) - 2*floor(sar12_trial / 65536))*1.8
let sar12_previous = @VD_B15[pwl]
let sar12_stimulus = vector(8)
let sar12_stimulus[0] = 0
let sar12_stimulus[1] = sar12_previous[length(sar12_previous)-1]
let sar12_stimulus[2] = 0.000142001
let sar12_stimulus[3] = sar12_stimulus[1]
let sar12_stimulus[4] = 0.000142003
let sar12_stimulus[5] = sar12_drive
let sar12_stimulus[6] = 0.000148
let sar12_stimulus[7] = sar12_stimulus[5]
alter @VD_B15[pwl] = sar12_stimulus
resume
let sar12_k = length(time)-1
if abs(time[sar12_k] - 0.0001425) > 1e-12
print time[sar12_k]
echo expected_pause_time_s 0.0001425
echo SAR12_PAUSE_FAILED
quit 1
end
print time[sar12_k] >> pause-times.txt
let sar12_previous = @VD_EVAL[pwl]
let sar12_stimulus = vector(8)
let sar12_stimulus[0] = 0
let sar12_stimulus[1] = sar12_previous[length(sar12_previous)-1]
let sar12_stimulus[2] = 0.000142501
let sar12_stimulus[3] = sar12_stimulus[1]
let sar12_stimulus[4] = 0.000142503
let sar12_stimulus[5] = 1.8
let sar12_stimulus[6] = 0.000148
let sar12_stimulus[7] = sar12_stimulus[5]
alter @VD_EVAL[pwl] = sar12_stimulus
resume
let sar12_k = length(time)-1
if abs(time[sar12_k] - 0.000143) > 1e-12
print time[sar12_k]
echo expected_pause_time_s 0.000143
echo SAR12_PAUSE_FAILED
quit 1
end
print time[sar12_k] >> pause-times.txt
let sar12_k = length(time)-1
let sar12_cmp = v(COMP)[sar12_k]
let sar12_cmpn = v(COMPN)[sar12_k]
let sar12_p = v(TOPP)[sar12_k]
let sar12_n = v(TOPN)[sar12_k]
let sar12_decision = 0
if sar12_cmp >= 0.9
let sar12_code = sar12_trial
let sar12_decision = 1
end
echo 5 4 $&sar12_trial $&sar12_cmp $&sar12_cmpn $&sar12_p $&sar12_n 1.19998168945312 $&sar12_decision >> decisions.csv
let sar12_previous = @VD_EVAL[pwl]
let sar12_stimulus = vector(8)
let sar12_stimulus[0] = 0
let sar12_stimulus[1] = sar12_previous[length(sar12_previous)-1]
let sar12_stimulus[2] = 0.000143001
let sar12_stimulus[3] = sar12_stimulus[1]
let sar12_stimulus[4] = 0.000143003
let sar12_stimulus[5] = 0
let sar12_stimulus[6] = 0.000148
let sar12_stimulus[7] = sar12_stimulus[5]
alter @VD_EVAL[pwl] = sar12_stimulus
let sar12_trial = sar12_code + 8
let sar12_drive = (floor(sar12_trial / 1) - 2*floor(sar12_trial / 2))*1.8
let sar12_previous = @VD_B0[pwl]
let sar12_stimulus = vector(8)
let sar12_stimulus[0] = 0
let sar12_stimulus[1] = sar12_previous[length(sar12_previous)-1]
let sar12_stimulus[2] = 0.000143001
let sar12_stimulus[3] = sar12_stimulus[1]
let sar12_stimulus[4] = 0.000143003
let sar12_stimulus[5] = sar12_drive
let sar12_stimulus[6] = 0.000148
let sar12_stimulus[7] = sar12_stimulus[5]
alter @VD_B0[pwl] = sar12_stimulus
let sar12_drive = (floor(sar12_trial / 2) - 2*floor(sar12_trial / 4))*1.8
let sar12_previous = @VD_B1[pwl]
let sar12_stimulus = vector(8)
let sar12_stimulus[0] = 0
let sar12_stimulus[1] = sar12_previous[length(sar12_previous)-1]
let sar12_stimulus[2] = 0.000143001
let sar12_stimulus[3] = sar12_stimulus[1]
let sar12_stimulus[4] = 0.000143003
let sar12_stimulus[5] = sar12_drive
let sar12_stimulus[6] = 0.000148
let sar12_stimulus[7] = sar12_stimulus[5]
alter @VD_B1[pwl] = sar12_stimulus
let sar12_drive = (floor(sar12_trial / 4) - 2*floor(sar12_trial / 8))*1.8
let sar12_previous = @VD_B2[pwl]
let sar12_stimulus = vector(8)
let sar12_stimulus[0] = 0
let sar12_stimulus[1] = sar12_previous[length(sar12_previous)-1]
let sar12_stimulus[2] = 0.000143001
let sar12_stimulus[3] = sar12_stimulus[1]
let sar12_stimulus[4] = 0.000143003
let sar12_stimulus[5] = sar12_drive
let sar12_stimulus[6] = 0.000148
let sar12_stimulus[7] = sar12_stimulus[5]
alter @VD_B2[pwl] = sar12_stimulus
let sar12_drive = (floor(sar12_trial / 8) - 2*floor(sar12_trial / 16))*1.8
let sar12_previous = @VD_B3[pwl]
let sar12_stimulus = vector(8)
let sar12_stimulus[0] = 0
let sar12_stimulus[1] = sar12_previous[length(sar12_previous)-1]
let sar12_stimulus[2] = 0.000143001
let sar12_stimulus[3] = sar12_stimulus[1]
let sar12_stimulus[4] = 0.000143003
let sar12_stimulus[5] = sar12_drive
let sar12_stimulus[6] = 0.000148
let sar12_stimulus[7] = sar12_stimulus[5]
alter @VD_B3[pwl] = sar12_stimulus
let sar12_drive = (floor(sar12_trial / 16) - 2*floor(sar12_trial / 32))*1.8
let sar12_previous = @VD_B4[pwl]
let sar12_stimulus = vector(8)
let sar12_stimulus[0] = 0
let sar12_stimulus[1] = sar12_previous[length(sar12_previous)-1]
let sar12_stimulus[2] = 0.000143001
let sar12_stimulus[3] = sar12_stimulus[1]
let sar12_stimulus[4] = 0.000143003
let sar12_stimulus[5] = sar12_drive
let sar12_stimulus[6] = 0.000148
let sar12_stimulus[7] = sar12_stimulus[5]
alter @VD_B4[pwl] = sar12_stimulus
let sar12_drive = (floor(sar12_trial / 32) - 2*floor(sar12_trial / 64))*1.8
let sar12_previous = @VD_B5[pwl]
let sar12_stimulus = vector(8)
let sar12_stimulus[0] = 0
let sar12_stimulus[1] = sar12_previous[length(sar12_previous)-1]
let sar12_stimulus[2] = 0.000143001
let sar12_stimulus[3] = sar12_stimulus[1]
let sar12_stimulus[4] = 0.000143003
let sar12_stimulus[5] = sar12_drive
let sar12_stimulus[6] = 0.000148
let sar12_stimulus[7] = sar12_stimulus[5]
alter @VD_B5[pwl] = sar12_stimulus
let sar12_drive = (floor(sar12_trial / 64) - 2*floor(sar12_trial / 128))*1.8
let sar12_previous = @VD_B6[pwl]
let sar12_stimulus = vector(8)
let sar12_stimulus[0] = 0
let sar12_stimulus[1] = sar12_previous[length(sar12_previous)-1]
let sar12_stimulus[2] = 0.000143001
let sar12_stimulus[3] = sar12_stimulus[1]
let sar12_stimulus[4] = 0.000143003
let sar12_stimulus[5] = sar12_drive
let sar12_stimulus[6] = 0.000148
let sar12_stimulus[7] = sar12_stimulus[5]
alter @VD_B6[pwl] = sar12_stimulus
let sar12_drive = (floor(sar12_trial / 128) - 2*floor(sar12_trial / 256))*1.8
let sar12_previous = @VD_B7[pwl]
let sar12_stimulus = vector(8)
let sar12_stimulus[0] = 0
let sar12_stimulus[1] = sar12_previous[length(sar12_previous)-1]
let sar12_stimulus[2] = 0.000143001
let sar12_stimulus[3] = sar12_stimulus[1]
let sar12_stimulus[4] = 0.000143003
let sar12_stimulus[5] = sar12_drive
let sar12_stimulus[6] = 0.000148
let sar12_stimulus[7] = sar12_stimulus[5]
alter @VD_B7[pwl] = sar12_stimulus
let sar12_drive = (floor(sar12_trial / 256) - 2*floor(sar12_trial / 512))*1.8
let sar12_previous = @VD_B8[pwl]
let sar12_stimulus = vector(8)
let sar12_stimulus[0] = 0
let sar12_stimulus[1] = sar12_previous[length(sar12_previous)-1]
let sar12_stimulus[2] = 0.000143001
let sar12_stimulus[3] = sar12_stimulus[1]
let sar12_stimulus[4] = 0.000143003
let sar12_stimulus[5] = sar12_drive
let sar12_stimulus[6] = 0.000148
let sar12_stimulus[7] = sar12_stimulus[5]
alter @VD_B8[pwl] = sar12_stimulus
let sar12_drive = (floor(sar12_trial / 512) - 2*floor(sar12_trial / 1024))*1.8
let sar12_previous = @VD_B9[pwl]
let sar12_stimulus = vector(8)
let sar12_stimulus[0] = 0
let sar12_stimulus[1] = sar12_previous[length(sar12_previous)-1]
let sar12_stimulus[2] = 0.000143001
let sar12_stimulus[3] = sar12_stimulus[1]
let sar12_stimulus[4] = 0.000143003
let sar12_stimulus[5] = sar12_drive
let sar12_stimulus[6] = 0.000148
let sar12_stimulus[7] = sar12_stimulus[5]
alter @VD_B9[pwl] = sar12_stimulus
let sar12_drive = (floor(sar12_trial / 1024) - 2*floor(sar12_trial / 2048))*1.8
let sar12_previous = @VD_B10[pwl]
let sar12_stimulus = vector(8)
let sar12_stimulus[0] = 0
let sar12_stimulus[1] = sar12_previous[length(sar12_previous)-1]
let sar12_stimulus[2] = 0.000143001
let sar12_stimulus[3] = sar12_stimulus[1]
let sar12_stimulus[4] = 0.000143003
let sar12_stimulus[5] = sar12_drive
let sar12_stimulus[6] = 0.000148
let sar12_stimulus[7] = sar12_stimulus[5]
alter @VD_B10[pwl] = sar12_stimulus
let sar12_drive = (floor(sar12_trial / 2048) - 2*floor(sar12_trial / 4096))*1.8
let sar12_previous = @VD_B11[pwl]
let sar12_stimulus = vector(8)
let sar12_stimulus[0] = 0
let sar12_stimulus[1] = sar12_previous[length(sar12_previous)-1]
let sar12_stimulus[2] = 0.000143001
let sar12_stimulus[3] = sar12_stimulus[1]
let sar12_stimulus[4] = 0.000143003
let sar12_stimulus[5] = sar12_drive
let sar12_stimulus[6] = 0.000148
let sar12_stimulus[7] = sar12_stimulus[5]
alter @VD_B11[pwl] = sar12_stimulus
let sar12_drive = (floor(sar12_trial / 4096) - 2*floor(sar12_trial / 8192))*1.8
let sar12_previous = @VD_B12[pwl]
let sar12_stimulus = vector(8)
let sar12_stimulus[0] = 0
let sar12_stimulus[1] = sar12_previous[length(sar12_previous)-1]
let sar12_stimulus[2] = 0.000143001
let sar12_stimulus[3] = sar12_stimulus[1]
let sar12_stimulus[4] = 0.000143003
let sar12_stimulus[5] = sar12_drive
let sar12_stimulus[6] = 0.000148
let sar12_stimulus[7] = sar12_stimulus[5]
alter @VD_B12[pwl] = sar12_stimulus
let sar12_drive = (floor(sar12_trial / 8192) - 2*floor(sar12_trial / 16384))*1.8
let sar12_previous = @VD_B13[pwl]
let sar12_stimulus = vector(8)
let sar12_stimulus[0] = 0
let sar12_stimulus[1] = sar12_previous[length(sar12_previous)-1]
let sar12_stimulus[2] = 0.000143001
let sar12_stimulus[3] = sar12_stimulus[1]
let sar12_stimulus[4] = 0.000143003
let sar12_stimulus[5] = sar12_drive
let sar12_stimulus[6] = 0.000148
let sar12_stimulus[7] = sar12_stimulus[5]
alter @VD_B13[pwl] = sar12_stimulus
let sar12_drive = (floor(sar12_trial / 16384) - 2*floor(sar12_trial / 32768))*1.8
let sar12_previous = @VD_B14[pwl]
let sar12_stimulus = vector(8)
let sar12_stimulus[0] = 0
let sar12_stimulus[1] = sar12_previous[length(sar12_previous)-1]
let sar12_stimulus[2] = 0.000143001
let sar12_stimulus[3] = sar12_stimulus[1]
let sar12_stimulus[4] = 0.000143003
let sar12_stimulus[5] = sar12_drive
let sar12_stimulus[6] = 0.000148
let sar12_stimulus[7] = sar12_stimulus[5]
alter @VD_B14[pwl] = sar12_stimulus
let sar12_drive = (floor(sar12_trial / 32768) - 2*floor(sar12_trial / 65536))*1.8
let sar12_previous = @VD_B15[pwl]
let sar12_stimulus = vector(8)
let sar12_stimulus[0] = 0
let sar12_stimulus[1] = sar12_previous[length(sar12_previous)-1]
let sar12_stimulus[2] = 0.000143001
let sar12_stimulus[3] = sar12_stimulus[1]
let sar12_stimulus[4] = 0.000143003
let sar12_stimulus[5] = sar12_drive
let sar12_stimulus[6] = 0.000148
let sar12_stimulus[7] = sar12_stimulus[5]
alter @VD_B15[pwl] = sar12_stimulus
resume
let sar12_k = length(time)-1
if abs(time[sar12_k] - 0.0001435) > 1e-12
print time[sar12_k]
echo expected_pause_time_s 0.0001435
echo SAR12_PAUSE_FAILED
quit 1
end
print time[sar12_k] >> pause-times.txt
let sar12_previous = @VD_EVAL[pwl]
let sar12_stimulus = vector(8)
let sar12_stimulus[0] = 0
let sar12_stimulus[1] = sar12_previous[length(sar12_previous)-1]
let sar12_stimulus[2] = 0.000143501
let sar12_stimulus[3] = sar12_stimulus[1]
let sar12_stimulus[4] = 0.000143503
let sar12_stimulus[5] = 1.8
let sar12_stimulus[6] = 0.000148
let sar12_stimulus[7] = sar12_stimulus[5]
alter @VD_EVAL[pwl] = sar12_stimulus
resume
let sar12_k = length(time)-1
if abs(time[sar12_k] - 0.000144) > 1e-12
print time[sar12_k]
echo expected_pause_time_s 0.000144
echo SAR12_PAUSE_FAILED
quit 1
end
print time[sar12_k] >> pause-times.txt
let sar12_k = length(time)-1
let sar12_cmp = v(COMP)[sar12_k]
let sar12_cmpn = v(COMPN)[sar12_k]
let sar12_p = v(TOPP)[sar12_k]
let sar12_n = v(TOPN)[sar12_k]
let sar12_decision = 0
if sar12_cmp >= 0.9
let sar12_code = sar12_trial
let sar12_decision = 1
end
echo 5 3 $&sar12_trial $&sar12_cmp $&sar12_cmpn $&sar12_p $&sar12_n 1.19998168945312 $&sar12_decision >> decisions.csv
let sar12_previous = @VD_EVAL[pwl]
let sar12_stimulus = vector(8)
let sar12_stimulus[0] = 0
let sar12_stimulus[1] = sar12_previous[length(sar12_previous)-1]
let sar12_stimulus[2] = 0.000144001
let sar12_stimulus[3] = sar12_stimulus[1]
let sar12_stimulus[4] = 0.000144003
let sar12_stimulus[5] = 0
let sar12_stimulus[6] = 0.000148
let sar12_stimulus[7] = sar12_stimulus[5]
alter @VD_EVAL[pwl] = sar12_stimulus
let sar12_trial = sar12_code + 4
let sar12_drive = (floor(sar12_trial / 1) - 2*floor(sar12_trial / 2))*1.8
let sar12_previous = @VD_B0[pwl]
let sar12_stimulus = vector(8)
let sar12_stimulus[0] = 0
let sar12_stimulus[1] = sar12_previous[length(sar12_previous)-1]
let sar12_stimulus[2] = 0.000144001
let sar12_stimulus[3] = sar12_stimulus[1]
let sar12_stimulus[4] = 0.000144003
let sar12_stimulus[5] = sar12_drive
let sar12_stimulus[6] = 0.000148
let sar12_stimulus[7] = sar12_stimulus[5]
alter @VD_B0[pwl] = sar12_stimulus
let sar12_drive = (floor(sar12_trial / 2) - 2*floor(sar12_trial / 4))*1.8
let sar12_previous = @VD_B1[pwl]
let sar12_stimulus = vector(8)
let sar12_stimulus[0] = 0
let sar12_stimulus[1] = sar12_previous[length(sar12_previous)-1]
let sar12_stimulus[2] = 0.000144001
let sar12_stimulus[3] = sar12_stimulus[1]
let sar12_stimulus[4] = 0.000144003
let sar12_stimulus[5] = sar12_drive
let sar12_stimulus[6] = 0.000148
let sar12_stimulus[7] = sar12_stimulus[5]
alter @VD_B1[pwl] = sar12_stimulus
let sar12_drive = (floor(sar12_trial / 4) - 2*floor(sar12_trial / 8))*1.8
let sar12_previous = @VD_B2[pwl]
let sar12_stimulus = vector(8)
let sar12_stimulus[0] = 0
let sar12_stimulus[1] = sar12_previous[length(sar12_previous)-1]
let sar12_stimulus[2] = 0.000144001
let sar12_stimulus[3] = sar12_stimulus[1]
let sar12_stimulus[4] = 0.000144003
let sar12_stimulus[5] = sar12_drive
let sar12_stimulus[6] = 0.000148
let sar12_stimulus[7] = sar12_stimulus[5]
alter @VD_B2[pwl] = sar12_stimulus
let sar12_drive = (floor(sar12_trial / 8) - 2*floor(sar12_trial / 16))*1.8
let sar12_previous = @VD_B3[pwl]
let sar12_stimulus = vector(8)
let sar12_stimulus[0] = 0
let sar12_stimulus[1] = sar12_previous[length(sar12_previous)-1]
let sar12_stimulus[2] = 0.000144001
let sar12_stimulus[3] = sar12_stimulus[1]
let sar12_stimulus[4] = 0.000144003
let sar12_stimulus[5] = sar12_drive
let sar12_stimulus[6] = 0.000148
let sar12_stimulus[7] = sar12_stimulus[5]
alter @VD_B3[pwl] = sar12_stimulus
let sar12_drive = (floor(sar12_trial / 16) - 2*floor(sar12_trial / 32))*1.8
let sar12_previous = @VD_B4[pwl]
let sar12_stimulus = vector(8)
let sar12_stimulus[0] = 0
let sar12_stimulus[1] = sar12_previous[length(sar12_previous)-1]
let sar12_stimulus[2] = 0.000144001
let sar12_stimulus[3] = sar12_stimulus[1]
let sar12_stimulus[4] = 0.000144003
let sar12_stimulus[5] = sar12_drive
let sar12_stimulus[6] = 0.000148
let sar12_stimulus[7] = sar12_stimulus[5]
alter @VD_B4[pwl] = sar12_stimulus
let sar12_drive = (floor(sar12_trial / 32) - 2*floor(sar12_trial / 64))*1.8
let sar12_previous = @VD_B5[pwl]
let sar12_stimulus = vector(8)
let sar12_stimulus[0] = 0
let sar12_stimulus[1] = sar12_previous[length(sar12_previous)-1]
let sar12_stimulus[2] = 0.000144001
let sar12_stimulus[3] = sar12_stimulus[1]
let sar12_stimulus[4] = 0.000144003
let sar12_stimulus[5] = sar12_drive
let sar12_stimulus[6] = 0.000148
let sar12_stimulus[7] = sar12_stimulus[5]
alter @VD_B5[pwl] = sar12_stimulus
let sar12_drive = (floor(sar12_trial / 64) - 2*floor(sar12_trial / 128))*1.8
let sar12_previous = @VD_B6[pwl]
let sar12_stimulus = vector(8)
let sar12_stimulus[0] = 0
let sar12_stimulus[1] = sar12_previous[length(sar12_previous)-1]
let sar12_stimulus[2] = 0.000144001
let sar12_stimulus[3] = sar12_stimulus[1]
let sar12_stimulus[4] = 0.000144003
let sar12_stimulus[5] = sar12_drive
let sar12_stimulus[6] = 0.000148
let sar12_stimulus[7] = sar12_stimulus[5]
alter @VD_B6[pwl] = sar12_stimulus
let sar12_drive = (floor(sar12_trial / 128) - 2*floor(sar12_trial / 256))*1.8
let sar12_previous = @VD_B7[pwl]
let sar12_stimulus = vector(8)
let sar12_stimulus[0] = 0
let sar12_stimulus[1] = sar12_previous[length(sar12_previous)-1]
let sar12_stimulus[2] = 0.000144001
let sar12_stimulus[3] = sar12_stimulus[1]
let sar12_stimulus[4] = 0.000144003
let sar12_stimulus[5] = sar12_drive
let sar12_stimulus[6] = 0.000148
let sar12_stimulus[7] = sar12_stimulus[5]
alter @VD_B7[pwl] = sar12_stimulus
let sar12_drive = (floor(sar12_trial / 256) - 2*floor(sar12_trial / 512))*1.8
let sar12_previous = @VD_B8[pwl]
let sar12_stimulus = vector(8)
let sar12_stimulus[0] = 0
let sar12_stimulus[1] = sar12_previous[length(sar12_previous)-1]
let sar12_stimulus[2] = 0.000144001
let sar12_stimulus[3] = sar12_stimulus[1]
let sar12_stimulus[4] = 0.000144003
let sar12_stimulus[5] = sar12_drive
let sar12_stimulus[6] = 0.000148
let sar12_stimulus[7] = sar12_stimulus[5]
alter @VD_B8[pwl] = sar12_stimulus
let sar12_drive = (floor(sar12_trial / 512) - 2*floor(sar12_trial / 1024))*1.8
let sar12_previous = @VD_B9[pwl]
let sar12_stimulus = vector(8)
let sar12_stimulus[0] = 0
let sar12_stimulus[1] = sar12_previous[length(sar12_previous)-1]
let sar12_stimulus[2] = 0.000144001
let sar12_stimulus[3] = sar12_stimulus[1]
let sar12_stimulus[4] = 0.000144003
let sar12_stimulus[5] = sar12_drive
let sar12_stimulus[6] = 0.000148
let sar12_stimulus[7] = sar12_stimulus[5]
alter @VD_B9[pwl] = sar12_stimulus
let sar12_drive = (floor(sar12_trial / 1024) - 2*floor(sar12_trial / 2048))*1.8
let sar12_previous = @VD_B10[pwl]
let sar12_stimulus = vector(8)
let sar12_stimulus[0] = 0
let sar12_stimulus[1] = sar12_previous[length(sar12_previous)-1]
let sar12_stimulus[2] = 0.000144001
let sar12_stimulus[3] = sar12_stimulus[1]
let sar12_stimulus[4] = 0.000144003
let sar12_stimulus[5] = sar12_drive
let sar12_stimulus[6] = 0.000148
let sar12_stimulus[7] = sar12_stimulus[5]
alter @VD_B10[pwl] = sar12_stimulus
let sar12_drive = (floor(sar12_trial / 2048) - 2*floor(sar12_trial / 4096))*1.8
let sar12_previous = @VD_B11[pwl]
let sar12_stimulus = vector(8)
let sar12_stimulus[0] = 0
let sar12_stimulus[1] = sar12_previous[length(sar12_previous)-1]
let sar12_stimulus[2] = 0.000144001
let sar12_stimulus[3] = sar12_stimulus[1]
let sar12_stimulus[4] = 0.000144003
let sar12_stimulus[5] = sar12_drive
let sar12_stimulus[6] = 0.000148
let sar12_stimulus[7] = sar12_stimulus[5]
alter @VD_B11[pwl] = sar12_stimulus
let sar12_drive = (floor(sar12_trial / 4096) - 2*floor(sar12_trial / 8192))*1.8
let sar12_previous = @VD_B12[pwl]
let sar12_stimulus = vector(8)
let sar12_stimulus[0] = 0
let sar12_stimulus[1] = sar12_previous[length(sar12_previous)-1]
let sar12_stimulus[2] = 0.000144001
let sar12_stimulus[3] = sar12_stimulus[1]
let sar12_stimulus[4] = 0.000144003
let sar12_stimulus[5] = sar12_drive
let sar12_stimulus[6] = 0.000148
let sar12_stimulus[7] = sar12_stimulus[5]
alter @VD_B12[pwl] = sar12_stimulus
let sar12_drive = (floor(sar12_trial / 8192) - 2*floor(sar12_trial / 16384))*1.8
let sar12_previous = @VD_B13[pwl]
let sar12_stimulus = vector(8)
let sar12_stimulus[0] = 0
let sar12_stimulus[1] = sar12_previous[length(sar12_previous)-1]
let sar12_stimulus[2] = 0.000144001
let sar12_stimulus[3] = sar12_stimulus[1]
let sar12_stimulus[4] = 0.000144003
let sar12_stimulus[5] = sar12_drive
let sar12_stimulus[6] = 0.000148
let sar12_stimulus[7] = sar12_stimulus[5]
alter @VD_B13[pwl] = sar12_stimulus
let sar12_drive = (floor(sar12_trial / 16384) - 2*floor(sar12_trial / 32768))*1.8
let sar12_previous = @VD_B14[pwl]
let sar12_stimulus = vector(8)
let sar12_stimulus[0] = 0
let sar12_stimulus[1] = sar12_previous[length(sar12_previous)-1]
let sar12_stimulus[2] = 0.000144001
let sar12_stimulus[3] = sar12_stimulus[1]
let sar12_stimulus[4] = 0.000144003
let sar12_stimulus[5] = sar12_drive
let sar12_stimulus[6] = 0.000148
let sar12_stimulus[7] = sar12_stimulus[5]
alter @VD_B14[pwl] = sar12_stimulus
let sar12_drive = (floor(sar12_trial / 32768) - 2*floor(sar12_trial / 65536))*1.8
let sar12_previous = @VD_B15[pwl]
let sar12_stimulus = vector(8)
let sar12_stimulus[0] = 0
let sar12_stimulus[1] = sar12_previous[length(sar12_previous)-1]
let sar12_stimulus[2] = 0.000144001
let sar12_stimulus[3] = sar12_stimulus[1]
let sar12_stimulus[4] = 0.000144003
let sar12_stimulus[5] = sar12_drive
let sar12_stimulus[6] = 0.000148
let sar12_stimulus[7] = sar12_stimulus[5]
alter @VD_B15[pwl] = sar12_stimulus
resume
let sar12_k = length(time)-1
if abs(time[sar12_k] - 0.0001445) > 1e-12
print time[sar12_k]
echo expected_pause_time_s 0.0001445
echo SAR12_PAUSE_FAILED
quit 1
end
print time[sar12_k] >> pause-times.txt
let sar12_previous = @VD_EVAL[pwl]
let sar12_stimulus = vector(8)
let sar12_stimulus[0] = 0
let sar12_stimulus[1] = sar12_previous[length(sar12_previous)-1]
let sar12_stimulus[2] = 0.000144501
let sar12_stimulus[3] = sar12_stimulus[1]
let sar12_stimulus[4] = 0.000144503
let sar12_stimulus[5] = 1.8
let sar12_stimulus[6] = 0.000148
let sar12_stimulus[7] = sar12_stimulus[5]
alter @VD_EVAL[pwl] = sar12_stimulus
resume
let sar12_k = length(time)-1
if abs(time[sar12_k] - 0.000145) > 1e-12
print time[sar12_k]
echo expected_pause_time_s 0.000145
echo SAR12_PAUSE_FAILED
quit 1
end
print time[sar12_k] >> pause-times.txt
let sar12_k = length(time)-1
let sar12_cmp = v(COMP)[sar12_k]
let sar12_cmpn = v(COMPN)[sar12_k]
let sar12_p = v(TOPP)[sar12_k]
let sar12_n = v(TOPN)[sar12_k]
let sar12_decision = 0
if sar12_cmp >= 0.9
let sar12_code = sar12_trial
let sar12_decision = 1
end
echo 5 2 $&sar12_trial $&sar12_cmp $&sar12_cmpn $&sar12_p $&sar12_n 1.19998168945312 $&sar12_decision >> decisions.csv
let sar12_previous = @VD_EVAL[pwl]
let sar12_stimulus = vector(8)
let sar12_stimulus[0] = 0
let sar12_stimulus[1] = sar12_previous[length(sar12_previous)-1]
let sar12_stimulus[2] = 0.000145001
let sar12_stimulus[3] = sar12_stimulus[1]
let sar12_stimulus[4] = 0.000145003
let sar12_stimulus[5] = 0
let sar12_stimulus[6] = 0.000148
let sar12_stimulus[7] = sar12_stimulus[5]
alter @VD_EVAL[pwl] = sar12_stimulus
let sar12_trial = sar12_code + 2
let sar12_drive = (floor(sar12_trial / 1) - 2*floor(sar12_trial / 2))*1.8
let sar12_previous = @VD_B0[pwl]
let sar12_stimulus = vector(8)
let sar12_stimulus[0] = 0
let sar12_stimulus[1] = sar12_previous[length(sar12_previous)-1]
let sar12_stimulus[2] = 0.000145001
let sar12_stimulus[3] = sar12_stimulus[1]
let sar12_stimulus[4] = 0.000145003
let sar12_stimulus[5] = sar12_drive
let sar12_stimulus[6] = 0.000148
let sar12_stimulus[7] = sar12_stimulus[5]
alter @VD_B0[pwl] = sar12_stimulus
let sar12_drive = (floor(sar12_trial / 2) - 2*floor(sar12_trial / 4))*1.8
let sar12_previous = @VD_B1[pwl]
let sar12_stimulus = vector(8)
let sar12_stimulus[0] = 0
let sar12_stimulus[1] = sar12_previous[length(sar12_previous)-1]
let sar12_stimulus[2] = 0.000145001
let sar12_stimulus[3] = sar12_stimulus[1]
let sar12_stimulus[4] = 0.000145003
let sar12_stimulus[5] = sar12_drive
let sar12_stimulus[6] = 0.000148
let sar12_stimulus[7] = sar12_stimulus[5]
alter @VD_B1[pwl] = sar12_stimulus
let sar12_drive = (floor(sar12_trial / 4) - 2*floor(sar12_trial / 8))*1.8
let sar12_previous = @VD_B2[pwl]
let sar12_stimulus = vector(8)
let sar12_stimulus[0] = 0
let sar12_stimulus[1] = sar12_previous[length(sar12_previous)-1]
let sar12_stimulus[2] = 0.000145001
let sar12_stimulus[3] = sar12_stimulus[1]
let sar12_stimulus[4] = 0.000145003
let sar12_stimulus[5] = sar12_drive
let sar12_stimulus[6] = 0.000148
let sar12_stimulus[7] = sar12_stimulus[5]
alter @VD_B2[pwl] = sar12_stimulus
let sar12_drive = (floor(sar12_trial / 8) - 2*floor(sar12_trial / 16))*1.8
let sar12_previous = @VD_B3[pwl]
let sar12_stimulus = vector(8)
let sar12_stimulus[0] = 0
let sar12_stimulus[1] = sar12_previous[length(sar12_previous)-1]
let sar12_stimulus[2] = 0.000145001
let sar12_stimulus[3] = sar12_stimulus[1]
let sar12_stimulus[4] = 0.000145003
let sar12_stimulus[5] = sar12_drive
let sar12_stimulus[6] = 0.000148
let sar12_stimulus[7] = sar12_stimulus[5]
alter @VD_B3[pwl] = sar12_stimulus
let sar12_drive = (floor(sar12_trial / 16) - 2*floor(sar12_trial / 32))*1.8
let sar12_previous = @VD_B4[pwl]
let sar12_stimulus = vector(8)
let sar12_stimulus[0] = 0
let sar12_stimulus[1] = sar12_previous[length(sar12_previous)-1]
let sar12_stimulus[2] = 0.000145001
let sar12_stimulus[3] = sar12_stimulus[1]
let sar12_stimulus[4] = 0.000145003
let sar12_stimulus[5] = sar12_drive
let sar12_stimulus[6] = 0.000148
let sar12_stimulus[7] = sar12_stimulus[5]
alter @VD_B4[pwl] = sar12_stimulus
let sar12_drive = (floor(sar12_trial / 32) - 2*floor(sar12_trial / 64))*1.8
let sar12_previous = @VD_B5[pwl]
let sar12_stimulus = vector(8)
let sar12_stimulus[0] = 0
let sar12_stimulus[1] = sar12_previous[length(sar12_previous)-1]
let sar12_stimulus[2] = 0.000145001
let sar12_stimulus[3] = sar12_stimulus[1]
let sar12_stimulus[4] = 0.000145003
let sar12_stimulus[5] = sar12_drive
let sar12_stimulus[6] = 0.000148
let sar12_stimulus[7] = sar12_stimulus[5]
alter @VD_B5[pwl] = sar12_stimulus
let sar12_drive = (floor(sar12_trial / 64) - 2*floor(sar12_trial / 128))*1.8
let sar12_previous = @VD_B6[pwl]
let sar12_stimulus = vector(8)
let sar12_stimulus[0] = 0
let sar12_stimulus[1] = sar12_previous[length(sar12_previous)-1]
let sar12_stimulus[2] = 0.000145001
let sar12_stimulus[3] = sar12_stimulus[1]
let sar12_stimulus[4] = 0.000145003
let sar12_stimulus[5] = sar12_drive
let sar12_stimulus[6] = 0.000148
let sar12_stimulus[7] = sar12_stimulus[5]
alter @VD_B6[pwl] = sar12_stimulus
let sar12_drive = (floor(sar12_trial / 128) - 2*floor(sar12_trial / 256))*1.8
let sar12_previous = @VD_B7[pwl]
let sar12_stimulus = vector(8)
let sar12_stimulus[0] = 0
let sar12_stimulus[1] = sar12_previous[length(sar12_previous)-1]
let sar12_stimulus[2] = 0.000145001
let sar12_stimulus[3] = sar12_stimulus[1]
let sar12_stimulus[4] = 0.000145003
let sar12_stimulus[5] = sar12_drive
let sar12_stimulus[6] = 0.000148
let sar12_stimulus[7] = sar12_stimulus[5]
alter @VD_B7[pwl] = sar12_stimulus
let sar12_drive = (floor(sar12_trial / 256) - 2*floor(sar12_trial / 512))*1.8
let sar12_previous = @VD_B8[pwl]
let sar12_stimulus = vector(8)
let sar12_stimulus[0] = 0
let sar12_stimulus[1] = sar12_previous[length(sar12_previous)-1]
let sar12_stimulus[2] = 0.000145001
let sar12_stimulus[3] = sar12_stimulus[1]
let sar12_stimulus[4] = 0.000145003
let sar12_stimulus[5] = sar12_drive
let sar12_stimulus[6] = 0.000148
let sar12_stimulus[7] = sar12_stimulus[5]
alter @VD_B8[pwl] = sar12_stimulus
let sar12_drive = (floor(sar12_trial / 512) - 2*floor(sar12_trial / 1024))*1.8
let sar12_previous = @VD_B9[pwl]
let sar12_stimulus = vector(8)
let sar12_stimulus[0] = 0
let sar12_stimulus[1] = sar12_previous[length(sar12_previous)-1]
let sar12_stimulus[2] = 0.000145001
let sar12_stimulus[3] = sar12_stimulus[1]
let sar12_stimulus[4] = 0.000145003
let sar12_stimulus[5] = sar12_drive
let sar12_stimulus[6] = 0.000148
let sar12_stimulus[7] = sar12_stimulus[5]
alter @VD_B9[pwl] = sar12_stimulus
let sar12_drive = (floor(sar12_trial / 1024) - 2*floor(sar12_trial / 2048))*1.8
let sar12_previous = @VD_B10[pwl]
let sar12_stimulus = vector(8)
let sar12_stimulus[0] = 0
let sar12_stimulus[1] = sar12_previous[length(sar12_previous)-1]
let sar12_stimulus[2] = 0.000145001
let sar12_stimulus[3] = sar12_stimulus[1]
let sar12_stimulus[4] = 0.000145003
let sar12_stimulus[5] = sar12_drive
let sar12_stimulus[6] = 0.000148
let sar12_stimulus[7] = sar12_stimulus[5]
alter @VD_B10[pwl] = sar12_stimulus
let sar12_drive = (floor(sar12_trial / 2048) - 2*floor(sar12_trial / 4096))*1.8
let sar12_previous = @VD_B11[pwl]
let sar12_stimulus = vector(8)
let sar12_stimulus[0] = 0
let sar12_stimulus[1] = sar12_previous[length(sar12_previous)-1]
let sar12_stimulus[2] = 0.000145001
let sar12_stimulus[3] = sar12_stimulus[1]
let sar12_stimulus[4] = 0.000145003
let sar12_stimulus[5] = sar12_drive
let sar12_stimulus[6] = 0.000148
let sar12_stimulus[7] = sar12_stimulus[5]
alter @VD_B11[pwl] = sar12_stimulus
let sar12_drive = (floor(sar12_trial / 4096) - 2*floor(sar12_trial / 8192))*1.8
let sar12_previous = @VD_B12[pwl]
let sar12_stimulus = vector(8)
let sar12_stimulus[0] = 0
let sar12_stimulus[1] = sar12_previous[length(sar12_previous)-1]
let sar12_stimulus[2] = 0.000145001
let sar12_stimulus[3] = sar12_stimulus[1]
let sar12_stimulus[4] = 0.000145003
let sar12_stimulus[5] = sar12_drive
let sar12_stimulus[6] = 0.000148
let sar12_stimulus[7] = sar12_stimulus[5]
alter @VD_B12[pwl] = sar12_stimulus
let sar12_drive = (floor(sar12_trial / 8192) - 2*floor(sar12_trial / 16384))*1.8
let sar12_previous = @VD_B13[pwl]
let sar12_stimulus = vector(8)
let sar12_stimulus[0] = 0
let sar12_stimulus[1] = sar12_previous[length(sar12_previous)-1]
let sar12_stimulus[2] = 0.000145001
let sar12_stimulus[3] = sar12_stimulus[1]
let sar12_stimulus[4] = 0.000145003
let sar12_stimulus[5] = sar12_drive
let sar12_stimulus[6] = 0.000148
let sar12_stimulus[7] = sar12_stimulus[5]
alter @VD_B13[pwl] = sar12_stimulus
let sar12_drive = (floor(sar12_trial / 16384) - 2*floor(sar12_trial / 32768))*1.8
let sar12_previous = @VD_B14[pwl]
let sar12_stimulus = vector(8)
let sar12_stimulus[0] = 0
let sar12_stimulus[1] = sar12_previous[length(sar12_previous)-1]
let sar12_stimulus[2] = 0.000145001
let sar12_stimulus[3] = sar12_stimulus[1]
let sar12_stimulus[4] = 0.000145003
let sar12_stimulus[5] = sar12_drive
let sar12_stimulus[6] = 0.000148
let sar12_stimulus[7] = sar12_stimulus[5]
alter @VD_B14[pwl] = sar12_stimulus
let sar12_drive = (floor(sar12_trial / 32768) - 2*floor(sar12_trial / 65536))*1.8
let sar12_previous = @VD_B15[pwl]
let sar12_stimulus = vector(8)
let sar12_stimulus[0] = 0
let sar12_stimulus[1] = sar12_previous[length(sar12_previous)-1]
let sar12_stimulus[2] = 0.000145001
let sar12_stimulus[3] = sar12_stimulus[1]
let sar12_stimulus[4] = 0.000145003
let sar12_stimulus[5] = sar12_drive
let sar12_stimulus[6] = 0.000148
let sar12_stimulus[7] = sar12_stimulus[5]
alter @VD_B15[pwl] = sar12_stimulus
resume
let sar12_k = length(time)-1
if abs(time[sar12_k] - 0.0001455) > 1e-12
print time[sar12_k]
echo expected_pause_time_s 0.0001455
echo SAR12_PAUSE_FAILED
quit 1
end
print time[sar12_k] >> pause-times.txt
let sar12_previous = @VD_EVAL[pwl]
let sar12_stimulus = vector(8)
let sar12_stimulus[0] = 0
let sar12_stimulus[1] = sar12_previous[length(sar12_previous)-1]
let sar12_stimulus[2] = 0.000145501
let sar12_stimulus[3] = sar12_stimulus[1]
let sar12_stimulus[4] = 0.000145503
let sar12_stimulus[5] = 1.8
let sar12_stimulus[6] = 0.000148
let sar12_stimulus[7] = sar12_stimulus[5]
alter @VD_EVAL[pwl] = sar12_stimulus
resume
let sar12_k = length(time)-1
if abs(time[sar12_k] - 0.000146) > 1e-12
print time[sar12_k]
echo expected_pause_time_s 0.000146
echo SAR12_PAUSE_FAILED
quit 1
end
print time[sar12_k] >> pause-times.txt
let sar12_k = length(time)-1
let sar12_cmp = v(COMP)[sar12_k]
let sar12_cmpn = v(COMPN)[sar12_k]
let sar12_p = v(TOPP)[sar12_k]
let sar12_n = v(TOPN)[sar12_k]
let sar12_decision = 0
if sar12_cmp >= 0.9
let sar12_code = sar12_trial
let sar12_decision = 1
end
echo 5 1 $&sar12_trial $&sar12_cmp $&sar12_cmpn $&sar12_p $&sar12_n 1.19998168945312 $&sar12_decision >> decisions.csv
let sar12_previous = @VD_EVAL[pwl]
let sar12_stimulus = vector(8)
let sar12_stimulus[0] = 0
let sar12_stimulus[1] = sar12_previous[length(sar12_previous)-1]
let sar12_stimulus[2] = 0.000146001
let sar12_stimulus[3] = sar12_stimulus[1]
let sar12_stimulus[4] = 0.000146003
let sar12_stimulus[5] = 0
let sar12_stimulus[6] = 0.000148
let sar12_stimulus[7] = sar12_stimulus[5]
alter @VD_EVAL[pwl] = sar12_stimulus
let sar12_trial = sar12_code + 1
let sar12_drive = (floor(sar12_trial / 1) - 2*floor(sar12_trial / 2))*1.8
let sar12_previous = @VD_B0[pwl]
let sar12_stimulus = vector(8)
let sar12_stimulus[0] = 0
let sar12_stimulus[1] = sar12_previous[length(sar12_previous)-1]
let sar12_stimulus[2] = 0.000146001
let sar12_stimulus[3] = sar12_stimulus[1]
let sar12_stimulus[4] = 0.000146003
let sar12_stimulus[5] = sar12_drive
let sar12_stimulus[6] = 0.000148
let sar12_stimulus[7] = sar12_stimulus[5]
alter @VD_B0[pwl] = sar12_stimulus
let sar12_drive = (floor(sar12_trial / 2) - 2*floor(sar12_trial / 4))*1.8
let sar12_previous = @VD_B1[pwl]
let sar12_stimulus = vector(8)
let sar12_stimulus[0] = 0
let sar12_stimulus[1] = sar12_previous[length(sar12_previous)-1]
let sar12_stimulus[2] = 0.000146001
let sar12_stimulus[3] = sar12_stimulus[1]
let sar12_stimulus[4] = 0.000146003
let sar12_stimulus[5] = sar12_drive
let sar12_stimulus[6] = 0.000148
let sar12_stimulus[7] = sar12_stimulus[5]
alter @VD_B1[pwl] = sar12_stimulus
let sar12_drive = (floor(sar12_trial / 4) - 2*floor(sar12_trial / 8))*1.8
let sar12_previous = @VD_B2[pwl]
let sar12_stimulus = vector(8)
let sar12_stimulus[0] = 0
let sar12_stimulus[1] = sar12_previous[length(sar12_previous)-1]
let sar12_stimulus[2] = 0.000146001
let sar12_stimulus[3] = sar12_stimulus[1]
let sar12_stimulus[4] = 0.000146003
let sar12_stimulus[5] = sar12_drive
let sar12_stimulus[6] = 0.000148
let sar12_stimulus[7] = sar12_stimulus[5]
alter @VD_B2[pwl] = sar12_stimulus
let sar12_drive = (floor(sar12_trial / 8) - 2*floor(sar12_trial / 16))*1.8
let sar12_previous = @VD_B3[pwl]
let sar12_stimulus = vector(8)
let sar12_stimulus[0] = 0
let sar12_stimulus[1] = sar12_previous[length(sar12_previous)-1]
let sar12_stimulus[2] = 0.000146001
let sar12_stimulus[3] = sar12_stimulus[1]
let sar12_stimulus[4] = 0.000146003
let sar12_stimulus[5] = sar12_drive
let sar12_stimulus[6] = 0.000148
let sar12_stimulus[7] = sar12_stimulus[5]
alter @VD_B3[pwl] = sar12_stimulus
let sar12_drive = (floor(sar12_trial / 16) - 2*floor(sar12_trial / 32))*1.8
let sar12_previous = @VD_B4[pwl]
let sar12_stimulus = vector(8)
let sar12_stimulus[0] = 0
let sar12_stimulus[1] = sar12_previous[length(sar12_previous)-1]
let sar12_stimulus[2] = 0.000146001
let sar12_stimulus[3] = sar12_stimulus[1]
let sar12_stimulus[4] = 0.000146003
let sar12_stimulus[5] = sar12_drive
let sar12_stimulus[6] = 0.000148
let sar12_stimulus[7] = sar12_stimulus[5]
alter @VD_B4[pwl] = sar12_stimulus
let sar12_drive = (floor(sar12_trial / 32) - 2*floor(sar12_trial / 64))*1.8
let sar12_previous = @VD_B5[pwl]
let sar12_stimulus = vector(8)
let sar12_stimulus[0] = 0
let sar12_stimulus[1] = sar12_previous[length(sar12_previous)-1]
let sar12_stimulus[2] = 0.000146001
let sar12_stimulus[3] = sar12_stimulus[1]
let sar12_stimulus[4] = 0.000146003
let sar12_stimulus[5] = sar12_drive
let sar12_stimulus[6] = 0.000148
let sar12_stimulus[7] = sar12_stimulus[5]
alter @VD_B5[pwl] = sar12_stimulus
let sar12_drive = (floor(sar12_trial / 64) - 2*floor(sar12_trial / 128))*1.8
let sar12_previous = @VD_B6[pwl]
let sar12_stimulus = vector(8)
let sar12_stimulus[0] = 0
let sar12_stimulus[1] = sar12_previous[length(sar12_previous)-1]
let sar12_stimulus[2] = 0.000146001
let sar12_stimulus[3] = sar12_stimulus[1]
let sar12_stimulus[4] = 0.000146003
let sar12_stimulus[5] = sar12_drive
let sar12_stimulus[6] = 0.000148
let sar12_stimulus[7] = sar12_stimulus[5]
alter @VD_B6[pwl] = sar12_stimulus
let sar12_drive = (floor(sar12_trial / 128) - 2*floor(sar12_trial / 256))*1.8
let sar12_previous = @VD_B7[pwl]
let sar12_stimulus = vector(8)
let sar12_stimulus[0] = 0
let sar12_stimulus[1] = sar12_previous[length(sar12_previous)-1]
let sar12_stimulus[2] = 0.000146001
let sar12_stimulus[3] = sar12_stimulus[1]
let sar12_stimulus[4] = 0.000146003
let sar12_stimulus[5] = sar12_drive
let sar12_stimulus[6] = 0.000148
let sar12_stimulus[7] = sar12_stimulus[5]
alter @VD_B7[pwl] = sar12_stimulus
let sar12_drive = (floor(sar12_trial / 256) - 2*floor(sar12_trial / 512))*1.8
let sar12_previous = @VD_B8[pwl]
let sar12_stimulus = vector(8)
let sar12_stimulus[0] = 0
let sar12_stimulus[1] = sar12_previous[length(sar12_previous)-1]
let sar12_stimulus[2] = 0.000146001
let sar12_stimulus[3] = sar12_stimulus[1]
let sar12_stimulus[4] = 0.000146003
let sar12_stimulus[5] = sar12_drive
let sar12_stimulus[6] = 0.000148
let sar12_stimulus[7] = sar12_stimulus[5]
alter @VD_B8[pwl] = sar12_stimulus
let sar12_drive = (floor(sar12_trial / 512) - 2*floor(sar12_trial / 1024))*1.8
let sar12_previous = @VD_B9[pwl]
let sar12_stimulus = vector(8)
let sar12_stimulus[0] = 0
let sar12_stimulus[1] = sar12_previous[length(sar12_previous)-1]
let sar12_stimulus[2] = 0.000146001
let sar12_stimulus[3] = sar12_stimulus[1]
let sar12_stimulus[4] = 0.000146003
let sar12_stimulus[5] = sar12_drive
let sar12_stimulus[6] = 0.000148
let sar12_stimulus[7] = sar12_stimulus[5]
alter @VD_B9[pwl] = sar12_stimulus
let sar12_drive = (floor(sar12_trial / 1024) - 2*floor(sar12_trial / 2048))*1.8
let sar12_previous = @VD_B10[pwl]
let sar12_stimulus = vector(8)
let sar12_stimulus[0] = 0
let sar12_stimulus[1] = sar12_previous[length(sar12_previous)-1]
let sar12_stimulus[2] = 0.000146001
let sar12_stimulus[3] = sar12_stimulus[1]
let sar12_stimulus[4] = 0.000146003
let sar12_stimulus[5] = sar12_drive
let sar12_stimulus[6] = 0.000148
let sar12_stimulus[7] = sar12_stimulus[5]
alter @VD_B10[pwl] = sar12_stimulus
let sar12_drive = (floor(sar12_trial / 2048) - 2*floor(sar12_trial / 4096))*1.8
let sar12_previous = @VD_B11[pwl]
let sar12_stimulus = vector(8)
let sar12_stimulus[0] = 0
let sar12_stimulus[1] = sar12_previous[length(sar12_previous)-1]
let sar12_stimulus[2] = 0.000146001
let sar12_stimulus[3] = sar12_stimulus[1]
let sar12_stimulus[4] = 0.000146003
let sar12_stimulus[5] = sar12_drive
let sar12_stimulus[6] = 0.000148
let sar12_stimulus[7] = sar12_stimulus[5]
alter @VD_B11[pwl] = sar12_stimulus
let sar12_drive = (floor(sar12_trial / 4096) - 2*floor(sar12_trial / 8192))*1.8
let sar12_previous = @VD_B12[pwl]
let sar12_stimulus = vector(8)
let sar12_stimulus[0] = 0
let sar12_stimulus[1] = sar12_previous[length(sar12_previous)-1]
let sar12_stimulus[2] = 0.000146001
let sar12_stimulus[3] = sar12_stimulus[1]
let sar12_stimulus[4] = 0.000146003
let sar12_stimulus[5] = sar12_drive
let sar12_stimulus[6] = 0.000148
let sar12_stimulus[7] = sar12_stimulus[5]
alter @VD_B12[pwl] = sar12_stimulus
let sar12_drive = (floor(sar12_trial / 8192) - 2*floor(sar12_trial / 16384))*1.8
let sar12_previous = @VD_B13[pwl]
let sar12_stimulus = vector(8)
let sar12_stimulus[0] = 0
let sar12_stimulus[1] = sar12_previous[length(sar12_previous)-1]
let sar12_stimulus[2] = 0.000146001
let sar12_stimulus[3] = sar12_stimulus[1]
let sar12_stimulus[4] = 0.000146003
let sar12_stimulus[5] = sar12_drive
let sar12_stimulus[6] = 0.000148
let sar12_stimulus[7] = sar12_stimulus[5]
alter @VD_B13[pwl] = sar12_stimulus
let sar12_drive = (floor(sar12_trial / 16384) - 2*floor(sar12_trial / 32768))*1.8
let sar12_previous = @VD_B14[pwl]
let sar12_stimulus = vector(8)
let sar12_stimulus[0] = 0
let sar12_stimulus[1] = sar12_previous[length(sar12_previous)-1]
let sar12_stimulus[2] = 0.000146001
let sar12_stimulus[3] = sar12_stimulus[1]
let sar12_stimulus[4] = 0.000146003
let sar12_stimulus[5] = sar12_drive
let sar12_stimulus[6] = 0.000148
let sar12_stimulus[7] = sar12_stimulus[5]
alter @VD_B14[pwl] = sar12_stimulus
let sar12_drive = (floor(sar12_trial / 32768) - 2*floor(sar12_trial / 65536))*1.8
let sar12_previous = @VD_B15[pwl]
let sar12_stimulus = vector(8)
let sar12_stimulus[0] = 0
let sar12_stimulus[1] = sar12_previous[length(sar12_previous)-1]
let sar12_stimulus[2] = 0.000146001
let sar12_stimulus[3] = sar12_stimulus[1]
let sar12_stimulus[4] = 0.000146003
let sar12_stimulus[5] = sar12_drive
let sar12_stimulus[6] = 0.000148
let sar12_stimulus[7] = sar12_stimulus[5]
alter @VD_B15[pwl] = sar12_stimulus
resume
let sar12_k = length(time)-1
if abs(time[sar12_k] - 0.0001465) > 1e-12
print time[sar12_k]
echo expected_pause_time_s 0.0001465
echo SAR12_PAUSE_FAILED
quit 1
end
print time[sar12_k] >> pause-times.txt
let sar12_previous = @VD_EVAL[pwl]
let sar12_stimulus = vector(8)
let sar12_stimulus[0] = 0
let sar12_stimulus[1] = sar12_previous[length(sar12_previous)-1]
let sar12_stimulus[2] = 0.000146501
let sar12_stimulus[3] = sar12_stimulus[1]
let sar12_stimulus[4] = 0.000146503
let sar12_stimulus[5] = 1.8
let sar12_stimulus[6] = 0.000148
let sar12_stimulus[7] = sar12_stimulus[5]
alter @VD_EVAL[pwl] = sar12_stimulus
resume
let sar12_k = length(time)-1
if abs(time[sar12_k] - 0.000147) > 1e-12
print time[sar12_k]
echo expected_pause_time_s 0.000147
echo SAR12_PAUSE_FAILED
quit 1
end
print time[sar12_k] >> pause-times.txt
let sar12_k = length(time)-1
let sar12_cmp = v(COMP)[sar12_k]
let sar12_cmpn = v(COMPN)[sar12_k]
let sar12_p = v(TOPP)[sar12_k]
let sar12_n = v(TOPN)[sar12_k]
let sar12_decision = 0
if sar12_cmp >= 0.9
let sar12_code = sar12_trial
let sar12_decision = 1
end
echo 5 0 $&sar12_trial $&sar12_cmp $&sar12_cmpn $&sar12_p $&sar12_n 1.19998168945312 $&sar12_decision >> decisions.csv
let sar12_previous = @VD_EVAL[pwl]
let sar12_stimulus = vector(8)
let sar12_stimulus[0] = 0
let sar12_stimulus[1] = sar12_previous[length(sar12_previous)-1]
let sar12_stimulus[2] = 0.000147001
let sar12_stimulus[3] = sar12_stimulus[1]
let sar12_stimulus[4] = 0.000147003
let sar12_stimulus[5] = 0
let sar12_stimulus[6] = 0.000148
let sar12_stimulus[7] = sar12_stimulus[5]
alter @VD_EVAL[pwl] = sar12_stimulus
resume
let supply_current = -i(VDD)
let reference_current = -i(VREF)
wrdata waveform.dat v(VINP) v(VINN) v(SAMPLE) v(EVAL) v(TOPP) v(TOPN) v(COMP) v(COMPN) supply_current reference_current v(B0) v(B1) v(B2) v(B3) v(B4) v(B5) v(B6) v(B7) v(B8) v(B9) v(B10) v(B11) v(B12) v(B13) v(B14) v(B15) v(VPWR)
echo SAR16_NATIVE_COMPLETE
quit
.endc
.end

.subckt PREAMP INP INN BIAS OUT VPWR VGND
XN_INN MIR INN TAIL VGND sky130_fd_pr__nfet_01v8 w=10 l=1 nf=1 m=1
XN_INP OUT INP TAIL VGND sky130_fd_pr__nfet_01v8 w=10 l=1 nf=1 m=1
XN_TAIL TAIL BIAS VGND VGND sky130_fd_pr__nfet_01v8 w=2 l=1 nf=1 m=1
XP_DIODE MIR MIR VPWR VPWR sky130_fd_pr__pfet_01v8_hvt w=20 l=1 nf=1 m=1
XP_MIRROR OUT MIR VPWR VPWR sky130_fd_pr__pfet_01v8_hvt w=20 l=1 nf=1 m=1
.ends PREAMP
.subckt ADC16_COMPARATOR INP INN BIAS OUT VPWR VGND
XN_OUT OUT PRE VGND VGND sky130_fd_pr__nfet_01v8 w=4 l=0.15 nf=1 m=1
XPREAMP INP INN BIAS PRE VPWR VGND PREAMP
XP_OUT OUT PRE VPWR VPWR sky130_fd_pr__pfet_01v8_hvt w=8 l=0.15 nf=1 m=1
.ends ADC16_COMPARATOR
.subckt PIPE16_SUBADC VINP VINN VCM THP THN BIAS HIGH LOW VPWR VGND
XHIGH AVG_P AVG_HIGH BIAS HIGH VPWR VGND ADC16_COMPARATOR
XLOW AVG_P AVG_LOW BIAS LOW VPWR VGND ADC16_COMPARATOR
RR_HIGH0 VINN AVG_HIGH 1000000
RR_HIGH1 THP AVG_HIGH 1000000
RR_LOW0 VINN AVG_LOW 1000000
RR_LOW1 THN AVG_LOW 1000000
RR_P0 VINP AVG_P 1000000
RR_P1 VCM AVG_P 1000000
.ends PIPE16_SUBADC
.subckt INV A Y VPWR VGND
XMN Y A VGND VGND sky130_fd_pr__nfet_01v8 w=0.65 l=0.15 nf=1 m=1
XMP Y A VPWR VPWR sky130_fd_pr__pfet_01v8_hvt w=0.65 l=0.15 nf=1 m=1
.ends INV
.subckt MUX2 A B S Y VPWR VGND
XIS S SB VPWR VGND INV
XMNA Y SB A VGND sky130_fd_pr__nfet_01v8 w=0.65 l=0.15 nf=1 m=1
XMNB Y S B VGND sky130_fd_pr__nfet_01v8 w=0.65 l=0.15 nf=1 m=1
XMPA Y S A VPWR sky130_fd_pr__pfet_01v8_hvt w=0.65 l=0.15 nf=1 m=1
XMPB Y SB B VPWR sky130_fd_pr__pfet_01v8_hvt w=0.65 l=0.15 nf=1 m=1
.ends MUX2
.subckt DFF D CLK Q VPWR VGND
XICLK CLK CLKB VPWR VGND INV
XM1 M MB VPWR VGND INV
XM2 MB MF VPWR VGND INV
XMNIN M CLKB D VGND sky130_fd_pr__nfet_01v8 w=0.65 l=0.15 nf=1 m=1
XMNMF M CLK MF VGND sky130_fd_pr__nfet_01v8 w=0.65 l=0.15 nf=1 m=1
XMNOUT T CLK MF VGND sky130_fd_pr__nfet_01v8 w=0.65 l=0.15 nf=1 m=1
XMNSF T CLKB Q VGND sky130_fd_pr__nfet_01v8 w=0.65 l=0.15 nf=1 m=1
XMPIN M CLK D VPWR sky130_fd_pr__pfet_01v8_hvt w=0.65 l=0.15 nf=1 m=1
XMPMF M CLKB MF VPWR sky130_fd_pr__pfet_01v8_hvt w=0.65 l=0.15 nf=1 m=1
XMPOUT T CLKB MF VPWR sky130_fd_pr__pfet_01v8_hvt w=0.65 l=0.15 nf=1 m=1
XMPSF T CLK Q VPWR sky130_fd_pr__pfet_01v8_hvt w=0.65 l=0.15 nf=1 m=1
XS1 T TB VPWR VGND INV
XS2 TB Q VPWR VGND INV
.ends DFF
.subckt SDM8_SAMPLE_LATCH D CLK RESET Q VPWR VGND
XRESET_DATA D VGND RESET DATA VPWR VGND MUX2
XSAMPLE DATA CLK Q VPWR VGND DFF
.ends SDM8_SAMPLE_LATCH
.subckt SDM8_OTA_FIRST INP INN BIAS OUT VPWR VGND
XN_INN MIR INN TAIL VGND sky130_fd_pr__nfet_01v8 w=10 l=1 nf=1 m=1
XN_INP OUT INP TAIL VGND sky130_fd_pr__nfet_01v8 w=10 l=1 nf=1 m=1
XN_TAIL TAIL BIAS VGND VGND sky130_fd_pr__nfet_01v8 w=2 l=1 nf=1 m=1
XP_DIODE MIR MIR VPWR VPWR sky130_fd_pr__pfet_01v8_hvt w=20 l=1 nf=1 m=1
XP_MIRROR OUT MIR VPWR VPWR sky130_fd_pr__pfet_01v8_hvt w=20 l=1 nf=1 m=1
.ends SDM8_OTA_FIRST
.subckt ADC16_OTA INP INN BIAS OUT VPWR VGND
CC_MILLER PRE COMP 5e-13
XFIRST INP INN BIAS PRE VPWR VGND SDM8_OTA_FIRST
XN_SECOND OUT BIAS VGND VGND sky130_fd_pr__nfet_01v8 w=10 l=1 nf=1 m=1
XP_SECOND OUT PRE VPWR VPWR sky130_fd_pr__pfet_01v8_hvt w=20 l=1 nf=1 m=1
RR_ZERO COMP OUT 1000
.ends ADC16_OTA
.subckt SAR12_TG A Y EN ENB VPWR VGND
XN A EN Y VGND sky130_fd_pr__nfet_01v8 w=8 l=0.15 nf=1 m=1
XP A ENB Y VPWR sky130_fd_pr__pfet_01v8_hvt w=12 l=0.15 nf=1 m=1
.ends SAR12_TG
.subckt PIPE16_MDAC VIN DAC VCM BIAS SAMPLE SAMPLEB OUT VPWR VGND
XAMP VCM SUM BIAS OUT VPWR VGND ADC16_OTA
CC_FEEDBACK SUM OUT 1e-12
CC_SAMPLE SUM BOTTOM 2e-12
XHOLD DAC BOTTOM SAMPLEB SAMPLE VPWR VGND SAR12_TG
XRESET_OUT VCM OUT SAMPLE SAMPLEB VPWR VGND SAR12_TG
XRESET_SUM VCM SUM SAMPLE SAMPLEB VPWR VGND SAR12_TG
XSAMPLE VIN BOTTOM SAMPLE SAMPLEB VPWR VGND SAR12_TG
.ends PIPE16_MDAC
.subckt PIPE16_STAGE VINP VINN OUTP OUTN VCM REFP REFN THP THN BIAS SAMPLE HOLD RESET HIGH LOW VPWR VGND
XDAC0_N REFP VCM LOW DAC0_N VPWR VGND MUX2
XDAC0_P REFN VCM LOW DAC0_P VPWR VGND MUX2
XDAC1_N DAC0_N REFN HIGH DAC_N VPWR VGND MUX2
XDAC1_P DAC0_P REFP HIGH DAC_P VPWR VGND MUX2
XLATCH_HIGH HI_RAW HOLD RESET HIGH VPWR VGND SDM8_SAMPLE_LATCH
XLATCH_LOW LO_RAW HOLD RESET LOW VPWR VGND SDM8_SAMPLE_LATCH
XMDAC_N VINN DAC_N VCM BIAS SAMPLE SAMPLEB OUTN VPWR VGND PIPE16_MDAC
XMDAC_P VINP DAC_P VCM BIAS SAMPLE SAMPLEB OUTP VPWR VGND PIPE16_MDAC
XSAMPLE_INV SAMPLE SAMPLEB VPWR VGND INV
XSUBADC VINP VINN VCM THP THN BIAS HI_RAW LO_RAW VPWR VGND PIPE16_SUBADC
.ends PIPE16_STAGE
.subckt PIPE16_FLASH VINP VINN VCM FP FM BIAS CLK RESET Q0 Q1 Q2 VPWR VGND
XCMP0 AVG_P AVG_0 BIAS RAW_Q0 VPWR VGND ADC16_COMPARATOR
XCMP1 AVG_P AVG_1 BIAS RAW_Q1 VPWR VGND ADC16_COMPARATOR
XCMP2 AVG_P AVG_2 BIAS RAW_Q2 VPWR VGND ADC16_COMPARATOR
XLATCH0 RAW_Q0 CLK RESET Q0 VPWR VGND SDM8_SAMPLE_LATCH
XLATCH1 RAW_Q1 CLK RESET Q1 VPWR VGND SDM8_SAMPLE_LATCH
XLATCH2 RAW_Q2 CLK RESET Q2 VPWR VGND SDM8_SAMPLE_LATCH
RR_N00 VINN AVG_0 1000000
RR_N01 FM AVG_0 1000000
RR_N10 VINN AVG_1 1000000
RR_N11 VCM AVG_1 1000000
RR_N20 VINN AVG_2 1000000
RR_N21 FP AVG_2 1000000
RR_P0 VINP AVG_P 1000000
RR_P1 VCM AVG_P 1000000
.ends PIPE16_FLASH
.subckt pipeline16_analog VINP VINN VCM REFP REFN THP THN FP FM BIAS PHI1 PHI2 RESET STAGE0_LOW STAGE0_HIGH STAGE1_LOW STAGE1_HIGH STAGE2_LOW STAGE2_HIGH STAGE3_LOW STAGE3_HIGH STAGE4_LOW STAGE4_HIGH STAGE5_LOW STAGE5_HIGH STAGE6_LOW STAGE6_HIGH STAGE7_LOW STAGE7_HIGH STAGE8_LOW STAGE8_HIGH STAGE9_LOW STAGE9_HIGH STAGE10_LOW STAGE10_HIGH STAGE11_LOW STAGE11_HIGH STAGE12_LOW STAGE12_HIGH STAGE13_LOW STAGE13_HIGH RESIDUEP RESIDUEN Q0 Q1 Q2 VPWR VGND
XFLASH RESIDUEP RESIDUEN VCM FP FM BIAS PHI2 RESET Q0 Q1 Q2 VPWR VGND PIPE16_FLASH
XSTAGE0 VINP VINN R1P R1N VCM REFP REFN THP THN BIAS PHI1 PHI2 RESET STAGE0_HIGH STAGE0_LOW VPWR VGND PIPE16_STAGE
XSTAGE1 R1P R1N R2P R2N VCM REFP REFN THP THN BIAS PHI2 PHI1 RESET STAGE1_HIGH STAGE1_LOW VPWR VGND PIPE16_STAGE
XSTAGE10 R10P R10N R11P R11N VCM REFP REFN THP THN BIAS PHI1 PHI2 RESET STAGE10_HIGH STAGE10_LOW VPWR VGND PIPE16_STAGE
XSTAGE11 R11P R11N R12P R12N VCM REFP REFN THP THN BIAS PHI2 PHI1 RESET STAGE11_HIGH STAGE11_LOW VPWR VGND PIPE16_STAGE
XSTAGE12 R12P R12N R13P R13N VCM REFP REFN THP THN BIAS PHI1 PHI2 RESET STAGE12_HIGH STAGE12_LOW VPWR VGND PIPE16_STAGE
XSTAGE13 R13P R13N RESIDUEP RESIDUEN VCM REFP REFN THP THN BIAS PHI2 PHI1 RESET STAGE13_HIGH STAGE13_LOW VPWR VGND PIPE16_STAGE
XSTAGE2 R2P R2N R3P R3N VCM REFP REFN THP THN BIAS PHI1 PHI2 RESET STAGE2_HIGH STAGE2_LOW VPWR VGND PIPE16_STAGE
XSTAGE3 R3P R3N R4P R4N VCM REFP REFN THP THN BIAS PHI2 PHI1 RESET STAGE3_HIGH STAGE3_LOW VPWR VGND PIPE16_STAGE
XSTAGE4 R4P R4N R5P R5N VCM REFP REFN THP THN BIAS PHI1 PHI2 RESET STAGE4_HIGH STAGE4_LOW VPWR VGND PIPE16_STAGE
XSTAGE5 R5P R5N R6P R6N VCM REFP REFN THP THN BIAS PHI2 PHI1 RESET STAGE5_HIGH STAGE5_LOW VPWR VGND PIPE16_STAGE
XSTAGE6 R6P R6N R7P R7N VCM REFP REFN THP THN BIAS PHI1 PHI2 RESET STAGE6_HIGH STAGE6_LOW VPWR VGND PIPE16_STAGE
XSTAGE7 R7P R7N R8P R8N VCM REFP REFN THP THN BIAS PHI2 PHI1 RESET STAGE7_HIGH STAGE7_LOW VPWR VGND PIPE16_STAGE
XSTAGE8 R8P R8N R9P R9N VCM REFP REFN THP THN BIAS PHI1 PHI2 RESET STAGE8_HIGH STAGE8_LOW VPWR VGND PIPE16_STAGE
XSTAGE9 R9P R9N R10P R10N VCM REFP REFN THP THN BIAS PHI2 PHI1 RESET STAGE9_HIGH STAGE9_LOW VPWR VGND PIPE16_STAGE
.ends pipeline16_analog

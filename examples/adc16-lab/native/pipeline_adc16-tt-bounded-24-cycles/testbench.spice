Resistor Indust actual ADC16 MOS reference
.include "/mnt/d/Coldbrew/Resistor/.runtime/adc16/native/pipeline_adc16-tt-bounded-24-cycles/supported-tt.spice"
.include "/mnt/d/Coldbrew/Resistor/.runtime/adc16/native/pipeline_adc16-tt-bounded-24-cycles/analog.spice"
.option sparse scale=1e-6 method=gear maxord=2 reltol=1e-5 vntol=1e-6 abstol=1e-12
.temp 27.0
VGND VGND 0 0
VDD SUPPLY VGND 1.8
R_SUPPLY SUPPLY VPWR .1
XU VINP VINN VCM REFP REFN THP THN FP FM BIAS PHI1 PHI2 RESET STAGE0_LOW STAGE0_HIGH STAGE1_LOW STAGE1_HIGH STAGE2_LOW STAGE2_HIGH STAGE3_LOW STAGE3_HIGH STAGE4_LOW STAGE4_HIGH STAGE5_LOW STAGE5_HIGH STAGE6_LOW STAGE6_HIGH STAGE7_LOW STAGE7_HIGH STAGE8_LOW STAGE8_HIGH STAGE9_LOW STAGE9_HIGH STAGE10_LOW STAGE10_HIGH STAGE11_LOW STAGE11_HIGH STAGE12_LOW STAGE12_HIGH STAGE13_LOW STAGE13_HIGH RESIDUEP RESIDUEN Q0 Q1 Q2 VPWR VGND pipeline16_analog
V_VINP VINP_DRV VGND 0.975
R_VINP VINP_DRV VINP 50
V_VINN VINN_DRV VGND 0.825
R_VINN VINN_DRV VINN 50
V_VCM VCM_DRV VGND 0.9
R_VCM VCM_DRV VCM 2
V_REFP REFP_DRV VGND 1.2
R_REFP REFP_DRV REFP 2
V_REFN REFN_DRV VGND 0.6
R_REFN REFN_DRV REFN 2
V_THP THP_DRV VGND 1.2
R_THP THP_DRV THP 2
V_THN THN_DRV VGND 0.6
R_THN THN_DRV THN 2
V_FP FP_DRV VGND 1.5
R_FP FP_DRV FP 2
V_FM FM_DRV VGND 0.3
R_FM FM_DRV FM 2
V_BIAS BIAS_DRV VGND 0.75
R_BIAS BIAS_DRV BIAS 2
VPHI1 PHI1 VGND PULSE(0 1.8 1e-07 1e-08 1e-08 4.7e-06 1e-05)
VPHI2 PHI2 VGND PULSE(0 1.8 5.1e-06 1e-08 1e-08 4.7e-06 1e-05)
VRESET RESET VGND PWL(0 1.8 1.99e-05 1.8 2e-05 0)
.control
set num_threads=1
set numdgt=17
set wr_singlescale
set wr_vecnames
tran 5e-08 0.00024 0 5e-08
let supply_current = -i(VDD)
wrdata waveform.dat v(VINP) v(VINN) v(PHI1) v(PHI2) v(RESET) v(RESIDUEP) v(RESIDUEN) v(STAGE0_LOW) v(STAGE0_HIGH) v(STAGE1_LOW) v(STAGE1_HIGH) v(STAGE2_LOW) v(STAGE2_HIGH) v(STAGE3_LOW) v(STAGE3_HIGH) v(STAGE4_LOW) v(STAGE4_HIGH) v(STAGE5_LOW) v(STAGE5_HIGH) v(STAGE6_LOW) v(STAGE6_HIGH) v(STAGE7_LOW) v(STAGE7_HIGH) v(STAGE8_LOW) v(STAGE8_HIGH) v(STAGE9_LOW) v(STAGE9_HIGH) v(STAGE10_LOW) v(STAGE10_HIGH) v(STAGE11_LOW) v(STAGE11_HIGH) v(STAGE12_LOW) v(STAGE12_HIGH) v(STAGE13_LOW) v(STAGE13_HIGH) v(Q0) v(Q1) v(Q2) supply_current
echo ADC16_NATIVE_COMPLETE
quit
.endc
.end

.subckt PREAMP INP INN BIAS OUT VPWR VGND
XN_INN MIR INN TAIL VGND sky130_fd_pr__nfet_01v8 w=10 l=1 nf=1 m=1
XN_INP OUT INP TAIL VGND sky130_fd_pr__nfet_01v8 w=10 l=1 nf=1 m=1
XN_TAIL TAIL BIAS VGND VGND sky130_fd_pr__nfet_01v8 w=2 l=1 nf=1 m=1
XP_DIODE MIR MIR VPWR VPWR sky130_fd_pr__pfet_01v8_hvt w=20 l=1 nf=1 m=1
XP_MIRROR OUT MIR VPWR VPWR sky130_fd_pr__pfet_01v8_hvt w=20 l=1 nf=1 m=1
.ends PREAMP
.subckt adc16_comparator INP INN BIAS OUT VPWR VGND
XN_OUT OUT PRE VGND VGND sky130_fd_pr__nfet_01v8 w=4 l=0.15 nf=1 m=1
XPREAMP INP INN BIAS PRE VPWR VGND PREAMP
XP_OUT OUT PRE VPWR VPWR sky130_fd_pr__pfet_01v8_hvt w=8 l=0.15 nf=1 m=1
.ends adc16_comparator

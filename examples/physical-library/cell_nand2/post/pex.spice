* NGSPICE file created from cell_nand2.ext - technology: sky130A

.subckt cell_nand2 VPWR VGND A1 Y A0
X0 VGND.t2 A1.t0 N1.t1 VGND.t1 sky130_fd_pr__nfet_01v8 ad=0.1885 pd=1.88 as=0.1885 ps=1.88 w=0.65 l=0.15
X1 VPWR.t1 A0.t0 Y.t0 VPWR.t0 sky130_fd_pr__pfet_01v8_hvt ad=0.1885 pd=1.88 as=0.1885 ps=1.88 w=0.65 l=0.15
X2 N1.t0 A0.t1 Y.t1 VGND.t0 sky130_fd_pr__nfet_01v8 ad=0.1885 pd=1.88 as=0.1885 ps=1.88 w=0.65 l=0.15
X3 VPWR.t3 A1.t1 Y.t2 VPWR.t2 sky130_fd_pr__pfet_01v8_hvt ad=0.1885 pd=1.88 as=0.1885 ps=1.88 w=0.65 l=0.15
C0 VPWR A0 0.43865f
C1 N1 Y 0.34236f
C2 N1 VPWR 0.01205f
C3 A1 Y 1.13097f
C4 N1 A0 0.57614f
C5 VPWR A1 0.42782f
C6 VPWR Y 0.52665f
C7 A1 A0 0.00702f
C8 A0 Y 1.15678f
C9 N1 A1 1.15233f
R0 A1 A1.t1 330.341
R1 A1 A1.t0 315.88
R2 A1 A1.n0 31.0332
R3 A1.n0 A1 30.2004
R4 A1.n0 A1 2.22536
R5 N1.t1 N1.n1 255.345
R6 N1.n2 N1.t1 255.345
R7 N1.t0 N1.n0 255.345
R8 N1.n5 N1.t0 255.345
R9 N1.n4 N1.n3 23.9345
R10 N1 N1.n1 12.8005
R11 N1.n2 N1 12.8005
R12 N1 N1.n0 12.8005
R13 N1 N1.n5 12.8005
R14 N1.n3 N1.n1 10.1513
R15 N1.n3 N1.n2 10.1513
R16 N1.n4 N1.n0 10.1513
R17 N1.n5 N1.n4 10.1513
R18 VGND.n50 VGND.n43 3975.41
R19 VGND.n31 VGND.n21 1315.26
R20 VGND.n41 VGND.n17 1315.26
R21 VGND.n33 VGND.n19 1315.26
R22 VGND.n35 VGND.n34 1315.26
R23 VGND.n52 VGND.n10 1315.26
R24 VGND.n63 VGND.n11 1315.26
R25 VGND.n65 VGND.n8 1315.26
R26 VGND.n47 VGND.n7 1315.26
R27 VGND.n41 VGND.n40 585
R28 VGND.n39 VGND.n16 585
R29 VGND.n38 VGND.n37 585
R30 VGND.n36 VGND.n35 585
R31 VGND.n34 VGND.n1 585
R32 VGND.n34 VGND.n14 585
R33 VGND.n33 VGND.n0 585
R34 VGND.n33 VGND.n32 585
R35 VGND.n22 VGND.n19 585
R36 VGND.n26 VGND.n23 585
R37 VGND.n28 VGND.n27 585
R38 VGND.n29 VGND.n21 585
R39 VGND.n31 VGND.n30 585
R40 VGND.n32 VGND.n31 585
R41 VGND.n18 VGND.n17 585
R42 VGND.n17 VGND.n14 585
R43 VGND.n47 VGND.n46 585
R44 VGND.n45 VGND.n44 585
R45 VGND.n13 VGND.n12 585
R46 VGND.n53 VGND.n52 585
R47 VGND.n54 VGND.n10 585
R48 VGND.n49 VGND.n10 585
R49 VGND.n63 VGND.n62 585
R50 VGND.n64 VGND.n63 585
R51 VGND.n61 VGND.n11 585
R52 VGND.n60 VGND.n59 585
R53 VGND.n57 VGND.n55 585
R54 VGND.n8 VGND.n6 585
R55 VGND.n66 VGND.n65 585
R56 VGND.n65 VGND.n64 585
R57 VGND.n7 VGND.n5 585
R58 VGND.n49 VGND.n7 585
R59 VGND.n31 VGND.n17 394
R60 VGND.n27 VGND.n26 394
R61 VGND.n34 VGND.n33 394
R62 VGND.n37 VGND.n16 394
R63 VGND.n63 VGND.n10 394
R64 VGND.n59 VGND.n57 394
R65 VGND.n65 VGND.n7 394
R66 VGND.n44 VGND.n13 394
R67 VGND.t2 VGND.n2 255.345
R68 VGND.n3 VGND.t2 255.345
R69 VGND.n43 VGND.n42 218.815
R70 VGND.n43 VGND.n15 218.815
R71 VGND.n25 VGND.n20 218.815
R72 VGND.n24 VGND.n20 218.815
R73 VGND.n50 VGND.n48 218.815
R74 VGND.n51 VGND.n50 218.815
R75 VGND.n58 VGND.n9 218.815
R76 VGND.n56 VGND.n9 218.815
R77 VGND.n32 VGND.n20 188.921
R78 VGND.n43 VGND.n14 188.921
R79 VGND.n50 VGND.n49 188.921
R80 VGND.n64 VGND.n9 188.921
R81 VGND.n27 VGND.n24 147.374
R82 VGND.n25 VGND.n19 147.374
R83 VGND.n42 VGND.n41 147.374
R84 VGND.n35 VGND.n15 147.374
R85 VGND.n42 VGND.n16 147.374
R86 VGND.n37 VGND.n15 147.374
R87 VGND.n26 VGND.n25 147.374
R88 VGND.n24 VGND.n21 147.374
R89 VGND.n58 VGND.n11 147.374
R90 VGND.n56 VGND.n8 147.374
R91 VGND.n52 VGND.n51 147.374
R92 VGND.n48 VGND.n44 147.374
R93 VGND.n48 VGND.n47 147.374
R94 VGND.n51 VGND.n13 147.374
R95 VGND.n59 VGND.n58 147.374
R96 VGND.n57 VGND.n56 147.374
R97 VGND.n30 VGND.n29 85.4593
R98 VGND.n40 VGND.n18 85.4593
R99 VGND.n22 VGND.n0 85.4593
R100 VGND.n36 VGND.n1 85.4593
R101 VGND.n54 VGND.n53 85.4593
R102 VGND.n46 VGND.n5 85.4593
R103 VGND.n62 VGND.n61 85.4593
R104 VGND.n66 VGND.n6 85.4593
R105 VGND.n32 VGND.t1 51.8011
R106 VGND.t1 VGND.n14 51.8011
R107 VGND.n49 VGND.t0 51.8011
R108 VGND.n64 VGND.t0 51.8011
R109 VGND.n30 VGND.n18 25.6005
R110 VGND.n29 VGND.n28 25.6005
R111 VGND.n28 VGND.n23 25.6005
R112 VGND.n23 VGND.n22 25.6005
R113 VGND.n40 VGND.n39 25.6005
R114 VGND.n39 VGND.n38 25.6005
R115 VGND.n38 VGND.n36 25.6005
R116 VGND.n53 VGND.n12 25.6005
R117 VGND.n45 VGND.n12 25.6005
R118 VGND.n46 VGND.n45 25.6005
R119 VGND.n62 VGND.n54 25.6005
R120 VGND.n61 VGND.n60 25.6005
R121 VGND.n60 VGND.n55 25.6005
R122 VGND.n55 VGND.n6 25.6005
R123 VGND VGND.n68 18.3598
R124 VGND.n67 VGND 18.3598
R125 VGND VGND.n2 12.8005
R126 VGND.n3 VGND 12.8005
R127 VGND VGND.n0 12.8005
R128 VGND VGND.n1 12.8005
R129 VGND VGND.n5 12.8005
R130 VGND VGND.n66 12.8005
R131 VGND.n68 VGND.n4 10.1647
R132 VGND.n4 VGND.n2 10.1513
R133 VGND.n4 VGND.n3 10.1513
R134 VGND.n68 VGND.n67 1.64668
R135 VGND.n67 VGND 1.18255
R136 A0 A0.t0 330.341
R137 A0 A0.t1 315.88
R138 A0 A0.n0 30.1999
R139 A0.n0 A0 29.3671
R140 A0.n0 A0 0.567438
R141 Y.t0 Y.n1 700.484
R142 Y.n2 Y.t0 700.484
R143 Y.t2 Y.n0 700.484
R144 Y.n10 Y.t2 700.484
R145 Y.t1 Y.n5 255.345
R146 Y.n6 Y.t1 255.345
R147 Y Y.n5 12.8005
R148 Y.n6 Y 12.8005
R149 Y Y.n0 12.8005
R150 Y Y.n10 12.8005
R151 Y Y.n1 12.8005
R152 Y.n2 Y 12.8005
R153 Y.n9 Y.n8 11.2693
R154 Y.n8 Y.n7 10.4521
R155 Y.n4 Y.n3 10.4521
R156 Y.n7 Y.n5 10.1513
R157 Y.n7 Y.n6 10.1513
R158 Y.n9 Y.n0 10.1513
R159 Y.n10 Y.n9 10.1513
R160 Y.n3 Y.n1 10.1513
R161 Y.n3 Y.n2 10.1513
R162 Y.n8 Y.n4 0.817713
R163 Y.n4 Y 0.212587
R164 VPWR.n55 VPWR.n43 832.942
R165 VPWR.n66 VPWR.n44 832.942
R166 VPWR.n68 VPWR.n41 832.942
R167 VPWR.n50 VPWR.n40 832.942
R168 VPWR.n18 VPWR.n6 832.942
R169 VPWR.n29 VPWR.n7 832.942
R170 VPWR.n31 VPWR.n4 832.942
R171 VPWR.n13 VPWR.n3 832.942
R172 VPWR.t1 VPWR.n34 700.484
R173 VPWR.n35 VPWR.t1 700.484
R174 VPWR.t3 VPWR.n0 700.484
R175 VPWR.n72 VPWR.t3 700.484
R176 VPWR.n66 VPWR.n43 240
R177 VPWR.n62 VPWR.n60 240
R178 VPWR.n68 VPWR.n40 240
R179 VPWR.n47 VPWR.n46 240
R180 VPWR.n29 VPWR.n6 240
R181 VPWR.n25 VPWR.n23 240
R182 VPWR.n31 VPWR.n3 240
R183 VPWR.n10 VPWR.n9 240
R184 VPWR.n53 VPWR.n52 207.394
R185 VPWR.n67 VPWR.n42 207.394
R186 VPWR.n16 VPWR.n15 207.394
R187 VPWR.n30 VPWR.n5 207.394
R188 VPWR.n50 VPWR.n49 185
R189 VPWR.n48 VPWR.n47 185
R190 VPWR.n46 VPWR.n45 185
R191 VPWR.n56 VPWR.n55 185
R192 VPWR.n57 VPWR.n43 185
R193 VPWR.n52 VPWR.n43 185
R194 VPWR.n66 VPWR.n65 185
R195 VPWR.n67 VPWR.n66 185
R196 VPWR.n64 VPWR.n44 185
R197 VPWR.n63 VPWR.n62 185
R198 VPWR.n60 VPWR.n58 185
R199 VPWR.n41 VPWR.n39 185
R200 VPWR.n69 VPWR.n68 185
R201 VPWR.n68 VPWR.n67 185
R202 VPWR.n40 VPWR.n38 185
R203 VPWR.n52 VPWR.n40 185
R204 VPWR.n13 VPWR.n12 185
R205 VPWR.n11 VPWR.n10 185
R206 VPWR.n9 VPWR.n8 185
R207 VPWR.n19 VPWR.n18 185
R208 VPWR.n20 VPWR.n6 185
R209 VPWR.n15 VPWR.n6 185
R210 VPWR.n29 VPWR.n28 185
R211 VPWR.n30 VPWR.n29 185
R212 VPWR.n27 VPWR.n7 185
R213 VPWR.n26 VPWR.n25 185
R214 VPWR.n23 VPWR.n21 185
R215 VPWR.n4 VPWR.n2 185
R216 VPWR.n32 VPWR.n31 185
R217 VPWR.n31 VPWR.n30 185
R218 VPWR.n3 VPWR.n1 185
R219 VPWR.n15 VPWR.n3 185
R220 VPWR.n57 VPWR.n56 88.8476
R221 VPWR.n49 VPWR.n38 88.8476
R222 VPWR.n65 VPWR.n64 88.8476
R223 VPWR.n69 VPWR.n39 88.8476
R224 VPWR.n20 VPWR.n19 88.8476
R225 VPWR.n12 VPWR.n1 88.8476
R226 VPWR.n28 VPWR.n27 88.8476
R227 VPWR.n32 VPWR.n2 88.8476
R228 VPWR.n61 VPWR.n44 72.7879
R229 VPWR.n59 VPWR.n41 72.7879
R230 VPWR.n55 VPWR.n54 72.7879
R231 VPWR.n51 VPWR.n47 72.7879
R232 VPWR.n51 VPWR.n50 72.7879
R233 VPWR.n54 VPWR.n46 72.7879
R234 VPWR.n62 VPWR.n61 72.7879
R235 VPWR.n60 VPWR.n59 72.7879
R236 VPWR.n24 VPWR.n7 72.7879
R237 VPWR.n22 VPWR.n4 72.7879
R238 VPWR.n18 VPWR.n17 72.7879
R239 VPWR.n14 VPWR.n10 72.7879
R240 VPWR.n14 VPWR.n13 72.7879
R241 VPWR.n17 VPWR.n9 72.7879
R242 VPWR.n25 VPWR.n24 72.7879
R243 VPWR.n23 VPWR.n22 72.7879
R244 VPWR.n52 VPWR.t2 56.8667
R245 VPWR.n67 VPWR.t2 56.8667
R246 VPWR.n15 VPWR.t0 56.8667
R247 VPWR.n30 VPWR.t0 56.8667
R248 VPWR.n53 VPWR.n51 56.1076
R249 VPWR.n54 VPWR.n53 56.1076
R250 VPWR.n61 VPWR.n42 56.1076
R251 VPWR.n59 VPWR.n42 56.1076
R252 VPWR.n16 VPWR.n14 56.1076
R253 VPWR.n17 VPWR.n16 56.1076
R254 VPWR.n24 VPWR.n5 56.1076
R255 VPWR.n22 VPWR.n5 56.1076
R256 VPWR.n56 VPWR.n45 25.6005
R257 VPWR.n48 VPWR.n45 25.6005
R258 VPWR.n49 VPWR.n48 25.6005
R259 VPWR.n65 VPWR.n57 25.6005
R260 VPWR.n64 VPWR.n63 25.6005
R261 VPWR.n63 VPWR.n58 25.6005
R262 VPWR.n58 VPWR.n39 25.6005
R263 VPWR.n19 VPWR.n8 25.6005
R264 VPWR.n11 VPWR.n8 25.6005
R265 VPWR.n12 VPWR.n11 25.6005
R266 VPWR.n28 VPWR.n20 25.6005
R267 VPWR.n27 VPWR.n26 25.6005
R268 VPWR.n26 VPWR.n21 25.6005
R269 VPWR.n21 VPWR.n2 25.6005
R270 VPWR.n70 VPWR 18.865
R271 VPWR.n33 VPWR 18.865
R272 VPWR VPWR.n34 12.8005
R273 VPWR.n35 VPWR 12.8005
R274 VPWR VPWR.n38 12.8005
R275 VPWR VPWR.n69 12.8005
R276 VPWR VPWR.n0 12.8005
R277 VPWR VPWR.n72 12.8005
R278 VPWR VPWR.n1 12.8005
R279 VPWR VPWR.n32 12.8005
R280 VPWR.n71 VPWR.n70 10.6855
R281 VPWR.n37 VPWR.n36 10.5563
R282 VPWR.n36 VPWR.n34 10.1513
R283 VPWR.n36 VPWR.n35 10.1513
R284 VPWR.n71 VPWR.n0 10.1513
R285 VPWR.n72 VPWR.n71 10.1513
R286 VPWR.n70 VPWR.n37 1.50567
R287 VPWR.n33 VPWR 0.353587
R288 VPWR.n37 VPWR.n33 0.12975
C10 A1 VGND 2.82123f
C11 Y VGND 1.78376f
C12 A0 VGND 1.65826f
C13 VPWR VGND 5.72877f
C14 N1 VGND 2.02191f $ **FLOATING
.ends

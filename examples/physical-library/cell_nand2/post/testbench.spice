Resistor public CMOS cell actual input truth matrix
.include "./supported-tt.spice"
.option scale=1e-6
.include "./current-probe.spice"
.temp 27.0
VGND VGND 0 0
VDD VPWR VGND 1.8
VA0 A0 VGND PWL(0 0 5e-08 0 5.01e-08 1.8 1e-07 1.8 1.001e-07 0 1.5e-07 0 1.501e-07 1.8 2e-07 1.8)
VA1 A1 VGND PWL(0 0 5e-08 0 5.01e-08 0 1e-07 0 1.001e-07 1.8 1.5e-07 1.8 1.501e-07 1.8 2e-07 1.8)
CLOAD Y VGND 5e-15
XU VPWR VGND A1 Y A0 cell_nand2
.control
save v(A0) v(A1) v(Y) i(VDD) i(v.xu.vregister_cf_142c8d7d64380b1c) i(v.xu.vregister_cf_fbf828f20dc297a4) i(v.xu.vregister_cf_19c218fd0e6808d6) i(v.xu.vregister_cf_b2d044cb9d8d8299) i(VGND) i(VA0) i(VA1) v(XU.VGND.t2) v(XU.N1.t1) v(XU.A1.t0) v(XU.VGND.t1) v(XU.VPWR.t1) v(XU.Y.t0) v(XU.A0.t0) v(XU.VPWR.t0) v(XU.N1.t0) v(XU.Y.t1) v(XU.A0.t1) v(XU.VGND.t0) v(XU.VPWR.t3) v(XU.Y.t2) v(XU.A1.t1) v(XU.VPWR.t2) v(VGND) v(VPWR)
set numdgt=17
set wr_singlescale
set wr_vecnames
tran 100p 2e-07
let mos_wave_0 = v(A0)
let mos_wave_1 = v(A1)
let mos_wave_2 = v(Y)
let mos_wave_3 = -i(VDD)
wrdata waveform.dat mos_wave_0 mos_wave_1 mos_wave_2 mos_wave_3
write waveform.raw all
let register_flow_0 = i(v.xu.vregister_cf_142c8d7d64380b1c)
let register_flow_1 = i(v.xu.vregister_cf_fbf828f20dc297a4)
let register_flow_2 = i(v.xu.vregister_cf_19c218fd0e6808d6)
let register_flow_3 = i(v.xu.vregister_cf_b2d044cb9d8d8299)
let register_flow_4 = i(VGND)
let register_flow_5 = i(VDD)
let register_flow_6 = i(VA0)
let register_flow_7 = i(VA1)
wrdata current-flow.dat register_flow_0 register_flow_1 register_flow_2 register_flow_3 register_flow_4 register_flow_5 register_flow_6 register_flow_7
let register_voltage_0 = v(XU.VGND.t2)
let register_voltage_1 = v(XU.N1.t1)
let register_voltage_2 = v(XU.A1.t0)
let register_voltage_3 = v(XU.VGND.t1)
let register_voltage_4 = v(XU.VPWR.t1)
let register_voltage_5 = v(XU.Y.t0)
let register_voltage_6 = v(XU.A0.t0)
let register_voltage_7 = v(XU.VPWR.t0)
let register_voltage_8 = v(XU.N1.t0)
let register_voltage_9 = v(XU.Y.t1)
let register_voltage_10 = v(XU.A0.t1)
let register_voltage_11 = v(XU.VGND.t0)
let register_voltage_12 = v(XU.VPWR.t3)
let register_voltage_13 = v(XU.Y.t2)
let register_voltage_14 = v(XU.A1.t1)
let register_voltage_15 = v(XU.VPWR.t2)
let register_voltage_16 = v(VGND)
let register_voltage_17 = 0*register_flow_0
let register_voltage_18 = v(VPWR)
let register_voltage_19 = v(A0)
let register_voltage_20 = v(A1)
wrdata node-voltages.dat register_voltage_0 register_voltage_1 register_voltage_2 register_voltage_3 register_voltage_4 register_voltage_5 register_voltage_6 register_voltage_7 register_voltage_8 register_voltage_9 register_voltage_10 register_voltage_11 register_voltage_12 register_voltage_13 register_voltage_14 register_voltage_15 register_voltage_16 register_voltage_17 register_voltage_18 register_voltage_19 register_voltage_20
quit
.endc
.end

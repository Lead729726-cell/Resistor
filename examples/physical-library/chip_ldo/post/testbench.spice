Resistor actual SKY130 chip reference chip_ldo
.options method=gear maxord=2
.include "./supported-tt.spice"
.option scale=1e-6
.include "./current-probe.spice"
.temp 27.0
VGND VGND 0 0
VDD VPWR VGND 1.8
VREF VREF VGND 0.6
VBIAS BIAS VGND 0.9
COUT OUT VGND 1e-09
RLOAD OUT VGND 60000
RSTEP OUT LOADSTEP 6666.66666667
SLOAD LOADSTEP VGND LOADCTL VGND LOADSW
VLOAD LOADCTL VGND PULSE(0 1.8 20u 100n 100n 40u 100u)
.model LOADSW SW(Ron=0.1 Roff=1e12 Vt=0.9 Vh=0.01)
XU VPWR OUT VGND BIAS VREF chip_ldo
.control
save v(OUT) i(VDD) v(xu.FB) v(xu.GATE) i(v.xu.vregister_cf_7b2e503a288b8722) i(v.xu.vregister_cf_eefefc6c06c921d0) i(v.xu.vregister_cf_a05bee7a367ec656) i(v.xu.vregister_cf_c10da4fdaabac09e) i(v.xu.vregister_cf_37b5bae114b87098) i(v.xu.vregister_cf_66c93ee4ff93fbf8) i(v.xu.vregister_cf_b2d0114a94ac8350) i(v.xu.vregister_cf_3ad1eb309f2b715a) i(v.xu.vregister_cf_fd38354a7dc389bd) i(v.xu.vregister_cf_44e4d7555c3112e1) i(VGND) i(VREF) i(VBIAS) i(VLOAD) v(XU.VPWR.t13) v(XU.OUT.t4) v(XU.GATE.t5) v(XU.VPWR.t12) v(XU.ERROR_AMP__TAIL.t0) v(XU.ERROR_AMP__MIR.t0) v(XU.FB.t2) v(XU.VGND.t3) v(XU.VGND.t8) v(XU.ERROR_AMP__TAIL.t1) v(XU.BIAS.t0) v(XU.VGND.t7) v(XU.ERROR_AMP__TAIL.t2) v(XU.GATE.t1) v(XU.VREF.t0) v(XU.VGND.t14) v(XU.VPWR.t11) v(XU.OUT.t1) v(XU.GATE.t7) v(XU.VPWR.t10) v(XU.VPWR.t9) v(XU.OUT.t2) v(XU.GATE.t8) v(XU.VPWR.t8) v(XU.VPWR.t3) v(XU.ERROR_AMP__MIR.t2) v(XU.ERROR_AMP__MIR.t1) v(XU.VPWR.t2) v(XU.VPWR.t7) v(XU.OUT.t3) v(XU.GATE.t16) v(XU.VPWR.t6) v(XU.VPWR.t1) v(XU.GATE.t0) v(XU.ERROR_AMP__MIR.t3) v(XU.VPWR.t0) v(XU.VPWR.t5) v(XU.OUT.t5) v(XU.GATE.t18) v(XU.VPWR.t4) v(VGND) v(VPWR) v(VREF) v(BIAS) v(LOADCTL)
set num_threads=1
set numdgt=17
set noaskquit
set wr_singlescale
set wr_vecnames
tran 5e-08 0.0001
let mos_wave_0 = v(OUT)
let mos_wave_1 = -i(VDD)
let mos_wave_2 = v(xu.FB)
let mos_wave_3 = v(xu.GATE)
wrdata waveform.dat mos_wave_0 mos_wave_1 mos_wave_2 mos_wave_3
write waveform.raw all
let register_flow_0 = i(v.xu.vregister_cf_7b2e503a288b8722)
let register_flow_1 = i(v.xu.vregister_cf_eefefc6c06c921d0)
let register_flow_2 = i(v.xu.vregister_cf_a05bee7a367ec656)
let register_flow_3 = i(v.xu.vregister_cf_c10da4fdaabac09e)
let register_flow_4 = i(v.xu.vregister_cf_37b5bae114b87098)
let register_flow_5 = i(v.xu.vregister_cf_66c93ee4ff93fbf8)
let register_flow_6 = i(v.xu.vregister_cf_b2d0114a94ac8350)
let register_flow_7 = i(v.xu.vregister_cf_3ad1eb309f2b715a)
let register_flow_8 = i(v.xu.vregister_cf_fd38354a7dc389bd)
let register_flow_9 = i(v.xu.vregister_cf_44e4d7555c3112e1)
let register_flow_10 = i(VGND)
let register_flow_11 = i(VDD)
let register_flow_12 = i(VREF)
let register_flow_13 = i(VBIAS)
let register_flow_14 = i(VLOAD)
wrdata current-flow.dat register_flow_0 register_flow_1 register_flow_2 register_flow_3 register_flow_4 register_flow_5 register_flow_6 register_flow_7 register_flow_8 register_flow_9 register_flow_10 register_flow_11 register_flow_12 register_flow_13 register_flow_14
let register_voltage_0 = v(XU.VPWR.t13)
let register_voltage_1 = v(XU.OUT.t4)
let register_voltage_2 = v(XU.GATE.t5)
let register_voltage_3 = v(XU.VPWR.t12)
let register_voltage_4 = v(XU.ERROR_AMP__TAIL.t0)
let register_voltage_5 = v(XU.ERROR_AMP__MIR.t0)
let register_voltage_6 = v(XU.FB.t2)
let register_voltage_7 = v(XU.VGND.t3)
let register_voltage_8 = v(XU.VGND.t8)
let register_voltage_9 = v(XU.ERROR_AMP__TAIL.t1)
let register_voltage_10 = v(XU.BIAS.t0)
let register_voltage_11 = v(XU.VGND.t7)
let register_voltage_12 = v(XU.ERROR_AMP__TAIL.t2)
let register_voltage_13 = v(XU.GATE.t1)
let register_voltage_14 = v(XU.VREF.t0)
let register_voltage_15 = v(XU.VGND.t14)
let register_voltage_16 = v(XU.VPWR.t11)
let register_voltage_17 = v(XU.OUT.t1)
let register_voltage_18 = v(XU.GATE.t7)
let register_voltage_19 = v(XU.VPWR.t10)
let register_voltage_20 = v(XU.VPWR.t9)
let register_voltage_21 = v(XU.OUT.t2)
let register_voltage_22 = v(XU.GATE.t8)
let register_voltage_23 = v(XU.VPWR.t8)
let register_voltage_24 = v(XU.VPWR.t3)
let register_voltage_25 = v(XU.ERROR_AMP__MIR.t2)
let register_voltage_26 = v(XU.ERROR_AMP__MIR.t1)
let register_voltage_27 = v(XU.VPWR.t2)
let register_voltage_28 = v(XU.VPWR.t7)
let register_voltage_29 = v(XU.OUT.t3)
let register_voltage_30 = v(XU.GATE.t16)
let register_voltage_31 = v(XU.VPWR.t6)
let register_voltage_32 = v(XU.VPWR.t1)
let register_voltage_33 = v(XU.GATE.t0)
let register_voltage_34 = v(XU.ERROR_AMP__MIR.t3)
let register_voltage_35 = v(XU.VPWR.t0)
let register_voltage_36 = v(XU.VPWR.t5)
let register_voltage_37 = v(XU.OUT.t5)
let register_voltage_38 = v(XU.GATE.t18)
let register_voltage_39 = v(XU.VPWR.t4)
let register_voltage_40 = v(VGND)
let register_voltage_41 = 0*register_flow_0
let register_voltage_42 = v(VPWR)
let register_voltage_43 = v(VREF)
let register_voltage_44 = v(BIAS)
let register_voltage_45 = v(LOADCTL)
wrdata node-voltages.dat register_voltage_0 register_voltage_1 register_voltage_2 register_voltage_3 register_voltage_4 register_voltage_5 register_voltage_6 register_voltage_7 register_voltage_8 register_voltage_9 register_voltage_10 register_voltage_11 register_voltage_12 register_voltage_13 register_voltage_14 register_voltage_15 register_voltage_16 register_voltage_17 register_voltage_18 register_voltage_19 register_voltage_20 register_voltage_21 register_voltage_22 register_voltage_23 register_voltage_24 register_voltage_25 register_voltage_26 register_voltage_27 register_voltage_28 register_voltage_29 register_voltage_30 register_voltage_31 register_voltage_32 register_voltage_33 register_voltage_34 register_voltage_35 register_voltage_36 register_voltage_37 register_voltage_38 register_voltage_39 register_voltage_40 register_voltage_41 register_voltage_42 register_voltage_43 register_voltage_44 register_voltage_45
quit
.endc
.end

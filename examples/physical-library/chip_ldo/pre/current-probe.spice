.subckt chip_ldo VREF BIAS OUT VPWR VGND
XC_COMP_P0 GATE COMP sky130_fd_pr__cap_mim_m3_1 w=28.68 l=28.68
XC_COMP_P1 GATE COMP sky130_fd_pr__cap_mim_m3_1 w=28.68 l=28.68
XC_COMP_P10 GATE COMP sky130_fd_pr__cap_mim_m3_1 w=28.68 l=28.68
XC_COMP_P11 GATE COMP sky130_fd_pr__cap_mim_m3_1 w=28.68 l=28.68
XC_COMP_P2 GATE COMP sky130_fd_pr__cap_mim_m3_1 w=28.68 l=28.68
XC_COMP_P3 GATE COMP sky130_fd_pr__cap_mim_m3_1 w=28.68 l=28.68
XC_COMP_P4 GATE COMP sky130_fd_pr__cap_mim_m3_1 w=28.68 l=28.68
XC_COMP_P5 GATE COMP sky130_fd_pr__cap_mim_m3_1 w=28.68 l=28.68
XC_COMP_P6 GATE COMP sky130_fd_pr__cap_mim_m3_1 w=28.68 l=28.68
XC_COMP_P7 GATE COMP sky130_fd_pr__cap_mim_m3_1 w=28.68 l=28.68
XC_COMP_P8 GATE COMP sky130_fd_pr__cap_mim_m3_1 w=28.68 l=28.68
XC_COMP_P9 GATE COMP sky130_fd_pr__cap_mim_m3_1 w=28.68 l=28.68
XERROR_AMP_N_INN register_cf_node_ad624a38a20f86e3 FB register_cf_node_ad624a38a20f86e3_source VGND sky130_fd_pr__nfet_01v8 w=10 l=1 nf=1 m=1
Vregister_cf_ad624a38a20f86e3 ERROR_AMP__MIR register_cf_node_ad624a38a20f86e3 0
Vregister_cf_ad624a38a20f86e3_source ERROR_AMP__TAIL register_cf_node_ad624a38a20f86e3_source 0
XERROR_AMP_N_INP register_cf_node_f14f8bdf50d5f8b0 VREF register_cf_node_f14f8bdf50d5f8b0_source VGND sky130_fd_pr__nfet_01v8 w=10 l=1 nf=1 m=1
Vregister_cf_f14f8bdf50d5f8b0 GATE register_cf_node_f14f8bdf50d5f8b0 0
Vregister_cf_f14f8bdf50d5f8b0_source ERROR_AMP__TAIL register_cf_node_f14f8bdf50d5f8b0_source 0
XERROR_AMP_N_TAIL register_cf_node_a4f5d5cf8ab6ff8c BIAS register_cf_node_a4f5d5cf8ab6ff8c_source VGND sky130_fd_pr__nfet_01v8 w=2 l=1 nf=1 m=1
Vregister_cf_a4f5d5cf8ab6ff8c ERROR_AMP__TAIL register_cf_node_a4f5d5cf8ab6ff8c 0
Vregister_cf_a4f5d5cf8ab6ff8c_source VGND register_cf_node_a4f5d5cf8ab6ff8c_source 0
XERROR_AMP_P_DIODE register_cf_node_45738ee016e05868 ERROR_AMP__MIR register_cf_node_45738ee016e05868_source VPWR sky130_fd_pr__pfet_01v8_hvt w=20 l=1 nf=1 m=1
Vregister_cf_45738ee016e05868 ERROR_AMP__MIR register_cf_node_45738ee016e05868 0
Vregister_cf_45738ee016e05868_source VPWR register_cf_node_45738ee016e05868_source 0
XERROR_AMP_P_MIRROR register_cf_node_fe2ae4d6dab922b1 ERROR_AMP__MIR register_cf_node_fe2ae4d6dab922b1_source VPWR sky130_fd_pr__pfet_01v8_hvt w=20 l=1 nf=1 m=1
Vregister_cf_fe2ae4d6dab922b1 GATE register_cf_node_fe2ae4d6dab922b1 0
Vregister_cf_fe2ae4d6dab922b1_source VPWR register_cf_node_fe2ae4d6dab922b1_source 0
XPASS0 register_cf_node_d969221a365d2a95 GATE register_cf_node_d969221a365d2a95_source VPWR sky130_fd_pr__pfet_01v8_hvt w=20 l=0.15 nf=1 m=1
Vregister_cf_d969221a365d2a95 OUT register_cf_node_d969221a365d2a95 0
Vregister_cf_d969221a365d2a95_source VPWR register_cf_node_d969221a365d2a95_source 0
XPASS1 register_cf_node_6bad8ec437fcbab1 GATE register_cf_node_6bad8ec437fcbab1_source VPWR sky130_fd_pr__pfet_01v8_hvt w=20 l=0.15 nf=1 m=1
Vregister_cf_6bad8ec437fcbab1 OUT register_cf_node_6bad8ec437fcbab1 0
Vregister_cf_6bad8ec437fcbab1_source VPWR register_cf_node_6bad8ec437fcbab1_source 0
XPASS2 register_cf_node_d33fcf75d0929dfd GATE register_cf_node_d33fcf75d0929dfd_source VPWR sky130_fd_pr__pfet_01v8_hvt w=20 l=0.15 nf=1 m=1
Vregister_cf_d33fcf75d0929dfd OUT register_cf_node_d33fcf75d0929dfd 0
Vregister_cf_d33fcf75d0929dfd_source VPWR register_cf_node_d33fcf75d0929dfd_source 0
XPASS3 register_cf_node_6ce00279bd0a7baa GATE register_cf_node_6ce00279bd0a7baa_source VPWR sky130_fd_pr__pfet_01v8_hvt w=20 l=0.15 nf=1 m=1
Vregister_cf_6ce00279bd0a7baa OUT register_cf_node_6ce00279bd0a7baa 0
Vregister_cf_6ce00279bd0a7baa_source VPWR register_cf_node_6ce00279bd0a7baa_source 0
XPASS4 register_cf_node_83563f53a4988147 GATE register_cf_node_83563f53a4988147_source VPWR sky130_fd_pr__pfet_01v8_hvt w=20 l=0.15 nf=1 m=1
Vregister_cf_83563f53a4988147 OUT register_cf_node_83563f53a4988147 0
Vregister_cf_83563f53a4988147_source VPWR register_cf_node_83563f53a4988147_source 0
XR_FB_BOTTOM_P0 FB R_FB_BOTTOM_R0_N0 VGND sky130_fd_pr__res_xhigh_po_1p41 l=28.035
XR_FB_BOTTOM_P1 R_FB_BOTTOM_R0_N0 R_FB_BOTTOM_R0_N1 VGND sky130_fd_pr__res_xhigh_po_1p41 l=28.035
XR_FB_BOTTOM_P2 R_FB_BOTTOM_R0_N1 R_FB_BOTTOM_R0_N2 VGND sky130_fd_pr__res_xhigh_po_1p41 l=28.035
XR_FB_BOTTOM_P3 R_FB_BOTTOM_R0_N2 R_FB_BOTTOM_R0_N3 VGND sky130_fd_pr__res_xhigh_po_1p41 l=28.035
XR_FB_BOTTOM_P4 R_FB_BOTTOM_R0_N3 VGND VGND sky130_fd_pr__res_xhigh_po_1p41 l=28.035
XR_FB_TOP_P0 OUT R_FB_TOP_R0_N0 VGND sky130_fd_pr__res_xhigh_po_1p41 l=28.035
XR_FB_TOP_P1 R_FB_TOP_R0_N0 R_FB_TOP_R0_N1 VGND sky130_fd_pr__res_xhigh_po_1p41 l=28.035
XR_FB_TOP_P2 R_FB_TOP_R0_N1 R_FB_TOP_R0_N2 VGND sky130_fd_pr__res_xhigh_po_1p41 l=28.035
XR_FB_TOP_P3 R_FB_TOP_R0_N2 R_FB_TOP_R0_N3 VGND sky130_fd_pr__res_xhigh_po_1p41 l=28.035
XR_FB_TOP_P4 R_FB_TOP_R0_N3 FB VGND sky130_fd_pr__res_xhigh_po_1p41 l=28.035
XR_ZERO_P0 COMP OUT VGND sky130_fd_pr__res_xhigh_po_1p41 l=0.54
.ends chip_ldo

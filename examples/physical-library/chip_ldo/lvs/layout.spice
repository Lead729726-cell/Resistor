* NGSPICE file created from chip_ldo.ext - technology: sky130A

.subckt chip_ldo VPWR OUT VGND BIAS VREF
X0 FB R_FB_BOTTOM_R0_N0 VGND sky130_fd_pr__res_xhigh_po_1p41 l=28.04
X1 R_FB_TOP_R0_N3 FB VGND sky130_fd_pr__res_xhigh_po_1p41 l=28.04
X2 GATE COMP sky130_fd_pr__cap_mim_m3_1 l=28.68 w=28.68
X3 GATE COMP sky130_fd_pr__cap_mim_m3_1 l=28.68 w=28.68
X4 GATE COMP sky130_fd_pr__cap_mim_m3_1 l=28.68 w=28.68
X5 VPWR GATE OUT VPWR sky130_fd_pr__pfet_01v8_hvt ad=5.8 pd=40.58 as=5.8 ps=40.58 w=20 l=0.15
X6 ERROR_AMP__TAIL FB ERROR_AMP__MIR VGND sky130_fd_pr__nfet_01v8 ad=2.9 pd=20.58 as=2.9 ps=20.58 w=10 l=1
X7 VGND BIAS ERROR_AMP__TAIL VGND sky130_fd_pr__nfet_01v8 ad=0.58 pd=4.58 as=0.58 ps=4.58 w=2 l=1
X8 GATE COMP sky130_fd_pr__cap_mim_m3_1 l=28.68 w=28.68
X9 ERROR_AMP__TAIL VREF GATE VGND sky130_fd_pr__nfet_01v8 ad=2.9 pd=20.58 as=2.9 ps=20.58 w=10 l=1
X10 VPWR GATE OUT VPWR sky130_fd_pr__pfet_01v8_hvt ad=5.8 pd=40.58 as=5.8 ps=40.58 w=20 l=0.15
X11 VPWR GATE OUT VPWR sky130_fd_pr__pfet_01v8_hvt ad=5.8 pd=40.58 as=5.8 ps=40.58 w=20 l=0.15
X12 GATE COMP sky130_fd_pr__cap_mim_m3_1 l=28.68 w=28.68
X13 GATE COMP sky130_fd_pr__cap_mim_m3_1 l=28.68 w=28.68
X14 GATE COMP sky130_fd_pr__cap_mim_m3_1 l=28.68 w=28.68
X15 R_FB_BOTTOM_R0_N3 VGND VGND sky130_fd_pr__res_xhigh_po_1p41 l=28.04
X16 R_FB_BOTTOM_R0_N2 R_FB_BOTTOM_R0_N3 VGND sky130_fd_pr__res_xhigh_po_1p41 l=28.04
X17 GATE COMP sky130_fd_pr__cap_mim_m3_1 l=28.68 w=28.68
X18 R_FB_TOP_R0_N1 R_FB_TOP_R0_N2 VGND sky130_fd_pr__res_xhigh_po_1p41 l=28.04
X19 R_FB_TOP_R0_N0 R_FB_TOP_R0_N1 VGND sky130_fd_pr__res_xhigh_po_1p41 l=28.04
X20 R_FB_TOP_R0_N2 R_FB_TOP_R0_N3 VGND sky130_fd_pr__res_xhigh_po_1p41 l=28.04
X21 COMP OUT VGND sky130_fd_pr__res_xhigh_po_1p41 l=0.54
X22 GATE COMP sky130_fd_pr__cap_mim_m3_1 l=28.68 w=28.68
X23 GATE COMP sky130_fd_pr__cap_mim_m3_1 l=28.68 w=28.68
X24 OUT R_FB_TOP_R0_N0 VGND sky130_fd_pr__res_xhigh_po_1p41 l=28.04
X25 R_FB_BOTTOM_R0_N1 R_FB_BOTTOM_R0_N2 VGND sky130_fd_pr__res_xhigh_po_1p41 l=28.04
X26 GATE COMP sky130_fd_pr__cap_mim_m3_1 l=28.68 w=28.68
X27 VPWR ERROR_AMP__MIR ERROR_AMP__MIR VPWR sky130_fd_pr__pfet_01v8_hvt ad=5.8 pd=40.58 as=5.8 ps=40.58 w=20 l=1
X28 R_FB_BOTTOM_R0_N0 R_FB_BOTTOM_R0_N1 VGND sky130_fd_pr__res_xhigh_po_1p41 l=28.04
X29 VPWR GATE OUT VPWR sky130_fd_pr__pfet_01v8_hvt ad=5.8 pd=40.58 as=5.8 ps=40.58 w=20 l=0.15
X30 VPWR ERROR_AMP__MIR GATE VPWR sky130_fd_pr__pfet_01v8_hvt ad=5.8 pd=40.58 as=5.8 ps=40.58 w=20 l=1
X31 GATE COMP sky130_fd_pr__cap_mim_m3_1 l=28.68 w=28.68
X32 VPWR GATE OUT VPWR sky130_fd_pr__pfet_01v8_hvt ad=5.8 pd=40.58 as=5.8 ps=40.58 w=20 l=0.15
.ends

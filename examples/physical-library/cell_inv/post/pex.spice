* NGSPICE file created from cell_inv.ext - technology: sky130A

.subckt cell_inv VPWR VGND A Y
X0 VPWR.t1 A.t0 Y.t1 VPWR.t0 sky130_fd_pr__pfet_01v8_hvt ad=0.1885 pd=1.88 as=0.1885 ps=1.88 w=0.65 l=0.15
X1 VGND.t1 A.t1 Y.t0 VGND.t0 sky130_fd_pr__nfet_01v8 ad=0.1885 pd=1.88 as=0.1885 ps=1.88 w=0.65 l=0.15
C0 A VPWR 0.41987f
C1 Y VPWR 0.28581f
C2 Y A 0.90889f
R0 A A.t0 330.341
R1 A A.t1 315.88
R2 A A.n0 30.6166
R3 A.n0 A 29.7837
R4 A.n0 A 0.567438
R5 Y.t1 Y.n1 700.484
R6 Y.n2 Y.t1 700.484
R7 Y.t0 Y.n0 255.345
R8 Y.n6 Y.t0 255.345
R9 Y Y.n0 12.8005
R10 Y Y.n6 12.8005
R11 Y Y.n1 12.8005
R12 Y.n2 Y 12.8005
R13 Y.n5 Y.n4 10.8526
R14 Y.n5 Y.n0 10.1513
R15 Y.n6 Y.n5 10.1513
R16 Y.n3 Y.n1 10.1513
R17 Y.n3 Y.n2 10.1513
R18 Y.n4 Y.n3 10.0354
R19 Y.n4 Y 0.212587
R20 VPWR.n18 VPWR.n6 832.942
R21 VPWR.n29 VPWR.n7 832.942
R22 VPWR.n31 VPWR.n4 832.942
R23 VPWR.n13 VPWR.n3 832.942
R24 VPWR.t1 VPWR.n0 700.484
R25 VPWR.n35 VPWR.t1 700.484
R26 VPWR.n29 VPWR.n6 240
R27 VPWR.n25 VPWR.n23 240
R28 VPWR.n31 VPWR.n3 240
R29 VPWR.n10 VPWR.n9 240
R30 VPWR.n16 VPWR.n15 207.394
R31 VPWR.n30 VPWR.n5 207.394
R32 VPWR.n13 VPWR.n12 185
R33 VPWR.n11 VPWR.n10 185
R34 VPWR.n9 VPWR.n8 185
R35 VPWR.n19 VPWR.n18 185
R36 VPWR.n20 VPWR.n6 185
R37 VPWR.n15 VPWR.n6 185
R38 VPWR.n29 VPWR.n28 185
R39 VPWR.n30 VPWR.n29 185
R40 VPWR.n27 VPWR.n7 185
R41 VPWR.n26 VPWR.n25 185
R42 VPWR.n23 VPWR.n21 185
R43 VPWR.n4 VPWR.n2 185
R44 VPWR.n32 VPWR.n31 185
R45 VPWR.n31 VPWR.n30 185
R46 VPWR.n3 VPWR.n1 185
R47 VPWR.n15 VPWR.n3 185
R48 VPWR.n20 VPWR.n19 88.8476
R49 VPWR.n12 VPWR.n1 88.8476
R50 VPWR.n28 VPWR.n27 88.8476
R51 VPWR.n32 VPWR.n2 88.8476
R52 VPWR.n24 VPWR.n7 72.7879
R53 VPWR.n22 VPWR.n4 72.7879
R54 VPWR.n18 VPWR.n17 72.7879
R55 VPWR.n14 VPWR.n10 72.7879
R56 VPWR.n14 VPWR.n13 72.7879
R57 VPWR.n17 VPWR.n9 72.7879
R58 VPWR.n25 VPWR.n24 72.7879
R59 VPWR.n23 VPWR.n22 72.7879
R60 VPWR.n15 VPWR.t0 56.8667
R61 VPWR.n30 VPWR.t0 56.8667
R62 VPWR.n16 VPWR.n14 56.1076
R63 VPWR.n17 VPWR.n16 56.1076
R64 VPWR.n24 VPWR.n5 56.1076
R65 VPWR.n22 VPWR.n5 56.1076
R66 VPWR.n19 VPWR.n8 25.6005
R67 VPWR.n11 VPWR.n8 25.6005
R68 VPWR.n12 VPWR.n11 25.6005
R69 VPWR.n28 VPWR.n20 25.6005
R70 VPWR.n27 VPWR.n26 25.6005
R71 VPWR.n26 VPWR.n21 25.6005
R72 VPWR.n21 VPWR.n2 25.6005
R73 VPWR.n33 VPWR 18.865
R74 VPWR VPWR.n0 12.8005
R75 VPWR VPWR.n35 12.8005
R76 VPWR VPWR.n1 12.8005
R77 VPWR VPWR.n32 12.8005
R78 VPWR.n34 VPWR.n33 10.6855
R79 VPWR.n34 VPWR.n0 10.1513
R80 VPWR.n35 VPWR.n34 10.1513
R81 VPWR.n33 VPWR 0.353587
R82 VGND.n18 VGND.n6 1315.26
R83 VGND.n29 VGND.n7 1315.26
R84 VGND.n31 VGND.n4 1315.26
R85 VGND.n13 VGND.n3 1315.26
R86 VGND.n13 VGND.n12 585
R87 VGND.n11 VGND.n10 585
R88 VGND.n9 VGND.n8 585
R89 VGND.n19 VGND.n18 585
R90 VGND.n20 VGND.n6 585
R91 VGND.n15 VGND.n6 585
R92 VGND.n29 VGND.n28 585
R93 VGND.n30 VGND.n29 585
R94 VGND.n27 VGND.n7 585
R95 VGND.n26 VGND.n25 585
R96 VGND.n23 VGND.n21 585
R97 VGND.n4 VGND.n2 585
R98 VGND.n32 VGND.n31 585
R99 VGND.n31 VGND.n30 585
R100 VGND.n3 VGND.n1 585
R101 VGND.n15 VGND.n3 585
R102 VGND.n29 VGND.n6 394
R103 VGND.n25 VGND.n23 394
R104 VGND.n31 VGND.n3 394
R105 VGND.n10 VGND.n9 394
R106 VGND.t1 VGND.n0 255.345
R107 VGND.n35 VGND.t1 255.345
R108 VGND.n16 VGND.n15 226.578
R109 VGND.n30 VGND.n5 226.578
R110 VGND.n16 VGND.n14 218.815
R111 VGND.n17 VGND.n16 218.815
R112 VGND.n24 VGND.n5 218.815
R113 VGND.n22 VGND.n5 218.815
R114 VGND.n24 VGND.n7 147.374
R115 VGND.n22 VGND.n4 147.374
R116 VGND.n18 VGND.n17 147.374
R117 VGND.n14 VGND.n10 147.374
R118 VGND.n14 VGND.n13 147.374
R119 VGND.n17 VGND.n9 147.374
R120 VGND.n25 VGND.n24 147.374
R121 VGND.n23 VGND.n22 147.374
R122 VGND.n20 VGND.n19 85.4593
R123 VGND.n12 VGND.n1 85.4593
R124 VGND.n28 VGND.n27 85.4593
R125 VGND.n32 VGND.n2 85.4593
R126 VGND.n15 VGND.t0 62.1267
R127 VGND.n30 VGND.t0 62.1267
R128 VGND.n19 VGND.n8 25.6005
R129 VGND.n11 VGND.n8 25.6005
R130 VGND.n12 VGND.n11 25.6005
R131 VGND.n28 VGND.n20 25.6005
R132 VGND.n27 VGND.n26 25.6005
R133 VGND.n26 VGND.n21 25.6005
R134 VGND.n21 VGND.n2 25.6005
R135 VGND.n33 VGND 18.3598
R136 VGND VGND.n0 12.8005
R137 VGND VGND.n35 12.8005
R138 VGND VGND.n1 12.8005
R139 VGND VGND.n32 12.8005
R140 VGND.n34 VGND.n33 10.1647
R141 VGND.n34 VGND.n0 10.1513
R142 VGND.n35 VGND.n34 10.1513
R143 VGND.n33 VGND 1.18255
C3 Y VGND 1.44289f
C4 A VGND 2.23362f
C5 VPWR VGND 2.39622f
.ends

* NGSPICE file created from cell_or2.ext - technology: sky130A

.subckt cell_or2 VGND VPWR B Y A
X0 VGND.t5 A.t0 N.t2 VGND.t4 sky130_fd_pr__nfet_01v8 ad=0.1885 pd=1.88 as=0.1885 ps=1.88 w=0.65 l=0.15
X1 VGND.t3 N.t3 Y.t1 VGND.t2 sky130_fd_pr__nfet_01v8 ad=0.1885 pd=1.88 as=0.1885 ps=1.88 w=0.65 l=0.15
X2 VGND.t1 B.t0 N.t1 VGND.t0 sky130_fd_pr__nfet_01v8 ad=0.1885 pd=1.88 as=0.1885 ps=1.88 w=0.65 l=0.15
X3 VPWR.t4 A.t1 CORE__N.t1 VPWR.t3 sky130_fd_pr__pfet_01v8_hvt ad=0.1885 pd=1.88 as=0.1885 ps=1.88 w=0.65 l=0.15
X4 CORE__N.t0 B.t1 N.t0 VPWR.t0 sky130_fd_pr__pfet_01v8_hvt ad=0.1885 pd=1.88 as=0.1885 ps=1.88 w=0.65 l=0.15
X5 VPWR.t2 N.t4 Y.t0 VPWR.t1 sky130_fd_pr__pfet_01v8_hvt ad=0.1885 pd=1.88 as=0.1885 ps=1.88 w=0.65 l=0.15
C0 B Y 1.69772f
C1 VPWR N 0.57041f
C2 A N 0.36669f
C3 CORE__N Y 0.77223f
C4 B N 0.45398f
C5 A VPWR 0.45418f
C6 CORE__N N 0.62179f
C7 B VPWR 0.32348f
C8 A B 1.2916f
C9 VPWR CORE__N 0.38806f
C10 Y N 1.49414f
C11 A CORE__N 0.24971f
C12 VPWR Y 0.2775f
C13 B CORE__N 0.73959f
C14 A Y 0.00202f
R0 A A.t1 330.341
R1 A A.t0 315.88
R2 A A.n0 31.0353
R3 A.n0 A 29.3671
R4 A.n0 A 0.567438
R5 N.t0 N.n0 700.484
R6 N.n11 N.t0 700.484
R7 N N.t4 330.341
R8 N N.t3 315.88
R9 N.t2 N.n6 255.345
R10 N.n7 N.t2 255.345
R11 N.t1 N.n2 255.345
R12 N.n3 N.t1 255.345
R13 N.n1 N 31.8666
R14 N.n1 N 31.0337
R15 N N.n6 12.8005
R16 N.n7 N 12.8005
R17 N N.n2 12.8005
R18 N.n3 N 12.8005
R19 N N.n0 12.8005
R20 N N.n11 12.8005
R21 N.n10 N.n9 12.5193
R22 N.n9 N.n8 11.7021
R23 N.n5 N.n4 11.7021
R24 N.n8 N.n6 10.1513
R25 N.n8 N.n7 10.1513
R26 N.n4 N.n2 10.1513
R27 N.n4 N.n3 10.1513
R28 N.n10 N.n0 10.1513
R29 N.n11 N.n10 10.1513
R30 N.n5 N.n1 1.17256
R31 N.n9 N.n5 0.81125
R32 VGND.n79 VGND.n78 3656.77
R33 VGND.n70 VGND.n69 1524.81
R34 VGND.n67 VGND.n22 1315.26
R35 VGND.n63 VGND.n23 1315.26
R36 VGND.n33 VGND.n21 1315.26
R37 VGND.n55 VGND.n28 1315.26
R38 VGND.n76 VGND.n12 1315.26
R39 VGND.n72 VGND.n13 1315.26
R40 VGND.n40 VGND.n11 1315.26
R41 VGND.n47 VGND.n46 1315.26
R42 VGND.n92 VGND.n80 1315.26
R43 VGND.n103 VGND.n81 1315.26
R44 VGND.n105 VGND.n8 1315.26
R45 VGND.n87 VGND.n7 1315.26
R46 VGND.n73 VGND.n72 585
R47 VGND.n16 VGND.n15 585
R48 VGND.n44 VGND.n43 585
R49 VGND.n46 VGND.n45 585
R50 VGND.n48 VGND.n47 585
R51 VGND.n47 VGND.n17 585
R52 VGND.n42 VGND.n11 585
R53 VGND.n77 VGND.n11 585
R54 VGND.n41 VGND.n40 585
R55 VGND.n39 VGND.n38 585
R56 VGND.n37 VGND.n36 585
R57 VGND.n14 VGND.n12 585
R58 VGND.n76 VGND.n75 585
R59 VGND.n77 VGND.n76 585
R60 VGND.n74 VGND.n13 585
R61 VGND.n17 VGND.n13 585
R62 VGND.n64 VGND.n63 585
R63 VGND.n26 VGND.n25 585
R64 VGND.n59 VGND.n58 585
R65 VGND.n57 VGND.n28 585
R66 VGND.n56 VGND.n55 585
R67 VGND.n55 VGND.n27 585
R68 VGND.n35 VGND.n21 585
R69 VGND.n68 VGND.n21 585
R70 VGND.n34 VGND.n33 585
R71 VGND.n32 VGND.n31 585
R72 VGND.n30 VGND.n29 585
R73 VGND.n24 VGND.n22 585
R74 VGND.n67 VGND.n66 585
R75 VGND.n68 VGND.n67 585
R76 VGND.n65 VGND.n23 585
R77 VGND.n27 VGND.n23 585
R78 VGND.n87 VGND.n86 585
R79 VGND.n85 VGND.n84 585
R80 VGND.n83 VGND.n82 585
R81 VGND.n93 VGND.n92 585
R82 VGND.n94 VGND.n80 585
R83 VGND.n89 VGND.n80 585
R84 VGND.n103 VGND.n102 585
R85 VGND.n104 VGND.n103 585
R86 VGND.n101 VGND.n81 585
R87 VGND.n100 VGND.n99 585
R88 VGND.n97 VGND.n95 585
R89 VGND.n8 VGND.n6 585
R90 VGND.n106 VGND.n105 585
R91 VGND.n105 VGND.n104 585
R92 VGND.n7 VGND.n5 585
R93 VGND.n89 VGND.n7 585
R94 VGND.n67 VGND.n23 394
R95 VGND.n31 VGND.n30 394
R96 VGND.n55 VGND.n21 394
R97 VGND.n59 VGND.n26 394
R98 VGND.n76 VGND.n13 394
R99 VGND.n38 VGND.n37 394
R100 VGND.n47 VGND.n11 394
R101 VGND.n43 VGND.n16 394
R102 VGND.n103 VGND.n80 394
R103 VGND.n99 VGND.n97 394
R104 VGND.n105 VGND.n7 394
R105 VGND.n84 VGND.n83 394
R106 VGND.t5 VGND.n50 255.345
R107 VGND.n51 VGND.t5 255.345
R108 VGND.t1 VGND.n1 255.345
R109 VGND.n2 VGND.t1 255.345
R110 VGND.t3 VGND.n0 255.345
R111 VGND.n109 VGND.t3 255.345
R112 VGND.n71 VGND.n70 218.815
R113 VGND.n70 VGND.n18 218.815
R114 VGND.n78 VGND.n10 218.815
R115 VGND.n78 VGND.n9 218.815
R116 VGND.n62 VGND.n61 218.815
R117 VGND.n61 VGND.n60 218.815
R118 VGND.n69 VGND.n20 218.815
R119 VGND.n69 VGND.n19 218.815
R120 VGND.n90 VGND.n88 218.815
R121 VGND.n91 VGND.n90 218.815
R122 VGND.n98 VGND.n79 218.815
R123 VGND.n96 VGND.n79 218.815
R124 VGND.n78 VGND.n77 174.425
R125 VGND.n70 VGND.n17 174.425
R126 VGND.n69 VGND.n68 174.425
R127 VGND.n61 VGND.n27 174.425
R128 VGND.n90 VGND.n89 174.425
R129 VGND.n104 VGND.n79 174.425
R130 VGND.n30 VGND.n19 147.374
R131 VGND.n33 VGND.n20 147.374
R132 VGND.n63 VGND.n62 147.374
R133 VGND.n60 VGND.n28 147.374
R134 VGND.n37 VGND.n9 147.374
R135 VGND.n40 VGND.n10 147.374
R136 VGND.n72 VGND.n71 147.374
R137 VGND.n46 VGND.n18 147.374
R138 VGND.n71 VGND.n16 147.374
R139 VGND.n43 VGND.n18 147.374
R140 VGND.n38 VGND.n10 147.374
R141 VGND.n12 VGND.n9 147.374
R142 VGND.n62 VGND.n26 147.374
R143 VGND.n60 VGND.n59 147.374
R144 VGND.n31 VGND.n20 147.374
R145 VGND.n22 VGND.n19 147.374
R146 VGND.n98 VGND.n81 147.374
R147 VGND.n96 VGND.n8 147.374
R148 VGND.n92 VGND.n91 147.374
R149 VGND.n88 VGND.n84 147.374
R150 VGND.n88 VGND.n87 147.374
R151 VGND.n91 VGND.n83 147.374
R152 VGND.n99 VGND.n98 147.374
R153 VGND.n97 VGND.n96 147.374
R154 VGND.n66 VGND.n24 85.4593
R155 VGND.n65 VGND.n64 85.4593
R156 VGND.n35 VGND.n34 85.4593
R157 VGND.n57 VGND.n56 85.4593
R158 VGND.n75 VGND.n14 85.4593
R159 VGND.n74 VGND.n73 85.4593
R160 VGND.n42 VGND.n41 85.4593
R161 VGND.n48 VGND.n45 85.4593
R162 VGND.n94 VGND.n93 85.4593
R163 VGND.n86 VGND.n5 85.4593
R164 VGND.n102 VGND.n101 85.4593
R165 VGND.n106 VGND.n6 85.4593
R166 VGND.n77 VGND.t0 47.8266
R167 VGND.n17 VGND.t0 47.8266
R168 VGND.n68 VGND.t4 47.8266
R169 VGND.n27 VGND.t4 47.8266
R170 VGND.n89 VGND.t2 47.8266
R171 VGND.n104 VGND.t2 47.8266
R172 VGND.n66 VGND.n65 25.6005
R173 VGND.n29 VGND.n24 25.6005
R174 VGND.n32 VGND.n29 25.6005
R175 VGND.n34 VGND.n32 25.6005
R176 VGND.n64 VGND.n25 25.6005
R177 VGND.n58 VGND.n25 25.6005
R178 VGND.n58 VGND.n57 25.6005
R179 VGND.n75 VGND.n74 25.6005
R180 VGND.n36 VGND.n14 25.6005
R181 VGND.n39 VGND.n36 25.6005
R182 VGND.n41 VGND.n39 25.6005
R183 VGND.n73 VGND.n15 25.6005
R184 VGND.n44 VGND.n15 25.6005
R185 VGND.n45 VGND.n44 25.6005
R186 VGND.n93 VGND.n82 25.6005
R187 VGND.n85 VGND.n82 25.6005
R188 VGND.n86 VGND.n85 25.6005
R189 VGND.n102 VGND.n94 25.6005
R190 VGND.n101 VGND.n100 25.6005
R191 VGND.n100 VGND.n95 25.6005
R192 VGND.n95 VGND.n6 25.6005
R193 VGND VGND.n54 18.3598
R194 VGND.n49 VGND 18.3598
R195 VGND.n107 VGND 18.3598
R196 VGND VGND.n1 12.8005
R197 VGND.n2 VGND 12.8005
R198 VGND VGND.n35 12.8005
R199 VGND.n56 VGND 12.8005
R200 VGND VGND.n42 12.8005
R201 VGND VGND.n48 12.8005
R202 VGND VGND.n5 12.8005
R203 VGND VGND.n106 12.8005
R204 VGND VGND.n0 12.8005
R205 VGND VGND.n109 12.8005
R206 VGND VGND.n50 12.8005
R207 VGND.n51 VGND 12.8005
R208 VGND.n108 VGND.n107 10.1647
R209 VGND.n3 VGND.n1 10.1513
R210 VGND.n3 VGND.n2 10.1513
R211 VGND.n108 VGND.n0 10.1513
R212 VGND.n109 VGND.n108 10.1513
R213 VGND.n52 VGND.n50 10.1513
R214 VGND.n52 VGND.n51 10.1513
R215 VGND.n4 VGND.n3 10.0354
R216 VGND.n53 VGND.n52 10.0354
R217 VGND.n54 VGND 2.01797
R218 VGND.n107 VGND.n4 1.50567
R219 VGND.n53 VGND.n49 0.67025
R220 VGND.n54 VGND.n53 0.12975
R221 VGND.n49 VGND.n4 0.12975
R222 Y.t0 Y.n1 700.484
R223 Y.n2 Y.t0 700.484
R224 Y.t1 Y.n0 255.345
R225 Y.n6 Y.t1 255.345
R226 Y Y.n0 12.8005
R227 Y Y.n6 12.8005
R228 Y Y.n1 12.8005
R229 Y.n2 Y 12.8005
R230 Y.n5 Y.n4 11.686
R231 Y.n4 Y.n3 10.8688
R232 Y.n5 Y.n0 10.1513
R233 Y.n6 Y.n5 10.1513
R234 Y.n3 Y.n1 10.1513
R235 Y.n3 Y.n2 10.1513
R236 Y.n4 Y 3.52844
R237 B B.t1 330.341
R238 B B.t0 315.88
R239 B B.n0 31.4391
R240 B.n0 B 29.7837
R241 B.n0 B 1.40286
R242 CORE__N.t1 CORE__N.n1 700.484
R243 CORE__N.n2 CORE__N.t1 700.484
R244 CORE__N.t0 CORE__N.n0 700.484
R245 CORE__N.n5 CORE__N.t0 700.484
R246 CORE__N.n4 CORE__N.n3 23.676
R247 CORE__N CORE__N.n1 12.8005
R248 CORE__N.n2 CORE__N 12.8005
R249 CORE__N CORE__N.n0 12.8005
R250 CORE__N CORE__N.n5 12.8005
R251 CORE__N.n3 CORE__N.n1 10.1513
R252 CORE__N.n3 CORE__N.n2 10.1513
R253 CORE__N.n4 CORE__N.n0 10.1513
R254 CORE__N.n5 CORE__N.n4 10.1513
R255 VPWR.n55 VPWR.n43 832.942
R256 VPWR.n66 VPWR.n44 832.942
R257 VPWR.n68 VPWR.n41 832.942
R258 VPWR.n50 VPWR.n40 832.942
R259 VPWR.n88 VPWR.n76 832.942
R260 VPWR.n99 VPWR.n77 832.942
R261 VPWR.n101 VPWR.n74 832.942
R262 VPWR.n83 VPWR.n73 832.942
R263 VPWR.n18 VPWR.n6 832.942
R264 VPWR.n29 VPWR.n7 832.942
R265 VPWR.n31 VPWR.n4 832.942
R266 VPWR.n13 VPWR.n3 832.942
R267 VPWR.t4 VPWR.n34 700.484
R268 VPWR.n35 VPWR.t4 700.484
R269 VPWR.t2 VPWR.n0 700.484
R270 VPWR.n105 VPWR.t2 700.484
R271 VPWR.n66 VPWR.n43 240
R272 VPWR.n62 VPWR.n60 240
R273 VPWR.n68 VPWR.n40 240
R274 VPWR.n47 VPWR.n46 240
R275 VPWR.n99 VPWR.n76 240
R276 VPWR.n95 VPWR.n93 240
R277 VPWR.n101 VPWR.n73 240
R278 VPWR.n80 VPWR.n79 240
R279 VPWR.n29 VPWR.n6 240
R280 VPWR.n25 VPWR.n23 240
R281 VPWR.n31 VPWR.n3 240
R282 VPWR.n10 VPWR.n9 240
R283 VPWR.n53 VPWR.n52 207.394
R284 VPWR.n67 VPWR.n42 207.394
R285 VPWR.n86 VPWR.n85 207.394
R286 VPWR.n100 VPWR.n75 207.394
R287 VPWR.n16 VPWR.n15 207.394
R288 VPWR.n30 VPWR.n5 207.394
R289 VPWR.n50 VPWR.n49 185
R290 VPWR.n48 VPWR.n47 185
R291 VPWR.n46 VPWR.n45 185
R292 VPWR.n56 VPWR.n55 185
R293 VPWR.n57 VPWR.n43 185
R294 VPWR.n52 VPWR.n43 185
R295 VPWR.n66 VPWR.n65 185
R296 VPWR.n67 VPWR.n66 185
R297 VPWR.n64 VPWR.n44 185
R298 VPWR.n63 VPWR.n62 185
R299 VPWR.n60 VPWR.n58 185
R300 VPWR.n41 VPWR.n39 185
R301 VPWR.n69 VPWR.n68 185
R302 VPWR.n68 VPWR.n67 185
R303 VPWR.n40 VPWR.n38 185
R304 VPWR.n52 VPWR.n40 185
R305 VPWR.n83 VPWR.n82 185
R306 VPWR.n81 VPWR.n80 185
R307 VPWR.n79 VPWR.n78 185
R308 VPWR.n89 VPWR.n88 185
R309 VPWR.n90 VPWR.n76 185
R310 VPWR.n85 VPWR.n76 185
R311 VPWR.n99 VPWR.n98 185
R312 VPWR.n100 VPWR.n99 185
R313 VPWR.n97 VPWR.n77 185
R314 VPWR.n96 VPWR.n95 185
R315 VPWR.n93 VPWR.n91 185
R316 VPWR.n74 VPWR.n72 185
R317 VPWR.n102 VPWR.n101 185
R318 VPWR.n101 VPWR.n100 185
R319 VPWR.n73 VPWR.n71 185
R320 VPWR.n85 VPWR.n73 185
R321 VPWR.n13 VPWR.n12 185
R322 VPWR.n11 VPWR.n10 185
R323 VPWR.n9 VPWR.n8 185
R324 VPWR.n19 VPWR.n18 185
R325 VPWR.n20 VPWR.n6 185
R326 VPWR.n15 VPWR.n6 185
R327 VPWR.n29 VPWR.n28 185
R328 VPWR.n30 VPWR.n29 185
R329 VPWR.n27 VPWR.n7 185
R330 VPWR.n26 VPWR.n25 185
R331 VPWR.n23 VPWR.n21 185
R332 VPWR.n4 VPWR.n2 185
R333 VPWR.n32 VPWR.n31 185
R334 VPWR.n31 VPWR.n30 185
R335 VPWR.n3 VPWR.n1 185
R336 VPWR.n15 VPWR.n3 185
R337 VPWR.n57 VPWR.n56 88.8476
R338 VPWR.n49 VPWR.n38 88.8476
R339 VPWR.n65 VPWR.n64 88.8476
R340 VPWR.n69 VPWR.n39 88.8476
R341 VPWR.n90 VPWR.n89 88.8476
R342 VPWR.n82 VPWR.n71 88.8476
R343 VPWR.n98 VPWR.n97 88.8476
R344 VPWR.n102 VPWR.n72 88.8476
R345 VPWR.n20 VPWR.n19 88.8476
R346 VPWR.n12 VPWR.n1 88.8476
R347 VPWR.n28 VPWR.n27 88.8476
R348 VPWR.n32 VPWR.n2 88.8476
R349 VPWR.n61 VPWR.n44 72.7879
R350 VPWR.n59 VPWR.n41 72.7879
R351 VPWR.n55 VPWR.n54 72.7879
R352 VPWR.n51 VPWR.n47 72.7879
R353 VPWR.n51 VPWR.n50 72.7879
R354 VPWR.n54 VPWR.n46 72.7879
R355 VPWR.n62 VPWR.n61 72.7879
R356 VPWR.n60 VPWR.n59 72.7879
R357 VPWR.n94 VPWR.n77 72.7879
R358 VPWR.n92 VPWR.n74 72.7879
R359 VPWR.n88 VPWR.n87 72.7879
R360 VPWR.n84 VPWR.n80 72.7879
R361 VPWR.n84 VPWR.n83 72.7879
R362 VPWR.n87 VPWR.n79 72.7879
R363 VPWR.n95 VPWR.n94 72.7879
R364 VPWR.n93 VPWR.n92 72.7879
R365 VPWR.n24 VPWR.n7 72.7879
R366 VPWR.n22 VPWR.n4 72.7879
R367 VPWR.n18 VPWR.n17 72.7879
R368 VPWR.n14 VPWR.n10 72.7879
R369 VPWR.n14 VPWR.n13 72.7879
R370 VPWR.n17 VPWR.n9 72.7879
R371 VPWR.n25 VPWR.n24 72.7879
R372 VPWR.n23 VPWR.n22 72.7879
R373 VPWR.n52 VPWR.t0 56.8667
R374 VPWR.n67 VPWR.t0 56.8667
R375 VPWR.n85 VPWR.t1 56.8667
R376 VPWR.n100 VPWR.t1 56.8667
R377 VPWR.n15 VPWR.t3 56.8667
R378 VPWR.n30 VPWR.t3 56.8667
R379 VPWR.n53 VPWR.n51 56.1076
R380 VPWR.n54 VPWR.n53 56.1076
R381 VPWR.n61 VPWR.n42 56.1076
R382 VPWR.n59 VPWR.n42 56.1076
R383 VPWR.n86 VPWR.n84 56.1076
R384 VPWR.n87 VPWR.n86 56.1076
R385 VPWR.n94 VPWR.n75 56.1076
R386 VPWR.n92 VPWR.n75 56.1076
R387 VPWR.n16 VPWR.n14 56.1076
R388 VPWR.n17 VPWR.n16 56.1076
R389 VPWR.n24 VPWR.n5 56.1076
R390 VPWR.n22 VPWR.n5 56.1076
R391 VPWR.n56 VPWR.n45 25.6005
R392 VPWR.n48 VPWR.n45 25.6005
R393 VPWR.n49 VPWR.n48 25.6005
R394 VPWR.n65 VPWR.n57 25.6005
R395 VPWR.n64 VPWR.n63 25.6005
R396 VPWR.n63 VPWR.n58 25.6005
R397 VPWR.n58 VPWR.n39 25.6005
R398 VPWR.n89 VPWR.n78 25.6005
R399 VPWR.n81 VPWR.n78 25.6005
R400 VPWR.n82 VPWR.n81 25.6005
R401 VPWR.n98 VPWR.n90 25.6005
R402 VPWR.n97 VPWR.n96 25.6005
R403 VPWR.n96 VPWR.n91 25.6005
R404 VPWR.n91 VPWR.n72 25.6005
R405 VPWR.n19 VPWR.n8 25.6005
R406 VPWR.n11 VPWR.n8 25.6005
R407 VPWR.n12 VPWR.n11 25.6005
R408 VPWR.n28 VPWR.n20 25.6005
R409 VPWR.n27 VPWR.n26 25.6005
R410 VPWR.n26 VPWR.n21 25.6005
R411 VPWR.n21 VPWR.n2 25.6005
R412 VPWR.n70 VPWR 18.865
R413 VPWR.n103 VPWR 18.865
R414 VPWR.n33 VPWR 18.865
R415 VPWR VPWR.n34 12.8005
R416 VPWR.n35 VPWR 12.8005
R417 VPWR VPWR.n38 12.8005
R418 VPWR VPWR.n69 12.8005
R419 VPWR VPWR.n71 12.8005
R420 VPWR VPWR.n102 12.8005
R421 VPWR VPWR.n0 12.8005
R422 VPWR VPWR.n105 12.8005
R423 VPWR VPWR.n1 12.8005
R424 VPWR VPWR.n32 12.8005
R425 VPWR.n104 VPWR.n103 10.6855
R426 VPWR.n37 VPWR.n36 10.5563
R427 VPWR.n36 VPWR.n34 10.1513
R428 VPWR.n36 VPWR.n35 10.1513
R429 VPWR.n104 VPWR.n0 10.1513
R430 VPWR.n105 VPWR.n104 10.1513
R431 VPWR.n103 VPWR.n70 2.46918
R432 VPWR.n70 VPWR.n37 0.683175
R433 VPWR.n33 VPWR 0.353587
R434 VPWR.n37 VPWR.n33 0.12975
C15 Y VGND 2.30174f
C16 B VGND 1.90641f
C17 A VGND 2.13842f
C18 VPWR VGND 8.63648f
C19 N VGND 6.16526f $ **FLOATING
C20 CORE__N VGND 1.43185f $ **FLOATING
.ends

Resistor actual SKY130 chip reference chip_pll
.options method=gear maxord=2
.include "./supported-tt.spice"
.option scale=1e-6
.include "./current-probe.spice"
.temp 27.0
VGND VGND 0 0
VDD VPWR VGND 1.8
VREF REF VGND PULSE(0 1.8 1n 100p 100p 1.65666666667e-08 3.33333333333e-08)
.ic v(xu.OSCILLATOR__Q0)=0.1 v(xu.OSCILLATOR__Q1)=1.5 v(OUT)=0.2 v(CTRL)=0.9 v(xu.TUNE)=0.9
XU VPWR VGND OUT CTRL REF chip_pll
.control
save v(OUT) i(VDD) v(REF) v(xu.PD) v(xu.TUNE) v(CTRL) i(v.xu.vregister_cf_1e7cb8e34aa66fc4) i(v.xu.vregister_cf_154cdf18f4b0fd5b) i(v.xu.vregister_cf_c75e3235646023a6) i(v.xu.vregister_cf_6301ac38e39fb8d4) i(v.xu.vregister_cf_a7c49398f0ff52d5) i(v.xu.vregister_cf_c9dd6933c4474ccc) i(v.xu.vregister_cf_c51241f15c938239) i(v.xu.vregister_cf_8e6667d3efca4655) i(v.xu.vregister_cf_561a4caab26ca7a6) i(v.xu.vregister_cf_7dc7f36f8d4f10d6) i(v.xu.vregister_cf_f3d3ef8b4b6ebcfd) i(v.xu.vregister_cf_ab56a74baa4afbc2) i(v.xu.vregister_cf_d4bf9648df1e5bc9) i(v.xu.vregister_cf_990715172bf8cb7d) i(v.xu.vregister_cf_f02fcdf807644e9f) i(v.xu.vregister_cf_c99a0f4607d02f81) i(v.xu.vregister_cf_3794fad982e1d4e2) i(v.xu.vregister_cf_bb4936000ebbc9b3) i(v.xu.vregister_cf_0f81b0e223ca79e3) i(v.xu.vregister_cf_305c02dd1deef9c0) i(v.xu.vregister_cf_562e4855bbe97519) i(v.xu.vregister_cf_0f0236ad4f96775e) i(v.xu.vregister_cf_2f5eb8f92d6b0822) i(v.xu.vregister_cf_4054e4f878aca6cc) i(v.xu.vregister_cf_9ff2629569fdc8ee) i(v.xu.vregister_cf_ec73208ebc8348bf) i(v.xu.vregister_cf_2d3592162fa97555) i(v.xu.vregister_cf_45cef32972e65e72) i(v.xu.vregister_cf_9240bb38bb1476c1) i(v.xu.vregister_cf_742f88df7a24fe73) i(VGND) i(VREF) v(XU.VPWR.t9) v(XU.PD.t2) v(XU.PHASE_DETECTOR__N2.t3) v(XU.VPWR.t8) v(XU.VGND.t59) v(XU.OSCILLATOR__PBIAS.t0) v(XU.TUNE.t3) v(XU.VGND.t58) v(XU.OSCILLATOR__P2.t0) v(XU.OUT.t0) v(XU.OSCILLATOR__Q1.t2) v(XU.VPWR.t14) v(XU.VPWR.t7) v(XU.OSCILLATOR__P1.t0) v(XU.OSCILLATOR__PBIAS.t3) v(XU.VPWR.t6) v(XU.OSCILLATOR__P1.t1) v(XU.OSCILLATOR__Q1.t1) v(XU.OSCILLATOR__Q0.t2) v(XU.VPWR.t27) v(XU.PHASE_DETECTOR__N2__N1.t0) v(XU.PHASE_DETECTOR__N2.t2) v(XU.REF.t0) v(XU.VGND.t57) v(XU.VPWR.t23) v(XU.PHASE_DETECTOR__N3.t2) v(XU.PHASE_DETECTOR__N1.t3) v(XU.VPWR.t22) v(XU.VPWR.t19) v(XU.PHASE_DETECTOR__N3.t0) v(XU.OUT.t3) v(XU.VPWR.t18) v(XU.VGND.t62) v(XU.OSCILLATOR__N2.t1) v(XU.TUNE.t4) v(XU.VGND.t61) v(XU.VPWR.t11) v(XU.OSCILLATOR__P0.t1) v(XU.OSCILLATOR__PBIAS.t4) v(XU.VPWR.t10) v(XU.VGND.t27) v(XU.OSCILLATOR__N0.t1) v(XU.TUNE.t5) v(XU.VGND.t26) v(XU.OSCILLATOR__N0.t0) v(XU.OSCILLATOR__Q0.t1) v(XU.OUT.t4) v(XU.VGND.t2) v(XU.VGND.t6) v(XU.PHASE_DETECTOR__N1__N1.t0) v(XU.OUT.t5) v(XU.VGND.t5) v(XU.VPWR.t21) v(XU.PHASE_DETECTOR__N2.t0) v(XU.PHASE_DETECTOR__N1.t4) v(XU.VPWR.t20) v(XU.PHASE_DETECTOR__N4__N1.t1) v(XU.PD.t1) v(XU.PHASE_DETECTOR__N2.t4) v(XU.VGND.t33) v(XU.VGND.t4) v(XU.PHASE_DETECTOR__N4__N1.t0) v(XU.PHASE_DETECTOR__N3.t3) v(XU.VGND.t3) v(XU.VPWR.t17) v(XU.OSCILLATOR__P2.t1) v(XU.OSCILLATOR__PBIAS.t5) v(XU.VPWR.t16) v(XU.VPWR.t3) v(XU.PHASE_DETECTOR__N1.t1) v(XU.REF.t1) v(XU.VPWR.t2) v(XU.OSCILLATOR__N2.t0) v(XU.OUT.t1) v(XU.OSCILLATOR__Q1.t4) v(XU.VGND.t37) v(XU.VGND.t19) v(XU.OSCILLATOR__N1.t0) v(XU.TUNE.t6) v(XU.VGND.t18) v(XU.OSCILLATOR__N1.t1) v(XU.OSCILLATOR__Q1.t0) v(XU.OSCILLATOR__Q0.t4) v(XU.VGND.t8) v(XU.OSCILLATOR__P0.t0) v(XU.OSCILLATOR__Q0.t0) v(XU.OUT.t6) v(XU.VPWR.t15) v(XU.PHASE_DETECTOR__N1__N1.t1) v(XU.PHASE_DETECTOR__N1.t2) v(XU.REF.t2) v(XU.VGND.t30) v(XU.VPWR.t25) v(XU.PHASE_DETECTOR__N2.t1) v(XU.REF.t3) v(XU.VPWR.t24) v(XU.VGND.t49) v(XU.PHASE_DETECTOR__N3__N1.t1) v(XU.PHASE_DETECTOR__N1.t5) v(XU.VGND.t48) v(XU.VPWR.t5) v(XU.PD.t0) v(XU.PHASE_DETECTOR__N3.t4) v(XU.VPWR.t4) v(XU.PHASE_DETECTOR__N3__N1.t0) v(XU.PHASE_DETECTOR__N3.t1) v(XU.OUT.t7) v(XU.VGND.t39) v(XU.VPWR.t1) v(XU.PHASE_DETECTOR__N1.t0) v(XU.OUT.t8) v(XU.VPWR.t0) v(XU.VGND.t47) v(XU.PHASE_DETECTOR__N2__N1.t1) v(XU.PHASE_DETECTOR__N1.t6) v(XU.VGND.t46) v(XU.VPWR.t13) v(XU.OSCILLATOR__PBIAS.t2) v(XU.OSCILLATOR__PBIAS.t1) v(XU.VPWR.t12) v(VGND) v(VPWR)
set num_threads=1
set numdgt=17
set noaskquit
set wr_singlescale
set wr_vecnames
tran 1e-09 1.5e-05 uic
let mos_wave_0 = v(OUT)
let mos_wave_1 = -i(VDD)
let mos_wave_2 = v(REF)
let mos_wave_3 = v(xu.PD)
let mos_wave_4 = v(xu.TUNE)
let mos_wave_5 = v(CTRL)
wrdata waveform.dat mos_wave_0 mos_wave_1 mos_wave_2 mos_wave_3 mos_wave_4 mos_wave_5
write waveform.raw all
let register_flow_0 = i(v.xu.vregister_cf_1e7cb8e34aa66fc4)
let register_flow_1 = i(v.xu.vregister_cf_154cdf18f4b0fd5b)
let register_flow_2 = i(v.xu.vregister_cf_c75e3235646023a6)
let register_flow_3 = i(v.xu.vregister_cf_6301ac38e39fb8d4)
let register_flow_4 = i(v.xu.vregister_cf_a7c49398f0ff52d5)
let register_flow_5 = i(v.xu.vregister_cf_c9dd6933c4474ccc)
let register_flow_6 = i(v.xu.vregister_cf_c51241f15c938239)
let register_flow_7 = i(v.xu.vregister_cf_8e6667d3efca4655)
let register_flow_8 = i(v.xu.vregister_cf_561a4caab26ca7a6)
let register_flow_9 = i(v.xu.vregister_cf_7dc7f36f8d4f10d6)
let register_flow_10 = i(v.xu.vregister_cf_f3d3ef8b4b6ebcfd)
let register_flow_11 = i(v.xu.vregister_cf_ab56a74baa4afbc2)
let register_flow_12 = i(v.xu.vregister_cf_d4bf9648df1e5bc9)
let register_flow_13 = i(v.xu.vregister_cf_990715172bf8cb7d)
let register_flow_14 = i(v.xu.vregister_cf_f02fcdf807644e9f)
let register_flow_15 = i(v.xu.vregister_cf_c99a0f4607d02f81)
let register_flow_16 = i(v.xu.vregister_cf_3794fad982e1d4e2)
let register_flow_17 = i(v.xu.vregister_cf_bb4936000ebbc9b3)
let register_flow_18 = i(v.xu.vregister_cf_0f81b0e223ca79e3)
let register_flow_19 = i(v.xu.vregister_cf_305c02dd1deef9c0)
let register_flow_20 = i(v.xu.vregister_cf_562e4855bbe97519)
let register_flow_21 = i(v.xu.vregister_cf_0f0236ad4f96775e)
let register_flow_22 = i(v.xu.vregister_cf_2f5eb8f92d6b0822)
let register_flow_23 = i(v.xu.vregister_cf_4054e4f878aca6cc)
let register_flow_24 = i(v.xu.vregister_cf_9ff2629569fdc8ee)
let register_flow_25 = i(v.xu.vregister_cf_ec73208ebc8348bf)
let register_flow_26 = i(v.xu.vregister_cf_2d3592162fa97555)
let register_flow_27 = i(v.xu.vregister_cf_45cef32972e65e72)
let register_flow_28 = i(v.xu.vregister_cf_9240bb38bb1476c1)
let register_flow_29 = i(v.xu.vregister_cf_742f88df7a24fe73)
let register_flow_30 = i(VGND)
let register_flow_31 = i(VDD)
let register_flow_32 = i(VREF)
wrdata current-flow.dat register_flow_0 register_flow_1 register_flow_2 register_flow_3 register_flow_4 register_flow_5 register_flow_6 register_flow_7 register_flow_8 register_flow_9 register_flow_10 register_flow_11 register_flow_12 register_flow_13 register_flow_14 register_flow_15 register_flow_16 register_flow_17 register_flow_18 register_flow_19 register_flow_20 register_flow_21 register_flow_22 register_flow_23 register_flow_24 register_flow_25 register_flow_26 register_flow_27 register_flow_28 register_flow_29 register_flow_30 register_flow_31 register_flow_32
let register_voltage_0 = v(XU.VPWR.t9)
let register_voltage_1 = v(XU.PD.t2)
let register_voltage_2 = v(XU.PHASE_DETECTOR__N2.t3)
let register_voltage_3 = v(XU.VPWR.t8)
let register_voltage_4 = v(XU.VGND.t59)
let register_voltage_5 = v(XU.OSCILLATOR__PBIAS.t0)
let register_voltage_6 = v(XU.TUNE.t3)
let register_voltage_7 = v(XU.VGND.t58)
let register_voltage_8 = v(XU.OSCILLATOR__P2.t0)
let register_voltage_9 = v(XU.OUT.t0)
let register_voltage_10 = v(XU.OSCILLATOR__Q1.t2)
let register_voltage_11 = v(XU.VPWR.t14)
let register_voltage_12 = v(XU.VPWR.t7)
let register_voltage_13 = v(XU.OSCILLATOR__P1.t0)
let register_voltage_14 = v(XU.OSCILLATOR__PBIAS.t3)
let register_voltage_15 = v(XU.VPWR.t6)
let register_voltage_16 = v(XU.OSCILLATOR__P1.t1)
let register_voltage_17 = v(XU.OSCILLATOR__Q1.t1)
let register_voltage_18 = v(XU.OSCILLATOR__Q0.t2)
let register_voltage_19 = v(XU.VPWR.t27)
let register_voltage_20 = v(XU.PHASE_DETECTOR__N2__N1.t0)
let register_voltage_21 = v(XU.PHASE_DETECTOR__N2.t2)
let register_voltage_22 = v(XU.REF.t0)
let register_voltage_23 = v(XU.VGND.t57)
let register_voltage_24 = v(XU.VPWR.t23)
let register_voltage_25 = v(XU.PHASE_DETECTOR__N3.t2)
let register_voltage_26 = v(XU.PHASE_DETECTOR__N1.t3)
let register_voltage_27 = v(XU.VPWR.t22)
let register_voltage_28 = v(XU.VPWR.t19)
let register_voltage_29 = v(XU.PHASE_DETECTOR__N3.t0)
let register_voltage_30 = v(XU.OUT.t3)
let register_voltage_31 = v(XU.VPWR.t18)
let register_voltage_32 = v(XU.VGND.t62)
let register_voltage_33 = v(XU.OSCILLATOR__N2.t1)
let register_voltage_34 = v(XU.TUNE.t4)
let register_voltage_35 = v(XU.VGND.t61)
let register_voltage_36 = v(XU.VPWR.t11)
let register_voltage_37 = v(XU.OSCILLATOR__P0.t1)
let register_voltage_38 = v(XU.OSCILLATOR__PBIAS.t4)
let register_voltage_39 = v(XU.VPWR.t10)
let register_voltage_40 = v(XU.VGND.t27)
let register_voltage_41 = v(XU.OSCILLATOR__N0.t1)
let register_voltage_42 = v(XU.TUNE.t5)
let register_voltage_43 = v(XU.VGND.t26)
let register_voltage_44 = v(XU.OSCILLATOR__N0.t0)
let register_voltage_45 = v(XU.OSCILLATOR__Q0.t1)
let register_voltage_46 = v(XU.OUT.t4)
let register_voltage_47 = v(XU.VGND.t2)
let register_voltage_48 = v(XU.VGND.t6)
let register_voltage_49 = v(XU.PHASE_DETECTOR__N1__N1.t0)
let register_voltage_50 = v(XU.OUT.t5)
let register_voltage_51 = v(XU.VGND.t5)
let register_voltage_52 = v(XU.VPWR.t21)
let register_voltage_53 = v(XU.PHASE_DETECTOR__N2.t0)
let register_voltage_54 = v(XU.PHASE_DETECTOR__N1.t4)
let register_voltage_55 = v(XU.VPWR.t20)
let register_voltage_56 = v(XU.PHASE_DETECTOR__N4__N1.t1)
let register_voltage_57 = v(XU.PD.t1)
let register_voltage_58 = v(XU.PHASE_DETECTOR__N2.t4)
let register_voltage_59 = v(XU.VGND.t33)
let register_voltage_60 = v(XU.VGND.t4)
let register_voltage_61 = v(XU.PHASE_DETECTOR__N4__N1.t0)
let register_voltage_62 = v(XU.PHASE_DETECTOR__N3.t3)
let register_voltage_63 = v(XU.VGND.t3)
let register_voltage_64 = v(XU.VPWR.t17)
let register_voltage_65 = v(XU.OSCILLATOR__P2.t1)
let register_voltage_66 = v(XU.OSCILLATOR__PBIAS.t5)
let register_voltage_67 = v(XU.VPWR.t16)
let register_voltage_68 = v(XU.VPWR.t3)
let register_voltage_69 = v(XU.PHASE_DETECTOR__N1.t1)
let register_voltage_70 = v(XU.REF.t1)
let register_voltage_71 = v(XU.VPWR.t2)
let register_voltage_72 = v(XU.OSCILLATOR__N2.t0)
let register_voltage_73 = v(XU.OUT.t1)
let register_voltage_74 = v(XU.OSCILLATOR__Q1.t4)
let register_voltage_75 = v(XU.VGND.t37)
let register_voltage_76 = v(XU.VGND.t19)
let register_voltage_77 = v(XU.OSCILLATOR__N1.t0)
let register_voltage_78 = v(XU.TUNE.t6)
let register_voltage_79 = v(XU.VGND.t18)
let register_voltage_80 = v(XU.OSCILLATOR__N1.t1)
let register_voltage_81 = v(XU.OSCILLATOR__Q1.t0)
let register_voltage_82 = v(XU.OSCILLATOR__Q0.t4)
let register_voltage_83 = v(XU.VGND.t8)
let register_voltage_84 = v(XU.OSCILLATOR__P0.t0)
let register_voltage_85 = v(XU.OSCILLATOR__Q0.t0)
let register_voltage_86 = v(XU.OUT.t6)
let register_voltage_87 = v(XU.VPWR.t15)
let register_voltage_88 = v(XU.PHASE_DETECTOR__N1__N1.t1)
let register_voltage_89 = v(XU.PHASE_DETECTOR__N1.t2)
let register_voltage_90 = v(XU.REF.t2)
let register_voltage_91 = v(XU.VGND.t30)
let register_voltage_92 = v(XU.VPWR.t25)
let register_voltage_93 = v(XU.PHASE_DETECTOR__N2.t1)
let register_voltage_94 = v(XU.REF.t3)
let register_voltage_95 = v(XU.VPWR.t24)
let register_voltage_96 = v(XU.VGND.t49)
let register_voltage_97 = v(XU.PHASE_DETECTOR__N3__N1.t1)
let register_voltage_98 = v(XU.PHASE_DETECTOR__N1.t5)
let register_voltage_99 = v(XU.VGND.t48)
let register_voltage_100 = v(XU.VPWR.t5)
let register_voltage_101 = v(XU.PD.t0)
let register_voltage_102 = v(XU.PHASE_DETECTOR__N3.t4)
let register_voltage_103 = v(XU.VPWR.t4)
let register_voltage_104 = v(XU.PHASE_DETECTOR__N3__N1.t0)
let register_voltage_105 = v(XU.PHASE_DETECTOR__N3.t1)
let register_voltage_106 = v(XU.OUT.t7)
let register_voltage_107 = v(XU.VGND.t39)
let register_voltage_108 = v(XU.VPWR.t1)
let register_voltage_109 = v(XU.PHASE_DETECTOR__N1.t0)
let register_voltage_110 = v(XU.OUT.t8)
let register_voltage_111 = v(XU.VPWR.t0)
let register_voltage_112 = v(XU.VGND.t47)
let register_voltage_113 = v(XU.PHASE_DETECTOR__N2__N1.t1)
let register_voltage_114 = v(XU.PHASE_DETECTOR__N1.t6)
let register_voltage_115 = v(XU.VGND.t46)
let register_voltage_116 = v(XU.VPWR.t13)
let register_voltage_117 = v(XU.OSCILLATOR__PBIAS.t2)
let register_voltage_118 = v(XU.OSCILLATOR__PBIAS.t1)
let register_voltage_119 = v(XU.VPWR.t12)
let register_voltage_120 = v(VGND)
let register_voltage_121 = 0*register_flow_0
let register_voltage_122 = v(VPWR)
let register_voltage_123 = v(REF)
wrdata node-voltages.dat register_voltage_0 register_voltage_1 register_voltage_2 register_voltage_3 register_voltage_4 register_voltage_5 register_voltage_6 register_voltage_7 register_voltage_8 register_voltage_9 register_voltage_10 register_voltage_11 register_voltage_12 register_voltage_13 register_voltage_14 register_voltage_15 register_voltage_16 register_voltage_17 register_voltage_18 register_voltage_19 register_voltage_20 register_voltage_21 register_voltage_22 register_voltage_23 register_voltage_24 register_voltage_25 register_voltage_26 register_voltage_27 register_voltage_28 register_voltage_29 register_voltage_30 register_voltage_31 register_voltage_32 register_voltage_33 register_voltage_34 register_voltage_35 register_voltage_36 register_voltage_37 register_voltage_38 register_voltage_39 register_voltage_40 register_voltage_41 register_voltage_42 register_voltage_43 register_voltage_44 register_voltage_45 register_voltage_46 register_voltage_47 register_voltage_48 register_voltage_49 register_voltage_50 register_voltage_51 register_voltage_52 register_voltage_53 register_voltage_54 register_voltage_55 register_voltage_56 register_voltage_57 register_voltage_58 register_voltage_59 register_voltage_60 register_voltage_61 register_voltage_62 register_voltage_63 register_voltage_64 register_voltage_65 register_voltage_66 register_voltage_67 register_voltage_68 register_voltage_69 register_voltage_70 register_voltage_71 register_voltage_72 register_voltage_73 register_voltage_74 register_voltage_75 register_voltage_76 register_voltage_77 register_voltage_78 register_voltage_79 register_voltage_80 register_voltage_81 register_voltage_82 register_voltage_83 register_voltage_84 register_voltage_85 register_voltage_86 register_voltage_87 register_voltage_88 register_voltage_89 register_voltage_90 register_voltage_91 register_voltage_92 register_voltage_93 register_voltage_94 register_voltage_95 register_voltage_96 register_voltage_97 register_voltage_98 register_voltage_99 register_voltage_100 register_voltage_101 register_voltage_102 register_voltage_103 register_voltage_104 register_voltage_105 register_voltage_106 register_voltage_107 register_voltage_108 register_voltage_109 register_voltage_110 register_voltage_111 register_voltage_112 register_voltage_113 register_voltage_114 register_voltage_115 register_voltage_116 register_voltage_117 register_voltage_118 register_voltage_119 register_voltage_120 register_voltage_121 register_voltage_122 register_voltage_123
quit
.endc
.end

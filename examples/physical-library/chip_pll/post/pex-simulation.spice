* NGSPICE file created from chip_pll.ext - technology: sky130A

.subckt chip_pll VPWR VGND OUT CTRL REF
X0 VPWR.t9 PHASE_DETECTOR__N2.t3 PD.t2 VPWR.t8 sky130_fd_pr__pfet_01v8_hvt ad=0.1885 pd=1.88 as=0.1885 ps=1.88 w=0.65 l=0.15
X1 PD.t3 CTRL.t1 VGND.t52 sky130_fd_pr__res_xhigh_po_1p41 l=13.94
X2 CTRL.t0 R_TUNE_R0_N0.t0 VGND.t44 sky130_fd_pr__res_xhigh_po_1p41 l=29.21
X3 VGND.t59 TUNE.t3 OSCILLATOR__PBIAS.t0 VGND.t58 sky130_fd_pr__nfet_01v8 ad=1.45 pd=10.58 as=1.45 ps=10.58 w=5 l=0.5
X4 OSCILLATOR__P2.t0 OSCILLATOR__Q1.t2 OUT.t0 VPWR.t14 sky130_fd_pr__pfet_01v8_hvt ad=2.32 pd=16.58 as=2.32 ps=16.58 w=8 l=0.15
X5 CTRL.t2 VGND.t14 sky130_fd_pr__cap_mim_m3_1 l=28.68 w=28.68
X6 VPWR.t7 OSCILLATOR__PBIAS.t3 OSCILLATOR__P1.t0 VPWR.t6 sky130_fd_pr__pfet_01v8_hvt ad=2.9 pd=20.58 as=2.9 ps=20.58 w=10 l=0.5
X7 OSCILLATOR__Q1.t3 VGND.t38 sky130_fd_pr__cap_mim_m3_1 l=15.63 w=15.63
X8 R_TUNE_R0_N1.t0 R_TUNE_R0_N2.t0 VGND.t1 sky130_fd_pr__res_xhigh_po_1p41 l=29.21
X9 R_TUNE_R0_N10.t0 R_TUNE_R0_N11.t1 VGND.t32 sky130_fd_pr__res_xhigh_po_1p41 l=29.21
X10 R_TUNE_R0_N22.t1 TUNE.t1 VGND.t36 sky130_fd_pr__res_xhigh_po_1p41 l=29.21
X11 CTRL.t3 VGND.t13 sky130_fd_pr__cap_mim_m3_1 l=28.68 w=28.68
X12 R_TUNE_R0_N2.t1 R_TUNE_R0_N3.t0 VGND.t31 sky130_fd_pr__res_xhigh_po_1p41 l=29.21
X13 R_TUNE_R0_N9.t0 R_TUNE_R0_N10.t1 VGND.t35 sky130_fd_pr__res_xhigh_po_1p41 l=29.21
X14 R_TUNE_R0_N12.t1 R_TUNE_R0_N13.t1 VGND.t34 sky130_fd_pr__res_xhigh_po_1p41 l=29.21
X15 R_TUNE_R0_N21.t0 R_TUNE_R0_N22.t0 VGND.t0 sky130_fd_pr__res_xhigh_po_1p41 l=29.21
X16 R_TUNE_R0_N8.t1 R_TUNE_R0_N9.t1 VGND.t41 sky130_fd_pr__res_xhigh_po_1p41 l=29.21
X17 R_TUNE_R0_N11.t0 R_TUNE_R0_N12.t0 VGND.t29 sky130_fd_pr__res_xhigh_po_1p41 l=29.21
X18 OSCILLATOR__P1.t1 OSCILLATOR__Q0.t2 OSCILLATOR__Q1.t1 VPWR.t27 sky130_fd_pr__pfet_01v8_hvt ad=2.32 pd=16.58 as=2.32 ps=16.58 w=8 l=0.15
X19 R_TUNE_R0_N14.t1 R_TUNE_R0_N15.t0 VGND.t25 sky130_fd_pr__res_xhigh_po_1p41 l=29.21
X20 CTRL.t4 VGND.t12 sky130_fd_pr__cap_mim_m3_1 l=28.68 w=28.68
X21 PHASE_DETECTOR__N2__N1.t0 REF.t0 PHASE_DETECTOR__N2.t2 VGND.t57 sky130_fd_pr__nfet_01v8 ad=0.1885 pd=1.88 as=0.1885 ps=1.88 w=0.65 l=0.15
X22 VPWR.t23 PHASE_DETECTOR__N1.t3 PHASE_DETECTOR__N3.t2 VPWR.t22 sky130_fd_pr__pfet_01v8_hvt ad=0.1885 pd=1.88 as=0.1885 ps=1.88 w=0.65 l=0.15
X23 OUT.t2 VGND.t7 sky130_fd_pr__cap_mim_m3_1 l=15.63 w=15.63
X24 VPWR.t19 OUT.t3 PHASE_DETECTOR__N3.t0 VPWR.t18 sky130_fd_pr__pfet_01v8_hvt ad=0.1885 pd=1.88 as=0.1885 ps=1.88 w=0.65 l=0.15
X25 R_BIAS_TOP_R0_N0.t0 R_BIAS_TOP_R0_N1.t1 VGND.t24 sky130_fd_pr__res_xhigh_po_1p41 l=23.34
X26 VGND.t62 TUNE.t4 OSCILLATOR__N2.t1 VGND.t61 sky130_fd_pr__nfet_01v8 ad=1.45 pd=10.58 as=1.45 ps=10.58 w=5 l=0.5
X27 VPWR.t26 R_BIAS_TOP_R0_N0.t1 VGND.t56 sky130_fd_pr__res_xhigh_po_1p41 l=23.34
X28 VPWR.t11 OSCILLATOR__PBIAS.t4 OSCILLATOR__P0.t1 VPWR.t10 sky130_fd_pr__pfet_01v8_hvt ad=2.9 pd=20.58 as=2.9 ps=20.58 w=10 l=0.5
X29 VGND.t27 TUNE.t5 OSCILLATOR__N0.t1 VGND.t26 sky130_fd_pr__nfet_01v8 ad=1.45 pd=10.58 as=1.45 ps=10.58 w=5 l=0.5
X30 OSCILLATOR__N0.t0 OUT.t4 OSCILLATOR__Q0.t1 VGND.t2 sky130_fd_pr__nfet_01v8 ad=1.16 pd=8.58 as=1.16 ps=8.58 w=4 l=0.15
X31 VGND.t6 OUT.t5 PHASE_DETECTOR__N1__N1.t0 VGND.t5 sky130_fd_pr__nfet_01v8 ad=0.1885 pd=1.88 as=0.1885 ps=1.88 w=0.65 l=0.15
X32 CTRL.t5 VGND.t11 sky130_fd_pr__cap_mim_m3_1 l=28.68 w=28.68
X33 VPWR.t21 PHASE_DETECTOR__N1.t4 PHASE_DETECTOR__N2.t0 VPWR.t20 sky130_fd_pr__pfet_01v8_hvt ad=0.1885 pd=1.88 as=0.1885 ps=1.88 w=0.65 l=0.15
X34 PHASE_DETECTOR__N4__N1.t1 PHASE_DETECTOR__N2.t4 PD.t1 VGND.t33 sky130_fd_pr__nfet_01v8 ad=0.1885 pd=1.88 as=0.1885 ps=1.88 w=0.65 l=0.15
X35 VGND.t4 PHASE_DETECTOR__N3.t3 PHASE_DETECTOR__N4__N1.t0 VGND.t3 sky130_fd_pr__nfet_01v8 ad=0.1885 pd=1.88 as=0.1885 ps=1.88 w=0.65 l=0.15
X36 R_BIAS_BOTTOM_R0_N1.t1 VGND.t23 VGND.t22 sky130_fd_pr__res_xhigh_po_1p41 l=23.34
X37 VPWR.t17 OSCILLATOR__PBIAS.t5 OSCILLATOR__P2.t1 VPWR.t16 sky130_fd_pr__pfet_01v8_hvt ad=2.9 pd=20.58 as=2.9 ps=20.58 w=10 l=0.5
X38 CTRL.t6 VGND.t10 sky130_fd_pr__cap_mim_m3_1 l=28.68 w=28.68
X39 VPWR.t3 REF.t1 PHASE_DETECTOR__N1.t1 VPWR.t2 sky130_fd_pr__pfet_01v8_hvt ad=0.1885 pd=1.88 as=0.1885 ps=1.88 w=0.65 l=0.15
X40 R_TUNE_R0_N19.t0 R_TUNE_R0_N20.t0 VGND.t43 sky130_fd_pr__res_xhigh_po_1p41 l=29.21
X41 R_TUNE_R0_N18.t1 R_TUNE_R0_N19.t1 VGND.t51 sky130_fd_pr__res_xhigh_po_1p41 l=29.21
X42 R_TUNE_R0_N20.t1 R_TUNE_R0_N21.t1 VGND.t50 sky130_fd_pr__res_xhigh_po_1p41 l=29.21
X43 OSCILLATOR__N2.t0 OSCILLATOR__Q1.t4 OUT.t1 VGND.t37 sky130_fd_pr__nfet_01v8 ad=1.16 pd=8.58 as=1.16 ps=8.58 w=4 l=0.15
X44 R_BIAS_TOP_R0_N1.t0 TUNE.t0 VGND.t17 sky130_fd_pr__res_xhigh_po_1p41 l=23.34
X45 VGND.t19 TUNE.t6 OSCILLATOR__N1.t0 VGND.t18 sky130_fd_pr__nfet_01v8 ad=1.45 pd=10.58 as=1.45 ps=10.58 w=5 l=0.5
X46 OSCILLATOR__Q0.t3 VGND.t60 sky130_fd_pr__cap_mim_m3_1 l=15.63 w=15.63
X47 R_BIAS_BOTTOM_R0_N0.t0 R_BIAS_BOTTOM_R0_N1.t0 VGND.t21 sky130_fd_pr__res_xhigh_po_1p41 l=23.34
X48 OSCILLATOR__N1.t1 OSCILLATOR__Q0.t4 OSCILLATOR__Q1.t0 VGND.t8 sky130_fd_pr__nfet_01v8 ad=1.16 pd=8.58 as=1.16 ps=8.58 w=4 l=0.15
X49 TUNE.t2 R_BIAS_BOTTOM_R0_N0.t1 VGND.t40 sky130_fd_pr__res_xhigh_po_1p41 l=23.34
X50 OSCILLATOR__P0.t0 OUT.t6 OSCILLATOR__Q0.t0 VPWR.t15 sky130_fd_pr__pfet_01v8_hvt ad=2.32 pd=16.58 as=2.32 ps=16.58 w=8 l=0.15
X51 CTRL.t7 VGND.t9 sky130_fd_pr__cap_mim_m3_1 l=28.68 w=28.68
X52 R_TUNE_R0_N5.t1 R_TUNE_R0_N6.t1 VGND.t63 sky130_fd_pr__res_xhigh_po_1p41 l=29.21
X53 R_TUNE_R0_N17.t0 R_TUNE_R0_N18.t0 VGND.t15 sky130_fd_pr__res_xhigh_po_1p41 l=29.21
X54 PHASE_DETECTOR__N1__N1.t1 REF.t2 PHASE_DETECTOR__N1.t2 VGND.t30 sky130_fd_pr__nfet_01v8 ad=0.1885 pd=1.88 as=0.1885 ps=1.88 w=0.65 l=0.15
X55 VPWR.t25 REF.t3 PHASE_DETECTOR__N2.t1 VPWR.t24 sky130_fd_pr__pfet_01v8_hvt ad=0.1885 pd=1.88 as=0.1885 ps=1.88 w=0.65 l=0.15
X56 VGND.t49 PHASE_DETECTOR__N1.t5 PHASE_DETECTOR__N3__N1.t1 VGND.t48 sky130_fd_pr__nfet_01v8 ad=0.1885 pd=1.88 as=0.1885 ps=1.88 w=0.65 l=0.15
X57 VPWR.t5 PHASE_DETECTOR__N3.t4 PD.t0 VPWR.t4 sky130_fd_pr__pfet_01v8_hvt ad=0.1885 pd=1.88 as=0.1885 ps=1.88 w=0.65 l=0.15
X58 R_TUNE_R0_N4.t0 R_TUNE_R0_N5.t0 VGND.t28 sky130_fd_pr__res_xhigh_po_1p41 l=29.21
X59 R_TUNE_R0_N7.t0 R_TUNE_R0_N8.t0 VGND.t20 sky130_fd_pr__res_xhigh_po_1p41 l=29.21
X60 R_TUNE_R0_N16.t1 R_TUNE_R0_N17.t1 VGND.t53 sky130_fd_pr__res_xhigh_po_1p41 l=29.21
X61 PHASE_DETECTOR__N3__N1.t0 OUT.t7 PHASE_DETECTOR__N3.t1 VGND.t39 sky130_fd_pr__nfet_01v8 ad=0.1885 pd=1.88 as=0.1885 ps=1.88 w=0.65 l=0.15
X62 R_TUNE_R0_N3.t1 R_TUNE_R0_N4.t1 VGND.t45 sky130_fd_pr__res_xhigh_po_1p41 l=29.21
X63 R_TUNE_R0_N6.t0 R_TUNE_R0_N7.t1 VGND.t55 sky130_fd_pr__res_xhigh_po_1p41 l=29.21
X64 R_TUNE_R0_N13.t0 R_TUNE_R0_N14.t0 VGND.t16 sky130_fd_pr__res_xhigh_po_1p41 l=29.21
X65 R_TUNE_R0_N15.t1 R_TUNE_R0_N16.t0 VGND.t42 sky130_fd_pr__res_xhigh_po_1p41 l=29.21
X66 VPWR.t1 OUT.t8 PHASE_DETECTOR__N1.t0 VPWR.t0 sky130_fd_pr__pfet_01v8_hvt ad=0.1885 pd=1.88 as=0.1885 ps=1.88 w=0.65 l=0.15
X67 VGND.t47 PHASE_DETECTOR__N1.t6 PHASE_DETECTOR__N2__N1.t1 VGND.t46 sky130_fd_pr__nfet_01v8 ad=0.1885 pd=1.88 as=0.1885 ps=1.88 w=0.65 l=0.15
X68 R_TUNE_R0_N0.t1 R_TUNE_R0_N1.t1 VGND.t54 sky130_fd_pr__res_xhigh_po_1p41 l=29.21
X69 VPWR.t13 OSCILLATOR__PBIAS.t1 OSCILLATOR__PBIAS.t2 VPWR.t12 sky130_fd_pr__pfet_01v8_hvt ad=2.9 pd=20.58 as=2.9 ps=20.58 w=10 l=0.5
C0 PHASE_DETECTOR__N1__N1 VPWR 0.20313f
C1 PHASE_DETECTOR__N3 PHASE_DETECTOR__N4__N1 0.42478f
C2 OSCILLATOR__N0 VPWR 0
C3 PHASE_DETECTOR__N4__N1 CTRL 0.12812f
C4 OSCILLATOR__PBIAS OSCILLATOR__P0 0.31639f
C5 PHASE_DETECTOR__N2__N1 VPWR 0.19249f
C6 PHASE_DETECTOR__N1__N1 REF 2.0798f
C7 PD PHASE_DETECTOR__N4__N1 0.5979f
C8 OSCILLATOR__Q1 VPWR 3.18725f
C9 PHASE_DETECTOR__N1 PHASE_DETECTOR__N1__N1 1.06387f
C10 OSCILLATOR__P0 OSCILLATOR__Q0 1.63797f
C11 OSCILLATOR__PBIAS OSCILLATOR__N0 0.12792f
C12 TUNE OSCILLATOR__P0 0.36517f
C13 PHASE_DETECTOR__N3__N1 VPWR 0.2132f
C14 OSCILLATOR__P0 OUT 2.59487f
C15 PHASE_DETECTOR__N2__N1 REF 2.00118f
C16 OSCILLATOR__P2 VPWR 5.48858f
C17 PHASE_DETECTOR__N1__N1 OUT 0.44906f
C18 PHASE_DETECTOR__N1__N1 PHASE_DETECTOR__N2 0.00538f
C19 PHASE_DETECTOR__N1 PHASE_DETECTOR__N2__N1 0.46416f
C20 OSCILLATOR__Q0 OSCILLATOR__N0 0.99096f
C21 OSCILLATOR__PBIAS OSCILLATOR__Q1 0.44067f
C22 TUNE OSCILLATOR__N0 0.25122f
C23 OSCILLATOR__N0 OUT 2.71535f
C24 PHASE_DETECTOR__N2__N1 OUT 0.13935f
C25 PHASE_DETECTOR__N2 PHASE_DETECTOR__N2__N1 1.07693f
C26 PHASE_DETECTOR__N1 PHASE_DETECTOR__N3__N1 0.46448f
C27 OSCILLATOR__PBIAS OSCILLATOR__P2 0.25871f
C28 OSCILLATOR__Q0 OSCILLATOR__Q1 1.21006f
C29 PHASE_DETECTOR__N1__N1 CTRL 0.13935f
C30 TUNE OSCILLATOR__Q1 0.41749f
C31 OSCILLATOR__Q1 OUT 1.53272f
C32 PHASE_DETECTOR__N3__N1 OUT 2.27641f
C33 PHASE_DETECTOR__N2 PHASE_DETECTOR__N3__N1 0.90074f
C34 PHASE_DETECTOR__N2__N1 PHASE_DETECTOR__N3 0
C35 OSCILLATOR__P1 OSCILLATOR__Q1 1.43642f
C36 PHASE_DETECTOR__N2__N1 CTRL 0.14823f
C37 TUNE OSCILLATOR__P2 0.15211f
C38 OSCILLATOR__P2 OUT 2.13921f
C39 PHASE_DETECTOR__N3 PHASE_DETECTOR__N3__N1 0.26695f
C40 OSCILLATOR__Q1 OSCILLATOR__N1 0.78277f
C41 PHASE_DETECTOR__N3__N1 CTRL 0.12786f
C42 VPWR REF 5.0467f
C43 OSCILLATOR__PBIAS VPWR 11.6782f
C44 PHASE_DETECTOR__N1 VPWR 8.86183f
C45 OSCILLATOR__Q1 OSCILLATOR__N2 2.19295f
C46 OSCILLATOR__Q0 VPWR 3.08148f
C47 TUNE VPWR 0.85695f
C48 VPWR OUT 9.55304f
C49 PHASE_DETECTOR__N2 VPWR 6.33258f
C50 OSCILLATOR__P2 OSCILLATOR__N2 0
C51 PHASE_DETECTOR__N1 REF 0.79609f
C52 OSCILLATOR__P1 VPWR 5.46611f
C53 OSCILLATOR__PBIAS OSCILLATOR__Q0 0.56753f
C54 PHASE_DETECTOR__N3 VPWR 5.26867f
C55 TUNE OSCILLATOR__PBIAS 8.26541f
C56 VPWR CTRL 1.12624f
C57 REF OUT 0.15634f
C58 OSCILLATOR__PBIAS OUT 7.8403f
C59 PHASE_DETECTOR__N2 REF 0.71432f
C60 OSCILLATOR__N1 VPWR 0
C61 PHASE_DETECTOR__N1 OUT 5.52341f
C62 PHASE_DETECTOR__N1 PHASE_DETECTOR__N2 3.52305f
C63 OSCILLATOR__P0 OSCILLATOR__N0 0.00546f
C64 OSCILLATOR__PBIAS OSCILLATOR__P1 0.31693f
C65 TUNE OSCILLATOR__Q0 0.41202f
C66 PD VPWR 2.97956f
C67 OSCILLATOR__Q0 OUT 2.05057f
C68 TUNE OUT 2.31696f
C69 REF CTRL 2.50651f
C70 OSCILLATOR__N2 VPWR 0
C71 PHASE_DETECTOR__N2 OUT 0.72544f
C72 PHASE_DETECTOR__N1 PHASE_DETECTOR__N3 0.42336f
C73 OSCILLATOR__PBIAS OSCILLATOR__N1 0.12792f
C74 OSCILLATOR__Q0 OSCILLATOR__P1 2.58859f
C75 PHASE_DETECTOR__N1 CTRL 0.47888f
C76 TUNE OSCILLATOR__P1 0.14659f
C77 OSCILLATOR__P1 OUT 0.76475f
C78 PHASE_DETECTOR__N4__N1 VPWR 0.24266f
C79 TUNE CTRL 1.94336f
C80 PHASE_DETECTOR__N3 OUT 0.70367f
C81 OUT CTRL 24.024f
C82 PHASE_DETECTOR__N1 PD 0.30738f
C83 PHASE_DETECTOR__N2 PHASE_DETECTOR__N3 0.14988f
C84 OSCILLATOR__Q0 OSCILLATOR__N1 2.51553f
C85 PHASE_DETECTOR__N2 CTRL 0.3448f
C86 TUNE OSCILLATOR__N1 0.25122f
C87 OSCILLATOR__N1 OUT 0.46107f
C88 PD OUT 2.0854f
C89 PHASE_DETECTOR__N2 PD 1.44029f
C90 OSCILLATOR__P1 OSCILLATOR__N1 0.00546f
C91 PHASE_DETECTOR__N3 CTRL 3.28389f
C92 TUNE OSCILLATOR__N2 0.58437f
C93 OSCILLATOR__N2 OUT 0.99096f
C94 PHASE_DETECTOR__N3 PD 0.39828f
C95 OSCILLATOR__Q1 OSCILLATOR__P2 2.26705f
C96 PHASE_DETECTOR__N4__N1 OUT 0.12812f
C97 PD CTRL 0.34957f
C98 PHASE_DETECTOR__N2 PHASE_DETECTOR__N4__N1 2.4999f
C99 OSCILLATOR__P0 VPWR 5.48046f
C100 CTRL VGND 0.49142p
C101 OUT VGND 88.731f
C102 REF VGND 8.12317f
C103 VPWR VGND 0.14092p
C104 OSCILLATOR__N2 VGND 5.25848f $ **FLOATING
C105 OSCILLATOR__P2 VGND 2.77279f $ **FLOATING
C106 OSCILLATOR__N1 VGND 5.61361f $ **FLOATING
C107 OSCILLATOR__Q1 VGND 41.17083f $ **FLOATING
C108 OSCILLATOR__P1 VGND 2.68786f $ **FLOATING
C109 OSCILLATOR__N0 VGND 5.62014f $ **FLOATING
C110 OSCILLATOR__Q0 VGND 39.59866f $ **FLOATING
C111 OSCILLATOR__P0 VGND 2.57673f $ **FLOATING
C112 OSCILLATOR__PBIAS VGND 13.00898f $ **FLOATING
C113 TUNE VGND 43.59953f $ **FLOATING
C114 PHASE_DETECTOR__N4__N1 VGND 5.43651f $ **FLOATING
C115 PD VGND 7.67287f $ **FLOATING
C116 PHASE_DETECTOR__N3__N1 VGND 5.41801f $ **FLOATING
C117 PHASE_DETECTOR__N3 VGND 10.98514f $ **FLOATING
C118 PHASE_DETECTOR__N2__N1 VGND 5.4625f $ **FLOATING
C119 PHASE_DETECTOR__N2 VGND 10.48279f $ **FLOATING
C120 PHASE_DETECTOR__N1__N1 VGND 4.96011f $ **FLOATING
C121 PHASE_DETECTOR__N1 VGND 17.36937f $ **FLOATING
C122 PHASE_DETECTOR__N3__N1.n0 VGND 0.00561f $ **FLOATING
C123 PHASE_DETECTOR__N3__N1.n1 VGND 0.00561f $ **FLOATING
C124 PHASE_DETECTOR__N3__N1.t1 VGND 0.01363f $ **FLOATING
C125 PHASE_DETECTOR__N3__N1.n2 VGND 0.00561f $ **FLOATING
C126 PHASE_DETECTOR__N3__N1.n3 VGND 1.12254f $ **FLOATING
C127 PHASE_DETECTOR__N3__N1.n4 VGND 1.12254f $ **FLOATING
C128 PHASE_DETECTOR__N3__N1.t0 VGND 0.01363f $ **FLOATING
C129 PHASE_DETECTOR__N3__N1.n5 VGND 0.00561f $ **FLOATING
C130 OSCILLATOR__N1.n0 VGND 0.01832f $ **FLOATING
C131 OSCILLATOR__N1.n1 VGND 0.01263f $ **FLOATING
C132 OSCILLATOR__N1.t1 VGND 0.02776f $ **FLOATING
C133 OSCILLATOR__N1.n2 VGND 0.08686f $ **FLOATING
C134 OSCILLATOR__N1.n3 VGND 0.00391f $ **FLOATING
C135 OSCILLATOR__N1.n4 VGND 1.07575f $ **FLOATING
C136 OSCILLATOR__N1.n5 VGND 1.22177f $ **FLOATING
C137 OSCILLATOR__N1.t0 VGND 0.02237f $ **FLOATING
C138 OSCILLATOR__N1.n6 VGND 0.01832f $ **FLOATING
C139 PHASE_DETECTOR__N4__N1.n0 VGND 0.00609f $ **FLOATING
C140 PHASE_DETECTOR__N4__N1.n1 VGND 0.00609f $ **FLOATING
C141 PHASE_DETECTOR__N4__N1.t1 VGND 0.01481f $ **FLOATING
C142 PHASE_DETECTOR__N4__N1.n2 VGND 0.00609f $ **FLOATING
C143 PHASE_DETECTOR__N4__N1.n3 VGND 1.22015f $ **FLOATING
C144 PHASE_DETECTOR__N4__N1.n4 VGND 1.22015f $ **FLOATING
C145 PHASE_DETECTOR__N4__N1.t0 VGND 0.01481f $ **FLOATING
C146 PHASE_DETECTOR__N4__N1.n5 VGND 0.00609f $ **FLOATING
C147 PHASE_DETECTOR__N1__N1.n0 VGND 0.0053f $ **FLOATING
C148 PHASE_DETECTOR__N1__N1.n1 VGND 0.0053f $ **FLOATING
C149 PHASE_DETECTOR__N1__N1.t1 VGND 0.01288f $ **FLOATING
C150 PHASE_DETECTOR__N1__N1.n2 VGND 0.0053f $ **FLOATING
C151 PHASE_DETECTOR__N1__N1.n3 VGND 1.02404f $ **FLOATING
C152 PHASE_DETECTOR__N1__N1.n4 VGND 1.02404f $ **FLOATING
C153 PHASE_DETECTOR__N1__N1.t0 VGND 0.01288f $ **FLOATING
C154 PHASE_DETECTOR__N1__N1.n5 VGND 0.0053f $ **FLOATING
C155 OSCILLATOR__N0.n0 VGND 0.01298f $ **FLOATING
C156 OSCILLATOR__N0.n1 VGND 0.01979f $ **FLOATING
C157 OSCILLATOR__N0.t1 VGND 0.02416f $ **FLOATING
C158 OSCILLATOR__N0.n2 VGND 0.01979f $ **FLOATING
C159 OSCILLATOR__N0.n3 VGND 1.31951f $ **FLOATING
C160 OSCILLATOR__N0.n4 VGND 1.16181f $ **FLOATING
C161 OSCILLATOR__N0.t0 VGND 0.02998f $ **FLOATING
C162 OSCILLATOR__N0.n5 VGND 0.09381f $ **FLOATING
C163 OSCILLATOR__N0.n6 VGND 0.00488f $ **FLOATING
C164 OSCILLATOR__P0.n0 VGND 0.08819f $ **FLOATING
C165 OSCILLATOR__P0.t0 VGND 0.13699f $ **FLOATING
C166 OSCILLATOR__P0.n1 VGND 0.4246f $ **FLOATING
C167 OSCILLATOR__P0.n2 VGND 0.10922f $ **FLOATING
C168 OSCILLATOR__P0.t1 VGND 0.17124f $ **FLOATING
C169 OSCILLATOR__P0.n3 VGND 0.53823f $ **FLOATING
C170 OSCILLATOR__P0.n4 VGND 0.03757f $ **FLOATING
C171 OSCILLATOR__P0.n5 VGND 3.34151f $ **FLOATING
C172 OSCILLATOR__P0.n6 VGND 3.18846f $ **FLOATING
C173 OSCILLATOR__P0.n7 VGND 0.02631f $ **FLOATING
C174 OSCILLATOR__N2.n0 VGND 0.01133f $ **FLOATING
C175 OSCILLATOR__N2.n1 VGND 0.01727f $ **FLOATING
C176 OSCILLATOR__N2.t1 VGND 0.02108f $ **FLOATING
C177 OSCILLATOR__N2.n2 VGND 0.01727f $ **FLOATING
C178 OSCILLATOR__N2.n3 VGND 1.07326f $ **FLOATING
C179 OSCILLATOR__N2.n4 VGND 0.93593f $ **FLOATING
C180 OSCILLATOR__N2.t0 VGND 0.02616f $ **FLOATING
C181 OSCILLATOR__N2.n5 VGND 0.08186f $ **FLOATING
C182 OSCILLATOR__N2.n6 VGND 0.00425f $ **FLOATING
C183 PHASE_DETECTOR__N3.n0 VGND 0.00757f $ **FLOATING
C184 PHASE_DETECTOR__N3.t3 VGND 0.03127f $ **FLOATING
C185 PHASE_DETECTOR__N3.t4 VGND 0.0325f $ **FLOATING
C186 PHASE_DETECTOR__N3.n1 VGND 2.95084f $ **FLOATING
C187 PHASE_DETECTOR__N3.n2 VGND 0.00757f $ **FLOATING
C188 PHASE_DETECTOR__N3.t2 VGND 0.02318f $ **FLOATING
C189 PHASE_DETECTOR__N3.n3 VGND 0.00757f $ **FLOATING
C190 PHASE_DETECTOR__N3.n4 VGND 0.50739f $ **FLOATING
C191 PHASE_DETECTOR__N3.n5 VGND 1.65497f $ **FLOATING
C192 PHASE_DETECTOR__N3.n6 VGND 0.00865f $ **FLOATING
C193 PHASE_DETECTOR__N3.t1 VGND 0.02102f $ **FLOATING
C194 PHASE_DETECTOR__N3.n7 VGND 0.00865f $ **FLOATING
C195 PHASE_DETECTOR__N3.n8 VGND 0.50739f $ **FLOATING
C196 PHASE_DETECTOR__N3.n9 VGND 1.72969f $ **FLOATING
C197 PHASE_DETECTOR__N3.n10 VGND 0.54677f $ **FLOATING
C198 PHASE_DETECTOR__N3.t0 VGND 0.02318f $ **FLOATING
C199 PHASE_DETECTOR__N3.n11 VGND 0.00757f $ **FLOATING
C200 PHASE_DETECTOR__N1.n0 VGND 0.00989f $ **FLOATING
C201 PHASE_DETECTOR__N1.t5 VGND 0.04087f $ **FLOATING
C202 PHASE_DETECTOR__N1.t3 VGND 0.04247f $ **FLOATING
C203 PHASE_DETECTOR__N1.n1 VGND 3.83133f $ **FLOATING
C204 PHASE_DETECTOR__N1.t6 VGND 0.04087f $ **FLOATING
C205 PHASE_DETECTOR__N1.n2 VGND 2.31386f $ **FLOATING
C206 PHASE_DETECTOR__N1.t4 VGND 0.04247f $ **FLOATING
C207 PHASE_DETECTOR__N1.n3 VGND 2.68044f $ **FLOATING
C208 PHASE_DETECTOR__N1.n4 VGND 0.00989f $ **FLOATING
C209 PHASE_DETECTOR__N1.t1 VGND 0.03029f $ **FLOATING
C210 PHASE_DETECTOR__N1.n5 VGND 0.00989f $ **FLOATING
C211 PHASE_DETECTOR__N1.n6 VGND 0.82859f $ **FLOATING
C212 PHASE_DETECTOR__N1.n7 VGND 0.0113f $ **FLOATING
C213 PHASE_DETECTOR__N1.t2 VGND 0.02748f $ **FLOATING
C214 PHASE_DETECTOR__N1.n8 VGND 0.0113f $ **FLOATING
C215 PHASE_DETECTOR__N1.n9 VGND 0.77497f $ **FLOATING
C216 PHASE_DETECTOR__N1.n10 VGND 2.50904f $ **FLOATING
C217 PHASE_DETECTOR__N1.n11 VGND 2.28823f $ **FLOATING
C218 PHASE_DETECTOR__N1.n12 VGND 0.77497f $ **FLOATING
C219 PHASE_DETECTOR__N1.t0 VGND 0.03029f $ **FLOATING
C220 PHASE_DETECTOR__N1.n13 VGND 0.00989f $ **FLOATING
C221 PHASE_DETECTOR__N2__N1.n0 VGND 0.00487f $ **FLOATING
C222 PHASE_DETECTOR__N2__N1.n1 VGND 0.00487f $ **FLOATING
C223 PHASE_DETECTOR__N2__N1.t1 VGND 0.01185f $ **FLOATING
C224 PHASE_DETECTOR__N2__N1.n2 VGND 0.00487f $ **FLOATING
C225 PHASE_DETECTOR__N2__N1.n3 VGND 0.97612f $ **FLOATING
C226 PHASE_DETECTOR__N2__N1.n4 VGND 0.97612f $ **FLOATING
C227 PHASE_DETECTOR__N2__N1.t0 VGND 0.01185f $ **FLOATING
C228 PHASE_DETECTOR__N2__N1.n5 VGND 0.00487f $ **FLOATING
C229 REF.t1 VGND 0.05584f $ **FLOATING
C230 REF.n0 VGND 2.03002f $ **FLOATING
C231 REF.t2 VGND 0.05373f $ **FLOATING
C232 REF.n1 VGND 2.81453f $ **FLOATING
C233 REF.t3 VGND 0.05584f $ **FLOATING
C234 REF.n2 VGND 4.58557f $ **FLOATING
C235 REF.t0 VGND 0.05373f $ **FLOATING
C236 OSCILLATOR__Q0.n0 VGND 0.00691f $ **FLOATING
C237 OSCILLATOR__Q0.t0 VGND 0.01073f $ **FLOATING
C238 OSCILLATOR__Q0.n1 VGND 0.03326f $ **FLOATING
C239 OSCILLATOR__Q0.t4 VGND 0.01074f $ **FLOATING
C240 OSCILLATOR__Q0.t2 VGND 0.01916f $ **FLOATING
C241 OSCILLATOR__Q0.n2 VGND 0.38648f $ **FLOATING
C242 OSCILLATOR__Q0.t3 VGND 4.5204f $ **FLOATING
C243 OSCILLATOR__Q0.n3 VGND 0.2115f $ **FLOATING
C244 OSCILLATOR__Q0.n4 VGND 0.00244f $ **FLOATING
C245 OSCILLATOR__Q0.t1 VGND 0.00537f $ **FLOATING
C246 OSCILLATOR__Q0.n5 VGND 0.01679f $ **FLOATING
C247 OSCILLATOR__Q0.n6 VGND 0 $ **FLOATING
C248 OSCILLATOR__Q0.n7 VGND 0.10364f $ **FLOATING
C249 OSCILLATOR__Q0.n8 VGND 0.31927f $ **FLOATING
C250 OSCILLATOR__Q0.n9 VGND 0.13283f $ **FLOATING
C251 OSCILLATOR__Q0.n10 VGND 0.00206f $ **FLOATING
C252 OSCILLATOR__P1.n0 VGND 0.11136f $ **FLOATING
C253 OSCILLATOR__P1.n1 VGND 0.02631f $ **FLOATING
C254 OSCILLATOR__P1.t1 VGND 0.13699f $ **FLOATING
C255 OSCILLATOR__P1.n2 VGND 0.4246f $ **FLOATING
C256 OSCILLATOR__P1.n3 VGND 0.08819f $ **FLOATING
C257 OSCILLATOR__P1.n4 VGND 3.18846f $ **FLOATING
C258 OSCILLATOR__P1.n5 VGND 3.34151f $ **FLOATING
C259 OSCILLATOR__P1.t0 VGND 0.17124f $ **FLOATING
C260 OSCILLATOR__P1.n6 VGND 0.53823f $ **FLOATING
C261 OSCILLATOR__P1.n7 VGND 0.03543f $ **FLOATING
C262 OSCILLATOR__P2.n0 VGND 0.10779f $ **FLOATING
C263 OSCILLATOR__P2.t0 VGND 0.16744f $ **FLOATING
C264 OSCILLATOR__P2.n1 VGND 0.51896f $ **FLOATING
C265 OSCILLATOR__P2.n2 VGND 0.13349f $ **FLOATING
C266 OSCILLATOR__P2.t1 VGND 0.20929f $ **FLOATING
C267 OSCILLATOR__P2.n3 VGND 0.65784f $ **FLOATING
C268 OSCILLATOR__P2.n4 VGND 0.04592f $ **FLOATING
C269 OSCILLATOR__P2.n5 VGND 4.08407f $ **FLOATING
C270 OSCILLATOR__P2.n6 VGND 3.89701f $ **FLOATING
C271 OSCILLATOR__P2.n7 VGND 0.03216f $ **FLOATING
C272 OUT.t8 VGND 0.01713f $ **FLOATING
C273 OUT.n0 VGND 0.87812f $ **FLOATING
C274 OUT.t5 VGND 0.01649f $ **FLOATING
C275 OUT.n1 VGND 1.11881f $ **FLOATING
C276 OUT.t3 VGND 0.01713f $ **FLOATING
C277 OUT.n2 VGND 1.11794f $ **FLOATING
C278 OUT.t7 VGND 0.01649f $ **FLOATING
C279 OUT.n3 VGND 8.44836f $ **FLOATING
C280 OUT.t6 VGND 0.07644f $ **FLOATING
C281 OUT.n4 VGND 8.37561f $ **FLOATING
C282 OUT.t4 VGND 0.04285f $ **FLOATING
C283 OUT.n5 VGND 1.93487f $ **FLOATING
C284 OUT.n6 VGND 0.00822f $ **FLOATING
C285 OUT.t0 VGND 0.04282f $ **FLOATING
C286 OUT.n7 VGND 0.13272f $ **FLOATING
C287 OUT.n8 VGND 0.02757f $ **FLOATING
C288 OUT.n9 VGND 0.47789f $ **FLOATING
C289 OUT.n10 VGND 1.8146f $ **FLOATING
C290 OUT.n11 VGND 0.00927f $ **FLOATING
C291 OUT.t1 VGND 0.02141f $ **FLOATING
C292 OUT.n12 VGND 0.06701f $ **FLOATING
C293 OUT.n13 VGND 0.00348f $ **FLOATING
C294 OUT.n14 VGND 0.38331f $ **FLOATING
C295 OUT.n15 VGND 1.07764f $ **FLOATING
C296 OUT.t2 VGND 18.0365f $ **FLOATING
C297 OSCILLATOR__Q1.n0 VGND 0.00173f $ **FLOATING
C298 OSCILLATOR__Q1.t4 VGND 0.00799f $ **FLOATING
C299 OSCILLATOR__Q1.t2 VGND 0.01426f $ **FLOATING
C300 OSCILLATOR__Q1.n1 VGND 0.29629f $ **FLOATING
C301 OSCILLATOR__Q1.t3 VGND 3.36525f $ **FLOATING
C302 OSCILLATOR__Q1.n2 VGND 0.15973f $ **FLOATING
C303 OSCILLATOR__Q1.n3 VGND 0.00153f $ **FLOATING
C304 OSCILLATOR__Q1.t1 VGND 0.00799f $ **FLOATING
C305 OSCILLATOR__Q1.n4 VGND 0.02476f $ **FLOATING
C306 OSCILLATOR__Q1.n5 VGND 0.00514f $ **FLOATING
C307 OSCILLATOR__Q1.n6 VGND 0.10176f $ **FLOATING
C308 OSCILLATOR__Q1.n7 VGND 0.24388f $ **FLOATING
C309 OSCILLATOR__Q1.n8 VGND 0.07999f $ **FLOATING
C310 OSCILLATOR__Q1.t0 VGND 0.00399f $ **FLOATING
C311 OSCILLATOR__Q1.n9 VGND 0.0125f $ **FLOATING
C312 OSCILLATOR__Q1.n10 VGND 0 $ **FLOATING
C313 OSCILLATOR__PBIAS.n0 VGND 0.04341f $ **FLOATING
C314 OSCILLATOR__PBIAS.t5 VGND 0.9774f $ **FLOATING
C315 OSCILLATOR__PBIAS.t3 VGND 0.9774f $ **FLOATING
C316 OSCILLATOR__PBIAS.n1 VGND 8.77376f $ **FLOATING
C317 OSCILLATOR__PBIAS.t4 VGND 0.9774f $ **FLOATING
C318 OSCILLATOR__PBIAS.n2 VGND 3.96515f $ **FLOATING
C319 OSCILLATOR__PBIAS.n3 VGND 0.03401f $ **FLOATING
C320 OSCILLATOR__PBIAS.t2 VGND 0.1644f $ **FLOATING
C321 OSCILLATOR__PBIAS.n4 VGND 0.51672f $ **FLOATING
C322 OSCILLATOR__PBIAS.n5 VGND 0.10691f $ **FLOATING
C323 OSCILLATOR__PBIAS.n6 VGND 1.58256f $ **FLOATING
C324 OSCILLATOR__PBIAS.t1 VGND 0.9774f $ **FLOATING
C325 OSCILLATOR__PBIAS.n7 VGND 2.61475f $ **FLOATING
C326 OSCILLATOR__PBIAS.n8 VGND 1.66033f $ **FLOATING
C327 OSCILLATOR__PBIAS.n9 VGND 1.4667f $ **FLOATING
C328 OSCILLATOR__PBIAS.t0 VGND 0.053f $ **FLOATING
C329 OSCILLATOR__PBIAS.n10 VGND 0.04341f $ **FLOATING
C330 TUNE.t0 VGND 0.64109f $ **FLOATING
C331 TUNE.t2 VGND 0.24595f $ **FLOATING
C332 TUNE.n0 VGND 2.51623f $ **FLOATING
C333 TUNE.t1 VGND 0.46108f $ **FLOATING
C334 TUNE.n1 VGND 2.51857f $ **FLOATING
C335 TUNE.t3 VGND 0.10433f $ **FLOATING
C336 TUNE.n2 VGND 0.6371f $ **FLOATING
C337 TUNE.t5 VGND 0.10433f $ **FLOATING
C338 TUNE.n3 VGND 0.95097f $ **FLOATING
C339 TUNE.t6 VGND 0.10433f $ **FLOATING
C340 TUNE.n4 VGND 1.74124f $ **FLOATING
C341 TUNE.t4 VGND 0.10433f $ **FLOATING
C342 CTRL.t0 VGND 0.03231f $ **FLOATING
C343 CTRL.t1 VGND 0.02803f $ **FLOATING
C344 CTRL.n0 VGND 0.11431f $ **FLOATING
C345 CTRL.t6 VGND 2.46439f $ **FLOATING
C346 CTRL.n1 VGND 0.0381f $ **FLOATING
C347 CTRL.t2 VGND 2.46439f $ **FLOATING
C348 CTRL.n2 VGND 0.04749f $ **FLOATING
C349 CTRL.t7 VGND 2.46439f $ **FLOATING
C350 CTRL.n3 VGND 0.04749f $ **FLOATING
C351 CTRL.t4 VGND 2.46439f $ **FLOATING
C352 CTRL.n4 VGND 0.04749f $ **FLOATING
C353 CTRL.t5 VGND 2.46439f $ **FLOATING
C354 CTRL.n5 VGND 0.04749f $ **FLOATING
C355 CTRL.n6 VGND 0.1095f $ **FLOATING
C356 CTRL.t3 VGND 2.46439f $ **FLOATING
C357 VPWR.n0 VGND 0.00887f $ **FLOATING
C358 VPWR.n1 VGND 0.0101f $ **FLOATING
C359 VPWR.n2 VGND 0.00998f $ **FLOATING
C360 VPWR.n3 VGND 0.0101f $ **FLOATING
C361 VPWR.t14 VGND 0.13287f $ **FLOATING
C362 VPWR.n4 VGND 0.4494f $ **FLOATING
C363 VPWR.n5 VGND 0.00998f $ **FLOATING
C364 VPWR.n6 VGND 0.0101f $ **FLOATING
C365 VPWR.n7 VGND 0.00443f $ **FLOATING
C366 VPWR.n8 VGND 0.00443f $ **FLOATING
C367 VPWR.n20 VGND 0.00443f $ **FLOATING
C368 VPWR.n21 VGND 0.00443f $ **FLOATING
C369 VPWR.n22 VGND 0.00443f $ **FLOATING
C370 VPWR.n23 VGND 0.00443f $ **FLOATING
C371 VPWR.n24 VGND 0.00443f $ **FLOATING
C372 VPWR.n25 VGND 0.00443f $ **FLOATING
C373 VPWR.n26 VGND 0.00443f $ **FLOATING
C374 VPWR.n27 VGND 0.00443f $ **FLOATING
C375 VPWR.n28 VGND 0.00443f $ **FLOATING
C376 VPWR.n29 VGND 0.00443f $ **FLOATING
C377 VPWR.n30 VGND 0.00443f $ **FLOATING
C378 VPWR.n31 VGND 0.00443f $ **FLOATING
C379 VPWR.n32 VGND 0.00443f $ **FLOATING
C380 VPWR.n33 VGND 0.00443f $ **FLOATING
C381 VPWR.n34 VGND 0.00443f $ **FLOATING
C382 VPWR.n35 VGND 0.00443f $ **FLOATING
C383 VPWR.n36 VGND 0.00443f $ **FLOATING
C384 VPWR.n37 VGND 0.00443f $ **FLOATING
C385 VPWR.n38 VGND 0.00443f $ **FLOATING
C386 VPWR.n39 VGND 0.00443f $ **FLOATING
C387 VPWR.n40 VGND 0.00443f $ **FLOATING
C388 VPWR.n41 VGND 0.00443f $ **FLOATING
C389 VPWR.n42 VGND 0.00443f $ **FLOATING
C390 VPWR.n43 VGND 0.00443f $ **FLOATING
C391 VPWR.n44 VGND 0.00443f $ **FLOATING
C392 VPWR.n45 VGND 0.00443f $ **FLOATING
C393 VPWR.n46 VGND 0.00443f $ **FLOATING
C394 VPWR.n47 VGND 0.00443f $ **FLOATING
C395 VPWR.n48 VGND 0.00443f $ **FLOATING
C396 VPWR.n49 VGND 0.00443f $ **FLOATING
C397 VPWR.n50 VGND 0.00443f $ **FLOATING
C398 VPWR.n51 VGND 0.00443f $ **FLOATING
C399 VPWR.n52 VGND 0.00443f $ **FLOATING
C400 VPWR.n53 VGND 0.00443f $ **FLOATING
C401 VPWR.n54 VGND 0.00443f $ **FLOATING
C402 VPWR.n55 VGND 0.00443f $ **FLOATING
C403 VPWR.n56 VGND 0.00443f $ **FLOATING
C404 VPWR.n57 VGND 0.00443f $ **FLOATING
C405 VPWR.n58 VGND 0.00443f $ **FLOATING
C406 VPWR.n59 VGND 0.00443f $ **FLOATING
C407 VPWR.n60 VGND 0.00443f $ **FLOATING
C408 VPWR.n61 VGND 0.00443f $ **FLOATING
C409 VPWR.n62 VGND 0.00443f $ **FLOATING
C410 VPWR.n63 VGND 0.00443f $ **FLOATING
C411 VPWR.n64 VGND 0.00443f $ **FLOATING
C412 VPWR.n65 VGND 0.00443f $ **FLOATING
C413 VPWR.n66 VGND 0.0101f $ **FLOATING
C414 VPWR.n67 VGND 0.0101f $ **FLOATING
C415 VPWR.n69 VGND 0.30872f $ **FLOATING
C416 VPWR.n70 VGND 0.4494f $ **FLOATING
C417 VPWR.n72 VGND 0.0101f $ **FLOATING
C418 VPWR.n73 VGND 0.0101f $ **FLOATING
C419 VPWR.n74 VGND 0.00998f $ **FLOATING
C420 VPWR.n75 VGND 0.00443f $ **FLOATING
C421 VPWR.n77 VGND 0.00443f $ **FLOATING
C422 VPWR.n78 VGND 0.00443f $ **FLOATING
C423 VPWR.n79 VGND 0.00443f $ **FLOATING
C424 VPWR.n80 VGND 0.00443f $ **FLOATING
C425 VPWR.n81 VGND 0.00443f $ **FLOATING
C426 VPWR.n82 VGND 0.00443f $ **FLOATING
C427 VPWR.n83 VGND 0.00443f $ **FLOATING
C428 VPWR.n84 VGND 0.00443f $ **FLOATING
C429 VPWR.n85 VGND 0.00443f $ **FLOATING
C430 VPWR.n86 VGND 0.00443f $ **FLOATING
C431 VPWR.n88 VGND 0.00443f $ **FLOATING
C432 VPWR.n89 VGND 0.00443f $ **FLOATING
C433 VPWR.n90 VGND 0.00443f $ **FLOATING
C434 VPWR.n91 VGND 0.00443f $ **FLOATING
C435 VPWR.n92 VGND 0.00443f $ **FLOATING
C436 VPWR.n94 VGND 0.00443f $ **FLOATING
C437 VPWR.n96 VGND 0.00443f $ **FLOATING
C438 VPWR.n97 VGND 0.00443f $ **FLOATING
C439 VPWR.n98 VGND 0.00443f $ **FLOATING
C440 VPWR.n99 VGND 0.00443f $ **FLOATING
C441 VPWR.n100 VGND 0.00443f $ **FLOATING
C442 VPWR.n102 VGND 0.00443f $ **FLOATING
C443 VPWR.n104 VGND 0.00443f $ **FLOATING
C444 VPWR.n105 VGND 0.00443f $ **FLOATING
C445 VPWR.n106 VGND 0.00443f $ **FLOATING
C446 VPWR.n107 VGND 0.00443f $ **FLOATING
C447 VPWR.n108 VGND 0.00443f $ **FLOATING
C448 VPWR.n110 VGND 0.00443f $ **FLOATING
C449 VPWR.n112 VGND 0.00443f $ **FLOATING
C450 VPWR.n113 VGND 0.00443f $ **FLOATING
C451 VPWR.n114 VGND 0.00443f $ **FLOATING
C452 VPWR.n115 VGND 0.00443f $ **FLOATING
C453 VPWR.n116 VGND 0.00443f $ **FLOATING
C454 VPWR.n118 VGND 0.00443f $ **FLOATING
C455 VPWR.n120 VGND 0.00443f $ **FLOATING
C456 VPWR.n121 VGND 0.00443f $ **FLOATING
C457 VPWR.n122 VGND 0.00443f $ **FLOATING
C458 VPWR.n123 VGND 0.00443f $ **FLOATING
C459 VPWR.n124 VGND 0.00443f $ **FLOATING
C460 VPWR.n126 VGND 0.00443f $ **FLOATING
C461 VPWR.n127 VGND 0.00443f $ **FLOATING
C462 VPWR.n128 VGND 0.00443f $ **FLOATING
C463 VPWR.n129 VGND 0.00443f $ **FLOATING
C464 VPWR.n130 VGND 0.00443f $ **FLOATING
C465 VPWR.n131 VGND 0.00443f $ **FLOATING
C466 VPWR.n133 VGND 0.00443f $ **FLOATING
C467 VPWR.n134 VGND 0.00443f $ **FLOATING
C468 VPWR.n135 VGND 0.0101f $ **FLOATING
C469 VPWR.n136 VGND 0.00998f $ **FLOATING
C470 VPWR.n137 VGND 0.00998f $ **FLOATING
C471 VPWR.n138 VGND 0.30872f $ **FLOATING
C472 VPWR.n139 VGND 0.00998f $ **FLOATING
C473 VPWR.n140 VGND 0.00887f $ **FLOATING
C474 VPWR.n141 VGND 0.00933f $ **FLOATING
C475 VPWR.n142 VGND 0.01049f $ **FLOATING
C476 VPWR.n143 VGND 0.01044f $ **FLOATING
C477 VPWR.n144 VGND 0.01049f $ **FLOATING
C478 VPWR.t2 VGND 0.03703f $ **FLOATING
C479 VPWR.n145 VGND 0.12525f $ **FLOATING
C480 VPWR.n146 VGND 0.01044f $ **FLOATING
C481 VPWR.n147 VGND 0.01049f $ **FLOATING
C482 VPWR.n148 VGND 0.00443f $ **FLOATING
C483 VPWR.n149 VGND 0.00443f $ **FLOATING
C484 VPWR.n150 VGND 0.00443f $ **FLOATING
C485 VPWR.n151 VGND 0.00443f $ **FLOATING
C486 VPWR.n152 VGND 0.01049f $ **FLOATING
C487 VPWR.n153 VGND 0.01049f $ **FLOATING
C488 VPWR.n155 VGND 0.08604f $ **FLOATING
C489 VPWR.n156 VGND 0.12525f $ **FLOATING
C490 VPWR.n158 VGND 0.01049f $ **FLOATING
C491 VPWR.n159 VGND 0.01049f $ **FLOATING
C492 VPWR.n160 VGND 0.01044f $ **FLOATING
C493 VPWR.n161 VGND 0.00443f $ **FLOATING
C494 VPWR.n163 VGND 0.00443f $ **FLOATING
C495 VPWR.n165 VGND 0.00443f $ **FLOATING
C496 VPWR.n166 VGND 0.00443f $ **FLOATING
C497 VPWR.n167 VGND 0.01049f $ **FLOATING
C498 VPWR.n168 VGND 0.01044f $ **FLOATING
C499 VPWR.n169 VGND 0.01044f $ **FLOATING
C500 VPWR.n170 VGND 0.08604f $ **FLOATING
C501 VPWR.n171 VGND 0.01044f $ **FLOATING
C502 VPWR.n172 VGND 0.00933f $ **FLOATING
C503 VPWR.n173 VGND 0.65097f $ **FLOATING
C504 VPWR.n174 VGND 0.00415f $ **FLOATING
C505 VPWR.t3 VGND 0.0127f $ **FLOATING
C506 VPWR.n175 VGND 0.00415f $ **FLOATING
C507 VPWR.n176 VGND 0.39189f $ **FLOATING
C508 VPWR.n177 VGND 0.66187f $ **FLOATING
C509 VPWR.n178 VGND 0.00933f $ **FLOATING
C510 VPWR.n179 VGND 0.01049f $ **FLOATING
C511 VPWR.n180 VGND 0.01044f $ **FLOATING
C512 VPWR.n181 VGND 0.01049f $ **FLOATING
C513 VPWR.t0 VGND 0.03703f $ **FLOATING
C514 VPWR.n182 VGND 0.12525f $ **FLOATING
C515 VPWR.n183 VGND 0.01044f $ **FLOATING
C516 VPWR.n184 VGND 0.01049f $ **FLOATING
C517 VPWR.n185 VGND 0.00443f $ **FLOATING
C518 VPWR.n186 VGND 0.00443f $ **FLOATING
C519 VPWR.n187 VGND 0.00443f $ **FLOATING
C520 VPWR.n188 VGND 0.00443f $ **FLOATING
C521 VPWR.n189 VGND 0.01049f $ **FLOATING
C522 VPWR.n190 VGND 0.01049f $ **FLOATING
C523 VPWR.n192 VGND 0.08604f $ **FLOATING
C524 VPWR.n193 VGND 0.12525f $ **FLOATING
C525 VPWR.n195 VGND 0.01049f $ **FLOATING
C526 VPWR.n196 VGND 0.01049f $ **FLOATING
C527 VPWR.n197 VGND 0.01044f $ **FLOATING
C528 VPWR.n198 VGND 0.00443f $ **FLOATING
C529 VPWR.n200 VGND 0.00443f $ **FLOATING
C530 VPWR.n202 VGND 0.00443f $ **FLOATING
C531 VPWR.n203 VGND 0.00443f $ **FLOATING
C532 VPWR.n204 VGND 0.01049f $ **FLOATING
C533 VPWR.n205 VGND 0.01044f $ **FLOATING
C534 VPWR.n206 VGND 0.01044f $ **FLOATING
C535 VPWR.n207 VGND 0.08604f $ **FLOATING
C536 VPWR.n208 VGND 0.01044f $ **FLOATING
C537 VPWR.n209 VGND 0.00933f $ **FLOATING
C538 VPWR.n210 VGND 0.80149f $ **FLOATING
C539 VPWR.n211 VGND 0.00415f $ **FLOATING
C540 VPWR.t1 VGND 0.0127f $ **FLOATING
C541 VPWR.n212 VGND 0.00415f $ **FLOATING
C542 VPWR.n213 VGND 0.39189f $ **FLOATING
C543 VPWR.n214 VGND 0.66187f $ **FLOATING
C544 VPWR.n215 VGND 0.00933f $ **FLOATING
C545 VPWR.n216 VGND 0.01049f $ **FLOATING
C546 VPWR.n217 VGND 0.01044f $ **FLOATING
C547 VPWR.n218 VGND 0.01049f $ **FLOATING
C548 VPWR.t24 VGND 0.03703f $ **FLOATING
C549 VPWR.n219 VGND 0.12525f $ **FLOATING
C550 VPWR.n220 VGND 0.01044f $ **FLOATING
C551 VPWR.n221 VGND 0.01049f $ **FLOATING
C552 VPWR.n222 VGND 0.00443f $ **FLOATING
C553 VPWR.n223 VGND 0.00443f $ **FLOATING
C554 VPWR.n224 VGND 0.00443f $ **FLOATING
C555 VPWR.n225 VGND 0.00443f $ **FLOATING
C556 VPWR.n226 VGND 0.01049f $ **FLOATING
C557 VPWR.n227 VGND 0.01049f $ **FLOATING
C558 VPWR.n229 VGND 0.08604f $ **FLOATING
C559 VPWR.n230 VGND 0.12525f $ **FLOATING
C560 VPWR.n232 VGND 0.01049f $ **FLOATING
C561 VPWR.n233 VGND 0.01049f $ **FLOATING
C562 VPWR.n234 VGND 0.01044f $ **FLOATING
C563 VPWR.n235 VGND 0.00443f $ **FLOATING
C564 VPWR.n237 VGND 0.00443f $ **FLOATING
C565 VPWR.n239 VGND 0.00443f $ **FLOATING
C566 VPWR.n240 VGND 0.00443f $ **FLOATING
C567 VPWR.n241 VGND 0.01049f $ **FLOATING
C568 VPWR.n242 VGND 0.01044f $ **FLOATING
C569 VPWR.n243 VGND 0.01044f $ **FLOATING
C570 VPWR.n244 VGND 0.08604f $ **FLOATING
C571 VPWR.n245 VGND 0.01044f $ **FLOATING
C572 VPWR.n246 VGND 0.00933f $ **FLOATING
C573 VPWR.n247 VGND 0.80149f $ **FLOATING
C574 VPWR.n248 VGND 0.00415f $ **FLOATING
C575 VPWR.t25 VGND 0.0127f $ **FLOATING
C576 VPWR.n249 VGND 0.00415f $ **FLOATING
C577 VPWR.n250 VGND 0.39189f $ **FLOATING
C578 VPWR.n251 VGND 0.66187f $ **FLOATING
C579 VPWR.n252 VGND 0.00933f $ **FLOATING
C580 VPWR.n253 VGND 0.01049f $ **FLOATING
C581 VPWR.n254 VGND 0.01044f $ **FLOATING
C582 VPWR.n255 VGND 0.01049f $ **FLOATING
C583 VPWR.t20 VGND 0.03703f $ **FLOATING
C584 VPWR.n256 VGND 0.12525f $ **FLOATING
C585 VPWR.n257 VGND 0.01044f $ **FLOATING
C586 VPWR.n258 VGND 0.01049f $ **FLOATING
C587 VPWR.n259 VGND 0.00443f $ **FLOATING
C588 VPWR.n260 VGND 0.00443f $ **FLOATING
C589 VPWR.n261 VGND 0.00443f $ **FLOATING
C590 VPWR.n262 VGND 0.00443f $ **FLOATING
C591 VPWR.n263 VGND 0.01049f $ **FLOATING
C592 VPWR.n264 VGND 0.01049f $ **FLOATING
C593 VPWR.n266 VGND 0.08604f $ **FLOATING
C594 VPWR.n267 VGND 0.12525f $ **FLOATING
C595 VPWR.n269 VGND 0.01049f $ **FLOATING
C596 VPWR.n270 VGND 0.01049f $ **FLOATING
C597 VPWR.n271 VGND 0.01044f $ **FLOATING
C598 VPWR.n272 VGND 0.00443f $ **FLOATING
C599 VPWR.n274 VGND 0.00443f $ **FLOATING
C600 VPWR.n276 VGND 0.00443f $ **FLOATING
C601 VPWR.n277 VGND 0.00443f $ **FLOATING
C602 VPWR.n278 VGND 0.01049f $ **FLOATING
C603 VPWR.n279 VGND 0.01044f $ **FLOATING
C604 VPWR.n280 VGND 0.01044f $ **FLOATING
C605 VPWR.n281 VGND 0.08604f $ **FLOATING
C606 VPWR.n282 VGND 0.01044f $ **FLOATING
C607 VPWR.n283 VGND 0.00933f $ **FLOATING
C608 VPWR.n284 VGND 0.80149f $ **FLOATING
C609 VPWR.n285 VGND 0.00415f $ **FLOATING
C610 VPWR.t21 VGND 0.0127f $ **FLOATING
C611 VPWR.n286 VGND 0.00415f $ **FLOATING
C612 VPWR.n287 VGND 0.39189f $ **FLOATING
C613 VPWR.n288 VGND 0.66187f $ **FLOATING
C614 VPWR.n289 VGND 0.00933f $ **FLOATING
C615 VPWR.n290 VGND 0.01049f $ **FLOATING
C616 VPWR.n291 VGND 0.01044f $ **FLOATING
C617 VPWR.n292 VGND 0.01049f $ **FLOATING
C618 VPWR.t18 VGND 0.03703f $ **FLOATING
C619 VPWR.n293 VGND 0.12525f $ **FLOATING
C620 VPWR.n294 VGND 0.01044f $ **FLOATING
C621 VPWR.n295 VGND 0.01049f $ **FLOATING
C622 VPWR.n296 VGND 0.00443f $ **FLOATING
C623 VPWR.n297 VGND 0.00443f $ **FLOATING
C624 VPWR.n298 VGND 0.00443f $ **FLOATING
C625 VPWR.n299 VGND 0.00443f $ **FLOATING
C626 VPWR.n300 VGND 0.01049f $ **FLOATING
C627 VPWR.n301 VGND 0.01049f $ **FLOATING
C628 VPWR.n303 VGND 0.08604f $ **FLOATING
C629 VPWR.n304 VGND 0.12525f $ **FLOATING
C630 VPWR.n306 VGND 0.01049f $ **FLOATING
C631 VPWR.n307 VGND 0.01049f $ **FLOATING
C632 VPWR.n308 VGND 0.01044f $ **FLOATING
C633 VPWR.n309 VGND 0.00443f $ **FLOATING
C634 VPWR.n311 VGND 0.00443f $ **FLOATING
C635 VPWR.n313 VGND 0.00443f $ **FLOATING
C636 VPWR.n314 VGND 0.00443f $ **FLOATING
C637 VPWR.n315 VGND 0.01049f $ **FLOATING
C638 VPWR.n316 VGND 0.01044f $ **FLOATING
C639 VPWR.n317 VGND 0.01044f $ **FLOATING
C640 VPWR.n318 VGND 0.08604f $ **FLOATING
C641 VPWR.n319 VGND 0.01044f $ **FLOATING
C642 VPWR.n320 VGND 0.00933f $ **FLOATING
C643 VPWR.n321 VGND 0.80149f $ **FLOATING
C644 VPWR.n322 VGND 0.00415f $ **FLOATING
C645 VPWR.t19 VGND 0.0127f $ **FLOATING
C646 VPWR.n323 VGND 0.00415f $ **FLOATING
C647 VPWR.n324 VGND 0.39189f $ **FLOATING
C648 VPWR.n325 VGND 0.66187f $ **FLOATING
C649 VPWR.n326 VGND 0.00933f $ **FLOATING
C650 VPWR.n327 VGND 0.01049f $ **FLOATING
C651 VPWR.n328 VGND 0.01044f $ **FLOATING
C652 VPWR.n329 VGND 0.01049f $ **FLOATING
C653 VPWR.t22 VGND 0.03703f $ **FLOATING
C654 VPWR.n330 VGND 0.12525f $ **FLOATING
C655 VPWR.n331 VGND 0.01044f $ **FLOATING
C656 VPWR.n332 VGND 0.01049f $ **FLOATING
C657 VPWR.n333 VGND 0.00443f $ **FLOATING
C658 VPWR.n334 VGND 0.00443f $ **FLOATING
C659 VPWR.n335 VGND 0.00443f $ **FLOATING
C660 VPWR.n336 VGND 0.00443f $ **FLOATING
C661 VPWR.n337 VGND 0.01049f $ **FLOATING
C662 VPWR.n338 VGND 0.01049f $ **FLOATING
C663 VPWR.n340 VGND 0.08604f $ **FLOATING
C664 VPWR.n341 VGND 0.12525f $ **FLOATING
C665 VPWR.n343 VGND 0.01049f $ **FLOATING
C666 VPWR.n344 VGND 0.01049f $ **FLOATING
C667 VPWR.n345 VGND 0.01044f $ **FLOATING
C668 VPWR.n346 VGND 0.00443f $ **FLOATING
C669 VPWR.n348 VGND 0.00443f $ **FLOATING
C670 VPWR.n350 VGND 0.00443f $ **FLOATING
C671 VPWR.n351 VGND 0.00443f $ **FLOATING
C672 VPWR.n352 VGND 0.01049f $ **FLOATING
C673 VPWR.n353 VGND 0.01044f $ **FLOATING
C674 VPWR.n354 VGND 0.01044f $ **FLOATING
C675 VPWR.n355 VGND 0.08604f $ **FLOATING
C676 VPWR.n356 VGND 0.01044f $ **FLOATING
C677 VPWR.n357 VGND 0.00933f $ **FLOATING
C678 VPWR.n358 VGND 0.80149f $ **FLOATING
C679 VPWR.n359 VGND 0.00415f $ **FLOATING
C680 VPWR.t23 VGND 0.0127f $ **FLOATING
C681 VPWR.n360 VGND 0.00415f $ **FLOATING
C682 VPWR.n361 VGND 0.39189f $ **FLOATING
C683 VPWR.n362 VGND 0.66187f $ **FLOATING
C684 VPWR.n363 VGND 0.00933f $ **FLOATING
C685 VPWR.n364 VGND 0.01049f $ **FLOATING
C686 VPWR.n365 VGND 0.01044f $ **FLOATING
C687 VPWR.n366 VGND 0.01049f $ **FLOATING
C688 VPWR.t8 VGND 0.03703f $ **FLOATING
C689 VPWR.n367 VGND 0.12525f $ **FLOATING
C690 VPWR.n368 VGND 0.01044f $ **FLOATING
C691 VPWR.n369 VGND 0.01049f $ **FLOATING
C692 VPWR.n370 VGND 0.00443f $ **FLOATING
C693 VPWR.n371 VGND 0.00443f $ **FLOATING
C694 VPWR.n372 VGND 0.00443f $ **FLOATING
C695 VPWR.n373 VGND 0.00443f $ **FLOATING
C696 VPWR.n374 VGND 0.01049f $ **FLOATING
C697 VPWR.n375 VGND 0.01049f $ **FLOATING
C698 VPWR.n377 VGND 0.08604f $ **FLOATING
C699 VPWR.n378 VGND 0.12525f $ **FLOATING
C700 VPWR.n380 VGND 0.01049f $ **FLOATING
C701 VPWR.n381 VGND 0.01049f $ **FLOATING
C702 VPWR.n382 VGND 0.01044f $ **FLOATING
C703 VPWR.n383 VGND 0.00443f $ **FLOATING
C704 VPWR.n385 VGND 0.00443f $ **FLOATING
C705 VPWR.n387 VGND 0.00443f $ **FLOATING
C706 VPWR.n388 VGND 0.00443f $ **FLOATING
C707 VPWR.n389 VGND 0.01049f $ **FLOATING
C708 VPWR.n390 VGND 0.01044f $ **FLOATING
C709 VPWR.n391 VGND 0.01044f $ **FLOATING
C710 VPWR.n392 VGND 0.08604f $ **FLOATING
C711 VPWR.n393 VGND 0.01044f $ **FLOATING
C712 VPWR.n394 VGND 0.00933f $ **FLOATING
C713 VPWR.n395 VGND 0.80149f $ **FLOATING
C714 VPWR.n396 VGND 0.00415f $ **FLOATING
C715 VPWR.t9 VGND 0.0127f $ **FLOATING
C716 VPWR.n397 VGND 0.00415f $ **FLOATING
C717 VPWR.n398 VGND 0.39189f $ **FLOATING
C718 VPWR.n399 VGND 0.66187f $ **FLOATING
C719 VPWR.n400 VGND 0.00933f $ **FLOATING
C720 VPWR.n401 VGND 0.01049f $ **FLOATING
C721 VPWR.n402 VGND 0.01044f $ **FLOATING
C722 VPWR.n403 VGND 0.01049f $ **FLOATING
C723 VPWR.t4 VGND 0.03703f $ **FLOATING
C724 VPWR.n404 VGND 0.12525f $ **FLOATING
C725 VPWR.n405 VGND 0.01044f $ **FLOATING
C726 VPWR.n406 VGND 0.01049f $ **FLOATING
C727 VPWR.n407 VGND 0.00443f $ **FLOATING
C728 VPWR.n408 VGND 0.00443f $ **FLOATING
C729 VPWR.n409 VGND 0.00443f $ **FLOATING
C730 VPWR.n410 VGND 0.00443f $ **FLOATING
C731 VPWR.n411 VGND 0.01049f $ **FLOATING
C732 VPWR.n412 VGND 0.01049f $ **FLOATING
C733 VPWR.n414 VGND 0.08604f $ **FLOATING
C734 VPWR.n415 VGND 0.12525f $ **FLOATING
C735 VPWR.n417 VGND 0.01049f $ **FLOATING
C736 VPWR.n418 VGND 0.01049f $ **FLOATING
C737 VPWR.n419 VGND 0.01044f $ **FLOATING
C738 VPWR.n420 VGND 0.00443f $ **FLOATING
C739 VPWR.n422 VGND 0.00443f $ **FLOATING
C740 VPWR.n424 VGND 0.00443f $ **FLOATING
C741 VPWR.n425 VGND 0.00443f $ **FLOATING
C742 VPWR.n426 VGND 0.01049f $ **FLOATING
C743 VPWR.n427 VGND 0.01044f $ **FLOATING
C744 VPWR.n428 VGND 0.01044f $ **FLOATING
C745 VPWR.n429 VGND 0.08604f $ **FLOATING
C746 VPWR.n430 VGND 0.01044f $ **FLOATING
C747 VPWR.n431 VGND 0.00933f $ **FLOATING
C748 VPWR.n432 VGND 0.80149f $ **FLOATING
C749 VPWR.n433 VGND 0.00415f $ **FLOATING
C750 VPWR.t5 VGND 0.0127f $ **FLOATING
C751 VPWR.n434 VGND 0.00415f $ **FLOATING
C752 VPWR.n435 VGND 0.39189f $ **FLOATING
C753 VPWR.n436 VGND 4.04316f $ **FLOATING
C754 VPWR.t26 VGND 0.5313f $ **FLOATING
C755 VPWR.n437 VGND 7.84935f $ **FLOATING
C756 VPWR.n438 VGND 0.00987f $ **FLOATING
C757 VPWR.n439 VGND 0.00443f $ **FLOATING
C758 VPWR.n440 VGND 0.01002f $ **FLOATING
C759 VPWR.n442 VGND 0.00443f $ **FLOATING
C760 VPWR.n443 VGND 0.06415f $ **FLOATING
C761 VPWR.n444 VGND 0.10283f $ **FLOATING
C762 VPWR.n445 VGND 0.00443f $ **FLOATING
C763 VPWR.n446 VGND 0.00987f $ **FLOATING
C764 VPWR.n447 VGND 0.00443f $ **FLOATING
C765 VPWR.n448 VGND 0.00443f $ **FLOATING
C766 VPWR.n449 VGND 0.06415f $ **FLOATING
C767 VPWR.n450 VGND 0.00443f $ **FLOATING
C768 VPWR.n451 VGND 0.00443f $ **FLOATING
C769 VPWR.n452 VGND 0.00443f $ **FLOATING
C770 VPWR.n453 VGND 0.06415f $ **FLOATING
C771 VPWR.n454 VGND 0.00443f $ **FLOATING
C772 VPWR.n455 VGND 0.00443f $ **FLOATING
C773 VPWR.n456 VGND 0.00443f $ **FLOATING
C774 VPWR.n457 VGND 0.06415f $ **FLOATING
C775 VPWR.n458 VGND 0.00443f $ **FLOATING
C776 VPWR.n459 VGND 0.00443f $ **FLOATING
C777 VPWR.n460 VGND 0.00443f $ **FLOATING
C778 VPWR.n461 VGND 0.06415f $ **FLOATING
C779 VPWR.n462 VGND 0.00443f $ **FLOATING
C780 VPWR.n463 VGND 0.00443f $ **FLOATING
C781 VPWR.n464 VGND 0.00443f $ **FLOATING
C782 VPWR.n465 VGND 0.06415f $ **FLOATING
C783 VPWR.n466 VGND 0.00443f $ **FLOATING
C784 VPWR.n467 VGND 0.00443f $ **FLOATING
C785 VPWR.n468 VGND 0.00443f $ **FLOATING
C786 VPWR.n469 VGND 0.06415f $ **FLOATING
C787 VPWR.n470 VGND 0.00443f $ **FLOATING
C788 VPWR.n471 VGND 0.00443f $ **FLOATING
C789 VPWR.n472 VGND 0.00443f $ **FLOATING
C790 VPWR.n473 VGND 0.04811f $ **FLOATING
C791 VPWR.n474 VGND 0.00443f $ **FLOATING
C792 VPWR.n475 VGND 0.00443f $ **FLOATING
C793 VPWR.n476 VGND 0.00443f $ **FLOATING
C794 VPWR.n477 VGND 0.06415f $ **FLOATING
C795 VPWR.t12 VGND 0.03208f $ **FLOATING
C796 VPWR.n478 VGND 0.00443f $ **FLOATING
C797 VPWR.n479 VGND 0.00443f $ **FLOATING
C798 VPWR.n480 VGND 0.00443f $ **FLOATING
C799 VPWR.n481 VGND 0.06415f $ **FLOATING
C800 VPWR.n482 VGND 0.00443f $ **FLOATING
C801 VPWR.n483 VGND 0.00443f $ **FLOATING
C802 VPWR.n484 VGND 0.00443f $ **FLOATING
C803 VPWR.n485 VGND 0.06415f $ **FLOATING
C804 VPWR.n486 VGND 0.00443f $ **FLOATING
C805 VPWR.n487 VGND 0.00443f $ **FLOATING
C806 VPWR.n488 VGND 0.00443f $ **FLOATING
C807 VPWR.n489 VGND 0.06415f $ **FLOATING
C808 VPWR.n490 VGND 0.00443f $ **FLOATING
C809 VPWR.n491 VGND 0.00443f $ **FLOATING
C810 VPWR.n492 VGND 0.00443f $ **FLOATING
C811 VPWR.n493 VGND 0.06415f $ **FLOATING
C812 VPWR.n494 VGND 0.00443f $ **FLOATING
C813 VPWR.n495 VGND 0.00443f $ **FLOATING
C814 VPWR.n496 VGND 0.00443f $ **FLOATING
C815 VPWR.n497 VGND 0.06415f $ **FLOATING
C816 VPWR.n498 VGND 0.00443f $ **FLOATING
C817 VPWR.n499 VGND 0.00443f $ **FLOATING
C818 VPWR.n500 VGND 0.00443f $ **FLOATING
C819 VPWR.n501 VGND 0.06415f $ **FLOATING
C820 VPWR.n502 VGND 0.00443f $ **FLOATING
C821 VPWR.n503 VGND 0.01002f $ **FLOATING
C822 VPWR.n504 VGND 0.01002f $ **FLOATING
C823 VPWR.n505 VGND 0.08491f $ **FLOATING
C824 VPWR.n506 VGND 0.01002f $ **FLOATING
C825 VPWR.n507 VGND 0.00443f $ **FLOATING
C826 VPWR.n508 VGND 0.00443f $ **FLOATING
C827 VPWR.n509 VGND 0.00987f $ **FLOATING
C828 VPWR.n510 VGND 0.00987f $ **FLOATING
C829 VPWR.n512 VGND 0.10283f $ **FLOATING
C830 VPWR.n513 VGND 0.00987f $ **FLOATING
C831 VPWR.n514 VGND 0.00987f $ **FLOATING
C832 VPWR.n515 VGND 0.01002f $ **FLOATING
C833 VPWR.n516 VGND 0.00443f $ **FLOATING
C834 VPWR.n517 VGND 0.00443f $ **FLOATING
C835 VPWR.n518 VGND 0.06415f $ **FLOATING
C836 VPWR.n519 VGND 0.00443f $ **FLOATING
C837 VPWR.n520 VGND 0.00443f $ **FLOATING
C838 VPWR.n521 VGND 0.00443f $ **FLOATING
C839 VPWR.n522 VGND 0.00443f $ **FLOATING
C840 VPWR.n523 VGND 0.00443f $ **FLOATING
C841 VPWR.n524 VGND 0.06415f $ **FLOATING
C842 VPWR.n525 VGND 0.00443f $ **FLOATING
C843 VPWR.n526 VGND 0.00443f $ **FLOATING
C844 VPWR.n527 VGND 0.00443f $ **FLOATING
C845 VPWR.n528 VGND 0.00443f $ **FLOATING
C846 VPWR.n529 VGND 0.00443f $ **FLOATING
C847 VPWR.n530 VGND 0.06415f $ **FLOATING
C848 VPWR.n531 VGND 0.00443f $ **FLOATING
C849 VPWR.n532 VGND 0.00443f $ **FLOATING
C850 VPWR.n533 VGND 0.00443f $ **FLOATING
C851 VPWR.n534 VGND 0.00443f $ **FLOATING
C852 VPWR.n535 VGND 0.00443f $ **FLOATING
C853 VPWR.n536 VGND 0.06415f $ **FLOATING
C854 VPWR.n537 VGND 0.00443f $ **FLOATING
C855 VPWR.n538 VGND 0.00443f $ **FLOATING
C856 VPWR.n539 VGND 0.00443f $ **FLOATING
C857 VPWR.n540 VGND 0.00443f $ **FLOATING
C858 VPWR.n541 VGND 0.00443f $ **FLOATING
C859 VPWR.n542 VGND 0.06415f $ **FLOATING
C860 VPWR.n543 VGND 0.00443f $ **FLOATING
C861 VPWR.n544 VGND 0.00443f $ **FLOATING
C862 VPWR.n545 VGND 0.00443f $ **FLOATING
C863 VPWR.n546 VGND 0.00443f $ **FLOATING
C864 VPWR.n547 VGND 0.00443f $ **FLOATING
C865 VPWR.n548 VGND 0.06415f $ **FLOATING
C866 VPWR.n549 VGND 0.00443f $ **FLOATING
C867 VPWR.n550 VGND 0.00443f $ **FLOATING
C868 VPWR.n551 VGND 0.00443f $ **FLOATING
C869 VPWR.n552 VGND 0.00443f $ **FLOATING
C870 VPWR.n553 VGND 0.00443f $ **FLOATING
C871 VPWR.n554 VGND 0.06415f $ **FLOATING
C872 VPWR.n555 VGND 0.00443f $ **FLOATING
C873 VPWR.n556 VGND 0.00443f $ **FLOATING
C874 VPWR.n557 VGND 0.00443f $ **FLOATING
C875 VPWR.n558 VGND 0.00443f $ **FLOATING
C876 VPWR.n559 VGND 0.00443f $ **FLOATING
C877 VPWR.n560 VGND 0.04811f $ **FLOATING
C878 VPWR.n561 VGND 0.00443f $ **FLOATING
C879 VPWR.n562 VGND 0.00443f $ **FLOATING
C880 VPWR.n563 VGND 0.00443f $ **FLOATING
C881 VPWR.n564 VGND 0.00443f $ **FLOATING
C882 VPWR.n565 VGND 0.00443f $ **FLOATING
C883 VPWR.n566 VGND 0.06415f $ **FLOATING
C884 VPWR.n567 VGND 0.00443f $ **FLOATING
C885 VPWR.n568 VGND 0.00443f $ **FLOATING
C886 VPWR.n569 VGND 0.00443f $ **FLOATING
C887 VPWR.n570 VGND 0.00443f $ **FLOATING
C888 VPWR.n571 VGND 0.00443f $ **FLOATING
C889 VPWR.n572 VGND 0.06415f $ **FLOATING
C890 VPWR.n573 VGND 0.00443f $ **FLOATING
C891 VPWR.n574 VGND 0.00443f $ **FLOATING
C892 VPWR.n575 VGND 0.00443f $ **FLOATING
C893 VPWR.n576 VGND 0.00443f $ **FLOATING
C894 VPWR.n577 VGND 0.00443f $ **FLOATING
C895 VPWR.n578 VGND 0.06415f $ **FLOATING
C896 VPWR.n579 VGND 0.00443f $ **FLOATING
C897 VPWR.n580 VGND 0.00443f $ **FLOATING
C898 VPWR.n581 VGND 0.00443f $ **FLOATING
C899 VPWR.n582 VGND 0.00443f $ **FLOATING
C900 VPWR.n583 VGND 0.00443f $ **FLOATING
C901 VPWR.n584 VGND 0.06415f $ **FLOATING
C902 VPWR.n585 VGND 0.00443f $ **FLOATING
C903 VPWR.n586 VGND 0.00443f $ **FLOATING
C904 VPWR.n587 VGND 0.00443f $ **FLOATING
C905 VPWR.n588 VGND 0.00443f $ **FLOATING
C906 VPWR.n589 VGND 0.00443f $ **FLOATING
C907 VPWR.n590 VGND 0.06415f $ **FLOATING
C908 VPWR.n591 VGND 0.00443f $ **FLOATING
C909 VPWR.n592 VGND 0.00443f $ **FLOATING
C910 VPWR.n593 VGND 0.00443f $ **FLOATING
C911 VPWR.n594 VGND 0.00443f $ **FLOATING
C912 VPWR.n595 VGND 0.00443f $ **FLOATING
C913 VPWR.n596 VGND 0.06415f $ **FLOATING
C914 VPWR.n597 VGND 0.00443f $ **FLOATING
C915 VPWR.n598 VGND 0.00443f $ **FLOATING
C916 VPWR.n599 VGND 0.00443f $ **FLOATING
C917 VPWR.n600 VGND 0.00443f $ **FLOATING
C918 VPWR.n601 VGND 0.00443f $ **FLOATING
C919 VPWR.n602 VGND 0.00443f $ **FLOATING
C920 VPWR.n603 VGND 0.06415f $ **FLOATING
C921 VPWR.n604 VGND 0.00443f $ **FLOATING
C922 VPWR.n605 VGND 0.00443f $ **FLOATING
C923 VPWR.n606 VGND 0.00443f $ **FLOATING
C924 VPWR.n607 VGND 0.01002f $ **FLOATING
C925 VPWR.n608 VGND 0.01002f $ **FLOATING
C926 VPWR.n609 VGND 0.08491f $ **FLOATING
C927 VPWR.n610 VGND 0.01002f $ **FLOATING
C928 VPWR.n611 VGND 0.00987f $ **FLOATING
C929 VPWR.n612 VGND 0.00987f $ **FLOATING
C930 VPWR.n613 VGND 4.3598f $ **FLOATING
C931 VPWR.n614 VGND 0.0115f $ **FLOATING
C932 VPWR.t13 VGND 0.05561f $ **FLOATING
C933 VPWR.n615 VGND 0.17478f $ **FLOATING
C934 VPWR.n616 VGND 0.03616f $ **FLOATING
C935 VPWR.n617 VGND 0.62531f $ **FLOATING
C936 VPWR.n618 VGND 0.66997f $ **FLOATING
C937 VPWR.n619 VGND 0.00987f $ **FLOATING
C938 VPWR.n620 VGND 0.00443f $ **FLOATING
C939 VPWR.n621 VGND 0.01002f $ **FLOATING
C940 VPWR.n623 VGND 0.00443f $ **FLOATING
C941 VPWR.n624 VGND 0.06415f $ **FLOATING
C942 VPWR.n625 VGND 0.10283f $ **FLOATING
C943 VPWR.n626 VGND 0.00443f $ **FLOATING
C944 VPWR.n627 VGND 0.00987f $ **FLOATING
C945 VPWR.n628 VGND 0.00443f $ **FLOATING
C946 VPWR.n629 VGND 0.00443f $ **FLOATING
C947 VPWR.n630 VGND 0.06415f $ **FLOATING
C948 VPWR.n631 VGND 0.00443f $ **FLOATING
C949 VPWR.n632 VGND 0.00443f $ **FLOATING
C950 VPWR.n633 VGND 0.00443f $ **FLOATING
C951 VPWR.n634 VGND 0.06415f $ **FLOATING
C952 VPWR.n635 VGND 0.00443f $ **FLOATING
C953 VPWR.n636 VGND 0.00443f $ **FLOATING
C954 VPWR.n637 VGND 0.00443f $ **FLOATING
C955 VPWR.n638 VGND 0.06415f $ **FLOATING
C956 VPWR.n639 VGND 0.00443f $ **FLOATING
C957 VPWR.n640 VGND 0.00443f $ **FLOATING
C958 VPWR.n641 VGND 0.00443f $ **FLOATING
C959 VPWR.n642 VGND 0.06415f $ **FLOATING
C960 VPWR.n643 VGND 0.00443f $ **FLOATING
C961 VPWR.n644 VGND 0.00443f $ **FLOATING
C962 VPWR.n645 VGND 0.00443f $ **FLOATING
C963 VPWR.n646 VGND 0.06415f $ **FLOATING
C964 VPWR.n647 VGND 0.00443f $ **FLOATING
C965 VPWR.n648 VGND 0.00443f $ **FLOATING
C966 VPWR.n649 VGND 0.00443f $ **FLOATING
C967 VPWR.n650 VGND 0.06415f $ **FLOATING
C968 VPWR.n651 VGND 0.00443f $ **FLOATING
C969 VPWR.n652 VGND 0.00443f $ **FLOATING
C970 VPWR.n653 VGND 0.00443f $ **FLOATING
C971 VPWR.n654 VGND 0.04811f $ **FLOATING
C972 VPWR.n655 VGND 0.00443f $ **FLOATING
C973 VPWR.n656 VGND 0.00443f $ **FLOATING
C974 VPWR.n657 VGND 0.00443f $ **FLOATING
C975 VPWR.n658 VGND 0.06415f $ **FLOATING
C976 VPWR.t10 VGND 0.03208f $ **FLOATING
C977 VPWR.n659 VGND 0.00443f $ **FLOATING
C978 VPWR.n660 VGND 0.00443f $ **FLOATING
C979 VPWR.n661 VGND 0.00443f $ **FLOATING
C980 VPWR.n662 VGND 0.06415f $ **FLOATING
C981 VPWR.n663 VGND 0.00443f $ **FLOATING
C982 VPWR.n664 VGND 0.00443f $ **FLOATING
C983 VPWR.n665 VGND 0.00443f $ **FLOATING
C984 VPWR.n666 VGND 0.06415f $ **FLOATING
C985 VPWR.n667 VGND 0.00443f $ **FLOATING
C986 VPWR.n668 VGND 0.00443f $ **FLOATING
C987 VPWR.n669 VGND 0.00443f $ **FLOATING
C988 VPWR.n670 VGND 0.06415f $ **FLOATING
C989 VPWR.n671 VGND 0.00443f $ **FLOATING
C990 VPWR.n672 VGND 0.00443f $ **FLOATING
C991 VPWR.n673 VGND 0.00443f $ **FLOATING
C992 VPWR.n674 VGND 0.06415f $ **FLOATING
C993 VPWR.n675 VGND 0.00443f $ **FLOATING
C994 VPWR.n676 VGND 0.00443f $ **FLOATING
C995 VPWR.n677 VGND 0.00443f $ **FLOATING
C996 VPWR.n678 VGND 0.06415f $ **FLOATING
C997 VPWR.n679 VGND 0.00443f $ **FLOATING
C998 VPWR.n680 VGND 0.00443f $ **FLOATING
C999 VPWR.n681 VGND 0.00443f $ **FLOATING
C1000 VPWR.n682 VGND 0.06415f $ **FLOATING
C1001 VPWR.n683 VGND 0.00443f $ **FLOATING
C1002 VPWR.n684 VGND 0.01002f $ **FLOATING
C1003 VPWR.n685 VGND 0.01002f $ **FLOATING
C1004 VPWR.n686 VGND 0.08491f $ **FLOATING
C1005 VPWR.n687 VGND 0.01002f $ **FLOATING
C1006 VPWR.n688 VGND 0.00443f $ **FLOATING
C1007 VPWR.n689 VGND 0.00443f $ **FLOATING
C1008 VPWR.n690 VGND 0.00987f $ **FLOATING
C1009 VPWR.n691 VGND 0.00987f $ **FLOATING
C1010 VPWR.n693 VGND 0.10283f $ **FLOATING
C1011 VPWR.n694 VGND 0.00987f $ **FLOATING
C1012 VPWR.n695 VGND 0.00987f $ **FLOATING
C1013 VPWR.n696 VGND 0.01002f $ **FLOATING
C1014 VPWR.n697 VGND 0.00443f $ **FLOATING
C1015 VPWR.n698 VGND 0.00443f $ **FLOATING
C1016 VPWR.n699 VGND 0.06415f $ **FLOATING
C1017 VPWR.n700 VGND 0.00443f $ **FLOATING
C1018 VPWR.n701 VGND 0.00443f $ **FLOATING
C1019 VPWR.n702 VGND 0.00443f $ **FLOATING
C1020 VPWR.n703 VGND 0.00443f $ **FLOATING
C1021 VPWR.n704 VGND 0.00443f $ **FLOATING
C1022 VPWR.n705 VGND 0.06415f $ **FLOATING
C1023 VPWR.n706 VGND 0.00443f $ **FLOATING
C1024 VPWR.n707 VGND 0.00443f $ **FLOATING
C1025 VPWR.n708 VGND 0.00443f $ **FLOATING
C1026 VPWR.n709 VGND 0.00443f $ **FLOATING
C1027 VPWR.n710 VGND 0.00443f $ **FLOATING
C1028 VPWR.n711 VGND 0.06415f $ **FLOATING
C1029 VPWR.n712 VGND 0.00443f $ **FLOATING
C1030 VPWR.n713 VGND 0.00443f $ **FLOATING
C1031 VPWR.n714 VGND 0.00443f $ **FLOATING
C1032 VPWR.n715 VGND 0.00443f $ **FLOATING
C1033 VPWR.n716 VGND 0.00443f $ **FLOATING
C1034 VPWR.n717 VGND 0.06415f $ **FLOATING
C1035 VPWR.n718 VGND 0.00443f $ **FLOATING
C1036 VPWR.n719 VGND 0.00443f $ **FLOATING
C1037 VPWR.n720 VGND 0.00443f $ **FLOATING
C1038 VPWR.n721 VGND 0.00443f $ **FLOATING
C1039 VPWR.n722 VGND 0.00443f $ **FLOATING
C1040 VPWR.n723 VGND 0.06415f $ **FLOATING
C1041 VPWR.n724 VGND 0.00443f $ **FLOATING
C1042 VPWR.n725 VGND 0.00443f $ **FLOATING
C1043 VPWR.n726 VGND 0.00443f $ **FLOATING
C1044 VPWR.n727 VGND 0.00443f $ **FLOATING
C1045 VPWR.n728 VGND 0.00443f $ **FLOATING
C1046 VPWR.n729 VGND 0.06415f $ **FLOATING
C1047 VPWR.n730 VGND 0.00443f $ **FLOATING
C1048 VPWR.n731 VGND 0.00443f $ **FLOATING
C1049 VPWR.n732 VGND 0.00443f $ **FLOATING
C1050 VPWR.n733 VGND 0.00443f $ **FLOATING
C1051 VPWR.n734 VGND 0.00443f $ **FLOATING
C1052 VPWR.n735 VGND 0.06415f $ **FLOATING
C1053 VPWR.n736 VGND 0.00443f $ **FLOATING
C1054 VPWR.n737 VGND 0.00443f $ **FLOATING
C1055 VPWR.n738 VGND 0.00443f $ **FLOATING
C1056 VPWR.n739 VGND 0.00443f $ **FLOATING
C1057 VPWR.n740 VGND 0.00443f $ **FLOATING
C1058 VPWR.n741 VGND 0.04811f $ **FLOATING
C1059 VPWR.n742 VGND 0.00443f $ **FLOATING
C1060 VPWR.n743 VGND 0.00443f $ **FLOATING
C1061 VPWR.n744 VGND 0.00443f $ **FLOATING
C1062 VPWR.n745 VGND 0.00443f $ **FLOATING
C1063 VPWR.n746 VGND 0.00443f $ **FLOATING
C1064 VPWR.n747 VGND 0.06415f $ **FLOATING
C1065 VPWR.n748 VGND 0.00443f $ **FLOATING
C1066 VPWR.n749 VGND 0.00443f $ **FLOATING
C1067 VPWR.n750 VGND 0.00443f $ **FLOATING
C1068 VPWR.n751 VGND 0.00443f $ **FLOATING
C1069 VPWR.n752 VGND 0.00443f $ **FLOATING
C1070 VPWR.n753 VGND 0.06415f $ **FLOATING
C1071 VPWR.n754 VGND 0.00443f $ **FLOATING
C1072 VPWR.n755 VGND 0.00443f $ **FLOATING
C1073 VPWR.n756 VGND 0.00443f $ **FLOATING
C1074 VPWR.n757 VGND 0.00443f $ **FLOATING
C1075 VPWR.n758 VGND 0.00443f $ **FLOATING
C1076 VPWR.n759 VGND 0.06415f $ **FLOATING
C1077 VPWR.n760 VGND 0.00443f $ **FLOATING
C1078 VPWR.n761 VGND 0.00443f $ **FLOATING
C1079 VPWR.n762 VGND 0.00443f $ **FLOATING
C1080 VPWR.n763 VGND 0.00443f $ **FLOATING
C1081 VPWR.n764 VGND 0.00443f $ **FLOATING
C1082 VPWR.n765 VGND 0.06415f $ **FLOATING
C1083 VPWR.n766 VGND 0.00443f $ **FLOATING
C1084 VPWR.n767 VGND 0.00443f $ **FLOATING
C1085 VPWR.n768 VGND 0.00443f $ **FLOATING
C1086 VPWR.n769 VGND 0.00443f $ **FLOATING
C1087 VPWR.n770 VGND 0.00443f $ **FLOATING
C1088 VPWR.n771 VGND 0.06415f $ **FLOATING
C1089 VPWR.n772 VGND 0.00443f $ **FLOATING
C1090 VPWR.n773 VGND 0.00443f $ **FLOATING
C1091 VPWR.n774 VGND 0.00443f $ **FLOATING
C1092 VPWR.n775 VGND 0.00443f $ **FLOATING
C1093 VPWR.n776 VGND 0.00443f $ **FLOATING
C1094 VPWR.n777 VGND 0.06415f $ **FLOATING
C1095 VPWR.n778 VGND 0.00443f $ **FLOATING
C1096 VPWR.n779 VGND 0.00443f $ **FLOATING
C1097 VPWR.n780 VGND 0.00443f $ **FLOATING
C1098 VPWR.n781 VGND 0.00443f $ **FLOATING
C1099 VPWR.n782 VGND 0.00443f $ **FLOATING
C1100 VPWR.n783 VGND 0.00443f $ **FLOATING
C1101 VPWR.n784 VGND 0.06415f $ **FLOATING
C1102 VPWR.n785 VGND 0.00443f $ **FLOATING
C1103 VPWR.n786 VGND 0.00443f $ **FLOATING
C1104 VPWR.n787 VGND 0.00443f $ **FLOATING
C1105 VPWR.n788 VGND 0.01002f $ **FLOATING
C1106 VPWR.n789 VGND 0.01002f $ **FLOATING
C1107 VPWR.n790 VGND 0.08491f $ **FLOATING
C1108 VPWR.n791 VGND 0.01002f $ **FLOATING
C1109 VPWR.n792 VGND 0.00987f $ **FLOATING
C1110 VPWR.n793 VGND 0.00987f $ **FLOATING
C1111 VPWR.n794 VGND 0.89085f $ **FLOATING
C1112 VPWR.n795 VGND 0.0115f $ **FLOATING
C1113 VPWR.t11 VGND 0.05561f $ **FLOATING
C1114 VPWR.n796 VGND 0.17478f $ **FLOATING
C1115 VPWR.n797 VGND 0.03616f $ **FLOATING
C1116 VPWR.n798 VGND 0.62531f $ **FLOATING
C1117 VPWR.n799 VGND 0.55454f $ **FLOATING
C1118 VPWR.n800 VGND 0.00887f $ **FLOATING
C1119 VPWR.n801 VGND 0.0101f $ **FLOATING
C1120 VPWR.n802 VGND 0.00998f $ **FLOATING
C1121 VPWR.n803 VGND 0.0101f $ **FLOATING
C1122 VPWR.t15 VGND 0.13287f $ **FLOATING
C1123 VPWR.n804 VGND 0.4494f $ **FLOATING
C1124 VPWR.n805 VGND 0.00998f $ **FLOATING
C1125 VPWR.n806 VGND 0.0101f $ **FLOATING
C1126 VPWR.n807 VGND 0.00443f $ **FLOATING
C1127 VPWR.n808 VGND 0.00443f $ **FLOATING
C1128 VPWR.n820 VGND 0.00443f $ **FLOATING
C1129 VPWR.n821 VGND 0.00443f $ **FLOATING
C1130 VPWR.n822 VGND 0.00443f $ **FLOATING
C1131 VPWR.n823 VGND 0.00443f $ **FLOATING
C1132 VPWR.n824 VGND 0.00443f $ **FLOATING
C1133 VPWR.n825 VGND 0.00443f $ **FLOATING
C1134 VPWR.n826 VGND 0.00443f $ **FLOATING
C1135 VPWR.n827 VGND 0.00443f $ **FLOATING
C1136 VPWR.n828 VGND 0.00443f $ **FLOATING
C1137 VPWR.n829 VGND 0.00443f $ **FLOATING
C1138 VPWR.n830 VGND 0.00443f $ **FLOATING
C1139 VPWR.n831 VGND 0.00443f $ **FLOATING
C1140 VPWR.n832 VGND 0.00443f $ **FLOATING
C1141 VPWR.n833 VGND 0.00443f $ **FLOATING
C1142 VPWR.n834 VGND 0.00443f $ **FLOATING
C1143 VPWR.n835 VGND 0.00443f $ **FLOATING
C1144 VPWR.n836 VGND 0.00443f $ **FLOATING
C1145 VPWR.n837 VGND 0.00443f $ **FLOATING
C1146 VPWR.n838 VGND 0.00443f $ **FLOATING
C1147 VPWR.n839 VGND 0.00443f $ **FLOATING
C1148 VPWR.n840 VGND 0.00443f $ **FLOATING
C1149 VPWR.n841 VGND 0.00443f $ **FLOATING
C1150 VPWR.n842 VGND 0.00443f $ **FLOATING
C1151 VPWR.n843 VGND 0.00443f $ **FLOATING
C1152 VPWR.n844 VGND 0.00443f $ **FLOATING
C1153 VPWR.n845 VGND 0.00443f $ **FLOATING
C1154 VPWR.n846 VGND 0.00443f $ **FLOATING
C1155 VPWR.n847 VGND 0.00443f $ **FLOATING
C1156 VPWR.n848 VGND 0.00443f $ **FLOATING
C1157 VPWR.n849 VGND 0.00443f $ **FLOATING
C1158 VPWR.n850 VGND 0.00443f $ **FLOATING
C1159 VPWR.n851 VGND 0.00443f $ **FLOATING
C1160 VPWR.n852 VGND 0.00443f $ **FLOATING
C1161 VPWR.n853 VGND 0.00443f $ **FLOATING
C1162 VPWR.n854 VGND 0.00443f $ **FLOATING
C1163 VPWR.n855 VGND 0.00443f $ **FLOATING
C1164 VPWR.n856 VGND 0.00443f $ **FLOATING
C1165 VPWR.n857 VGND 0.00443f $ **FLOATING
C1166 VPWR.n858 VGND 0.00443f $ **FLOATING
C1167 VPWR.n859 VGND 0.00443f $ **FLOATING
C1168 VPWR.n860 VGND 0.00443f $ **FLOATING
C1169 VPWR.n861 VGND 0.00443f $ **FLOATING
C1170 VPWR.n862 VGND 0.00443f $ **FLOATING
C1171 VPWR.n863 VGND 0.00443f $ **FLOATING
C1172 VPWR.n864 VGND 0.00443f $ **FLOATING
C1173 VPWR.n865 VGND 0.00443f $ **FLOATING
C1174 VPWR.n866 VGND 0.0101f $ **FLOATING
C1175 VPWR.n867 VGND 0.0101f $ **FLOATING
C1176 VPWR.n869 VGND 0.30872f $ **FLOATING
C1177 VPWR.n870 VGND 0.4494f $ **FLOATING
C1178 VPWR.n872 VGND 0.0101f $ **FLOATING
C1179 VPWR.n873 VGND 0.0101f $ **FLOATING
C1180 VPWR.n874 VGND 0.00998f $ **FLOATING
C1181 VPWR.n875 VGND 0.00443f $ **FLOATING
C1182 VPWR.n877 VGND 0.00443f $ **FLOATING
C1183 VPWR.n878 VGND 0.00443f $ **FLOATING
C1184 VPWR.n879 VGND 0.00443f $ **FLOATING
C1185 VPWR.n880 VGND 0.00443f $ **FLOATING
C1186 VPWR.n881 VGND 0.00443f $ **FLOATING
C1187 VPWR.n882 VGND 0.00443f $ **FLOATING
C1188 VPWR.n883 VGND 0.00443f $ **FLOATING
C1189 VPWR.n884 VGND 0.00443f $ **FLOATING
C1190 VPWR.n885 VGND 0.00443f $ **FLOATING
C1191 VPWR.n886 VGND 0.00443f $ **FLOATING
C1192 VPWR.n888 VGND 0.00443f $ **FLOATING
C1193 VPWR.n889 VGND 0.00443f $ **FLOATING
C1194 VPWR.n890 VGND 0.00443f $ **FLOATING
C1195 VPWR.n891 VGND 0.00443f $ **FLOATING
C1196 VPWR.n892 VGND 0.00443f $ **FLOATING
C1197 VPWR.n894 VGND 0.00443f $ **FLOATING
C1198 VPWR.n896 VGND 0.00443f $ **FLOATING
C1199 VPWR.n897 VGND 0.00443f $ **FLOATING
C1200 VPWR.n898 VGND 0.00443f $ **FLOATING
C1201 VPWR.n899 VGND 0.00443f $ **FLOATING
C1202 VPWR.n900 VGND 0.00443f $ **FLOATING
C1203 VPWR.n902 VGND 0.00443f $ **FLOATING
C1204 VPWR.n904 VGND 0.00443f $ **FLOATING
C1205 VPWR.n905 VGND 0.00443f $ **FLOATING
C1206 VPWR.n906 VGND 0.00443f $ **FLOATING
C1207 VPWR.n907 VGND 0.00443f $ **FLOATING
C1208 VPWR.n908 VGND 0.00443f $ **FLOATING
C1209 VPWR.n910 VGND 0.00443f $ **FLOATING
C1210 VPWR.n912 VGND 0.00443f $ **FLOATING
C1211 VPWR.n913 VGND 0.00443f $ **FLOATING
C1212 VPWR.n914 VGND 0.00443f $ **FLOATING
C1213 VPWR.n915 VGND 0.00443f $ **FLOATING
C1214 VPWR.n916 VGND 0.00443f $ **FLOATING
C1215 VPWR.n918 VGND 0.00443f $ **FLOATING
C1216 VPWR.n920 VGND 0.00443f $ **FLOATING
C1217 VPWR.n921 VGND 0.00443f $ **FLOATING
C1218 VPWR.n922 VGND 0.00443f $ **FLOATING
C1219 VPWR.n923 VGND 0.00443f $ **FLOATING
C1220 VPWR.n924 VGND 0.00443f $ **FLOATING
C1221 VPWR.n926 VGND 0.00443f $ **FLOATING
C1222 VPWR.n927 VGND 0.00443f $ **FLOATING
C1223 VPWR.n928 VGND 0.00443f $ **FLOATING
C1224 VPWR.n929 VGND 0.00443f $ **FLOATING
C1225 VPWR.n930 VGND 0.00443f $ **FLOATING
C1226 VPWR.n931 VGND 0.00443f $ **FLOATING
C1227 VPWR.n933 VGND 0.00443f $ **FLOATING
C1228 VPWR.n934 VGND 0.00443f $ **FLOATING
C1229 VPWR.n935 VGND 0.0101f $ **FLOATING
C1230 VPWR.n936 VGND 0.00998f $ **FLOATING
C1231 VPWR.n937 VGND 0.00998f $ **FLOATING
C1232 VPWR.n938 VGND 0.30872f $ **FLOATING
C1233 VPWR.n939 VGND 0.00998f $ **FLOATING
C1234 VPWR.n940 VGND 0.00887f $ **FLOATING
C1235 VPWR.n941 VGND 1.41719f $ **FLOATING
C1236 VPWR.n942 VGND 0.00987f $ **FLOATING
C1237 VPWR.n943 VGND 0.00443f $ **FLOATING
C1238 VPWR.n944 VGND 0.01002f $ **FLOATING
C1239 VPWR.n946 VGND 0.00443f $ **FLOATING
C1240 VPWR.n947 VGND 0.06415f $ **FLOATING
C1241 VPWR.n948 VGND 0.10283f $ **FLOATING
C1242 VPWR.n949 VGND 0.00443f $ **FLOATING
C1243 VPWR.n950 VGND 0.00987f $ **FLOATING
C1244 VPWR.n951 VGND 0.00443f $ **FLOATING
C1245 VPWR.n952 VGND 0.00443f $ **FLOATING
C1246 VPWR.n953 VGND 0.06415f $ **FLOATING
C1247 VPWR.n954 VGND 0.00443f $ **FLOATING
C1248 VPWR.n955 VGND 0.00443f $ **FLOATING
C1249 VPWR.n956 VGND 0.00443f $ **FLOATING
C1250 VPWR.n957 VGND 0.06415f $ **FLOATING
C1251 VPWR.n958 VGND 0.00443f $ **FLOATING
C1252 VPWR.n959 VGND 0.00443f $ **FLOATING
C1253 VPWR.n960 VGND 0.00443f $ **FLOATING
C1254 VPWR.n961 VGND 0.06415f $ **FLOATING
C1255 VPWR.n962 VGND 0.00443f $ **FLOATING
C1256 VPWR.n963 VGND 0.00443f $ **FLOATING
C1257 VPWR.n964 VGND 0.00443f $ **FLOATING
C1258 VPWR.n965 VGND 0.06415f $ **FLOATING
C1259 VPWR.n966 VGND 0.00443f $ **FLOATING
C1260 VPWR.n967 VGND 0.00443f $ **FLOATING
C1261 VPWR.n968 VGND 0.00443f $ **FLOATING
C1262 VPWR.n969 VGND 0.06415f $ **FLOATING
C1263 VPWR.n970 VGND 0.00443f $ **FLOATING
C1264 VPWR.n971 VGND 0.00443f $ **FLOATING
C1265 VPWR.n972 VGND 0.00443f $ **FLOATING
C1266 VPWR.n973 VGND 0.06415f $ **FLOATING
C1267 VPWR.n974 VGND 0.00443f $ **FLOATING
C1268 VPWR.n975 VGND 0.00443f $ **FLOATING
C1269 VPWR.n976 VGND 0.00443f $ **FLOATING
C1270 VPWR.n977 VGND 0.04811f $ **FLOATING
C1271 VPWR.n978 VGND 0.00443f $ **FLOATING
C1272 VPWR.n979 VGND 0.00443f $ **FLOATING
C1273 VPWR.n980 VGND 0.00443f $ **FLOATING
C1274 VPWR.n981 VGND 0.06415f $ **FLOATING
C1275 VPWR.t6 VGND 0.03208f $ **FLOATING
C1276 VPWR.n982 VGND 0.00443f $ **FLOATING
C1277 VPWR.n983 VGND 0.00443f $ **FLOATING
C1278 VPWR.n984 VGND 0.00443f $ **FLOATING
C1279 VPWR.n985 VGND 0.06415f $ **FLOATING
C1280 VPWR.n986 VGND 0.00443f $ **FLOATING
C1281 VPWR.n987 VGND 0.00443f $ **FLOATING
C1282 VPWR.n988 VGND 0.00443f $ **FLOATING
C1283 VPWR.n989 VGND 0.06415f $ **FLOATING
C1284 VPWR.n990 VGND 0.00443f $ **FLOATING
C1285 VPWR.n991 VGND 0.00443f $ **FLOATING
C1286 VPWR.n992 VGND 0.00443f $ **FLOATING
C1287 VPWR.n993 VGND 0.06415f $ **FLOATING
C1288 VPWR.n994 VGND 0.00443f $ **FLOATING
C1289 VPWR.n995 VGND 0.00443f $ **FLOATING
C1290 VPWR.n996 VGND 0.00443f $ **FLOATING
C1291 VPWR.n997 VGND 0.06415f $ **FLOATING
C1292 VPWR.n998 VGND 0.00443f $ **FLOATING
C1293 VPWR.n999 VGND 0.00443f $ **FLOATING
C1294 VPWR.n1000 VGND 0.00443f $ **FLOATING
C1295 VPWR.n1001 VGND 0.06415f $ **FLOATING
C1296 VPWR.n1002 VGND 0.00443f $ **FLOATING
C1297 VPWR.n1003 VGND 0.00443f $ **FLOATING
C1298 VPWR.n1004 VGND 0.00443f $ **FLOATING
C1299 VPWR.n1005 VGND 0.06415f $ **FLOATING
C1300 VPWR.n1006 VGND 0.00443f $ **FLOATING
C1301 VPWR.n1007 VGND 0.01002f $ **FLOATING
C1302 VPWR.n1008 VGND 0.01002f $ **FLOATING
C1303 VPWR.n1009 VGND 0.08491f $ **FLOATING
C1304 VPWR.n1010 VGND 0.01002f $ **FLOATING
C1305 VPWR.n1011 VGND 0.00443f $ **FLOATING
C1306 VPWR.n1012 VGND 0.00443f $ **FLOATING
C1307 VPWR.n1013 VGND 0.00987f $ **FLOATING
C1308 VPWR.n1014 VGND 0.00987f $ **FLOATING
C1309 VPWR.n1016 VGND 0.10283f $ **FLOATING
C1310 VPWR.n1017 VGND 0.00987f $ **FLOATING
C1311 VPWR.n1018 VGND 0.00987f $ **FLOATING
C1312 VPWR.n1019 VGND 0.01002f $ **FLOATING
C1313 VPWR.n1020 VGND 0.00443f $ **FLOATING
C1314 VPWR.n1021 VGND 0.00443f $ **FLOATING
C1315 VPWR.n1022 VGND 0.06415f $ **FLOATING
C1316 VPWR.n1023 VGND 0.00443f $ **FLOATING
C1317 VPWR.n1024 VGND 0.00443f $ **FLOATING
C1318 VPWR.n1025 VGND 0.00443f $ **FLOATING
C1319 VPWR.n1026 VGND 0.00443f $ **FLOATING
C1320 VPWR.n1027 VGND 0.00443f $ **FLOATING
C1321 VPWR.n1028 VGND 0.06415f $ **FLOATING
C1322 VPWR.n1029 VGND 0.00443f $ **FLOATING
C1323 VPWR.n1030 VGND 0.00443f $ **FLOATING
C1324 VPWR.n1031 VGND 0.00443f $ **FLOATING
C1325 VPWR.n1032 VGND 0.00443f $ **FLOATING
C1326 VPWR.n1033 VGND 0.00443f $ **FLOATING
C1327 VPWR.n1034 VGND 0.06415f $ **FLOATING
C1328 VPWR.n1035 VGND 0.00443f $ **FLOATING
C1329 VPWR.n1036 VGND 0.00443f $ **FLOATING
C1330 VPWR.n1037 VGND 0.00443f $ **FLOATING
C1331 VPWR.n1038 VGND 0.00443f $ **FLOATING
C1332 VPWR.n1039 VGND 0.00443f $ **FLOATING
C1333 VPWR.n1040 VGND 0.06415f $ **FLOATING
C1334 VPWR.n1041 VGND 0.00443f $ **FLOATING
C1335 VPWR.n1042 VGND 0.00443f $ **FLOATING
C1336 VPWR.n1043 VGND 0.00443f $ **FLOATING
C1337 VPWR.n1044 VGND 0.00443f $ **FLOATING
C1338 VPWR.n1045 VGND 0.00443f $ **FLOATING
C1339 VPWR.n1046 VGND 0.06415f $ **FLOATING
C1340 VPWR.n1047 VGND 0.00443f $ **FLOATING
C1341 VPWR.n1048 VGND 0.00443f $ **FLOATING
C1342 VPWR.n1049 VGND 0.00443f $ **FLOATING
C1343 VPWR.n1050 VGND 0.00443f $ **FLOATING
C1344 VPWR.n1051 VGND 0.00443f $ **FLOATING
C1345 VPWR.n1052 VGND 0.06415f $ **FLOATING
C1346 VPWR.n1053 VGND 0.00443f $ **FLOATING
C1347 VPWR.n1054 VGND 0.00443f $ **FLOATING
C1348 VPWR.n1055 VGND 0.00443f $ **FLOATING
C1349 VPWR.n1056 VGND 0.00443f $ **FLOATING
C1350 VPWR.n1057 VGND 0.00443f $ **FLOATING
C1351 VPWR.n1058 VGND 0.06415f $ **FLOATING
C1352 VPWR.n1059 VGND 0.00443f $ **FLOATING
C1353 VPWR.n1060 VGND 0.00443f $ **FLOATING
C1354 VPWR.n1061 VGND 0.00443f $ **FLOATING
C1355 VPWR.n1062 VGND 0.00443f $ **FLOATING
C1356 VPWR.n1063 VGND 0.00443f $ **FLOATING
C1357 VPWR.n1064 VGND 0.04811f $ **FLOATING
C1358 VPWR.n1065 VGND 0.00443f $ **FLOATING
C1359 VPWR.n1066 VGND 0.00443f $ **FLOATING
C1360 VPWR.n1067 VGND 0.00443f $ **FLOATING
C1361 VPWR.n1068 VGND 0.00443f $ **FLOATING
C1362 VPWR.n1069 VGND 0.00443f $ **FLOATING
C1363 VPWR.n1070 VGND 0.06415f $ **FLOATING
C1364 VPWR.n1071 VGND 0.00443f $ **FLOATING
C1365 VPWR.n1072 VGND 0.00443f $ **FLOATING
C1366 VPWR.n1073 VGND 0.00443f $ **FLOATING
C1367 VPWR.n1074 VGND 0.00443f $ **FLOATING
C1368 VPWR.n1075 VGND 0.00443f $ **FLOATING
C1369 VPWR.n1076 VGND 0.06415f $ **FLOATING
C1370 VPWR.n1077 VGND 0.00443f $ **FLOATING
C1371 VPWR.n1078 VGND 0.00443f $ **FLOATING
C1372 VPWR.n1079 VGND 0.00443f $ **FLOATING
C1373 VPWR.n1080 VGND 0.00443f $ **FLOATING
C1374 VPWR.n1081 VGND 0.00443f $ **FLOATING
C1375 VPWR.n1082 VGND 0.06415f $ **FLOATING
C1376 VPWR.n1083 VGND 0.00443f $ **FLOATING
C1377 VPWR.n1084 VGND 0.00443f $ **FLOATING
C1378 VPWR.n1085 VGND 0.00443f $ **FLOATING
C1379 VPWR.n1086 VGND 0.00443f $ **FLOATING
C1380 VPWR.n1087 VGND 0.00443f $ **FLOATING
C1381 VPWR.n1088 VGND 0.06415f $ **FLOATING
C1382 VPWR.n1089 VGND 0.00443f $ **FLOATING
C1383 VPWR.n1090 VGND 0.00443f $ **FLOATING
C1384 VPWR.n1091 VGND 0.00443f $ **FLOATING
C1385 VPWR.n1092 VGND 0.00443f $ **FLOATING
C1386 VPWR.n1093 VGND 0.00443f $ **FLOATING
C1387 VPWR.n1094 VGND 0.06415f $ **FLOATING
C1388 VPWR.n1095 VGND 0.00443f $ **FLOATING
C1389 VPWR.n1096 VGND 0.00443f $ **FLOATING
C1390 VPWR.n1097 VGND 0.00443f $ **FLOATING
C1391 VPWR.n1098 VGND 0.00443f $ **FLOATING
C1392 VPWR.n1099 VGND 0.00443f $ **FLOATING
C1393 VPWR.n1100 VGND 0.06415f $ **FLOATING
C1394 VPWR.n1101 VGND 0.00443f $ **FLOATING
C1395 VPWR.n1102 VGND 0.00443f $ **FLOATING
C1396 VPWR.n1103 VGND 0.00443f $ **FLOATING
C1397 VPWR.n1104 VGND 0.00443f $ **FLOATING
C1398 VPWR.n1105 VGND 0.00443f $ **FLOATING
C1399 VPWR.n1106 VGND 0.00443f $ **FLOATING
C1400 VPWR.n1107 VGND 0.06415f $ **FLOATING
C1401 VPWR.n1108 VGND 0.00443f $ **FLOATING
C1402 VPWR.n1109 VGND 0.00443f $ **FLOATING
C1403 VPWR.n1110 VGND 0.00443f $ **FLOATING
C1404 VPWR.n1111 VGND 0.01002f $ **FLOATING
C1405 VPWR.n1112 VGND 0.01002f $ **FLOATING
C1406 VPWR.n1113 VGND 0.08491f $ **FLOATING
C1407 VPWR.n1114 VGND 0.01002f $ **FLOATING
C1408 VPWR.n1115 VGND 0.00987f $ **FLOATING
C1409 VPWR.n1116 VGND 0.00987f $ **FLOATING
C1410 VPWR.n1117 VGND 1.35894f $ **FLOATING
C1411 VPWR.n1118 VGND 0.0115f $ **FLOATING
C1412 VPWR.t7 VGND 0.05561f $ **FLOATING
C1413 VPWR.n1119 VGND 0.17478f $ **FLOATING
C1414 VPWR.n1120 VGND 0.03616f $ **FLOATING
C1415 VPWR.n1121 VGND 0.62531f $ **FLOATING
C1416 VPWR.n1122 VGND 0.55454f $ **FLOATING
C1417 VPWR.n1123 VGND 0.00887f $ **FLOATING
C1418 VPWR.n1124 VGND 0.0101f $ **FLOATING
C1419 VPWR.n1125 VGND 0.00998f $ **FLOATING
C1420 VPWR.n1126 VGND 0.0101f $ **FLOATING
C1421 VPWR.t27 VGND 0.13287f $ **FLOATING
C1422 VPWR.n1127 VGND 0.4494f $ **FLOATING
C1423 VPWR.n1128 VGND 0.00998f $ **FLOATING
C1424 VPWR.n1129 VGND 0.0101f $ **FLOATING
C1425 VPWR.n1130 VGND 0.00443f $ **FLOATING
C1426 VPWR.n1131 VGND 0.00443f $ **FLOATING
C1427 VPWR.n1143 VGND 0.00443f $ **FLOATING
C1428 VPWR.n1144 VGND 0.00443f $ **FLOATING
C1429 VPWR.n1145 VGND 0.00443f $ **FLOATING
C1430 VPWR.n1146 VGND 0.00443f $ **FLOATING
C1431 VPWR.n1147 VGND 0.00443f $ **FLOATING
C1432 VPWR.n1148 VGND 0.00443f $ **FLOATING
C1433 VPWR.n1149 VGND 0.00443f $ **FLOATING
C1434 VPWR.n1150 VGND 0.00443f $ **FLOATING
C1435 VPWR.n1151 VGND 0.00443f $ **FLOATING
C1436 VPWR.n1152 VGND 0.00443f $ **FLOATING
C1437 VPWR.n1153 VGND 0.00443f $ **FLOATING
C1438 VPWR.n1154 VGND 0.00443f $ **FLOATING
C1439 VPWR.n1155 VGND 0.00443f $ **FLOATING
C1440 VPWR.n1156 VGND 0.00443f $ **FLOATING
C1441 VPWR.n1157 VGND 0.00443f $ **FLOATING
C1442 VPWR.n1158 VGND 0.00443f $ **FLOATING
C1443 VPWR.n1159 VGND 0.00443f $ **FLOATING
C1444 VPWR.n1160 VGND 0.00443f $ **FLOATING
C1445 VPWR.n1161 VGND 0.00443f $ **FLOATING
C1446 VPWR.n1162 VGND 0.00443f $ **FLOATING
C1447 VPWR.n1163 VGND 0.00443f $ **FLOATING
C1448 VPWR.n1164 VGND 0.00443f $ **FLOATING
C1449 VPWR.n1165 VGND 0.00443f $ **FLOATING
C1450 VPWR.n1166 VGND 0.00443f $ **FLOATING
C1451 VPWR.n1167 VGND 0.00443f $ **FLOATING
C1452 VPWR.n1168 VGND 0.00443f $ **FLOATING
C1453 VPWR.n1169 VGND 0.00443f $ **FLOATING
C1454 VPWR.n1170 VGND 0.00443f $ **FLOATING
C1455 VPWR.n1171 VGND 0.00443f $ **FLOATING
C1456 VPWR.n1172 VGND 0.00443f $ **FLOATING
C1457 VPWR.n1173 VGND 0.00443f $ **FLOATING
C1458 VPWR.n1174 VGND 0.00443f $ **FLOATING
C1459 VPWR.n1175 VGND 0.00443f $ **FLOATING
C1460 VPWR.n1176 VGND 0.00443f $ **FLOATING
C1461 VPWR.n1177 VGND 0.00443f $ **FLOATING
C1462 VPWR.n1178 VGND 0.00443f $ **FLOATING
C1463 VPWR.n1179 VGND 0.00443f $ **FLOATING
C1464 VPWR.n1180 VGND 0.00443f $ **FLOATING
C1465 VPWR.n1181 VGND 0.00443f $ **FLOATING
C1466 VPWR.n1182 VGND 0.00443f $ **FLOATING
C1467 VPWR.n1183 VGND 0.00443f $ **FLOATING
C1468 VPWR.n1184 VGND 0.00443f $ **FLOATING
C1469 VPWR.n1185 VGND 0.00443f $ **FLOATING
C1470 VPWR.n1186 VGND 0.00443f $ **FLOATING
C1471 VPWR.n1187 VGND 0.00443f $ **FLOATING
C1472 VPWR.n1188 VGND 0.00443f $ **FLOATING
C1473 VPWR.n1189 VGND 0.0101f $ **FLOATING
C1474 VPWR.n1190 VGND 0.0101f $ **FLOATING
C1475 VPWR.n1192 VGND 0.30872f $ **FLOATING
C1476 VPWR.n1193 VGND 0.4494f $ **FLOATING
C1477 VPWR.n1195 VGND 0.0101f $ **FLOATING
C1478 VPWR.n1196 VGND 0.0101f $ **FLOATING
C1479 VPWR.n1197 VGND 0.00998f $ **FLOATING
C1480 VPWR.n1198 VGND 0.00443f $ **FLOATING
C1481 VPWR.n1200 VGND 0.00443f $ **FLOATING
C1482 VPWR.n1201 VGND 0.00443f $ **FLOATING
C1483 VPWR.n1202 VGND 0.00443f $ **FLOATING
C1484 VPWR.n1203 VGND 0.00443f $ **FLOATING
C1485 VPWR.n1204 VGND 0.00443f $ **FLOATING
C1486 VPWR.n1205 VGND 0.00443f $ **FLOATING
C1487 VPWR.n1206 VGND 0.00443f $ **FLOATING
C1488 VPWR.n1207 VGND 0.00443f $ **FLOATING
C1489 VPWR.n1208 VGND 0.00443f $ **FLOATING
C1490 VPWR.n1209 VGND 0.00443f $ **FLOATING
C1491 VPWR.n1211 VGND 0.00443f $ **FLOATING
C1492 VPWR.n1212 VGND 0.00443f $ **FLOATING
C1493 VPWR.n1213 VGND 0.00443f $ **FLOATING
C1494 VPWR.n1214 VGND 0.00443f $ **FLOATING
C1495 VPWR.n1215 VGND 0.00443f $ **FLOATING
C1496 VPWR.n1217 VGND 0.00443f $ **FLOATING
C1497 VPWR.n1219 VGND 0.00443f $ **FLOATING
C1498 VPWR.n1220 VGND 0.00443f $ **FLOATING
C1499 VPWR.n1221 VGND 0.00443f $ **FLOATING
C1500 VPWR.n1222 VGND 0.00443f $ **FLOATING
C1501 VPWR.n1223 VGND 0.00443f $ **FLOATING
C1502 VPWR.n1225 VGND 0.00443f $ **FLOATING
C1503 VPWR.n1227 VGND 0.00443f $ **FLOATING
C1504 VPWR.n1228 VGND 0.00443f $ **FLOATING
C1505 VPWR.n1229 VGND 0.00443f $ **FLOATING
C1506 VPWR.n1230 VGND 0.00443f $ **FLOATING
C1507 VPWR.n1231 VGND 0.00443f $ **FLOATING
C1508 VPWR.n1233 VGND 0.00443f $ **FLOATING
C1509 VPWR.n1235 VGND 0.00443f $ **FLOATING
C1510 VPWR.n1236 VGND 0.00443f $ **FLOATING
C1511 VPWR.n1237 VGND 0.00443f $ **FLOATING
C1512 VPWR.n1238 VGND 0.00443f $ **FLOATING
C1513 VPWR.n1239 VGND 0.00443f $ **FLOATING
C1514 VPWR.n1241 VGND 0.00443f $ **FLOATING
C1515 VPWR.n1243 VGND 0.00443f $ **FLOATING
C1516 VPWR.n1244 VGND 0.00443f $ **FLOATING
C1517 VPWR.n1245 VGND 0.00443f $ **FLOATING
C1518 VPWR.n1246 VGND 0.00443f $ **FLOATING
C1519 VPWR.n1247 VGND 0.00443f $ **FLOATING
C1520 VPWR.n1249 VGND 0.00443f $ **FLOATING
C1521 VPWR.n1250 VGND 0.00443f $ **FLOATING
C1522 VPWR.n1251 VGND 0.00443f $ **FLOATING
C1523 VPWR.n1252 VGND 0.00443f $ **FLOATING
C1524 VPWR.n1253 VGND 0.00443f $ **FLOATING
C1525 VPWR.n1254 VGND 0.00443f $ **FLOATING
C1526 VPWR.n1256 VGND 0.00443f $ **FLOATING
C1527 VPWR.n1257 VGND 0.00443f $ **FLOATING
C1528 VPWR.n1258 VGND 0.0101f $ **FLOATING
C1529 VPWR.n1259 VGND 0.00998f $ **FLOATING
C1530 VPWR.n1260 VGND 0.00998f $ **FLOATING
C1531 VPWR.n1261 VGND 0.30872f $ **FLOATING
C1532 VPWR.n1262 VGND 0.00998f $ **FLOATING
C1533 VPWR.n1263 VGND 0.00887f $ **FLOATING
C1534 VPWR.n1264 VGND 1.41719f $ **FLOATING
C1535 VPWR.n1265 VGND 0.00987f $ **FLOATING
C1536 VPWR.n1266 VGND 0.00443f $ **FLOATING
C1537 VPWR.n1267 VGND 0.01002f $ **FLOATING
C1538 VPWR.n1269 VGND 0.00443f $ **FLOATING
C1539 VPWR.n1270 VGND 0.06415f $ **FLOATING
C1540 VPWR.n1271 VGND 0.10283f $ **FLOATING
C1541 VPWR.n1272 VGND 0.00443f $ **FLOATING
C1542 VPWR.n1273 VGND 0.00987f $ **FLOATING
C1543 VPWR.n1274 VGND 0.00443f $ **FLOATING
C1544 VPWR.n1275 VGND 0.00443f $ **FLOATING
C1545 VPWR.n1276 VGND 0.06415f $ **FLOATING
C1546 VPWR.n1277 VGND 0.00443f $ **FLOATING
C1547 VPWR.n1278 VGND 0.00443f $ **FLOATING
C1548 VPWR.n1279 VGND 0.00443f $ **FLOATING
C1549 VPWR.n1280 VGND 0.06415f $ **FLOATING
C1550 VPWR.n1281 VGND 0.00443f $ **FLOATING
C1551 VPWR.n1282 VGND 0.00443f $ **FLOATING
C1552 VPWR.n1283 VGND 0.00443f $ **FLOATING
C1553 VPWR.n1284 VGND 0.06415f $ **FLOATING
C1554 VPWR.n1285 VGND 0.00443f $ **FLOATING
C1555 VPWR.n1286 VGND 0.00443f $ **FLOATING
C1556 VPWR.n1287 VGND 0.00443f $ **FLOATING
C1557 VPWR.n1288 VGND 0.06415f $ **FLOATING
C1558 VPWR.n1289 VGND 0.00443f $ **FLOATING
C1559 VPWR.n1290 VGND 0.00443f $ **FLOATING
C1560 VPWR.n1291 VGND 0.00443f $ **FLOATING
C1561 VPWR.n1292 VGND 0.06415f $ **FLOATING
C1562 VPWR.n1293 VGND 0.00443f $ **FLOATING
C1563 VPWR.n1294 VGND 0.00443f $ **FLOATING
C1564 VPWR.n1295 VGND 0.00443f $ **FLOATING
C1565 VPWR.n1296 VGND 0.06415f $ **FLOATING
C1566 VPWR.n1297 VGND 0.00443f $ **FLOATING
C1567 VPWR.n1298 VGND 0.00443f $ **FLOATING
C1568 VPWR.n1299 VGND 0.00443f $ **FLOATING
C1569 VPWR.n1300 VGND 0.04811f $ **FLOATING
C1570 VPWR.n1301 VGND 0.00443f $ **FLOATING
C1571 VPWR.n1302 VGND 0.00443f $ **FLOATING
C1572 VPWR.n1303 VGND 0.00443f $ **FLOATING
C1573 VPWR.n1304 VGND 0.06415f $ **FLOATING
C1574 VPWR.t16 VGND 0.03208f $ **FLOATING
C1575 VPWR.n1305 VGND 0.00443f $ **FLOATING
C1576 VPWR.n1306 VGND 0.00443f $ **FLOATING
C1577 VPWR.n1307 VGND 0.00443f $ **FLOATING
C1578 VPWR.n1308 VGND 0.06415f $ **FLOATING
C1579 VPWR.n1309 VGND 0.00443f $ **FLOATING
C1580 VPWR.n1310 VGND 0.00443f $ **FLOATING
C1581 VPWR.n1311 VGND 0.00443f $ **FLOATING
C1582 VPWR.n1312 VGND 0.06415f $ **FLOATING
C1583 VPWR.n1313 VGND 0.00443f $ **FLOATING
C1584 VPWR.n1314 VGND 0.00443f $ **FLOATING
C1585 VPWR.n1315 VGND 0.00443f $ **FLOATING
C1586 VPWR.n1316 VGND 0.06415f $ **FLOATING
C1587 VPWR.n1317 VGND 0.00443f $ **FLOATING
C1588 VPWR.n1318 VGND 0.00443f $ **FLOATING
C1589 VPWR.n1319 VGND 0.00443f $ **FLOATING
C1590 VPWR.n1320 VGND 0.06415f $ **FLOATING
C1591 VPWR.n1321 VGND 0.00443f $ **FLOATING
C1592 VPWR.n1322 VGND 0.00443f $ **FLOATING
C1593 VPWR.n1323 VGND 0.00443f $ **FLOATING
C1594 VPWR.n1324 VGND 0.06415f $ **FLOATING
C1595 VPWR.n1325 VGND 0.00443f $ **FLOATING
C1596 VPWR.n1326 VGND 0.00443f $ **FLOATING
C1597 VPWR.n1327 VGND 0.00443f $ **FLOATING
C1598 VPWR.n1328 VGND 0.06415f $ **FLOATING
C1599 VPWR.n1329 VGND 0.00443f $ **FLOATING
C1600 VPWR.n1330 VGND 0.01002f $ **FLOATING
C1601 VPWR.n1331 VGND 0.01002f $ **FLOATING
C1602 VPWR.n1332 VGND 0.08491f $ **FLOATING
C1603 VPWR.n1333 VGND 0.01002f $ **FLOATING
C1604 VPWR.n1334 VGND 0.00443f $ **FLOATING
C1605 VPWR.n1335 VGND 0.00443f $ **FLOATING
C1606 VPWR.n1336 VGND 0.00987f $ **FLOATING
C1607 VPWR.n1337 VGND 0.00987f $ **FLOATING
C1608 VPWR.n1339 VGND 0.10283f $ **FLOATING
C1609 VPWR.n1340 VGND 0.00987f $ **FLOATING
C1610 VPWR.n1341 VGND 0.00987f $ **FLOATING
C1611 VPWR.n1342 VGND 0.01002f $ **FLOATING
C1612 VPWR.n1343 VGND 0.00443f $ **FLOATING
C1613 VPWR.n1344 VGND 0.00443f $ **FLOATING
C1614 VPWR.n1345 VGND 0.06415f $ **FLOATING
C1615 VPWR.n1346 VGND 0.00443f $ **FLOATING
C1616 VPWR.n1347 VGND 0.00443f $ **FLOATING
C1617 VPWR.n1348 VGND 0.00443f $ **FLOATING
C1618 VPWR.n1349 VGND 0.00443f $ **FLOATING
C1619 VPWR.n1350 VGND 0.00443f $ **FLOATING
C1620 VPWR.n1351 VGND 0.06415f $ **FLOATING
C1621 VPWR.n1352 VGND 0.00443f $ **FLOATING
C1622 VPWR.n1353 VGND 0.00443f $ **FLOATING
C1623 VPWR.n1354 VGND 0.00443f $ **FLOATING
C1624 VPWR.n1355 VGND 0.00443f $ **FLOATING
C1625 VPWR.n1356 VGND 0.00443f $ **FLOATING
C1626 VPWR.n1357 VGND 0.06415f $ **FLOATING
C1627 VPWR.n1358 VGND 0.00443f $ **FLOATING
C1628 VPWR.n1359 VGND 0.00443f $ **FLOATING
C1629 VPWR.n1360 VGND 0.00443f $ **FLOATING
C1630 VPWR.n1361 VGND 0.00443f $ **FLOATING
C1631 VPWR.n1362 VGND 0.00443f $ **FLOATING
C1632 VPWR.n1363 VGND 0.06415f $ **FLOATING
C1633 VPWR.n1364 VGND 0.00443f $ **FLOATING
C1634 VPWR.n1365 VGND 0.00443f $ **FLOATING
C1635 VPWR.n1366 VGND 0.00443f $ **FLOATING
C1636 VPWR.n1367 VGND 0.00443f $ **FLOATING
C1637 VPWR.n1368 VGND 0.00443f $ **FLOATING
C1638 VPWR.n1369 VGND 0.06415f $ **FLOATING
C1639 VPWR.n1370 VGND 0.00443f $ **FLOATING
C1640 VPWR.n1371 VGND 0.00443f $ **FLOATING
C1641 VPWR.n1372 VGND 0.00443f $ **FLOATING
C1642 VPWR.n1373 VGND 0.00443f $ **FLOATING
C1643 VPWR.n1374 VGND 0.00443f $ **FLOATING
C1644 VPWR.n1375 VGND 0.06415f $ **FLOATING
C1645 VPWR.n1376 VGND 0.00443f $ **FLOATING
C1646 VPWR.n1377 VGND 0.00443f $ **FLOATING
C1647 VPWR.n1378 VGND 0.00443f $ **FLOATING
C1648 VPWR.n1379 VGND 0.00443f $ **FLOATING
C1649 VPWR.n1380 VGND 0.00443f $ **FLOATING
C1650 VPWR.n1381 VGND 0.06415f $ **FLOATING
C1651 VPWR.n1382 VGND 0.00443f $ **FLOATING
C1652 VPWR.n1383 VGND 0.00443f $ **FLOATING
C1653 VPWR.n1384 VGND 0.00443f $ **FLOATING
C1654 VPWR.n1385 VGND 0.00443f $ **FLOATING
C1655 VPWR.n1386 VGND 0.00443f $ **FLOATING
C1656 VPWR.n1387 VGND 0.04811f $ **FLOATING
C1657 VPWR.n1388 VGND 0.00443f $ **FLOATING
C1658 VPWR.n1389 VGND 0.00443f $ **FLOATING
C1659 VPWR.n1390 VGND 0.00443f $ **FLOATING
C1660 VPWR.n1391 VGND 0.00443f $ **FLOATING
C1661 VPWR.n1392 VGND 0.00443f $ **FLOATING
C1662 VPWR.n1393 VGND 0.06415f $ **FLOATING
C1663 VPWR.n1394 VGND 0.00443f $ **FLOATING
C1664 VPWR.n1395 VGND 0.00443f $ **FLOATING
C1665 VPWR.n1396 VGND 0.00443f $ **FLOATING
C1666 VPWR.n1397 VGND 0.00443f $ **FLOATING
C1667 VPWR.n1398 VGND 0.00443f $ **FLOATING
C1668 VPWR.n1399 VGND 0.06415f $ **FLOATING
C1669 VPWR.n1400 VGND 0.00443f $ **FLOATING
C1670 VPWR.n1401 VGND 0.00443f $ **FLOATING
C1671 VPWR.n1402 VGND 0.00443f $ **FLOATING
C1672 VPWR.n1403 VGND 0.00443f $ **FLOATING
C1673 VPWR.n1404 VGND 0.00443f $ **FLOATING
C1674 VPWR.n1405 VGND 0.06415f $ **FLOATING
C1675 VPWR.n1406 VGND 0.00443f $ **FLOATING
C1676 VPWR.n1407 VGND 0.00443f $ **FLOATING
C1677 VPWR.n1408 VGND 0.00443f $ **FLOATING
C1678 VPWR.n1409 VGND 0.00443f $ **FLOATING
C1679 VPWR.n1410 VGND 0.00443f $ **FLOATING
C1680 VPWR.n1411 VGND 0.06415f $ **FLOATING
C1681 VPWR.n1412 VGND 0.00443f $ **FLOATING
C1682 VPWR.n1413 VGND 0.00443f $ **FLOATING
C1683 VPWR.n1414 VGND 0.00443f $ **FLOATING
C1684 VPWR.n1415 VGND 0.00443f $ **FLOATING
C1685 VPWR.n1416 VGND 0.00443f $ **FLOATING
C1686 VPWR.n1417 VGND 0.06415f $ **FLOATING
C1687 VPWR.n1418 VGND 0.00443f $ **FLOATING
C1688 VPWR.n1419 VGND 0.00443f $ **FLOATING
C1689 VPWR.n1420 VGND 0.00443f $ **FLOATING
C1690 VPWR.n1421 VGND 0.00443f $ **FLOATING
C1691 VPWR.n1422 VGND 0.00443f $ **FLOATING
C1692 VPWR.n1423 VGND 0.06415f $ **FLOATING
C1693 VPWR.n1424 VGND 0.00443f $ **FLOATING
C1694 VPWR.n1425 VGND 0.00443f $ **FLOATING
C1695 VPWR.n1426 VGND 0.00443f $ **FLOATING
C1696 VPWR.n1427 VGND 0.00443f $ **FLOATING
C1697 VPWR.n1428 VGND 0.00443f $ **FLOATING
C1698 VPWR.n1429 VGND 0.00443f $ **FLOATING
C1699 VPWR.n1430 VGND 0.06415f $ **FLOATING
C1700 VPWR.n1431 VGND 0.00443f $ **FLOATING
C1701 VPWR.n1432 VGND 0.00443f $ **FLOATING
C1702 VPWR.n1433 VGND 0.00443f $ **FLOATING
C1703 VPWR.n1434 VGND 0.01002f $ **FLOATING
C1704 VPWR.n1435 VGND 0.01002f $ **FLOATING
C1705 VPWR.n1436 VGND 0.08491f $ **FLOATING
C1706 VPWR.n1437 VGND 0.01002f $ **FLOATING
C1707 VPWR.n1438 VGND 0.00987f $ **FLOATING
C1708 VPWR.n1439 VGND 0.00987f $ **FLOATING
C1709 VPWR.n1440 VGND 1.35894f $ **FLOATING
C1710 VPWR.n1441 VGND 0.0115f $ **FLOATING
C1711 VPWR.t17 VGND 0.05561f $ **FLOATING
C1712 VPWR.n1442 VGND 0.17478f $ **FLOATING
C1713 VPWR.n1443 VGND 0.03616f $ **FLOATING
C1714 VPWR.n1444 VGND 0.62531f $ **FLOATING
C1715 VPWR.n1445 VGND 1.28333f $ **FLOATING
C1716 PD.n0 VGND 0.00508f $ **FLOATING
C1717 PD.t3 VGND 0.71054f $ **FLOATING
C1718 PD.n1 VGND 0.00508f $ **FLOATING
C1719 PD.t2 VGND 0.01556f $ **FLOATING
C1720 PD.n2 VGND 0.00508f $ **FLOATING
C1721 PD.n3 VGND 0.4255f $ **FLOATING
C1722 PD.n4 VGND 0.0058f $ **FLOATING
C1723 PD.t1 VGND 0.01411f $ **FLOATING
C1724 PD.n5 VGND 0.0058f $ **FLOATING
C1725 PD.n6 VGND 0.39796f $ **FLOATING
C1726 PD.n7 VGND 1.28844f $ **FLOATING
C1727 PD.n8 VGND 1.7943f $ **FLOATING
C1728 PD.n9 VGND 0.39796f $ **FLOATING
C1729 PD.t0 VGND 0.01556f $ **FLOATING
C1730 PD.n10 VGND 0.00508f $ **FLOATING
C1731 PHASE_DETECTOR__N2.n0 VGND 0.00878f $ **FLOATING
C1732 PHASE_DETECTOR__N2.t4 VGND 0.03629f $ **FLOATING
C1733 PHASE_DETECTOR__N2.t3 VGND 0.03771f $ **FLOATING
C1734 PHASE_DETECTOR__N2.n1 VGND 4.28784f $ **FLOATING
C1735 PHASE_DETECTOR__N2.n2 VGND 0.00878f $ **FLOATING
C1736 PHASE_DETECTOR__N2.t1 VGND 0.0269f $ **FLOATING
C1737 PHASE_DETECTOR__N2.n3 VGND 0.00878f $ **FLOATING
C1738 PHASE_DETECTOR__N2.n4 VGND 0.76955f $ **FLOATING
C1739 PHASE_DETECTOR__N2.n5 VGND 0.01003f $ **FLOATING
C1740 PHASE_DETECTOR__N2.t2 VGND 0.0244f $ **FLOATING
C1741 PHASE_DETECTOR__N2.n6 VGND 0.01003f $ **FLOATING
C1742 PHASE_DETECTOR__N2.n7 VGND 0.72136f $ **FLOATING
C1743 PHASE_DETECTOR__N2.n8 VGND 2.30092f $ **FLOATING
C1744 PHASE_DETECTOR__N2.n9 VGND 2.52703f $ **FLOATING
C1745 PHASE_DETECTOR__N2.n10 VGND 0.72136f $ **FLOATING
C1746 PHASE_DETECTOR__N2.t0 VGND 0.0269f $ **FLOATING
C1747 PHASE_DETECTOR__N2.n11 VGND 0.00878f $ **FLOATING
rmesh_equiv_0 ctrl ctrl.n0 13.8079
rmesh_equiv_1 ctrl ctrl.n1 4.1357100000000004
rmesh_equiv_10 ctrl ctrl.t5 0.00141837
rmesh_equiv_100 oscillator__p2.n1 oscillator__p2.t0 3.5711299999999997
rmesh_equiv_1000 vpwr.n1069 vpwr.n972 240
rmesh_equiv_1001 vpwr.n1069 vpwr.n978 240
rmesh_equiv_1002 vpwr.n107 vpwr.n108 185
rmesh_equiv_1003 vpwr.n107 vpwr.n81 25.6005
rmesh_equiv_1004 vpwr.n1070 vpwr.n1071 185
rmesh_equiv_1005 vpwr.n1070 vpwr.n973 131.30199999999999
rmesh_equiv_1006 vpwr.n1070 vpwr.n977 131.30199999999999
rmesh_equiv_1007 vpwr.n1071 vpwr.n1072 185
rmesh_equiv_1008 vpwr.n1071 vpwr.n974 240
rmesh_equiv_1009 vpwr.n1071 vpwr.n976 240
rmesh_equiv_101 oscillator__p2.n2 oscillator__p2.n3 43.578400000000002
rmesh_equiv_1010 vpwr.n1072 vpwr.n1073 25.6005
rmesh_equiv_1011 vpwr.n1072 vpwr.n975 25.6005
rmesh_equiv_1012 vpwr.n1073 vpwr.n1074 25.6005
rmesh_equiv_1013 vpwr.n1073 vpwr.n974 185
rmesh_equiv_1014 vpwr.n1074 vpwr.n1075 185
rmesh_equiv_1015 vpwr.n1074 vpwr.n967 25.6005
rmesh_equiv_1016 vpwr.n1075 vpwr.n1076 185
rmesh_equiv_1017 vpwr.n1075 vpwr.n968 240
rmesh_equiv_1018 vpwr.n1075 vpwr.n974 240
rmesh_equiv_1019 vpwr.n1076 vpwr.n1077 185
rmesh_equiv_102 oscillator__p2.n2 oscillator__p2.n5 0.234454
rmesh_equiv_1020 vpwr.n1076 vpwr.n969 131.30199999999999
rmesh_equiv_1021 vpwr.n1076 vpwr.n973 131.30199999999999
rmesh_equiv_1022 vpwr.n1077 vpwr.n1078 185
rmesh_equiv_1023 vpwr.n1077 vpwr.n970 240
rmesh_equiv_1024 vpwr.n1077 vpwr.n972 240
rmesh_equiv_1025 vpwr.n1078 vpwr.n1079 25.6005
rmesh_equiv_1026 vpwr.n1078 vpwr.n971 25.6005
rmesh_equiv_1027 vpwr.n1079 vpwr.n1080 25.6005
rmesh_equiv_1028 vpwr.n1079 vpwr.n970 185
rmesh_equiv_1029 vpwr.n108 vpwr.n110 240.00290767186621
rmesh_equiv_103 oscillator__p2.n3 oscillator__p2.n4 37.816499999999998
rmesh_equiv_1030 vpwr.n108 vpwr.n4 185.00310000000002
rmesh_equiv_1031 vpwr.n108 vpwr.n82 240
rmesh_equiv_1032 vpwr.n1080 vpwr.n1081 185
rmesh_equiv_1033 vpwr.n1080 vpwr.n963 25.6005
rmesh_equiv_1034 vpwr.n1081 vpwr.n1082 185
rmesh_equiv_1035 vpwr.n1081 vpwr.n964 240
rmesh_equiv_1036 vpwr.n1081 vpwr.n970 240
rmesh_equiv_1037 vpwr.n1082 vpwr.n1083 185
rmesh_equiv_1038 vpwr.n1082 vpwr.n965 131.30199999999999
rmesh_equiv_1039 vpwr.n1082 vpwr.n969 131.30199999999999
rmesh_equiv_104 oscillator__p2.n3 oscillator__p2.t1 2.8570000000000002
rmesh_equiv_1040 vpwr.n1083 vpwr.n1084 185
rmesh_equiv_1041 vpwr.n1083 vpwr.n966 240
rmesh_equiv_1042 vpwr.n1083 vpwr.n968 240
rmesh_equiv_1043 vpwr.n1084 vpwr.n1085 25.6005
rmesh_equiv_1044 vpwr.n1084 vpwr.n967 25.6005
rmesh_equiv_1045 vpwr.n1085 vpwr.n1086 25.6005
rmesh_equiv_1046 vpwr.n1085 vpwr.n966 185
rmesh_equiv_1047 vpwr.n1086 vpwr.n1087 185
rmesh_equiv_1048 vpwr.n1086 vpwr.n959 25.6005
rmesh_equiv_1049 vpwr.n1087 vpwr.n1088 185
rmesh_equiv_105 oscillator__p2.n4 oscillator__p2.n5 3.2602699999999998
rmesh_equiv_1050 vpwr.n1087 vpwr.n960 240
rmesh_equiv_1051 vpwr.n1087 vpwr.n966 240
rmesh_equiv_1052 vpwr.n1088 vpwr.n1089 185
rmesh_equiv_1053 vpwr.n1088 vpwr.n961 131.30199999999999
rmesh_equiv_1054 vpwr.n1088 vpwr.n965 131.30199999999999
rmesh_equiv_1055 vpwr.n1089 vpwr.n1090 185
rmesh_equiv_1056 vpwr.n1089 vpwr.n962 240
rmesh_equiv_1057 vpwr.n1089 vpwr.n964 240
rmesh_equiv_1058 vpwr.n1090 vpwr.n1091 25.6005
rmesh_equiv_1059 vpwr.n1090 vpwr.n963 25.6005
rmesh_equiv_106 oscillator__p2.n5 oscillator__p2.n6 34.706800000000001
rmesh_equiv_1060 vpwr.n1091 vpwr.n1092 25.6005
rmesh_equiv_1061 vpwr.n1091 vpwr.n962 185
rmesh_equiv_1062 vpwr.n1092 vpwr.n1093 185
rmesh_equiv_1063 vpwr.n1092 vpwr.n955 25.6005
rmesh_equiv_1064 vpwr.n1093 vpwr.n1094 185
rmesh_equiv_1065 vpwr.n1093 vpwr.n956 240
rmesh_equiv_1066 vpwr.n1093 vpwr.n962 240
rmesh_equiv_1067 vpwr.n1094 vpwr.n1095 185
rmesh_equiv_1068 vpwr.n1094 vpwr.n957 131.30199999999999
rmesh_equiv_1069 vpwr.n1094 vpwr.n961 131.30199999999999
rmesh_equiv_107 oscillator__p2.n6 oscillator__p2.n7 2.38164
rmesh_equiv_1070 vpwr.n1095 vpwr.n1096 185
rmesh_equiv_1071 vpwr.n1095 vpwr.n958 240
rmesh_equiv_1072 vpwr.n1095 vpwr.n960 240
rmesh_equiv_1073 vpwr.n1096 vpwr.n1097 25.6005
rmesh_equiv_1074 vpwr.n1096 vpwr.n959 25.6005
rmesh_equiv_1075 vpwr.n1097 vpwr.n1098 25.6005
rmesh_equiv_1076 vpwr.n1097 vpwr.n958 185
rmesh_equiv_1077 vpwr.n1098 vpwr.n1099 185
rmesh_equiv_1078 vpwr.n1098 vpwr.n951 25.6005
rmesh_equiv_1079 vpwr.n1099 vpwr.n1100 185
rmesh_equiv_108 oscillator__pbias oscillator__pbias.n0 15.6333
rmesh_equiv_1080 vpwr.n1099 vpwr.n952 240
rmesh_equiv_1081 vpwr.n1099 vpwr.n958 240
rmesh_equiv_1082 vpwr.n110 vpwr.n112 240
rmesh_equiv_1083 vpwr.n110 vpwr.n4 185.00310000000002
rmesh_equiv_1084 vpwr.n110 vpwr.n81 185
rmesh_equiv_1085 vpwr.n1100 vpwr.n1101 185
rmesh_equiv_1086 vpwr.n1100 vpwr.n953 131.30199999999999
rmesh_equiv_1087 vpwr.n1100 vpwr.n957 131.30199999999999
rmesh_equiv_1088 vpwr.n1101 vpwr.n1102 185
rmesh_equiv_1089 vpwr.n1101 vpwr.n954 240
rmesh_equiv_109 oscillator__pbias oscillator__pbias.n1 17.748942653638046
rmesh_equiv_1090 vpwr.n1101 vpwr.n956 240
rmesh_equiv_1091 vpwr.n1102 vpwr.n1103 25.6005
rmesh_equiv_1092 vpwr.n1102 vpwr.n955 25.6005
rmesh_equiv_1093 vpwr.n1103 vpwr.n1105 25.6005
rmesh_equiv_1094 vpwr.n1103 vpwr.n954 185
rmesh_equiv_1095 vpwr.n1104 vpwr.n1105 25.6005
rmesh_equiv_1096 vpwr.n1104 vpwr.n944 25.6005
rmesh_equiv_1097 vpwr.n1104 vpwr.n946 185
rmesh_equiv_1098 vpwr.n1105 vpwr.n1106 185
rmesh_equiv_1099 vpwr.n1106 vpwr.n1107 185
rmesh_equiv_11 ctrl ctrl.t6 0.00141837
rmesh_equiv_110 oscillator__pbias oscillator__pbias.n10 15.6333
rmesh_equiv_1100 vpwr.n1106 vpwr.n946 240
rmesh_equiv_1101 vpwr.n1106 vpwr.n954 240
rmesh_equiv_1102 vpwr.n1107 vpwr.n1108 185
rmesh_equiv_1103 vpwr.n1107 vpwr.n947 131.30199999999999
rmesh_equiv_1104 vpwr.n1107 vpwr.n953 131.30199999999999
rmesh_equiv_1105 vpwr.n1108 vpwr.n1109 185
rmesh_equiv_1106 vpwr.n1108 vpwr.n949 240
rmesh_equiv_1107 vpwr.n1108 vpwr.n952 240
rmesh_equiv_1108 vpwr.n1109 vpwr.n1110 25.6005
rmesh_equiv_1109 vpwr.n1109 vpwr.n951 25.6005
rmesh_equiv_111 oscillator__pbias oscillator__pbias.n2 32.7376
rmesh_equiv_1110 vpwr.n1110 vpwr.n1111 25.6005
rmesh_equiv_1111 vpwr.n1110 vpwr.n949 185
rmesh_equiv_1112 vpwr.n1111 vpwr.n1112 185
rmesh_equiv_1113 vpwr.n1111 vpwr.n942 82.823999999999998
rmesh_equiv_1114 vpwr.n1112 vpwr.n1113 185
rmesh_equiv_1115 vpwr.n1112 vpwr.n949 240
rmesh_equiv_1116 vpwr.n1112 vpwr.n950 776.471
rmesh_equiv_1117 vpwr.n1113 vpwr.n1114 185
rmesh_equiv_1118 vpwr.n1113 vpwr.n947 131.30199999999999
rmesh_equiv_1119 vpwr.n1113 vpwr.n948 216.26100000000002
rmesh_equiv_112 oscillator__pbias oscillator__pbias.n3 6.5282000000000009
rmesh_equiv_1120 vpwr.n1114 vpwr.n1115 776.471
rmesh_equiv_1121 vpwr.n1114 vpwr.n944 185
rmesh_equiv_1122 vpwr.n1114 vpwr.n946 240
rmesh_equiv_1123 vpwr.n1115 vpwr.n1116 185
rmesh_equiv_1124 vpwr.n1115 vpwr.n943 240.00290767186621
rmesh_equiv_1125 vpwr.n1115 vpwr.n948 185.00310000000002
rmesh_equiv_1126 vpwr.n1116 vpwr.n944 82.823999999999998
rmesh_equiv_1127 vpwr.n1117 vpwr.n1122 0.12975
rmesh_equiv_1128 vpwr.n1117 vpwr.n941 5.1734400000000003
rmesh_equiv_1129 vpwr.n1118 vpwr.n1119 40.104900000000001
rmesh_equiv_113 oscillator__pbias oscillator__pbias.n5 33.414000000000001
rmesh_equiv_1130 vpwr.n1118 vpwr.n1121 0.72065299999999999
rmesh_equiv_1131 vpwr.n1119 vpwr.n1120 42.739100000000001
rmesh_equiv_1132 vpwr.n1119 vpwr.t7 2.8570000000000002
rmesh_equiv_1133 vpwr.n112 vpwr.n113 185
rmesh_equiv_1134 vpwr.n112 vpwr.n4 185.00310000000002
rmesh_equiv_1135 vpwr.n112 vpwr.n80 240.00290767186621
rmesh_equiv_1136 vpwr.n1120 vpwr.n1121 1.10033
rmesh_equiv_1137 vpwr.n1121 vpwr.n1122 18.497
rmesh_equiv_1138 vpwr.n1122 vpwr.n1264 0.70373699999999995
rmesh_equiv_1139 vpwr.n1123 vpwr.n1125 185
rmesh_equiv_114 oscillator__pbias oscillator__pbias.n7 32.7376
rmesh_equiv_1140 vpwr.n1123 vpwr.n1189 83.953400000000002
rmesh_equiv_1141 vpwr.n1124 vpwr.n1126 185
rmesh_equiv_1142 vpwr.n1124 vpwr.n1212 25.6005
rmesh_equiv_1143 vpwr.n1124 vpwr.n1263 83.953400000000002
rmesh_equiv_1144 vpwr.n1125 vpwr.n1190 787.05899999999997
rmesh_equiv_1145 vpwr.n1125 vpwr.n1192 185
rmesh_equiv_1146 vpwr.n1125 vpwr.n1262 240
rmesh_equiv_1147 vpwr.n1126 vpwr.n1127 185
rmesh_equiv_1148 vpwr.n1126 vpwr.n1211 240
rmesh_equiv_1149 vpwr.n1126 vpwr.n1262 787.05899999999997
rmesh_equiv_115 oscillator__pbias oscillator__pbias.t1 664.84799999999996
rmesh_equiv_1150 vpwr.n1127 vpwr.n1129 185.00310000000002
rmesh_equiv_1151 vpwr.n1127 vpwr.n1201 185.00310000000002
rmesh_equiv_1152 vpwr.n1127 vpwr.n1203 185.00310000000002
rmesh_equiv_1153 vpwr.n1127 vpwr.n1205 185.00310000000002
rmesh_equiv_1154 vpwr.n1127 vpwr.n1207 185.00310000000002
rmesh_equiv_1155 vpwr.n1127 vpwr.n1209 185.00310000000002
rmesh_equiv_1156 vpwr.n1127 vpwr.n1211 185.00310000000002
rmesh_equiv_1157 vpwr.n1127 vpwr.n1215 185.00310000000002
rmesh_equiv_1158 vpwr.n1127 vpwr.n1217 185.00310000000002
rmesh_equiv_1159 vpwr.n1127 vpwr.n1219 185.00310000000002
rmesh_equiv_116 oscillator__pbias oscillator__pbias.t3 664.84799999999996
rmesh_equiv_1160 vpwr.n1127 vpwr.n1223 185.00310000000002
rmesh_equiv_1161 vpwr.n1127 vpwr.n1225 185.00310000000002
rmesh_equiv_1162 vpwr.n1127 vpwr.n1227 185.00310000000002
rmesh_equiv_1163 vpwr.n1127 vpwr.n1231 185.00310000000002
rmesh_equiv_1164 vpwr.n1127 vpwr.n1233 185.00310000000002
rmesh_equiv_1165 vpwr.n1127 vpwr.n1235 185.00310000000002
rmesh_equiv_1166 vpwr.n1127 vpwr.n1239 185.00310000000002
rmesh_equiv_1167 vpwr.n1127 vpwr.n1241 185.00310000000002
rmesh_equiv_1168 vpwr.n1127 vpwr.n1243 185.00310000000002
rmesh_equiv_1169 vpwr.n1127 vpwr.n1247 185.00310000000002
rmesh_equiv_117 oscillator__pbias oscillator__pbias.t4 664.84799999999996
rmesh_equiv_1170 vpwr.n1127 vpwr.n1249 185.00310000000002
rmesh_equiv_1171 vpwr.n1127 vpwr.n1250 185.00310000000002
rmesh_equiv_1172 vpwr.n1127 vpwr.n1253 185.00310000000002
rmesh_equiv_1173 vpwr.n1127 vpwr.n1254 185
rmesh_equiv_1174 vpwr.n1127 vpwr.n1256 185.00310000000002
rmesh_equiv_1175 vpwr.n1127 vpwr.n1261 57.802300000000002
rmesh_equiv_1176 vpwr.n1128 vpwr.n1192 185
rmesh_equiv_1177 vpwr.n1128 vpwr.n1195 787.05899999999997
rmesh_equiv_1178 vpwr.n1128 vpwr.n1197 185
rmesh_equiv_1179 vpwr.n1128 vpwr.n1260 240
rmesh_equiv_118 oscillator__pbias oscillator__pbias.t5 664.84799999999996
rmesh_equiv_1180 vpwr.n1129 vpwr.n1256 240.00290767186621
rmesh_equiv_1181 vpwr.n1129 vpwr.n1258 185
rmesh_equiv_1182 vpwr.n1129 vpwr.n1260 787.05899999999997
rmesh_equiv_1183 vpwr.n113 vpwr.n114 25.6005
rmesh_equiv_1184 vpwr.n113 vpwr.n81 25.6005
rmesh_equiv_1185 vpwr.n1130 vpwr.n1131 185
rmesh_equiv_1186 vpwr.n1130 vpwr.n1145 25.6005
rmesh_equiv_1187 vpwr.n1130 vpwr.n1196 25.6005
rmesh_equiv_1188 vpwr.n1131 vpwr.n1144 240
rmesh_equiv_1189 vpwr.n1131 vpwr.n1193 185.00310000000002
rmesh_equiv_119 oscillator__pbias.n0 oscillator__pbias.n9 5.2415200000000004
rmesh_equiv_1190 vpwr.n1131 vpwr.n1195 240.00290767186621
rmesh_equiv_1191 vpwr.n114 vpwr.n115 25.6005
rmesh_equiv_1192 vpwr.n114 vpwr.n80 185
rmesh_equiv_1193 vpwr.n1143 vpwr.n1186 240
rmesh_equiv_1194 vpwr.n1143 vpwr.n1188 185
rmesh_equiv_1195 vpwr.n1143 vpwr.n1190 240.00290767186621
rmesh_equiv_1196 vpwr.n1143 vpwr.n1193 185.00310000000002
rmesh_equiv_1197 vpwr.n1144 vpwr.n1145 185
rmesh_equiv_1198 vpwr.n1144 vpwr.n1147 240.00290767186621
rmesh_equiv_1199 vpwr.n1144 vpwr.n1193 185.00310000000002
rmesh_equiv_12 ctrl ctrl.t7 0.00141837
rmesh_equiv_120 oscillator__pbias.n0 oscillator__pbias.t0 174.857
rmesh_equiv_1200 vpwr.n1145 vpwr.n1146 25.6005
rmesh_equiv_1201 vpwr.n1146 vpwr.n1147 185
rmesh_equiv_1202 vpwr.n1146 vpwr.n1149 25.6005
rmesh_equiv_1203 vpwr.n1147 vpwr.n1148 240
rmesh_equiv_1204 vpwr.n1147 vpwr.n1193 185.00310000000002
rmesh_equiv_1205 vpwr.n1148 vpwr.n1149 185
rmesh_equiv_1206 vpwr.n1148 vpwr.n1151 240.00290767186621
rmesh_equiv_1207 vpwr.n1148 vpwr.n1193 185.00310000000002
rmesh_equiv_1208 vpwr.n1149 vpwr.n1150 25.6005
rmesh_equiv_1209 vpwr.n115 vpwr.n116 185
rmesh_equiv_121 oscillator__pbias.n1 oscillator__pbias.n2 6.0294200000000009
rmesh_equiv_1210 vpwr.n115 vpwr.n79 25.6005
rmesh_equiv_1211 vpwr.n1150 vpwr.n1151 185
rmesh_equiv_1212 vpwr.n1150 vpwr.n1153 25.6005
rmesh_equiv_1213 vpwr.n1151 vpwr.n1152 240
rmesh_equiv_1214 vpwr.n1151 vpwr.n1193 185.00310000000002
rmesh_equiv_1215 vpwr.n1152 vpwr.n1153 185
rmesh_equiv_1216 vpwr.n1152 vpwr.n1155 240.00290767186621
rmesh_equiv_1217 vpwr.n1152 vpwr.n1193 185.00310000000002
rmesh_equiv_1218 vpwr.n1153 vpwr.n1154 25.6005
rmesh_equiv_1219 vpwr.n1154 vpwr.n1155 185
rmesh_equiv_122 oscillator__pbias.n10 oscillator__pbias.n9 5.2415200000000004
rmesh_equiv_1220 vpwr.n1154 vpwr.n1157 25.6005
rmesh_equiv_1221 vpwr.n1155 vpwr.n1156 240
rmesh_equiv_1222 vpwr.n1155 vpwr.n1193 185.00310000000002
rmesh_equiv_1223 vpwr.n1156 vpwr.n1157 185
rmesh_equiv_1224 vpwr.n1156 vpwr.n1159 240.00290767186621
rmesh_equiv_1225 vpwr.n1156 vpwr.n1193 185.00310000000002
rmesh_equiv_1226 vpwr.n1157 vpwr.n1158 25.6005
rmesh_equiv_1227 vpwr.n1158 vpwr.n1159 185
rmesh_equiv_1228 vpwr.n1158 vpwr.n1161 25.6005
rmesh_equiv_1229 vpwr.n1159 vpwr.n1160 240
rmesh_equiv_123 oscillator__pbias.n10 oscillator__pbias.t0 174.857
rmesh_equiv_1230 vpwr.n1159 vpwr.n1193 185.00310000000002
rmesh_equiv_1231 vpwr.n116 vpwr.n118 240.00290767186621
rmesh_equiv_1232 vpwr.n116 vpwr.n4 185.00310000000002
rmesh_equiv_1233 vpwr.n116 vpwr.n80 240
rmesh_equiv_1234 vpwr.n1160 vpwr.n1161 185
rmesh_equiv_1235 vpwr.n1160 vpwr.n1163 240.00290767186621
rmesh_equiv_1236 vpwr.n1160 vpwr.n1193 185.00310000000002
rmesh_equiv_1237 vpwr.n1161 vpwr.n1162 25.6005
rmesh_equiv_1238 vpwr.n1162 vpwr.n1163 185
rmesh_equiv_1239 vpwr.n1162 vpwr.n1165 25.6005
rmesh_equiv_124 oscillator__pbias.n2 oscillator__pbias.n8 1.2342500000000001
rmesh_equiv_1240 vpwr.n1163 vpwr.n1164 240
rmesh_equiv_1241 vpwr.n1163 vpwr.n1193 185.00310000000002
rmesh_equiv_1242 vpwr.n1164 vpwr.n1165 185
rmesh_equiv_1243 vpwr.n1164 vpwr.n1167 240.00290767186621
rmesh_equiv_1244 vpwr.n1164 vpwr.n1193 185.00310000000002
rmesh_equiv_1245 vpwr.n1165 vpwr.n1166 25.6005
rmesh_equiv_1246 vpwr.n1166 vpwr.n1167 185
rmesh_equiv_1247 vpwr.n1166 vpwr.n1169 25.6005
rmesh_equiv_1248 vpwr.n1167 vpwr.n1168 240
rmesh_equiv_1249 vpwr.n1167 vpwr.n1193 185.00310000000002
rmesh_equiv_125 oscillator__pbias.n3 oscillator__pbias.n4 40.104900000000001
rmesh_equiv_1250 vpwr.n1168 vpwr.n1169 185
rmesh_equiv_1251 vpwr.n1168 vpwr.n1171 240.00290767186621
rmesh_equiv_1252 vpwr.n1168 vpwr.n1193 185.00310000000002
rmesh_equiv_1253 vpwr.n1169 vpwr.n1170 25.6005
rmesh_equiv_1254 vpwr.n1170 vpwr.n1171 185
rmesh_equiv_1255 vpwr.n1170 vpwr.n1173 25.6005
rmesh_equiv_1256 vpwr.n1171 vpwr.n1172 240
rmesh_equiv_1257 vpwr.n1171 vpwr.n1193 185.00310000000002
rmesh_equiv_1258 vpwr.n1172 vpwr.n1173 185
rmesh_equiv_1259 vpwr.n1172 vpwr.n1175 240.00290767186621
rmesh_equiv_126 oscillator__pbias.n3 oscillator__pbias.n6 0.72065299999999999
rmesh_equiv_1260 vpwr.n1172 vpwr.n1193 185.00310000000002
rmesh_equiv_1261 vpwr.n1173 vpwr.n1174 25.6005
rmesh_equiv_1262 vpwr.n1174 vpwr.n1175 185
rmesh_equiv_1263 vpwr.n1174 vpwr.n1177 25.6005
rmesh_equiv_1264 vpwr.n1175 vpwr.n1176 240
rmesh_equiv_1265 vpwr.n1175 vpwr.n1193 185.00310000000002
rmesh_equiv_1266 vpwr.n1176 vpwr.n1177 185
rmesh_equiv_1267 vpwr.n1176 vpwr.n1179 240.00290767186621
rmesh_equiv_1268 vpwr.n1176 vpwr.n1193 185.00310000000002
rmesh_equiv_1269 vpwr.n1177 vpwr.n1178 25.6005
rmesh_equiv_127 oscillator__pbias.n4 oscillator__pbias.n5 42.739100000000001
rmesh_equiv_1270 vpwr.n1178 vpwr.n1179 185
rmesh_equiv_1271 vpwr.n1178 vpwr.n1181 25.6005
rmesh_equiv_1272 vpwr.n1179 vpwr.n1180 240
rmesh_equiv_1273 vpwr.n1179 vpwr.n1193 185.00310000000002
rmesh_equiv_1274 vpwr.n118 vpwr.n120 240
rmesh_equiv_1275 vpwr.n118 vpwr.n4 185.00310000000002
rmesh_equiv_1276 vpwr.n118 vpwr.n79 185
rmesh_equiv_1277 vpwr.n1180 vpwr.n1181 185
rmesh_equiv_1278 vpwr.n1180 vpwr.n1183 240.00290767186621
rmesh_equiv_1279 vpwr.n1180 vpwr.n1193 185.00310000000002
rmesh_equiv_128 oscillator__pbias.n4 oscillator__pbias.t2 2.8570000000000002
rmesh_equiv_1280 vpwr.n1181 vpwr.n1182 25.6005
rmesh_equiv_1281 vpwr.n1182 vpwr.n1183 185
rmesh_equiv_1282 vpwr.n1182 vpwr.n1185 25.6005
rmesh_equiv_1283 vpwr.n1183 vpwr.n1184 240
rmesh_equiv_1284 vpwr.n1183 vpwr.n1193 185.00310000000002
rmesh_equiv_1285 vpwr.n1184 vpwr.n1185 185
rmesh_equiv_1286 vpwr.n1184 vpwr.n1186 240.00290767186621
rmesh_equiv_1287 vpwr.n1184 vpwr.n1193 185.00310000000002
rmesh_equiv_1288 vpwr.n1185 vpwr.n1187 25.6005
rmesh_equiv_1289 vpwr.n1186 vpwr.n1187 185
rmesh_equiv_129 oscillator__pbias.n5 oscillator__pbias.n6 1.10033
rmesh_equiv_1290 vpwr.n1186 vpwr.n1193 185.00310000000002
rmesh_equiv_1291 vpwr.n1187 vpwr.n1188 25.6005
rmesh_equiv_1292 vpwr.n1188 vpwr.n1189 25.6005
rmesh_equiv_1293 vpwr.n1189 vpwr.n1190 185
rmesh_equiv_1294 vpwr.n1190 vpwr.n1193 185.00310000000002
rmesh_equiv_1295 vpwr.n1192 vpwr.n1193 57.802300000000002
rmesh_equiv_1296 vpwr.n1192 vpwr.t27 15.849399999999999
rmesh_equiv_1297 vpwr.n1193 vpwr.n1195 185.00310000000002
rmesh_equiv_1298 vpwr.n1195 vpwr.n1196 185
rmesh_equiv_1299 vpwr.n1196 vpwr.n1197 83.953400000000002
rmesh_equiv_13 ctrl.n0 ctrl.n1 2.3117299999999998
rmesh_equiv_130 oscillator__pbias.n6 oscillator__pbias.n7 16.256499999999999
rmesh_equiv_1300 vpwr.n1197 vpwr.n1259 25.6005
rmesh_equiv_1301 vpwr.n1198 vpwr.n1252 25.6005
rmesh_equiv_1302 vpwr.n1198 vpwr.n1254 185
rmesh_equiv_1303 vpwr.n1198 vpwr.n1257 25.6005
rmesh_equiv_1304 vpwr.n120 vpwr.n121 185
rmesh_equiv_1305 vpwr.n120 vpwr.n4 185.00310000000002
rmesh_equiv_1306 vpwr.n120 vpwr.n78 240.00290767186621
rmesh_equiv_1307 vpwr.n1200 vpwr.n1246 25.6005
rmesh_equiv_1308 vpwr.n1200 vpwr.n1249 185
rmesh_equiv_1309 vpwr.n1200 vpwr.n1251 25.6005
rmesh_equiv_131 oscillator__pbias.n7 oscillator__pbias.n8 0.48342500000000005
rmesh_equiv_1310 vpwr.n1201 vpwr.n1243 240.00290767186621
rmesh_equiv_1311 vpwr.n1201 vpwr.n1245 185
rmesh_equiv_1312 vpwr.n1201 vpwr.n1247 240
rmesh_equiv_1313 vpwr.n1202 vpwr.n1238 25.6005
rmesh_equiv_1314 vpwr.n1202 vpwr.n1241 185
rmesh_equiv_1315 vpwr.n1202 vpwr.n1244 25.6005
rmesh_equiv_1316 vpwr.n1203 vpwr.n1235 240.00290767186621
rmesh_equiv_1317 vpwr.n1203 vpwr.n1237 185
rmesh_equiv_1318 vpwr.n1203 vpwr.n1239 240
rmesh_equiv_1319 vpwr.n1204 vpwr.n1230 25.6005
rmesh_equiv_132 oscillator__pbias.n8 oscillator__pbias.n9 15.892899999999999
rmesh_equiv_1320 vpwr.n1204 vpwr.n1233 185
rmesh_equiv_1321 vpwr.n1204 vpwr.n1236 25.6005
rmesh_equiv_1322 vpwr.n1205 vpwr.n1227 240.00290767186621
rmesh_equiv_1323 vpwr.n1205 vpwr.n1229 185
rmesh_equiv_1324 vpwr.n1205 vpwr.n1231 240
rmesh_equiv_1325 vpwr.n1206 vpwr.n1222 25.6005
rmesh_equiv_1326 vpwr.n1206 vpwr.n1225 185
rmesh_equiv_1327 vpwr.n1206 vpwr.n1228 25.6005
rmesh_equiv_1328 vpwr.n1207 vpwr.n1219 240.00290767186621
rmesh_equiv_1329 vpwr.n1207 vpwr.n1221 185
rmesh_equiv_133 oscillator__q0 oscillator__q0.n0 20.2395
rmesh_equiv_1330 vpwr.n1207 vpwr.n1223 240
rmesh_equiv_1331 vpwr.n1208 vpwr.n1214 25.6005
rmesh_equiv_1332 vpwr.n1208 vpwr.n1217 185
rmesh_equiv_1333 vpwr.n1208 vpwr.n1220 25.6005
rmesh_equiv_1334 vpwr.n1209 vpwr.n1211 240.00290767186621
rmesh_equiv_1335 vpwr.n1209 vpwr.n1213 185
rmesh_equiv_1336 vpwr.n1209 vpwr.n1215 240
rmesh_equiv_1337 vpwr.n121 vpwr.n122 25.6005
rmesh_equiv_1338 vpwr.n121 vpwr.n79 25.6005
rmesh_equiv_1339 vpwr.n1211 vpwr.n1212 185
rmesh_equiv_134 oscillator__q0 oscillator__q0.n10 17.948799999999999
rmesh_equiv_1340 vpwr.n1212 vpwr.n1213 25.6005
rmesh_equiv_1341 vpwr.n1213 vpwr.n1214 25.6005
rmesh_equiv_1342 vpwr.n1214 vpwr.n1215 185
rmesh_equiv_1343 vpwr.n1215 vpwr.n1217 240.00290767186621
rmesh_equiv_1344 vpwr.n1217 vpwr.n1219 240
rmesh_equiv_1345 vpwr.n1219 vpwr.n1220 185
rmesh_equiv_1346 vpwr.n122 vpwr.n123 25.6005
rmesh_equiv_1347 vpwr.n122 vpwr.n78 185
rmesh_equiv_1348 vpwr.n1220 vpwr.n1221 25.6005
rmesh_equiv_1349 vpwr.n1221 vpwr.n1222 25.6005
rmesh_equiv_135 oscillator__q0 oscillator__q0.n2 18.037295903243905
rmesh_equiv_1350 vpwr.n1222 vpwr.n1223 185
rmesh_equiv_1351 vpwr.n1223 vpwr.n1225 240.00290767186621
rmesh_equiv_1352 vpwr.n1225 vpwr.n1227 240
rmesh_equiv_1353 vpwr.n1227 vpwr.n1228 185
rmesh_equiv_1354 vpwr.n1228 vpwr.n1229 25.6005
rmesh_equiv_1355 vpwr.n1229 vpwr.n1230 25.6005
rmesh_equiv_1356 vpwr.n123 vpwr.n124 185
rmesh_equiv_1357 vpwr.n123 vpwr.n77 25.6005
rmesh_equiv_1358 vpwr.n1230 vpwr.n1231 185
rmesh_equiv_1359 vpwr.n1231 vpwr.n1233 240.00290767186621
rmesh_equiv_136 oscillator__q0 oscillator__q0.n3 5.0874600000000001
rmesh_equiv_1360 vpwr.n1233 vpwr.n1235 240
rmesh_equiv_1361 vpwr.n1235 vpwr.n1236 185
rmesh_equiv_1362 vpwr.n1236 vpwr.n1237 25.6005
rmesh_equiv_1363 vpwr.n1237 vpwr.n1238 25.6005
rmesh_equiv_1364 vpwr.n1238 vpwr.n1239 185
rmesh_equiv_1365 vpwr.n1239 vpwr.n1241 240.00290767186621
rmesh_equiv_1366 vpwr.n124 vpwr.n126 240.00290767186621
rmesh_equiv_1367 vpwr.n124 vpwr.n4 185.00310000000002
rmesh_equiv_1368 vpwr.n124 vpwr.n78 240
rmesh_equiv_1369 vpwr.n1241 vpwr.n1243 240
rmesh_equiv_137 oscillator__q0 oscillator__q0.n4 31.751799999999999
rmesh_equiv_1370 vpwr.n1243 vpwr.n1244 185
rmesh_equiv_1371 vpwr.n1244 vpwr.n1245 25.6005
rmesh_equiv_1372 vpwr.n1245 vpwr.n1246 25.6005
rmesh_equiv_1373 vpwr.n1246 vpwr.n1247 185
rmesh_equiv_1374 vpwr.n1247 vpwr.n1249 240.00290767186621
rmesh_equiv_1375 vpwr.n1249 vpwr.n1250 240
rmesh_equiv_1376 vpwr.n1250 vpwr.n1251 185
rmesh_equiv_1377 vpwr.n1250 vpwr.n1253 240.00290767186621
rmesh_equiv_1378 vpwr.n1251 vpwr.n1252 25.6005
rmesh_equiv_1379 vpwr.n1252 vpwr.n1253 185
rmesh_equiv_138 oscillator__q0 oscillator__q0.n6 5.4168500000000002
rmesh_equiv_1380 vpwr.n1253 vpwr.n1254 240
rmesh_equiv_1381 vpwr.n1254 vpwr.n1256 240
rmesh_equiv_1382 vpwr.n1256 vpwr.n1257 185
rmesh_equiv_1383 vpwr.n1257 vpwr.n1258 25.6005
rmesh_equiv_1384 vpwr.n1258 vpwr.n1259 83.953400000000002
rmesh_equiv_1385 vpwr.n1259 vpwr.n1260 185
rmesh_equiv_1386 vpwr.n126 vpwr.n127 240
rmesh_equiv_1387 vpwr.n126 vpwr.n4 185.00310000000002
rmesh_equiv_1388 vpwr.n126 vpwr.n77 185
rmesh_equiv_1389 vpwr.n1260 vpwr.n1261 185
rmesh_equiv_139 oscillator__q0 oscillator__q0.t2 1511.24
rmesh_equiv_1390 vpwr.n1261 vpwr.n1262 185
rmesh_equiv_1391 vpwr.n1261 vpwr.t27 15.849399999999999
rmesh_equiv_1392 vpwr.n1262 vpwr.n1263 185
rmesh_equiv_1393 vpwr.n1264 vpwr.n1440 5.1734400000000003
rmesh_equiv_1394 vpwr.n1265 vpwr.n1273 185
rmesh_equiv_1395 vpwr.n1265 vpwr.n1434 82.823999999999998
rmesh_equiv_1396 vpwr.n1266 vpwr.n1271 185.00310000000002
rmesh_equiv_1397 vpwr.n1266 vpwr.n1273 240
rmesh_equiv_1398 vpwr.n1266 vpwr.n1438 240.00290767186621
rmesh_equiv_1399 vpwr.n1267 vpwr.n1427 25.6005
rmesh_equiv_14 ctrl.n0 ctrl.t1 29.501799999999999
rmesh_equiv_140 oscillator__q0 oscillator__q0.t3 0.00361634
rmesh_equiv_1400 vpwr.n1267 vpwr.n1437 185
rmesh_equiv_1401 vpwr.n1267 vpwr.n1439 82.823999999999998
rmesh_equiv_1402 vpwr.n1269 vpwr.n1270 185
rmesh_equiv_1403 vpwr.n1269 vpwr.n1427 185
rmesh_equiv_1404 vpwr.n1269 vpwr.n1429 240
rmesh_equiv_1405 vpwr.n1269 vpwr.n1437 240
rmesh_equiv_1406 vpwr.n127 vpwr.n128 185
rmesh_equiv_1407 vpwr.n127 vpwr.n130 240.00290767186621
rmesh_equiv_1408 vpwr.n127 vpwr.n4 185.00310000000002
rmesh_equiv_1409 vpwr.n1270 vpwr.n1272 185
rmesh_equiv_141 oscillator__q0 oscillator__q0.t4 854.11400000000003
rmesh_equiv_1410 vpwr.n1270 vpwr.n1430 131.30199999999999
rmesh_equiv_1411 vpwr.n1270 vpwr.n1436 131.30199999999999
rmesh_equiv_1412 vpwr.n1271 vpwr.n1273 185
rmesh_equiv_1413 vpwr.n1271 vpwr.n1436 216.26100000000002
rmesh_equiv_1414 vpwr.n1271 vpwr.n1438 185.00310000000002
rmesh_equiv_1415 vpwr.n1272 vpwr.n1431 240
rmesh_equiv_1416 vpwr.n1272 vpwr.n1433 185
rmesh_equiv_1417 vpwr.n1272 vpwr.n1435 240
rmesh_equiv_1418 vpwr.n1273 vpwr.n1435 776.471
rmesh_equiv_1419 vpwr.n1274 vpwr.n1275 185
rmesh_equiv_142 oscillator__q0.n0 oscillator__q0.n1 54.441499999999998
rmesh_equiv_1420 vpwr.n1274 vpwr.n1421 25.6005
rmesh_equiv_1421 vpwr.n1274 vpwr.n1432 25.6005
rmesh_equiv_1422 vpwr.n1275 vpwr.n1276 185
rmesh_equiv_1423 vpwr.n1275 vpwr.n1422 240
rmesh_equiv_1424 vpwr.n1275 vpwr.n1431 240
rmesh_equiv_1425 vpwr.n1276 vpwr.n1277 185
rmesh_equiv_1426 vpwr.n1276 vpwr.n1423 131.30199999999999
rmesh_equiv_1427 vpwr.n1276 vpwr.n1430 131.30199999999999
rmesh_equiv_1428 vpwr.n1277 vpwr.n1424 240
rmesh_equiv_1429 vpwr.n1277 vpwr.n1426 185
rmesh_equiv_143 oscillator__q0.n0 oscillator__q0.n9 0.71089000000000002
rmesh_equiv_1430 vpwr.n1277 vpwr.n1429 240
rmesh_equiv_1431 vpwr.n1278 vpwr.n1279 185
rmesh_equiv_1432 vpwr.n1278 vpwr.n1415 25.6005
rmesh_equiv_1433 vpwr.n1278 vpwr.n1425 25.6005
rmesh_equiv_1434 vpwr.n1279 vpwr.n1280 185
rmesh_equiv_1435 vpwr.n1279 vpwr.n1416 240
rmesh_equiv_1436 vpwr.n1279 vpwr.n1424 240
rmesh_equiv_1437 vpwr.n128 vpwr.n129 25.6005
rmesh_equiv_1438 vpwr.n128 vpwr.n77 25.6005
rmesh_equiv_1439 vpwr.n1280 vpwr.n1281 185
rmesh_equiv_144 oscillator__q0.n1 oscillator__q0.n10 48.2789
rmesh_equiv_1440 vpwr.n1280 vpwr.n1417 131.30199999999999
rmesh_equiv_1441 vpwr.n1280 vpwr.n1423 131.30199999999999
rmesh_equiv_1442 vpwr.n1281 vpwr.n1418 240
rmesh_equiv_1443 vpwr.n1281 vpwr.n1420 185
rmesh_equiv_1444 vpwr.n1281 vpwr.n1422 240
rmesh_equiv_1445 vpwr.n1282 vpwr.n1283 185
rmesh_equiv_1446 vpwr.n1282 vpwr.n1409 25.6005
rmesh_equiv_1447 vpwr.n1282 vpwr.n1419 25.6005
rmesh_equiv_1448 vpwr.n1283 vpwr.n1284 185
rmesh_equiv_1449 vpwr.n1283 vpwr.n1410 240
rmesh_equiv_145 oscillator__q0.n1 oscillator__q0.t0 3.5711299999999997
rmesh_equiv_1450 vpwr.n1283 vpwr.n1418 240
rmesh_equiv_1451 vpwr.n1284 vpwr.n1285 185
rmesh_equiv_1452 vpwr.n1284 vpwr.n1411 131.30199999999999
rmesh_equiv_1453 vpwr.n1284 vpwr.n1417 131.30199999999999
rmesh_equiv_1454 vpwr.n1285 vpwr.n1412 240
rmesh_equiv_1455 vpwr.n1285 vpwr.n1414 185
rmesh_equiv_1456 vpwr.n1285 vpwr.n1416 240
rmesh_equiv_1457 vpwr.n1286 vpwr.n1287 185
rmesh_equiv_1458 vpwr.n1286 vpwr.n1403 25.6005
rmesh_equiv_1459 vpwr.n1286 vpwr.n1413 25.6005
rmesh_equiv_146 oscillator__q0.n10 oscillator__q0.n9 2.38164
rmesh_equiv_1460 vpwr.n1287 vpwr.n1288 185
rmesh_equiv_1461 vpwr.n1287 vpwr.n1404 240
rmesh_equiv_1462 vpwr.n1287 vpwr.n1412 240
rmesh_equiv_1463 vpwr.n1288 vpwr.n1289 185
rmesh_equiv_1464 vpwr.n1288 vpwr.n1405 131.30199999999999
rmesh_equiv_1465 vpwr.n1288 vpwr.n1411 131.30199999999999
rmesh_equiv_1466 vpwr.n1289 vpwr.n1406 240
rmesh_equiv_1467 vpwr.n1289 vpwr.n1408 185
rmesh_equiv_1468 vpwr.n1289 vpwr.n1410 240
rmesh_equiv_1469 vpwr.n129 vpwr.n130 185
rmesh_equiv_147 oscillator__q0.n2 oscillator__q0.n3 2.89805
rmesh_equiv_1470 vpwr.n129 vpwr.n75 25.6005
rmesh_equiv_1471 vpwr.n1290 vpwr.n1291 185
rmesh_equiv_1472 vpwr.n1290 vpwr.n1397 25.6005
rmesh_equiv_1473 vpwr.n1290 vpwr.n1407 25.6005
rmesh_equiv_1474 vpwr.n1291 vpwr.n1292 185
rmesh_equiv_1475 vpwr.n1291 vpwr.n1398 240
rmesh_equiv_1476 vpwr.n1291 vpwr.n1406 240
rmesh_equiv_1477 vpwr.n1292 vpwr.n1293 185
rmesh_equiv_1478 vpwr.n1292 vpwr.n1399 131.30199999999999
rmesh_equiv_1479 vpwr.n1292 vpwr.n1405 131.30199999999999
rmesh_equiv_148 oscillator__q0.n3 oscillator__q0.n8 2.6342599999999998
rmesh_equiv_1480 vpwr.n1293 vpwr.n1400 240
rmesh_equiv_1481 vpwr.n1293 vpwr.n1402 185
rmesh_equiv_1482 vpwr.n1293 vpwr.n1404 240
rmesh_equiv_1483 vpwr.n1294 vpwr.n1295 185
rmesh_equiv_1484 vpwr.n1294 vpwr.n1391 25.6005
rmesh_equiv_1485 vpwr.n1294 vpwr.n1401 25.6005
rmesh_equiv_1486 vpwr.n1295 vpwr.n1296 185
rmesh_equiv_1487 vpwr.n1295 vpwr.n1392 240
rmesh_equiv_1488 vpwr.n1295 vpwr.n1400 240
rmesh_equiv_1489 vpwr.n1296 vpwr.n1297 185
rmesh_equiv_149 oscillator__q0.n4 oscillator__q0.n5 37.418900000000001
rmesh_equiv_1490 vpwr.n1296 vpwr.n1393 131.30199999999999
rmesh_equiv_1491 vpwr.n1296 vpwr.n1399 131.30199999999999
rmesh_equiv_1492 vpwr.n1297 vpwr.n1394 240
rmesh_equiv_1493 vpwr.n1297 vpwr.n1396 185
rmesh_equiv_1494 vpwr.n1297 vpwr.n1398 240
rmesh_equiv_1495 vpwr.n1298 vpwr.n1299 185
rmesh_equiv_1496 vpwr.n1298 vpwr.n1385 25.6005
rmesh_equiv_1497 vpwr.n1298 vpwr.n1395 25.6005
rmesh_equiv_1498 vpwr.n1299 vpwr.n1300 185
rmesh_equiv_1499 vpwr.n1299 vpwr.n1386 240
rmesh_equiv_15 ctrl.n1 ctrl.n2 4.1529499999999997
rmesh_equiv_150 oscillator__q0.n4 oscillator__q0.n7 2.60127
rmesh_equiv_1500 vpwr.n1299 vpwr.n1394 240
rmesh_equiv_1501 vpwr.n130 vpwr.n131 240
rmesh_equiv_1502 vpwr.n130 vpwr.n4 185.00310000000002
rmesh_equiv_1503 vpwr.n1300 vpwr.n1301 185
rmesh_equiv_1504 vpwr.n1300 vpwr.n1393 131.30199999999999
rmesh_equiv_1505 vpwr.n1300 vpwr.t16 65.650899999999993
rmesh_equiv_1506 vpwr.n1301 vpwr.n1388 240
rmesh_equiv_1507 vpwr.n1301 vpwr.n1390 185
rmesh_equiv_1508 vpwr.n1301 vpwr.n1392 240
rmesh_equiv_1509 vpwr.n1302 vpwr.n1303 185
rmesh_equiv_151 oscillator__q0.n5 oscillator__q0.n6 31.473199999999995
rmesh_equiv_1510 vpwr.n1302 vpwr.n1379 25.6005
rmesh_equiv_1511 vpwr.n1302 vpwr.n1389 25.6005
rmesh_equiv_1512 vpwr.n1303 vpwr.n1304 185
rmesh_equiv_1513 vpwr.n1303 vpwr.n1380 240
rmesh_equiv_1514 vpwr.n1303 vpwr.n1388 240
rmesh_equiv_1515 vpwr.n1304 vpwr.n1305 185
rmesh_equiv_1516 vpwr.n1304 vpwr.n1381 131.30199999999999
rmesh_equiv_1517 vpwr.n1304 vpwr.n1387 131.30199999999999
rmesh_equiv_1518 vpwr.n1305 vpwr.n1382 240
rmesh_equiv_1519 vpwr.n1305 vpwr.n1384 185
rmesh_equiv_152 oscillator__q0.n5 oscillator__q0.t1 4.3505000000000003
rmesh_equiv_1520 vpwr.n1305 vpwr.n1386 240
rmesh_equiv_1521 vpwr.n1306 vpwr.n1307 185
rmesh_equiv_1522 vpwr.n1306 vpwr.n1373 25.6005
rmesh_equiv_1523 vpwr.n1306 vpwr.n1383 25.6005
rmesh_equiv_1524 vpwr.n1307 vpwr.n1308 185
rmesh_equiv_1525 vpwr.n1307 vpwr.n1374 240
rmesh_equiv_1526 vpwr.n1307 vpwr.n1382 240
rmesh_equiv_1527 vpwr.n1308 vpwr.n1309 185
rmesh_equiv_1528 vpwr.n1308 vpwr.n1375 131.30199999999999
rmesh_equiv_1529 vpwr.n1308 vpwr.n1381 131.30199999999999
rmesh_equiv_153 oscillator__q0.n6 oscillator__q0.n7 1.7058199999999999
rmesh_equiv_1530 vpwr.n1309 vpwr.n1376 240
rmesh_equiv_1531 vpwr.n1309 vpwr.n1378 185
rmesh_equiv_1532 vpwr.n1309 vpwr.n1380 240
rmesh_equiv_1533 vpwr.n131 vpwr.n133 240
rmesh_equiv_1534 vpwr.n131 vpwr.n4 185
rmesh_equiv_1535 vpwr.n131 vpwr.n75 185
rmesh_equiv_1536 vpwr.n1310 vpwr.n1311 185
rmesh_equiv_1537 vpwr.n1310 vpwr.n1367 25.6005
rmesh_equiv_1538 vpwr.n1310 vpwr.n1377 25.6005
rmesh_equiv_1539 vpwr.n1311 vpwr.n1312 185
rmesh_equiv_154 oscillator__q0.n7 oscillator__q0.n8 17.2715
rmesh_equiv_1540 vpwr.n1311 vpwr.n1368 240
rmesh_equiv_1541 vpwr.n1311 vpwr.n1376 240
rmesh_equiv_1542 vpwr.n1312 vpwr.n1313 185
rmesh_equiv_1543 vpwr.n1312 vpwr.n1369 131.30199999999999
rmesh_equiv_1544 vpwr.n1312 vpwr.n1375 131.30199999999999
rmesh_equiv_1545 vpwr.n1313 vpwr.n1370 240
rmesh_equiv_1546 vpwr.n1313 vpwr.n1372 185
rmesh_equiv_1547 vpwr.n1313 vpwr.n1374 240
rmesh_equiv_1548 vpwr.n1314 vpwr.n1315 185
rmesh_equiv_1549 vpwr.n1314 vpwr.n1361 25.6005
rmesh_equiv_155 oscillator__q0.n8 oscillator__q0.n9 18.088799999999999
rmesh_equiv_1550 vpwr.n1314 vpwr.n1371 25.6005
rmesh_equiv_1551 vpwr.n1315 vpwr.n1316 185
rmesh_equiv_1552 vpwr.n1315 vpwr.n1362 240
rmesh_equiv_1553 vpwr.n1315 vpwr.n1370 240
rmesh_equiv_1554 vpwr.n1316 vpwr.n1317 185
rmesh_equiv_1555 vpwr.n1316 vpwr.n1363 131.30199999999999
rmesh_equiv_1556 vpwr.n1316 vpwr.n1369 131.30199999999999
rmesh_equiv_1557 vpwr.n1317 vpwr.n1364 240
rmesh_equiv_1558 vpwr.n1317 vpwr.n1366 185
rmesh_equiv_1559 vpwr.n1317 vpwr.n1368 240
rmesh_equiv_156 oscillator__q1 oscillator__q1.n0 6.7655600000000007
rmesh_equiv_1560 vpwr.n1318 vpwr.n1319 185
rmesh_equiv_1561 vpwr.n1318 vpwr.n1355 25.6005
rmesh_equiv_1562 vpwr.n1318 vpwr.n1365 25.6005
rmesh_equiv_1563 vpwr.n1319 vpwr.n1320 185
rmesh_equiv_1564 vpwr.n1319 vpwr.n1356 240
rmesh_equiv_1565 vpwr.n1319 vpwr.n1364 240
rmesh_equiv_1566 vpwr.n1320 vpwr.n1321 185
rmesh_equiv_1567 vpwr.n1320 vpwr.n1357 131.30199999999999
rmesh_equiv_1568 vpwr.n1320 vpwr.n1363 131.30199999999999
rmesh_equiv_1569 vpwr.n1321 vpwr.n1358 240
rmesh_equiv_157 oscillator__q1 oscillator__q1.n1 18.245738118931889
rmesh_equiv_1570 vpwr.n1321 vpwr.n1360 185
rmesh_equiv_1571 vpwr.n1321 vpwr.n1362 240
rmesh_equiv_1572 vpwr.n1322 vpwr.n1323 185
rmesh_equiv_1573 vpwr.n1322 vpwr.n1349 25.6005
rmesh_equiv_1574 vpwr.n1322 vpwr.n1359 25.6005
rmesh_equiv_1575 vpwr.n1323 vpwr.n1324 185
rmesh_equiv_1576 vpwr.n1323 vpwr.n1350 240
rmesh_equiv_1577 vpwr.n1323 vpwr.n1358 240
rmesh_equiv_1578 vpwr.n1324 vpwr.n1325 185
rmesh_equiv_1579 vpwr.n1324 vpwr.n1351 131.30199999999999
rmesh_equiv_158 oscillator__q1 oscillator__q1.n10 23.111999999999998
rmesh_equiv_1580 vpwr.n1324 vpwr.n1357 131.30199999999999
rmesh_equiv_1581 vpwr.n1325 vpwr.n1352 240
rmesh_equiv_1582 vpwr.n1325 vpwr.n1354 185
rmesh_equiv_1583 vpwr.n1325 vpwr.n1356 240
rmesh_equiv_1584 vpwr.n1326 vpwr.n1327 185
rmesh_equiv_1585 vpwr.n1326 vpwr.n1343 25.6005
rmesh_equiv_1586 vpwr.n1326 vpwr.n1353 25.6005
rmesh_equiv_1587 vpwr.n1327 vpwr.n1328 185
rmesh_equiv_1588 vpwr.n1327 vpwr.n1344 240
rmesh_equiv_1589 vpwr.n1327 vpwr.n1352 240
rmesh_equiv_159 oscillator__q1 oscillator__q1.n2 5.2002600000000001
rmesh_equiv_1590 vpwr.n1328 vpwr.n1329 185
rmesh_equiv_1591 vpwr.n1328 vpwr.n1345 131.30199999999999
rmesh_equiv_1592 vpwr.n1328 vpwr.n1351 131.30199999999999
rmesh_equiv_1593 vpwr.n1329 vpwr.n1346 240
rmesh_equiv_1594 vpwr.n1329 vpwr.n1348 185
rmesh_equiv_1595 vpwr.n1329 vpwr.n1350 240
rmesh_equiv_1596 vpwr.n133 vpwr.n134 185
rmesh_equiv_1597 vpwr.n133 vpwr.n4 185.00310000000002
rmesh_equiv_1598 vpwr.n133 vpwr.n6 240.00290767186621
rmesh_equiv_1599 vpwr.n1330 vpwr.n1331 185
rmesh_equiv_16 ctrl.n2 ctrl.n3 4.1529499999999997
rmesh_equiv_160 oscillator__q1 oscillator__q1.n3 17.948799999999999
rmesh_equiv_1600 vpwr.n1330 vpwr.n1336 82.823999999999998
rmesh_equiv_1601 vpwr.n1330 vpwr.n1347 25.6005
rmesh_equiv_1602 vpwr.n1331 vpwr.n1332 185
rmesh_equiv_1603 vpwr.n1331 vpwr.n1337 776.471
rmesh_equiv_1604 vpwr.n1331 vpwr.n1346 240
rmesh_equiv_1605 vpwr.n1332 vpwr.n1333 185
rmesh_equiv_1606 vpwr.n1332 vpwr.n1339 216.26100000000002
rmesh_equiv_1607 vpwr.n1332 vpwr.n1345 131.30199999999999
rmesh_equiv_1608 vpwr.n1333 vpwr.n1340 776.471
rmesh_equiv_1609 vpwr.n1333 vpwr.n1342 185
rmesh_equiv_161 oscillator__q1 oscillator__q1.n5 20.2395
rmesh_equiv_1610 vpwr.n1333 vpwr.n1344 240
rmesh_equiv_1611 vpwr.n1334 vpwr.n1335 185
rmesh_equiv_1612 vpwr.n1334 vpwr.n1336 25.6005
rmesh_equiv_1613 vpwr.n1334 vpwr.n1341 25.6005
rmesh_equiv_1614 vpwr.n1335 vpwr.n1337 240.00290767186621
rmesh_equiv_1615 vpwr.n1335 vpwr.n1339 185.00310000000002
rmesh_equiv_1616 vpwr.n1335 vpwr.n1340 240
rmesh_equiv_1617 vpwr.n1336 vpwr.n1337 185
rmesh_equiv_1618 vpwr.n1337 vpwr.n1339 185.00310000000002
rmesh_equiv_1619 vpwr.n1339 vpwr.n1340 185
rmesh_equiv_162 oscillator__q1 oscillator__q1.t2 1511.24
rmesh_equiv_1620 vpwr.n134 vpwr.n135 25.6005
rmesh_equiv_1621 vpwr.n134 vpwr.n75 25.6005
rmesh_equiv_1622 vpwr.n1340 vpwr.n1341 185
rmesh_equiv_1623 vpwr.n1341 vpwr.n1342 82.823999999999998
rmesh_equiv_1624 vpwr.n1342 vpwr.n1343 25.6005
rmesh_equiv_1625 vpwr.n1343 vpwr.n1344 185
rmesh_equiv_1626 vpwr.n1344 vpwr.n1345 185
rmesh_equiv_1627 vpwr.n1345 vpwr.n1346 185
rmesh_equiv_1628 vpwr.n1346 vpwr.n1347 185
rmesh_equiv_1629 vpwr.n1347 vpwr.n1348 25.6005
rmesh_equiv_163 oscillator__q1 oscillator__q1.t3 0.00361634
rmesh_equiv_1630 vpwr.n1348 vpwr.n1349 25.6005
rmesh_equiv_1631 vpwr.n1349 vpwr.n1350 185
rmesh_equiv_1632 vpwr.n135 vpwr.n136 83.953400000000002
rmesh_equiv_1633 vpwr.n135 vpwr.n6 185
rmesh_equiv_1634 vpwr.n1350 vpwr.n1351 185
rmesh_equiv_1635 vpwr.n1351 vpwr.n1352 185
rmesh_equiv_1636 vpwr.n1352 vpwr.n1353 185
rmesh_equiv_1637 vpwr.n1353 vpwr.n1354 25.6005
rmesh_equiv_1638 vpwr.n1354 vpwr.n1355 25.6005
rmesh_equiv_1639 vpwr.n1355 vpwr.n1356 185
rmesh_equiv_164 oscillator__q1 oscillator__q1.t4 854.11400000000003
rmesh_equiv_1640 vpwr.n1356 vpwr.n1357 185
rmesh_equiv_1641 vpwr.n1357 vpwr.n1358 185
rmesh_equiv_1642 vpwr.n1358 vpwr.n1359 185
rmesh_equiv_1643 vpwr.n1359 vpwr.n1360 25.6005
rmesh_equiv_1644 vpwr.n136 vpwr.n137 185
rmesh_equiv_1645 vpwr.n136 vpwr.n74 25.6005
rmesh_equiv_1646 vpwr.n1360 vpwr.n1361 25.6005
rmesh_equiv_1647 vpwr.n1361 vpwr.n1362 185
rmesh_equiv_1648 vpwr.n1362 vpwr.n1363 185
rmesh_equiv_1649 vpwr.n1363 vpwr.n1364 185
rmesh_equiv_165 oscillator__q1.n0 oscillator__q1.n8 0.555091
rmesh_equiv_1650 vpwr.n1364 vpwr.n1365 185
rmesh_equiv_1651 vpwr.n1365 vpwr.n1366 25.6005
rmesh_equiv_1652 vpwr.n1366 vpwr.n1367 25.6005
rmesh_equiv_1653 vpwr.n1367 vpwr.n1368 185
rmesh_equiv_1654 vpwr.n1368 vpwr.n1369 185
rmesh_equiv_1655 vpwr.n1369 vpwr.n1370 185
rmesh_equiv_1656 vpwr.n137 vpwr.n138 185
rmesh_equiv_1657 vpwr.n137 vpwr.n5 240
rmesh_equiv_1658 vpwr.n137 vpwr.n6 787.05899999999997
rmesh_equiv_1659 vpwr.n1370 vpwr.n1371 185
rmesh_equiv_166 oscillator__q1.n0 oscillator__q1.n9 39.311100000000003
rmesh_equiv_1660 vpwr.n1371 vpwr.n1372 25.6005
rmesh_equiv_1661 vpwr.n1372 vpwr.n1373 25.6005
rmesh_equiv_1662 vpwr.n1373 vpwr.n1374 185
rmesh_equiv_1663 vpwr.n1374 vpwr.n1375 185
rmesh_equiv_1664 vpwr.n1375 vpwr.n1376 185
rmesh_equiv_1665 vpwr.n1376 vpwr.n1377 185
rmesh_equiv_1666 vpwr.n1377 vpwr.n1378 25.6005
rmesh_equiv_1667 vpwr.n1378 vpwr.n1379 25.6005
rmesh_equiv_1668 vpwr.n1379 vpwr.n1380 185
rmesh_equiv_1669 vpwr.n138 vpwr.n139 185
rmesh_equiv_167 oscillator__q1.n1 oscillator__q1.n2 2.89805
rmesh_equiv_1670 vpwr.n138 vpwr.n4 57.802300000000002
rmesh_equiv_1671 vpwr.n138 vpwr.t14 15.849399999999999
rmesh_equiv_1672 vpwr.n1380 vpwr.n1381 185
rmesh_equiv_1673 vpwr.n1381 vpwr.n1382 185
rmesh_equiv_1674 vpwr.n1382 vpwr.n1383 185
rmesh_equiv_1675 vpwr.n1383 vpwr.n1384 25.6005
rmesh_equiv_1676 vpwr.n1384 vpwr.n1385 25.6005
rmesh_equiv_1677 vpwr.n1385 vpwr.n1386 185
rmesh_equiv_1678 vpwr.n1386 vpwr.n1387 185
rmesh_equiv_1679 vpwr.n1387 vpwr.n1388 185
rmesh_equiv_168 oscillator__q1.n10 oscillator__q1.n8 7.2756299999999996
rmesh_equiv_1680 vpwr.n1387 vpwr.t16 65.650899999999993
rmesh_equiv_1681 vpwr.n1388 vpwr.n1389 185
rmesh_equiv_1682 vpwr.n1389 vpwr.n1390 25.6005
rmesh_equiv_1683 vpwr.n139 vpwr.n140 185
rmesh_equiv_1684 vpwr.n139 vpwr.n2 240
rmesh_equiv_1685 vpwr.n139 vpwr.n3 787.05899999999997
rmesh_equiv_1686 vpwr.n1390 vpwr.n1391 25.6005
rmesh_equiv_1687 vpwr.n1391 vpwr.n1392 185
rmesh_equiv_1688 vpwr.n1392 vpwr.n1393 185
rmesh_equiv_1689 vpwr.n1393 vpwr.n1394 185
rmesh_equiv_169 oscillator__q1.n10 oscillator__q1.n9 27.236099999999997
rmesh_equiv_1690 vpwr.n1394 vpwr.n1395 185
rmesh_equiv_1691 vpwr.n1395 vpwr.n1396 25.6005
rmesh_equiv_1692 vpwr.n1396 vpwr.n1397 25.6005
rmesh_equiv_1693 vpwr.n1397 vpwr.n1398 185
rmesh_equiv_1694 vpwr.n1398 vpwr.n1399 185
rmesh_equiv_1695 vpwr.n1399 vpwr.n1400 185
rmesh_equiv_1696 vpwr.n1400 vpwr.n1401 185
rmesh_equiv_1697 vpwr.n1401 vpwr.n1402 25.6005
rmesh_equiv_1698 vpwr.n1402 vpwr.n1403 25.6005
rmesh_equiv_1699 vpwr.n1403 vpwr.n1404 185
rmesh_equiv_17 ctrl.n3 ctrl.n4 4.1529499999999997
rmesh_equiv_170 oscillator__q1.n2 oscillator__q1.n7 2.6342599999999998
rmesh_equiv_1700 vpwr.n1404 vpwr.n1405 185
rmesh_equiv_1701 vpwr.n1405 vpwr.n1406 185
rmesh_equiv_1702 vpwr.n1406 vpwr.n1407 185
rmesh_equiv_1703 vpwr.n1407 vpwr.n1408 25.6005
rmesh_equiv_1704 vpwr.n1408 vpwr.n1409 25.6005
rmesh_equiv_1705 vpwr.n1409 vpwr.n1410 185
rmesh_equiv_1706 vpwr.n141 vpwr.n143 185
rmesh_equiv_1707 vpwr.n141 vpwr.n152 88.8476
rmesh_equiv_1708 vpwr.n1410 vpwr.n1411 185
rmesh_equiv_1709 vpwr.n1411 vpwr.n1412 185
rmesh_equiv_171 oscillator__q1.n3 oscillator__q1.n4 48.279000000000003
rmesh_equiv_1710 vpwr.n1412 vpwr.n1413 185
rmesh_equiv_1711 vpwr.n1413 vpwr.n1414 25.6005
rmesh_equiv_1712 vpwr.n1414 vpwr.n1415 25.6005
rmesh_equiv_1713 vpwr.n1415 vpwr.n1416 185
rmesh_equiv_1714 vpwr.n1416 vpwr.n1417 185
rmesh_equiv_1715 vpwr.n1417 vpwr.n1418 185
rmesh_equiv_1716 vpwr.n1418 vpwr.n1419 185
rmesh_equiv_1717 vpwr.n1419 vpwr.n1420 25.6005
rmesh_equiv_1718 vpwr.n142 vpwr.n144 185
rmesh_equiv_1719 vpwr.n142 vpwr.n161 25.6005
rmesh_equiv_172 oscillator__q1.n3 oscillator__q1.n6 2.38164
rmesh_equiv_1720 vpwr.n142 vpwr.n172 88.8476
rmesh_equiv_1721 vpwr.n1420 vpwr.n1421 25.6005
rmesh_equiv_1722 vpwr.n1421 vpwr.n1422 185
rmesh_equiv_1723 vpwr.n1422 vpwr.n1423 185
rmesh_equiv_1724 vpwr.n1423 vpwr.n1424 185
rmesh_equiv_1725 vpwr.n1424 vpwr.n1425 185
rmesh_equiv_1726 vpwr.n1425 vpwr.n1426 25.6005
rmesh_equiv_1727 vpwr.n1426 vpwr.n1428 25.6005
rmesh_equiv_1728 vpwr.n1427 vpwr.n1428 25.6005
rmesh_equiv_1729 vpwr.n1428 vpwr.n1429 185
rmesh_equiv_173 oscillator__q1.n4 oscillator__q1.n5 54.441499999999998
rmesh_equiv_1730 vpwr.n1429 vpwr.n1430 185
rmesh_equiv_1731 vpwr.n143 vpwr.n153 832.94199999999989
rmesh_equiv_1732 vpwr.n143 vpwr.n155 185
rmesh_equiv_1733 vpwr.n143 vpwr.n171 240
rmesh_equiv_1734 vpwr.n1430 vpwr.n1431 185
rmesh_equiv_1735 vpwr.n1431 vpwr.n1432 185
rmesh_equiv_1736 vpwr.n1432 vpwr.n1433 25.6005
rmesh_equiv_1737 vpwr.n1433 vpwr.n1434 25.6005
rmesh_equiv_1738 vpwr.n1434 vpwr.n1435 185
rmesh_equiv_1739 vpwr.n1435 vpwr.n1436 185
rmesh_equiv_174 oscillator__q1.n4 oscillator__q1.t1 3.5711299999999997
rmesh_equiv_1740 vpwr.n1436 vpwr.n1437 185
rmesh_equiv_1741 vpwr.n1437 vpwr.n1438 776.471
rmesh_equiv_1742 vpwr.n1438 vpwr.n1439 185
rmesh_equiv_1743 vpwr.n144 vpwr.n145 185.00310000000002
rmesh_equiv_1744 vpwr.n144 vpwr.n163 240.00290767186621
rmesh_equiv_1745 vpwr.n144 vpwr.n171 832.94199999999989
rmesh_equiv_1746 vpwr.n1440 vpwr.n1445 0.12975
rmesh_equiv_1747 vpwr.n1441 vpwr.n1442 40.104900000000001
rmesh_equiv_1748 vpwr.n1441 vpwr.n1444 0.72065299999999999
rmesh_equiv_1749 vpwr.n1442 vpwr.n1443 42.739100000000001
rmesh_equiv_175 oscillator__q1.n5 oscillator__q1.n6 0.71089000000000002
rmesh_equiv_1750 vpwr.n1442 vpwr.t17 2.8570000000000002
rmesh_equiv_1751 vpwr.n1443 vpwr.n1444 1.10033
rmesh_equiv_1752 vpwr.n1444 vpwr.n1445 18.497
rmesh_equiv_1753 vpwr.n145 vpwr.n147 185.00310000000002
rmesh_equiv_1754 vpwr.n145 vpwr.n163 185.00310000000002
rmesh_equiv_1755 vpwr.n145 vpwr.n165 185.00310000000002
rmesh_equiv_1756 vpwr.n145 vpwr.n170 207.39400000000001
rmesh_equiv_1757 vpwr.n146 vpwr.n155 185
rmesh_equiv_1758 vpwr.n146 vpwr.n158 832.94199999999989
rmesh_equiv_1759 vpwr.n146 vpwr.n160 185
rmesh_equiv_176 oscillator__q1.n6 oscillator__q1.n7 18.505400000000002
rmesh_equiv_1760 vpwr.n146 vpwr.n169 240
rmesh_equiv_1761 vpwr.n147 vpwr.n165 240.00290767186621
rmesh_equiv_1762 vpwr.n147 vpwr.n167 185
rmesh_equiv_1763 vpwr.n147 vpwr.n169 832.94199999999989
rmesh_equiv_1764 vpwr.n148 vpwr.n149 185
rmesh_equiv_1765 vpwr.n148 vpwr.n151 25.6005
rmesh_equiv_1766 vpwr.n148 vpwr.n159 25.6005
rmesh_equiv_1767 vpwr.n149 vpwr.n150 240
rmesh_equiv_1768 vpwr.n149 vpwr.n156 185.00310000000002
rmesh_equiv_1769 vpwr.n149 vpwr.n158 240.00290767186621
rmesh_equiv_177 oscillator__q1.n7 oscillator__q1.n8 17.688199999999998
rmesh_equiv_1770 vpwr.n150 vpwr.n151 185
rmesh_equiv_1771 vpwr.n150 vpwr.n153 240.00290767186621
rmesh_equiv_1772 vpwr.n150 vpwr.n156 185.00310000000002
rmesh_equiv_1773 vpwr.n151 vpwr.n152 25.6005
rmesh_equiv_1774 vpwr.n152 vpwr.n153 185
rmesh_equiv_1775 vpwr.n153 vpwr.n156 185.00310000000002
rmesh_equiv_1776 vpwr.n155 vpwr.n156 207.39400000000001
rmesh_equiv_1777 vpwr.n155 vpwr.t2 56.866700000000009
rmesh_equiv_1778 vpwr.n156 vpwr.n158 185.00310000000002
rmesh_equiv_1779 vpwr.n158 vpwr.n159 185
rmesh_equiv_178 oscillator__q1.n9 oscillator__q1.t0 4.3505000000000003
rmesh_equiv_1780 vpwr.n159 vpwr.n160 88.8476
rmesh_equiv_1781 vpwr.n160 vpwr.n168 25.6005
rmesh_equiv_1782 vpwr.n161 vpwr.n163 185
rmesh_equiv_1783 vpwr.n161 vpwr.n166 25.6005
rmesh_equiv_1784 vpwr.n163 vpwr.n165 240
rmesh_equiv_1785 vpwr.n165 vpwr.n166 185
rmesh_equiv_1786 vpwr.n166 vpwr.n167 25.6005
rmesh_equiv_1787 vpwr.n167 vpwr.n168 88.8476
rmesh_equiv_1788 vpwr.n168 vpwr.n169 185
rmesh_equiv_1789 vpwr.n169 vpwr.n170 185
rmesh_equiv_179 out out.n0 2.0950216324394999
rmesh_equiv_1790 vpwr.n170 vpwr.n171 185
rmesh_equiv_1791 vpwr.n170 vpwr.t2 56.866700000000009
rmesh_equiv_1792 vpwr.n171 vpwr.n172 185
rmesh_equiv_1793 vpwr.n173 vpwr.n177 0.12975
rmesh_equiv_1794 vpwr.n174 vpwr.n176 10.151300000000001
rmesh_equiv_1795 vpwr.n174 vpwr.t3 700.48400000000004
rmesh_equiv_1796 vpwr.n175 vpwr.n176 10.151300000000001
rmesh_equiv_1797 vpwr.n175 vpwr.t3 700.48400000000004
rmesh_equiv_1798 vpwr.n176 vpwr.n177 18.625699999999998
rmesh_equiv_1799 vpwr.n177 vpwr.n210 1.5056700000000001
rmesh_equiv_18 ctrl.n4 ctrl.n5 4.1529499999999997
rmesh_equiv_180 out out.n1 35.785499999999999
rmesh_equiv_1800 vpwr.n178 vpwr.n180 185
rmesh_equiv_1801 vpwr.n178 vpwr.n189 88.8476
rmesh_equiv_1802 vpwr.n179 vpwr.n181 185
rmesh_equiv_1803 vpwr.n179 vpwr.n198 25.6005
rmesh_equiv_1804 vpwr.n179 vpwr.n209 88.8476
rmesh_equiv_1805 vpwr.n180 vpwr.n190 832.94199999999989
rmesh_equiv_1806 vpwr.n180 vpwr.n192 185
rmesh_equiv_1807 vpwr.n180 vpwr.n208 240
rmesh_equiv_1808 vpwr.n181 vpwr.n182 185.00310000000002
rmesh_equiv_1809 vpwr.n181 vpwr.n200 240.00290767186621
rmesh_equiv_181 out out.n11 6.7655600000000007
rmesh_equiv_1810 vpwr.n181 vpwr.n208 832.94199999999989
rmesh_equiv_1811 vpwr.n182 vpwr.n184 185.00310000000002
rmesh_equiv_1812 vpwr.n182 vpwr.n200 185.00310000000002
rmesh_equiv_1813 vpwr.n182 vpwr.n202 185.00310000000002
rmesh_equiv_1814 vpwr.n182 vpwr.n207 207.39400000000001
rmesh_equiv_1815 vpwr.n183 vpwr.n192 185
rmesh_equiv_1816 vpwr.n183 vpwr.n195 832.94199999999989
rmesh_equiv_1817 vpwr.n183 vpwr.n197 185
rmesh_equiv_1818 vpwr.n183 vpwr.n206 240
rmesh_equiv_1819 vpwr.n184 vpwr.n202 240.00290767186621
rmesh_equiv_182 out out.n13 23.111999999999998
rmesh_equiv_1820 vpwr.n184 vpwr.n204 185
rmesh_equiv_1821 vpwr.n184 vpwr.n206 832.94199999999989
rmesh_equiv_1822 vpwr.n185 vpwr.n186 185
rmesh_equiv_1823 vpwr.n185 vpwr.n188 25.6005
rmesh_equiv_1824 vpwr.n185 vpwr.n196 25.6005
rmesh_equiv_1825 vpwr.n186 vpwr.n187 240
rmesh_equiv_1826 vpwr.n186 vpwr.n193 185.00310000000002
rmesh_equiv_1827 vpwr.n186 vpwr.n195 240.00290767186621
rmesh_equiv_1828 vpwr.n187 vpwr.n188 185
rmesh_equiv_1829 vpwr.n187 vpwr.n190 240.00290767186621
rmesh_equiv_183 out out.n15 7.4956200000000006
rmesh_equiv_1830 vpwr.n187 vpwr.n193 185.00310000000002
rmesh_equiv_1831 vpwr.n188 vpwr.n189 25.6005
rmesh_equiv_1832 vpwr.n189 vpwr.n190 185
rmesh_equiv_1833 vpwr.n190 vpwr.n193 185.00310000000002
rmesh_equiv_1834 vpwr.n192 vpwr.n193 207.39400000000001
rmesh_equiv_1835 vpwr.n192 vpwr.t0 56.866700000000009
rmesh_equiv_1836 vpwr.n193 vpwr.n195 185.00310000000002
rmesh_equiv_1837 vpwr.n195 vpwr.n196 185
rmesh_equiv_1838 vpwr.n196 vpwr.n197 88.8476
rmesh_equiv_1839 vpwr.n197 vpwr.n205 25.6005
rmesh_equiv_184 out out.n2 35.769799999999996
rmesh_equiv_1840 vpwr.n198 vpwr.n200 185
rmesh_equiv_1841 vpwr.n198 vpwr.n203 25.6005
rmesh_equiv_1842 vpwr.n2 vpwr.n67 787.05899999999997
rmesh_equiv_1843 vpwr.n2 vpwr.n69 185
rmesh_equiv_1844 vpwr.n20 vpwr.n63 240
rmesh_equiv_1845 vpwr.n20 vpwr.n65 185
rmesh_equiv_1846 vpwr.n20 vpwr.n67 240.00290767186621
rmesh_equiv_1847 vpwr.n20 vpwr.n70 185.00310000000002
rmesh_equiv_1848 vpwr.n200 vpwr.n202 240
rmesh_equiv_1849 vpwr.n202 vpwr.n203 185
rmesh_equiv_185 out out.n3 35.785499999999999
rmesh_equiv_1850 vpwr.n203 vpwr.n204 25.6005
rmesh_equiv_1851 vpwr.n204 vpwr.n205 88.8476
rmesh_equiv_1852 vpwr.n205 vpwr.n206 185
rmesh_equiv_1853 vpwr.n206 vpwr.n207 185
rmesh_equiv_1854 vpwr.n207 vpwr.n208 185
rmesh_equiv_1855 vpwr.n207 vpwr.t0 56.866700000000009
rmesh_equiv_1856 vpwr.n208 vpwr.n209 185
rmesh_equiv_1857 vpwr.n21 vpwr.n22 185
rmesh_equiv_1858 vpwr.n21 vpwr.n24 240.00290767186621
rmesh_equiv_1859 vpwr.n21 vpwr.n70 185.00310000000002
rmesh_equiv_186 out out.n4 34.4938
rmesh_equiv_1860 vpwr.n21 vpwr.n8 240
rmesh_equiv_1861 vpwr.n210 vpwr.n214 0.12975
rmesh_equiv_1862 vpwr.n211 vpwr.n213 10.151300000000001
rmesh_equiv_1863 vpwr.n211 vpwr.t1 700.48400000000004
rmesh_equiv_1864 vpwr.n212 vpwr.n213 10.151300000000001
rmesh_equiv_1865 vpwr.n212 vpwr.t1 700.48400000000004
rmesh_equiv_1866 vpwr.n213 vpwr.n214 18.625699999999998
rmesh_equiv_1867 vpwr.n214 vpwr.n247 1.5056700000000001
rmesh_equiv_1868 vpwr.n215 vpwr.n217 185
rmesh_equiv_1869 vpwr.n215 vpwr.n226 88.8476
rmesh_equiv_187 out out.n5 35.203899999999997
rmesh_equiv_1870 vpwr.n216 vpwr.n218 185
rmesh_equiv_1871 vpwr.n216 vpwr.n235 25.6005
rmesh_equiv_1872 vpwr.n216 vpwr.n246 88.8476
rmesh_equiv_1873 vpwr.n217 vpwr.n227 832.94199999999989
rmesh_equiv_1874 vpwr.n217 vpwr.n229 185
rmesh_equiv_1875 vpwr.n217 vpwr.n245 240
rmesh_equiv_1876 vpwr.n218 vpwr.n219 185.00310000000002
rmesh_equiv_1877 vpwr.n218 vpwr.n237 240.00290767186621
rmesh_equiv_1878 vpwr.n218 vpwr.n245 832.94199999999989
rmesh_equiv_1879 vpwr.n219 vpwr.n221 185.00310000000002
rmesh_equiv_188 out out.n6 17.948799999999999
rmesh_equiv_1880 vpwr.n219 vpwr.n237 185.00310000000002
rmesh_equiv_1881 vpwr.n219 vpwr.n239 185.00310000000002
rmesh_equiv_1882 vpwr.n219 vpwr.n244 207.39400000000001
rmesh_equiv_1883 vpwr.n22 vpwr.n23 25.6005
rmesh_equiv_1884 vpwr.n22 vpwr.n7 25.6005
rmesh_equiv_1885 vpwr.n220 vpwr.n229 185
rmesh_equiv_1886 vpwr.n220 vpwr.n232 832.94199999999989
rmesh_equiv_1887 vpwr.n220 vpwr.n234 185
rmesh_equiv_1888 vpwr.n220 vpwr.n243 240
rmesh_equiv_1889 vpwr.n221 vpwr.n239 240.00290767186621
rmesh_equiv_189 out out.n8 20.2395
rmesh_equiv_1890 vpwr.n221 vpwr.n241 185
rmesh_equiv_1891 vpwr.n221 vpwr.n243 832.94199999999989
rmesh_equiv_1892 vpwr.n222 vpwr.n223 185
rmesh_equiv_1893 vpwr.n222 vpwr.n225 25.6005
rmesh_equiv_1894 vpwr.n222 vpwr.n233 25.6005
rmesh_equiv_1895 vpwr.n223 vpwr.n224 240
rmesh_equiv_1896 vpwr.n223 vpwr.n230 185.00310000000002
rmesh_equiv_1897 vpwr.n223 vpwr.n232 240.00290767186621
rmesh_equiv_1898 vpwr.n224 vpwr.n225 185
rmesh_equiv_1899 vpwr.n224 vpwr.n227 240.00290767186621
rmesh_equiv_19 ctrl.n5 ctrl.n6 4.1529499999999997
rmesh_equiv_190 out out.t2 0.00361634
rmesh_equiv_1900 vpwr.n224 vpwr.n230 185.00310000000002
rmesh_equiv_1901 vpwr.n225 vpwr.n226 25.6005
rmesh_equiv_1902 vpwr.n226 vpwr.n227 185
rmesh_equiv_1903 vpwr.n227 vpwr.n230 185.00310000000002
rmesh_equiv_1904 vpwr.n229 vpwr.n230 207.39400000000001
rmesh_equiv_1905 vpwr.n229 vpwr.t24 56.866700000000009
rmesh_equiv_1906 vpwr.n23 vpwr.n24 185
rmesh_equiv_1907 vpwr.n23 vpwr.n26 25.6005
rmesh_equiv_1908 vpwr.n230 vpwr.n232 185.00310000000002
rmesh_equiv_1909 vpwr.n232 vpwr.n233 185
rmesh_equiv_191 out out.t3 330.34100000000001
rmesh_equiv_1910 vpwr.n233 vpwr.n234 88.8476
rmesh_equiv_1911 vpwr.n234 vpwr.n242 25.6005
rmesh_equiv_1912 vpwr.n235 vpwr.n237 185
rmesh_equiv_1913 vpwr.n235 vpwr.n240 25.6005
rmesh_equiv_1914 vpwr.n237 vpwr.n239 240
rmesh_equiv_1915 vpwr.n239 vpwr.n240 185
rmesh_equiv_1916 vpwr.n24 vpwr.n25 240
rmesh_equiv_1917 vpwr.n24 vpwr.n70 185.00310000000002
rmesh_equiv_1918 vpwr.n240 vpwr.n241 25.6005
rmesh_equiv_1919 vpwr.n241 vpwr.n242 88.8476
rmesh_equiv_192 out out.t4 854.11400000000003
rmesh_equiv_1920 vpwr.n242 vpwr.n243 185
rmesh_equiv_1921 vpwr.n243 vpwr.n244 185
rmesh_equiv_1922 vpwr.n244 vpwr.n245 185
rmesh_equiv_1923 vpwr.n244 vpwr.t24 56.866700000000009
rmesh_equiv_1924 vpwr.n245 vpwr.n246 185
rmesh_equiv_1925 vpwr.n247 vpwr.n251 0.12975
rmesh_equiv_1926 vpwr.n248 vpwr.n250 10.151300000000001
rmesh_equiv_1927 vpwr.n248 vpwr.t25 700.48400000000004
rmesh_equiv_1928 vpwr.n249 vpwr.n250 10.151300000000001
rmesh_equiv_1929 vpwr.n249 vpwr.t25 700.48400000000004
rmesh_equiv_193 out out.t5 315.88
rmesh_equiv_1930 vpwr.n25 vpwr.n26 185
rmesh_equiv_1931 vpwr.n25 vpwr.n28 240.00290767186621
rmesh_equiv_1932 vpwr.n25 vpwr.n70 185.00310000000002
rmesh_equiv_1933 vpwr.n250 vpwr.n251 18.625699999999998
rmesh_equiv_1934 vpwr.n251 vpwr.n284 1.5056700000000001
rmesh_equiv_1935 vpwr.n252 vpwr.n254 185
rmesh_equiv_1936 vpwr.n252 vpwr.n263 88.8476
rmesh_equiv_1937 vpwr.n253 vpwr.n255 185
rmesh_equiv_1938 vpwr.n253 vpwr.n272 25.6005
rmesh_equiv_1939 vpwr.n253 vpwr.n283 88.8476
rmesh_equiv_194 out out.t6 1511.24
rmesh_equiv_1940 vpwr.n254 vpwr.n264 832.94199999999989
rmesh_equiv_1941 vpwr.n254 vpwr.n266 185
rmesh_equiv_1942 vpwr.n254 vpwr.n282 240
rmesh_equiv_1943 vpwr.n255 vpwr.n256 185.00310000000002
rmesh_equiv_1944 vpwr.n255 vpwr.n274 240.00290767186621
rmesh_equiv_1945 vpwr.n255 vpwr.n282 832.94199999999989
rmesh_equiv_1946 vpwr.n256 vpwr.n258 185.00310000000002
rmesh_equiv_1947 vpwr.n256 vpwr.n274 185.00310000000002
rmesh_equiv_1948 vpwr.n256 vpwr.n276 185.00310000000002
rmesh_equiv_1949 vpwr.n256 vpwr.n281 207.39400000000001
rmesh_equiv_195 out out.t7 315.88
rmesh_equiv_1950 vpwr.n257 vpwr.n266 185
rmesh_equiv_1951 vpwr.n257 vpwr.n269 832.94199999999989
rmesh_equiv_1952 vpwr.n257 vpwr.n271 185
rmesh_equiv_1953 vpwr.n257 vpwr.n280 240
rmesh_equiv_1954 vpwr.n258 vpwr.n276 240.00290767186621
rmesh_equiv_1955 vpwr.n258 vpwr.n278 185
rmesh_equiv_1956 vpwr.n258 vpwr.n280 832.94199999999989
rmesh_equiv_1957 vpwr.n259 vpwr.n260 185
rmesh_equiv_1958 vpwr.n259 vpwr.n262 25.6005
rmesh_equiv_1959 vpwr.n259 vpwr.n270 25.6005
rmesh_equiv_196 out out.t8 330.34100000000001
rmesh_equiv_1960 vpwr.n26 vpwr.n27 25.6005
rmesh_equiv_1961 vpwr.n260 vpwr.n261 240
rmesh_equiv_1962 vpwr.n260 vpwr.n267 185.00310000000002
rmesh_equiv_1963 vpwr.n260 vpwr.n269 240.00290767186621
rmesh_equiv_1964 vpwr.n261 vpwr.n262 185
rmesh_equiv_1965 vpwr.n261 vpwr.n264 240.00290767186621
rmesh_equiv_1966 vpwr.n261 vpwr.n267 185.00310000000002
rmesh_equiv_1967 vpwr.n262 vpwr.n263 25.6005
rmesh_equiv_1968 vpwr.n263 vpwr.n264 185
rmesh_equiv_1969 vpwr.n264 vpwr.n267 185.00310000000002
rmesh_equiv_197 out.n0 out.n1 0.81771300000000002
rmesh_equiv_1970 vpwr.n266 vpwr.n267 207.39400000000001
rmesh_equiv_1971 vpwr.n266 vpwr.t20 56.866700000000009
rmesh_equiv_1972 vpwr.n267 vpwr.n269 185.00310000000002
rmesh_equiv_1973 vpwr.n269 vpwr.n270 185
rmesh_equiv_1974 vpwr.n27 vpwr.n28 185
rmesh_equiv_1975 vpwr.n27 vpwr.n30 25.6005
rmesh_equiv_1976 vpwr.n270 vpwr.n271 88.8476
rmesh_equiv_1977 vpwr.n271 vpwr.n279 25.6005
rmesh_equiv_1978 vpwr.n272 vpwr.n274 185
rmesh_equiv_1979 vpwr.n272 vpwr.n277 25.6005
rmesh_equiv_198 out.n1 out.n2 4.1335600000000001
rmesh_equiv_1980 vpwr.n274 vpwr.n276 240
rmesh_equiv_1981 vpwr.n276 vpwr.n277 185
rmesh_equiv_1982 vpwr.n277 vpwr.n278 25.6005
rmesh_equiv_1983 vpwr.n278 vpwr.n279 88.8476
rmesh_equiv_1984 vpwr.n279 vpwr.n280 185
rmesh_equiv_1985 vpwr.n28 vpwr.n29 240
rmesh_equiv_1986 vpwr.n28 vpwr.n70 185.00310000000002
rmesh_equiv_1987 vpwr.n280 vpwr.n281 185
rmesh_equiv_1988 vpwr.n281 vpwr.n282 185
rmesh_equiv_1989 vpwr.n281 vpwr.t20 56.866700000000009
rmesh_equiv_199 out.n10 out.n15 0.81771300000000002
rmesh_equiv_1990 vpwr.n282 vpwr.n283 185
rmesh_equiv_1991 vpwr.n284 vpwr.n288 0.12975
rmesh_equiv_1992 vpwr.n285 vpwr.n287 10.151300000000001
rmesh_equiv_1993 vpwr.n285 vpwr.t21 700.48400000000004
rmesh_equiv_1994 vpwr.n286 vpwr.n287 10.151300000000001
rmesh_equiv_1995 vpwr.n286 vpwr.t21 700.48400000000004
rmesh_equiv_1996 vpwr.n287 vpwr.n288 18.625699999999998
rmesh_equiv_1997 vpwr.n288 vpwr.n321 1.5056700000000001
rmesh_equiv_1998 vpwr.n289 vpwr.n291 185
rmesh_equiv_1999 vpwr.n289 vpwr.n300 88.8476
rmesh_equiv_2 ctrl ctrl.n2 4.1357100000000004
rmesh_equiv_20 ctrl.n6 ctrl.t0 28.737200000000001
rmesh_equiv_200 out.n10 out.n5 10.8863
rmesh_equiv_2000 vpwr.n29 vpwr.n30 185
rmesh_equiv_2001 vpwr.n29 vpwr.n32 240.00290767186621
rmesh_equiv_2002 vpwr.n29 vpwr.n70 185.00310000000002
rmesh_equiv_2003 vpwr.n290 vpwr.n292 185
rmesh_equiv_2004 vpwr.n290 vpwr.n309 25.6005
rmesh_equiv_2005 vpwr.n290 vpwr.n320 88.8476
rmesh_equiv_2006 vpwr.n291 vpwr.n301 832.94199999999989
rmesh_equiv_2007 vpwr.n291 vpwr.n303 185
rmesh_equiv_2008 vpwr.n291 vpwr.n319 240
rmesh_equiv_2009 vpwr.n292 vpwr.n293 185.00310000000002
rmesh_equiv_201 out.n10 out.n9 16.438199999999998
rmesh_equiv_2010 vpwr.n292 vpwr.n311 240.00290767186621
rmesh_equiv_2011 vpwr.n292 vpwr.n319 832.94199999999989
rmesh_equiv_2012 vpwr.n293 vpwr.n295 185.00310000000002
rmesh_equiv_2013 vpwr.n293 vpwr.n311 185.00310000000002
rmesh_equiv_2014 vpwr.n293 vpwr.n313 185.00310000000002
rmesh_equiv_2015 vpwr.n293 vpwr.n318 207.39400000000001
rmesh_equiv_2016 vpwr.n294 vpwr.n303 185
rmesh_equiv_2017 vpwr.n294 vpwr.n306 832.94199999999989
rmesh_equiv_2018 vpwr.n294 vpwr.n308 185
rmesh_equiv_2019 vpwr.n294 vpwr.n317 240
rmesh_equiv_202 out.n11 out.n12 39.311100000000003
rmesh_equiv_2020 vpwr.n295 vpwr.n313 240.00290767186621
rmesh_equiv_2021 vpwr.n295 vpwr.n315 185
rmesh_equiv_2022 vpwr.n295 vpwr.n317 832.94199999999989
rmesh_equiv_2023 vpwr.n296 vpwr.n297 185
rmesh_equiv_2024 vpwr.n296 vpwr.n299 25.6005
rmesh_equiv_2025 vpwr.n296 vpwr.n307 25.6005
rmesh_equiv_2026 vpwr.n297 vpwr.n298 240
rmesh_equiv_2027 vpwr.n297 vpwr.n304 185.00310000000002
rmesh_equiv_2028 vpwr.n297 vpwr.n306 240.00290767186621
rmesh_equiv_2029 vpwr.n298 vpwr.n299 185
rmesh_equiv_203 out.n11 out.n14 0.555091
rmesh_equiv_2030 vpwr.n298 vpwr.n301 240.00290767186621
rmesh_equiv_2031 vpwr.n298 vpwr.n304 185.00310000000002
rmesh_equiv_2032 vpwr.n299 vpwr.n300 25.6005
rmesh_equiv_2033 vpwr.n3 vpwr.n4 185
rmesh_equiv_2034 vpwr.n3 vpwr.n88 240
rmesh_equiv_2035 vpwr.n30 vpwr.n31 25.6005
rmesh_equiv_2036 vpwr.n300 vpwr.n301 185
rmesh_equiv_2037 vpwr.n301 vpwr.n304 185.00310000000002
rmesh_equiv_2038 vpwr.n303 vpwr.n304 207.39400000000001
rmesh_equiv_2039 vpwr.n303 vpwr.t18 56.866700000000009
rmesh_equiv_204 out.n12 out.n13 27.236099999999997
rmesh_equiv_2040 vpwr.n304 vpwr.n306 185.00310000000002
rmesh_equiv_2041 vpwr.n306 vpwr.n307 185
rmesh_equiv_2042 vpwr.n307 vpwr.n308 88.8476
rmesh_equiv_2043 vpwr.n308 vpwr.n316 25.6005
rmesh_equiv_2044 vpwr.n309 vpwr.n311 185
rmesh_equiv_2045 vpwr.n309 vpwr.n314 25.6005
rmesh_equiv_2046 vpwr.n31 vpwr.n32 185
rmesh_equiv_2047 vpwr.n31 vpwr.n34 25.6005
rmesh_equiv_2048 vpwr.n311 vpwr.n313 240
rmesh_equiv_2049 vpwr.n313 vpwr.n314 185
rmesh_equiv_205 out.n12 out.t1 4.3505000000000003
rmesh_equiv_2050 vpwr.n314 vpwr.n315 25.6005
rmesh_equiv_2051 vpwr.n315 vpwr.n316 88.8476
rmesh_equiv_2052 vpwr.n316 vpwr.n317 185
rmesh_equiv_2053 vpwr.n317 vpwr.n318 185
rmesh_equiv_2054 vpwr.n318 vpwr.n319 185
rmesh_equiv_2055 vpwr.n318 vpwr.t18 56.866700000000009
rmesh_equiv_2056 vpwr.n319 vpwr.n320 185
rmesh_equiv_2057 vpwr.n32 vpwr.n33 240
rmesh_equiv_2058 vpwr.n32 vpwr.n70 185.00310000000002
rmesh_equiv_2059 vpwr.n321 vpwr.n325 0.12975
rmesh_equiv_206 out.n13 out.n14 7.2756299999999996
rmesh_equiv_2060 vpwr.n322 vpwr.n324 10.151300000000001
rmesh_equiv_2061 vpwr.n322 vpwr.t19 700.48400000000004
rmesh_equiv_2062 vpwr.n323 vpwr.n324 10.151300000000001
rmesh_equiv_2063 vpwr.n323 vpwr.t19 700.48400000000004
rmesh_equiv_2064 vpwr.n324 vpwr.n325 18.625699999999998
rmesh_equiv_2065 vpwr.n325 vpwr.n358 1.5056700000000001
rmesh_equiv_2066 vpwr.n326 vpwr.n328 185
rmesh_equiv_2067 vpwr.n326 vpwr.n337 88.8476
rmesh_equiv_2068 vpwr.n327 vpwr.n329 185
rmesh_equiv_2069 vpwr.n327 vpwr.n346 25.6005
rmesh_equiv_207 out.n14 out.n15 16.438199999999998
rmesh_equiv_2070 vpwr.n327 vpwr.n357 88.8476
rmesh_equiv_2071 vpwr.n328 vpwr.n338 832.94199999999989
rmesh_equiv_2072 vpwr.n328 vpwr.n340 185
rmesh_equiv_2073 vpwr.n328 vpwr.n356 240
rmesh_equiv_2074 vpwr.n329 vpwr.n330 185.00310000000002
rmesh_equiv_2075 vpwr.n329 vpwr.n348 240.00290767186621
rmesh_equiv_2076 vpwr.n329 vpwr.n356 832.94199999999989
rmesh_equiv_2077 vpwr.n33 vpwr.n34 185
rmesh_equiv_2078 vpwr.n33 vpwr.n36 240.00290767186621
rmesh_equiv_2079 vpwr.n33 vpwr.n70 185.00310000000002
rmesh_equiv_208 out.n2 out.n3 0.81771300000000002
rmesh_equiv_2080 vpwr.n330 vpwr.n332 185.00310000000002
rmesh_equiv_2081 vpwr.n330 vpwr.n348 185.00310000000002
rmesh_equiv_2082 vpwr.n330 vpwr.n350 185.00310000000002
rmesh_equiv_2083 vpwr.n330 vpwr.n355 207.39400000000001
rmesh_equiv_2084 vpwr.n331 vpwr.n340 185
rmesh_equiv_2085 vpwr.n331 vpwr.n343 832.94199999999989
rmesh_equiv_2086 vpwr.n331 vpwr.n345 185
rmesh_equiv_2087 vpwr.n331 vpwr.n354 240
rmesh_equiv_2088 vpwr.n332 vpwr.n350 240.00290767186621
rmesh_equiv_2089 vpwr.n332 vpwr.n352 185
rmesh_equiv_209 out.n3 out.n4 62.458199999999998
rmesh_equiv_2090 vpwr.n332 vpwr.n354 832.94199999999989
rmesh_equiv_2091 vpwr.n333 vpwr.n334 185
rmesh_equiv_2092 vpwr.n333 vpwr.n336 25.6005
rmesh_equiv_2093 vpwr.n333 vpwr.n344 25.6005
rmesh_equiv_2094 vpwr.n334 vpwr.n335 240
rmesh_equiv_2095 vpwr.n334 vpwr.n341 185.00310000000002
rmesh_equiv_2096 vpwr.n334 vpwr.n343 240.00290767186621
rmesh_equiv_2097 vpwr.n335 vpwr.n336 185
rmesh_equiv_2098 vpwr.n335 vpwr.n338 240.00290767186621
rmesh_equiv_2099 vpwr.n335 vpwr.n341 185.00310000000002
rmesh_equiv_21 oscillator__n0 oscillator__n0.n0 6.7655600000000007
rmesh_equiv_210 out.n4 out.n5 0.81771300000000002
rmesh_equiv_2100 vpwr.n336 vpwr.n337 25.6005
rmesh_equiv_2101 vpwr.n337 vpwr.n338 185
rmesh_equiv_2102 vpwr.n338 vpwr.n341 185.00310000000002
rmesh_equiv_2103 vpwr.n34 vpwr.n35 25.6005
rmesh_equiv_2104 vpwr.n340 vpwr.n341 207.39400000000001
rmesh_equiv_2105 vpwr.n340 vpwr.t22 56.866700000000009
rmesh_equiv_2106 vpwr.n341 vpwr.n343 185.00310000000002
rmesh_equiv_2107 vpwr.n343 vpwr.n344 185
rmesh_equiv_2108 vpwr.n344 vpwr.n345 88.8476
rmesh_equiv_2109 vpwr.n345 vpwr.n353 25.6005
rmesh_equiv_211 out.n6 out.n7 48.279000000000003
rmesh_equiv_2110 vpwr.n346 vpwr.n348 185
rmesh_equiv_2111 vpwr.n346 vpwr.n351 25.6005
rmesh_equiv_2112 vpwr.n348 vpwr.n350 240
rmesh_equiv_2113 vpwr.n35 vpwr.n36 185
rmesh_equiv_2114 vpwr.n35 vpwr.n38 25.6005
rmesh_equiv_2115 vpwr.n350 vpwr.n351 185
rmesh_equiv_2116 vpwr.n351 vpwr.n352 25.6005
rmesh_equiv_2117 vpwr.n352 vpwr.n353 88.8476
rmesh_equiv_2118 vpwr.n353 vpwr.n354 185
rmesh_equiv_2119 vpwr.n354 vpwr.n355 185
rmesh_equiv_212 out.n6 out.n9 2.38164
rmesh_equiv_2120 vpwr.n355 vpwr.n356 185
rmesh_equiv_2121 vpwr.n355 vpwr.t22 56.866700000000009
rmesh_equiv_2122 vpwr.n356 vpwr.n357 185
rmesh_equiv_2123 vpwr.n358 vpwr.n362 0.12975
rmesh_equiv_2124 vpwr.n359 vpwr.n361 10.151300000000001
rmesh_equiv_2125 vpwr.n359 vpwr.t23 700.48400000000004
rmesh_equiv_2126 vpwr.n36 vpwr.n37 240
rmesh_equiv_2127 vpwr.n36 vpwr.n70 185.00310000000002
rmesh_equiv_2128 vpwr.n360 vpwr.n361 10.151300000000001
rmesh_equiv_2129 vpwr.n360 vpwr.t23 700.48400000000004
rmesh_equiv_213 out.n7 out.n8 54.441499999999998
rmesh_equiv_2130 vpwr.n361 vpwr.n362 18.625699999999998
rmesh_equiv_2131 vpwr.n362 vpwr.n395 1.5056700000000001
rmesh_equiv_2132 vpwr.n363 vpwr.n365 185
rmesh_equiv_2133 vpwr.n363 vpwr.n374 88.8476
rmesh_equiv_2134 vpwr.n364 vpwr.n366 185
rmesh_equiv_2135 vpwr.n364 vpwr.n383 25.6005
rmesh_equiv_2136 vpwr.n364 vpwr.n394 88.8476
rmesh_equiv_2137 vpwr.n365 vpwr.n375 832.94199999999989
rmesh_equiv_2138 vpwr.n365 vpwr.n377 185
rmesh_equiv_2139 vpwr.n365 vpwr.n393 240
rmesh_equiv_214 out.n7 out.t0 3.5711299999999997
rmesh_equiv_2140 vpwr.n366 vpwr.n367 185.00310000000002
rmesh_equiv_2141 vpwr.n366 vpwr.n385 240.00290767186621
rmesh_equiv_2142 vpwr.n366 vpwr.n393 832.94199999999989
rmesh_equiv_2143 vpwr.n367 vpwr.n369 185.00310000000002
rmesh_equiv_2144 vpwr.n367 vpwr.n385 185.00310000000002
rmesh_equiv_2145 vpwr.n367 vpwr.n387 185.00310000000002
rmesh_equiv_2146 vpwr.n367 vpwr.n392 207.39400000000001
rmesh_equiv_2147 vpwr.n368 vpwr.n377 185
rmesh_equiv_2148 vpwr.n368 vpwr.n380 832.94199999999989
rmesh_equiv_2149 vpwr.n368 vpwr.n382 185
rmesh_equiv_215 out.n8 out.n9 0.71089000000000002
rmesh_equiv_2150 vpwr.n368 vpwr.n391 240
rmesh_equiv_2151 vpwr.n369 vpwr.n387 240.00290767186621
rmesh_equiv_2152 vpwr.n369 vpwr.n389 185
rmesh_equiv_2153 vpwr.n369 vpwr.n391 832.94199999999989
rmesh_equiv_2154 vpwr.n37 vpwr.n38 185
rmesh_equiv_2155 vpwr.n37 vpwr.n40 240.00290767186621
rmesh_equiv_2156 vpwr.n37 vpwr.n70 185.00310000000002
rmesh_equiv_2157 vpwr.n370 vpwr.n371 185
rmesh_equiv_2158 vpwr.n370 vpwr.n373 25.6005
rmesh_equiv_2159 vpwr.n370 vpwr.n381 25.6005
rmesh_equiv_216 pd pd.n0 12.8005
rmesh_equiv_2160 vpwr.n371 vpwr.n372 240
rmesh_equiv_2161 vpwr.n371 vpwr.n378 185.00310000000002
rmesh_equiv_2162 vpwr.n371 vpwr.n380 240.00290767186621
rmesh_equiv_2163 vpwr.n372 vpwr.n373 185
rmesh_equiv_2164 vpwr.n372 vpwr.n375 240.00290767186621
rmesh_equiv_2165 vpwr.n372 vpwr.n378 185.00310000000002
rmesh_equiv_2166 vpwr.n373 vpwr.n374 25.6005
rmesh_equiv_2167 vpwr.n374 vpwr.n375 185
rmesh_equiv_2168 vpwr.n375 vpwr.n378 185.00310000000002
rmesh_equiv_2169 vpwr.n377 vpwr.n378 207.39400000000001
rmesh_equiv_217 pd pd.n1 12.8005
rmesh_equiv_2170 vpwr.n377 vpwr.t8 56.866700000000009
rmesh_equiv_2171 vpwr.n378 vpwr.n380 185.00310000000002
rmesh_equiv_2172 vpwr.n38 vpwr.n39 25.6005
rmesh_equiv_2173 vpwr.n380 vpwr.n381 185
rmesh_equiv_2174 vpwr.n381 vpwr.n382 88.8476
rmesh_equiv_2175 vpwr.n382 vpwr.n390 25.6005
rmesh_equiv_2176 vpwr.n383 vpwr.n385 185
rmesh_equiv_2177 vpwr.n383 vpwr.n388 25.6005
rmesh_equiv_2178 vpwr.n385 vpwr.n387 240
rmesh_equiv_2179 vpwr.n387 vpwr.n388 185
rmesh_equiv_218 pd pd.n10 12.8005
rmesh_equiv_2180 vpwr.n388 vpwr.n389 25.6005
rmesh_equiv_2181 vpwr.n389 vpwr.n390 88.8476
rmesh_equiv_2182 vpwr.n39 vpwr.n40 185
rmesh_equiv_2183 vpwr.n39 vpwr.n42 25.6005
rmesh_equiv_2184 vpwr.n390 vpwr.n391 185
rmesh_equiv_2185 vpwr.n391 vpwr.n392 185
rmesh_equiv_2186 vpwr.n392 vpwr.n393 185
rmesh_equiv_2187 vpwr.n392 vpwr.t8 56.866700000000009
rmesh_equiv_2188 vpwr.n393 vpwr.n394 185
rmesh_equiv_2189 vpwr.n395 vpwr.n399 0.12975
rmesh_equiv_219 pd pd.n2 12.8005
rmesh_equiv_2190 vpwr.n396 vpwr.n398 10.151300000000001
rmesh_equiv_2191 vpwr.n396 vpwr.t9 700.48400000000004
rmesh_equiv_2192 vpwr.n397 vpwr.n398 10.151300000000001
rmesh_equiv_2193 vpwr.n397 vpwr.t9 700.48400000000004
rmesh_equiv_2194 vpwr.n398 vpwr.n399 18.625699999999998
rmesh_equiv_2195 vpwr.n399 vpwr.n432 1.5056700000000001
rmesh_equiv_2196 vpwr.n4 vpwr.n6 185.00310000000002
rmesh_equiv_2197 vpwr.n4 vpwr.n78 185.00310000000002
rmesh_equiv_2198 vpwr.n4 vpwr.n80 185.00310000000002
rmesh_equiv_2199 vpwr.n4 vpwr.n82 185.00310000000002
rmesh_equiv_22 oscillator__n0 oscillator__n0.n1 15.6333
rmesh_equiv_220 pd pd.n4 12.8005
rmesh_equiv_2200 vpwr.n4 vpwr.n84 185.00310000000002
rmesh_equiv_2201 vpwr.n4 vpwr.n86 185.00310000000002
rmesh_equiv_2202 vpwr.n4 vpwr.n88 185.00310000000002
rmesh_equiv_2203 vpwr.n4 vpwr.n92 185.00310000000002
rmesh_equiv_2204 vpwr.n4 vpwr.n94 185.00310000000002
rmesh_equiv_2205 vpwr.n4 vpwr.n96 185.00310000000002
rmesh_equiv_2206 vpwr.n40 vpwr.n41 240
rmesh_equiv_2207 vpwr.n40 vpwr.n70 185.00310000000002
rmesh_equiv_2208 vpwr.n400 vpwr.n402 185
rmesh_equiv_2209 vpwr.n400 vpwr.n411 88.8476
rmesh_equiv_221 pd pd.n5 12.8005
rmesh_equiv_2210 vpwr.n401 vpwr.n403 185
rmesh_equiv_2211 vpwr.n401 vpwr.n420 25.6005
rmesh_equiv_2212 vpwr.n401 vpwr.n431 88.8476
rmesh_equiv_2213 vpwr.n402 vpwr.n412 832.94199999999989
rmesh_equiv_2214 vpwr.n402 vpwr.n414 185
rmesh_equiv_2215 vpwr.n402 vpwr.n430 240
rmesh_equiv_2216 vpwr.n403 vpwr.n404 185.00310000000002
rmesh_equiv_2217 vpwr.n403 vpwr.n422 240.00290767186621
rmesh_equiv_2218 vpwr.n403 vpwr.n430 832.94199999999989
rmesh_equiv_2219 vpwr.n404 vpwr.n406 185.00310000000002
rmesh_equiv_222 pd.n0 pd.n9 10.151300000000001
rmesh_equiv_2220 vpwr.n404 vpwr.n422 185.00310000000002
rmesh_equiv_2221 vpwr.n404 vpwr.n424 185.00310000000002
rmesh_equiv_2222 vpwr.n404 vpwr.n429 207.39400000000001
rmesh_equiv_2223 vpwr.n405 vpwr.n414 185
rmesh_equiv_2224 vpwr.n405 vpwr.n417 832.94199999999989
rmesh_equiv_2225 vpwr.n405 vpwr.n419 185
rmesh_equiv_2226 vpwr.n405 vpwr.n428 240
rmesh_equiv_2227 vpwr.n406 vpwr.n424 240.00290767186621
rmesh_equiv_2228 vpwr.n406 vpwr.n426 185
rmesh_equiv_2229 vpwr.n406 vpwr.n428 832.94199999999989
rmesh_equiv_223 pd.n0 pd.t0 700.48400000000004
rmesh_equiv_2230 vpwr.n407 vpwr.n408 185
rmesh_equiv_2231 vpwr.n407 vpwr.n410 25.6005
rmesh_equiv_2232 vpwr.n407 vpwr.n418 25.6005
rmesh_equiv_2233 vpwr.n408 vpwr.n409 240
rmesh_equiv_2234 vpwr.n408 vpwr.n415 185.00310000000002
rmesh_equiv_2235 vpwr.n408 vpwr.n417 240.00290767186621
rmesh_equiv_2236 vpwr.n409 vpwr.n410 185
rmesh_equiv_2237 vpwr.n409 vpwr.n412 240.00290767186621
rmesh_equiv_2238 vpwr.n409 vpwr.n415 185.00310000000002
rmesh_equiv_2239 vpwr.n41 vpwr.n42 185
rmesh_equiv_224 pd.n1 pd.n3 10.151300000000001
rmesh_equiv_2240 vpwr.n41 vpwr.n44 240.00290767186621
rmesh_equiv_2241 vpwr.n41 vpwr.n70 185.00310000000002
rmesh_equiv_2242 vpwr.n410 vpwr.n411 25.6005
rmesh_equiv_2243 vpwr.n411 vpwr.n412 185
rmesh_equiv_2244 vpwr.n412 vpwr.n415 185.00310000000002
rmesh_equiv_2245 vpwr.n414 vpwr.n415 207.39400000000001
rmesh_equiv_2246 vpwr.n414 vpwr.t4 56.866700000000009
rmesh_equiv_2247 vpwr.n415 vpwr.n417 185.00310000000002
rmesh_equiv_2248 vpwr.n417 vpwr.n418 185
rmesh_equiv_2249 vpwr.n418 vpwr.n419 88.8476
rmesh_equiv_225 pd.n1 pd.t2 700.48400000000004
rmesh_equiv_2250 vpwr.n419 vpwr.n427 25.6005
rmesh_equiv_2251 vpwr.n42 vpwr.n43 25.6005
rmesh_equiv_2252 vpwr.n420 vpwr.n422 185
rmesh_equiv_2253 vpwr.n420 vpwr.n425 25.6005
rmesh_equiv_2254 vpwr.n422 vpwr.n424 240
rmesh_equiv_2255 vpwr.n424 vpwr.n425 185
rmesh_equiv_2256 vpwr.n425 vpwr.n426 25.6005
rmesh_equiv_2257 vpwr.n426 vpwr.n427 88.8476
rmesh_equiv_2258 vpwr.n427 vpwr.n428 185
rmesh_equiv_2259 vpwr.n428 vpwr.n429 185
rmesh_equiv_226 pd.n10 pd.n9 10.151300000000001
rmesh_equiv_2260 vpwr.n429 vpwr.n430 185
rmesh_equiv_2261 vpwr.n429 vpwr.t4 56.866700000000009
rmesh_equiv_2262 vpwr.n43 vpwr.n44 185
rmesh_equiv_2263 vpwr.n43 vpwr.n46 25.6005
rmesh_equiv_2264 vpwr.n430 vpwr.n431 185
rmesh_equiv_2265 vpwr.n432 vpwr.n436 0.12975
rmesh_equiv_2266 vpwr.n433 vpwr.n435 10.151300000000001
rmesh_equiv_2267 vpwr.n433 vpwr.t5 700.48400000000004
rmesh_equiv_2268 vpwr.n434 vpwr.n435 10.151300000000001
rmesh_equiv_2269 vpwr.n434 vpwr.t5 700.48400000000004
rmesh_equiv_227 pd.n10 pd.t0 700.48400000000004
rmesh_equiv_2270 vpwr.n435 vpwr.n436 18.625699999999998
rmesh_equiv_2271 vpwr.n436 vpwr.n437 27.4056
rmesh_equiv_2272 vpwr.n437 vpwr.n613 28.159400000000002
rmesh_equiv_2273 vpwr.n437 vpwr.t26 24.265899999999998
rmesh_equiv_2274 vpwr.n438 vpwr.n446 185
rmesh_equiv_2275 vpwr.n438 vpwr.n607 82.823999999999998
rmesh_equiv_2276 vpwr.n439 vpwr.n444 185.00310000000002
rmesh_equiv_2277 vpwr.n439 vpwr.n446 240
rmesh_equiv_2278 vpwr.n439 vpwr.n611 240.00290767186621
rmesh_equiv_2279 vpwr.n44 vpwr.n45 240
rmesh_equiv_228 pd.n2 pd.n3 10.151300000000001
rmesh_equiv_2280 vpwr.n44 vpwr.n70 185.00310000000002
rmesh_equiv_2281 vpwr.n440 vpwr.n600 25.6005
rmesh_equiv_2282 vpwr.n440 vpwr.n610 185
rmesh_equiv_2283 vpwr.n440 vpwr.n612 82.823999999999998
rmesh_equiv_2284 vpwr.n442 vpwr.n443 185
rmesh_equiv_2285 vpwr.n442 vpwr.n600 185
rmesh_equiv_2286 vpwr.n442 vpwr.n602 240
rmesh_equiv_2287 vpwr.n442 vpwr.n610 240
rmesh_equiv_2288 vpwr.n443 vpwr.n445 185
rmesh_equiv_2289 vpwr.n443 vpwr.n603 131.30199999999999
rmesh_equiv_229 pd.n2 pd.t2 700.48400000000004
rmesh_equiv_2290 vpwr.n443 vpwr.n609 131.30199999999999
rmesh_equiv_2291 vpwr.n444 vpwr.n446 185
rmesh_equiv_2292 vpwr.n444 vpwr.n609 216.26100000000002
rmesh_equiv_2293 vpwr.n444 vpwr.n611 185.00310000000002
rmesh_equiv_2294 vpwr.n445 vpwr.n604 240
rmesh_equiv_2295 vpwr.n445 vpwr.n606 185
rmesh_equiv_2296 vpwr.n445 vpwr.n608 240
rmesh_equiv_2297 vpwr.n446 vpwr.n608 776.471
rmesh_equiv_2298 vpwr.n447 vpwr.n448 185
rmesh_equiv_2299 vpwr.n447 vpwr.n594 25.6005
rmesh_equiv_23 oscillator__n0 oscillator__n0.n2 15.6333
rmesh_equiv_230 pd.n3 pd.n7 17.6721
rmesh_equiv_2300 vpwr.n447 vpwr.n605 25.6005
rmesh_equiv_2301 vpwr.n448 vpwr.n449 185
rmesh_equiv_2302 vpwr.n448 vpwr.n595 240
rmesh_equiv_2303 vpwr.n448 vpwr.n604 240
rmesh_equiv_2304 vpwr.n449 vpwr.n450 185
rmesh_equiv_2305 vpwr.n449 vpwr.n596 131.30199999999999
rmesh_equiv_2306 vpwr.n449 vpwr.n603 131.30199999999999
rmesh_equiv_2307 vpwr.n45 vpwr.n46 185
rmesh_equiv_2308 vpwr.n45 vpwr.n48 240.00290767186621
rmesh_equiv_2309 vpwr.n45 vpwr.n70 185.00310000000002
rmesh_equiv_231 pd.n4 pd.n6 10.151300000000001
rmesh_equiv_2310 vpwr.n450 vpwr.n597 240
rmesh_equiv_2311 vpwr.n450 vpwr.n599 185
rmesh_equiv_2312 vpwr.n450 vpwr.n602 240
rmesh_equiv_2313 vpwr.n451 vpwr.n452 185
rmesh_equiv_2314 vpwr.n451 vpwr.n588 25.6005
rmesh_equiv_2315 vpwr.n451 vpwr.n598 25.6005
rmesh_equiv_2316 vpwr.n452 vpwr.n453 185
rmesh_equiv_2317 vpwr.n452 vpwr.n589 240
rmesh_equiv_2318 vpwr.n452 vpwr.n597 240
rmesh_equiv_2319 vpwr.n453 vpwr.n454 185
rmesh_equiv_232 pd.n4 pd.t1 255.34500000000003
rmesh_equiv_2320 vpwr.n453 vpwr.n590 131.30199999999999
rmesh_equiv_2321 vpwr.n453 vpwr.n596 131.30199999999999
rmesh_equiv_2322 vpwr.n454 vpwr.n591 240
rmesh_equiv_2323 vpwr.n454 vpwr.n593 185
rmesh_equiv_2324 vpwr.n454 vpwr.n595 240
rmesh_equiv_2325 vpwr.n455 vpwr.n456 185
rmesh_equiv_2326 vpwr.n455 vpwr.n582 25.6005
rmesh_equiv_2327 vpwr.n455 vpwr.n592 25.6005
rmesh_equiv_2328 vpwr.n456 vpwr.n457 185
rmesh_equiv_2329 vpwr.n456 vpwr.n583 240
rmesh_equiv_233 pd.n5 pd.n6 10.151300000000001
rmesh_equiv_2330 vpwr.n456 vpwr.n591 240
rmesh_equiv_2331 vpwr.n457 vpwr.n458 185
rmesh_equiv_2332 vpwr.n457 vpwr.n584 131.30199999999999
rmesh_equiv_2333 vpwr.n457 vpwr.n590 131.30199999999999
rmesh_equiv_2334 vpwr.n458 vpwr.n585 240
rmesh_equiv_2335 vpwr.n458 vpwr.n587 185
rmesh_equiv_2336 vpwr.n458 vpwr.n589 240
rmesh_equiv_2337 vpwr.n459 vpwr.n460 185
rmesh_equiv_2338 vpwr.n459 vpwr.n576 25.6005
rmesh_equiv_2339 vpwr.n459 vpwr.n586 25.6005
rmesh_equiv_234 pd.n5 pd.t1 255.34500000000003
rmesh_equiv_2340 vpwr.n46 vpwr.n47 25.6005
rmesh_equiv_2341 vpwr.n460 vpwr.n461 185
rmesh_equiv_2342 vpwr.n460 vpwr.n577 240
rmesh_equiv_2343 vpwr.n460 vpwr.n585 240
rmesh_equiv_2344 vpwr.n461 vpwr.n462 185
rmesh_equiv_2345 vpwr.n461 vpwr.n578 131.30199999999999
rmesh_equiv_2346 vpwr.n461 vpwr.n584 131.30199999999999
rmesh_equiv_2347 vpwr.n462 vpwr.n579 240
rmesh_equiv_2348 vpwr.n462 vpwr.n581 185
rmesh_equiv_2349 vpwr.n462 vpwr.n583 240
rmesh_equiv_235 pd.n6 pd.n7 16.854900000000001
rmesh_equiv_2350 vpwr.n463 vpwr.n464 185
rmesh_equiv_2351 vpwr.n463 vpwr.n570 25.6005
rmesh_equiv_2352 vpwr.n463 vpwr.n580 25.6005
rmesh_equiv_2353 vpwr.n464 vpwr.n465 185
rmesh_equiv_2354 vpwr.n464 vpwr.n571 240
rmesh_equiv_2355 vpwr.n464 vpwr.n579 240
rmesh_equiv_2356 vpwr.n465 vpwr.n466 185
rmesh_equiv_2357 vpwr.n465 vpwr.n572 131.30199999999999
rmesh_equiv_2358 vpwr.n465 vpwr.n578 131.30199999999999
rmesh_equiv_2359 vpwr.n466 vpwr.n573 240
rmesh_equiv_236 pd.n7 pd.n8 0.81771300000000002
rmesh_equiv_2360 vpwr.n466 vpwr.n575 185
rmesh_equiv_2361 vpwr.n466 vpwr.n577 240
rmesh_equiv_2362 vpwr.n467 vpwr.n468 185
rmesh_equiv_2363 vpwr.n467 vpwr.n564 25.6005
rmesh_equiv_2364 vpwr.n467 vpwr.n574 25.6005
rmesh_equiv_2365 vpwr.n468 vpwr.n469 185
rmesh_equiv_2366 vpwr.n468 vpwr.n565 240
rmesh_equiv_2367 vpwr.n468 vpwr.n573 240
rmesh_equiv_2368 vpwr.n469 vpwr.n470 185
rmesh_equiv_2369 vpwr.n469 vpwr.n566 131.30199999999999
rmesh_equiv_237 pd.n8 pd.n9 16.854900000000001
rmesh_equiv_2370 vpwr.n469 vpwr.n572 131.30199999999999
rmesh_equiv_2371 vpwr.n47 vpwr.n48 185
rmesh_equiv_2372 vpwr.n47 vpwr.n50 25.6005
rmesh_equiv_2373 vpwr.n470 vpwr.n567 240
rmesh_equiv_2374 vpwr.n470 vpwr.n569 185
rmesh_equiv_2375 vpwr.n470 vpwr.n571 240
rmesh_equiv_2376 vpwr.n471 vpwr.n472 185
rmesh_equiv_2377 vpwr.n471 vpwr.n558 25.6005
rmesh_equiv_2378 vpwr.n471 vpwr.n568 25.6005
rmesh_equiv_2379 vpwr.n472 vpwr.n473 185
rmesh_equiv_238 pd.n8 pd.t3 25.8231
rmesh_equiv_2380 vpwr.n472 vpwr.n559 240
rmesh_equiv_2381 vpwr.n472 vpwr.n567 240
rmesh_equiv_2382 vpwr.n473 vpwr.n474 185
rmesh_equiv_2383 vpwr.n473 vpwr.n566 131.30199999999999
rmesh_equiv_2384 vpwr.n473 vpwr.t12 65.650899999999993
rmesh_equiv_2385 vpwr.n474 vpwr.n561 240
rmesh_equiv_2386 vpwr.n474 vpwr.n563 185
rmesh_equiv_2387 vpwr.n474 vpwr.n565 240
rmesh_equiv_2388 vpwr.n475 vpwr.n476 185
rmesh_equiv_2389 vpwr.n475 vpwr.n552 25.6005
rmesh_equiv_239 phase_detector__n1 phase_detector__n1.n0 12.8005
rmesh_equiv_2390 vpwr.n475 vpwr.n562 25.6005
rmesh_equiv_2391 vpwr.n476 vpwr.n477 185
rmesh_equiv_2392 vpwr.n476 vpwr.n553 240
rmesh_equiv_2393 vpwr.n476 vpwr.n561 240
rmesh_equiv_2394 vpwr.n477 vpwr.n478 185
rmesh_equiv_2395 vpwr.n477 vpwr.n554 131.30199999999999
rmesh_equiv_2396 vpwr.n477 vpwr.n560 131.30199999999999
rmesh_equiv_2397 vpwr.n478 vpwr.n555 240
rmesh_equiv_2398 vpwr.n478 vpwr.n557 185
rmesh_equiv_2399 vpwr.n478 vpwr.n559 240
rmesh_equiv_24 oscillator__n0 oscillator__n0.n6 23.111999999999998
rmesh_equiv_240 phase_detector__n1 phase_detector__n1.n1 18.299105920424445
rmesh_equiv_2400 vpwr.n479 vpwr.n480 185
rmesh_equiv_2401 vpwr.n479 vpwr.n546 25.6005
rmesh_equiv_2402 vpwr.n479 vpwr.n556 25.6005
rmesh_equiv_2403 vpwr.n48 vpwr.n49 240
rmesh_equiv_2404 vpwr.n48 vpwr.n70 185.00310000000002
rmesh_equiv_2405 vpwr.n480 vpwr.n481 185
rmesh_equiv_2406 vpwr.n480 vpwr.n547 240
rmesh_equiv_2407 vpwr.n480 vpwr.n555 240
rmesh_equiv_2408 vpwr.n481 vpwr.n482 185
rmesh_equiv_2409 vpwr.n481 vpwr.n548 131.30199999999999
rmesh_equiv_241 phase_detector__n1 phase_detector__n1.n13 12.8005
rmesh_equiv_2410 vpwr.n481 vpwr.n554 131.30199999999999
rmesh_equiv_2411 vpwr.n482 vpwr.n549 240
rmesh_equiv_2412 vpwr.n482 vpwr.n551 185
rmesh_equiv_2413 vpwr.n482 vpwr.n553 240
rmesh_equiv_2414 vpwr.n483 vpwr.n484 185
rmesh_equiv_2415 vpwr.n483 vpwr.n540 25.6005
rmesh_equiv_2416 vpwr.n483 vpwr.n550 25.6005
rmesh_equiv_2417 vpwr.n484 vpwr.n485 185
rmesh_equiv_2418 vpwr.n484 vpwr.n541 240
rmesh_equiv_2419 vpwr.n484 vpwr.n549 240
rmesh_equiv_242 phase_detector__n1 phase_detector__n1.n2 36.202100000000002
rmesh_equiv_2420 vpwr.n485 vpwr.n486 185
rmesh_equiv_2421 vpwr.n485 vpwr.n542 131.30199999999999
rmesh_equiv_2422 vpwr.n485 vpwr.n548 131.30199999999999
rmesh_equiv_2423 vpwr.n486 vpwr.n543 240
rmesh_equiv_2424 vpwr.n486 vpwr.n545 185
rmesh_equiv_2425 vpwr.n486 vpwr.n547 240
rmesh_equiv_2426 vpwr.n487 vpwr.n488 185
rmesh_equiv_2427 vpwr.n487 vpwr.n534 25.6005
rmesh_equiv_2428 vpwr.n487 vpwr.n544 25.6005
rmesh_equiv_2429 vpwr.n488 vpwr.n489 185
rmesh_equiv_243 phase_detector__n1 phase_detector__n1.n3 36.186500000000002
rmesh_equiv_2430 vpwr.n488 vpwr.n535 240
rmesh_equiv_2431 vpwr.n488 vpwr.n543 240
rmesh_equiv_2432 vpwr.n489 vpwr.n490 185
rmesh_equiv_2433 vpwr.n489 vpwr.n536 131.30199999999999
rmesh_equiv_2434 vpwr.n489 vpwr.n542 131.30199999999999
rmesh_equiv_2435 vpwr.n49 vpwr.n50 185
rmesh_equiv_2436 vpwr.n49 vpwr.n52 240.00290767186621
rmesh_equiv_2437 vpwr.n49 vpwr.n70 185.00310000000002
rmesh_equiv_2438 vpwr.n490 vpwr.n537 240
rmesh_equiv_2439 vpwr.n490 vpwr.n539 185
rmesh_equiv_244 phase_detector__n1 phase_detector__n1.n4 12.8005
rmesh_equiv_2440 vpwr.n490 vpwr.n541 240
rmesh_equiv_2441 vpwr.n491 vpwr.n492 185
rmesh_equiv_2442 vpwr.n491 vpwr.n528 25.6005
rmesh_equiv_2443 vpwr.n491 vpwr.n538 25.6005
rmesh_equiv_2444 vpwr.n492 vpwr.n493 185
rmesh_equiv_2445 vpwr.n492 vpwr.n529 240
rmesh_equiv_2446 vpwr.n492 vpwr.n537 240
rmesh_equiv_2447 vpwr.n493 vpwr.n494 185
rmesh_equiv_2448 vpwr.n493 vpwr.n530 131.30199999999999
rmesh_equiv_2449 vpwr.n493 vpwr.n536 131.30199999999999
rmesh_equiv_245 phase_detector__n1 phase_detector__n1.n5 12.8005
rmesh_equiv_2450 vpwr.n494 vpwr.n531 240
rmesh_equiv_2451 vpwr.n494 vpwr.n533 185
rmesh_equiv_2452 vpwr.n494 vpwr.n535 240
rmesh_equiv_2453 vpwr.n495 vpwr.n496 185
rmesh_equiv_2454 vpwr.n495 vpwr.n522 25.6005
rmesh_equiv_2455 vpwr.n495 vpwr.n532 25.6005
rmesh_equiv_2456 vpwr.n496 vpwr.n497 185
rmesh_equiv_2457 vpwr.n496 vpwr.n523 240
rmesh_equiv_2458 vpwr.n496 vpwr.n531 240
rmesh_equiv_2459 vpwr.n497 vpwr.n498 185
rmesh_equiv_246 phase_detector__n1 phase_detector__n1.n7 12.8005
rmesh_equiv_2460 vpwr.n497 vpwr.n524 131.30199999999999
rmesh_equiv_2461 vpwr.n497 vpwr.n530 131.30199999999999
rmesh_equiv_2462 vpwr.n498 vpwr.n525 240
rmesh_equiv_2463 vpwr.n498 vpwr.n527 185
rmesh_equiv_2464 vpwr.n498 vpwr.n529 240
rmesh_equiv_2465 vpwr.n499 vpwr.n500 185
rmesh_equiv_2466 vpwr.n499 vpwr.n516 25.6005
rmesh_equiv_2467 vpwr.n499 vpwr.n526 25.6005
rmesh_equiv_2468 vpwr.n5 vpwr.n69 185
rmesh_equiv_2469 vpwr.n5 vpwr.n72 787.05899999999997
rmesh_equiv_247 phase_detector__n1 phase_detector__n1.n8 12.8005
rmesh_equiv_2470 vpwr.n5 vpwr.n74 185
rmesh_equiv_2471 vpwr.n50 vpwr.n51 25.6005
rmesh_equiv_2472 vpwr.n500 vpwr.n501 185
rmesh_equiv_2473 vpwr.n500 vpwr.n517 240
rmesh_equiv_2474 vpwr.n500 vpwr.n525 240
rmesh_equiv_2475 vpwr.n501 vpwr.n502 185
rmesh_equiv_2476 vpwr.n501 vpwr.n518 131.30199999999999
rmesh_equiv_2477 vpwr.n501 vpwr.n524 131.30199999999999
rmesh_equiv_2478 vpwr.n502 vpwr.n519 240
rmesh_equiv_2479 vpwr.n502 vpwr.n521 185
rmesh_equiv_248 phase_detector__n1 phase_detector__n1.t3 330.34100000000001
rmesh_equiv_2480 vpwr.n502 vpwr.n523 240
rmesh_equiv_2481 vpwr.n503 vpwr.n504 185
rmesh_equiv_2482 vpwr.n503 vpwr.n509 82.823999999999998
rmesh_equiv_2483 vpwr.n503 vpwr.n520 25.6005
rmesh_equiv_2484 vpwr.n504 vpwr.n505 185
rmesh_equiv_2485 vpwr.n504 vpwr.n510 776.471
rmesh_equiv_2486 vpwr.n504 vpwr.n519 240
rmesh_equiv_2487 vpwr.n505 vpwr.n506 185
rmesh_equiv_2488 vpwr.n505 vpwr.n512 216.26100000000002
rmesh_equiv_2489 vpwr.n505 vpwr.n518 131.30199999999999
rmesh_equiv_249 phase_detector__n1 phase_detector__n1.t4 330.34100000000001
rmesh_equiv_2490 vpwr.n506 vpwr.n513 776.471
rmesh_equiv_2491 vpwr.n506 vpwr.n515 185
rmesh_equiv_2492 vpwr.n506 vpwr.n517 240
rmesh_equiv_2493 vpwr.n507 vpwr.n508 185
rmesh_equiv_2494 vpwr.n507 vpwr.n509 25.6005
rmesh_equiv_2495 vpwr.n507 vpwr.n514 25.6005
rmesh_equiv_2496 vpwr.n508 vpwr.n510 240.00290767186621
rmesh_equiv_2497 vpwr.n508 vpwr.n512 185.00310000000002
rmesh_equiv_2498 vpwr.n508 vpwr.n513 240
rmesh_equiv_2499 vpwr.n509 vpwr.n510 185
rmesh_equiv_25 oscillator__n0.n0 oscillator__n0.n4 0.555091
rmesh_equiv_250 phase_detector__n1 phase_detector__n1.t5 315.88
rmesh_equiv_2500 vpwr.n51 vpwr.n52 185
rmesh_equiv_2501 vpwr.n51 vpwr.n54 25.6005
rmesh_equiv_2502 vpwr.n510 vpwr.n512 185.00310000000002
rmesh_equiv_2503 vpwr.n512 vpwr.n513 185
rmesh_equiv_2504 vpwr.n513 vpwr.n514 185
rmesh_equiv_2505 vpwr.n514 vpwr.n515 82.823999999999998
rmesh_equiv_2506 vpwr.n515 vpwr.n516 25.6005
rmesh_equiv_2507 vpwr.n516 vpwr.n517 185
rmesh_equiv_2508 vpwr.n517 vpwr.n518 185
rmesh_equiv_2509 vpwr.n518 vpwr.n519 185
rmesh_equiv_251 phase_detector__n1 phase_detector__n1.t6 315.88
rmesh_equiv_2510 vpwr.n519 vpwr.n520 185
rmesh_equiv_2511 vpwr.n52 vpwr.n53 240
rmesh_equiv_2512 vpwr.n52 vpwr.n70 185.00310000000002
rmesh_equiv_2513 vpwr.n520 vpwr.n521 25.6005
rmesh_equiv_2514 vpwr.n521 vpwr.n522 25.6005
rmesh_equiv_2515 vpwr.n522 vpwr.n523 185
rmesh_equiv_2516 vpwr.n523 vpwr.n524 185
rmesh_equiv_2517 vpwr.n524 vpwr.n525 185
rmesh_equiv_2518 vpwr.n525 vpwr.n526 185
rmesh_equiv_2519 vpwr.n526 vpwr.n527 25.6005
rmesh_equiv_252 phase_detector__n1.n0 phase_detector__n1.n12 10.151300000000001
rmesh_equiv_2520 vpwr.n527 vpwr.n528 25.6005
rmesh_equiv_2521 vpwr.n528 vpwr.n529 185
rmesh_equiv_2522 vpwr.n529 vpwr.n530 185
rmesh_equiv_2523 vpwr.n53 vpwr.n54 185
rmesh_equiv_2524 vpwr.n53 vpwr.n56 240.00290767186621
rmesh_equiv_2525 vpwr.n53 vpwr.n70 185.00310000000002
rmesh_equiv_2526 vpwr.n530 vpwr.n531 185
rmesh_equiv_2527 vpwr.n531 vpwr.n532 185
rmesh_equiv_2528 vpwr.n532 vpwr.n533 25.6005
rmesh_equiv_2529 vpwr.n533 vpwr.n534 25.6005
rmesh_equiv_253 phase_detector__n1.n0 phase_detector__n1.t0 700.48400000000004
rmesh_equiv_2530 vpwr.n534 vpwr.n535 185
rmesh_equiv_2531 vpwr.n535 vpwr.n536 185
rmesh_equiv_2532 vpwr.n536 vpwr.n537 185
rmesh_equiv_2533 vpwr.n537 vpwr.n538 185
rmesh_equiv_2534 vpwr.n538 vpwr.n539 25.6005
rmesh_equiv_2535 vpwr.n539 vpwr.n540 25.6005
rmesh_equiv_2536 vpwr.n54 vpwr.n55 25.6005
rmesh_equiv_2537 vpwr.n540 vpwr.n541 185
rmesh_equiv_2538 vpwr.n541 vpwr.n542 185
rmesh_equiv_2539 vpwr.n542 vpwr.n543 185
rmesh_equiv_254 phase_detector__n1.n1 phase_detector__n1.n2 2.4756399999999998
rmesh_equiv_2540 vpwr.n543 vpwr.n544 185
rmesh_equiv_2541 vpwr.n544 vpwr.n545 25.6005
rmesh_equiv_2542 vpwr.n545 vpwr.n546 25.6005
rmesh_equiv_2543 vpwr.n546 vpwr.n547 185
rmesh_equiv_2544 vpwr.n547 vpwr.n548 185
rmesh_equiv_2545 vpwr.n548 vpwr.n549 185
rmesh_equiv_2546 vpwr.n549 vpwr.n550 185
rmesh_equiv_2547 vpwr.n55 vpwr.n56 185
rmesh_equiv_2548 vpwr.n55 vpwr.n58 25.6005
rmesh_equiv_2549 vpwr.n550 vpwr.n551 25.6005
rmesh_equiv_255 phase_detector__n1.n10 phase_detector__n1.n11 0.81771300000000002
rmesh_equiv_2550 vpwr.n551 vpwr.n552 25.6005
rmesh_equiv_2551 vpwr.n552 vpwr.n553 185
rmesh_equiv_2552 vpwr.n553 vpwr.n554 185
rmesh_equiv_2553 vpwr.n554 vpwr.n555 185
rmesh_equiv_2554 vpwr.n555 vpwr.n556 185
rmesh_equiv_2555 vpwr.n556 vpwr.n557 25.6005
rmesh_equiv_2556 vpwr.n557 vpwr.n558 25.6005
rmesh_equiv_2557 vpwr.n558 vpwr.n559 185
rmesh_equiv_2558 vpwr.n559 vpwr.n560 185
rmesh_equiv_2559 vpwr.n56 vpwr.n57 240
rmesh_equiv_256 phase_detector__n1.n10 phase_detector__n1.n6 17.6721
rmesh_equiv_2560 vpwr.n56 vpwr.n70 185.00310000000002
rmesh_equiv_2561 vpwr.n560 vpwr.n561 185
rmesh_equiv_2562 vpwr.n560 vpwr.t12 65.650899999999993
rmesh_equiv_2563 vpwr.n561 vpwr.n562 185
rmesh_equiv_2564 vpwr.n562 vpwr.n563 25.6005
rmesh_equiv_2565 vpwr.n563 vpwr.n564 25.6005
rmesh_equiv_2566 vpwr.n564 vpwr.n565 185
rmesh_equiv_2567 vpwr.n565 vpwr.n566 185
rmesh_equiv_2568 vpwr.n566 vpwr.n567 185
rmesh_equiv_2569 vpwr.n567 vpwr.n568 185
rmesh_equiv_257 phase_detector__n1.n10 phase_detector__n1.n9 16.854900000000001
rmesh_equiv_2570 vpwr.n568 vpwr.n569 25.6005
rmesh_equiv_2571 vpwr.n569 vpwr.n570 25.6005
rmesh_equiv_2572 vpwr.n57 vpwr.n58 185
rmesh_equiv_2573 vpwr.n57 vpwr.n60 240.00290767186621
rmesh_equiv_2574 vpwr.n57 vpwr.n70 185.00310000000002
rmesh_equiv_2575 vpwr.n570 vpwr.n571 185
rmesh_equiv_2576 vpwr.n571 vpwr.n572 185
rmesh_equiv_2577 vpwr.n572 vpwr.n573 185
rmesh_equiv_2578 vpwr.n573 vpwr.n574 185
rmesh_equiv_2579 vpwr.n574 vpwr.n575 25.6005
rmesh_equiv_258 phase_detector__n1.n11 phase_detector__n1.n12 16.854900000000001
rmesh_equiv_2580 vpwr.n575 vpwr.n576 25.6005
rmesh_equiv_2581 vpwr.n576 vpwr.n577 185
rmesh_equiv_2582 vpwr.n577 vpwr.n578 185
rmesh_equiv_2583 vpwr.n578 vpwr.n579 185
rmesh_equiv_2584 vpwr.n579 vpwr.n580 185
rmesh_equiv_2585 vpwr.n58 vpwr.n59 25.6005
rmesh_equiv_2586 vpwr.n580 vpwr.n581 25.6005
rmesh_equiv_2587 vpwr.n581 vpwr.n582 25.6005
rmesh_equiv_2588 vpwr.n582 vpwr.n583 185
rmesh_equiv_2589 vpwr.n583 vpwr.n584 185
rmesh_equiv_259 phase_detector__n1.n11 phase_detector__n1.n3 3.6594500000000001
rmesh_equiv_2590 vpwr.n584 vpwr.n585 185
rmesh_equiv_2591 vpwr.n585 vpwr.n586 185
rmesh_equiv_2592 vpwr.n586 vpwr.n587 25.6005
rmesh_equiv_2593 vpwr.n587 vpwr.n588 25.6005
rmesh_equiv_2594 vpwr.n588 vpwr.n589 185
rmesh_equiv_2595 vpwr.n589 vpwr.n590 185
rmesh_equiv_2596 vpwr.n59 vpwr.n60 185
rmesh_equiv_2597 vpwr.n59 vpwr.n62 25.6005
rmesh_equiv_2598 vpwr.n590 vpwr.n591 185
rmesh_equiv_2599 vpwr.n591 vpwr.n592 185
rmesh_equiv_26 oscillator__n0.n0 oscillator__n0.n5 39.311100000000003
rmesh_equiv_260 phase_detector__n1.n12 phase_detector__n1.n13 10.151300000000001
rmesh_equiv_2600 vpwr.n592 vpwr.n593 25.6005
rmesh_equiv_2601 vpwr.n593 vpwr.n594 25.6005
rmesh_equiv_2602 vpwr.n594 vpwr.n595 185
rmesh_equiv_2603 vpwr.n595 vpwr.n596 185
rmesh_equiv_2604 vpwr.n596 vpwr.n597 185
rmesh_equiv_2605 vpwr.n597 vpwr.n598 185
rmesh_equiv_2606 vpwr.n598 vpwr.n599 25.6005
rmesh_equiv_2607 vpwr.n599 vpwr.n601 25.6005
rmesh_equiv_2608 vpwr.n60 vpwr.n61 240
rmesh_equiv_2609 vpwr.n60 vpwr.n70 185.00310000000002
rmesh_equiv_261 phase_detector__n1.n13 phase_detector__n1.t0 700.48400000000004
rmesh_equiv_2610 vpwr.n600 vpwr.n601 25.6005
rmesh_equiv_2611 vpwr.n601 vpwr.n602 185
rmesh_equiv_2612 vpwr.n602 vpwr.n603 185
rmesh_equiv_2613 vpwr.n603 vpwr.n604 185
rmesh_equiv_2614 vpwr.n604 vpwr.n605 185
rmesh_equiv_2615 vpwr.n605 vpwr.n606 25.6005
rmesh_equiv_2616 vpwr.n606 vpwr.n607 25.6005
rmesh_equiv_2617 vpwr.n607 vpwr.n608 185
rmesh_equiv_2618 vpwr.n608 vpwr.n609 185
rmesh_equiv_2619 vpwr.n609 vpwr.n610 185
rmesh_equiv_262 phase_detector__n1.n2 phase_detector__n1.n3 0.81771300000000002
rmesh_equiv_2620 vpwr.n61 vpwr.n62 185
rmesh_equiv_2621 vpwr.n61 vpwr.n63 240.00290767186621
rmesh_equiv_2622 vpwr.n61 vpwr.n70 185.00310000000002
rmesh_equiv_2623 vpwr.n610 vpwr.n611 776.471
rmesh_equiv_2624 vpwr.n611 vpwr.n612 185
rmesh_equiv_2625 vpwr.n613 vpwr.n618 0.12975
rmesh_equiv_2626 vpwr.n614 vpwr.n615 40.104900000000001
rmesh_equiv_2627 vpwr.n614 vpwr.n617 0.72065299999999999
rmesh_equiv_2628 vpwr.n615 vpwr.n616 42.739100000000001
rmesh_equiv_2629 vpwr.n615 vpwr.t13 2.8570000000000002
rmesh_equiv_263 phase_detector__n1.n4 phase_detector__n1.n6 10.151300000000001
rmesh_equiv_2630 vpwr.n616 vpwr.n617 1.10033
rmesh_equiv_2631 vpwr.n617 vpwr.n618 18.497
rmesh_equiv_2632 vpwr.n618 vpwr.n794 1.58792
rmesh_equiv_2633 vpwr.n619 vpwr.n627 185
rmesh_equiv_2634 vpwr.n619 vpwr.n788 82.823999999999998
rmesh_equiv_2635 vpwr.n62 vpwr.n64 25.6005
rmesh_equiv_2636 vpwr.n620 vpwr.n625 185.00310000000002
rmesh_equiv_2637 vpwr.n620 vpwr.n627 240
rmesh_equiv_2638 vpwr.n620 vpwr.n792 240.00290767186621
rmesh_equiv_2639 vpwr.n621 vpwr.n781 25.6005
rmesh_equiv_264 phase_detector__n1.n4 phase_detector__n1.t1 700.48400000000004
rmesh_equiv_2640 vpwr.n621 vpwr.n791 185
rmesh_equiv_2641 vpwr.n621 vpwr.n793 82.823999999999998
rmesh_equiv_2642 vpwr.n623 vpwr.n624 185
rmesh_equiv_2643 vpwr.n623 vpwr.n781 185
rmesh_equiv_2644 vpwr.n623 vpwr.n783 240
rmesh_equiv_2645 vpwr.n623 vpwr.n791 240
rmesh_equiv_2646 vpwr.n624 vpwr.n626 185
rmesh_equiv_2647 vpwr.n624 vpwr.n784 131.30199999999999
rmesh_equiv_2648 vpwr.n624 vpwr.n790 131.30199999999999
rmesh_equiv_2649 vpwr.n625 vpwr.n627 185
rmesh_equiv_265 phase_detector__n1.n5 phase_detector__n1.n6 10.151300000000001
rmesh_equiv_2650 vpwr.n625 vpwr.n790 216.26100000000002
rmesh_equiv_2651 vpwr.n625 vpwr.n792 185.00310000000002
rmesh_equiv_2652 vpwr.n626 vpwr.n785 240
rmesh_equiv_2653 vpwr.n626 vpwr.n787 185
rmesh_equiv_2654 vpwr.n626 vpwr.n789 240
rmesh_equiv_2655 vpwr.n627 vpwr.n789 776.471
rmesh_equiv_2656 vpwr.n628 vpwr.n629 185
rmesh_equiv_2657 vpwr.n628 vpwr.n775 25.6005
rmesh_equiv_2658 vpwr.n628 vpwr.n786 25.6005
rmesh_equiv_2659 vpwr.n629 vpwr.n630 185
rmesh_equiv_266 phase_detector__n1.n5 phase_detector__n1.t1 700.48400000000004
rmesh_equiv_2660 vpwr.n629 vpwr.n776 240
rmesh_equiv_2661 vpwr.n629 vpwr.n785 240
rmesh_equiv_2662 vpwr.n63 vpwr.n64 185
rmesh_equiv_2663 vpwr.n63 vpwr.n70 185.00310000000002
rmesh_equiv_2664 vpwr.n630 vpwr.n631 185
rmesh_equiv_2665 vpwr.n630 vpwr.n777 131.30199999999999
rmesh_equiv_2666 vpwr.n630 vpwr.n784 131.30199999999999
rmesh_equiv_2667 vpwr.n631 vpwr.n778 240
rmesh_equiv_2668 vpwr.n631 vpwr.n780 185
rmesh_equiv_2669 vpwr.n631 vpwr.n783 240
rmesh_equiv_267 phase_detector__n1.n7 phase_detector__n1.n9 10.151300000000001
rmesh_equiv_2670 vpwr.n632 vpwr.n633 185
rmesh_equiv_2671 vpwr.n632 vpwr.n769 25.6005
rmesh_equiv_2672 vpwr.n632 vpwr.n779 25.6005
rmesh_equiv_2673 vpwr.n633 vpwr.n634 185
rmesh_equiv_2674 vpwr.n633 vpwr.n770 240
rmesh_equiv_2675 vpwr.n633 vpwr.n778 240
rmesh_equiv_2676 vpwr.n634 vpwr.n635 185
rmesh_equiv_2677 vpwr.n634 vpwr.n771 131.30199999999999
rmesh_equiv_2678 vpwr.n634 vpwr.n777 131.30199999999999
rmesh_equiv_2679 vpwr.n635 vpwr.n772 240
rmesh_equiv_268 phase_detector__n1.n7 phase_detector__n1.t2 255.34500000000003
rmesh_equiv_2680 vpwr.n635 vpwr.n774 185
rmesh_equiv_2681 vpwr.n635 vpwr.n776 240
rmesh_equiv_2682 vpwr.n636 vpwr.n637 185
rmesh_equiv_2683 vpwr.n636 vpwr.n763 25.6005
rmesh_equiv_2684 vpwr.n636 vpwr.n773 25.6005
rmesh_equiv_2685 vpwr.n637 vpwr.n638 185
rmesh_equiv_2686 vpwr.n637 vpwr.n764 240
rmesh_equiv_2687 vpwr.n637 vpwr.n772 240
rmesh_equiv_2688 vpwr.n638 vpwr.n639 185
rmesh_equiv_2689 vpwr.n638 vpwr.n765 131.30199999999999
rmesh_equiv_269 phase_detector__n1.n8 phase_detector__n1.n9 10.151300000000001
rmesh_equiv_2690 vpwr.n638 vpwr.n771 131.30199999999999
rmesh_equiv_2691 vpwr.n639 vpwr.n766 240
rmesh_equiv_2692 vpwr.n639 vpwr.n768 185
rmesh_equiv_2693 vpwr.n639 vpwr.n770 240
rmesh_equiv_2694 vpwr.n64 vpwr.n65 25.6005
rmesh_equiv_2695 vpwr.n640 vpwr.n641 185
rmesh_equiv_2696 vpwr.n640 vpwr.n757 25.6005
rmesh_equiv_2697 vpwr.n640 vpwr.n767 25.6005
rmesh_equiv_2698 vpwr.n641 vpwr.n642 185
rmesh_equiv_2699 vpwr.n641 vpwr.n758 240
rmesh_equiv_27 oscillator__n0.n1 oscillator__n0.n3 5.2415200000000004
rmesh_equiv_270 phase_detector__n1.n8 phase_detector__n1.t2 255.34500000000003
rmesh_equiv_2700 vpwr.n641 vpwr.n766 240
rmesh_equiv_2701 vpwr.n642 vpwr.n643 185
rmesh_equiv_2702 vpwr.n642 vpwr.n759 131.30199999999999
rmesh_equiv_2703 vpwr.n642 vpwr.n765 131.30199999999999
rmesh_equiv_2704 vpwr.n643 vpwr.n760 240
rmesh_equiv_2705 vpwr.n643 vpwr.n762 185
rmesh_equiv_2706 vpwr.n643 vpwr.n764 240
rmesh_equiv_2707 vpwr.n644 vpwr.n645 185
rmesh_equiv_2708 vpwr.n644 vpwr.n751 25.6005
rmesh_equiv_2709 vpwr.n644 vpwr.n761 25.6005
rmesh_equiv_271 phase_detector__n1__n1 phase_detector__n1__n1.n0 12.8005
rmesh_equiv_2710 vpwr.n645 vpwr.n646 185
rmesh_equiv_2711 vpwr.n645 vpwr.n752 240
rmesh_equiv_2712 vpwr.n645 vpwr.n760 240
rmesh_equiv_2713 vpwr.n646 vpwr.n647 185
rmesh_equiv_2714 vpwr.n646 vpwr.n753 131.30199999999999
rmesh_equiv_2715 vpwr.n646 vpwr.n759 131.30199999999999
rmesh_equiv_2716 vpwr.n647 vpwr.n754 240
rmesh_equiv_2717 vpwr.n647 vpwr.n756 185
rmesh_equiv_2718 vpwr.n647 vpwr.n758 240
rmesh_equiv_2719 vpwr.n648 vpwr.n649 185
rmesh_equiv_272 phase_detector__n1__n1 phase_detector__n1__n1.n1 12.8005
rmesh_equiv_2720 vpwr.n648 vpwr.n745 25.6005
rmesh_equiv_2721 vpwr.n648 vpwr.n755 25.6005
rmesh_equiv_2722 vpwr.n649 vpwr.n650 185
rmesh_equiv_2723 vpwr.n649 vpwr.n746 240
rmesh_equiv_2724 vpwr.n649 vpwr.n754 240
rmesh_equiv_2725 vpwr.n65 vpwr.n66 25.6005
rmesh_equiv_2726 vpwr.n650 vpwr.n651 185
rmesh_equiv_2727 vpwr.n650 vpwr.n747 131.30199999999999
rmesh_equiv_2728 vpwr.n650 vpwr.n753 131.30199999999999
rmesh_equiv_2729 vpwr.n651 vpwr.n748 240
rmesh_equiv_273 phase_detector__n1__n1 phase_detector__n1__n1.n2 12.8005
rmesh_equiv_2730 vpwr.n651 vpwr.n750 185
rmesh_equiv_2731 vpwr.n651 vpwr.n752 240
rmesh_equiv_2732 vpwr.n652 vpwr.n653 185
rmesh_equiv_2733 vpwr.n652 vpwr.n739 25.6005
rmesh_equiv_2734 vpwr.n652 vpwr.n749 25.6005
rmesh_equiv_2735 vpwr.n653 vpwr.n654 185
rmesh_equiv_2736 vpwr.n653 vpwr.n740 240
rmesh_equiv_2737 vpwr.n653 vpwr.n748 240
rmesh_equiv_2738 vpwr.n654 vpwr.n655 185
rmesh_equiv_2739 vpwr.n654 vpwr.n747 131.30199999999999
rmesh_equiv_274 phase_detector__n1__n1 phase_detector__n1__n1.n5 12.8005
rmesh_equiv_2740 vpwr.n654 vpwr.t10 65.650899999999993
rmesh_equiv_2741 vpwr.n655 vpwr.n742 240
rmesh_equiv_2742 vpwr.n655 vpwr.n744 185
rmesh_equiv_2743 vpwr.n655 vpwr.n746 240
rmesh_equiv_2744 vpwr.n656 vpwr.n657 185
rmesh_equiv_2745 vpwr.n656 vpwr.n733 25.6005
rmesh_equiv_2746 vpwr.n656 vpwr.n743 25.6005
rmesh_equiv_2747 vpwr.n657 vpwr.n658 185
rmesh_equiv_2748 vpwr.n657 vpwr.n734 240
rmesh_equiv_2749 vpwr.n657 vpwr.n742 240
rmesh_equiv_275 phase_detector__n1__n1.n0 phase_detector__n1__n1.n4 10.151300000000001
rmesh_equiv_2750 vpwr.n658 vpwr.n659 185
rmesh_equiv_2751 vpwr.n658 vpwr.n735 131.30199999999999
rmesh_equiv_2752 vpwr.n658 vpwr.n741 131.30199999999999
rmesh_equiv_2753 vpwr.n659 vpwr.n736 240
rmesh_equiv_2754 vpwr.n659 vpwr.n738 185
rmesh_equiv_2755 vpwr.n659 vpwr.n740 240
rmesh_equiv_2756 vpwr.n66 vpwr.n67 185
rmesh_equiv_2757 vpwr.n660 vpwr.n661 185
rmesh_equiv_2758 vpwr.n660 vpwr.n727 25.6005
rmesh_equiv_2759 vpwr.n660 vpwr.n737 25.6005
rmesh_equiv_276 phase_detector__n1__n1.n0 phase_detector__n1__n1.t0 255.34500000000003
rmesh_equiv_2760 vpwr.n661 vpwr.n662 185
rmesh_equiv_2761 vpwr.n661 vpwr.n728 240
rmesh_equiv_2762 vpwr.n661 vpwr.n736 240
rmesh_equiv_2763 vpwr.n662 vpwr.n663 185
rmesh_equiv_2764 vpwr.n662 vpwr.n729 131.30199999999999
rmesh_equiv_2765 vpwr.n662 vpwr.n735 131.30199999999999
rmesh_equiv_2766 vpwr.n663 vpwr.n730 240
rmesh_equiv_2767 vpwr.n663 vpwr.n732 185
rmesh_equiv_2768 vpwr.n663 vpwr.n734 240
rmesh_equiv_2769 vpwr.n664 vpwr.n665 185
rmesh_equiv_277 phase_detector__n1__n1.n1 phase_detector__n1__n1.n3 10.151300000000001
rmesh_equiv_2770 vpwr.n664 vpwr.n721 25.6005
rmesh_equiv_2771 vpwr.n664 vpwr.n731 25.6005
rmesh_equiv_2772 vpwr.n665 vpwr.n666 185
rmesh_equiv_2773 vpwr.n665 vpwr.n722 240
rmesh_equiv_2774 vpwr.n665 vpwr.n730 240
rmesh_equiv_2775 vpwr.n666 vpwr.n667 185
rmesh_equiv_2776 vpwr.n666 vpwr.n723 131.30199999999999
rmesh_equiv_2777 vpwr.n666 vpwr.n729 131.30199999999999
rmesh_equiv_2778 vpwr.n667 vpwr.n724 240
rmesh_equiv_2779 vpwr.n667 vpwr.n726 185
rmesh_equiv_278 phase_detector__n1__n1.n1 phase_detector__n1__n1.t1 255.34500000000003
rmesh_equiv_2780 vpwr.n667 vpwr.n728 240
rmesh_equiv_2781 vpwr.n668 vpwr.n669 185
rmesh_equiv_2782 vpwr.n668 vpwr.n715 25.6005
rmesh_equiv_2783 vpwr.n668 vpwr.n725 25.6005
rmesh_equiv_2784 vpwr.n669 vpwr.n670 185
rmesh_equiv_2785 vpwr.n669 vpwr.n716 240
rmesh_equiv_2786 vpwr.n669 vpwr.n724 240
rmesh_equiv_2787 vpwr.n67 vpwr.n70 185.00310000000002
rmesh_equiv_2788 vpwr.n670 vpwr.n671 185
rmesh_equiv_2789 vpwr.n670 vpwr.n717 131.30199999999999
rmesh_equiv_279 phase_detector__n1__n1.n2 phase_detector__n1__n1.n3 10.151300000000001
rmesh_equiv_2790 vpwr.n670 vpwr.n723 131.30199999999999
rmesh_equiv_2791 vpwr.n671 vpwr.n718 240
rmesh_equiv_2792 vpwr.n671 vpwr.n720 185
rmesh_equiv_2793 vpwr.n671 vpwr.n722 240
rmesh_equiv_2794 vpwr.n672 vpwr.n673 185
rmesh_equiv_2795 vpwr.n672 vpwr.n709 25.6005
rmesh_equiv_2796 vpwr.n672 vpwr.n719 25.6005
rmesh_equiv_2797 vpwr.n673 vpwr.n674 185
rmesh_equiv_2798 vpwr.n673 vpwr.n710 240
rmesh_equiv_2799 vpwr.n673 vpwr.n718 240
rmesh_equiv_28 oscillator__n0.n1 oscillator__n0.t1 174.857
rmesh_equiv_280 phase_detector__n1__n1.n2 phase_detector__n1__n1.t1 255.34500000000003
rmesh_equiv_2800 vpwr.n674 vpwr.n675 185
rmesh_equiv_2801 vpwr.n674 vpwr.n711 131.30199999999999
rmesh_equiv_2802 vpwr.n674 vpwr.n717 131.30199999999999
rmesh_equiv_2803 vpwr.n675 vpwr.n712 240
rmesh_equiv_2804 vpwr.n675 vpwr.n714 185
rmesh_equiv_2805 vpwr.n675 vpwr.n716 240
rmesh_equiv_2806 vpwr.n676 vpwr.n677 185
rmesh_equiv_2807 vpwr.n676 vpwr.n703 25.6005
rmesh_equiv_2808 vpwr.n676 vpwr.n713 25.6005
rmesh_equiv_2809 vpwr.n677 vpwr.n678 185
rmesh_equiv_281 phase_detector__n1__n1.n3 phase_detector__n1__n1.n4 35.906799999999997
rmesh_equiv_2810 vpwr.n677 vpwr.n704 240
rmesh_equiv_2811 vpwr.n677 vpwr.n712 240
rmesh_equiv_2812 vpwr.n678 vpwr.n679 185
rmesh_equiv_2813 vpwr.n678 vpwr.n705 131.30199999999999
rmesh_equiv_2814 vpwr.n678 vpwr.n711 131.30199999999999
rmesh_equiv_2815 vpwr.n679 vpwr.n706 240
rmesh_equiv_2816 vpwr.n679 vpwr.n708 185
rmesh_equiv_2817 vpwr.n679 vpwr.n710 240
rmesh_equiv_2818 vpwr.n680 vpwr.n681 185
rmesh_equiv_2819 vpwr.n680 vpwr.n697 25.6005
rmesh_equiv_282 phase_detector__n1__n1.n4 phase_detector__n1__n1.n5 10.151300000000001
rmesh_equiv_2820 vpwr.n680 vpwr.n707 25.6005
rmesh_equiv_2821 vpwr.n681 vpwr.n682 185
rmesh_equiv_2822 vpwr.n681 vpwr.n698 240
rmesh_equiv_2823 vpwr.n681 vpwr.n706 240
rmesh_equiv_2824 vpwr.n682 vpwr.n683 185
rmesh_equiv_2825 vpwr.n682 vpwr.n699 131.30199999999999
rmesh_equiv_2826 vpwr.n682 vpwr.n705 131.30199999999999
rmesh_equiv_2827 vpwr.n683 vpwr.n700 240
rmesh_equiv_2828 vpwr.n683 vpwr.n702 185
rmesh_equiv_2829 vpwr.n683 vpwr.n704 240
rmesh_equiv_283 phase_detector__n1__n1.n5 phase_detector__n1__n1.t0 255.34500000000003
rmesh_equiv_2830 vpwr.n684 vpwr.n685 185
rmesh_equiv_2831 vpwr.n684 vpwr.n690 82.823999999999998
rmesh_equiv_2832 vpwr.n684 vpwr.n701 25.6005
rmesh_equiv_2833 vpwr.n685 vpwr.n686 185
rmesh_equiv_2834 vpwr.n685 vpwr.n691 776.471
rmesh_equiv_2835 vpwr.n685 vpwr.n700 240
rmesh_equiv_2836 vpwr.n686 vpwr.n687 185
rmesh_equiv_2837 vpwr.n686 vpwr.n693 216.26100000000002
rmesh_equiv_2838 vpwr.n686 vpwr.n699 131.30199999999999
rmesh_equiv_2839 vpwr.n687 vpwr.n694 776.471
rmesh_equiv_284 phase_detector__n2 phase_detector__n2.n0 12.8005
rmesh_equiv_2840 vpwr.n687 vpwr.n696 185
rmesh_equiv_2841 vpwr.n687 vpwr.n698 240
rmesh_equiv_2842 vpwr.n688 vpwr.n689 185
rmesh_equiv_2843 vpwr.n688 vpwr.n690 25.6005
rmesh_equiv_2844 vpwr.n688 vpwr.n695 25.6005
rmesh_equiv_2845 vpwr.n689 vpwr.n691 240.00290767186621
rmesh_equiv_2846 vpwr.n689 vpwr.n693 185.00310000000002
rmesh_equiv_2847 vpwr.n689 vpwr.n694 240
rmesh_equiv_2848 vpwr.n69 vpwr.n70 57.802300000000002
rmesh_equiv_2849 vpwr.n69 vpwr.t14 15.849399999999999
rmesh_equiv_285 phase_detector__n2 phase_detector__n2.n1 18.50745814649537
rmesh_equiv_2850 vpwr.n690 vpwr.n691 185
rmesh_equiv_2851 vpwr.n691 vpwr.n693 185.00310000000002
rmesh_equiv_2852 vpwr.n693 vpwr.n694 185
rmesh_equiv_2853 vpwr.n694 vpwr.n695 185
rmesh_equiv_2854 vpwr.n695 vpwr.n696 82.823999999999998
rmesh_equiv_2855 vpwr.n696 vpwr.n697 25.6005
rmesh_equiv_2856 vpwr.n697 vpwr.n698 185
rmesh_equiv_2857 vpwr.n698 vpwr.n699 185
rmesh_equiv_2858 vpwr.n699 vpwr.n700 185
rmesh_equiv_2859 vpwr.n7 vpwr.n73 25.6005
rmesh_equiv_286 phase_detector__n2 phase_detector__n2.n11 12.8005
rmesh_equiv_2860 vpwr.n7 vpwr.n8 185
rmesh_equiv_2861 vpwr.n70 vpwr.n72 185.00310000000002
rmesh_equiv_2862 vpwr.n70 vpwr.n8 185.00310000000002
rmesh_equiv_2863 vpwr.n700 vpwr.n701 185
rmesh_equiv_2864 vpwr.n701 vpwr.n702 25.6005
rmesh_equiv_2865 vpwr.n702 vpwr.n703 25.6005
rmesh_equiv_2866 vpwr.n703 vpwr.n704 185
rmesh_equiv_2867 vpwr.n704 vpwr.n705 185
rmesh_equiv_2868 vpwr.n705 vpwr.n706 185
rmesh_equiv_2869 vpwr.n706 vpwr.n707 185
rmesh_equiv_287 phase_detector__n2 phase_detector__n2.n2 12.8005
rmesh_equiv_2870 vpwr.n707 vpwr.n708 25.6005
rmesh_equiv_2871 vpwr.n708 vpwr.n709 25.6005
rmesh_equiv_2872 vpwr.n709 vpwr.n710 185
rmesh_equiv_2873 vpwr.n710 vpwr.n711 185
rmesh_equiv_2874 vpwr.n711 vpwr.n712 185
rmesh_equiv_2875 vpwr.n712 vpwr.n713 185
rmesh_equiv_2876 vpwr.n713 vpwr.n714 25.6005
rmesh_equiv_2877 vpwr.n714 vpwr.n715 25.6005
rmesh_equiv_2878 vpwr.n715 vpwr.n716 185
rmesh_equiv_2879 vpwr.n716 vpwr.n717 185
rmesh_equiv_288 phase_detector__n2 phase_detector__n2.n3 12.8005
rmesh_equiv_2880 vpwr.n717 vpwr.n718 185
rmesh_equiv_2881 vpwr.n718 vpwr.n719 185
rmesh_equiv_2882 vpwr.n719 vpwr.n720 25.6005
rmesh_equiv_2883 vpwr.n72 vpwr.n73 185
rmesh_equiv_2884 vpwr.n72 vpwr.n8 240.00290767186621
rmesh_equiv_2885 vpwr.n720 vpwr.n721 25.6005
rmesh_equiv_2886 vpwr.n721 vpwr.n722 185
rmesh_equiv_2887 vpwr.n722 vpwr.n723 185
rmesh_equiv_2888 vpwr.n723 vpwr.n724 185
rmesh_equiv_2889 vpwr.n724 vpwr.n725 185
rmesh_equiv_289 phase_detector__n2 phase_detector__n2.n5 12.8005
rmesh_equiv_2890 vpwr.n725 vpwr.n726 25.6005
rmesh_equiv_2891 vpwr.n726 vpwr.n727 25.6005
rmesh_equiv_2892 vpwr.n727 vpwr.n728 185
rmesh_equiv_2893 vpwr.n728 vpwr.n729 185
rmesh_equiv_2894 vpwr.n729 vpwr.n730 185
rmesh_equiv_2895 vpwr.n73 vpwr.n74 83.953400000000002
rmesh_equiv_2896 vpwr.n730 vpwr.n731 185
rmesh_equiv_2897 vpwr.n731 vpwr.n732 25.6005
rmesh_equiv_2898 vpwr.n732 vpwr.n733 25.6005
rmesh_equiv_2899 vpwr.n733 vpwr.n734 185
rmesh_equiv_29 oscillator__n0.n2 oscillator__n0.n3 5.2415200000000004
rmesh_equiv_290 phase_detector__n2 phase_detector__n2.n6 12.8005
rmesh_equiv_2900 vpwr.n734 vpwr.n735 185
rmesh_equiv_2901 vpwr.n735 vpwr.n736 185
rmesh_equiv_2902 vpwr.n736 vpwr.n737 185
rmesh_equiv_2903 vpwr.n737 vpwr.n738 25.6005
rmesh_equiv_2904 vpwr.n738 vpwr.n739 25.6005
rmesh_equiv_2905 vpwr.n739 vpwr.n740 185
rmesh_equiv_2906 vpwr.n740 vpwr.n741 185
rmesh_equiv_2907 vpwr.n741 vpwr.n742 185
rmesh_equiv_2908 vpwr.n741 vpwr.t10 65.650899999999993
rmesh_equiv_2909 vpwr.n742 vpwr.n743 185
rmesh_equiv_291 phase_detector__n2 phase_detector__n2.t3 330.34100000000001
rmesh_equiv_2910 vpwr.n743 vpwr.n744 25.6005
rmesh_equiv_2911 vpwr.n744 vpwr.n745 25.6005
rmesh_equiv_2912 vpwr.n745 vpwr.n746 185
rmesh_equiv_2913 vpwr.n746 vpwr.n747 185
rmesh_equiv_2914 vpwr.n747 vpwr.n748 185
rmesh_equiv_2915 vpwr.n748 vpwr.n749 185
rmesh_equiv_2916 vpwr.n749 vpwr.n750 25.6005
rmesh_equiv_2917 vpwr.n750 vpwr.n751 25.6005
rmesh_equiv_2918 vpwr.n751 vpwr.n752 185
rmesh_equiv_2919 vpwr.n752 vpwr.n753 185
rmesh_equiv_292 phase_detector__n2 phase_detector__n2.t4 315.88
rmesh_equiv_2920 vpwr.n753 vpwr.n754 185
rmesh_equiv_2921 vpwr.n754 vpwr.n755 185
rmesh_equiv_2922 vpwr.n755 vpwr.n756 25.6005
rmesh_equiv_2923 vpwr.n756 vpwr.n757 25.6005
rmesh_equiv_2924 vpwr.n757 vpwr.n758 185
rmesh_equiv_2925 vpwr.n758 vpwr.n759 185
rmesh_equiv_2926 vpwr.n759 vpwr.n760 185
rmesh_equiv_2927 vpwr.n760 vpwr.n761 185
rmesh_equiv_2928 vpwr.n761 vpwr.n762 25.6005
rmesh_equiv_2929 vpwr.n762 vpwr.n763 25.6005
rmesh_equiv_293 phase_detector__n2.n0 phase_detector__n2.n10 10.151300000000001
rmesh_equiv_2930 vpwr.n763 vpwr.n764 185
rmesh_equiv_2931 vpwr.n764 vpwr.n765 185
rmesh_equiv_2932 vpwr.n765 vpwr.n766 185
rmesh_equiv_2933 vpwr.n766 vpwr.n767 185
rmesh_equiv_2934 vpwr.n767 vpwr.n768 25.6005
rmesh_equiv_2935 vpwr.n768 vpwr.n769 25.6005
rmesh_equiv_2936 vpwr.n769 vpwr.n770 185
rmesh_equiv_2937 vpwr.n770 vpwr.n771 185
rmesh_equiv_2938 vpwr.n771 vpwr.n772 185
rmesh_equiv_2939 vpwr.n772 vpwr.n773 185
rmesh_equiv_294 phase_detector__n2.n0 phase_detector__n2.t0 700.48400000000004
rmesh_equiv_2940 vpwr.n773 vpwr.n774 25.6005
rmesh_equiv_2941 vpwr.n774 vpwr.n775 25.6005
rmesh_equiv_2942 vpwr.n775 vpwr.n776 185
rmesh_equiv_2943 vpwr.n776 vpwr.n777 185
rmesh_equiv_2944 vpwr.n777 vpwr.n778 185
rmesh_equiv_2945 vpwr.n778 vpwr.n779 185
rmesh_equiv_2946 vpwr.n779 vpwr.n780 25.6005
rmesh_equiv_2947 vpwr.n780 vpwr.n782 25.6005
rmesh_equiv_2948 vpwr.n781 vpwr.n782 25.6005
rmesh_equiv_2949 vpwr.n782 vpwr.n783 185
rmesh_equiv_295 phase_detector__n2.n1 phase_detector__n2.n9 5.3173700000000004
rmesh_equiv_2950 vpwr.n783 vpwr.n784 185
rmesh_equiv_2951 vpwr.n784 vpwr.n785 185
rmesh_equiv_2952 vpwr.n785 vpwr.n786 185
rmesh_equiv_2953 vpwr.n786 vpwr.n787 25.6005
rmesh_equiv_2954 vpwr.n787 vpwr.n788 25.6005
rmesh_equiv_2955 vpwr.n788 vpwr.n789 185
rmesh_equiv_2956 vpwr.n789 vpwr.n790 185
rmesh_equiv_2957 vpwr.n790 vpwr.n791 185
rmesh_equiv_2958 vpwr.n791 vpwr.n792 776.471
rmesh_equiv_2959 vpwr.n792 vpwr.n793 185
rmesh_equiv_296 phase_detector__n2.n10 phase_detector__n2.n11 10.151300000000001
rmesh_equiv_2960 vpwr.n794 vpwr.n799 0.12975
rmesh_equiv_2961 vpwr.n795 vpwr.n796 40.104900000000001
rmesh_equiv_2962 vpwr.n795 vpwr.n798 0.72065299999999999
rmesh_equiv_2963 vpwr.n796 vpwr.n797 42.739100000000001
rmesh_equiv_2964 vpwr.n796 vpwr.t11 2.8570000000000002
rmesh_equiv_2965 vpwr.n797 vpwr.n798 1.10033
rmesh_equiv_2966 vpwr.n798 vpwr.n799 18.497
rmesh_equiv_2967 vpwr.n799 vpwr.n941 0.70373699999999995
rmesh_equiv_2968 vpwr.n800 vpwr.n802 185
rmesh_equiv_2969 vpwr.n800 vpwr.n866 83.953400000000002
rmesh_equiv_297 phase_detector__n2.n10 phase_detector__n2.n9 17.2715
rmesh_equiv_2970 vpwr.n801 vpwr.n803 185
rmesh_equiv_2971 vpwr.n801 vpwr.n889 25.6005
rmesh_equiv_2972 vpwr.n801 vpwr.n940 83.953400000000002
rmesh_equiv_2973 vpwr.n802 vpwr.n867 787.05899999999997
rmesh_equiv_2974 vpwr.n802 vpwr.n869 185
rmesh_equiv_2975 vpwr.n802 vpwr.n939 240
rmesh_equiv_2976 vpwr.n803 vpwr.n804 185
rmesh_equiv_2977 vpwr.n803 vpwr.n888 240
rmesh_equiv_2978 vpwr.n803 vpwr.n939 787.05899999999997
rmesh_equiv_2979 vpwr.n804 vpwr.n806 185.00310000000002
rmesh_equiv_298 phase_detector__n2.n11 phase_detector__n2.t0 700.48400000000004
rmesh_equiv_2980 vpwr.n804 vpwr.n878 185.00310000000002
rmesh_equiv_2981 vpwr.n804 vpwr.n880 185.00310000000002
rmesh_equiv_2982 vpwr.n804 vpwr.n882 185.00310000000002
rmesh_equiv_2983 vpwr.n804 vpwr.n884 185.00310000000002
rmesh_equiv_2984 vpwr.n804 vpwr.n886 185.00310000000002
rmesh_equiv_2985 vpwr.n804 vpwr.n888 185.00310000000002
rmesh_equiv_2986 vpwr.n804 vpwr.n892 185.00310000000002
rmesh_equiv_2987 vpwr.n804 vpwr.n894 185.00310000000002
rmesh_equiv_2988 vpwr.n804 vpwr.n896 185.00310000000002
rmesh_equiv_2989 vpwr.n804 vpwr.n900 185.00310000000002
rmesh_equiv_299 phase_detector__n2.n2 phase_detector__n2.n4 10.151300000000001
rmesh_equiv_2990 vpwr.n804 vpwr.n902 185.00310000000002
rmesh_equiv_2991 vpwr.n804 vpwr.n904 185.00310000000002
rmesh_equiv_2992 vpwr.n804 vpwr.n908 185.00310000000002
rmesh_equiv_2993 vpwr.n804 vpwr.n910 185.00310000000002
rmesh_equiv_2994 vpwr.n804 vpwr.n912 185.00310000000002
rmesh_equiv_2995 vpwr.n804 vpwr.n916 185.00310000000002
rmesh_equiv_2996 vpwr.n804 vpwr.n918 185.00310000000002
rmesh_equiv_2997 vpwr.n804 vpwr.n920 185.00310000000002
rmesh_equiv_2998 vpwr.n804 vpwr.n924 185.00310000000002
rmesh_equiv_2999 vpwr.n804 vpwr.n926 185.00310000000002
rmesh_equiv_3 ctrl ctrl.n3 4.1357100000000004
rmesh_equiv_30 oscillator__n0.n2 oscillator__n0.t1 174.857
rmesh_equiv_300 phase_detector__n2.n2 phase_detector__n2.t1 700.48400000000004
rmesh_equiv_3000 vpwr.n804 vpwr.n927 185.00310000000002
rmesh_equiv_3001 vpwr.n804 vpwr.n930 185.00310000000002
rmesh_equiv_3002 vpwr.n804 vpwr.n931 185
rmesh_equiv_3003 vpwr.n804 vpwr.n933 185.00310000000002
rmesh_equiv_3004 vpwr.n804 vpwr.n938 57.802300000000002
rmesh_equiv_3005 vpwr.n805 vpwr.n869 185
rmesh_equiv_3006 vpwr.n805 vpwr.n872 787.05899999999997
rmesh_equiv_3007 vpwr.n805 vpwr.n874 185
rmesh_equiv_3008 vpwr.n805 vpwr.n937 240
rmesh_equiv_3009 vpwr.n806 vpwr.n933 240.00290767186621
rmesh_equiv_301 phase_detector__n2.n3 phase_detector__n2.n4 10.151300000000001
rmesh_equiv_3010 vpwr.n806 vpwr.n935 185
rmesh_equiv_3011 vpwr.n806 vpwr.n937 787.05899999999997
rmesh_equiv_3012 vpwr.n807 vpwr.n808 185
rmesh_equiv_3013 vpwr.n807 vpwr.n822 25.6005
rmesh_equiv_3014 vpwr.n807 vpwr.n873 25.6005
rmesh_equiv_3015 vpwr.n808 vpwr.n821 240
rmesh_equiv_3016 vpwr.n808 vpwr.n870 185.00310000000002
rmesh_equiv_3017 vpwr.n808 vpwr.n872 240.00290767186621
rmesh_equiv_3018 vpwr.n820 vpwr.n863 240
rmesh_equiv_3019 vpwr.n820 vpwr.n865 185
rmesh_equiv_302 phase_detector__n2.n3 phase_detector__n2.t1 700.48400000000004
rmesh_equiv_3020 vpwr.n820 vpwr.n867 240.00290767186621
rmesh_equiv_3021 vpwr.n820 vpwr.n870 185.00310000000002
rmesh_equiv_3022 vpwr.n821 vpwr.n822 185
rmesh_equiv_3023 vpwr.n821 vpwr.n824 240.00290767186621
rmesh_equiv_3024 vpwr.n821 vpwr.n870 185.00310000000002
rmesh_equiv_3025 vpwr.n822 vpwr.n823 25.6005
rmesh_equiv_3026 vpwr.n823 vpwr.n824 185
rmesh_equiv_3027 vpwr.n823 vpwr.n826 25.6005
rmesh_equiv_3028 vpwr.n824 vpwr.n825 240
rmesh_equiv_3029 vpwr.n824 vpwr.n870 185.00310000000002
rmesh_equiv_303 phase_detector__n2.n4 phase_detector__n2.n8 18.088799999999999
rmesh_equiv_3030 vpwr.n825 vpwr.n826 185
rmesh_equiv_3031 vpwr.n825 vpwr.n828 240.00290767186621
rmesh_equiv_3032 vpwr.n825 vpwr.n870 185.00310000000002
rmesh_equiv_3033 vpwr.n826 vpwr.n827 25.6005
rmesh_equiv_3034 vpwr.n827 vpwr.n828 185
rmesh_equiv_3035 vpwr.n827 vpwr.n830 25.6005
rmesh_equiv_3036 vpwr.n828 vpwr.n829 240
rmesh_equiv_3037 vpwr.n828 vpwr.n870 185.00310000000002
rmesh_equiv_3038 vpwr.n829 vpwr.n830 185
rmesh_equiv_3039 vpwr.n829 vpwr.n832 240.00290767186621
rmesh_equiv_304 phase_detector__n2.n5 phase_detector__n2.n7 10.151300000000001
rmesh_equiv_3040 vpwr.n829 vpwr.n870 185.00310000000002
rmesh_equiv_3041 vpwr.n83 vpwr.n99 25.6005
rmesh_equiv_3042 vpwr.n830 vpwr.n831 25.6005
rmesh_equiv_3043 vpwr.n831 vpwr.n832 185
rmesh_equiv_3044 vpwr.n831 vpwr.n834 25.6005
rmesh_equiv_3045 vpwr.n832 vpwr.n833 240
rmesh_equiv_3046 vpwr.n832 vpwr.n870 185.00310000000002
rmesh_equiv_3047 vpwr.n833 vpwr.n834 185
rmesh_equiv_3048 vpwr.n833 vpwr.n836 240.00290767186621
rmesh_equiv_3049 vpwr.n833 vpwr.n870 185.00310000000002
rmesh_equiv_305 phase_detector__n2.n5 phase_detector__n2.t2 255.34500000000003
rmesh_equiv_3050 vpwr.n834 vpwr.n835 25.6005
rmesh_equiv_3051 vpwr.n835 vpwr.n836 185
rmesh_equiv_3052 vpwr.n835 vpwr.n838 25.6005
rmesh_equiv_3053 vpwr.n836 vpwr.n837 240
rmesh_equiv_3054 vpwr.n836 vpwr.n870 185.00310000000002
rmesh_equiv_3055 vpwr.n837 vpwr.n838 185
rmesh_equiv_3056 vpwr.n837 vpwr.n840 240.00290767186621
rmesh_equiv_3057 vpwr.n837 vpwr.n870 185.00310000000002
rmesh_equiv_3058 vpwr.n838 vpwr.n839 25.6005
rmesh_equiv_3059 vpwr.n839 vpwr.n840 185
rmesh_equiv_306 phase_detector__n2.n6 phase_detector__n2.n7 10.151300000000001
rmesh_equiv_3060 vpwr.n839 vpwr.n842 25.6005
rmesh_equiv_3061 vpwr.n84 vpwr.n96 240.00290767186621
rmesh_equiv_3062 vpwr.n84 vpwr.n98 185
rmesh_equiv_3063 vpwr.n840 vpwr.n841 240
rmesh_equiv_3064 vpwr.n840 vpwr.n870 185.00310000000002
rmesh_equiv_3065 vpwr.n841 vpwr.n842 185
rmesh_equiv_3066 vpwr.n841 vpwr.n844 240.00290767186621
rmesh_equiv_3067 vpwr.n841 vpwr.n870 185.00310000000002
rmesh_equiv_3068 vpwr.n842 vpwr.n843 25.6005
rmesh_equiv_3069 vpwr.n843 vpwr.n844 185
rmesh_equiv_307 phase_detector__n2.n6 phase_detector__n2.t2 255.34500000000003
rmesh_equiv_3070 vpwr.n843 vpwr.n846 25.6005
rmesh_equiv_3071 vpwr.n844 vpwr.n845 240
rmesh_equiv_3072 vpwr.n844 vpwr.n870 185.00310000000002
rmesh_equiv_3073 vpwr.n845 vpwr.n846 185
rmesh_equiv_3074 vpwr.n845 vpwr.n848 240.00290767186621
rmesh_equiv_3075 vpwr.n845 vpwr.n870 185.00310000000002
rmesh_equiv_3076 vpwr.n846 vpwr.n847 25.6005
rmesh_equiv_3077 vpwr.n847 vpwr.n848 185
rmesh_equiv_3078 vpwr.n847 vpwr.n850 25.6005
rmesh_equiv_3079 vpwr.n848 vpwr.n849 240
rmesh_equiv_308 phase_detector__n2.n7 phase_detector__n2.n8 17.2715
rmesh_equiv_3080 vpwr.n848 vpwr.n870 185.00310000000002
rmesh_equiv_3081 vpwr.n849 vpwr.n850 185
rmesh_equiv_3082 vpwr.n849 vpwr.n852 240.00290767186621
rmesh_equiv_3083 vpwr.n849 vpwr.n870 185.00310000000002
rmesh_equiv_3084 vpwr.n85 vpwr.n91 25.6005
rmesh_equiv_3085 vpwr.n85 vpwr.n94 185
rmesh_equiv_3086 vpwr.n85 vpwr.n97 25.6005
rmesh_equiv_3087 vpwr.n850 vpwr.n851 25.6005
rmesh_equiv_3088 vpwr.n851 vpwr.n852 185
rmesh_equiv_3089 vpwr.n851 vpwr.n854 25.6005
rmesh_equiv_309 phase_detector__n2.n8 phase_detector__n2.n9 0.81771300000000002
rmesh_equiv_3090 vpwr.n852 vpwr.n853 240
rmesh_equiv_3091 vpwr.n852 vpwr.n870 185.00310000000002
rmesh_equiv_3092 vpwr.n853 vpwr.n854 185
rmesh_equiv_3093 vpwr.n853 vpwr.n856 240.00290767186621
rmesh_equiv_3094 vpwr.n853 vpwr.n870 185.00310000000002
rmesh_equiv_3095 vpwr.n854 vpwr.n855 25.6005
rmesh_equiv_3096 vpwr.n855 vpwr.n856 185
rmesh_equiv_3097 vpwr.n855 vpwr.n858 25.6005
rmesh_equiv_3098 vpwr.n856 vpwr.n857 240
rmesh_equiv_3099 vpwr.n856 vpwr.n870 185.00310000000002
rmesh_equiv_31 oscillator__n0.n3 oscillator__n0.n4 34.129899999999999
rmesh_equiv_310 phase_detector__n2__n1 phase_detector__n2__n1.n0 12.8005
rmesh_equiv_3100 vpwr.n857 vpwr.n858 185
rmesh_equiv_3101 vpwr.n857 vpwr.n860 240.00290767186621
rmesh_equiv_3102 vpwr.n857 vpwr.n870 185.00310000000002
rmesh_equiv_3103 vpwr.n858 vpwr.n859 25.6005
rmesh_equiv_3104 vpwr.n859 vpwr.n860 185
rmesh_equiv_3105 vpwr.n859 vpwr.n862 25.6005
rmesh_equiv_3106 vpwr.n86 vpwr.n88 240.00290767186621
rmesh_equiv_3107 vpwr.n86 vpwr.n90 185
rmesh_equiv_3108 vpwr.n86 vpwr.n92 240
rmesh_equiv_3109 vpwr.n860 vpwr.n861 240
rmesh_equiv_311 phase_detector__n2__n1 phase_detector__n2__n1.n1 12.8005
rmesh_equiv_3110 vpwr.n860 vpwr.n870 185.00310000000002
rmesh_equiv_3111 vpwr.n861 vpwr.n862 185
rmesh_equiv_3112 vpwr.n861 vpwr.n863 240.00290767186621
rmesh_equiv_3113 vpwr.n861 vpwr.n870 185.00310000000002
rmesh_equiv_3114 vpwr.n862 vpwr.n864 25.6005
rmesh_equiv_3115 vpwr.n863 vpwr.n864 185
rmesh_equiv_3116 vpwr.n863 vpwr.n870 185.00310000000002
rmesh_equiv_3117 vpwr.n864 vpwr.n865 25.6005
rmesh_equiv_3118 vpwr.n865 vpwr.n866 25.6005
rmesh_equiv_3119 vpwr.n866 vpwr.n867 185
rmesh_equiv_312 phase_detector__n2__n1 phase_detector__n2__n1.n2 12.8005
rmesh_equiv_3120 vpwr.n867 vpwr.n870 185.00310000000002
rmesh_equiv_3121 vpwr.n869 vpwr.n870 57.802300000000002
rmesh_equiv_3122 vpwr.n869 vpwr.t15 15.849399999999999
rmesh_equiv_3123 vpwr.n870 vpwr.n872 185.00310000000002
rmesh_equiv_3124 vpwr.n872 vpwr.n873 185
rmesh_equiv_3125 vpwr.n873 vpwr.n874 83.953400000000002
rmesh_equiv_3126 vpwr.n874 vpwr.n936 25.6005
rmesh_equiv_3127 vpwr.n875 vpwr.n929 25.6005
rmesh_equiv_3128 vpwr.n875 vpwr.n931 185
rmesh_equiv_3129 vpwr.n875 vpwr.n934 25.6005
rmesh_equiv_313 phase_detector__n2__n1 phase_detector__n2__n1.n5 12.8005
rmesh_equiv_3130 vpwr.n877 vpwr.n923 25.6005
rmesh_equiv_3131 vpwr.n877 vpwr.n926 185
rmesh_equiv_3132 vpwr.n877 vpwr.n928 25.6005
rmesh_equiv_3133 vpwr.n878 vpwr.n920 240.00290767186621
rmesh_equiv_3134 vpwr.n878 vpwr.n922 185
rmesh_equiv_3135 vpwr.n878 vpwr.n924 240
rmesh_equiv_3136 vpwr.n879 vpwr.n915 25.6005
rmesh_equiv_3137 vpwr.n879 vpwr.n918 185
rmesh_equiv_3138 vpwr.n879 vpwr.n921 25.6005
rmesh_equiv_3139 vpwr.n88 vpwr.n89 185
rmesh_equiv_314 phase_detector__n2__n1.n0 phase_detector__n2__n1.n4 10.151300000000001
rmesh_equiv_3140 vpwr.n880 vpwr.n912 240.00290767186621
rmesh_equiv_3141 vpwr.n880 vpwr.n914 185
rmesh_equiv_3142 vpwr.n880 vpwr.n916 240
rmesh_equiv_3143 vpwr.n881 vpwr.n907 25.6005
rmesh_equiv_3144 vpwr.n881 vpwr.n910 185
rmesh_equiv_3145 vpwr.n881 vpwr.n913 25.6005
rmesh_equiv_3146 vpwr.n882 vpwr.n904 240.00290767186621
rmesh_equiv_3147 vpwr.n882 vpwr.n906 185
rmesh_equiv_3148 vpwr.n882 vpwr.n908 240
rmesh_equiv_3149 vpwr.n883 vpwr.n899 25.6005
rmesh_equiv_315 phase_detector__n2__n1.n0 phase_detector__n2__n1.t0 255.34500000000003
rmesh_equiv_3150 vpwr.n883 vpwr.n902 185
rmesh_equiv_3151 vpwr.n883 vpwr.n905 25.6005
rmesh_equiv_3152 vpwr.n884 vpwr.n896 240.00290767186621
rmesh_equiv_3153 vpwr.n884 vpwr.n898 185
rmesh_equiv_3154 vpwr.n884 vpwr.n900 240
rmesh_equiv_3155 vpwr.n885 vpwr.n891 25.6005
rmesh_equiv_3156 vpwr.n885 vpwr.n894 185
rmesh_equiv_3157 vpwr.n885 vpwr.n897 25.6005
rmesh_equiv_3158 vpwr.n886 vpwr.n888 240.00290767186621
rmesh_equiv_3159 vpwr.n886 vpwr.n890 185
rmesh_equiv_316 phase_detector__n2__n1.n1 phase_detector__n2__n1.n3 10.151300000000001
rmesh_equiv_3160 vpwr.n886 vpwr.n892 240
rmesh_equiv_3161 vpwr.n888 vpwr.n889 185
rmesh_equiv_3162 vpwr.n889 vpwr.n890 25.6005
rmesh_equiv_3163 vpwr.n89 vpwr.n90 25.6005
rmesh_equiv_3164 vpwr.n890 vpwr.n891 25.6005
rmesh_equiv_3165 vpwr.n891 vpwr.n892 185
rmesh_equiv_3166 vpwr.n892 vpwr.n894 240.00290767186621
rmesh_equiv_3167 vpwr.n894 vpwr.n896 240
rmesh_equiv_3168 vpwr.n896 vpwr.n897 185
rmesh_equiv_3169 vpwr.n897 vpwr.n898 25.6005
rmesh_equiv_317 phase_detector__n2__n1.n1 phase_detector__n2__n1.t1 255.34500000000003
rmesh_equiv_3170 vpwr.n898 vpwr.n899 25.6005
rmesh_equiv_3171 vpwr.n899 vpwr.n900 185
rmesh_equiv_3172 vpwr.n90 vpwr.n91 25.6005
rmesh_equiv_3173 vpwr.n900 vpwr.n902 240.00290767186621
rmesh_equiv_3174 vpwr.n902 vpwr.n904 240
rmesh_equiv_3175 vpwr.n904 vpwr.n905 185
rmesh_equiv_3176 vpwr.n905 vpwr.n906 25.6005
rmesh_equiv_3177 vpwr.n906 vpwr.n907 25.6005
rmesh_equiv_3178 vpwr.n907 vpwr.n908 185
rmesh_equiv_3179 vpwr.n908 vpwr.n910 240.00290767186621
rmesh_equiv_318 phase_detector__n2__n1.n2 phase_detector__n2__n1.n3 10.151300000000001
rmesh_equiv_3180 vpwr.n91 vpwr.n92 185
rmesh_equiv_3181 vpwr.n910 vpwr.n912 240
rmesh_equiv_3182 vpwr.n912 vpwr.n913 185
rmesh_equiv_3183 vpwr.n913 vpwr.n914 25.6005
rmesh_equiv_3184 vpwr.n914 vpwr.n915 25.6005
rmesh_equiv_3185 vpwr.n915 vpwr.n916 185
rmesh_equiv_3186 vpwr.n916 vpwr.n918 240.00290767186621
rmesh_equiv_3187 vpwr.n918 vpwr.n920 240
rmesh_equiv_3188 vpwr.n92 vpwr.n94 240.00290767186621
rmesh_equiv_3189 vpwr.n920 vpwr.n921 185
rmesh_equiv_319 phase_detector__n2__n1.n2 phase_detector__n2__n1.t1 255.34500000000003
rmesh_equiv_3190 vpwr.n921 vpwr.n922 25.6005
rmesh_equiv_3191 vpwr.n922 vpwr.n923 25.6005
rmesh_equiv_3192 vpwr.n923 vpwr.n924 185
rmesh_equiv_3193 vpwr.n924 vpwr.n926 240.00290767186621
rmesh_equiv_3194 vpwr.n926 vpwr.n927 240
rmesh_equiv_3195 vpwr.n927 vpwr.n928 185
rmesh_equiv_3196 vpwr.n927 vpwr.n930 240.00290767186621
rmesh_equiv_3197 vpwr.n928 vpwr.n929 25.6005
rmesh_equiv_3198 vpwr.n929 vpwr.n930 185
rmesh_equiv_3199 vpwr.n930 vpwr.n931 240
rmesh_equiv_32 oscillator__n0.n4 oscillator__n0.n6 7.2756299999999996
rmesh_equiv_320 phase_detector__n2__n1.n3 phase_detector__n2__n1.n4 36.740099999999998
rmesh_equiv_3200 vpwr.n931 vpwr.n933 240
rmesh_equiv_3201 vpwr.n933 vpwr.n934 185
rmesh_equiv_3202 vpwr.n934 vpwr.n935 25.6005
rmesh_equiv_3203 vpwr.n935 vpwr.n936 83.953400000000002
rmesh_equiv_3204 vpwr.n936 vpwr.n937 185
rmesh_equiv_3205 vpwr.n937 vpwr.n938 185
rmesh_equiv_3206 vpwr.n938 vpwr.n939 185
rmesh_equiv_3207 vpwr.n938 vpwr.t15 15.849399999999999
rmesh_equiv_3208 vpwr.n939 vpwr.n940 185
rmesh_equiv_3209 vpwr.n94 vpwr.n96 240
rmesh_equiv_321 phase_detector__n2__n1.n4 phase_detector__n2__n1.n5 10.151300000000001
rmesh_equiv_3210 vpwr.n942 vpwr.n950 185
rmesh_equiv_3211 vpwr.n943 vpwr.n948 185.00310000000002
rmesh_equiv_3212 vpwr.n943 vpwr.n950 240
rmesh_equiv_3213 vpwr.n946 vpwr.n947 185
rmesh_equiv_3214 vpwr.n947 vpwr.n949 185
rmesh_equiv_3215 vpwr.n948 vpwr.n950 185
rmesh_equiv_3216 vpwr.n951 vpwr.n952 185
rmesh_equiv_3217 vpwr.n952 vpwr.n953 185
rmesh_equiv_3218 vpwr.n953 vpwr.n954 185
rmesh_equiv_3219 vpwr.n955 vpwr.n956 185
rmesh_equiv_322 phase_detector__n2__n1.n5 phase_detector__n2__n1.t0 255.34500000000003
rmesh_equiv_3220 vpwr.n956 vpwr.n957 185
rmesh_equiv_3221 vpwr.n957 vpwr.n958 185
rmesh_equiv_3222 vpwr.n959 vpwr.n960 185
rmesh_equiv_3223 vpwr.n96 vpwr.n97 185
rmesh_equiv_3224 vpwr.n960 vpwr.n961 185
rmesh_equiv_3225 vpwr.n961 vpwr.n962 185
rmesh_equiv_3226 vpwr.n963 vpwr.n964 185
rmesh_equiv_3227 vpwr.n964 vpwr.n965 185
rmesh_equiv_3228 vpwr.n965 vpwr.n966 185
rmesh_equiv_3229 vpwr.n967 vpwr.n968 185
rmesh_equiv_323 phase_detector__n3 phase_detector__n3.n0 12.8005
rmesh_equiv_3230 vpwr.n968 vpwr.n969 185
rmesh_equiv_3231 vpwr.n969 vpwr.n970 185
rmesh_equiv_3232 vpwr.n97 vpwr.n98 25.6005
rmesh_equiv_3233 vpwr.n971 vpwr.n972 185
rmesh_equiv_3234 vpwr.n972 vpwr.n973 185
rmesh_equiv_3235 vpwr.n973 vpwr.n974 185
rmesh_equiv_3236 vpwr.n975 vpwr.n976 185
rmesh_equiv_3237 vpwr.n976 vpwr.n977 185
rmesh_equiv_3238 vpwr.n977 vpwr.n978 185
rmesh_equiv_3239 vpwr.n977 vpwr.t6 65.650899999999993
rmesh_equiv_324 phase_detector__n3 phase_detector__n3.n1 17.673997740637969
rmesh_equiv_3240 vpwr.n979 vpwr.n980 185
rmesh_equiv_3241 vpwr.n98 vpwr.n99 25.6005
rmesh_equiv_3242 vpwr.n980 vpwr.n981 185
rmesh_equiv_3243 vpwr.n981 vpwr.n982 185
rmesh_equiv_3244 vpwr.n983 vpwr.n984 185
rmesh_equiv_3245 vpwr.n984 vpwr.n985 185
rmesh_equiv_3246 vpwr.n985 vpwr.n986 185
rmesh_equiv_3247 vpwr.n987 vpwr.n988 185
rmesh_equiv_3248 vpwr.n988 vpwr.n989 185
rmesh_equiv_3249 vpwr.n989 vpwr.n990 185
rmesh_equiv_325 phase_detector__n3 phase_detector__n3.n11 12.8005
rmesh_equiv_3250 vpwr.n991 vpwr.n992 185
rmesh_equiv_3251 vpwr.n992 vpwr.n993 185
rmesh_equiv_3252 vpwr.n993 vpwr.n994 185
rmesh_equiv_3253 vpwr.n995 vpwr.n996 185
rmesh_equiv_3254 vpwr.n996 vpwr.n997 185
rmesh_equiv_3255 vpwr.n997 vpwr.n998 185
rmesh_equiv_326 phase_detector__n3 phase_detector__n3.n2 12.8005
rmesh_equiv_327 phase_detector__n3 phase_detector__n3.n3 12.8005
rmesh_equiv_328 phase_detector__n3 phase_detector__n3.n6 12.8005
rmesh_equiv_329 phase_detector__n3 phase_detector__n3.n7 12.8005
rmesh_equiv_33 oscillator__n0.n5 oscillator__n0.n6 27.236099999999997
rmesh_equiv_330 phase_detector__n3 phase_detector__n3.t3 315.88
rmesh_equiv_331 phase_detector__n3 phase_detector__n3.t4 330.34100000000001
rmesh_equiv_332 phase_detector__n3.n0 phase_detector__n3.n10 10.151300000000001
rmesh_equiv_333 phase_detector__n3.n0 phase_detector__n3.t0 700.48400000000004
rmesh_equiv_334 phase_detector__n3.n1 phase_detector__n3.n5 3.6594500000000001
rmesh_equiv_335 phase_detector__n3.n10 phase_detector__n3.n11 10.151300000000001
rmesh_equiv_336 phase_detector__n3.n10 phase_detector__n3.n9 16.4221
rmesh_equiv_337 phase_detector__n3.n11 phase_detector__n3.t0 700.48400000000004
rmesh_equiv_338 phase_detector__n3.n2 phase_detector__n3.n4 10.151300000000001
rmesh_equiv_339 phase_detector__n3.n2 phase_detector__n3.t2 700.48400000000004
rmesh_equiv_34 oscillator__n0.n5 oscillator__n0.t0 4.3505000000000003
rmesh_equiv_340 phase_detector__n3.n3 phase_detector__n3.n4 10.151300000000001
rmesh_equiv_341 phase_detector__n3.n3 phase_detector__n3.t2 700.48400000000004
rmesh_equiv_342 phase_detector__n3.n4 phase_detector__n3.n5 15.604900000000001
rmesh_equiv_343 phase_detector__n3.n5 phase_detector__n3.n9 0.81771300000000002
rmesh_equiv_344 phase_detector__n3.n6 phase_detector__n3.n8 10.151300000000001
rmesh_equiv_345 phase_detector__n3.n6 phase_detector__n3.t1 255.34500000000003
rmesh_equiv_346 phase_detector__n3.n7 phase_detector__n3.n8 10.151300000000001
rmesh_equiv_347 phase_detector__n3.n7 phase_detector__n3.t1 255.34500000000003
rmesh_equiv_348 phase_detector__n3.n8 phase_detector__n3.n9 15.604900000000001
rmesh_equiv_349 phase_detector__n3__n1 phase_detector__n3__n1.n0 12.8005
rmesh_equiv_35 oscillator__n1 oscillator__n1.n0 15.6333
rmesh_equiv_350 phase_detector__n3__n1 phase_detector__n3__n1.n1 12.8005
rmesh_equiv_351 phase_detector__n3__n1 phase_detector__n3__n1.n2 12.8005
rmesh_equiv_352 phase_detector__n3__n1 phase_detector__n3__n1.n5 12.8005
rmesh_equiv_353 phase_detector__n3__n1.n0 phase_detector__n3__n1.n4 10.151300000000001
rmesh_equiv_354 phase_detector__n3__n1.n0 phase_detector__n3__n1.t0 255.34500000000003
rmesh_equiv_355 phase_detector__n3__n1.n1 phase_detector__n3__n1.n3 10.151300000000001
rmesh_equiv_356 phase_detector__n3__n1.n1 phase_detector__n3__n1.t1 255.34500000000003
rmesh_equiv_357 phase_detector__n3__n1.n2 phase_detector__n3__n1.n3 10.151300000000001
rmesh_equiv_358 phase_detector__n3__n1.n2 phase_detector__n3__n1.t1 255.34500000000003
rmesh_equiv_359 phase_detector__n3__n1.n3 phase_detector__n3__n1.n4 36.740099999999998
rmesh_equiv_36 oscillator__n1 oscillator__n1.n1 31.751799999999999
rmesh_equiv_360 phase_detector__n3__n1.n4 phase_detector__n3__n1.n5 10.151300000000001
rmesh_equiv_361 phase_detector__n3__n1.n5 phase_detector__n3__n1.t0 255.34500000000003
rmesh_equiv_362 phase_detector__n4__n1 phase_detector__n4__n1.n0 12.8005
rmesh_equiv_363 phase_detector__n4__n1 phase_detector__n4__n1.n1 12.8005
rmesh_equiv_364 phase_detector__n4__n1 phase_detector__n4__n1.n2 12.8005
rmesh_equiv_365 phase_detector__n4__n1 phase_detector__n4__n1.n5 12.8005
rmesh_equiv_366 phase_detector__n4__n1.n0 phase_detector__n4__n1.n4 10.151300000000001
rmesh_equiv_367 phase_detector__n4__n1.n0 phase_detector__n4__n1.t0 255.34500000000003
rmesh_equiv_368 phase_detector__n4__n1.n1 phase_detector__n4__n1.n3 10.151300000000001
rmesh_equiv_369 phase_detector__n4__n1.n1 phase_detector__n4__n1.t1 255.34500000000003
rmesh_equiv_37 oscillator__n1 oscillator__n1.n3 5.4168500000000002
rmesh_equiv_370 phase_detector__n4__n1.n2 phase_detector__n4__n1.n3 10.151300000000001
rmesh_equiv_371 phase_detector__n4__n1.n2 phase_detector__n4__n1.t1 255.34500000000003
rmesh_equiv_372 phase_detector__n4__n1.n3 phase_detector__n4__n1.n4 36.740099999999998
rmesh_equiv_373 phase_detector__n4__n1.n4 phase_detector__n4__n1.n5 10.151300000000001
rmesh_equiv_374 phase_detector__n4__n1.n5 phase_detector__n4__n1.t0 255.34500000000003
rmesh_equiv_375 r_bias_bottom_r0_n0.t0 r_bias_bottom_r0_n0.t1 55.103100000000005
rmesh_equiv_376 r_bias_bottom_r0_n1.t0 r_bias_bottom_r0_n1.t1 45.289900000000003
rmesh_equiv_377 r_bias_top_r0_n0.t0 r_bias_top_r0_n0.t1 52.603099999999991
rmesh_equiv_378 r_bias_top_r0_n1.t0 r_bias_top_r0_n1.t1 52.603099999999991
rmesh_equiv_379 r_tune_r0_n0.t0 r_tune_r0_n0.t1 43.623199999999997
rmesh_equiv_38 oscillator__n1 oscillator__n1.n6 15.6333
rmesh_equiv_380 r_tune_r0_n1.t0 r_tune_r0_n1.t1 53.436500000000002
rmesh_equiv_381 r_tune_r0_n10.t0 r_tune_r0_n10.t1 53.436500000000002
rmesh_equiv_382 r_tune_r0_n11.t0 r_tune_r0_n11.t1 53.436500000000002
rmesh_equiv_383 r_tune_r0_n12.t0 r_tune_r0_n12.t1 43.623199999999997
rmesh_equiv_384 r_tune_r0_n13.t0 r_tune_r0_n13.t1 53.436500000000002
rmesh_equiv_385 r_tune_r0_n14.t0 r_tune_r0_n14.t1 43.623199999999997
rmesh_equiv_386 r_tune_r0_n15.t0 r_tune_r0_n15.t1 43.623199999999997
rmesh_equiv_387 r_tune_r0_n16.t0 r_tune_r0_n16.t1 43.623199999999997
rmesh_equiv_388 r_tune_r0_n17.t0 r_tune_r0_n17.t1 53.436500000000002
rmesh_equiv_389 r_tune_r0_n18.t0 r_tune_r0_n18.t1 43.623199999999997
rmesh_equiv_39 oscillator__n1.n0 oscillator__n1.n5 5.2415200000000004
rmesh_equiv_390 r_tune_r0_n19.t0 r_tune_r0_n19.t1 53.436500000000002
rmesh_equiv_391 r_tune_r0_n2.t0 r_tune_r0_n2.t1 43.623199999999997
rmesh_equiv_392 r_tune_r0_n20.t0 r_tune_r0_n20.t1 43.623199999999997
rmesh_equiv_393 r_tune_r0_n21.t0 r_tune_r0_n21.t1 53.436500000000002
rmesh_equiv_394 r_tune_r0_n22.t0 r_tune_r0_n22.t1 43.623199999999997
rmesh_equiv_395 r_tune_r0_n3.t0 r_tune_r0_n3.t1 43.623199999999997
rmesh_equiv_396 r_tune_r0_n4.t0 r_tune_r0_n4.t1 53.436500000000002
rmesh_equiv_397 r_tune_r0_n5.t0 r_tune_r0_n5.t1 43.623199999999997
rmesh_equiv_398 r_tune_r0_n6.t0 r_tune_r0_n6.t1 53.436500000000002
rmesh_equiv_399 r_tune_r0_n7.t0 r_tune_r0_n7.t1 53.436500000000002
rmesh_equiv_4 ctrl ctrl.n4 4.1357100000000004
rmesh_equiv_40 oscillator__n1.n0 oscillator__n1.t0 174.857
rmesh_equiv_400 r_tune_r0_n8.t0 r_tune_r0_n8.t1 43.623199999999997
rmesh_equiv_401 r_tune_r0_n9.t0 r_tune_r0_n9.t1 53.436500000000002
rmesh_equiv_402 ref ref.n0 0.55836898112541766
rmesh_equiv_403 ref ref.n1 34.952100000000002
rmesh_equiv_404 ref ref.n2 17.673997740637969
rmesh_equiv_405 ref ref.t0 315.88
rmesh_equiv_406 ref ref.t1 330.34100000000001
rmesh_equiv_407 ref ref.t2 315.88
rmesh_equiv_408 ref ref.t3 330.34100000000001
rmesh_equiv_409 ref.n0 ref.n1 0.81771300000000002
rmesh_equiv_41 oscillator__n1.n1 oscillator__n1.n2 37.418900000000001
rmesh_equiv_410 ref.n1 ref.n2 2.4756399999999998
rmesh_equiv_411 tune tune.n2 33.204599999999999
rmesh_equiv_412 tune tune.n3 33.204599999999999
rmesh_equiv_413 tune tune.n4 17.984102235560798
rmesh_equiv_414 tune tune.t3 419.50999999999993
rmesh_equiv_415 tune tune.t4 419.50999999999993
rmesh_equiv_416 tune tune.t5 419.50999999999993
rmesh_equiv_417 tune tune.t6 419.50999999999993
rmesh_equiv_418 tune.n0 tune.n1 24.5886
rmesh_equiv_419 tune.n0 tune.t0 21.545300000000001
rmesh_equiv_42 oscillator__n1.n1 oscillator__n1.n4 2.60127
rmesh_equiv_420 tune.n0 tune.t2 21.245000000000001
rmesh_equiv_421 tune.n1 tune.n2 1.8581800000000002
rmesh_equiv_422 tune.n1 tune.t1 31.736100000000004
rmesh_equiv_423 tune.n2 tune.n3 3.3868499999999999
rmesh_equiv_424 tune.n3 tune.n4 6.0294200000000009
rmesh_equiv_425 vgnd vgnd.n14460 209.08968304548645
rmesh_equiv_426 vgnd vgnd.n15702 9089.1506227353348
rmesh_equiv_427 vgnd vgnd.n15707 138.82856407955094
rmesh_equiv_428 vgnd vgnd.n15940 229.30986381642515
rmesh_equiv_429 vgnd vgnd.n16085 3.8773069468885493
rmesh_equiv_43 oscillator__n1.n2 oscillator__n1.n3 31.473199999999995
rmesh_equiv_430 vgnd vgnd.n16120 214.56663169951815
rmesh_equiv_431 vgnd vgnd.n1926 209.08994823209713
rmesh_equiv_432 vgnd vgnd.n215 1215.7528897182228
rmesh_equiv_433 vgnd vgnd.n216 5825.9481296282611
rmesh_equiv_434 vgnd vgnd.n2460 209.08994853266535
rmesh_equiv_435 vgnd vgnd.n267 1559.4028476964852
rmesh_equiv_436 vgnd vgnd.n324 212.68374138231678
rmesh_equiv_437 vgnd vgnd.n4062 209.08950929479462
rmesh_equiv_438 vgnd vgnd.n5942 6.0191421435938377
rmesh_equiv_439 vgnd vgnd.n5946 20.388939652811608
rmesh_equiv_44 oscillator__n1.n2 oscillator__n1.t1 4.3505000000000003
rmesh_equiv_440 vgnd vgnd.n6198 698.87260383668604
rmesh_equiv_441 vgnd vgnd.n6208 578.44158053349031
rmesh_equiv_442 vgnd vgnd.n6394 231.10049282116933
rmesh_equiv_443 vgnd vgnd.n7045 206.9931189617154
rmesh_equiv_444 vgnd vgnd.n9949 209.08965650159715
rmesh_equiv_445 vgnd vgnd.t0 205.78065815875232
rmesh_equiv_446 vgnd vgnd.t1 133.95535037491854
rmesh_equiv_447 vgnd vgnd.t10 24.815432235092938
rmesh_equiv_448 vgnd vgnd.t15 133.955341628908
rmesh_equiv_449 vgnd vgnd.t16 133.95534148481283
rmesh_equiv_45 oscillator__n1.n3 oscillator__n1.n4 1.7058199999999999
rmesh_equiv_450 vgnd vgnd.t17 133.36945442367397
rmesh_equiv_451 vgnd vgnd.t18 135.62384337743367
rmesh_equiv_452 vgnd vgnd.t19 115.82620589707885
rmesh_equiv_453 vgnd vgnd.t2 133.74615157633264
rmesh_equiv_454 vgnd vgnd.t20 127.84665414569002
rmesh_equiv_455 vgnd vgnd.t21 127.81823545958078
rmesh_equiv_456 vgnd vgnd.t22 127.31565904563095
rmesh_equiv_457 vgnd vgnd.t23 56.443930342415669
rmesh_equiv_458 vgnd vgnd.t24 127.88379312916506
rmesh_equiv_459 vgnd vgnd.t25 127.89995520134379
rmesh_equiv_46 oscillator__n1.n4 oscillator__n1.n5 34.129899999999999
rmesh_equiv_460 vgnd vgnd.t26 130.47825955063533
rmesh_equiv_461 vgnd vgnd.t27 128.42470584343513
rmesh_equiv_462 vgnd vgnd.t28 133.95535051901359
rmesh_equiv_463 vgnd vgnd.t29 128.44497078835792
rmesh_equiv_464 vgnd vgnd.t3 152.23733069166289
rmesh_equiv_465 vgnd vgnd.t30 205.37796912507204
rmesh_equiv_466 vgnd vgnd.t31 127.90068002060656
rmesh_equiv_467 vgnd vgnd.t32 133.96199825287079
rmesh_equiv_468 vgnd vgnd.t33 213.06768209846717
rmesh_equiv_469 vgnd vgnd.t34 205.7822197894611
rmesh_equiv_47 oscillator__n1.n5 oscillator__n1.n6 5.2415200000000004
rmesh_equiv_470 vgnd vgnd.t35 205.78050017339604
rmesh_equiv_471 vgnd vgnd.t36 270.93758272232492
rmesh_equiv_472 vgnd vgnd.t37 132.79578187965271
rmesh_equiv_473 vgnd vgnd.t38 22.640528483775132
rmesh_equiv_474 vgnd vgnd.t39 247.92722875651907
rmesh_equiv_475 vgnd vgnd.t4 143.79324549901222
rmesh_equiv_476 vgnd vgnd.t40 205.2952133257198
rmesh_equiv_477 vgnd vgnd.t41 128.37904681583097
rmesh_equiv_478 vgnd vgnd.t42 127.83597689850968
rmesh_equiv_479 vgnd vgnd.t43 128.38510062827581
rmesh_equiv_48 oscillator__n1.n6 oscillator__n1.t0 174.857
rmesh_equiv_480 vgnd vgnd.t44 128.34621103982408
rmesh_equiv_481 vgnd vgnd.t45 127.90068002206091
rmesh_equiv_482 vgnd vgnd.t46 208.27004839353089
rmesh_equiv_483 vgnd vgnd.t47 135.78129945468697
rmesh_equiv_484 vgnd vgnd.t48 242.36159450027623
rmesh_equiv_485 vgnd vgnd.t49 138.63083315714204
rmesh_equiv_486 vgnd vgnd.t5 205.4100597129524
rmesh_equiv_487 vgnd vgnd.t50 128.38510063615743
rmesh_equiv_488 vgnd vgnd.t51 205.7806563298183
rmesh_equiv_489 vgnd vgnd.t52 130.74227359718267
rmesh_equiv_49 oscillator__n2 oscillator__n2.n0 6.7655600000000007
rmesh_equiv_490 vgnd vgnd.t53 127.89995520281444
rmesh_equiv_491 vgnd vgnd.t54 205.77964300919965
rmesh_equiv_492 vgnd vgnd.t55 128.37904680786178
rmesh_equiv_493 vgnd vgnd.t56 205.2969369009279
rmesh_equiv_494 vgnd vgnd.t57 205.63635942324871
rmesh_equiv_495 vgnd vgnd.t58 248.71839592059067
rmesh_equiv_496 vgnd vgnd.t59 110.44990351355557
rmesh_equiv_497 vgnd vgnd.t6 133.99043071995044
rmesh_equiv_498 vgnd vgnd.t60 52.20206650635631
rmesh_equiv_499 vgnd vgnd.t61 130.32529007615912
rmesh_equiv_5 ctrl ctrl.n5 4.1357100000000004
rmesh_equiv_50 oscillator__n2 oscillator__n2.n1 15.6333
rmesh_equiv_500 vgnd vgnd.t62 114.27833268733706
rmesh_equiv_501 vgnd vgnd.t63 205.78049834446188
rmesh_equiv_502 vgnd vgnd.t7 25.321446214556293
rmesh_equiv_503 vgnd vgnd.t8 237.68283238825612
rmesh_equiv_504 vgnd.n14460 vgnd.n1926 2933866767981.9951
rmesh_equiv_505 vgnd.n14460 vgnd.n324 478023235.57354963
rmesh_equiv_506 vgnd.n14460 vgnd.t0 78941726.751551911
rmesh_equiv_507 vgnd.n14460 vgnd.t15 833.30252663182023
rmesh_equiv_508 vgnd.n14460 vgnd.t16 53093414905.827469
rmesh_equiv_509 vgnd.n14460 vgnd.t25 593664398.44252229
rmesh_equiv_51 oscillator__n2 oscillator__n2.n2 15.6333
rmesh_equiv_510 vgnd.n14460 vgnd.t42 6647038.3966284515
rmesh_equiv_511 vgnd.n14460 vgnd.t43 8977.9283182156942
rmesh_equiv_512 vgnd.n14460 vgnd.t50 801851.4720225092
rmesh_equiv_513 vgnd.n14460 vgnd.t51 100.52252489182517
rmesh_equiv_514 vgnd.n14460 vgnd.t53 74424.417299779117
rmesh_equiv_515 vgnd.n15702 vgnd.n15707 34988.656343500261
rmesh_equiv_516 vgnd.n15702 vgnd.n15940 552648.19635465869
rmesh_equiv_517 vgnd.n15702 vgnd.n215 635.32467765354158
rmesh_equiv_518 vgnd.n15702 vgnd.n216 32221.191482860417
rmesh_equiv_519 vgnd.n15702 vgnd.n267 348.41551081030536
rmesh_equiv_52 oscillator__n2 oscillator__n2.n6 23.111999999999998
rmesh_equiv_520 vgnd.n15702 vgnd.n324 23200.613511345939
rmesh_equiv_521 vgnd.n15702 vgnd.t36 548.95789342684816
rmesh_equiv_522 vgnd.n15702 vgnd.t58 467843.80840195128
rmesh_equiv_523 vgnd.n15707 vgnd.n15940 22234.436991304796
rmesh_equiv_524 vgnd.n15707 vgnd.n215 359.99994500919428
rmesh_equiv_525 vgnd.n15707 vgnd.n216 292.29456986530897
rmesh_equiv_526 vgnd.n15707 vgnd.n267 1795.4642353083282
rmesh_equiv_527 vgnd.n15707 vgnd.n324 688367.44656987221
rmesh_equiv_528 vgnd.n15707 vgnd.t36 6774.0406225274573
rmesh_equiv_529 vgnd.n15707 vgnd.t58 18822.541624671627
rmesh_equiv_53 oscillator__n2.n0 oscillator__n2.n4 0.555091
rmesh_equiv_530 vgnd.n15940 vgnd.n16120 93446020041.706879
rmesh_equiv_531 vgnd.n15940 vgnd.n215 5443.9859987511963
rmesh_equiv_532 vgnd.n15940 vgnd.n216 18257.334533447971
rmesh_equiv_533 vgnd.n15940 vgnd.n267 24014.347521070958
rmesh_equiv_534 vgnd.n15940 vgnd.t2 65464.799921601865
rmesh_equiv_535 vgnd.n15940 vgnd.t26 11304915.846241981
rmesh_equiv_536 vgnd.n15940 vgnd.t58 142.09784709214802
rmesh_equiv_537 vgnd.n15940 vgnd.t8 9173258573.3246632
rmesh_equiv_538 vgnd.n16085 vgnd.n5942 1085.7203364617046
rmesh_equiv_539 vgnd.n16085 vgnd.t19 1207.2707151766251
rmesh_equiv_54 oscillator__n2.n0 oscillator__n2.n5 39.311100000000003
rmesh_equiv_540 vgnd.n16085 vgnd.t23 5528.9037418455637
rmesh_equiv_541 vgnd.n16085 vgnd.t27 338.40053338309883
rmesh_equiv_542 vgnd.n16085 vgnd.t38 36.51832877567324
rmesh_equiv_543 vgnd.n16085 vgnd.t59 602.55313708387587
rmesh_equiv_544 vgnd.n16085 vgnd.t60 10.457370254377075
rmesh_equiv_545 vgnd.n16085 vgnd.t62 3826.8953177508292
rmesh_equiv_546 vgnd.n16085 vgnd.t7 93.404483598494508
rmesh_equiv_547 vgnd.n16120 vgnd.t18 758.18637709923928
rmesh_equiv_548 vgnd.n16120 vgnd.t2 8797407.8807155285
rmesh_equiv_549 vgnd.n16120 vgnd.t26 72364.39894174879
rmesh_equiv_55 oscillator__n2.n1 oscillator__n2.n3 5.2415200000000004
rmesh_equiv_550 vgnd.n16120 vgnd.t37 574973.41709566559
rmesh_equiv_551 vgnd.n16120 vgnd.t58 4046441823.8243761
rmesh_equiv_552 vgnd.n16120 vgnd.t61 99164775.969122514
rmesh_equiv_553 vgnd.n16120 vgnd.t8 67.110680963558593
rmesh_equiv_554 vgnd.n1926 vgnd.n2460 44368584.848803803
rmesh_equiv_555 vgnd.n1926 vgnd.t15 53093415412.419083
rmesh_equiv_556 vgnd.n1926 vgnd.t16 833.30253454104081
rmesh_equiv_557 vgnd.n1926 vgnd.t25 74424.418006172171
rmesh_equiv_558 vgnd.n1926 vgnd.t29 8977.9295779435233
rmesh_equiv_559 vgnd.n1926 vgnd.t32 802926.60521263559
rmesh_equiv_56 oscillator__n2.n1 oscillator__n2.t1 174.857
rmesh_equiv_560 vgnd.n1926 vgnd.t34 100.52252212424807
rmesh_equiv_561 vgnd.n1926 vgnd.t42 6647038.4597182563
rmesh_equiv_562 vgnd.n1926 vgnd.t53 593664404.07724154
rmesh_equiv_563 vgnd.n215 vgnd.n216 314.56335420119177
rmesh_equiv_564 vgnd.n215 vgnd.n267 361.65758262461515
rmesh_equiv_565 vgnd.n215 vgnd.n324 277865.62581783126
rmesh_equiv_566 vgnd.n215 vgnd.t36 65.695499580941004
rmesh_equiv_567 vgnd.n215 vgnd.t58 4608.601202976115
rmesh_equiv_568 vgnd.n216 vgnd.n267 1478.9012568832011
rmesh_equiv_569 vgnd.n216 vgnd.n324 1823213.927324306
rmesh_equiv_57 oscillator__n2.n2 oscillator__n2.n3 5.2415200000000004
rmesh_equiv_570 vgnd.n216 vgnd.t36 17941.762453752293
rmesh_equiv_571 vgnd.n216 vgnd.t58 15455.729297115548
rmesh_equiv_572 vgnd.n2460 vgnd.n9949 42693499211.04451
rmesh_equiv_573 vgnd.n2460 vgnd.t20 801842.12081319338
rmesh_equiv_574 vgnd.n2460 vgnd.t29 74425.284013406432
rmesh_equiv_575 vgnd.n2460 vgnd.t32 833.30253575496431
rmesh_equiv_576 vgnd.n2460 vgnd.t34 7327118.0997820133
rmesh_equiv_577 vgnd.n2460 vgnd.t35 100.52252212231231
rmesh_equiv_578 vgnd.n2460 vgnd.t41 8977.9280577701829
rmesh_equiv_579 vgnd.n2460 vgnd.t55 71615439.789033249
rmesh_equiv_58 oscillator__n2.n2 oscillator__n2.t1 174.857
rmesh_equiv_580 vgnd.n2460 vgnd.t63 7050490838.8266582
rmesh_equiv_581 vgnd.n267 vgnd.n324 3161.0996157867239
rmesh_equiv_582 vgnd.n267 vgnd.t36 439.82298557187261
rmesh_equiv_583 vgnd.n267 vgnd.t58 20329.323201727824
rmesh_equiv_584 vgnd.n324 vgnd.t0 100.52252212232898
rmesh_equiv_585 vgnd.n324 vgnd.t36 1059.6836826864121
rmesh_equiv_586 vgnd.n324 vgnd.t43 801851.44993035286
rmesh_equiv_587 vgnd.n324 vgnd.t50 8977.9280708647821
rmesh_equiv_588 vgnd.n324 vgnd.t51 78941724.277444899
rmesh_equiv_589 vgnd.n4062 vgnd.n7045 41935476806.794075
rmesh_equiv_59 oscillator__n2.n3 oscillator__n2.n4 32.463200000000001
rmesh_equiv_590 vgnd.n4062 vgnd.n9949 32849415276.07753
rmesh_equiv_591 vgnd.n4062 vgnd.t1 833.30253454104309
rmesh_equiv_592 vgnd.n4062 vgnd.t21 71439740.529559448
rmesh_equiv_593 vgnd.n4062 vgnd.t22 803647.33367071487
rmesh_equiv_594 vgnd.n4062 vgnd.t28 594467230.18969512
rmesh_equiv_595 vgnd.n4062 vgnd.t31 74424.418007751825
rmesh_equiv_596 vgnd.n4062 vgnd.t40 7006257631.3077755
rmesh_equiv_597 vgnd.n4062 vgnd.t44 8977.974030283558
rmesh_equiv_598 vgnd.n4062 vgnd.t45 6647039.5850906912
rmesh_equiv_599 vgnd.n4062 vgnd.t54 100.52252218085303
rmesh_equiv_6 ctrl ctrl.n6 4.1357100000000004
rmesh_equiv_60 oscillator__n2.n4 oscillator__n2.n6 7.2756299999999996
rmesh_equiv_600 vgnd.n5942 vgnd.n5946 69.871743659922075
rmesh_equiv_601 vgnd.n5942 vgnd.t11 12.212040736173483
rmesh_equiv_602 vgnd.n5942 vgnd.t12 30.131853121479011
rmesh_equiv_603 vgnd.n5942 vgnd.t13 5.0536300000000001
rmesh_equiv_604 vgnd.n5942 vgnd.t23 98.017851134196491
rmesh_equiv_605 vgnd.n5942 vgnd.t59 106099.60178224652
rmesh_equiv_606 vgnd.n5942 vgnd.t9 85.025328961844494
rmesh_equiv_607 vgnd.n5946 vgnd.t10 11.599108950291445
rmesh_equiv_608 vgnd.n5946 vgnd.t11 85.025328961844494
rmesh_equiv_609 vgnd.n5946 vgnd.t12 30.131853121479011
rmesh_equiv_61 oscillator__n2.n5 oscillator__n2.n6 27.236099999999997
rmesh_equiv_610 vgnd.n5946 vgnd.t14 5.0536300000000001
rmesh_equiv_611 vgnd.n5946 vgnd.t4 3203.1893801039973
rmesh_equiv_612 vgnd.n5946 vgnd.t47 11586.318377587115
rmesh_equiv_613 vgnd.n5946 vgnd.t49 5924.6767926216226
rmesh_equiv_614 vgnd.n5946 vgnd.t6 28582.386081172437
rmesh_equiv_615 vgnd.n5946 vgnd.t9 12.212040736173483
rmesh_equiv_616 vgnd.n6198 vgnd.n6208 76392.951103692787
rmesh_equiv_617 vgnd.n6198 vgnd.n6394 26392309557.805443
rmesh_equiv_618 vgnd.n6198 vgnd.t3 21266.006765037346
rmesh_equiv_619 vgnd.n6198 vgnd.t30 19374030.919752669
rmesh_equiv_62 oscillator__n2.n5 oscillator__n2.t0 4.3505000000000003
rmesh_equiv_620 vgnd.n6198 vgnd.t33 4810.5289156726631
rmesh_equiv_621 vgnd.n6198 vgnd.t39 4840.2500275136754
rmesh_equiv_622 vgnd.n6198 vgnd.t46 39298.514668374912
rmesh_equiv_623 vgnd.n6198 vgnd.t48 576.48747004383927
rmesh_equiv_624 vgnd.n6198 vgnd.t5 2630078.1490953355
rmesh_equiv_625 vgnd.n6198 vgnd.t52 13220520.255397065
rmesh_equiv_626 vgnd.n6198 vgnd.t57 321128.58381749346
rmesh_equiv_627 vgnd.n6208 vgnd.n6394 988329089051.71594
rmesh_equiv_628 vgnd.n6208 vgnd.t3 796361.26758148894
rmesh_equiv_629 vgnd.n6208 vgnd.t30 15611274.501602875
rmesh_equiv_63 oscillator__p0 oscillator__p0.n0 20.2395
rmesh_equiv_630 vgnd.n6208 vgnd.t33 123184.22589089342
rmesh_equiv_631 vgnd.n6208 vgnd.t39 655.66514236159844
rmesh_equiv_632 vgnd.n6208 vgnd.t46 8661.696441519307
rmesh_equiv_633 vgnd.n6208 vgnd.t48 9144.2665370010545
rmesh_equiv_634 vgnd.n6208 vgnd.t5 1408899.7803039863
rmesh_equiv_635 vgnd.n6208 vgnd.t52 495076973.54747218
rmesh_equiv_636 vgnd.n6208 vgnd.t57 112158.27646589989
rmesh_equiv_637 vgnd.n6394 vgnd.n7045 43578417.786630079
rmesh_equiv_638 vgnd.n6394 vgnd.t17 794175.26255622297
rmesh_equiv_639 vgnd.n6394 vgnd.t24 8921.9475218040861
rmesh_equiv_64 oscillator__p0 oscillator__p0.n2 7.0934900000000001
rmesh_equiv_640 vgnd.n6394 vgnd.t3 2159295.3964921255
rmesh_equiv_641 vgnd.n6394 vgnd.t33 4489300655.4363747
rmesh_equiv_642 vgnd.n6394 vgnd.t48 170915367386.39737
rmesh_equiv_643 vgnd.n6394 vgnd.t52 29641.136511280511
rmesh_equiv_644 vgnd.n6394 vgnd.t56 100.36686838085022
rmesh_equiv_645 vgnd.n7045 vgnd.t17 835.13249226105768
rmesh_equiv_646 vgnd.n7045 vgnd.t21 8921.9459895493346
rmesh_equiv_647 vgnd.n7045 vgnd.t22 793097.48530884739
rmesh_equiv_648 vgnd.n7045 vgnd.t24 74238.594536767225
rmesh_equiv_649 vgnd.n7045 vgnd.t40 100.36686837887304
rmesh_equiv_65 oscillator__p0 oscillator__p0.n4 29.566400000000005
rmesh_equiv_650 vgnd.n7045 vgnd.t44 70343910.724648997
rmesh_equiv_651 vgnd.n7045 vgnd.t54 6925309702.3745575
rmesh_equiv_652 vgnd.n7045 vgnd.t56 7280747.6014778391
rmesh_equiv_653 vgnd.n9949 vgnd.t1 594467224.51757717
rmesh_equiv_654 vgnd.n9949 vgnd.t20 801842.14290474728
rmesh_equiv_655 vgnd.n9949 vgnd.t28 833.30252663182239
rmesh_equiv_656 vgnd.n9949 vgnd.t31 6647039.5220008353
rmesh_equiv_657 vgnd.n9949 vgnd.t35 7050491059.7955885
rmesh_equiv_658 vgnd.n9949 vgnd.t41 71615441.762141243
rmesh_equiv_659 vgnd.n9949 vgnd.t45 74424.417301358772
rmesh_equiv_66 oscillator__p0 oscillator__p0.n7 17.948799999999999
rmesh_equiv_660 vgnd.n9949 vgnd.t55 8977.9283051210914
rmesh_equiv_661 vgnd.n9949 vgnd.t63 100.5225248918085
rmesh_equiv_662 vgnd.t0 vgnd.t43 132419.37492805879
rmesh_equiv_663 vgnd.t0 vgnd.t50 1482.6332525759578
rmesh_equiv_664 vgnd.t0 vgnd.t51 13036596.473661523
rmesh_equiv_665 vgnd.t1 vgnd.t28 10757917.041368945
rmesh_equiv_666 vgnd.t1 vgnd.t31 1346.839109237477
rmesh_equiv_667 vgnd.t1 vgnd.t45 120289.72632231172
rmesh_equiv_668 vgnd.t10 vgnd.t4 3898.6102441663138
rmesh_equiv_669 vgnd.t10 vgnd.t47 14101.73866072415
rmesh_equiv_67 oscillator__p0.n0 oscillator__p0.n1 54.441499999999998
rmesh_equiv_670 vgnd.t10 vgnd.t49 7210.9397529093831
rmesh_equiv_671 vgnd.t10 vgnd.t6 34787.697496411442
rmesh_equiv_672 vgnd.t11 vgnd.t12 36.666763840234047
rmesh_equiv_673 vgnd.t11 vgnd.t9 103.46538080194709
rmesh_equiv_674 vgnd.t12 vgnd.t9 36.666763840234047
rmesh_equiv_675 vgnd.t15 vgnd.t16 960817568.13993168
rmesh_equiv_676 vgnd.t15 vgnd.t25 10743388.508999314
rmesh_equiv_677 vgnd.t15 vgnd.t42 120289.70596276932
rmesh_equiv_678 vgnd.t15 vgnd.t53 1346.8391092763663
rmesh_equiv_679 vgnd.t16 vgnd.t25 1346.8391092088905
rmesh_equiv_68 oscillator__p0.n0 oscillator__p0.n6 0.71089000000000002
rmesh_equiv_680 vgnd.t16 vgnd.t42 120289.70595674285
rmesh_equiv_681 vgnd.t16 vgnd.t53 10743388.508461142
rmesh_equiv_682 vgnd.t17 vgnd.t24 1352.9278551762986
rmesh_equiv_683 vgnd.t17 vgnd.t56 132684.70797448815
rmesh_equiv_684 vgnd.t18 vgnd.t37 6643.8505408586043
rmesh_equiv_685 vgnd.t18 vgnd.t61 1145854.627131324
rmesh_equiv_686 vgnd.t19 vgnd.t38 1587.9396860998299
rmesh_equiv_687 vgnd.t19 vgnd.t60 2640.0185521104736
rmesh_equiv_688 vgnd.t19 vgnd.t62 166406.27195553065
rmesh_equiv_689 vgnd.t19 vgnd.t7 4061.5409121491416
rmesh_equiv_69 oscillator__p0.n1 oscillator__p0.n7 48.2789
rmesh_equiv_690 vgnd.t2 vgnd.t26 1064.293115021557
rmesh_equiv_691 vgnd.t2 vgnd.t58 2834.7863747737406
rmesh_equiv_692 vgnd.t2 vgnd.t8 863609.78486605664
rmesh_equiv_693 vgnd.t20 vgnd.t35 132417.83429872777
rmesh_equiv_694 vgnd.t20 vgnd.t41 1345.0356322789733
rmesh_equiv_695 vgnd.t20 vgnd.t55 1345.0356322783935
rmesh_equiv_696 vgnd.t20 vgnd.t63 132417.83379687386
rmesh_equiv_697 vgnd.t21 vgnd.t22 1351.0917933793644
rmesh_equiv_698 vgnd.t21 vgnd.t40 1490.6102645116109
rmesh_equiv_699 vgnd.t21 vgnd.t44 119835.30682520456
rmesh_equiv_7 ctrl ctrl.t2 0.00141837
rmesh_equiv_70 oscillator__p0.n1 oscillator__p0.t0 3.5711299999999997
rmesh_equiv_700 vgnd.t21 vgnd.t54 11797703.660408232
rmesh_equiv_701 vgnd.t22 vgnd.t40 132504.64122339184
rmesh_equiv_702 vgnd.t22 vgnd.t44 1348.0637540927189
rmesh_equiv_703 vgnd.t22 vgnd.t54 132715.9508117376
rmesh_equiv_704 vgnd.t23 vgnd.t59 540299.80428839289
rmesh_equiv_705 vgnd.t24 vgnd.t56 1490.6105205089757
rmesh_equiv_706 vgnd.t25 vgnd.t42 1345.0202073515447
rmesh_equiv_707 vgnd.t25 vgnd.t53 120127.2754337347
rmesh_equiv_708 vgnd.t26 vgnd.t58 489530.57898700994
rmesh_equiv_709 vgnd.t26 vgnd.t8 7103.7519061765061
rmesh_equiv_71 oscillator__p0.n2 oscillator__p0.n3 43.578400000000002
rmesh_equiv_710 vgnd.t28 vgnd.t31 120289.7263283374
rmesh_equiv_711 vgnd.t28 vgnd.t45 1346.8391093049531
rmesh_equiv_712 vgnd.t29 vgnd.t32 1346.8547811139345
rmesh_equiv_713 vgnd.t29 vgnd.t34 1482.6335014579984
rmesh_equiv_714 vgnd.t3 vgnd.t33 3617.3226105769791
rmesh_equiv_715 vgnd.t3 vgnd.t48 137717.66927510226
rmesh_equiv_716 vgnd.t3 vgnd.t52 1081.6411676357855
rmesh_equiv_717 vgnd.t30 vgnd.t39 5120227.6655825265
rmesh_equiv_718 vgnd.t30 vgnd.t46 509502.22596781858
rmesh_equiv_719 vgnd.t30 vgnd.t5 6112.5075441271592
rmesh_equiv_72 oscillator__p0.n2 oscillator__p0.n5 0.234454
rmesh_equiv_720 vgnd.t30 vgnd.t57 56902.50328527137
rmesh_equiv_721 vgnd.t31 vgnd.t45 1345.0204350692984
rmesh_equiv_722 vgnd.t32 vgnd.t34 132596.92825223476
rmesh_equiv_723 vgnd.t33 vgnd.t48 21302.69912884181
rmesh_equiv_724 vgnd.t33 vgnd.t52 2248794.8664656016
rmesh_equiv_725 vgnd.t35 vgnd.t41 1482.6332504134891
rmesh_equiv_726 vgnd.t35 vgnd.t55 11826718.992508538
rmesh_equiv_727 vgnd.t35 vgnd.t63 1164332358.4368691
rmesh_equiv_728 vgnd.t37 vgnd.t61 1061.8901543996808
rmesh_equiv_729 vgnd.t38 vgnd.t60 79.857039724302723
rmesh_equiv_73 oscillator__p0.n3 oscillator__p0.n4 37.816499999999998
rmesh_equiv_730 vgnd.t38 vgnd.t62 1600.0627988470351
rmesh_equiv_731 vgnd.t38 vgnd.t7 39.053338814427434
rmesh_equiv_732 vgnd.t39 vgnd.t46 10385.930674662241
rmesh_equiv_733 vgnd.t39 vgnd.t5 695085.03199054149
rmesh_equiv_734 vgnd.t39 vgnd.t57 84868.836324364544
rmesh_equiv_735 vgnd.t4 vgnd.t47 522361.35329534934
rmesh_equiv_736 vgnd.t4 vgnd.t49 267110.05915546801
rmesh_equiv_737 vgnd.t4 vgnd.t6 1288617.6080447633
rmesh_equiv_738 vgnd.t40 vgnd.t44 11752520.749943096
rmesh_equiv_739 vgnd.t40 vgnd.t54 1157027596.823952
rmesh_equiv_74 oscillator__p0.n3 oscillator__p0.t1 2.8570000000000002
rmesh_equiv_740 vgnd.t41 vgnd.t55 120130.03038539572
rmesh_equiv_741 vgnd.t41 vgnd.t63 11826718.947691238
rmesh_equiv_742 vgnd.t42 vgnd.t53 1345.0202073515529
rmesh_equiv_743 vgnd.t43 vgnd.t50 1345.0512812386269
rmesh_equiv_744 vgnd.t43 vgnd.t51 1482.6332469568858
rmesh_equiv_745 vgnd.t44 vgnd.t54 1482.6408424075998
rmesh_equiv_746 vgnd.t46 vgnd.t5 63156.617672122331
rmesh_equiv_747 vgnd.t46 vgnd.t57 6774.0688391087251
rmesh_equiv_748 vgnd.t47 vgnd.t49 283177.26596331189
rmesh_equiv_749 vgnd.t47 vgnd.t6 384071.71197706577
rmesh_equiv_75 oscillator__p0.n4 oscillator__p0.n5 3.2602699999999998
rmesh_equiv_750 vgnd.t48 vgnd.t52 85615473.384072646
rmesh_equiv_751 vgnd.t49 vgnd.t6 698572.37488236569
rmesh_equiv_752 vgnd.t5 vgnd.t57 6751.2212134585961
rmesh_equiv_753 vgnd.t50 vgnd.t51 132419.37442625602
rmesh_equiv_754 vgnd.t55 vgnd.t63 1482.6332447944169
rmesh_equiv_755 vgnd.t58 vgnd.t8 397224591.64434659
rmesh_equiv_756 vgnd.t60 vgnd.t62 8368.524564408739
rmesh_equiv_757 vgnd.t60 vgnd.t7 204.25374893173614
rmesh_equiv_758 vgnd.t62 vgnd.t7 1045.9668820695988
rmesh_equiv_759 vpwr vpwr.n0 12.8005
rmesh_equiv_76 oscillator__p0.n5 oscillator__p0.n6 34.706800000000001
rmesh_equiv_760 vpwr vpwr.n1116 25.6005
rmesh_equiv_761 vpwr vpwr.n1117 29.3598
rmesh_equiv_762 vpwr vpwr.n1118 6.5282000000000009
rmesh_equiv_763 vpwr vpwr.n1120 33.414000000000001
rmesh_equiv_764 vpwr vpwr.n1123 12.8005
rmesh_equiv_765 vpwr vpwr.n1263 12.8005
rmesh_equiv_766 vpwr vpwr.n1264 29.012600000000003
rmesh_equiv_767 vpwr vpwr.n1265 25.6005
rmesh_equiv_768 vpwr vpwr.n1266 185
rmesh_equiv_769 vpwr vpwr.n140 12.8005
rmesh_equiv_77 oscillator__p0.n6 oscillator__p0.n7 2.38164
rmesh_equiv_770 vpwr vpwr.n141 12.8005
rmesh_equiv_771 vpwr vpwr.n1439 25.6005
rmesh_equiv_772 vpwr vpwr.n1440 29.3598
rmesh_equiv_773 vpwr vpwr.n1441 6.5282000000000009
rmesh_equiv_774 vpwr vpwr.n1443 33.414000000000001
rmesh_equiv_775 vpwr vpwr.n1445 29.715800000000002
rmesh_equiv_776 vpwr vpwr.n172 12.8005
rmesh_equiv_777 vpwr vpwr.n173 0.34913618549846431
rmesh_equiv_778 vpwr vpwr.n174 12.8005
rmesh_equiv_779 vpwr vpwr.n175 12.8005
rmesh_equiv_78 oscillator__p1 oscillator__p1.n0 33.414000000000001
rmesh_equiv_780 vpwr vpwr.n178 12.8005
rmesh_equiv_781 vpwr vpwr.n209 12.8005
rmesh_equiv_782 vpwr vpwr.n210 27.736499999999999
rmesh_equiv_783 vpwr vpwr.n211 12.8005
rmesh_equiv_784 vpwr vpwr.n212 12.8005
rmesh_equiv_785 vpwr vpwr.n215 12.8005
rmesh_equiv_786 vpwr vpwr.n246 12.8005
rmesh_equiv_787 vpwr vpwr.n247 27.736499999999999
rmesh_equiv_788 vpwr vpwr.n248 12.8005
rmesh_equiv_789 vpwr vpwr.n249 12.8005
rmesh_equiv_79 oscillator__p1 oscillator__p1.n1 17.948799999999999
rmesh_equiv_790 vpwr vpwr.n252 12.8005
rmesh_equiv_791 vpwr vpwr.n283 12.8005
rmesh_equiv_792 vpwr vpwr.n284 27.736499999999999
rmesh_equiv_793 vpwr vpwr.n285 12.8005
rmesh_equiv_794 vpwr vpwr.n286 12.8005
rmesh_equiv_795 vpwr vpwr.n289 12.8005
rmesh_equiv_796 vpwr vpwr.n320 12.8005
rmesh_equiv_797 vpwr vpwr.n321 27.736499999999999
rmesh_equiv_798 vpwr vpwr.n322 12.8005
rmesh_equiv_799 vpwr vpwr.n323 12.8005
rmesh_equiv_8 ctrl ctrl.t3 0.00141837
rmesh_equiv_80 oscillator__p1 oscillator__p1.n3 20.2395
rmesh_equiv_800 vpwr vpwr.n326 12.8005
rmesh_equiv_801 vpwr vpwr.n357 12.8005
rmesh_equiv_802 vpwr vpwr.n358 27.736499999999999
rmesh_equiv_803 vpwr vpwr.n359 12.8005
rmesh_equiv_804 vpwr vpwr.n360 12.8005
rmesh_equiv_805 vpwr vpwr.n363 12.8005
rmesh_equiv_806 vpwr vpwr.n394 12.8005
rmesh_equiv_807 vpwr vpwr.n395 27.736499999999999
rmesh_equiv_808 vpwr vpwr.n396 12.8005
rmesh_equiv_809 vpwr vpwr.n397 12.8005
rmesh_equiv_81 oscillator__p1 oscillator__p1.n7 6.5282000000000009
rmesh_equiv_810 vpwr vpwr.n400 12.8005
rmesh_equiv_811 vpwr vpwr.n431 12.8005
rmesh_equiv_812 vpwr vpwr.n432 27.736499999999999
rmesh_equiv_813 vpwr vpwr.n433 12.8005
rmesh_equiv_814 vpwr vpwr.n434 12.8005
rmesh_equiv_815 vpwr vpwr.n438 25.6005
rmesh_equiv_816 vpwr vpwr.n439 185
rmesh_equiv_817 vpwr vpwr.n612 25.6005
rmesh_equiv_818 vpwr vpwr.n613 29.3598
rmesh_equiv_819 vpwr vpwr.n614 6.5282000000000009
rmesh_equiv_82 oscillator__p1.n0 oscillator__p1.n5 1.10033
rmesh_equiv_820 vpwr vpwr.n616 33.414000000000001
rmesh_equiv_821 vpwr vpwr.n619 25.6005
rmesh_equiv_822 vpwr vpwr.n620 185
rmesh_equiv_823 vpwr vpwr.n793 25.6005
rmesh_equiv_824 vpwr vpwr.n794 29.3598
rmesh_equiv_825 vpwr vpwr.n795 6.5282000000000009
rmesh_equiv_826 vpwr vpwr.n797 33.414000000000001
rmesh_equiv_827 vpwr vpwr.n800 12.8005
rmesh_equiv_828 vpwr vpwr.n940 12.8005
rmesh_equiv_829 vpwr vpwr.n941 29.012600000000003
rmesh_equiv_83 oscillator__p1.n0 oscillator__p1.n6 42.739100000000001
rmesh_equiv_830 vpwr vpwr.n942 25.6005
rmesh_equiv_831 vpwr vpwr.n943 185
rmesh_equiv_832 vpwr.n0 vpwr.n2 185
rmesh_equiv_833 vpwr.n0 vpwr.n66 83.953400000000002
rmesh_equiv_834 vpwr.n1 vpwr.n140 83.953400000000002
rmesh_equiv_835 vpwr.n1 vpwr.n3 185
rmesh_equiv_836 vpwr.n1 vpwr.n89 25.6005
rmesh_equiv_837 vpwr.n100 vpwr.n102 240.00290767186621
rmesh_equiv_838 vpwr.n100 vpwr.n4 185.00310000000002
rmesh_equiv_839 vpwr.n100 vpwr.n84 240
rmesh_equiv_84 oscillator__p1.n1 oscillator__p1.n2 48.279000000000003
rmesh_equiv_840 vpwr.n100 vpwr.n99 185
rmesh_equiv_841 vpwr.n1000 vpwr.n1001 185
rmesh_equiv_842 vpwr.n1000 vpwr.n1027 240
rmesh_equiv_843 vpwr.n1000 vpwr.n1035 240
rmesh_equiv_844 vpwr.n1000 vpwr.n999 185
rmesh_equiv_845 vpwr.n1001 vpwr.n1002 185
rmesh_equiv_846 vpwr.n1001 vpwr.n1028 131.30199999999999
rmesh_equiv_847 vpwr.n1001 vpwr.n1034 131.30199999999999
rmesh_equiv_848 vpwr.n1002 vpwr.n1029 240
rmesh_equiv_849 vpwr.n1002 vpwr.n1031 185
rmesh_equiv_85 oscillator__p1.n1 oscillator__p1.n4 2.38164
rmesh_equiv_850 vpwr.n1002 vpwr.n1033 240
rmesh_equiv_851 vpwr.n1003 vpwr.n1004 185
rmesh_equiv_852 vpwr.n1003 vpwr.n1020 25.6005
rmesh_equiv_853 vpwr.n1003 vpwr.n1030 25.6005
rmesh_equiv_854 vpwr.n1004 vpwr.n1005 185
rmesh_equiv_855 vpwr.n1004 vpwr.n1021 240
rmesh_equiv_856 vpwr.n1004 vpwr.n1029 240
rmesh_equiv_857 vpwr.n1005 vpwr.n1006 185
rmesh_equiv_858 vpwr.n1005 vpwr.n1022 131.30199999999999
rmesh_equiv_859 vpwr.n1005 vpwr.n1028 131.30199999999999
rmesh_equiv_86 oscillator__p1.n2 oscillator__p1.n3 54.441499999999998
rmesh_equiv_860 vpwr.n1006 vpwr.n1023 240
rmesh_equiv_861 vpwr.n1006 vpwr.n1025 185
rmesh_equiv_862 vpwr.n1006 vpwr.n1027 240
rmesh_equiv_863 vpwr.n1007 vpwr.n1008 185
rmesh_equiv_864 vpwr.n1007 vpwr.n1013 82.823999999999998
rmesh_equiv_865 vpwr.n1007 vpwr.n1024 25.6005
rmesh_equiv_866 vpwr.n1008 vpwr.n1009 185
rmesh_equiv_867 vpwr.n1008 vpwr.n1014 776.471
rmesh_equiv_868 vpwr.n1008 vpwr.n1023 240
rmesh_equiv_869 vpwr.n1009 vpwr.n1010 185
rmesh_equiv_87 oscillator__p1.n2 oscillator__p1.t1 3.5711299999999997
rmesh_equiv_870 vpwr.n1009 vpwr.n1016 216.26100000000002
rmesh_equiv_871 vpwr.n1009 vpwr.n1022 131.30199999999999
rmesh_equiv_872 vpwr.n1010 vpwr.n1017 776.471
rmesh_equiv_873 vpwr.n1010 vpwr.n1019 185
rmesh_equiv_874 vpwr.n1010 vpwr.n1021 240
rmesh_equiv_875 vpwr.n1011 vpwr.n1012 185
rmesh_equiv_876 vpwr.n1011 vpwr.n1013 25.6005
rmesh_equiv_877 vpwr.n1011 vpwr.n1018 25.6005
rmesh_equiv_878 vpwr.n1012 vpwr.n1014 240.00290767186621
rmesh_equiv_879 vpwr.n1012 vpwr.n1016 185.00310000000002
rmesh_equiv_88 oscillator__p1.n3 oscillator__p1.n4 0.71089000000000002
rmesh_equiv_880 vpwr.n1012 vpwr.n1017 240
rmesh_equiv_881 vpwr.n1013 vpwr.n1014 185
rmesh_equiv_882 vpwr.n1014 vpwr.n1016 185.00310000000002
rmesh_equiv_883 vpwr.n1016 vpwr.n1017 185
rmesh_equiv_884 vpwr.n1017 vpwr.n1018 185
rmesh_equiv_885 vpwr.n1018 vpwr.n1019 82.823999999999998
rmesh_equiv_886 vpwr.n1019 vpwr.n1020 25.6005
rmesh_equiv_887 vpwr.n102 vpwr.n104 240
rmesh_equiv_888 vpwr.n102 vpwr.n4 185.00310000000002
rmesh_equiv_889 vpwr.n102 vpwr.n83 185
rmesh_equiv_89 oscillator__p1.n4 oscillator__p1.n5 34.706800000000001
rmesh_equiv_890 vpwr.n1020 vpwr.n1021 185
rmesh_equiv_891 vpwr.n1021 vpwr.n1022 185
rmesh_equiv_892 vpwr.n1022 vpwr.n1023 185
rmesh_equiv_893 vpwr.n1023 vpwr.n1024 185
rmesh_equiv_894 vpwr.n1024 vpwr.n1025 25.6005
rmesh_equiv_895 vpwr.n1025 vpwr.n1026 25.6005
rmesh_equiv_896 vpwr.n1026 vpwr.n1027 185
rmesh_equiv_897 vpwr.n1026 vpwr.n999 25.6005
rmesh_equiv_898 vpwr.n1027 vpwr.n1028 185
rmesh_equiv_899 vpwr.n1028 vpwr.n1029 185
rmesh_equiv_9 ctrl ctrl.t4 0.00141837
rmesh_equiv_90 oscillator__p1.n5 oscillator__p1.n7 0.72065299999999999
rmesh_equiv_900 vpwr.n1029 vpwr.n1030 185
rmesh_equiv_901 vpwr.n1030 vpwr.n1031 25.6005
rmesh_equiv_902 vpwr.n1031 vpwr.n1032 25.6005
rmesh_equiv_903 vpwr.n1032 vpwr.n1033 185
rmesh_equiv_904 vpwr.n1032 vpwr.n995 25.6005
rmesh_equiv_905 vpwr.n1033 vpwr.n1034 185
rmesh_equiv_906 vpwr.n1033 vpwr.n996 240
rmesh_equiv_907 vpwr.n1034 vpwr.n1035 185
rmesh_equiv_908 vpwr.n1034 vpwr.n997 131.30199999999999
rmesh_equiv_909 vpwr.n1035 vpwr.n1036 185
rmesh_equiv_91 oscillator__p1.n6 oscillator__p1.n7 40.104900000000001
rmesh_equiv_910 vpwr.n1035 vpwr.n998 240
rmesh_equiv_911 vpwr.n1036 vpwr.n1037 25.6005
rmesh_equiv_912 vpwr.n1036 vpwr.n999 25.6005
rmesh_equiv_913 vpwr.n1037 vpwr.n1038 25.6005
rmesh_equiv_914 vpwr.n1037 vpwr.n998 185
rmesh_equiv_915 vpwr.n1038 vpwr.n1039 185
rmesh_equiv_916 vpwr.n1038 vpwr.n991 25.6005
rmesh_equiv_917 vpwr.n1039 vpwr.n1040 185
rmesh_equiv_918 vpwr.n1039 vpwr.n992 240
rmesh_equiv_919 vpwr.n1039 vpwr.n998 240
rmesh_equiv_92 oscillator__p1.n6 oscillator__p1.t0 2.8570000000000002
rmesh_equiv_920 vpwr.n104 vpwr.n105 185
rmesh_equiv_921 vpwr.n104 vpwr.n4 185.00310000000002
rmesh_equiv_922 vpwr.n104 vpwr.n82 240.00290767186621
rmesh_equiv_923 vpwr.n1040 vpwr.n1041 185
rmesh_equiv_924 vpwr.n1040 vpwr.n993 131.30199999999999
rmesh_equiv_925 vpwr.n1040 vpwr.n997 131.30199999999999
rmesh_equiv_926 vpwr.n1041 vpwr.n1042 185
rmesh_equiv_927 vpwr.n1041 vpwr.n994 240
rmesh_equiv_928 vpwr.n1041 vpwr.n996 240
rmesh_equiv_929 vpwr.n1042 vpwr.n1043 25.6005
rmesh_equiv_93 oscillator__p2 oscillator__p2.n0 20.2395
rmesh_equiv_930 vpwr.n1042 vpwr.n995 25.6005
rmesh_equiv_931 vpwr.n1043 vpwr.n1044 25.6005
rmesh_equiv_932 vpwr.n1043 vpwr.n994 185
rmesh_equiv_933 vpwr.n1044 vpwr.n1045 185
rmesh_equiv_934 vpwr.n1044 vpwr.n987 25.6005
rmesh_equiv_935 vpwr.n1045 vpwr.n1046 185
rmesh_equiv_936 vpwr.n1045 vpwr.n988 240
rmesh_equiv_937 vpwr.n1045 vpwr.n994 240
rmesh_equiv_938 vpwr.n1046 vpwr.n1047 185
rmesh_equiv_939 vpwr.n1046 vpwr.n989 131.30199999999999
rmesh_equiv_94 oscillator__p2 oscillator__p2.n2 7.0934900000000001
rmesh_equiv_940 vpwr.n1046 vpwr.n993 131.30199999999999
rmesh_equiv_941 vpwr.n1047 vpwr.n1048 185
rmesh_equiv_942 vpwr.n1047 vpwr.n990 240
rmesh_equiv_943 vpwr.n1047 vpwr.n992 240
rmesh_equiv_944 vpwr.n1048 vpwr.n1049 25.6005
rmesh_equiv_945 vpwr.n1048 vpwr.n991 25.6005
rmesh_equiv_946 vpwr.n1049 vpwr.n1050 25.6005
rmesh_equiv_947 vpwr.n1049 vpwr.n990 185
rmesh_equiv_948 vpwr.n105 vpwr.n106 25.6005
rmesh_equiv_949 vpwr.n105 vpwr.n83 25.6005
rmesh_equiv_95 oscillator__p2 oscillator__p2.n4 29.566400000000005
rmesh_equiv_950 vpwr.n1050 vpwr.n1051 185
rmesh_equiv_951 vpwr.n1050 vpwr.n983 25.6005
rmesh_equiv_952 vpwr.n1051 vpwr.n1052 185
rmesh_equiv_953 vpwr.n1051 vpwr.n984 240
rmesh_equiv_954 vpwr.n1051 vpwr.n990 240
rmesh_equiv_955 vpwr.n1052 vpwr.n1053 185
rmesh_equiv_956 vpwr.n1052 vpwr.n985 131.30199999999999
rmesh_equiv_957 vpwr.n1052 vpwr.n989 131.30199999999999
rmesh_equiv_958 vpwr.n1053 vpwr.n1054 185
rmesh_equiv_959 vpwr.n1053 vpwr.n986 240
rmesh_equiv_96 oscillator__p2 oscillator__p2.n7 17.948799999999999
rmesh_equiv_960 vpwr.n1053 vpwr.n988 240
rmesh_equiv_961 vpwr.n1054 vpwr.n1055 25.6005
rmesh_equiv_962 vpwr.n1054 vpwr.n987 25.6005
rmesh_equiv_963 vpwr.n1055 vpwr.n1056 25.6005
rmesh_equiv_964 vpwr.n1055 vpwr.n986 185
rmesh_equiv_965 vpwr.n1056 vpwr.n1057 185
rmesh_equiv_966 vpwr.n1056 vpwr.n979 25.6005
rmesh_equiv_967 vpwr.n1057 vpwr.n1058 185
rmesh_equiv_968 vpwr.n1057 vpwr.n980 240
rmesh_equiv_969 vpwr.n1057 vpwr.n986 240
rmesh_equiv_97 oscillator__p2.n0 oscillator__p2.n1 54.441499999999998
rmesh_equiv_970 vpwr.n1058 vpwr.n1059 185
rmesh_equiv_971 vpwr.n1058 vpwr.n981 131.30199999999999
rmesh_equiv_972 vpwr.n1058 vpwr.n985 131.30199999999999
rmesh_equiv_973 vpwr.n1059 vpwr.n1060 185
rmesh_equiv_974 vpwr.n1059 vpwr.n982 240
rmesh_equiv_975 vpwr.n1059 vpwr.n984 240
rmesh_equiv_976 vpwr.n106 vpwr.n107 25.6005
rmesh_equiv_977 vpwr.n106 vpwr.n82 185
rmesh_equiv_978 vpwr.n1060 vpwr.n1061 25.6005
rmesh_equiv_979 vpwr.n1060 vpwr.n983 25.6005
rmesh_equiv_98 oscillator__p2.n0 oscillator__p2.n6 0.71089000000000002
rmesh_equiv_980 vpwr.n1061 vpwr.n1062 25.6005
rmesh_equiv_981 vpwr.n1061 vpwr.n982 185
rmesh_equiv_982 vpwr.n1062 vpwr.n1063 185
rmesh_equiv_983 vpwr.n1062 vpwr.n975 25.6005
rmesh_equiv_984 vpwr.n1063 vpwr.n1064 185
rmesh_equiv_985 vpwr.n1063 vpwr.n976 240
rmesh_equiv_986 vpwr.n1063 vpwr.n982 240
rmesh_equiv_987 vpwr.n1064 vpwr.n1065 185
rmesh_equiv_988 vpwr.n1064 vpwr.n981 131.30199999999999
rmesh_equiv_989 vpwr.n1064 vpwr.t6 65.650899999999993
rmesh_equiv_99 oscillator__p2.n1 oscillator__p2.n7 48.2789
rmesh_equiv_990 vpwr.n1065 vpwr.n1066 185
rmesh_equiv_991 vpwr.n1065 vpwr.n978 240
rmesh_equiv_992 vpwr.n1065 vpwr.n980 240
rmesh_equiv_993 vpwr.n1066 vpwr.n1067 25.6005
rmesh_equiv_994 vpwr.n1066 vpwr.n979 25.6005
rmesh_equiv_995 vpwr.n1067 vpwr.n1068 25.6005
rmesh_equiv_996 vpwr.n1067 vpwr.n978 185
rmesh_equiv_997 vpwr.n1068 vpwr.n1069 185
rmesh_equiv_998 vpwr.n1068 vpwr.n971 25.6005
rmesh_equiv_999 vpwr.n1069 vpwr.n1070 185
.ends

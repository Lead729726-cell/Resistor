.subckt chip_pll REF CTRL OUT VPWR VGND
XC_FILTER_P0 CTRL VGND sky130_fd_pr__cap_mim_m3_1 w=28.68 l=28.68
XC_FILTER_P1 CTRL VGND sky130_fd_pr__cap_mim_m3_1 w=28.68 l=28.68
XC_FILTER_P2 CTRL VGND sky130_fd_pr__cap_mim_m3_1 w=28.68 l=28.68
XC_FILTER_P3 CTRL VGND sky130_fd_pr__cap_mim_m3_1 w=28.68 l=28.68
XC_FILTER_P4 CTRL VGND sky130_fd_pr__cap_mim_m3_1 w=28.68 l=28.68
XC_FILTER_P5 CTRL VGND sky130_fd_pr__cap_mim_m3_1 w=28.68 l=28.68
XOSCILLATOR_C_STAGE0_P0 OSCILLATOR__Q0 VGND sky130_fd_pr__cap_mim_m3_1 w=15.625 l=15.625
XOSCILLATOR_C_STAGE1_P0 OSCILLATOR__Q1 VGND sky130_fd_pr__cap_mim_m3_1 w=15.625 l=15.625
XOSCILLATOR_C_STAGE2_P0 OUT VGND sky130_fd_pr__cap_mim_m3_1 w=15.625 l=15.625
XOSCILLATOR_N_BIAS register_cf_node_611a7adabea56164 TUNE register_cf_node_611a7adabea56164_source VGND sky130_fd_pr__nfet_01v8 w=5 l=0.5 nf=1 m=1
Vregister_cf_611a7adabea56164 OSCILLATOR__PBIAS register_cf_node_611a7adabea56164 0
Vregister_cf_611a7adabea56164_source VGND register_cf_node_611a7adabea56164_source 0
XOSCILLATOR_N_INV0 register_cf_node_187c69a86515739c OUT register_cf_node_187c69a86515739c_source VGND sky130_fd_pr__nfet_01v8 w=4 l=0.15 nf=1 m=1
Vregister_cf_187c69a86515739c OSCILLATOR__Q0 register_cf_node_187c69a86515739c 0
Vregister_cf_187c69a86515739c_source OSCILLATOR__N0 register_cf_node_187c69a86515739c_source 0
XOSCILLATOR_N_INV1 register_cf_node_a41d16a1047ed44c OSCILLATOR__Q0 register_cf_node_a41d16a1047ed44c_source VGND sky130_fd_pr__nfet_01v8 w=4 l=0.15 nf=1 m=1
Vregister_cf_a41d16a1047ed44c OSCILLATOR__Q1 register_cf_node_a41d16a1047ed44c 0
Vregister_cf_a41d16a1047ed44c_source OSCILLATOR__N1 register_cf_node_a41d16a1047ed44c_source 0
XOSCILLATOR_N_INV2 register_cf_node_a5809a940a210ff5 OSCILLATOR__Q1 register_cf_node_a5809a940a210ff5_source VGND sky130_fd_pr__nfet_01v8 w=4 l=0.15 nf=1 m=1
Vregister_cf_a5809a940a210ff5 OUT register_cf_node_a5809a940a210ff5 0
Vregister_cf_a5809a940a210ff5_source OSCILLATOR__N2 register_cf_node_a5809a940a210ff5_source 0
XOSCILLATOR_N_LIMIT0 register_cf_node_99ed6bf5d6c7bade TUNE register_cf_node_99ed6bf5d6c7bade_source VGND sky130_fd_pr__nfet_01v8 w=5 l=0.5 nf=1 m=1
Vregister_cf_99ed6bf5d6c7bade OSCILLATOR__N0 register_cf_node_99ed6bf5d6c7bade 0
Vregister_cf_99ed6bf5d6c7bade_source VGND register_cf_node_99ed6bf5d6c7bade_source 0
XOSCILLATOR_N_LIMIT1 register_cf_node_ab654e91d81305b5 TUNE register_cf_node_ab654e91d81305b5_source VGND sky130_fd_pr__nfet_01v8 w=5 l=0.5 nf=1 m=1
Vregister_cf_ab654e91d81305b5 OSCILLATOR__N1 register_cf_node_ab654e91d81305b5 0
Vregister_cf_ab654e91d81305b5_source VGND register_cf_node_ab654e91d81305b5_source 0
XOSCILLATOR_N_LIMIT2 register_cf_node_d6fb0d00764270e1 TUNE register_cf_node_d6fb0d00764270e1_source VGND sky130_fd_pr__nfet_01v8 w=5 l=0.5 nf=1 m=1
Vregister_cf_d6fb0d00764270e1 OSCILLATOR__N2 register_cf_node_d6fb0d00764270e1 0
Vregister_cf_d6fb0d00764270e1_source VGND register_cf_node_d6fb0d00764270e1_source 0
XOSCILLATOR_P_BIAS register_cf_node_2c754be20e9e1083 OSCILLATOR__PBIAS register_cf_node_2c754be20e9e1083_source VPWR sky130_fd_pr__pfet_01v8_hvt w=10 l=0.5 nf=1 m=1
Vregister_cf_2c754be20e9e1083 OSCILLATOR__PBIAS register_cf_node_2c754be20e9e1083 0
Vregister_cf_2c754be20e9e1083_source VPWR register_cf_node_2c754be20e9e1083_source 0
XOSCILLATOR_P_INV0 register_cf_node_1a3836b0030729ef OUT register_cf_node_1a3836b0030729ef_source VPWR sky130_fd_pr__pfet_01v8_hvt w=8 l=0.15 nf=1 m=1
Vregister_cf_1a3836b0030729ef OSCILLATOR__Q0 register_cf_node_1a3836b0030729ef 0
Vregister_cf_1a3836b0030729ef_source OSCILLATOR__P0 register_cf_node_1a3836b0030729ef_source 0
XOSCILLATOR_P_INV1 register_cf_node_99467f97a98d1e39 OSCILLATOR__Q0 register_cf_node_99467f97a98d1e39_source VPWR sky130_fd_pr__pfet_01v8_hvt w=8 l=0.15 nf=1 m=1
Vregister_cf_99467f97a98d1e39 OSCILLATOR__Q1 register_cf_node_99467f97a98d1e39 0
Vregister_cf_99467f97a98d1e39_source OSCILLATOR__P1 register_cf_node_99467f97a98d1e39_source 0
XOSCILLATOR_P_INV2 register_cf_node_0fbff0300d425579 OSCILLATOR__Q1 register_cf_node_0fbff0300d425579_source VPWR sky130_fd_pr__pfet_01v8_hvt w=8 l=0.15 nf=1 m=1
Vregister_cf_0fbff0300d425579 OUT register_cf_node_0fbff0300d425579 0
Vregister_cf_0fbff0300d425579_source OSCILLATOR__P2 register_cf_node_0fbff0300d425579_source 0
XOSCILLATOR_P_LIMIT0 register_cf_node_5860662fe1480ac2 OSCILLATOR__PBIAS register_cf_node_5860662fe1480ac2_source VPWR sky130_fd_pr__pfet_01v8_hvt w=10 l=0.5 nf=1 m=1
Vregister_cf_5860662fe1480ac2 OSCILLATOR__P0 register_cf_node_5860662fe1480ac2 0
Vregister_cf_5860662fe1480ac2_source VPWR register_cf_node_5860662fe1480ac2_source 0
XOSCILLATOR_P_LIMIT1 register_cf_node_b69ae517540b2da5 OSCILLATOR__PBIAS register_cf_node_b69ae517540b2da5_source VPWR sky130_fd_pr__pfet_01v8_hvt w=10 l=0.5 nf=1 m=1
Vregister_cf_b69ae517540b2da5 OSCILLATOR__P1 register_cf_node_b69ae517540b2da5 0
Vregister_cf_b69ae517540b2da5_source VPWR register_cf_node_b69ae517540b2da5_source 0
XOSCILLATOR_P_LIMIT2 register_cf_node_2b04b12e7e7fb88e OSCILLATOR__PBIAS register_cf_node_2b04b12e7e7fb88e_source VPWR sky130_fd_pr__pfet_01v8_hvt w=10 l=0.5 nf=1 m=1
Vregister_cf_2b04b12e7e7fb88e OSCILLATOR__P2 register_cf_node_2b04b12e7e7fb88e 0
Vregister_cf_2b04b12e7e7fb88e_source VPWR register_cf_node_2b04b12e7e7fb88e_source 0
XPHASE_DETECTOR_N1_MN0 register_cf_node_26863b5b6a00a9b8 REF register_cf_node_26863b5b6a00a9b8_source VGND sky130_fd_pr__nfet_01v8 w=0.65 l=0.15 nf=1 m=1
Vregister_cf_26863b5b6a00a9b8 PHASE_DETECTOR__N1 register_cf_node_26863b5b6a00a9b8 0
Vregister_cf_26863b5b6a00a9b8_source PHASE_DETECTOR__N1__N1 register_cf_node_26863b5b6a00a9b8_source 0
XPHASE_DETECTOR_N1_MN1 register_cf_node_bf95df23174799b1 OUT register_cf_node_bf95df23174799b1_source VGND sky130_fd_pr__nfet_01v8 w=0.65 l=0.15 nf=1 m=1
Vregister_cf_bf95df23174799b1 PHASE_DETECTOR__N1__N1 register_cf_node_bf95df23174799b1 0
Vregister_cf_bf95df23174799b1_source VGND register_cf_node_bf95df23174799b1_source 0
XPHASE_DETECTOR_N1_MP0 register_cf_node_59c5e519cc6ea3dc REF register_cf_node_59c5e519cc6ea3dc_source VPWR sky130_fd_pr__pfet_01v8_hvt w=0.65 l=0.15 nf=1 m=1
Vregister_cf_59c5e519cc6ea3dc PHASE_DETECTOR__N1 register_cf_node_59c5e519cc6ea3dc 0
Vregister_cf_59c5e519cc6ea3dc_source VPWR register_cf_node_59c5e519cc6ea3dc_source 0
XPHASE_DETECTOR_N1_MP1 register_cf_node_8ad12ec1b4273416 OUT register_cf_node_8ad12ec1b4273416_source VPWR sky130_fd_pr__pfet_01v8_hvt w=0.65 l=0.15 nf=1 m=1
Vregister_cf_8ad12ec1b4273416 PHASE_DETECTOR__N1 register_cf_node_8ad12ec1b4273416 0
Vregister_cf_8ad12ec1b4273416_source VPWR register_cf_node_8ad12ec1b4273416_source 0
XPHASE_DETECTOR_N2_MN0 register_cf_node_0cf3ac7f9ba937db REF register_cf_node_0cf3ac7f9ba937db_source VGND sky130_fd_pr__nfet_01v8 w=0.65 l=0.15 nf=1 m=1
Vregister_cf_0cf3ac7f9ba937db PHASE_DETECTOR__N2 register_cf_node_0cf3ac7f9ba937db 0
Vregister_cf_0cf3ac7f9ba937db_source PHASE_DETECTOR__N2__N1 register_cf_node_0cf3ac7f9ba937db_source 0
XPHASE_DETECTOR_N2_MN1 register_cf_node_c7ee7188f4699fd8 PHASE_DETECTOR__N1 register_cf_node_c7ee7188f4699fd8_source VGND sky130_fd_pr__nfet_01v8 w=0.65 l=0.15 nf=1 m=1
Vregister_cf_c7ee7188f4699fd8 PHASE_DETECTOR__N2__N1 register_cf_node_c7ee7188f4699fd8 0
Vregister_cf_c7ee7188f4699fd8_source VGND register_cf_node_c7ee7188f4699fd8_source 0
XPHASE_DETECTOR_N2_MP0 register_cf_node_6d8948e956e490f2 REF register_cf_node_6d8948e956e490f2_source VPWR sky130_fd_pr__pfet_01v8_hvt w=0.65 l=0.15 nf=1 m=1
Vregister_cf_6d8948e956e490f2 PHASE_DETECTOR__N2 register_cf_node_6d8948e956e490f2 0
Vregister_cf_6d8948e956e490f2_source VPWR register_cf_node_6d8948e956e490f2_source 0
XPHASE_DETECTOR_N2_MP1 register_cf_node_992318c7d2516a90 PHASE_DETECTOR__N1 register_cf_node_992318c7d2516a90_source VPWR sky130_fd_pr__pfet_01v8_hvt w=0.65 l=0.15 nf=1 m=1
Vregister_cf_992318c7d2516a90 PHASE_DETECTOR__N2 register_cf_node_992318c7d2516a90 0
Vregister_cf_992318c7d2516a90_source VPWR register_cf_node_992318c7d2516a90_source 0
XPHASE_DETECTOR_N3_MN0 register_cf_node_66628a149eec7f39 OUT register_cf_node_66628a149eec7f39_source VGND sky130_fd_pr__nfet_01v8 w=0.65 l=0.15 nf=1 m=1
Vregister_cf_66628a149eec7f39 PHASE_DETECTOR__N3 register_cf_node_66628a149eec7f39 0
Vregister_cf_66628a149eec7f39_source PHASE_DETECTOR__N3__N1 register_cf_node_66628a149eec7f39_source 0
XPHASE_DETECTOR_N3_MN1 register_cf_node_72eb237a9c70e0c8 PHASE_DETECTOR__N1 register_cf_node_72eb237a9c70e0c8_source VGND sky130_fd_pr__nfet_01v8 w=0.65 l=0.15 nf=1 m=1
Vregister_cf_72eb237a9c70e0c8 PHASE_DETECTOR__N3__N1 register_cf_node_72eb237a9c70e0c8 0
Vregister_cf_72eb237a9c70e0c8_source VGND register_cf_node_72eb237a9c70e0c8_source 0
XPHASE_DETECTOR_N3_MP0 register_cf_node_b6faa3d82ecafa3c OUT register_cf_node_b6faa3d82ecafa3c_source VPWR sky130_fd_pr__pfet_01v8_hvt w=0.65 l=0.15 nf=1 m=1
Vregister_cf_b6faa3d82ecafa3c PHASE_DETECTOR__N3 register_cf_node_b6faa3d82ecafa3c 0
Vregister_cf_b6faa3d82ecafa3c_source VPWR register_cf_node_b6faa3d82ecafa3c_source 0
XPHASE_DETECTOR_N3_MP1 register_cf_node_f1573a7f38d30d90 PHASE_DETECTOR__N1 register_cf_node_f1573a7f38d30d90_source VPWR sky130_fd_pr__pfet_01v8_hvt w=0.65 l=0.15 nf=1 m=1
Vregister_cf_f1573a7f38d30d90 PHASE_DETECTOR__N3 register_cf_node_f1573a7f38d30d90 0
Vregister_cf_f1573a7f38d30d90_source VPWR register_cf_node_f1573a7f38d30d90_source 0
XPHASE_DETECTOR_N4_MN0 register_cf_node_e0da7734c409f930 PHASE_DETECTOR__N2 register_cf_node_e0da7734c409f930_source VGND sky130_fd_pr__nfet_01v8 w=0.65 l=0.15 nf=1 m=1
Vregister_cf_e0da7734c409f930 PD register_cf_node_e0da7734c409f930 0
Vregister_cf_e0da7734c409f930_source PHASE_DETECTOR__N4__N1 register_cf_node_e0da7734c409f930_source 0
XPHASE_DETECTOR_N4_MN1 register_cf_node_c9be47f7b2f94d83 PHASE_DETECTOR__N3 register_cf_node_c9be47f7b2f94d83_source VGND sky130_fd_pr__nfet_01v8 w=0.65 l=0.15 nf=1 m=1
Vregister_cf_c9be47f7b2f94d83 PHASE_DETECTOR__N4__N1 register_cf_node_c9be47f7b2f94d83 0
Vregister_cf_c9be47f7b2f94d83_source VGND register_cf_node_c9be47f7b2f94d83_source 0
XPHASE_DETECTOR_N4_MP0 register_cf_node_d6673d65708192b0 PHASE_DETECTOR__N2 register_cf_node_d6673d65708192b0_source VPWR sky130_fd_pr__pfet_01v8_hvt w=0.65 l=0.15 nf=1 m=1
Vregister_cf_d6673d65708192b0 PD register_cf_node_d6673d65708192b0 0
Vregister_cf_d6673d65708192b0_source VPWR register_cf_node_d6673d65708192b0_source 0
XPHASE_DETECTOR_N4_MP1 register_cf_node_4ed801369ef5996c PHASE_DETECTOR__N3 register_cf_node_4ed801369ef5996c_source VPWR sky130_fd_pr__pfet_01v8_hvt w=0.65 l=0.15 nf=1 m=1
Vregister_cf_4ed801369ef5996c PD register_cf_node_4ed801369ef5996c 0
Vregister_cf_4ed801369ef5996c_source VPWR register_cf_node_4ed801369ef5996c_source 0
XR_BIAS_BOTTOM_P0 TUNE R_BIAS_BOTTOM_R0_N0 VGND sky130_fd_pr__res_xhigh_po_1p41 l=23.335
XR_BIAS_BOTTOM_P1 R_BIAS_BOTTOM_R0_N0 R_BIAS_BOTTOM_R0_N1 VGND sky130_fd_pr__res_xhigh_po_1p41 l=23.335
XR_BIAS_BOTTOM_P2 R_BIAS_BOTTOM_R0_N1 VGND VGND sky130_fd_pr__res_xhigh_po_1p41 l=23.335
XR_BIAS_TOP_P0 VPWR R_BIAS_TOP_R0_N0 VGND sky130_fd_pr__res_xhigh_po_1p41 l=23.335
XR_BIAS_TOP_P1 R_BIAS_TOP_R0_N0 R_BIAS_TOP_R0_N1 VGND sky130_fd_pr__res_xhigh_po_1p41 l=23.335
XR_BIAS_TOP_P2 R_BIAS_TOP_R0_N1 TUNE VGND sky130_fd_pr__res_xhigh_po_1p41 l=23.335
XR_FILTER_P0 PD CTRL VGND sky130_fd_pr__res_xhigh_po_1p41 l=13.935
XR_TUNE_P0 CTRL R_TUNE_R0_N0 VGND sky130_fd_pr__res_xhigh_po_1p41 l=29.21
XR_TUNE_P1 R_TUNE_R0_N0 R_TUNE_R0_N1 VGND sky130_fd_pr__res_xhigh_po_1p41 l=29.21
XR_TUNE_P10 R_TUNE_R0_N9 R_TUNE_R0_N10 VGND sky130_fd_pr__res_xhigh_po_1p41 l=29.21
XR_TUNE_P11 R_TUNE_R0_N10 R_TUNE_R0_N11 VGND sky130_fd_pr__res_xhigh_po_1p41 l=29.21
XR_TUNE_P12 R_TUNE_R0_N11 R_TUNE_R0_N12 VGND sky130_fd_pr__res_xhigh_po_1p41 l=29.21
XR_TUNE_P13 R_TUNE_R0_N12 R_TUNE_R0_N13 VGND sky130_fd_pr__res_xhigh_po_1p41 l=29.21
XR_TUNE_P14 R_TUNE_R0_N13 R_TUNE_R0_N14 VGND sky130_fd_pr__res_xhigh_po_1p41 l=29.21
XR_TUNE_P15 R_TUNE_R0_N14 R_TUNE_R0_N15 VGND sky130_fd_pr__res_xhigh_po_1p41 l=29.21
XR_TUNE_P16 R_TUNE_R0_N15 R_TUNE_R0_N16 VGND sky130_fd_pr__res_xhigh_po_1p41 l=29.21
XR_TUNE_P17 R_TUNE_R0_N16 R_TUNE_R0_N17 VGND sky130_fd_pr__res_xhigh_po_1p41 l=29.21
XR_TUNE_P18 R_TUNE_R0_N17 R_TUNE_R0_N18 VGND sky130_fd_pr__res_xhigh_po_1p41 l=29.21
XR_TUNE_P19 R_TUNE_R0_N18 R_TUNE_R0_N19 VGND sky130_fd_pr__res_xhigh_po_1p41 l=29.21
XR_TUNE_P2 R_TUNE_R0_N1 R_TUNE_R0_N2 VGND sky130_fd_pr__res_xhigh_po_1p41 l=29.21
XR_TUNE_P20 R_TUNE_R0_N19 R_TUNE_R0_N20 VGND sky130_fd_pr__res_xhigh_po_1p41 l=29.21
XR_TUNE_P21 R_TUNE_R0_N20 R_TUNE_R0_N21 VGND sky130_fd_pr__res_xhigh_po_1p41 l=29.21
XR_TUNE_P22 R_TUNE_R0_N21 R_TUNE_R0_N22 VGND sky130_fd_pr__res_xhigh_po_1p41 l=29.21
XR_TUNE_P23 R_TUNE_R0_N22 TUNE VGND sky130_fd_pr__res_xhigh_po_1p41 l=29.21
XR_TUNE_P3 R_TUNE_R0_N2 R_TUNE_R0_N3 VGND sky130_fd_pr__res_xhigh_po_1p41 l=29.21
XR_TUNE_P4 R_TUNE_R0_N3 R_TUNE_R0_N4 VGND sky130_fd_pr__res_xhigh_po_1p41 l=29.21
XR_TUNE_P5 R_TUNE_R0_N4 R_TUNE_R0_N5 VGND sky130_fd_pr__res_xhigh_po_1p41 l=29.21
XR_TUNE_P6 R_TUNE_R0_N5 R_TUNE_R0_N6 VGND sky130_fd_pr__res_xhigh_po_1p41 l=29.21
XR_TUNE_P7 R_TUNE_R0_N6 R_TUNE_R0_N7 VGND sky130_fd_pr__res_xhigh_po_1p41 l=29.21
XR_TUNE_P8 R_TUNE_R0_N7 R_TUNE_R0_N8 VGND sky130_fd_pr__res_xhigh_po_1p41 l=29.21
XR_TUNE_P9 R_TUNE_R0_N8 R_TUNE_R0_N9 VGND sky130_fd_pr__res_xhigh_po_1p41 l=29.21
.ends chip_pll

.subckt chip_pll REF CTRL OUT VPWR VGND
XC_FILTER_P0 CTRL VGND sky130_fd_pr__cap_mim_m3_1 w=28.68 l=28.68
XC_FILTER_P1 CTRL VGND sky130_fd_pr__cap_mim_m3_1 w=28.68 l=28.68
XC_FILTER_P2 CTRL VGND sky130_fd_pr__cap_mim_m3_1 w=28.68 l=28.68
XC_FILTER_P3 CTRL VGND sky130_fd_pr__cap_mim_m3_1 w=28.68 l=28.68
XC_FILTER_P4 CTRL VGND sky130_fd_pr__cap_mim_m3_1 w=28.68 l=28.68
XC_FILTER_P5 CTRL VGND sky130_fd_pr__cap_mim_m3_1 w=28.68 l=28.68
XOSCILLATOR_C_STAGE0_P0 OSCILLATOR__Q0 VGND sky130_fd_pr__cap_mim_m3_1 w=15.625 l=15.625
XOSCILLATOR_C_STAGE1_P0 OSCILLATOR__Q1 VGND sky130_fd_pr__cap_mim_m3_1 w=15.625 l=15.625
XOSCILLATOR_C_STAGE2_P0 OUT VGND sky130_fd_pr__cap_mim_m3_1 w=15.625 l=15.625
XOSCILLATOR_N_BIAS OSCILLATOR__PBIAS TUNE VGND VGND sky130_fd_pr__nfet_01v8 w=5 l=0.5 nf=1 m=1
XOSCILLATOR_N_INV0 OSCILLATOR__Q0 OUT OSCILLATOR__N0 VGND sky130_fd_pr__nfet_01v8 w=4 l=0.15 nf=1 m=1
XOSCILLATOR_N_INV1 OSCILLATOR__Q1 OSCILLATOR__Q0 OSCILLATOR__N1 VGND sky130_fd_pr__nfet_01v8 w=4 l=0.15 nf=1 m=1
XOSCILLATOR_N_INV2 OUT OSCILLATOR__Q1 OSCILLATOR__N2 VGND sky130_fd_pr__nfet_01v8 w=4 l=0.15 nf=1 m=1
XOSCILLATOR_N_LIMIT0 OSCILLATOR__N0 TUNE VGND VGND sky130_fd_pr__nfet_01v8 w=5 l=0.5 nf=1 m=1
XOSCILLATOR_N_LIMIT1 OSCILLATOR__N1 TUNE VGND VGND sky130_fd_pr__nfet_01v8 w=5 l=0.5 nf=1 m=1
XOSCILLATOR_N_LIMIT2 OSCILLATOR__N2 TUNE VGND VGND sky130_fd_pr__nfet_01v8 w=5 l=0.5 nf=1 m=1
XOSCILLATOR_P_BIAS OSCILLATOR__PBIAS OSCILLATOR__PBIAS VPWR VPWR sky130_fd_pr__pfet_01v8_hvt w=10 l=0.5 nf=1 m=1
XOSCILLATOR_P_INV0 OSCILLATOR__Q0 OUT OSCILLATOR__P0 VPWR sky130_fd_pr__pfet_01v8_hvt w=8 l=0.15 nf=1 m=1
XOSCILLATOR_P_INV1 OSCILLATOR__Q1 OSCILLATOR__Q0 OSCILLATOR__P1 VPWR sky130_fd_pr__pfet_01v8_hvt w=8 l=0.15 nf=1 m=1
XOSCILLATOR_P_INV2 OUT OSCILLATOR__Q1 OSCILLATOR__P2 VPWR sky130_fd_pr__pfet_01v8_hvt w=8 l=0.15 nf=1 m=1
XOSCILLATOR_P_LIMIT0 OSCILLATOR__P0 OSCILLATOR__PBIAS VPWR VPWR sky130_fd_pr__pfet_01v8_hvt w=10 l=0.5 nf=1 m=1
XOSCILLATOR_P_LIMIT1 OSCILLATOR__P1 OSCILLATOR__PBIAS VPWR VPWR sky130_fd_pr__pfet_01v8_hvt w=10 l=0.5 nf=1 m=1
XOSCILLATOR_P_LIMIT2 OSCILLATOR__P2 OSCILLATOR__PBIAS VPWR VPWR sky130_fd_pr__pfet_01v8_hvt w=10 l=0.5 nf=1 m=1
XPHASE_DETECTOR_N1_MN0 PHASE_DETECTOR__N1 REF PHASE_DETECTOR__N1__N1 VGND sky130_fd_pr__nfet_01v8 w=0.65 l=0.15 nf=1 m=1
XPHASE_DETECTOR_N1_MN1 PHASE_DETECTOR__N1__N1 OUT VGND VGND sky130_fd_pr__nfet_01v8 w=0.65 l=0.15 nf=1 m=1
XPHASE_DETECTOR_N1_MP0 PHASE_DETECTOR__N1 REF VPWR VPWR sky130_fd_pr__pfet_01v8_hvt w=0.65 l=0.15 nf=1 m=1
XPHASE_DETECTOR_N1_MP1 PHASE_DETECTOR__N1 OUT VPWR VPWR sky130_fd_pr__pfet_01v8_hvt w=0.65 l=0.15 nf=1 m=1
XPHASE_DETECTOR_N2_MN0 PHASE_DETECTOR__N2 REF PHASE_DETECTOR__N2__N1 VGND sky130_fd_pr__nfet_01v8 w=0.65 l=0.15 nf=1 m=1
XPHASE_DETECTOR_N2_MN1 PHASE_DETECTOR__N2__N1 PHASE_DETECTOR__N1 VGND VGND sky130_fd_pr__nfet_01v8 w=0.65 l=0.15 nf=1 m=1
XPHASE_DETECTOR_N2_MP0 PHASE_DETECTOR__N2 REF VPWR VPWR sky130_fd_pr__pfet_01v8_hvt w=0.65 l=0.15 nf=1 m=1
XPHASE_DETECTOR_N2_MP1 PHASE_DETECTOR__N2 PHASE_DETECTOR__N1 VPWR VPWR sky130_fd_pr__pfet_01v8_hvt w=0.65 l=0.15 nf=1 m=1
XPHASE_DETECTOR_N3_MN0 PHASE_DETECTOR__N3 OUT PHASE_DETECTOR__N3__N1 VGND sky130_fd_pr__nfet_01v8 w=0.65 l=0.15 nf=1 m=1
XPHASE_DETECTOR_N3_MN1 PHASE_DETECTOR__N3__N1 PHASE_DETECTOR__N1 VGND VGND sky130_fd_pr__nfet_01v8 w=0.65 l=0.15 nf=1 m=1
XPHASE_DETECTOR_N3_MP0 PHASE_DETECTOR__N3 OUT VPWR VPWR sky130_fd_pr__pfet_01v8_hvt w=0.65 l=0.15 nf=1 m=1
XPHASE_DETECTOR_N3_MP1 PHASE_DETECTOR__N3 PHASE_DETECTOR__N1 VPWR VPWR sky130_fd_pr__pfet_01v8_hvt w=0.65 l=0.15 nf=1 m=1
XPHASE_DETECTOR_N4_MN0 PD PHASE_DETECTOR__N2 PHASE_DETECTOR__N4__N1 VGND sky130_fd_pr__nfet_01v8 w=0.65 l=0.15 nf=1 m=1
XPHASE_DETECTOR_N4_MN1 PHASE_DETECTOR__N4__N1 PHASE_DETECTOR__N3 VGND VGND sky130_fd_pr__nfet_01v8 w=0.65 l=0.15 nf=1 m=1
XPHASE_DETECTOR_N4_MP0 PD PHASE_DETECTOR__N2 VPWR VPWR sky130_fd_pr__pfet_01v8_hvt w=0.65 l=0.15 nf=1 m=1
XPHASE_DETECTOR_N4_MP1 PD PHASE_DETECTOR__N3 VPWR VPWR sky130_fd_pr__pfet_01v8_hvt w=0.65 l=0.15 nf=1 m=1
XR_BIAS_BOTTOM_P0 TUNE R_BIAS_BOTTOM_R0_N0 VGND sky130_fd_pr__res_xhigh_po_1p41 l=23.335
XR_BIAS_BOTTOM_P1 R_BIAS_BOTTOM_R0_N0 R_BIAS_BOTTOM_R0_N1 VGND sky130_fd_pr__res_xhigh_po_1p41 l=23.335
XR_BIAS_BOTTOM_P2 R_BIAS_BOTTOM_R0_N1 VGND VGND sky130_fd_pr__res_xhigh_po_1p41 l=23.335
XR_BIAS_TOP_P0 VPWR R_BIAS_TOP_R0_N0 VGND sky130_fd_pr__res_xhigh_po_1p41 l=23.335
XR_BIAS_TOP_P1 R_BIAS_TOP_R0_N0 R_BIAS_TOP_R0_N1 VGND sky130_fd_pr__res_xhigh_po_1p41 l=23.335
XR_BIAS_TOP_P2 R_BIAS_TOP_R0_N1 TUNE VGND sky130_fd_pr__res_xhigh_po_1p41 l=23.335
XR_FILTER_P0 PD CTRL VGND sky130_fd_pr__res_xhigh_po_1p41 l=13.935
XR_TUNE_P0 CTRL R_TUNE_R0_N0 VGND sky130_fd_pr__res_xhigh_po_1p41 l=29.21
XR_TUNE_P1 R_TUNE_R0_N0 R_TUNE_R0_N1 VGND sky130_fd_pr__res_xhigh_po_1p41 l=29.21
XR_TUNE_P10 R_TUNE_R0_N9 R_TUNE_R0_N10 VGND sky130_fd_pr__res_xhigh_po_1p41 l=29.21
XR_TUNE_P11 R_TUNE_R0_N10 R_TUNE_R0_N11 VGND sky130_fd_pr__res_xhigh_po_1p41 l=29.21
XR_TUNE_P12 R_TUNE_R0_N11 R_TUNE_R0_N12 VGND sky130_fd_pr__res_xhigh_po_1p41 l=29.21
XR_TUNE_P13 R_TUNE_R0_N12 R_TUNE_R0_N13 VGND sky130_fd_pr__res_xhigh_po_1p41 l=29.21
XR_TUNE_P14 R_TUNE_R0_N13 R_TUNE_R0_N14 VGND sky130_fd_pr__res_xhigh_po_1p41 l=29.21
XR_TUNE_P15 R_TUNE_R0_N14 R_TUNE_R0_N15 VGND sky130_fd_pr__res_xhigh_po_1p41 l=29.21
XR_TUNE_P16 R_TUNE_R0_N15 R_TUNE_R0_N16 VGND sky130_fd_pr__res_xhigh_po_1p41 l=29.21
XR_TUNE_P17 R_TUNE_R0_N16 R_TUNE_R0_N17 VGND sky130_fd_pr__res_xhigh_po_1p41 l=29.21
XR_TUNE_P18 R_TUNE_R0_N17 R_TUNE_R0_N18 VGND sky130_fd_pr__res_xhigh_po_1p41 l=29.21
XR_TUNE_P19 R_TUNE_R0_N18 R_TUNE_R0_N19 VGND sky130_fd_pr__res_xhigh_po_1p41 l=29.21
XR_TUNE_P2 R_TUNE_R0_N1 R_TUNE_R0_N2 VGND sky130_fd_pr__res_xhigh_po_1p41 l=29.21
XR_TUNE_P20 R_TUNE_R0_N19 R_TUNE_R0_N20 VGND sky130_fd_pr__res_xhigh_po_1p41 l=29.21
XR_TUNE_P21 R_TUNE_R0_N20 R_TUNE_R0_N21 VGND sky130_fd_pr__res_xhigh_po_1p41 l=29.21
XR_TUNE_P22 R_TUNE_R0_N21 R_TUNE_R0_N22 VGND sky130_fd_pr__res_xhigh_po_1p41 l=29.21
XR_TUNE_P23 R_TUNE_R0_N22 TUNE VGND sky130_fd_pr__res_xhigh_po_1p41 l=29.21
XR_TUNE_P3 R_TUNE_R0_N2 R_TUNE_R0_N3 VGND sky130_fd_pr__res_xhigh_po_1p41 l=29.21
XR_TUNE_P4 R_TUNE_R0_N3 R_TUNE_R0_N4 VGND sky130_fd_pr__res_xhigh_po_1p41 l=29.21
XR_TUNE_P5 R_TUNE_R0_N4 R_TUNE_R0_N5 VGND sky130_fd_pr__res_xhigh_po_1p41 l=29.21
XR_TUNE_P6 R_TUNE_R0_N5 R_TUNE_R0_N6 VGND sky130_fd_pr__res_xhigh_po_1p41 l=29.21
XR_TUNE_P7 R_TUNE_R0_N6 R_TUNE_R0_N7 VGND sky130_fd_pr__res_xhigh_po_1p41 l=29.21
XR_TUNE_P8 R_TUNE_R0_N7 R_TUNE_R0_N8 VGND sky130_fd_pr__res_xhigh_po_1p41 l=29.21
XR_TUNE_P9 R_TUNE_R0_N8 R_TUNE_R0_N9 VGND sky130_fd_pr__res_xhigh_po_1p41 l=29.21
.ends chip_pll

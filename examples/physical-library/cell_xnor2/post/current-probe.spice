* NGSPICE file created from cell_xnor2.ext - technology: sky130A

.subckt cell_xnor2 VGND VPWR Y B A
X0 register_cf_node_6779f271fd7072b8 CORE__N2.t3 register_cf_node_6779f271fd7072b8_source VPWR.t0 sky130_fd_pr__pfet_01v8_hvt ad=0.1885 pd=1.88 as=0.1885 ps=1.88 w=0.65 l=0.15
Vregister_cf_6779f271fd7072b8 VPWR.t1 register_cf_node_6779f271fd7072b8 0
Vregister_cf_6779f271fd7072b8_source N.t1 register_cf_node_6779f271fd7072b8_source 0
X1 register_cf_node_6227a5df2a0c9f0e A.t0 register_cf_node_6227a5df2a0c9f0e_source VGND.t4 sky130_fd_pr__nfet_01v8 ad=0.1885 pd=1.88 as=0.1885 ps=1.88 w=0.65 l=0.15
Vregister_cf_6227a5df2a0c9f0e CORE__N2__N1.t1 register_cf_node_6227a5df2a0c9f0e 0
Vregister_cf_6227a5df2a0c9f0e_source CORE__N2.t0 register_cf_node_6227a5df2a0c9f0e_source 0
X2 register_cf_node_9b67a9b567806368 CORE__N1.t3 register_cf_node_9b67a9b567806368_source VPWR.t2 sky130_fd_pr__pfet_01v8_hvt ad=0.1885 pd=1.88 as=0.1885 ps=1.88 w=0.65 l=0.15
Vregister_cf_9b67a9b567806368 VPWR.t3 register_cf_node_9b67a9b567806368 0
Vregister_cf_9b67a9b567806368_source CORE__N3.t0 register_cf_node_9b67a9b567806368_source 0
X3 register_cf_node_6ea5b723c39d0e7a B.t0 register_cf_node_6ea5b723c39d0e7a_source VPWR.t16 sky130_fd_pr__pfet_01v8_hvt ad=0.1885 pd=1.88 as=0.1885 ps=1.88 w=0.65 l=0.15
Vregister_cf_6ea5b723c39d0e7a VPWR.t17 register_cf_node_6ea5b723c39d0e7a 0
Vregister_cf_6ea5b723c39d0e7a_source CORE__N3.t2 register_cf_node_6ea5b723c39d0e7a_source 0
X4 register_cf_node_287390746a5ce89e N.t3 register_cf_node_287390746a5ce89e_source VGND.t7 sky130_fd_pr__nfet_01v8 ad=0.1885 pd=1.88 as=0.1885 ps=1.88 w=0.65 l=0.15
Vregister_cf_287390746a5ce89e VGND.t8 register_cf_node_287390746a5ce89e 0
Vregister_cf_287390746a5ce89e_source Y.t1 register_cf_node_287390746a5ce89e_source 0
X5 register_cf_node_b86504c57a67f3d9 B.t1 register_cf_node_b86504c57a67f3d9_source VGND.t11 sky130_fd_pr__nfet_01v8 ad=0.1885 pd=1.88 as=0.1885 ps=1.88 w=0.65 l=0.15
Vregister_cf_b86504c57a67f3d9 VGND.t12 register_cf_node_b86504c57a67f3d9 0
Vregister_cf_b86504c57a67f3d9_source CORE__N1__N1.t1 register_cf_node_b86504c57a67f3d9_source 0
X6 register_cf_node_b1948cc6e2f441e7 CORE__N1.t4 register_cf_node_b1948cc6e2f441e7_source VPWR.t6 sky130_fd_pr__pfet_01v8_hvt ad=0.1885 pd=1.88 as=0.1885 ps=1.88 w=0.65 l=0.15
Vregister_cf_b1948cc6e2f441e7 VPWR.t7 register_cf_node_b1948cc6e2f441e7 0
Vregister_cf_b1948cc6e2f441e7_source CORE__N2.t1 register_cf_node_b1948cc6e2f441e7_source 0
X7 register_cf_node_0bfdfa0e618b8b36 CORE__N2.t4 register_cf_node_0bfdfa0e618b8b36_source VGND.t2 sky130_fd_pr__nfet_01v8 ad=0.1885 pd=1.88 as=0.1885 ps=1.88 w=0.65 l=0.15
Vregister_cf_0bfdfa0e618b8b36 CORE__N4__N1.t0 register_cf_node_0bfdfa0e618b8b36 0
Vregister_cf_0bfdfa0e618b8b36_source N.t0 register_cf_node_0bfdfa0e618b8b36_source 0
X8 register_cf_node_c048b0073cdbe8d0 CORE__N3.t3 register_cf_node_c048b0073cdbe8d0_source VGND.t9 sky130_fd_pr__nfet_01v8 ad=0.1885 pd=1.88 as=0.1885 ps=1.88 w=0.65 l=0.15
Vregister_cf_c048b0073cdbe8d0 VGND.t10 register_cf_node_c048b0073cdbe8d0 0
Vregister_cf_c048b0073cdbe8d0_source CORE__N4__N1.t1 register_cf_node_c048b0073cdbe8d0_source 0
X9 register_cf_node_f4651a778aa37b8f A.t1 register_cf_node_f4651a778aa37b8f_source VPWR.t4 sky130_fd_pr__pfet_01v8_hvt ad=0.1885 pd=1.88 as=0.1885 ps=1.88 w=0.65 l=0.15
Vregister_cf_f4651a778aa37b8f VPWR.t5 register_cf_node_f4651a778aa37b8f 0
Vregister_cf_f4651a778aa37b8f_source CORE__N1.t0 register_cf_node_f4651a778aa37b8f_source 0
X10 register_cf_node_0f58f9beb1aea027 A.t2 register_cf_node_0f58f9beb1aea027_source VGND.t3 sky130_fd_pr__nfet_01v8 ad=0.1885 pd=1.88 as=0.1885 ps=1.88 w=0.65 l=0.15
Vregister_cf_0f58f9beb1aea027 CORE__N1__N1.t0 register_cf_node_0f58f9beb1aea027 0
Vregister_cf_0f58f9beb1aea027_source CORE__N1.t1 register_cf_node_0f58f9beb1aea027_source 0
X11 register_cf_node_da5082e3af6f94da A.t3 register_cf_node_da5082e3af6f94da_source VPWR.t10 sky130_fd_pr__pfet_01v8_hvt ad=0.1885 pd=1.88 as=0.1885 ps=1.88 w=0.65 l=0.15
Vregister_cf_da5082e3af6f94da VPWR.t11 register_cf_node_da5082e3af6f94da 0
Vregister_cf_da5082e3af6f94da_source CORE__N2.t2 register_cf_node_da5082e3af6f94da_source 0
X12 register_cf_node_683e772207d5a49b CORE__N1.t5 register_cf_node_683e772207d5a49b_source VGND.t5 sky130_fd_pr__nfet_01v8 ad=0.1885 pd=1.88 as=0.1885 ps=1.88 w=0.65 l=0.15
Vregister_cf_683e772207d5a49b VGND.t6 register_cf_node_683e772207d5a49b 0
Vregister_cf_683e772207d5a49b_source CORE__N3__N1.t1 register_cf_node_683e772207d5a49b_source 0
X13 register_cf_node_2976951d4cc7e9ee CORE__N3.t4 register_cf_node_2976951d4cc7e9ee_source VPWR.t14 sky130_fd_pr__pfet_01v8_hvt ad=0.1885 pd=1.88 as=0.1885 ps=1.88 w=0.65 l=0.15
Vregister_cf_2976951d4cc7e9ee VPWR.t15 register_cf_node_2976951d4cc7e9ee 0
Vregister_cf_2976951d4cc7e9ee_source N.t2 register_cf_node_2976951d4cc7e9ee_source 0
X14 register_cf_node_fd0df8653d3c64de B.t2 register_cf_node_fd0df8653d3c64de_source VGND.t13 sky130_fd_pr__nfet_01v8 ad=0.1885 pd=1.88 as=0.1885 ps=1.88 w=0.65 l=0.15
Vregister_cf_fd0df8653d3c64de CORE__N3__N1.t0 register_cf_node_fd0df8653d3c64de 0
Vregister_cf_fd0df8653d3c64de_source CORE__N3.t1 register_cf_node_fd0df8653d3c64de_source 0
X15 register_cf_node_1ae6626625e43773 B.t3 register_cf_node_1ae6626625e43773_source VPWR.t12 sky130_fd_pr__pfet_01v8_hvt ad=0.1885 pd=1.88 as=0.1885 ps=1.88 w=0.65 l=0.15
Vregister_cf_1ae6626625e43773 VPWR.t13 register_cf_node_1ae6626625e43773 0
Vregister_cf_1ae6626625e43773_source CORE__N1.t2 register_cf_node_1ae6626625e43773_source 0
X16 register_cf_node_de24ee25d69c50c6 CORE__N1.t6 register_cf_node_de24ee25d69c50c6_source VGND.t0 sky130_fd_pr__nfet_01v8 ad=0.1885 pd=1.88 as=0.1885 ps=1.88 w=0.65 l=0.15
Vregister_cf_de24ee25d69c50c6 VGND.t1 register_cf_node_de24ee25d69c50c6 0
Vregister_cf_de24ee25d69c50c6_source CORE__N2__N1.t0 register_cf_node_de24ee25d69c50c6_source 0
X17 register_cf_node_9d23c38679883abc N.t4 register_cf_node_9d23c38679883abc_source VPWR.t8 sky130_fd_pr__pfet_01v8_hvt ad=0.1885 pd=1.88 as=0.1885 ps=1.88 w=0.65 l=0.15
Vregister_cf_9d23c38679883abc VPWR.t9 register_cf_node_9d23c38679883abc 0
Vregister_cf_9d23c38679883abc_source Y.t0 register_cf_node_9d23c38679883abc_source 0
C0 A CORE__N2__N1 0.57595f
C1 CORE__N1 CORE__N2 3.68821f
C2 VPWR CORE__N3 1.01761f
C3 Y VPWR 0.27182f
C4 VPWR CORE__N1__N1 0.0122f
C5 B CORE__N3 1.05596f
C6 VPWR CORE__N4__N1 0.01238f
C7 N CORE__N3 1.88954f
C8 CORE__N1 VPWR 1.36821f
C9 CORE__N3 CORE__N3__N1 0.38898f
C10 B CORE__N1__N1 0.33316f
C11 Y B 4.24891f
C12 Y N 2.69678f
C13 N CORE__N4__N1 0.40275f
C14 Y CORE__N3__N1 0.1561f
C15 CORE__N1 B 0.54043f
C16 Y A 0.00384f
C17 A CORE__N1__N1 0.65925f
C18 VPWR CORE__N2 0.94638f
C19 CORE__N1 N 0.06633f
C20 CORE__N1 CORE__N3__N1 0.42266f
C21 CORE__N1 A 0.48342f
C22 B CORE__N2 0.29973f
C23 CORE__N3 CORE__N2__N1 0.00306f
C24 N CORE__N2 0.41912f
C25 CORE__N3__N1 CORE__N2 0.91385f
C26 A CORE__N2 0.3955f
C27 Y CORE__N2__N1 0.14763f
C28 CORE__N1 CORE__N2__N1 0.40398f
C29 B VPWR 0.85648f
C30 N VPWR 0.95815f
C31 CORE__N2__N1 CORE__N2 1.30662f
C32 VPWR CORE__N3__N1 0.0121f
C33 A VPWR 0.89523f
C34 Y CORE__N3 0.59646f
C35 CORE__N4__N1 CORE__N3 0.30434f
C36 B CORE__N3__N1 0.68586f
C37 B A 2.69235f
C38 CORE__N1 CORE__N3 0.33125f
C39 Y CORE__N1__N1 0.14988f
C40 Y CORE__N4__N1 0.92156f
C41 N CORE__N3__N1 0.00306f
C42 CORE__N1 Y 5.55074f
C43 CORE__N1 CORE__N1__N1 1.27643f
C44 VPWR CORE__N2__N1 0.0121f
C45 CORE__N3 CORE__N2 0.16527f
C46 B CORE__N2__N1 0.15663f
C47 CORE__N2 CORE__N1__N1 0.03409f
C48 Y CORE__N2 0.76958f
C49 CORE__N4__N1 CORE__N2 0.98897f
C50 Y VGND 8.94718f
C51 B VGND 5.22518f
C52 A VGND 4.34746f
C53 VPWR VGND 29.0572f
C54 CORE__N4__N1 VGND 1.8917f $ **FLOATING
C55 N VGND 3.98008f $ **FLOATING
C56 CORE__N3__N1 VGND 2.34631f $ **FLOATING
C57 CORE__N3 VGND 4.88994f $ **FLOATING
C58 CORE__N2__N1 VGND 2.23395f $ **FLOATING
C59 CORE__N2 VGND 6.24383f $ **FLOATING
C60 CORE__N1__N1 VGND 2.11301f $ **FLOATING
C61 CORE__N1 VGND 7.31288f $ **FLOATING
C62 Y.n0 VGND 0.014f $ **FLOATING
C63 Y.n1 VGND 0.01225f $ **FLOATING
C64 Y.t0 VGND 0.03752f $ **FLOATING
C65 Y.n2 VGND 0.01225f $ **FLOATING
C66 Y.n3 VGND 0.31388f $ **FLOATING
C67 Y.n4 VGND 6.48905f $ **FLOATING
C68 Y.n5 VGND 0.36112f $ **FLOATING
C69 Y.t1 VGND 0.03403f $ **FLOATING
C70 Y.n6 VGND 0.014f $ **FLOATING
C71 B.t3 VGND 0.04199f $ **FLOATING
C72 B.n0 VGND 1.28382f $ **FLOATING
C73 B.t1 VGND 0.04041f $ **FLOATING
C74 B.n1 VGND 1.87397f $ **FLOATING
C75 B.t0 VGND 0.04199f $ **FLOATING
C76 B.n2 VGND 2.46714f $ **FLOATING
C77 B.t2 VGND 0.04041f $ **FLOATING
C78 CORE__N1.n0 VGND 0.00876f $ **FLOATING
C79 CORE__N1.t5 VGND 0.03619f $ **FLOATING
C80 CORE__N1.t3 VGND 0.0376f $ **FLOATING
C81 CORE__N1.n1 VGND 1.97869f $ **FLOATING
C82 CORE__N1.t6 VGND 0.03619f $ **FLOATING
C83 CORE__N1.n2 VGND 1.33546f $ **FLOATING
C84 CORE__N1.t4 VGND 0.0376f $ **FLOATING
C85 CORE__N1.n3 VGND 1.65981f $ **FLOATING
C86 CORE__N1.n4 VGND 0.00876f $ **FLOATING
C87 CORE__N1.t2 VGND 0.02682f $ **FLOATING
C88 CORE__N1.n5 VGND 0.00876f $ **FLOATING
C89 CORE__N1.n6 VGND 0.25511f $ **FLOATING
C90 CORE__N1.n7 VGND 1.52153f $ **FLOATING
C91 CORE__N1.n8 VGND 0.01001f $ **FLOATING
C92 CORE__N1.t1 VGND 0.02433f $ **FLOATING
C93 CORE__N1.n9 VGND 0.01001f $ **FLOATING
C94 CORE__N1.n10 VGND 0.25511f $ **FLOATING
C95 CORE__N1.n11 VGND 1.22474f $ **FLOATING
C96 CORE__N1.n12 VGND 0.29037f $ **FLOATING
C97 CORE__N1.t0 VGND 0.02682f $ **FLOATING
C98 CORE__N1.n13 VGND 0.00876f $ **FLOATING
C99 A.t1 VGND 0.02495f $ **FLOATING
C100 A.n0 VGND 0.4206f $ **FLOATING
C101 A.t2 VGND 0.02401f $ **FLOATING
C102 A.n1 VGND 0.77128f $ **FLOATING
C103 A.t3 VGND 0.02495f $ **FLOATING
C104 A.n2 VGND 1.08592f $ **FLOATING
C105 A.t0 VGND 0.02401f $ **FLOATING
C106 N.n0 VGND 0.00574f $ **FLOATING
C107 N.t3 VGND 0.02075f $ **FLOATING
C108 N.t4 VGND 0.02156f $ **FLOATING
C109 N.n1 VGND 0.9295f $ **FLOATING
C110 N.n2 VGND 0.00502f $ **FLOATING
C111 N.t2 VGND 0.01538f $ **FLOATING
C112 N.n3 VGND 0.00502f $ **FLOATING
C113 N.n4 VGND 0.11121f $ **FLOATING
C114 N.n5 VGND 0.56498f $ **FLOATING
C115 N.n6 VGND 0.00502f $ **FLOATING
C116 N.t1 VGND 0.01538f $ **FLOATING
C117 N.n7 VGND 0.00502f $ **FLOATING
C118 N.n8 VGND 0.12964f $ **FLOATING
C119 N.n9 VGND 0.61354f $ **FLOATING
C120 N.n10 VGND 0.11121f $ **FLOATING
C121 N.t0 VGND 0.01395f $ **FLOATING
C122 N.n11 VGND 0.00574f $ **FLOATING
C123 CORE__N2.n0 VGND 0.00488f $ **FLOATING
C124 CORE__N2.t4 VGND 0.01764f $ **FLOATING
C125 CORE__N2.t3 VGND 0.01834f $ **FLOATING
C126 CORE__N2.n1 VGND 1.40137f $ **FLOATING
C127 CORE__N2.n2 VGND 0.00427f $ **FLOATING
C128 CORE__N2.t1 VGND 0.01308f $ **FLOATING
C129 CORE__N2.n3 VGND 0.00427f $ **FLOATING
C130 CORE__N2.n4 VGND 0.13953f $ **FLOATING
C131 CORE__N2.n5 VGND 0.98384f $ **FLOATING
C132 CORE__N2.n6 VGND 0.00427f $ **FLOATING
C133 CORE__N2.t2 VGND 0.01308f $ **FLOATING
C134 CORE__N2.n7 VGND 0.00427f $ **FLOATING
C135 CORE__N2.n8 VGND 0.15739f $ **FLOATING
C136 CORE__N2.n9 VGND 0.63451f $ **FLOATING
C137 CORE__N2.n10 VGND 0.13953f $ **FLOATING
C138 CORE__N2.t0 VGND 0.01186f $ **FLOATING
C139 CORE__N2.n11 VGND 0.00488f $ **FLOATING
rmesh_equiv_0 a a.n0 0.55668166616768899
rmesh_equiv_1 a a.n1 29.3827
rmesh_equiv_10 b b.n1 29.799399999999999
rmesh_equiv_100 n n.n3 12.8005
rmesh_equiv_101 n n.n6 12.8005
rmesh_equiv_102 n n.n7 12.8005
rmesh_equiv_103 n n.t3 315.88
rmesh_equiv_104 n n.t4 330.34100000000001
rmesh_equiv_105 n.n0 n.n10 10.151300000000001
rmesh_equiv_106 n.n0 n.t0 255.34500000000003
rmesh_equiv_107 n.n1 n.n5 2.0015200000000002
rmesh_equiv_108 n.n10 n.n11 10.151300000000001
rmesh_equiv_109 n.n10 n.n9 10.4521
rmesh_equiv_11 b b.n2 15.097203646670627
rmesh_equiv_110 n.n11 n.t0 255.34500000000003
rmesh_equiv_111 n.n2 n.n4 10.151300000000001
rmesh_equiv_112 n.n2 n.t2 700.48400000000004
rmesh_equiv_113 n.n3 n.n4 10.151300000000001
rmesh_equiv_114 n.n3 n.t2 700.48400000000004
rmesh_equiv_115 n.n4 n.n5 10.4521
rmesh_equiv_116 n.n5 n.n9 0.81771300000000002
rmesh_equiv_117 n.n6 n.n8 10.151300000000001
rmesh_equiv_118 n.n6 n.t1 700.48400000000004
rmesh_equiv_119 n.n7 n.n8 10.151300000000001
rmesh_equiv_12 b b.t0 330.34100000000001
rmesh_equiv_120 n.n7 n.t1 700.48400000000004
rmesh_equiv_121 n.n8 n.n9 11.269299999999999
rmesh_equiv_122 vgnd vgnd.n257 361.82106036961653
rmesh_equiv_123 vgnd vgnd.t0 190.40451766782007
rmesh_equiv_124 vgnd vgnd.t1 132.62698419228045
rmesh_equiv_125 vgnd vgnd.t10 132.8254136938167
rmesh_equiv_126 vgnd vgnd.t11 190.30997823053593
rmesh_equiv_127 vgnd vgnd.t12 132.4587155554012
rmesh_equiv_128 vgnd vgnd.t13 286.00669817176941
rmesh_equiv_129 vgnd vgnd.t2 190.31178304125231
rmesh_equiv_13 b b.t1 315.88
rmesh_equiv_130 vgnd vgnd.t3 190.30997802276534
rmesh_equiv_131 vgnd vgnd.t4 190.31011824391155
rmesh_equiv_132 vgnd vgnd.t5 192.64769315665583
rmesh_equiv_133 vgnd vgnd.t6 132.73097396062539
rmesh_equiv_134 vgnd vgnd.t7 240.80434557107083
rmesh_equiv_135 vgnd vgnd.t8 132.86142809450467
rmesh_equiv_136 vgnd vgnd.t9 189.2232332395823
rmesh_equiv_137 vgnd.n257 vgnd.t0 130244.59880285744
rmesh_equiv_138 vgnd.n257 vgnd.t11 59146354005.862808
rmesh_equiv_139 vgnd.n257 vgnd.t13 193.27496068226975
rmesh_equiv_14 b b.t2 315.88
rmesh_equiv_140 vgnd.n257 vgnd.t2 3591305.4375717584
rmesh_equiv_141 vgnd.n257 vgnd.t3 39798629762502.391
rmesh_equiv_142 vgnd.n257 vgnd.t4 87769545.81925492
rmesh_equiv_143 vgnd.n257 vgnd.t5 5329.2760227752024
rmesh_equiv_144 vgnd.n257 vgnd.t7 2557470029675.3823
rmesh_equiv_145 vgnd.n257 vgnd.t9 2419719714.8986282
rmesh_equiv_146 vgnd.t0 vgnd.t11 5645458.8862880357
rmesh_equiv_147 vgnd.t0 vgnd.t13 8734.923188352459
rmesh_equiv_148 vgnd.t0 vgnd.t3 3798738431.6628437
rmesh_equiv_149 vgnd.t0 vgnd.t4 8377.5132164809675
rmesh_equiv_15 b b.t3 330.34100000000001
rmesh_equiv_150 vgnd.t1 vgnd.t10 314849.40432292456
rmesh_equiv_151 vgnd.t1 vgnd.t12 246193.04312502514
rmesh_equiv_152 vgnd.t1 vgnd.t6 182286.29872963714
rmesh_equiv_153 vgnd.t1 vgnd.t8 365102.31179430324
rmesh_equiv_154 vgnd.t10 vgnd.t12 828900.66618143022
rmesh_equiv_155 vgnd.t10 vgnd.t6 146549.27697406316
rmesh_equiv_156 vgnd.t10 vgnd.t8 82383.067652440412
rmesh_equiv_157 vgnd.t11 vgnd.t13 3966681642.5479283
rmesh_equiv_158 vgnd.t11 vgnd.t3 8365.0991698184716
rmesh_equiv_159 vgnd.t11 vgnd.t4 8377.5124342663676
rmesh_equiv_16 b.n0 b.n1 0.81771300000000002
rmesh_equiv_160 vgnd.t12 vgnd.t6 479903.19301278039
rmesh_equiv_161 vgnd.t12 vgnd.t8 961200.95930142747
rmesh_equiv_162 vgnd.t13 vgnd.t3 2669116241076.0151
rmesh_equiv_163 vgnd.t13 vgnd.t4 5886311.2025721399
rmesh_equiv_164 vgnd.t2 vgnd.t5 8377.963339369293
rmesh_equiv_165 vgnd.t2 vgnd.t7 8852973.4882449377
rmesh_equiv_166 vgnd.t2 vgnd.t9 8376.1351008677102
rmesh_equiv_167 vgnd.t3 vgnd.t4 5637093.2968932968
rmesh_equiv_168 vgnd.t5 vgnd.t7 5966184308.9134159
rmesh_equiv_169 vgnd.t5 vgnd.t9 5644834.0068442775
rmesh_equiv_17 b.n1 b.n2 4.1335600000000001
rmesh_equiv_170 vgnd.t6 vgnd.t8 169939.91120953919
rmesh_equiv_171 vgnd.t7 vgnd.t9 13137.267252432122
rmesh_equiv_172 vpwr vpwr.n222 2.1150394523900933
rmesh_equiv_173 vpwr vpwr.t0 117.18187411979875
rmesh_equiv_174 vpwr vpwr.t1 448.89819667415935
rmesh_equiv_175 vpwr vpwr.t10 117.18187411979875
rmesh_equiv_176 vpwr vpwr.t11 383.8230562263862
rmesh_equiv_177 vpwr vpwr.t12 117.18187411979875
rmesh_equiv_178 vpwr vpwr.t13 369.26639715799701
rmesh_equiv_179 vpwr vpwr.t14 117.18187411979875
rmesh_equiv_18 core__n1 core__n1.n0 12.8005
rmesh_equiv_180 vpwr vpwr.t15 423.54480612847732
rmesh_equiv_181 vpwr vpwr.t16 117.18187411979875
rmesh_equiv_182 vpwr vpwr.t17 439.03047632248513
rmesh_equiv_183 vpwr vpwr.t2 117.18187411979875
rmesh_equiv_184 vpwr vpwr.t3 500.04319233285042
rmesh_equiv_185 vpwr vpwr.t4 117.18187411979875
rmesh_equiv_186 vpwr vpwr.t5 357.9104478469107
rmesh_equiv_187 vpwr vpwr.t6 117.18187411979875
rmesh_equiv_188 vpwr vpwr.t7 404.97883591565119
rmesh_equiv_189 vpwr vpwr.t8 117.18187411979875
rmesh_equiv_19 core__n1 core__n1.n1 15.513956422736719
rmesh_equiv_190 vpwr vpwr.t9 412.97790568127351
rmesh_equiv_191 vpwr.n222 vpwr.t1 1697.7607546611125
rmesh_equiv_192 vpwr.n222 vpwr.t11 4746.9610901294564
rmesh_equiv_193 vpwr.n222 vpwr.t13 9214.792504485571
rmesh_equiv_194 vpwr.n222 vpwr.t15 2200.1428248447796
rmesh_equiv_195 vpwr.n222 vpwr.t17 1854.5250068154082
rmesh_equiv_196 vpwr.n222 vpwr.t3 1221.3038835025977
rmesh_equiv_197 vpwr.n222 vpwr.t5 41774.798273144421
rmesh_equiv_198 vpwr.n222 vpwr.t7 2882.8252040691009
rmesh_equiv_199 vpwr.n222 vpwr.t9 2540.891921147941
rmesh_equiv_2 a a.n2 14.888839177564758
rmesh_equiv_20 core__n1 core__n1.n13 12.8005
rmesh_equiv_200 vpwr.t1 vpwr.t15 1632690.8590592269
rmesh_equiv_201 vpwr.t1 vpwr.t9 1885555.3224406508
rmesh_equiv_202 vpwr.t11 vpwr.t13 1861584.2184083783
rmesh_equiv_203 vpwr.t11 vpwr.t17 3522644.0268535628
rmesh_equiv_204 vpwr.t11 vpwr.t5 8439398.4080079626
rmesh_equiv_205 vpwr.t11 vpwr.t7 1629510.2668078935
rmesh_equiv_206 vpwr.t13 vpwr.t17 6838150.3783794101
rmesh_equiv_207 vpwr.t13 vpwr.t5 5364246.136323465
rmesh_equiv_208 vpwr.t13 vpwr.t7 3163202.4588923194
rmesh_equiv_209 vpwr.t15 vpwr.t9 872223.17473153945
rmesh_equiv_21 core__n1 core__n1.n2 30.632700000000003
rmesh_equiv_210 vpwr.t17 vpwr.t5 31000410.750342071
rmesh_equiv_211 vpwr.t17 vpwr.t7 2139298.5518025337
rmesh_equiv_212 vpwr.t5 vpwr.t7 14340219.223929022
rmesh_equiv_213 y y.n0 12.8005
rmesh_equiv_214 y y.n1 12.8005
rmesh_equiv_215 y y.n2 12.8005
rmesh_equiv_216 y y.n4 13.476000000000001
rmesh_equiv_217 y y.n6 12.8005
rmesh_equiv_218 y.n0 y.n5 10.151300000000001
rmesh_equiv_219 y.n0 y.t1 255.34500000000003
rmesh_equiv_22 core__n1 core__n1.n3 30.617100000000001
rmesh_equiv_220 y.n1 y.n3 10.151300000000001
rmesh_equiv_221 y.n1 y.t0 700.48400000000004
rmesh_equiv_222 y.n2 y.n3 10.151300000000001
rmesh_equiv_223 y.n2 y.t0 700.48400000000004
rmesh_equiv_224 y.n3 y.n4 10.8688
rmesh_equiv_225 y.n4 y.n5 11.686
rmesh_equiv_226 y.n5 y.n6 10.151300000000001
rmesh_equiv_227 y.n6 y.t1 255.34500000000003
rmesh_equiv_23 core__n1 core__n1.n4 12.8005
rmesh_equiv_24 core__n1 core__n1.n5 12.8005
rmesh_equiv_25 core__n1 core__n1.n8 12.8005
rmesh_equiv_26 core__n1 core__n1.n9 12.8005
rmesh_equiv_27 core__n1 core__n1.t3 330.34100000000001
rmesh_equiv_28 core__n1 core__n1.t4 330.34100000000001
rmesh_equiv_29 core__n1 core__n1.t5 315.88
rmesh_equiv_3 a a.t0 315.88
rmesh_equiv_30 core__n1 core__n1.t6 315.88
rmesh_equiv_31 core__n1.n0 core__n1.n12 10.151300000000001
rmesh_equiv_32 core__n1.n0 core__n1.t0 700.48400000000004
rmesh_equiv_33 core__n1.n1 core__n1.n2 2.4756399999999998
rmesh_equiv_34 core__n1.n10 core__n1.n11 11.285399999999999
rmesh_equiv_35 core__n1.n10 core__n1.n8 10.151300000000001
rmesh_equiv_36 core__n1.n10 core__n1.n9 10.151300000000001
rmesh_equiv_37 core__n1.n11 core__n1.n12 12.102600000000001
rmesh_equiv_38 core__n1.n11 core__n1.n7 0.81771300000000002
rmesh_equiv_39 core__n1.n12 core__n1.n13 10.151300000000001
rmesh_equiv_4 a a.t1 330.34100000000001
rmesh_equiv_40 core__n1.n13 core__n1.t0 700.48400000000004
rmesh_equiv_41 core__n1.n2 core__n1.n3 0.81771300000000002
rmesh_equiv_42 core__n1.n3 core__n1.n7 3.6594500000000001
rmesh_equiv_43 core__n1.n4 core__n1.n6 10.151300000000001
rmesh_equiv_44 core__n1.n4 core__n1.t2 700.48400000000004
rmesh_equiv_45 core__n1.n5 core__n1.n6 10.151300000000001
rmesh_equiv_46 core__n1.n5 core__n1.t2 700.48400000000004
rmesh_equiv_47 core__n1.n6 core__n1.n7 11.285399999999999
rmesh_equiv_48 core__n1.n8 core__n1.t1 255.34500000000003
rmesh_equiv_49 core__n1.n9 core__n1.t1 255.34500000000003
rmesh_equiv_5 a a.t2 315.88
rmesh_equiv_50 core__n1__n1 core__n1__n1.t0 134.07275000000001
rmesh_equiv_51 core__n1__n1 core__n1__n1.t1 134.07275000000001
rmesh_equiv_52 core__n1__n1.t0 core__n1__n1.t1 20672.249182095649
rmesh_equiv_53 core__n2 core__n2.n0 12.8005
rmesh_equiv_54 core__n2 core__n2.n1 15.722317769867551
rmesh_equiv_55 core__n2 core__n2.n11 12.8005
rmesh_equiv_56 core__n2 core__n2.n2 12.8005
rmesh_equiv_57 core__n2 core__n2.n3 12.8005
rmesh_equiv_58 core__n2 core__n2.n6 12.8005
rmesh_equiv_59 core__n2 core__n2.n7 12.8005
rmesh_equiv_6 a a.t3 330.34100000000001
rmesh_equiv_60 core__n2 core__n2.t3 330.34100000000001
rmesh_equiv_61 core__n2 core__n2.t4 315.88
rmesh_equiv_62 core__n2.n0 core__n2.n10 10.151300000000001
rmesh_equiv_63 core__n2.n0 core__n2.t0 255.34500000000003
rmesh_equiv_64 core__n2.n1 core__n2.n5 5.3173700000000004
rmesh_equiv_65 core__n2.n10 core__n2.n11 10.151300000000001
rmesh_equiv_66 core__n2.n10 core__n2.n9 11.7021
rmesh_equiv_67 core__n2.n11 core__n2.t0 255.34500000000003
rmesh_equiv_68 core__n2.n2 core__n2.n4 10.151300000000001
rmesh_equiv_69 core__n2.n2 core__n2.t1 700.48400000000004
rmesh_equiv_7 a.n0 a.n1 0.81771300000000002
rmesh_equiv_70 core__n2.n3 core__n2.n4 10.151300000000001
rmesh_equiv_71 core__n2.n3 core__n2.t1 700.48400000000004
rmesh_equiv_72 core__n2.n4 core__n2.n5 11.7021
rmesh_equiv_73 core__n2.n5 core__n2.n9 0.81771300000000002
rmesh_equiv_74 core__n2.n6 core__n2.n8 10.151300000000001
rmesh_equiv_75 core__n2.n6 core__n2.t2 700.48400000000004
rmesh_equiv_76 core__n2.n7 core__n2.n8 10.151300000000001
rmesh_equiv_77 core__n2.n7 core__n2.t2 700.48400000000004
rmesh_equiv_78 core__n2.n8 core__n2.n9 12.519299999999999
rmesh_equiv_79 core__n2__n1 core__n2__n1.t0 134.07275000000001
rmesh_equiv_8 a.n1 a.n2 2.4756399999999998
rmesh_equiv_80 core__n2__n1 core__n2__n1.t1 134.07275000000001
rmesh_equiv_81 core__n2__n1.t0 core__n2__n1.t1 21037.918515486057
rmesh_equiv_82 core__n3 core__n3.t0 356.83634236426815
rmesh_equiv_83 core__n3 core__n3.t1 132.98773872464969
rmesh_equiv_84 core__n3 core__n3.t2 356.9260006352381
rmesh_equiv_85 core__n3 core__n3.t3 315.88
rmesh_equiv_86 core__n3 core__n3.t4 330.34100000000001
rmesh_equiv_87 core__n3.t0 core__n3.t1 106144.09219836524
rmesh_equiv_88 core__n3.t0 core__n3.t2 295769.79209788376
rmesh_equiv_89 core__n3.t1 core__n3.t2 101818.15522945518
rmesh_equiv_9 b b.n0 2.0706467054015332
rmesh_equiv_90 core__n3__n1 core__n3__n1.t0 134.07275000000001
rmesh_equiv_91 core__n3__n1 core__n3__n1.t1 134.07275000000001
rmesh_equiv_92 core__n3__n1.t0 core__n3__n1.t1 21037.918515486057
rmesh_equiv_93 core__n4__n1 core__n4__n1.t0 134.07275000000001
rmesh_equiv_94 core__n4__n1 core__n4__n1.t1 134.07275000000001
rmesh_equiv_95 core__n4__n1.t0 core__n4__n1.t1 20306.535966629948
rmesh_equiv_96 n n.n0 12.8005
rmesh_equiv_97 n n.n1 15.097203646670627
rmesh_equiv_98 n n.n11 12.8005
rmesh_equiv_99 n n.n2 12.8005
.ends

* NGSPICE file created from cell_xnor2.ext - technology: sky130A

.subckt cell_xnor2 VGND VPWR Y B A
X0 VPWR.t1 CORE__N2.t3 N.t1 VPWR.t0 sky130_fd_pr__pfet_01v8_hvt ad=0.1885 pd=1.88 as=0.1885 ps=1.88 w=0.65 l=0.15
X1 CORE__N2__N1.t1 A.t0 CORE__N2.t0 VGND.t4 sky130_fd_pr__nfet_01v8 ad=0.1885 pd=1.88 as=0.1885 ps=1.88 w=0.65 l=0.15
X2 VPWR.t3 CORE__N1.t3 CORE__N3.t0 VPWR.t2 sky130_fd_pr__pfet_01v8_hvt ad=0.1885 pd=1.88 as=0.1885 ps=1.88 w=0.65 l=0.15
X3 VPWR.t17 B.t0 CORE__N3.t2 VPWR.t16 sky130_fd_pr__pfet_01v8_hvt ad=0.1885 pd=1.88 as=0.1885 ps=1.88 w=0.65 l=0.15
X4 VGND.t8 N.t3 Y.t1 VGND.t7 sky130_fd_pr__nfet_01v8 ad=0.1885 pd=1.88 as=0.1885 ps=1.88 w=0.65 l=0.15
X5 VGND.t12 B.t1 CORE__N1__N1.t1 VGND.t11 sky130_fd_pr__nfet_01v8 ad=0.1885 pd=1.88 as=0.1885 ps=1.88 w=0.65 l=0.15
X6 VPWR.t7 CORE__N1.t4 CORE__N2.t1 VPWR.t6 sky130_fd_pr__pfet_01v8_hvt ad=0.1885 pd=1.88 as=0.1885 ps=1.88 w=0.65 l=0.15
X7 CORE__N4__N1.t0 CORE__N2.t4 N.t0 VGND.t2 sky130_fd_pr__nfet_01v8 ad=0.1885 pd=1.88 as=0.1885 ps=1.88 w=0.65 l=0.15
X8 VGND.t10 CORE__N3.t3 CORE__N4__N1.t1 VGND.t9 sky130_fd_pr__nfet_01v8 ad=0.1885 pd=1.88 as=0.1885 ps=1.88 w=0.65 l=0.15
X9 VPWR.t5 A.t1 CORE__N1.t0 VPWR.t4 sky130_fd_pr__pfet_01v8_hvt ad=0.1885 pd=1.88 as=0.1885 ps=1.88 w=0.65 l=0.15
X10 CORE__N1__N1.t0 A.t2 CORE__N1.t1 VGND.t3 sky130_fd_pr__nfet_01v8 ad=0.1885 pd=1.88 as=0.1885 ps=1.88 w=0.65 l=0.15
X11 VPWR.t11 A.t3 CORE__N2.t2 VPWR.t10 sky130_fd_pr__pfet_01v8_hvt ad=0.1885 pd=1.88 as=0.1885 ps=1.88 w=0.65 l=0.15
X12 VGND.t6 CORE__N1.t5 CORE__N3__N1.t1 VGND.t5 sky130_fd_pr__nfet_01v8 ad=0.1885 pd=1.88 as=0.1885 ps=1.88 w=0.65 l=0.15
X13 VPWR.t15 CORE__N3.t4 N.t2 VPWR.t14 sky130_fd_pr__pfet_01v8_hvt ad=0.1885 pd=1.88 as=0.1885 ps=1.88 w=0.65 l=0.15
X14 CORE__N3__N1.t0 B.t2 CORE__N3.t1 VGND.t13 sky130_fd_pr__nfet_01v8 ad=0.1885 pd=1.88 as=0.1885 ps=1.88 w=0.65 l=0.15
X15 VPWR.t13 B.t3 CORE__N1.t2 VPWR.t12 sky130_fd_pr__pfet_01v8_hvt ad=0.1885 pd=1.88 as=0.1885 ps=1.88 w=0.65 l=0.15
X16 VGND.t1 CORE__N1.t6 CORE__N2__N1.t0 VGND.t0 sky130_fd_pr__nfet_01v8 ad=0.1885 pd=1.88 as=0.1885 ps=1.88 w=0.65 l=0.15
X17 VPWR.t9 N.t4 Y.t0 VPWR.t8 sky130_fd_pr__pfet_01v8_hvt ad=0.1885 pd=1.88 as=0.1885 ps=1.88 w=0.65 l=0.15
C0 A CORE__N2__N1 0.57595f
C1 CORE__N1 CORE__N2 3.68821f
C2 VPWR CORE__N3 1.01761f
C3 Y VPWR 0.27182f
C4 VPWR CORE__N1__N1 0.0122f
C5 B CORE__N3 1.05596f
C6 VPWR CORE__N4__N1 0.01238f
C7 N CORE__N3 1.88954f
C8 CORE__N1 VPWR 1.36821f
C9 CORE__N3 CORE__N3__N1 0.38898f
C10 B CORE__N1__N1 0.33316f
C11 Y B 4.24891f
C12 Y N 2.69678f
C13 N CORE__N4__N1 0.40275f
C14 Y CORE__N3__N1 0.1561f
C15 CORE__N1 B 0.54043f
C16 Y A 0.00384f
C17 A CORE__N1__N1 0.65925f
C18 VPWR CORE__N2 0.94638f
C19 CORE__N1 N 0.06633f
C20 CORE__N1 CORE__N3__N1 0.42266f
C21 CORE__N1 A 0.48342f
C22 B CORE__N2 0.29973f
C23 CORE__N3 CORE__N2__N1 0.00306f
C24 N CORE__N2 0.41912f
C25 CORE__N3__N1 CORE__N2 0.91385f
C26 A CORE__N2 0.3955f
C27 Y CORE__N2__N1 0.14763f
C28 CORE__N1 CORE__N2__N1 0.40398f
C29 B VPWR 0.85648f
C30 N VPWR 0.95815f
C31 CORE__N2__N1 CORE__N2 1.30662f
C32 VPWR CORE__N3__N1 0.0121f
C33 A VPWR 0.89523f
C34 Y CORE__N3 0.59646f
C35 CORE__N4__N1 CORE__N3 0.30434f
C36 B CORE__N3__N1 0.68586f
C37 B A 2.69235f
C38 CORE__N1 CORE__N3 0.33125f
C39 Y CORE__N1__N1 0.14988f
C40 Y CORE__N4__N1 0.92156f
C41 N CORE__N3__N1 0.00306f
C42 CORE__N1 Y 5.55074f
C43 CORE__N1 CORE__N1__N1 1.27643f
C44 VPWR CORE__N2__N1 0.0121f
C45 CORE__N3 CORE__N2 0.16527f
C46 B CORE__N2__N1 0.15663f
C47 CORE__N2 CORE__N1__N1 0.03409f
C48 Y CORE__N2 0.76958f
C49 CORE__N4__N1 CORE__N2 0.98897f
R0 CORE__N2.t2 CORE__N2.n6 700.484
R1 CORE__N2.n7 CORE__N2.t2 700.484
R2 CORE__N2.t1 CORE__N2.n2 700.484
R3 CORE__N2.n3 CORE__N2.t1 700.484
R4 CORE__N2 CORE__N2.t3 330.341
R5 CORE__N2 CORE__N2.t4 315.88
R6 CORE__N2.t0 CORE__N2.n0 255.345
R7 CORE__N2.n11 CORE__N2.t0 255.345
R8 CORE__N2.n1 CORE__N2 31.8666
R9 CORE__N2.n1 CORE__N2 31.0337
R10 CORE__N2 CORE__N2.n6 12.8005
R11 CORE__N2.n7 CORE__N2 12.8005
R12 CORE__N2 CORE__N2.n2 12.8005
R13 CORE__N2.n3 CORE__N2 12.8005
R14 CORE__N2 CORE__N2.n0 12.8005
R15 CORE__N2 CORE__N2.n11 12.8005
R16 CORE__N2.n9 CORE__N2.n8 12.5193
R17 CORE__N2.n5 CORE__N2.n4 11.7021
R18 CORE__N2.n10 CORE__N2.n9 11.7021
R19 CORE__N2.n8 CORE__N2.n6 10.1513
R20 CORE__N2.n8 CORE__N2.n7 10.1513
R21 CORE__N2.n4 CORE__N2.n2 10.1513
R22 CORE__N2.n4 CORE__N2.n3 10.1513
R23 CORE__N2.n10 CORE__N2.n0 10.1513
R24 CORE__N2.n11 CORE__N2.n10 10.1513
R25 CORE__N2.n5 CORE__N2.n1 5.31737
R26 CORE__N2.n9 CORE__N2.n5 0.817713
R27 N.t1 N.n6 700.484
R28 N.n7 N.t1 700.484
R29 N.t2 N.n2 700.484
R30 N.n3 N.t2 700.484
R31 N N.t4 330.341
R32 N N.t3 315.88
R33 N.t0 N.n0 255.345
R34 N.n11 N.t0 255.345
R35 N.n1 N 30.6166
R36 N.n1 N 29.7837
R37 N N.n6 12.8005
R38 N.n7 N 12.8005
R39 N N.n2 12.8005
R40 N.n3 N 12.8005
R41 N N.n0 12.8005
R42 N N.n11 12.8005
R43 N.n9 N.n8 11.2693
R44 N.n5 N.n4 10.4521
R45 N.n10 N.n9 10.4521
R46 N.n8 N.n6 10.1513
R47 N.n8 N.n7 10.1513
R48 N.n4 N.n2 10.1513
R49 N.n4 N.n3 10.1513
R50 N.n10 N.n0 10.1513
R51 N.n11 N.n10 10.1513
R52 N.n5 N.n1 2.00152
R53 N.n9 N.n5 0.817713
R54 VPWR.n55 VPWR.n43 832.942
R55 VPWR.n66 VPWR.n44 832.942
R56 VPWR.n68 VPWR.n41 832.942
R57 VPWR.n50 VPWR.n40 832.942
R58 VPWR.n92 VPWR.n80 832.942
R59 VPWR.n103 VPWR.n81 832.942
R60 VPWR.n105 VPWR.n78 832.942
R61 VPWR.n87 VPWR.n77 832.942
R62 VPWR.n129 VPWR.n117 832.942
R63 VPWR.n140 VPWR.n118 832.942
R64 VPWR.n142 VPWR.n115 832.942
R65 VPWR.n124 VPWR.n114 832.942
R66 VPWR.n166 VPWR.n154 832.942
R67 VPWR.n177 VPWR.n155 832.942
R68 VPWR.n179 VPWR.n152 832.942
R69 VPWR.n161 VPWR.n151 832.942
R70 VPWR.n203 VPWR.n191 832.942
R71 VPWR.n214 VPWR.n192 832.942
R72 VPWR.n216 VPWR.n189 832.942
R73 VPWR.n198 VPWR.n188 832.942
R74 VPWR.n240 VPWR.n228 832.942
R75 VPWR.n251 VPWR.n229 832.942
R76 VPWR.n253 VPWR.n226 832.942
R77 VPWR.n235 VPWR.n225 832.942
R78 VPWR.n277 VPWR.n265 832.942
R79 VPWR.n288 VPWR.n266 832.942
R80 VPWR.n290 VPWR.n263 832.942
R81 VPWR.n272 VPWR.n262 832.942
R82 VPWR.n314 VPWR.n302 832.942
R83 VPWR.n325 VPWR.n303 832.942
R84 VPWR.n327 VPWR.n300 832.942
R85 VPWR.n309 VPWR.n299 832.942
R86 VPWR.n18 VPWR.n6 832.942
R87 VPWR.n29 VPWR.n7 832.942
R88 VPWR.n31 VPWR.n4 832.942
R89 VPWR.n13 VPWR.n3 832.942
R90 VPWR.t5 VPWR.n34 700.484
R91 VPWR.n35 VPWR.t5 700.484
R92 VPWR.t13 VPWR.n71 700.484
R93 VPWR.n72 VPWR.t13 700.484
R94 VPWR.t11 VPWR.n108 700.484
R95 VPWR.n109 VPWR.t11 700.484
R96 VPWR.t7 VPWR.n145 700.484
R97 VPWR.n146 VPWR.t7 700.484
R98 VPWR.t17 VPWR.n182 700.484
R99 VPWR.n183 VPWR.t17 700.484
R100 VPWR.t3 VPWR.n219 700.484
R101 VPWR.n220 VPWR.t3 700.484
R102 VPWR.t1 VPWR.n256 700.484
R103 VPWR.n257 VPWR.t1 700.484
R104 VPWR.t15 VPWR.n293 700.484
R105 VPWR.n294 VPWR.t15 700.484
R106 VPWR.t9 VPWR.n0 700.484
R107 VPWR.n331 VPWR.t9 700.484
R108 VPWR.n66 VPWR.n43 240
R109 VPWR.n62 VPWR.n60 240
R110 VPWR.n68 VPWR.n40 240
R111 VPWR.n47 VPWR.n46 240
R112 VPWR.n103 VPWR.n80 240
R113 VPWR.n99 VPWR.n97 240
R114 VPWR.n105 VPWR.n77 240
R115 VPWR.n84 VPWR.n83 240
R116 VPWR.n140 VPWR.n117 240
R117 VPWR.n136 VPWR.n134 240
R118 VPWR.n142 VPWR.n114 240
R119 VPWR.n121 VPWR.n120 240
R120 VPWR.n177 VPWR.n154 240
R121 VPWR.n173 VPWR.n171 240
R122 VPWR.n179 VPWR.n151 240
R123 VPWR.n158 VPWR.n157 240
R124 VPWR.n214 VPWR.n191 240
R125 VPWR.n210 VPWR.n208 240
R126 VPWR.n216 VPWR.n188 240
R127 VPWR.n195 VPWR.n194 240
R128 VPWR.n251 VPWR.n228 240
R129 VPWR.n247 VPWR.n245 240
R130 VPWR.n253 VPWR.n225 240
R131 VPWR.n232 VPWR.n231 240
R132 VPWR.n288 VPWR.n265 240
R133 VPWR.n284 VPWR.n282 240
R134 VPWR.n290 VPWR.n262 240
R135 VPWR.n269 VPWR.n268 240
R136 VPWR.n325 VPWR.n302 240
R137 VPWR.n321 VPWR.n319 240
R138 VPWR.n327 VPWR.n299 240
R139 VPWR.n306 VPWR.n305 240
R140 VPWR.n29 VPWR.n6 240
R141 VPWR.n25 VPWR.n23 240
R142 VPWR.n31 VPWR.n3 240
R143 VPWR.n10 VPWR.n9 240
R144 VPWR.n53 VPWR.n52 207.394
R145 VPWR.n67 VPWR.n42 207.394
R146 VPWR.n90 VPWR.n89 207.394
R147 VPWR.n104 VPWR.n79 207.394
R148 VPWR.n127 VPWR.n126 207.394
R149 VPWR.n141 VPWR.n116 207.394
R150 VPWR.n164 VPWR.n163 207.394
R151 VPWR.n178 VPWR.n153 207.394
R152 VPWR.n201 VPWR.n200 207.394
R153 VPWR.n215 VPWR.n190 207.394
R154 VPWR.n238 VPWR.n237 207.394
R155 VPWR.n252 VPWR.n227 207.394
R156 VPWR.n275 VPWR.n274 207.394
R157 VPWR.n289 VPWR.n264 207.394
R158 VPWR.n312 VPWR.n311 207.394
R159 VPWR.n326 VPWR.n301 207.394
R160 VPWR.n16 VPWR.n15 207.394
R161 VPWR.n30 VPWR.n5 207.394
R162 VPWR.n50 VPWR.n49 185
R163 VPWR.n48 VPWR.n47 185
R164 VPWR.n46 VPWR.n45 185
R165 VPWR.n56 VPWR.n55 185
R166 VPWR.n57 VPWR.n43 185
R167 VPWR.n52 VPWR.n43 185
R168 VPWR.n66 VPWR.n65 185
R169 VPWR.n67 VPWR.n66 185
R170 VPWR.n64 VPWR.n44 185
R171 VPWR.n63 VPWR.n62 185
R172 VPWR.n60 VPWR.n58 185
R173 VPWR.n41 VPWR.n39 185
R174 VPWR.n69 VPWR.n68 185
R175 VPWR.n68 VPWR.n67 185
R176 VPWR.n40 VPWR.n38 185
R177 VPWR.n52 VPWR.n40 185
R178 VPWR.n87 VPWR.n86 185
R179 VPWR.n85 VPWR.n84 185
R180 VPWR.n83 VPWR.n82 185
R181 VPWR.n93 VPWR.n92 185
R182 VPWR.n94 VPWR.n80 185
R183 VPWR.n89 VPWR.n80 185
R184 VPWR.n103 VPWR.n102 185
R185 VPWR.n104 VPWR.n103 185
R186 VPWR.n101 VPWR.n81 185
R187 VPWR.n100 VPWR.n99 185
R188 VPWR.n97 VPWR.n95 185
R189 VPWR.n78 VPWR.n76 185
R190 VPWR.n106 VPWR.n105 185
R191 VPWR.n105 VPWR.n104 185
R192 VPWR.n77 VPWR.n75 185
R193 VPWR.n89 VPWR.n77 185
R194 VPWR.n124 VPWR.n123 185
R195 VPWR.n122 VPWR.n121 185
R196 VPWR.n120 VPWR.n119 185
R197 VPWR.n130 VPWR.n129 185
R198 VPWR.n131 VPWR.n117 185
R199 VPWR.n126 VPWR.n117 185
R200 VPWR.n140 VPWR.n139 185
R201 VPWR.n141 VPWR.n140 185
R202 VPWR.n138 VPWR.n118 185
R203 VPWR.n137 VPWR.n136 185
R204 VPWR.n134 VPWR.n132 185
R205 VPWR.n115 VPWR.n113 185
R206 VPWR.n143 VPWR.n142 185
R207 VPWR.n142 VPWR.n141 185
R208 VPWR.n114 VPWR.n112 185
R209 VPWR.n126 VPWR.n114 185
R210 VPWR.n161 VPWR.n160 185
R211 VPWR.n159 VPWR.n158 185
R212 VPWR.n157 VPWR.n156 185
R213 VPWR.n167 VPWR.n166 185
R214 VPWR.n168 VPWR.n154 185
R215 VPWR.n163 VPWR.n154 185
R216 VPWR.n177 VPWR.n176 185
R217 VPWR.n178 VPWR.n177 185
R218 VPWR.n175 VPWR.n155 185
R219 VPWR.n174 VPWR.n173 185
R220 VPWR.n171 VPWR.n169 185
R221 VPWR.n152 VPWR.n150 185
R222 VPWR.n180 VPWR.n179 185
R223 VPWR.n179 VPWR.n178 185
R224 VPWR.n151 VPWR.n149 185
R225 VPWR.n163 VPWR.n151 185
R226 VPWR.n198 VPWR.n197 185
R227 VPWR.n196 VPWR.n195 185
R228 VPWR.n194 VPWR.n193 185
R229 VPWR.n204 VPWR.n203 185
R230 VPWR.n205 VPWR.n191 185
R231 VPWR.n200 VPWR.n191 185
R232 VPWR.n214 VPWR.n213 185
R233 VPWR.n215 VPWR.n214 185
R234 VPWR.n212 VPWR.n192 185
R235 VPWR.n211 VPWR.n210 185
R236 VPWR.n208 VPWR.n206 185
R237 VPWR.n189 VPWR.n187 185
R238 VPWR.n217 VPWR.n216 185
R239 VPWR.n216 VPWR.n215 185
R240 VPWR.n188 VPWR.n186 185
R241 VPWR.n200 VPWR.n188 185
R242 VPWR.n235 VPWR.n234 185
R243 VPWR.n233 VPWR.n232 185
R244 VPWR.n231 VPWR.n230 185
R245 VPWR.n241 VPWR.n240 185
R246 VPWR.n242 VPWR.n228 185
R247 VPWR.n237 VPWR.n228 185
R248 VPWR.n251 VPWR.n250 185
R249 VPWR.n252 VPWR.n251 185
R250 VPWR.n249 VPWR.n229 185
R251 VPWR.n248 VPWR.n247 185
R252 VPWR.n245 VPWR.n243 185
R253 VPWR.n226 VPWR.n224 185
R254 VPWR.n254 VPWR.n253 185
R255 VPWR.n253 VPWR.n252 185
R256 VPWR.n225 VPWR.n223 185
R257 VPWR.n237 VPWR.n225 185
R258 VPWR.n272 VPWR.n271 185
R259 VPWR.n270 VPWR.n269 185
R260 VPWR.n268 VPWR.n267 185
R261 VPWR.n278 VPWR.n277 185
R262 VPWR.n279 VPWR.n265 185
R263 VPWR.n274 VPWR.n265 185
R264 VPWR.n288 VPWR.n287 185
R265 VPWR.n289 VPWR.n288 185
R266 VPWR.n286 VPWR.n266 185
R267 VPWR.n285 VPWR.n284 185
R268 VPWR.n282 VPWR.n280 185
R269 VPWR.n263 VPWR.n261 185
R270 VPWR.n291 VPWR.n290 185
R271 VPWR.n290 VPWR.n289 185
R272 VPWR.n262 VPWR.n260 185
R273 VPWR.n274 VPWR.n262 185
R274 VPWR.n309 VPWR.n308 185
R275 VPWR.n307 VPWR.n306 185
R276 VPWR.n305 VPWR.n304 185
R277 VPWR.n315 VPWR.n314 185
R278 VPWR.n316 VPWR.n302 185
R279 VPWR.n311 VPWR.n302 185
R280 VPWR.n325 VPWR.n324 185
R281 VPWR.n326 VPWR.n325 185
R282 VPWR.n323 VPWR.n303 185
R283 VPWR.n322 VPWR.n321 185
R284 VPWR.n319 VPWR.n317 185
R285 VPWR.n300 VPWR.n298 185
R286 VPWR.n328 VPWR.n327 185
R287 VPWR.n327 VPWR.n326 185
R288 VPWR.n299 VPWR.n297 185
R289 VPWR.n311 VPWR.n299 185
R290 VPWR.n13 VPWR.n12 185
R291 VPWR.n11 VPWR.n10 185
R292 VPWR.n9 VPWR.n8 185
R293 VPWR.n19 VPWR.n18 185
R294 VPWR.n20 VPWR.n6 185
R295 VPWR.n15 VPWR.n6 185
R296 VPWR.n29 VPWR.n28 185
R297 VPWR.n30 VPWR.n29 185
R298 VPWR.n27 VPWR.n7 185
R299 VPWR.n26 VPWR.n25 185
R300 VPWR.n23 VPWR.n21 185
R301 VPWR.n4 VPWR.n2 185
R302 VPWR.n32 VPWR.n31 185
R303 VPWR.n31 VPWR.n30 185
R304 VPWR.n3 VPWR.n1 185
R305 VPWR.n15 VPWR.n3 185
R306 VPWR.n57 VPWR.n56 88.8476
R307 VPWR.n49 VPWR.n38 88.8476
R308 VPWR.n65 VPWR.n64 88.8476
R309 VPWR.n69 VPWR.n39 88.8476
R310 VPWR.n94 VPWR.n93 88.8476
R311 VPWR.n86 VPWR.n75 88.8476
R312 VPWR.n102 VPWR.n101 88.8476
R313 VPWR.n106 VPWR.n76 88.8476
R314 VPWR.n131 VPWR.n130 88.8476
R315 VPWR.n123 VPWR.n112 88.8476
R316 VPWR.n139 VPWR.n138 88.8476
R317 VPWR.n143 VPWR.n113 88.8476
R318 VPWR.n168 VPWR.n167 88.8476
R319 VPWR.n160 VPWR.n149 88.8476
R320 VPWR.n176 VPWR.n175 88.8476
R321 VPWR.n180 VPWR.n150 88.8476
R322 VPWR.n205 VPWR.n204 88.8476
R323 VPWR.n197 VPWR.n186 88.8476
R324 VPWR.n213 VPWR.n212 88.8476
R325 VPWR.n217 VPWR.n187 88.8476
R326 VPWR.n242 VPWR.n241 88.8476
R327 VPWR.n234 VPWR.n223 88.8476
R328 VPWR.n250 VPWR.n249 88.8476
R329 VPWR.n254 VPWR.n224 88.8476
R330 VPWR.n279 VPWR.n278 88.8476
R331 VPWR.n271 VPWR.n260 88.8476
R332 VPWR.n287 VPWR.n286 88.8476
R333 VPWR.n291 VPWR.n261 88.8476
R334 VPWR.n316 VPWR.n315 88.8476
R335 VPWR.n308 VPWR.n297 88.8476
R336 VPWR.n324 VPWR.n323 88.8476
R337 VPWR.n328 VPWR.n298 88.8476
R338 VPWR.n20 VPWR.n19 88.8476
R339 VPWR.n12 VPWR.n1 88.8476
R340 VPWR.n28 VPWR.n27 88.8476
R341 VPWR.n32 VPWR.n2 88.8476
R342 VPWR.n61 VPWR.n44 72.7879
R343 VPWR.n59 VPWR.n41 72.7879
R344 VPWR.n55 VPWR.n54 72.7879
R345 VPWR.n51 VPWR.n47 72.7879
R346 VPWR.n51 VPWR.n50 72.7879
R347 VPWR.n54 VPWR.n46 72.7879
R348 VPWR.n62 VPWR.n61 72.7879
R349 VPWR.n60 VPWR.n59 72.7879
R350 VPWR.n98 VPWR.n81 72.7879
R351 VPWR.n96 VPWR.n78 72.7879
R352 VPWR.n92 VPWR.n91 72.7879
R353 VPWR.n88 VPWR.n84 72.7879
R354 VPWR.n88 VPWR.n87 72.7879
R355 VPWR.n91 VPWR.n83 72.7879
R356 VPWR.n99 VPWR.n98 72.7879
R357 VPWR.n97 VPWR.n96 72.7879
R358 VPWR.n135 VPWR.n118 72.7879
R359 VPWR.n133 VPWR.n115 72.7879
R360 VPWR.n129 VPWR.n128 72.7879
R361 VPWR.n125 VPWR.n121 72.7879
R362 VPWR.n125 VPWR.n124 72.7879
R363 VPWR.n128 VPWR.n120 72.7879
R364 VPWR.n136 VPWR.n135 72.7879
R365 VPWR.n134 VPWR.n133 72.7879
R366 VPWR.n172 VPWR.n155 72.7879
R367 VPWR.n170 VPWR.n152 72.7879
R368 VPWR.n166 VPWR.n165 72.7879
R369 VPWR.n162 VPWR.n158 72.7879
R370 VPWR.n162 VPWR.n161 72.7879
R371 VPWR.n165 VPWR.n157 72.7879
R372 VPWR.n173 VPWR.n172 72.7879
R373 VPWR.n171 VPWR.n170 72.7879
R374 VPWR.n209 VPWR.n192 72.7879
R375 VPWR.n207 VPWR.n189 72.7879
R376 VPWR.n203 VPWR.n202 72.7879
R377 VPWR.n199 VPWR.n195 72.7879
R378 VPWR.n199 VPWR.n198 72.7879
R379 VPWR.n202 VPWR.n194 72.7879
R380 VPWR.n210 VPWR.n209 72.7879
R381 VPWR.n208 VPWR.n207 72.7879
R382 VPWR.n246 VPWR.n229 72.7879
R383 VPWR.n244 VPWR.n226 72.7879
R384 VPWR.n240 VPWR.n239 72.7879
R385 VPWR.n236 VPWR.n232 72.7879
R386 VPWR.n236 VPWR.n235 72.7879
R387 VPWR.n239 VPWR.n231 72.7879
R388 VPWR.n247 VPWR.n246 72.7879
R389 VPWR.n245 VPWR.n244 72.7879
R390 VPWR.n283 VPWR.n266 72.7879
R391 VPWR.n281 VPWR.n263 72.7879
R392 VPWR.n277 VPWR.n276 72.7879
R393 VPWR.n273 VPWR.n269 72.7879
R394 VPWR.n273 VPWR.n272 72.7879
R395 VPWR.n276 VPWR.n268 72.7879
R396 VPWR.n284 VPWR.n283 72.7879
R397 VPWR.n282 VPWR.n281 72.7879
R398 VPWR.n320 VPWR.n303 72.7879
R399 VPWR.n318 VPWR.n300 72.7879
R400 VPWR.n314 VPWR.n313 72.7879
R401 VPWR.n310 VPWR.n306 72.7879
R402 VPWR.n310 VPWR.n309 72.7879
R403 VPWR.n313 VPWR.n305 72.7879
R404 VPWR.n321 VPWR.n320 72.7879
R405 VPWR.n319 VPWR.n318 72.7879
R406 VPWR.n24 VPWR.n7 72.7879
R407 VPWR.n22 VPWR.n4 72.7879
R408 VPWR.n18 VPWR.n17 72.7879
R409 VPWR.n14 VPWR.n10 72.7879
R410 VPWR.n14 VPWR.n13 72.7879
R411 VPWR.n17 VPWR.n9 72.7879
R412 VPWR.n25 VPWR.n24 72.7879
R413 VPWR.n23 VPWR.n22 72.7879
R414 VPWR.n52 VPWR.t12 56.8667
R415 VPWR.n67 VPWR.t12 56.8667
R416 VPWR.n89 VPWR.t10 56.8667
R417 VPWR.n104 VPWR.t10 56.8667
R418 VPWR.n126 VPWR.t6 56.8667
R419 VPWR.n141 VPWR.t6 56.8667
R420 VPWR.n163 VPWR.t16 56.8667
R421 VPWR.n178 VPWR.t16 56.8667
R422 VPWR.n200 VPWR.t2 56.8667
R423 VPWR.n215 VPWR.t2 56.8667
R424 VPWR.n237 VPWR.t0 56.8667
R425 VPWR.n252 VPWR.t0 56.8667
R426 VPWR.n274 VPWR.t14 56.8667
R427 VPWR.n289 VPWR.t14 56.8667
R428 VPWR.n311 VPWR.t8 56.8667
R429 VPWR.n326 VPWR.t8 56.8667
R430 VPWR.n15 VPWR.t4 56.8667
R431 VPWR.n30 VPWR.t4 56.8667
R432 VPWR.n53 VPWR.n51 56.1076
R433 VPWR.n54 VPWR.n53 56.1076
R434 VPWR.n61 VPWR.n42 56.1076
R435 VPWR.n59 VPWR.n42 56.1076
R436 VPWR.n90 VPWR.n88 56.1076
R437 VPWR.n91 VPWR.n90 56.1076
R438 VPWR.n98 VPWR.n79 56.1076
R439 VPWR.n96 VPWR.n79 56.1076
R440 VPWR.n127 VPWR.n125 56.1076
R441 VPWR.n128 VPWR.n127 56.1076
R442 VPWR.n135 VPWR.n116 56.1076
R443 VPWR.n133 VPWR.n116 56.1076
R444 VPWR.n164 VPWR.n162 56.1076
R445 VPWR.n165 VPWR.n164 56.1076
R446 VPWR.n172 VPWR.n153 56.1076
R447 VPWR.n170 VPWR.n153 56.1076
R448 VPWR.n201 VPWR.n199 56.1076
R449 VPWR.n202 VPWR.n201 56.1076
R450 VPWR.n209 VPWR.n190 56.1076
R451 VPWR.n207 VPWR.n190 56.1076
R452 VPWR.n238 VPWR.n236 56.1076
R453 VPWR.n239 VPWR.n238 56.1076
R454 VPWR.n246 VPWR.n227 56.1076
R455 VPWR.n244 VPWR.n227 56.1076
R456 VPWR.n275 VPWR.n273 56.1076
R457 VPWR.n276 VPWR.n275 56.1076
R458 VPWR.n283 VPWR.n264 56.1076
R459 VPWR.n281 VPWR.n264 56.1076
R460 VPWR.n312 VPWR.n310 56.1076
R461 VPWR.n313 VPWR.n312 56.1076
R462 VPWR.n320 VPWR.n301 56.1076
R463 VPWR.n318 VPWR.n301 56.1076
R464 VPWR.n16 VPWR.n14 56.1076
R465 VPWR.n17 VPWR.n16 56.1076
R466 VPWR.n24 VPWR.n5 56.1076
R467 VPWR.n22 VPWR.n5 56.1076
R468 VPWR.n56 VPWR.n45 25.6005
R469 VPWR.n48 VPWR.n45 25.6005
R470 VPWR.n49 VPWR.n48 25.6005
R471 VPWR.n65 VPWR.n57 25.6005
R472 VPWR.n64 VPWR.n63 25.6005
R473 VPWR.n63 VPWR.n58 25.6005
R474 VPWR.n58 VPWR.n39 25.6005
R475 VPWR.n93 VPWR.n82 25.6005
R476 VPWR.n85 VPWR.n82 25.6005
R477 VPWR.n86 VPWR.n85 25.6005
R478 VPWR.n102 VPWR.n94 25.6005
R479 VPWR.n101 VPWR.n100 25.6005
R480 VPWR.n100 VPWR.n95 25.6005
R481 VPWR.n95 VPWR.n76 25.6005
R482 VPWR.n130 VPWR.n119 25.6005
R483 VPWR.n122 VPWR.n119 25.6005
R484 VPWR.n123 VPWR.n122 25.6005
R485 VPWR.n139 VPWR.n131 25.6005
R486 VPWR.n138 VPWR.n137 25.6005
R487 VPWR.n137 VPWR.n132 25.6005
R488 VPWR.n132 VPWR.n113 25.6005
R489 VPWR.n167 VPWR.n156 25.6005
R490 VPWR.n159 VPWR.n156 25.6005
R491 VPWR.n160 VPWR.n159 25.6005
R492 VPWR.n176 VPWR.n168 25.6005
R493 VPWR.n175 VPWR.n174 25.6005
R494 VPWR.n174 VPWR.n169 25.6005
R495 VPWR.n169 VPWR.n150 25.6005
R496 VPWR.n204 VPWR.n193 25.6005
R497 VPWR.n196 VPWR.n193 25.6005
R498 VPWR.n197 VPWR.n196 25.6005
R499 VPWR.n213 VPWR.n205 25.6005
R500 VPWR.n212 VPWR.n211 25.6005
R501 VPWR.n211 VPWR.n206 25.6005
R502 VPWR.n206 VPWR.n187 25.6005
R503 VPWR.n241 VPWR.n230 25.6005
R504 VPWR.n233 VPWR.n230 25.6005
R505 VPWR.n234 VPWR.n233 25.6005
R506 VPWR.n250 VPWR.n242 25.6005
R507 VPWR.n249 VPWR.n248 25.6005
R508 VPWR.n248 VPWR.n243 25.6005
R509 VPWR.n243 VPWR.n224 25.6005
R510 VPWR.n278 VPWR.n267 25.6005
R511 VPWR.n270 VPWR.n267 25.6005
R512 VPWR.n271 VPWR.n270 25.6005
R513 VPWR.n287 VPWR.n279 25.6005
R514 VPWR.n286 VPWR.n285 25.6005
R515 VPWR.n285 VPWR.n280 25.6005
R516 VPWR.n280 VPWR.n261 25.6005
R517 VPWR.n315 VPWR.n304 25.6005
R518 VPWR.n307 VPWR.n304 25.6005
R519 VPWR.n308 VPWR.n307 25.6005
R520 VPWR.n324 VPWR.n316 25.6005
R521 VPWR.n323 VPWR.n322 25.6005
R522 VPWR.n322 VPWR.n317 25.6005
R523 VPWR.n317 VPWR.n298 25.6005
R524 VPWR.n19 VPWR.n8 25.6005
R525 VPWR.n11 VPWR.n8 25.6005
R526 VPWR.n12 VPWR.n11 25.6005
R527 VPWR.n28 VPWR.n20 25.6005
R528 VPWR.n27 VPWR.n26 25.6005
R529 VPWR.n26 VPWR.n21 25.6005
R530 VPWR.n21 VPWR.n2 25.6005
R531 VPWR.n70 VPWR 18.865
R532 VPWR.n107 VPWR 18.865
R533 VPWR.n144 VPWR 18.865
R534 VPWR.n181 VPWR 18.865
R535 VPWR.n218 VPWR 18.865
R536 VPWR.n255 VPWR 18.865
R537 VPWR.n292 VPWR 18.865
R538 VPWR.n329 VPWR 18.865
R539 VPWR.n33 VPWR 18.865
R540 VPWR VPWR.n34 12.8005
R541 VPWR.n35 VPWR 12.8005
R542 VPWR VPWR.n38 12.8005
R543 VPWR VPWR.n69 12.8005
R544 VPWR VPWR.n71 12.8005
R545 VPWR.n72 VPWR 12.8005
R546 VPWR VPWR.n75 12.8005
R547 VPWR VPWR.n106 12.8005
R548 VPWR VPWR.n108 12.8005
R549 VPWR.n109 VPWR 12.8005
R550 VPWR VPWR.n112 12.8005
R551 VPWR VPWR.n143 12.8005
R552 VPWR VPWR.n145 12.8005
R553 VPWR.n146 VPWR 12.8005
R554 VPWR VPWR.n149 12.8005
R555 VPWR VPWR.n180 12.8005
R556 VPWR VPWR.n182 12.8005
R557 VPWR.n183 VPWR 12.8005
R558 VPWR VPWR.n186 12.8005
R559 VPWR VPWR.n217 12.8005
R560 VPWR VPWR.n219 12.8005
R561 VPWR.n220 VPWR 12.8005
R562 VPWR VPWR.n223 12.8005
R563 VPWR VPWR.n254 12.8005
R564 VPWR VPWR.n256 12.8005
R565 VPWR.n257 VPWR 12.8005
R566 VPWR VPWR.n260 12.8005
R567 VPWR VPWR.n291 12.8005
R568 VPWR VPWR.n293 12.8005
R569 VPWR.n294 VPWR 12.8005
R570 VPWR VPWR.n297 12.8005
R571 VPWR VPWR.n328 12.8005
R572 VPWR VPWR.n0 12.8005
R573 VPWR VPWR.n331 12.8005
R574 VPWR VPWR.n1 12.8005
R575 VPWR VPWR.n32 12.8005
R576 VPWR.n330 VPWR.n329 10.6855
R577 VPWR.n37 VPWR.n36 10.5563
R578 VPWR.n74 VPWR.n73 10.5563
R579 VPWR.n111 VPWR.n110 10.5563
R580 VPWR.n148 VPWR.n147 10.5563
R581 VPWR.n185 VPWR.n184 10.5563
R582 VPWR.n222 VPWR.n221 10.5563
R583 VPWR.n259 VPWR.n258 10.5563
R584 VPWR.n296 VPWR.n295 10.5563
R585 VPWR.n36 VPWR.n34 10.1513
R586 VPWR.n36 VPWR.n35 10.1513
R587 VPWR.n73 VPWR.n71 10.1513
R588 VPWR.n73 VPWR.n72 10.1513
R589 VPWR.n110 VPWR.n108 10.1513
R590 VPWR.n110 VPWR.n109 10.1513
R591 VPWR.n147 VPWR.n145 10.1513
R592 VPWR.n147 VPWR.n146 10.1513
R593 VPWR.n184 VPWR.n182 10.1513
R594 VPWR.n184 VPWR.n183 10.1513
R595 VPWR.n221 VPWR.n219 10.1513
R596 VPWR.n221 VPWR.n220 10.1513
R597 VPWR.n258 VPWR.n256 10.1513
R598 VPWR.n258 VPWR.n257 10.1513
R599 VPWR.n295 VPWR.n293 10.1513
R600 VPWR.n295 VPWR.n294 10.1513
R601 VPWR.n330 VPWR.n0 10.1513
R602 VPWR.n331 VPWR.n330 10.1513
R603 VPWR.n329 VPWR.n296 1.50567
R604 VPWR.n292 VPWR.n259 1.50567
R605 VPWR.n255 VPWR.n222 1.50567
R606 VPWR.n218 VPWR.n185 1.50567
R607 VPWR.n181 VPWR.n148 1.50567
R608 VPWR.n144 VPWR.n111 1.50567
R609 VPWR.n107 VPWR.n74 1.50567
R610 VPWR.n70 VPWR.n37 1.50567
R611 VPWR.n33 VPWR 0.353587
R612 VPWR.n296 VPWR.n292 0.12975
R613 VPWR.n259 VPWR.n255 0.12975
R614 VPWR.n222 VPWR.n218 0.12975
R615 VPWR.n185 VPWR.n181 0.12975
R616 VPWR.n148 VPWR.n144 0.12975
R617 VPWR.n111 VPWR.n107 0.12975
R618 VPWR.n74 VPWR.n70 0.12975
R619 VPWR.n37 VPWR.n33 0.12975
R620 A A.t1 330.341
R621 A A.t3 330.341
R622 A A.t2 315.88
R623 A A.t0 315.88
R624 A A.n2 30.1999
R625 A.n1 A 29.3827
R626 A.n2 A 29.3671
R627 A.n0 A 29.3671
R628 A.n2 A.n1 2.47564
R629 A.n1 A.n0 0.817713
R630 A.n0 A 0.567438
R631 CORE__N2__N1.t1 CORE__N2__N1.n1 255.345
R632 CORE__N2__N1.n2 CORE__N2__N1.t1 255.345
R633 CORE__N2__N1.t0 CORE__N2__N1.n0 255.345
R634 CORE__N2__N1.n5 CORE__N2__N1.t0 255.345
R635 CORE__N2__N1.n4 CORE__N2__N1.n3 25.6012
R636 CORE__N2__N1 CORE__N2__N1.n1 12.8005
R637 CORE__N2__N1.n2 CORE__N2__N1 12.8005
R638 CORE__N2__N1 CORE__N2__N1.n0 12.8005
R639 CORE__N2__N1 CORE__N2__N1.n5 12.8005
R640 CORE__N2__N1.n3 CORE__N2__N1.n1 10.1513
R641 CORE__N2__N1.n3 CORE__N2__N1.n2 10.1513
R642 CORE__N2__N1.n4 CORE__N2__N1.n0 10.1513
R643 CORE__N2__N1.n5 CORE__N2__N1.n4 10.1513
R644 VGND.n285 VGND.n284 3773.63
R645 VGND.n222 VGND.n221 3385.71
R646 VGND.n231 VGND.n230 3385.71
R647 VGND.n240 VGND.n239 3385.71
R648 VGND.n249 VGND.n248 3385.71
R649 VGND.n258 VGND.n257 3385.71
R650 VGND.n267 VGND.n266 3385.71
R651 VGND.n276 VGND.n275 3385.71
R652 VGND.n282 VGND.n12 1315.26
R653 VGND.n278 VGND.n13 1315.26
R654 VGND.n100 VGND.n11 1315.26
R655 VGND.n107 VGND.n106 1315.26
R656 VGND.n273 VGND.n22 1315.26
R657 VGND.n269 VGND.n23 1315.26
R658 VGND.n114 VGND.n21 1315.26
R659 VGND.n121 VGND.n120 1315.26
R660 VGND.n264 VGND.n32 1315.26
R661 VGND.n260 VGND.n33 1315.26
R662 VGND.n132 VGND.n31 1315.26
R663 VGND.n139 VGND.n138 1315.26
R664 VGND.n255 VGND.n42 1315.26
R665 VGND.n251 VGND.n43 1315.26
R666 VGND.n146 VGND.n41 1315.26
R667 VGND.n153 VGND.n152 1315.26
R668 VGND.n246 VGND.n52 1315.26
R669 VGND.n242 VGND.n53 1315.26
R670 VGND.n164 VGND.n51 1315.26
R671 VGND.n171 VGND.n170 1315.26
R672 VGND.n237 VGND.n62 1315.26
R673 VGND.n233 VGND.n63 1315.26
R674 VGND.n178 VGND.n61 1315.26
R675 VGND.n185 VGND.n184 1315.26
R676 VGND.n228 VGND.n72 1315.26
R677 VGND.n224 VGND.n73 1315.26
R678 VGND.n196 VGND.n71 1315.26
R679 VGND.n203 VGND.n202 1315.26
R680 VGND.n219 VGND.n82 1315.26
R681 VGND.n215 VGND.n83 1315.26
R682 VGND.n93 VGND.n81 1315.26
R683 VGND.n207 VGND.n88 1315.26
R684 VGND.n298 VGND.n286 1315.26
R685 VGND.n309 VGND.n287 1315.26
R686 VGND.n311 VGND.n8 1315.26
R687 VGND.n293 VGND.n7 1315.26
R688 VGND.n216 VGND.n215 585
R689 VGND.n86 VGND.n85 585
R690 VGND.n211 VGND.n210 585
R691 VGND.n209 VGND.n88 585
R692 VGND.n208 VGND.n207 585
R693 VGND.n207 VGND.n87 585
R694 VGND.n95 VGND.n81 585
R695 VGND.n220 VGND.n81 585
R696 VGND.n94 VGND.n93 585
R697 VGND.n92 VGND.n91 585
R698 VGND.n90 VGND.n89 585
R699 VGND.n84 VGND.n82 585
R700 VGND.n219 VGND.n218 585
R701 VGND.n220 VGND.n219 585
R702 VGND.n217 VGND.n83 585
R703 VGND.n87 VGND.n83 585
R704 VGND.n225 VGND.n224 585
R705 VGND.n76 VGND.n75 585
R706 VGND.n200 VGND.n199 585
R707 VGND.n202 VGND.n201 585
R708 VGND.n204 VGND.n203 585
R709 VGND.n203 VGND.n77 585
R710 VGND.n198 VGND.n71 585
R711 VGND.n229 VGND.n71 585
R712 VGND.n197 VGND.n196 585
R713 VGND.n195 VGND.n194 585
R714 VGND.n193 VGND.n192 585
R715 VGND.n74 VGND.n72 585
R716 VGND.n228 VGND.n227 585
R717 VGND.n229 VGND.n228 585
R718 VGND.n226 VGND.n73 585
R719 VGND.n77 VGND.n73 585
R720 VGND.n234 VGND.n233 585
R721 VGND.n66 VGND.n65 585
R722 VGND.n182 VGND.n181 585
R723 VGND.n184 VGND.n183 585
R724 VGND.n186 VGND.n185 585
R725 VGND.n185 VGND.n67 585
R726 VGND.n180 VGND.n61 585
R727 VGND.n238 VGND.n61 585
R728 VGND.n179 VGND.n178 585
R729 VGND.n177 VGND.n176 585
R730 VGND.n175 VGND.n174 585
R731 VGND.n64 VGND.n62 585
R732 VGND.n237 VGND.n236 585
R733 VGND.n238 VGND.n237 585
R734 VGND.n235 VGND.n63 585
R735 VGND.n67 VGND.n63 585
R736 VGND.n243 VGND.n242 585
R737 VGND.n56 VGND.n55 585
R738 VGND.n168 VGND.n167 585
R739 VGND.n170 VGND.n169 585
R740 VGND.n172 VGND.n171 585
R741 VGND.n171 VGND.n57 585
R742 VGND.n166 VGND.n51 585
R743 VGND.n247 VGND.n51 585
R744 VGND.n165 VGND.n164 585
R745 VGND.n163 VGND.n162 585
R746 VGND.n161 VGND.n160 585
R747 VGND.n54 VGND.n52 585
R748 VGND.n246 VGND.n245 585
R749 VGND.n247 VGND.n246 585
R750 VGND.n244 VGND.n53 585
R751 VGND.n57 VGND.n53 585
R752 VGND.n252 VGND.n251 585
R753 VGND.n46 VGND.n45 585
R754 VGND.n150 VGND.n149 585
R755 VGND.n152 VGND.n151 585
R756 VGND.n154 VGND.n153 585
R757 VGND.n153 VGND.n47 585
R758 VGND.n148 VGND.n41 585
R759 VGND.n256 VGND.n41 585
R760 VGND.n147 VGND.n146 585
R761 VGND.n145 VGND.n144 585
R762 VGND.n143 VGND.n142 585
R763 VGND.n44 VGND.n42 585
R764 VGND.n255 VGND.n254 585
R765 VGND.n256 VGND.n255 585
R766 VGND.n253 VGND.n43 585
R767 VGND.n47 VGND.n43 585
R768 VGND.n261 VGND.n260 585
R769 VGND.n36 VGND.n35 585
R770 VGND.n136 VGND.n135 585
R771 VGND.n138 VGND.n137 585
R772 VGND.n140 VGND.n139 585
R773 VGND.n139 VGND.n37 585
R774 VGND.n134 VGND.n31 585
R775 VGND.n265 VGND.n31 585
R776 VGND.n133 VGND.n132 585
R777 VGND.n131 VGND.n130 585
R778 VGND.n129 VGND.n128 585
R779 VGND.n34 VGND.n32 585
R780 VGND.n264 VGND.n263 585
R781 VGND.n265 VGND.n264 585
R782 VGND.n262 VGND.n33 585
R783 VGND.n37 VGND.n33 585
R784 VGND.n270 VGND.n269 585
R785 VGND.n26 VGND.n25 585
R786 VGND.n118 VGND.n117 585
R787 VGND.n120 VGND.n119 585
R788 VGND.n122 VGND.n121 585
R789 VGND.n121 VGND.n27 585
R790 VGND.n116 VGND.n21 585
R791 VGND.n274 VGND.n21 585
R792 VGND.n115 VGND.n114 585
R793 VGND.n113 VGND.n112 585
R794 VGND.n111 VGND.n110 585
R795 VGND.n24 VGND.n22 585
R796 VGND.n273 VGND.n272 585
R797 VGND.n274 VGND.n273 585
R798 VGND.n271 VGND.n23 585
R799 VGND.n27 VGND.n23 585
R800 VGND.n279 VGND.n278 585
R801 VGND.n16 VGND.n15 585
R802 VGND.n104 VGND.n103 585
R803 VGND.n106 VGND.n105 585
R804 VGND.n108 VGND.n107 585
R805 VGND.n107 VGND.n17 585
R806 VGND.n102 VGND.n11 585
R807 VGND.n283 VGND.n11 585
R808 VGND.n101 VGND.n100 585
R809 VGND.n99 VGND.n98 585
R810 VGND.n97 VGND.n96 585
R811 VGND.n14 VGND.n12 585
R812 VGND.n282 VGND.n281 585
R813 VGND.n283 VGND.n282 585
R814 VGND.n280 VGND.n13 585
R815 VGND.n17 VGND.n13 585
R816 VGND.n293 VGND.n292 585
R817 VGND.n291 VGND.n290 585
R818 VGND.n289 VGND.n288 585
R819 VGND.n299 VGND.n298 585
R820 VGND.n300 VGND.n286 585
R821 VGND.n295 VGND.n286 585
R822 VGND.n309 VGND.n308 585
R823 VGND.n310 VGND.n309 585
R824 VGND.n307 VGND.n287 585
R825 VGND.n306 VGND.n305 585
R826 VGND.n303 VGND.n301 585
R827 VGND.n8 VGND.n6 585
R828 VGND.n312 VGND.n311 585
R829 VGND.n311 VGND.n310 585
R830 VGND.n7 VGND.n5 585
R831 VGND.n295 VGND.n7 585
R832 VGND.n282 VGND.n13 394
R833 VGND.n98 VGND.n97 394
R834 VGND.n107 VGND.n11 394
R835 VGND.n103 VGND.n16 394
R836 VGND.n273 VGND.n23 394
R837 VGND.n112 VGND.n111 394
R838 VGND.n121 VGND.n21 394
R839 VGND.n117 VGND.n26 394
R840 VGND.n264 VGND.n33 394
R841 VGND.n130 VGND.n129 394
R842 VGND.n139 VGND.n31 394
R843 VGND.n135 VGND.n36 394
R844 VGND.n255 VGND.n43 394
R845 VGND.n144 VGND.n143 394
R846 VGND.n153 VGND.n41 394
R847 VGND.n149 VGND.n46 394
R848 VGND.n246 VGND.n53 394
R849 VGND.n162 VGND.n161 394
R850 VGND.n171 VGND.n51 394
R851 VGND.n167 VGND.n56 394
R852 VGND.n237 VGND.n63 394
R853 VGND.n176 VGND.n175 394
R854 VGND.n185 VGND.n61 394
R855 VGND.n181 VGND.n66 394
R856 VGND.n228 VGND.n73 394
R857 VGND.n194 VGND.n193 394
R858 VGND.n203 VGND.n71 394
R859 VGND.n199 VGND.n76 394
R860 VGND.n219 VGND.n83 394
R861 VGND.n91 VGND.n90 394
R862 VGND.n207 VGND.n81 394
R863 VGND.n211 VGND.n86 394
R864 VGND.n309 VGND.n286 394
R865 VGND.n305 VGND.n303 394
R866 VGND.n311 VGND.n7 394
R867 VGND.n290 VGND.n289 394
R868 VGND.n296 VGND.n295 359.421
R869 VGND.n310 VGND.n285 359.421
R870 VGND.t12 VGND.n188 255.345
R871 VGND.n189 VGND.t12 255.345
R872 VGND.t1 VGND.n156 255.345
R873 VGND.n157 VGND.t1 255.345
R874 VGND.t6 VGND.n124 255.345
R875 VGND.n125 VGND.t6 255.345
R876 VGND.t10 VGND.n1 255.345
R877 VGND.n2 VGND.t10 255.345
R878 VGND.t8 VGND.n0 255.345
R879 VGND.n315 VGND.t8 255.345
R880 VGND.n214 VGND.n213 218.815
R881 VGND.n213 VGND.n212 218.815
R882 VGND.n221 VGND.n80 218.815
R883 VGND.n221 VGND.n79 218.815
R884 VGND.n223 VGND.n222 218.815
R885 VGND.n222 VGND.n78 218.815
R886 VGND.n230 VGND.n70 218.815
R887 VGND.n230 VGND.n69 218.815
R888 VGND.n232 VGND.n231 218.815
R889 VGND.n231 VGND.n68 218.815
R890 VGND.n239 VGND.n60 218.815
R891 VGND.n239 VGND.n59 218.815
R892 VGND.n241 VGND.n240 218.815
R893 VGND.n240 VGND.n58 218.815
R894 VGND.n248 VGND.n50 218.815
R895 VGND.n248 VGND.n49 218.815
R896 VGND.n250 VGND.n249 218.815
R897 VGND.n249 VGND.n48 218.815
R898 VGND.n257 VGND.n40 218.815
R899 VGND.n257 VGND.n39 218.815
R900 VGND.n259 VGND.n258 218.815
R901 VGND.n258 VGND.n38 218.815
R902 VGND.n266 VGND.n30 218.815
R903 VGND.n266 VGND.n29 218.815
R904 VGND.n268 VGND.n267 218.815
R905 VGND.n267 VGND.n28 218.815
R906 VGND.n275 VGND.n20 218.815
R907 VGND.n275 VGND.n19 218.815
R908 VGND.n277 VGND.n276 218.815
R909 VGND.n276 VGND.n18 218.815
R910 VGND.n284 VGND.n10 218.815
R911 VGND.n284 VGND.n9 218.815
R912 VGND.n296 VGND.n294 218.815
R913 VGND.n297 VGND.n296 218.815
R914 VGND.n304 VGND.n285 218.815
R915 VGND.n302 VGND.n285 218.815
R916 VGND.n221 VGND.n220 161.995
R917 VGND.n213 VGND.n87 161.995
R918 VGND.n230 VGND.n229 161.995
R919 VGND.n222 VGND.n77 161.995
R920 VGND.n239 VGND.n238 161.995
R921 VGND.n231 VGND.n67 161.995
R922 VGND.n248 VGND.n247 161.995
R923 VGND.n240 VGND.n57 161.995
R924 VGND.n257 VGND.n256 161.995
R925 VGND.n249 VGND.n47 161.995
R926 VGND.n266 VGND.n265 161.995
R927 VGND.n258 VGND.n37 161.995
R928 VGND.n275 VGND.n274 161.995
R929 VGND.n267 VGND.n27 161.995
R930 VGND.n284 VGND.n283 161.995
R931 VGND.n276 VGND.n17 161.995
R932 VGND.n97 VGND.n9 147.374
R933 VGND.n100 VGND.n10 147.374
R934 VGND.n278 VGND.n277 147.374
R935 VGND.n106 VGND.n18 147.374
R936 VGND.n111 VGND.n19 147.374
R937 VGND.n114 VGND.n20 147.374
R938 VGND.n269 VGND.n268 147.374
R939 VGND.n120 VGND.n28 147.374
R940 VGND.n129 VGND.n29 147.374
R941 VGND.n132 VGND.n30 147.374
R942 VGND.n260 VGND.n259 147.374
R943 VGND.n138 VGND.n38 147.374
R944 VGND.n143 VGND.n39 147.374
R945 VGND.n146 VGND.n40 147.374
R946 VGND.n251 VGND.n250 147.374
R947 VGND.n152 VGND.n48 147.374
R948 VGND.n161 VGND.n49 147.374
R949 VGND.n164 VGND.n50 147.374
R950 VGND.n242 VGND.n241 147.374
R951 VGND.n170 VGND.n58 147.374
R952 VGND.n175 VGND.n59 147.374
R953 VGND.n178 VGND.n60 147.374
R954 VGND.n233 VGND.n232 147.374
R955 VGND.n184 VGND.n68 147.374
R956 VGND.n193 VGND.n69 147.374
R957 VGND.n196 VGND.n70 147.374
R958 VGND.n224 VGND.n223 147.374
R959 VGND.n202 VGND.n78 147.374
R960 VGND.n90 VGND.n79 147.374
R961 VGND.n93 VGND.n80 147.374
R962 VGND.n215 VGND.n214 147.374
R963 VGND.n212 VGND.n88 147.374
R964 VGND.n214 VGND.n86 147.374
R965 VGND.n212 VGND.n211 147.374
R966 VGND.n91 VGND.n80 147.374
R967 VGND.n82 VGND.n79 147.374
R968 VGND.n223 VGND.n76 147.374
R969 VGND.n199 VGND.n78 147.374
R970 VGND.n194 VGND.n70 147.374
R971 VGND.n72 VGND.n69 147.374
R972 VGND.n232 VGND.n66 147.374
R973 VGND.n181 VGND.n68 147.374
R974 VGND.n176 VGND.n60 147.374
R975 VGND.n62 VGND.n59 147.374
R976 VGND.n241 VGND.n56 147.374
R977 VGND.n167 VGND.n58 147.374
R978 VGND.n162 VGND.n50 147.374
R979 VGND.n52 VGND.n49 147.374
R980 VGND.n250 VGND.n46 147.374
R981 VGND.n149 VGND.n48 147.374
R982 VGND.n144 VGND.n40 147.374
R983 VGND.n42 VGND.n39 147.374
R984 VGND.n259 VGND.n36 147.374
R985 VGND.n135 VGND.n38 147.374
R986 VGND.n130 VGND.n30 147.374
R987 VGND.n32 VGND.n29 147.374
R988 VGND.n268 VGND.n26 147.374
R989 VGND.n117 VGND.n28 147.374
R990 VGND.n112 VGND.n20 147.374
R991 VGND.n22 VGND.n19 147.374
R992 VGND.n277 VGND.n16 147.374
R993 VGND.n103 VGND.n18 147.374
R994 VGND.n98 VGND.n10 147.374
R995 VGND.n12 VGND.n9 147.374
R996 VGND.n304 VGND.n287 147.374
R997 VGND.n302 VGND.n8 147.374
R998 VGND.n298 VGND.n297 147.374
R999 VGND.n294 VGND.n290 147.374
R1000 VGND.n294 VGND.n293 147.374
R1001 VGND.n297 VGND.n289 147.374
R1002 VGND.n305 VGND.n304 147.374
R1003 VGND.n303 VGND.n302 147.374
R1004 VGND.n295 VGND.t7 98.5512
R1005 VGND.n310 VGND.t7 98.5512
R1006 VGND.n281 VGND.n14 85.4593
R1007 VGND.n280 VGND.n279 85.4593
R1008 VGND.n102 VGND.n101 85.4593
R1009 VGND.n108 VGND.n105 85.4593
R1010 VGND.n272 VGND.n24 85.4593
R1011 VGND.n271 VGND.n270 85.4593
R1012 VGND.n116 VGND.n115 85.4593
R1013 VGND.n122 VGND.n119 85.4593
R1014 VGND.n263 VGND.n34 85.4593
R1015 VGND.n262 VGND.n261 85.4593
R1016 VGND.n134 VGND.n133 85.4593
R1017 VGND.n140 VGND.n137 85.4593
R1018 VGND.n254 VGND.n44 85.4593
R1019 VGND.n253 VGND.n252 85.4593
R1020 VGND.n148 VGND.n147 85.4593
R1021 VGND.n154 VGND.n151 85.4593
R1022 VGND.n245 VGND.n54 85.4593
R1023 VGND.n244 VGND.n243 85.4593
R1024 VGND.n166 VGND.n165 85.4593
R1025 VGND.n172 VGND.n169 85.4593
R1026 VGND.n236 VGND.n64 85.4593
R1027 VGND.n235 VGND.n234 85.4593
R1028 VGND.n180 VGND.n179 85.4593
R1029 VGND.n186 VGND.n183 85.4593
R1030 VGND.n227 VGND.n74 85.4593
R1031 VGND.n198 VGND.n197 85.4593
R1032 VGND.n226 VGND.n225 85.4593
R1033 VGND.n204 VGND.n201 85.4593
R1034 VGND.n218 VGND.n84 85.4593
R1035 VGND.n217 VGND.n216 85.4593
R1036 VGND.n95 VGND.n94 85.4593
R1037 VGND.n209 VGND.n208 85.4593
R1038 VGND.n300 VGND.n299 85.4593
R1039 VGND.n292 VGND.n5 85.4593
R1040 VGND.n308 VGND.n307 85.4593
R1041 VGND.n312 VGND.n6 85.4593
R1042 VGND.n220 VGND.t3 44.4186
R1043 VGND.n87 VGND.t3 44.4186
R1044 VGND.n229 VGND.t11 44.4186
R1045 VGND.n77 VGND.t11 44.4186
R1046 VGND.n238 VGND.t4 44.4186
R1047 VGND.n67 VGND.t4 44.4186
R1048 VGND.n247 VGND.t0 44.4186
R1049 VGND.n57 VGND.t0 44.4186
R1050 VGND.n256 VGND.t13 44.4186
R1051 VGND.n47 VGND.t13 44.4186
R1052 VGND.n265 VGND.t5 44.4186
R1053 VGND.n37 VGND.t5 44.4186
R1054 VGND.n274 VGND.t2 44.4186
R1055 VGND.n27 VGND.t2 44.4186
R1056 VGND.n283 VGND.t9 44.4186
R1057 VGND.n17 VGND.t9 44.4186
R1058 VGND.n281 VGND.n280 25.6005
R1059 VGND.n96 VGND.n14 25.6005
R1060 VGND.n99 VGND.n96 25.6005
R1061 VGND.n101 VGND.n99 25.6005
R1062 VGND.n279 VGND.n15 25.6005
R1063 VGND.n104 VGND.n15 25.6005
R1064 VGND.n105 VGND.n104 25.6005
R1065 VGND.n272 VGND.n271 25.6005
R1066 VGND.n110 VGND.n24 25.6005
R1067 VGND.n113 VGND.n110 25.6005
R1068 VGND.n115 VGND.n113 25.6005
R1069 VGND.n270 VGND.n25 25.6005
R1070 VGND.n118 VGND.n25 25.6005
R1071 VGND.n119 VGND.n118 25.6005
R1072 VGND.n263 VGND.n262 25.6005
R1073 VGND.n128 VGND.n34 25.6005
R1074 VGND.n131 VGND.n128 25.6005
R1075 VGND.n133 VGND.n131 25.6005
R1076 VGND.n261 VGND.n35 25.6005
R1077 VGND.n136 VGND.n35 25.6005
R1078 VGND.n137 VGND.n136 25.6005
R1079 VGND.n254 VGND.n253 25.6005
R1080 VGND.n142 VGND.n44 25.6005
R1081 VGND.n145 VGND.n142 25.6005
R1082 VGND.n147 VGND.n145 25.6005
R1083 VGND.n252 VGND.n45 25.6005
R1084 VGND.n150 VGND.n45 25.6005
R1085 VGND.n151 VGND.n150 25.6005
R1086 VGND.n245 VGND.n244 25.6005
R1087 VGND.n160 VGND.n54 25.6005
R1088 VGND.n163 VGND.n160 25.6005
R1089 VGND.n165 VGND.n163 25.6005
R1090 VGND.n243 VGND.n55 25.6005
R1091 VGND.n168 VGND.n55 25.6005
R1092 VGND.n169 VGND.n168 25.6005
R1093 VGND.n236 VGND.n235 25.6005
R1094 VGND.n174 VGND.n64 25.6005
R1095 VGND.n177 VGND.n174 25.6005
R1096 VGND.n179 VGND.n177 25.6005
R1097 VGND.n234 VGND.n65 25.6005
R1098 VGND.n182 VGND.n65 25.6005
R1099 VGND.n183 VGND.n182 25.6005
R1100 VGND.n192 VGND.n74 25.6005
R1101 VGND.n195 VGND.n192 25.6005
R1102 VGND.n197 VGND.n195 25.6005
R1103 VGND.n227 VGND.n226 25.6005
R1104 VGND.n225 VGND.n75 25.6005
R1105 VGND.n200 VGND.n75 25.6005
R1106 VGND.n201 VGND.n200 25.6005
R1107 VGND.n218 VGND.n217 25.6005
R1108 VGND.n89 VGND.n84 25.6005
R1109 VGND.n92 VGND.n89 25.6005
R1110 VGND.n94 VGND.n92 25.6005
R1111 VGND.n216 VGND.n85 25.6005
R1112 VGND.n210 VGND.n85 25.6005
R1113 VGND.n210 VGND.n209 25.6005
R1114 VGND.n299 VGND.n288 25.6005
R1115 VGND.n291 VGND.n288 25.6005
R1116 VGND.n292 VGND.n291 25.6005
R1117 VGND.n308 VGND.n300 25.6005
R1118 VGND.n307 VGND.n306 25.6005
R1119 VGND.n306 VGND.n301 25.6005
R1120 VGND.n301 VGND.n6 25.6005
R1121 VGND.n109 VGND 18.3598
R1122 VGND.n123 VGND 18.3598
R1123 VGND.n141 VGND 18.3598
R1124 VGND.n155 VGND 18.3598
R1125 VGND.n173 VGND 18.3598
R1126 VGND.n187 VGND 18.3598
R1127 VGND.n205 VGND 18.3598
R1128 VGND VGND.n206 18.3598
R1129 VGND.n313 VGND 18.3598
R1130 VGND VGND.n156 12.8005
R1131 VGND.n157 VGND 12.8005
R1132 VGND VGND.n124 12.8005
R1133 VGND.n125 VGND 12.8005
R1134 VGND VGND.n1 12.8005
R1135 VGND.n2 VGND 12.8005
R1136 VGND VGND.n102 12.8005
R1137 VGND VGND.n108 12.8005
R1138 VGND VGND.n116 12.8005
R1139 VGND VGND.n122 12.8005
R1140 VGND VGND.n134 12.8005
R1141 VGND VGND.n140 12.8005
R1142 VGND VGND.n148 12.8005
R1143 VGND VGND.n154 12.8005
R1144 VGND VGND.n166 12.8005
R1145 VGND VGND.n172 12.8005
R1146 VGND VGND.n180 12.8005
R1147 VGND VGND.n186 12.8005
R1148 VGND VGND.n198 12.8005
R1149 VGND VGND.n204 12.8005
R1150 VGND VGND.n95 12.8005
R1151 VGND.n208 VGND 12.8005
R1152 VGND VGND.n5 12.8005
R1153 VGND VGND.n312 12.8005
R1154 VGND VGND.n0 12.8005
R1155 VGND VGND.n315 12.8005
R1156 VGND VGND.n188 12.8005
R1157 VGND.n189 VGND 12.8005
R1158 VGND.n314 VGND.n313 10.1647
R1159 VGND.n158 VGND.n156 10.1513
R1160 VGND.n158 VGND.n157 10.1513
R1161 VGND.n126 VGND.n124 10.1513
R1162 VGND.n126 VGND.n125 10.1513
R1163 VGND.n3 VGND.n1 10.1513
R1164 VGND.n3 VGND.n2 10.1513
R1165 VGND.n314 VGND.n0 10.1513
R1166 VGND.n315 VGND.n314 10.1513
R1167 VGND.n190 VGND.n188 10.1513
R1168 VGND.n190 VGND.n189 10.1513
R1169 VGND.n159 VGND.n158 10.0354
R1170 VGND.n127 VGND.n126 10.0354
R1171 VGND.n4 VGND.n3 10.0354
R1172 VGND.n191 VGND.n190 10.0354
R1173 VGND.n206 VGND.n205 1.64668
R1174 VGND.n123 VGND.n109 1.64668
R1175 VGND.n155 VGND.n141 1.64668
R1176 VGND.n187 VGND.n173 1.64668
R1177 VGND.n313 VGND.n4 1.50567
R1178 VGND.n127 VGND.n123 1.50567
R1179 VGND.n159 VGND.n155 1.50567
R1180 VGND.n191 VGND.n187 1.50567
R1181 VGND.n206 VGND 1.18255
R1182 VGND.n205 VGND.n191 0.12975
R1183 VGND.n109 VGND.n4 0.12975
R1184 VGND.n141 VGND.n127 0.12975
R1185 VGND.n173 VGND.n159 0.12975
R1186 CORE__N1.t2 CORE__N1.n4 700.484
R1187 CORE__N1.n5 CORE__N1.t2 700.484
R1188 CORE__N1.t0 CORE__N1.n0 700.484
R1189 CORE__N1.n13 CORE__N1.t0 700.484
R1190 CORE__N1 CORE__N1.t4 330.341
R1191 CORE__N1 CORE__N1.t3 330.341
R1192 CORE__N1 CORE__N1.t6 315.88
R1193 CORE__N1 CORE__N1.t5 315.88
R1194 CORE__N1.t1 CORE__N1.n8 255.345
R1195 CORE__N1.n9 CORE__N1.t1 255.345
R1196 CORE__N1.n1 CORE__N1 31.4499
R1197 CORE__N1.n2 CORE__N1 30.6327
R1198 CORE__N1.n3 CORE__N1 30.6171
R1199 CORE__N1.n1 CORE__N1 30.6171
R1200 CORE__N1 CORE__N1.n8 12.8005
R1201 CORE__N1.n9 CORE__N1 12.8005
R1202 CORE__N1 CORE__N1.n4 12.8005
R1203 CORE__N1.n5 CORE__N1 12.8005
R1204 CORE__N1 CORE__N1.n0 12.8005
R1205 CORE__N1 CORE__N1.n13 12.8005
R1206 CORE__N1.n12 CORE__N1.n11 12.1026
R1207 CORE__N1.n11 CORE__N1.n10 11.2854
R1208 CORE__N1.n7 CORE__N1.n6 11.2854
R1209 CORE__N1.n10 CORE__N1.n8 10.1513
R1210 CORE__N1.n10 CORE__N1.n9 10.1513
R1211 CORE__N1.n6 CORE__N1.n4 10.1513
R1212 CORE__N1.n6 CORE__N1.n5 10.1513
R1213 CORE__N1.n12 CORE__N1.n0 10.1513
R1214 CORE__N1.n13 CORE__N1.n12 10.1513
R1215 CORE__N1.n7 CORE__N1.n3 3.65945
R1216 CORE__N1.n2 CORE__N1.n1 2.47564
R1217 CORE__N1.n3 CORE__N1.n2 0.817713
R1218 CORE__N1.n11 CORE__N1.n7 0.817713
R1219 CORE__N3.t2 CORE__N3.n2 700.484
R1220 CORE__N3.n3 CORE__N3.t2 700.484
R1221 CORE__N3.t0 CORE__N3.n0 700.484
R1222 CORE__N3.n11 CORE__N3.t0 700.484
R1223 CORE__N3 CORE__N3.t4 330.341
R1224 CORE__N3 CORE__N3.t3 315.88
R1225 CORE__N3.t1 CORE__N3.n5 255.345
R1226 CORE__N3.n6 CORE__N3.t1 255.345
R1227 CORE__N3.n1 CORE__N3 30.1999
R1228 CORE__N3.n1 CORE__N3 29.3671
R1229 CORE__N3 CORE__N3.n5 12.8005
R1230 CORE__N3.n6 CORE__N3 12.8005
R1231 CORE__N3 CORE__N3.n2 12.8005
R1232 CORE__N3.n3 CORE__N3 12.8005
R1233 CORE__N3 CORE__N3.n0 12.8005
R1234 CORE__N3 CORE__N3.n11 12.8005
R1235 CORE__N3.n8 CORE__N3.n4 10.8526
R1236 CORE__N3.n7 CORE__N3.n5 10.1513
R1237 CORE__N3.n7 CORE__N3.n6 10.1513
R1238 CORE__N3.n4 CORE__N3.n2 10.1513
R1239 CORE__N3.n4 CORE__N3.n3 10.1513
R1240 CORE__N3.n10 CORE__N3.n0 10.1513
R1241 CORE__N3.n11 CORE__N3.n10 10.1513
R1242 CORE__N3.n8 CORE__N3.n7 10.0354
R1243 CORE__N3.n10 CORE__N3.n9 10.0354
R1244 CORE__N3.n9 CORE__N3.n1 3.65945
R1245 CORE__N3.n9 CORE__N3.n8 0.817713
R1246 B B.t3 330.341
R1247 B B.t0 330.341
R1248 B B.t1 315.88
R1249 B B.t2 315.88
R1250 B B.n2 30.6166
R1251 B.n1 B 29.7994
R1252 B.n2 B 29.7837
R1253 B.n0 B 29.7837
R1254 B.n2 B.n1 4.13356
R1255 B.n0 B 2.22536
R1256 B.n1 B.n0 0.817713
R1257 Y.t0 Y.n1 700.484
R1258 Y.n2 Y.t0 700.484
R1259 Y.t1 Y.n0 255.345
R1260 Y.n6 Y.t1 255.345
R1261 Y.n4 Y 13.476
R1262 Y Y.n0 12.8005
R1263 Y Y.n6 12.8005
R1264 Y Y.n1 12.8005
R1265 Y.n2 Y 12.8005
R1266 Y.n5 Y.n4 11.686
R1267 Y.n4 Y.n3 10.8688
R1268 Y.n5 Y.n0 10.1513
R1269 Y.n6 Y.n5 10.1513
R1270 Y.n3 Y.n1 10.1513
R1271 Y.n3 Y.n2 10.1513
R1272 CORE__N1__N1.t1 CORE__N1__N1.n1 255.345
R1273 CORE__N1__N1.n2 CORE__N1__N1.t1 255.345
R1274 CORE__N1__N1.t0 CORE__N1__N1.n0 255.345
R1275 CORE__N1__N1.n5 CORE__N1__N1.t0 255.345
R1276 CORE__N1__N1.n4 CORE__N1__N1.n3 24.7679
R1277 CORE__N1__N1 CORE__N1__N1.n1 12.8005
R1278 CORE__N1__N1.n2 CORE__N1__N1 12.8005
R1279 CORE__N1__N1 CORE__N1__N1.n0 12.8005
R1280 CORE__N1__N1 CORE__N1__N1.n5 12.8005
R1281 CORE__N1__N1.n3 CORE__N1__N1.n1 10.1513
R1282 CORE__N1__N1.n3 CORE__N1__N1.n2 10.1513
R1283 CORE__N1__N1.n4 CORE__N1__N1.n0 10.1513
R1284 CORE__N1__N1.n5 CORE__N1__N1.n4 10.1513
R1285 CORE__N4__N1.t1 CORE__N4__N1.n1 255.345
R1286 CORE__N4__N1.n2 CORE__N4__N1.t1 255.345
R1287 CORE__N4__N1.t0 CORE__N4__N1.n0 255.345
R1288 CORE__N4__N1.n5 CORE__N4__N1.t0 255.345
R1289 CORE__N4__N1.n4 CORE__N4__N1.n3 23.9345
R1290 CORE__N4__N1 CORE__N4__N1.n1 12.8005
R1291 CORE__N4__N1.n2 CORE__N4__N1 12.8005
R1292 CORE__N4__N1 CORE__N4__N1.n0 12.8005
R1293 CORE__N4__N1 CORE__N4__N1.n5 12.8005
R1294 CORE__N4__N1.n3 CORE__N4__N1.n1 10.1513
R1295 CORE__N4__N1.n3 CORE__N4__N1.n2 10.1513
R1296 CORE__N4__N1.n4 CORE__N4__N1.n0 10.1513
R1297 CORE__N4__N1.n5 CORE__N4__N1.n4 10.1513
R1298 CORE__N3__N1.t1 CORE__N3__N1.n1 255.345
R1299 CORE__N3__N1.n2 CORE__N3__N1.t1 255.345
R1300 CORE__N3__N1.t0 CORE__N3__N1.n0 255.345
R1301 CORE__N3__N1.n5 CORE__N3__N1.t0 255.345
R1302 CORE__N3__N1.n4 CORE__N3__N1.n3 25.6012
R1303 CORE__N3__N1 CORE__N3__N1.n1 12.8005
R1304 CORE__N3__N1.n2 CORE__N3__N1 12.8005
R1305 CORE__N3__N1 CORE__N3__N1.n0 12.8005
R1306 CORE__N3__N1 CORE__N3__N1.n5 12.8005
R1307 CORE__N3__N1.n3 CORE__N3__N1.n1 10.1513
R1308 CORE__N3__N1.n3 CORE__N3__N1.n2 10.1513
R1309 CORE__N3__N1.n4 CORE__N3__N1.n0 10.1513
R1310 CORE__N3__N1.n5 CORE__N3__N1.n4 10.1513
C50 Y VGND 8.94718f
C51 B VGND 5.22518f
C52 A VGND 4.34746f
C53 VPWR VGND 29.0572f
C54 CORE__N4__N1 VGND 1.8917f $ **FLOATING
C55 N VGND 3.98008f $ **FLOATING
C56 CORE__N3__N1 VGND 2.34631f $ **FLOATING
C57 CORE__N3 VGND 4.88994f $ **FLOATING
C58 CORE__N2__N1 VGND 2.23395f $ **FLOATING
C59 CORE__N2 VGND 6.24383f $ **FLOATING
C60 CORE__N1__N1 VGND 2.11301f $ **FLOATING
C61 CORE__N1 VGND 7.31288f $ **FLOATING
C62 Y.n0 VGND 0.014f $ **FLOATING
C63 Y.n1 VGND 0.01225f $ **FLOATING
C64 Y.t0 VGND 0.03752f $ **FLOATING
C65 Y.n2 VGND 0.01225f $ **FLOATING
C66 Y.n3 VGND 0.31388f $ **FLOATING
C67 Y.n4 VGND 6.48905f $ **FLOATING
C68 Y.n5 VGND 0.36112f $ **FLOATING
C69 Y.t1 VGND 0.03403f $ **FLOATING
C70 Y.n6 VGND 0.014f $ **FLOATING
C71 B.t3 VGND 0.04199f $ **FLOATING
C72 B.n0 VGND 1.28382f $ **FLOATING
C73 B.t1 VGND 0.04041f $ **FLOATING
C74 B.n1 VGND 1.87397f $ **FLOATING
C75 B.t0 VGND 0.04199f $ **FLOATING
C76 B.n2 VGND 2.46714f $ **FLOATING
C77 B.t2 VGND 0.04041f $ **FLOATING
C78 CORE__N1.n0 VGND 0.00876f $ **FLOATING
C79 CORE__N1.t5 VGND 0.03619f $ **FLOATING
C80 CORE__N1.t3 VGND 0.0376f $ **FLOATING
C81 CORE__N1.n1 VGND 1.97869f $ **FLOATING
C82 CORE__N1.t6 VGND 0.03619f $ **FLOATING
C83 CORE__N1.n2 VGND 1.33546f $ **FLOATING
C84 CORE__N1.t4 VGND 0.0376f $ **FLOATING
C85 CORE__N1.n3 VGND 1.65981f $ **FLOATING
C86 CORE__N1.n4 VGND 0.00876f $ **FLOATING
C87 CORE__N1.t2 VGND 0.02682f $ **FLOATING
C88 CORE__N1.n5 VGND 0.00876f $ **FLOATING
C89 CORE__N1.n6 VGND 0.25511f $ **FLOATING
C90 CORE__N1.n7 VGND 1.52153f $ **FLOATING
C91 CORE__N1.n8 VGND 0.01001f $ **FLOATING
C92 CORE__N1.t1 VGND 0.02433f $ **FLOATING
C93 CORE__N1.n9 VGND 0.01001f $ **FLOATING
C94 CORE__N1.n10 VGND 0.25511f $ **FLOATING
C95 CORE__N1.n11 VGND 1.22474f $ **FLOATING
C96 CORE__N1.n12 VGND 0.29037f $ **FLOATING
C97 CORE__N1.t0 VGND 0.02682f $ **FLOATING
C98 CORE__N1.n13 VGND 0.00876f $ **FLOATING
C99 A.t1 VGND 0.02495f $ **FLOATING
C100 A.n0 VGND 0.4206f $ **FLOATING
C101 A.t2 VGND 0.02401f $ **FLOATING
C102 A.n1 VGND 0.77128f $ **FLOATING
C103 A.t3 VGND 0.02495f $ **FLOATING
C104 A.n2 VGND 1.08592f $ **FLOATING
C105 A.t0 VGND 0.02401f $ **FLOATING
C106 N.n0 VGND 0.00574f $ **FLOATING
C107 N.t3 VGND 0.02075f $ **FLOATING
C108 N.t4 VGND 0.02156f $ **FLOATING
C109 N.n1 VGND 0.9295f $ **FLOATING
C110 N.n2 VGND 0.00502f $ **FLOATING
C111 N.t2 VGND 0.01538f $ **FLOATING
C112 N.n3 VGND 0.00502f $ **FLOATING
C113 N.n4 VGND 0.11121f $ **FLOATING
C114 N.n5 VGND 0.56498f $ **FLOATING
C115 N.n6 VGND 0.00502f $ **FLOATING
C116 N.t1 VGND 0.01538f $ **FLOATING
C117 N.n7 VGND 0.00502f $ **FLOATING
C118 N.n8 VGND 0.12964f $ **FLOATING
C119 N.n9 VGND 0.61354f $ **FLOATING
C120 N.n10 VGND 0.11121f $ **FLOATING
C121 N.t0 VGND 0.01395f $ **FLOATING
C122 N.n11 VGND 0.00574f $ **FLOATING
C123 CORE__N2.n0 VGND 0.00488f $ **FLOATING
C124 CORE__N2.t4 VGND 0.01764f $ **FLOATING
C125 CORE__N2.t3 VGND 0.01834f $ **FLOATING
C126 CORE__N2.n1 VGND 1.40137f $ **FLOATING
C127 CORE__N2.n2 VGND 0.00427f $ **FLOATING
C128 CORE__N2.t1 VGND 0.01308f $ **FLOATING
C129 CORE__N2.n3 VGND 0.00427f $ **FLOATING
C130 CORE__N2.n4 VGND 0.13953f $ **FLOATING
C131 CORE__N2.n5 VGND 0.98384f $ **FLOATING
C132 CORE__N2.n6 VGND 0.00427f $ **FLOATING
C133 CORE__N2.t2 VGND 0.01308f $ **FLOATING
C134 CORE__N2.n7 VGND 0.00427f $ **FLOATING
C135 CORE__N2.n8 VGND 0.15739f $ **FLOATING
C136 CORE__N2.n9 VGND 0.63451f $ **FLOATING
C137 CORE__N2.n10 VGND 0.13953f $ **FLOATING
C138 CORE__N2.t0 VGND 0.01186f $ **FLOATING
C139 CORE__N2.n11 VGND 0.00488f $ **FLOATING
.ends

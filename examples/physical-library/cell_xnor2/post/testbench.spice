Resistor public CMOS cell actual input truth matrix
.include "./supported-tt.spice"
.option scale=1e-6
.include "./current-probe.spice"
.temp 27.0
VGND VGND 0 0
VDD VPWR VGND 1.8
VA A VGND PWL(0 0 5e-08 0 5.01e-08 1.8 1e-07 1.8 1.001e-07 0 1.5e-07 0 1.501e-07 1.8 2e-07 1.8)
VB B VGND PWL(0 0 5e-08 0 5.01e-08 0 1e-07 0 1.001e-07 1.8 1.5e-07 1.8 1.501e-07 1.8 2e-07 1.8)
CLOAD Y VGND 5e-15
XU VGND VPWR Y B A cell_xnor2
.control
save v(A) v(B) v(Y) i(VDD) i(v.xu.vregister_cf_6779f271fd7072b8) i(v.xu.vregister_cf_6227a5df2a0c9f0e) i(v.xu.vregister_cf_9b67a9b567806368) i(v.xu.vregister_cf_6ea5b723c39d0e7a) i(v.xu.vregister_cf_287390746a5ce89e) i(v.xu.vregister_cf_b86504c57a67f3d9) i(v.xu.vregister_cf_b1948cc6e2f441e7) i(v.xu.vregister_cf_0bfdfa0e618b8b36) i(v.xu.vregister_cf_c048b0073cdbe8d0) i(v.xu.vregister_cf_f4651a778aa37b8f) i(v.xu.vregister_cf_0f58f9beb1aea027) i(v.xu.vregister_cf_da5082e3af6f94da) i(v.xu.vregister_cf_683e772207d5a49b) i(v.xu.vregister_cf_2976951d4cc7e9ee) i(v.xu.vregister_cf_fd0df8653d3c64de) i(v.xu.vregister_cf_1ae6626625e43773) i(v.xu.vregister_cf_de24ee25d69c50c6) i(v.xu.vregister_cf_9d23c38679883abc) i(VGND) i(VA) i(VB) v(XU.VPWR.t1) v(XU.N.t1) v(XU.CORE__N2.t3) v(XU.VPWR.t0) v(XU.CORE__N2__N1.t1) v(XU.CORE__N2.t0) v(XU.A.t0) v(XU.VGND.t4) v(XU.VPWR.t3) v(XU.CORE__N3.t0) v(XU.CORE__N1.t3) v(XU.VPWR.t2) v(XU.VPWR.t17) v(XU.CORE__N3.t2) v(XU.B.t0) v(XU.VPWR.t16) v(XU.VGND.t8) v(XU.Y.t1) v(XU.N.t3) v(XU.VGND.t7) v(XU.VGND.t12) v(XU.CORE__N1__N1.t1) v(XU.B.t1) v(XU.VGND.t11) v(XU.VPWR.t7) v(XU.CORE__N2.t1) v(XU.CORE__N1.t4) v(XU.VPWR.t6) v(XU.CORE__N4__N1.t0) v(XU.N.t0) v(XU.CORE__N2.t4) v(XU.VGND.t2) v(XU.VGND.t10) v(XU.CORE__N4__N1.t1) v(XU.CORE__N3.t3) v(XU.VGND.t9) v(XU.VPWR.t5) v(XU.CORE__N1.t0) v(XU.A.t1) v(XU.VPWR.t4) v(XU.CORE__N1__N1.t0) v(XU.CORE__N1.t1) v(XU.A.t2) v(XU.VGND.t3) v(XU.VPWR.t11) v(XU.CORE__N2.t2) v(XU.A.t3) v(XU.VPWR.t10) v(XU.VGND.t6) v(XU.CORE__N3__N1.t1) v(XU.CORE__N1.t5) v(XU.VGND.t5) v(XU.VPWR.t15) v(XU.N.t2) v(XU.CORE__N3.t4) v(XU.VPWR.t14) v(XU.CORE__N3__N1.t0) v(XU.CORE__N3.t1) v(XU.B.t2) v(XU.VGND.t13) v(XU.VPWR.t13) v(XU.CORE__N1.t2) v(XU.B.t3) v(XU.VPWR.t12) v(XU.VGND.t1) v(XU.CORE__N2__N1.t0) v(XU.CORE__N1.t6) v(XU.VGND.t0) v(XU.VPWR.t9) v(XU.Y.t0) v(XU.N.t4) v(XU.VPWR.t8) v(VGND) v(VPWR)
set numdgt=17
set wr_singlescale
set wr_vecnames
tran 100p 2e-07
let mos_wave_0 = v(A)
let mos_wave_1 = v(B)
let mos_wave_2 = v(Y)
let mos_wave_3 = -i(VDD)
wrdata waveform.dat mos_wave_0 mos_wave_1 mos_wave_2 mos_wave_3
write waveform.raw all
let register_flow_0 = i(v.xu.vregister_cf_6779f271fd7072b8)
let register_flow_1 = i(v.xu.vregister_cf_6227a5df2a0c9f0e)
let register_flow_2 = i(v.xu.vregister_cf_9b67a9b567806368)
let register_flow_3 = i(v.xu.vregister_cf_6ea5b723c39d0e7a)
let register_flow_4 = i(v.xu.vregister_cf_287390746a5ce89e)
let register_flow_5 = i(v.xu.vregister_cf_b86504c57a67f3d9)
let register_flow_6 = i(v.xu.vregister_cf_b1948cc6e2f441e7)
let register_flow_7 = i(v.xu.vregister_cf_0bfdfa0e618b8b36)
let register_flow_8 = i(v.xu.vregister_cf_c048b0073cdbe8d0)
let register_flow_9 = i(v.xu.vregister_cf_f4651a778aa37b8f)
let register_flow_10 = i(v.xu.vregister_cf_0f58f9beb1aea027)
let register_flow_11 = i(v.xu.vregister_cf_da5082e3af6f94da)
let register_flow_12 = i(v.xu.vregister_cf_683e772207d5a49b)
let register_flow_13 = i(v.xu.vregister_cf_2976951d4cc7e9ee)
let register_flow_14 = i(v.xu.vregister_cf_fd0df8653d3c64de)
let register_flow_15 = i(v.xu.vregister_cf_1ae6626625e43773)
let register_flow_16 = i(v.xu.vregister_cf_de24ee25d69c50c6)
let register_flow_17 = i(v.xu.vregister_cf_9d23c38679883abc)
let register_flow_18 = i(VGND)
let register_flow_19 = i(VDD)
let register_flow_20 = i(VA)
let register_flow_21 = i(VB)
wrdata current-flow.dat register_flow_0 register_flow_1 register_flow_2 register_flow_3 register_flow_4 register_flow_5 register_flow_6 register_flow_7 register_flow_8 register_flow_9 register_flow_10 register_flow_11 register_flow_12 register_flow_13 register_flow_14 register_flow_15 register_flow_16 register_flow_17 register_flow_18 register_flow_19 register_flow_20 register_flow_21
let register_voltage_0 = v(XU.VPWR.t1)
let register_voltage_1 = v(XU.N.t1)
let register_voltage_2 = v(XU.CORE__N2.t3)
let register_voltage_3 = v(XU.VPWR.t0)
let register_voltage_4 = v(XU.CORE__N2__N1.t1)
let register_voltage_5 = v(XU.CORE__N2.t0)
let register_voltage_6 = v(XU.A.t0)
let register_voltage_7 = v(XU.VGND.t4)
let register_voltage_8 = v(XU.VPWR.t3)
let register_voltage_9 = v(XU.CORE__N3.t0)
let register_voltage_10 = v(XU.CORE__N1.t3)
let register_voltage_11 = v(XU.VPWR.t2)
let register_voltage_12 = v(XU.VPWR.t17)
let register_voltage_13 = v(XU.CORE__N3.t2)
let register_voltage_14 = v(XU.B.t0)
let register_voltage_15 = v(XU.VPWR.t16)
let register_voltage_16 = v(XU.VGND.t8)
let register_voltage_17 = v(XU.Y.t1)
let register_voltage_18 = v(XU.N.t3)
let register_voltage_19 = v(XU.VGND.t7)
let register_voltage_20 = v(XU.VGND.t12)
let register_voltage_21 = v(XU.CORE__N1__N1.t1)
let register_voltage_22 = v(XU.B.t1)
let register_voltage_23 = v(XU.VGND.t11)
let register_voltage_24 = v(XU.VPWR.t7)
let register_voltage_25 = v(XU.CORE__N2.t1)
let register_voltage_26 = v(XU.CORE__N1.t4)
let register_voltage_27 = v(XU.VPWR.t6)
let register_voltage_28 = v(XU.CORE__N4__N1.t0)
let register_voltage_29 = v(XU.N.t0)
let register_voltage_30 = v(XU.CORE__N2.t4)
let register_voltage_31 = v(XU.VGND.t2)
let register_voltage_32 = v(XU.VGND.t10)
let register_voltage_33 = v(XU.CORE__N4__N1.t1)
let register_voltage_34 = v(XU.CORE__N3.t3)
let register_voltage_35 = v(XU.VGND.t9)
let register_voltage_36 = v(XU.VPWR.t5)
let register_voltage_37 = v(XU.CORE__N1.t0)
let register_voltage_38 = v(XU.A.t1)
let register_voltage_39 = v(XU.VPWR.t4)
let register_voltage_40 = v(XU.CORE__N1__N1.t0)
let register_voltage_41 = v(XU.CORE__N1.t1)
let register_voltage_42 = v(XU.A.t2)
let register_voltage_43 = v(XU.VGND.t3)
let register_voltage_44 = v(XU.VPWR.t11)
let register_voltage_45 = v(XU.CORE__N2.t2)
let register_voltage_46 = v(XU.A.t3)
let register_voltage_47 = v(XU.VPWR.t10)
let register_voltage_48 = v(XU.VGND.t6)
let register_voltage_49 = v(XU.CORE__N3__N1.t1)
let register_voltage_50 = v(XU.CORE__N1.t5)
let register_voltage_51 = v(XU.VGND.t5)
let register_voltage_52 = v(XU.VPWR.t15)
let register_voltage_53 = v(XU.N.t2)
let register_voltage_54 = v(XU.CORE__N3.t4)
let register_voltage_55 = v(XU.VPWR.t14)
let register_voltage_56 = v(XU.CORE__N3__N1.t0)
let register_voltage_57 = v(XU.CORE__N3.t1)
let register_voltage_58 = v(XU.B.t2)
let register_voltage_59 = v(XU.VGND.t13)
let register_voltage_60 = v(XU.VPWR.t13)
let register_voltage_61 = v(XU.CORE__N1.t2)
let register_voltage_62 = v(XU.B.t3)
let register_voltage_63 = v(XU.VPWR.t12)
let register_voltage_64 = v(XU.VGND.t1)
let register_voltage_65 = v(XU.CORE__N2__N1.t0)
let register_voltage_66 = v(XU.CORE__N1.t6)
let register_voltage_67 = v(XU.VGND.t0)
let register_voltage_68 = v(XU.VPWR.t9)
let register_voltage_69 = v(XU.Y.t0)
let register_voltage_70 = v(XU.N.t4)
let register_voltage_71 = v(XU.VPWR.t8)
let register_voltage_72 = v(VGND)
let register_voltage_73 = 0*register_flow_0
let register_voltage_74 = v(VPWR)
let register_voltage_75 = v(A)
let register_voltage_76 = v(B)
wrdata node-voltages.dat register_voltage_0 register_voltage_1 register_voltage_2 register_voltage_3 register_voltage_4 register_voltage_5 register_voltage_6 register_voltage_7 register_voltage_8 register_voltage_9 register_voltage_10 register_voltage_11 register_voltage_12 register_voltage_13 register_voltage_14 register_voltage_15 register_voltage_16 register_voltage_17 register_voltage_18 register_voltage_19 register_voltage_20 register_voltage_21 register_voltage_22 register_voltage_23 register_voltage_24 register_voltage_25 register_voltage_26 register_voltage_27 register_voltage_28 register_voltage_29 register_voltage_30 register_voltage_31 register_voltage_32 register_voltage_33 register_voltage_34 register_voltage_35 register_voltage_36 register_voltage_37 register_voltage_38 register_voltage_39 register_voltage_40 register_voltage_41 register_voltage_42 register_voltage_43 register_voltage_44 register_voltage_45 register_voltage_46 register_voltage_47 register_voltage_48 register_voltage_49 register_voltage_50 register_voltage_51 register_voltage_52 register_voltage_53 register_voltage_54 register_voltage_55 register_voltage_56 register_voltage_57 register_voltage_58 register_voltage_59 register_voltage_60 register_voltage_61 register_voltage_62 register_voltage_63 register_voltage_64 register_voltage_65 register_voltage_66 register_voltage_67 register_voltage_68 register_voltage_69 register_voltage_70 register_voltage_71 register_voltage_72 register_voltage_73 register_voltage_74 register_voltage_75 register_voltage_76
quit
.endc
.end

* NGSPICE file created from cell_mux2.ext - technology: sky130A

.subckt cell_mux2 VPWR VGND B Y S A
X0 B.t1 S.t0 Y.t3 VGND.t3 sky130_fd_pr__nfet_01v8 ad=0.1885 pd=1.88 as=0.1885 ps=1.88 w=0.65 l=0.15
X1 A.t0 SB.t2 Y.t0 VGND.t0 sky130_fd_pr__nfet_01v8 ad=0.1885 pd=1.88 as=0.1885 ps=1.88 w=0.65 l=0.15
X2 B.t0 SB.t3 Y.t1 VPWR.t0 sky130_fd_pr__pfet_01v8_hvt ad=0.1885 pd=1.88 as=0.1885 ps=1.88 w=0.65 l=0.15
X3 A.t1 S.t1 Y.t2 VPWR.t3 sky130_fd_pr__pfet_01v8_hvt ad=0.1885 pd=1.88 as=0.1885 ps=1.88 w=0.65 l=0.15
X4 VPWR.t2 S.t2 SB.t0 VPWR.t1 sky130_fd_pr__pfet_01v8_hvt ad=0.1885 pd=1.88 as=0.1885 ps=1.88 w=0.65 l=0.15
X5 VGND.t2 S.t3 SB.t1 VGND.t1 sky130_fd_pr__nfet_01v8 ad=0.1885 pd=1.88 as=0.1885 ps=1.88 w=0.65 l=0.15
C0 VPWR SB 0.59088f
C1 A SB 0.74357f
C2 VPWR Y 0.28168f
C3 A Y 0.61868f
C4 S SB 0.53999f
C5 S Y 2.58321f
C6 VPWR B 0.13604f
C7 A B 0
C8 S B 0.68659f
C9 Y SB 0.42078f
C10 B SB 3.42175f
C11 A VPWR 0.16514f
C12 B Y 2.94731f
C13 VPWR S 0.74324f
C14 A S 2.27151f
R0 S S.t2 330.341
R1 S S.t1 330.341
R2 S S.t3 315.88
R3 S S.t0 315.88
R4 S S.n2 30.6166
R5 S.n1 S 29.7994
R6 S.n2 S 29.7837
R7 S.n0 S 29.7837
R8 S.n2 S.n1 1.64021
R9 S.n1 S.n0 0.817713
R10 S.n0 S 0.567438
R11 Y.t2 Y.n5 700.484
R12 Y.n6 Y.t2 700.484
R13 Y.t1 Y.n0 700.484
R14 Y.n14 Y.t1 700.484
R15 Y.t0 Y.n1 255.345
R16 Y.n2 Y.t0 255.345
R17 Y.t3 Y.n9 255.345
R18 Y.n10 Y.t3 255.345
R19 Y Y.n5 12.8005
R20 Y.n6 Y 12.8005
R21 Y Y.n9 12.8005
R22 Y.n10 Y 12.8005
R23 Y Y.n0 12.8005
R24 Y Y.n14 12.8005
R25 Y Y.n1 12.8005
R26 Y.n2 Y 12.8005
R27 Y.n13 Y.n12 11.686
R28 Y.n8 Y.n7 10.8688
R29 Y.n12 Y.n11 10.8688
R30 Y.n4 Y.n3 10.8688
R31 Y.n7 Y.n5 10.1513
R32 Y.n7 Y.n6 10.1513
R33 Y.n11 Y.n9 10.1513
R34 Y.n11 Y.n10 10.1513
R35 Y.n13 Y.n0 10.1513
R36 Y.n14 Y.n13 10.1513
R37 Y.n3 Y.n1 10.1513
R38 Y.n3 Y.n2 10.1513
R39 Y.n4 Y 1.86405
R40 Y.n12 Y.n8 0.817713
R41 Y.n8 Y.n4 0.817713
R42 B.t0 B.n0 700.484
R43 B.n6 B.t0 700.484
R44 B.t1 B.n1 255.345
R45 B.n2 B.t1 255.345
R46 B B.n0 12.8005
R47 B B.n6 12.8005
R48 B B.n1 12.8005
R49 B.n2 B 12.8005
R50 B.n5 B.n4 12.1026
R51 B.n4 B.n3 11.2854
R52 B.n5 B.n0 10.1513
R53 B.n6 B.n5 10.1513
R54 B.n3 B.n1 10.1513
R55 B.n3 B.n2 10.1513
R56 B.n4 B 3.80398
R57 VGND.n78 VGND.n76 3656.77
R58 VGND.n43 VGND.n42 1524.81
R59 VGND.n40 VGND.n13 1315.26
R60 VGND.n36 VGND.n14 1315.26
R61 VGND.n24 VGND.n12 1315.26
R62 VGND.n28 VGND.n19 1315.26
R63 VGND.n86 VGND.n44 1315.26
R64 VGND.n97 VGND.n45 1315.26
R65 VGND.n81 VGND.n8 1315.26
R66 VGND.n99 VGND.n9 1315.26
R67 VGND.n64 VGND.n54 1315.26
R68 VGND.n74 VGND.n50 1315.26
R69 VGND.n68 VGND.n67 1315.26
R70 VGND.n66 VGND.n52 1315.26
R71 VGND.n95 VGND.n45 585
R72 VGND.n94 VGND.n93 585
R73 VGND.n91 VGND.n89 585
R74 VGND.n9 VGND.n7 585
R75 VGND.n100 VGND.n99 585
R76 VGND.n99 VGND.n98 585
R77 VGND.n8 VGND.n6 585
R78 VGND.n77 VGND.n8 585
R79 VGND.n81 VGND.n80 585
R80 VGND.n83 VGND.n79 585
R81 VGND.n84 VGND.n46 585
R82 VGND.n87 VGND.n86 585
R83 VGND.n88 VGND.n44 585
R84 VGND.n77 VGND.n44 585
R85 VGND.n97 VGND.n96 585
R86 VGND.n98 VGND.n97 585
R87 VGND.n37 VGND.n36 585
R88 VGND.n17 VGND.n16 585
R89 VGND.n32 VGND.n31 585
R90 VGND.n30 VGND.n19 585
R91 VGND.n29 VGND.n28 585
R92 VGND.n28 VGND.n18 585
R93 VGND.n26 VGND.n12 585
R94 VGND.n41 VGND.n12 585
R95 VGND.n25 VGND.n24 585
R96 VGND.n23 VGND.n22 585
R97 VGND.n21 VGND.n20 585
R98 VGND.n15 VGND.n13 585
R99 VGND.n40 VGND.n39 585
R100 VGND.n41 VGND.n40 585
R101 VGND.n38 VGND.n14 585
R102 VGND.n18 VGND.n14 585
R103 VGND.n55 VGND.n52 585
R104 VGND.n58 VGND.n56 585
R105 VGND.n61 VGND.n60 585
R106 VGND.n62 VGND.n54 585
R107 VGND.n64 VGND.n63 585
R108 VGND.n65 VGND.n64 585
R109 VGND.n51 VGND.n50 585
R110 VGND.n50 VGND.n47 585
R111 VGND.n74 VGND.n73 585
R112 VGND.n72 VGND.n49 585
R113 VGND.n71 VGND.n70 585
R114 VGND.n69 VGND.n68 585
R115 VGND.n67 VGND.n1 585
R116 VGND.n67 VGND.n47 585
R117 VGND.n66 VGND.n0 585
R118 VGND.n66 VGND.n65 585
R119 VGND.n40 VGND.n14 394
R120 VGND.n22 VGND.n21 394
R121 VGND.n28 VGND.n12 394
R122 VGND.n32 VGND.n17 394
R123 VGND.n97 VGND.n44 394
R124 VGND.n84 VGND.n83 394
R125 VGND.n99 VGND.n8 394
R126 VGND.n93 VGND.n91 394
R127 VGND.n64 VGND.n50 394
R128 VGND.n70 VGND.n49 394
R129 VGND.n67 VGND.n66 394
R130 VGND.n60 VGND.n58 394
R131 VGND.t2 VGND.n2 255.345
R132 VGND.n3 VGND.t2 255.345
R133 VGND.n92 VGND.n43 218.815
R134 VGND.n90 VGND.n43 218.815
R135 VGND.n82 VGND.n78 218.815
R136 VGND.n85 VGND.n78 218.815
R137 VGND.n35 VGND.n34 218.815
R138 VGND.n34 VGND.n33 218.815
R139 VGND.n42 VGND.n11 218.815
R140 VGND.n42 VGND.n10 218.815
R141 VGND.n57 VGND.n53 218.815
R142 VGND.n59 VGND.n53 218.815
R143 VGND.n76 VGND.n75 218.815
R144 VGND.n76 VGND.n48 218.815
R145 VGND.n78 VGND.n77 174.425
R146 VGND.n98 VGND.n43 174.425
R147 VGND.n42 VGND.n41 174.425
R148 VGND.n34 VGND.n18 174.425
R149 VGND.n65 VGND.n53 174.425
R150 VGND.n76 VGND.n47 174.425
R151 VGND.n21 VGND.n10 147.374
R152 VGND.n24 VGND.n11 147.374
R153 VGND.n36 VGND.n35 147.374
R154 VGND.n33 VGND.n19 147.374
R155 VGND.n85 VGND.n84 147.374
R156 VGND.n82 VGND.n81 147.374
R157 VGND.n92 VGND.n45 147.374
R158 VGND.n90 VGND.n9 147.374
R159 VGND.n93 VGND.n92 147.374
R160 VGND.n91 VGND.n90 147.374
R161 VGND.n83 VGND.n82 147.374
R162 VGND.n86 VGND.n85 147.374
R163 VGND.n35 VGND.n17 147.374
R164 VGND.n33 VGND.n32 147.374
R165 VGND.n22 VGND.n11 147.374
R166 VGND.n13 VGND.n10 147.374
R167 VGND.n75 VGND.n74 147.374
R168 VGND.n68 VGND.n48 147.374
R169 VGND.n59 VGND.n54 147.374
R170 VGND.n58 VGND.n57 147.374
R171 VGND.n57 VGND.n52 147.374
R172 VGND.n60 VGND.n59 147.374
R173 VGND.n75 VGND.n49 147.374
R174 VGND.n70 VGND.n48 147.374
R175 VGND.n39 VGND.n15 85.4593
R176 VGND.n38 VGND.n37 85.4593
R177 VGND.n26 VGND.n25 85.4593
R178 VGND.n30 VGND.n29 85.4593
R179 VGND.n88 VGND.n87 85.4593
R180 VGND.n96 VGND.n95 85.4593
R181 VGND.n80 VGND.n6 85.4593
R182 VGND.n100 VGND.n7 85.4593
R183 VGND.n63 VGND.n62 85.4593
R184 VGND.n55 VGND.n0 85.4593
R185 VGND.n73 VGND.n51 85.4593
R186 VGND.n69 VGND.n1 85.4593
R187 VGND.n77 VGND.t0 47.8266
R188 VGND.n98 VGND.t0 47.8266
R189 VGND.n41 VGND.t1 47.8266
R190 VGND.n18 VGND.t1 47.8266
R191 VGND.n65 VGND.t3 47.8266
R192 VGND.t3 VGND.n47 47.8266
R193 VGND.n39 VGND.n38 25.6005
R194 VGND.n20 VGND.n15 25.6005
R195 VGND.n23 VGND.n20 25.6005
R196 VGND.n25 VGND.n23 25.6005
R197 VGND.n37 VGND.n16 25.6005
R198 VGND.n31 VGND.n16 25.6005
R199 VGND.n31 VGND.n30 25.6005
R200 VGND.n96 VGND.n88 25.6005
R201 VGND.n87 VGND.n46 25.6005
R202 VGND.n79 VGND.n46 25.6005
R203 VGND.n80 VGND.n79 25.6005
R204 VGND.n95 VGND.n94 25.6005
R205 VGND.n94 VGND.n89 25.6005
R206 VGND.n89 VGND.n7 25.6005
R207 VGND.n62 VGND.n61 25.6005
R208 VGND.n61 VGND.n56 25.6005
R209 VGND.n56 VGND.n55 25.6005
R210 VGND.n63 VGND.n51 25.6005
R211 VGND.n73 VGND.n72 25.6005
R212 VGND.n72 VGND.n71 25.6005
R213 VGND.n71 VGND.n69 25.6005
R214 VGND VGND.n101 20.006
R215 VGND VGND.n27 18.3598
R216 VGND.n101 VGND 18.3598
R217 VGND VGND.n26 12.8005
R218 VGND.n29 VGND 12.8005
R219 VGND VGND.n6 12.8005
R220 VGND VGND.n100 12.8005
R221 VGND VGND.n0 12.8005
R222 VGND VGND.n1 12.8005
R223 VGND VGND.n2 12.8005
R224 VGND.n3 VGND 12.8005
R225 VGND.n4 VGND.n2 10.1513
R226 VGND.n4 VGND.n3 10.1513
R227 VGND.n5 VGND.n4 10.0354
R228 VGND.n27 VGND 1.18255
R229 VGND.n101 VGND.n5 0.67025
R230 VGND.n27 VGND.n5 0.12975
R231 SB.t0 SB.n0 700.484
R232 SB.n7 SB.t0 700.484
R233 SB SB.t3 330.341
R234 SB SB.t2 315.88
R235 SB.t1 SB.n2 255.345
R236 SB.n3 SB.t1 255.345
R237 SB.n1 SB 33.5089
R238 SB.n1 SB 31.0494
R239 SB SB.n2 12.8005
R240 SB.n3 SB 12.8005
R241 SB SB.n0 12.8005
R242 SB SB.n7 12.8005
R243 SB.n6 SB.n5 12.5193
R244 SB.n5 SB.n4 11.7021
R245 SB.n4 SB.n2 10.1513
R246 SB.n4 SB.n3 10.1513
R247 SB.n6 SB.n0 10.1513
R248 SB.n7 SB.n6 10.1513
R249 SB.n5 SB.n1 1.1661
R250 A.t1 A.n0 700.484
R251 A.n6 A.t1 700.484
R252 A.t0 A.n1 255.345
R253 A.n2 A.t0 255.345
R254 A A.n0 12.8005
R255 A A.n6 12.8005
R256 A A.n1 12.8005
R257 A.n2 A 12.8005
R258 A.n5 A.n4 10.8526
R259 A.n5 A.n0 10.1513
R260 A.n6 A.n5 10.1513
R261 A.n3 A.n1 10.1513
R262 A.n3 A.n2 10.1513
R263 A.n4 A.n3 10.0354
R264 A.n4 A 2.14605
R265 VPWR.n86 VPWR.n74 832.942
R266 VPWR.n97 VPWR.n75 832.942
R267 VPWR.n99 VPWR.n72 832.942
R268 VPWR.n81 VPWR.n71 832.942
R269 VPWR.n17 VPWR.n5 832.942
R270 VPWR.n28 VPWR.n6 832.942
R271 VPWR.n30 VPWR.n3 832.942
R272 VPWR.n12 VPWR.n2 832.942
R273 VPWR.n49 VPWR.n37 832.942
R274 VPWR.n60 VPWR.n38 832.942
R275 VPWR.n62 VPWR.n35 832.942
R276 VPWR.n44 VPWR.n34 832.942
R277 VPWR.t2 VPWR.n65 700.484
R278 VPWR.n66 VPWR.t2 700.484
R279 VPWR.n97 VPWR.n74 240
R280 VPWR.n93 VPWR.n91 240
R281 VPWR.n99 VPWR.n71 240
R282 VPWR.n78 VPWR.n77 240
R283 VPWR.n28 VPWR.n5 240
R284 VPWR.n24 VPWR.n22 240
R285 VPWR.n30 VPWR.n2 240
R286 VPWR.n9 VPWR.n8 240
R287 VPWR.n60 VPWR.n37 240
R288 VPWR.n56 VPWR.n54 240
R289 VPWR.n62 VPWR.n34 240
R290 VPWR.n41 VPWR.n40 240
R291 VPWR.n84 VPWR.n83 207.394
R292 VPWR.n98 VPWR.n73 207.394
R293 VPWR.n15 VPWR.n14 207.394
R294 VPWR.n29 VPWR.n4 207.394
R295 VPWR.n47 VPWR.n46 207.394
R296 VPWR.n61 VPWR.n36 207.394
R297 VPWR.n81 VPWR.n80 185
R298 VPWR.n79 VPWR.n78 185
R299 VPWR.n77 VPWR.n76 185
R300 VPWR.n87 VPWR.n86 185
R301 VPWR.n88 VPWR.n74 185
R302 VPWR.n83 VPWR.n74 185
R303 VPWR.n97 VPWR.n96 185
R304 VPWR.n98 VPWR.n97 185
R305 VPWR.n95 VPWR.n75 185
R306 VPWR.n94 VPWR.n93 185
R307 VPWR.n91 VPWR.n89 185
R308 VPWR.n72 VPWR.n70 185
R309 VPWR.n100 VPWR.n99 185
R310 VPWR.n99 VPWR.n98 185
R311 VPWR.n71 VPWR.n69 185
R312 VPWR.n83 VPWR.n71 185
R313 VPWR.n12 VPWR.n11 185
R314 VPWR.n10 VPWR.n9 185
R315 VPWR.n8 VPWR.n7 185
R316 VPWR.n18 VPWR.n17 185
R317 VPWR.n19 VPWR.n5 185
R318 VPWR.n14 VPWR.n5 185
R319 VPWR.n28 VPWR.n27 185
R320 VPWR.n29 VPWR.n28 185
R321 VPWR.n26 VPWR.n6 185
R322 VPWR.n25 VPWR.n24 185
R323 VPWR.n22 VPWR.n20 185
R324 VPWR.n3 VPWR.n1 185
R325 VPWR.n31 VPWR.n30 185
R326 VPWR.n30 VPWR.n29 185
R327 VPWR.n2 VPWR.n0 185
R328 VPWR.n14 VPWR.n2 185
R329 VPWR.n44 VPWR.n43 185
R330 VPWR.n42 VPWR.n41 185
R331 VPWR.n40 VPWR.n39 185
R332 VPWR.n50 VPWR.n49 185
R333 VPWR.n51 VPWR.n37 185
R334 VPWR.n46 VPWR.n37 185
R335 VPWR.n60 VPWR.n59 185
R336 VPWR.n61 VPWR.n60 185
R337 VPWR.n58 VPWR.n38 185
R338 VPWR.n57 VPWR.n56 185
R339 VPWR.n54 VPWR.n52 185
R340 VPWR.n35 VPWR.n33 185
R341 VPWR.n63 VPWR.n62 185
R342 VPWR.n62 VPWR.n61 185
R343 VPWR.n34 VPWR.n32 185
R344 VPWR.n46 VPWR.n34 185
R345 VPWR.n88 VPWR.n87 88.8476
R346 VPWR.n80 VPWR.n69 88.8476
R347 VPWR.n96 VPWR.n95 88.8476
R348 VPWR.n100 VPWR.n70 88.8476
R349 VPWR.n19 VPWR.n18 88.8476
R350 VPWR.n11 VPWR.n0 88.8476
R351 VPWR.n27 VPWR.n26 88.8476
R352 VPWR.n31 VPWR.n1 88.8476
R353 VPWR.n51 VPWR.n50 88.8476
R354 VPWR.n43 VPWR.n32 88.8476
R355 VPWR.n59 VPWR.n58 88.8476
R356 VPWR.n63 VPWR.n33 88.8476
R357 VPWR.n92 VPWR.n75 72.7879
R358 VPWR.n90 VPWR.n72 72.7879
R359 VPWR.n86 VPWR.n85 72.7879
R360 VPWR.n82 VPWR.n78 72.7879
R361 VPWR.n82 VPWR.n81 72.7879
R362 VPWR.n85 VPWR.n77 72.7879
R363 VPWR.n93 VPWR.n92 72.7879
R364 VPWR.n91 VPWR.n90 72.7879
R365 VPWR.n23 VPWR.n6 72.7879
R366 VPWR.n21 VPWR.n3 72.7879
R367 VPWR.n17 VPWR.n16 72.7879
R368 VPWR.n13 VPWR.n9 72.7879
R369 VPWR.n13 VPWR.n12 72.7879
R370 VPWR.n16 VPWR.n8 72.7879
R371 VPWR.n24 VPWR.n23 72.7879
R372 VPWR.n22 VPWR.n21 72.7879
R373 VPWR.n55 VPWR.n38 72.7879
R374 VPWR.n53 VPWR.n35 72.7879
R375 VPWR.n49 VPWR.n48 72.7879
R376 VPWR.n45 VPWR.n41 72.7879
R377 VPWR.n45 VPWR.n44 72.7879
R378 VPWR.n48 VPWR.n40 72.7879
R379 VPWR.n56 VPWR.n55 72.7879
R380 VPWR.n54 VPWR.n53 72.7879
R381 VPWR.n83 VPWR.t3 56.8667
R382 VPWR.n98 VPWR.t3 56.8667
R383 VPWR.n14 VPWR.t0 56.8667
R384 VPWR.n29 VPWR.t0 56.8667
R385 VPWR.n46 VPWR.t1 56.8667
R386 VPWR.n61 VPWR.t1 56.8667
R387 VPWR.n84 VPWR.n82 56.1076
R388 VPWR.n85 VPWR.n84 56.1076
R389 VPWR.n92 VPWR.n73 56.1076
R390 VPWR.n90 VPWR.n73 56.1076
R391 VPWR.n15 VPWR.n13 56.1076
R392 VPWR.n16 VPWR.n15 56.1076
R393 VPWR.n23 VPWR.n4 56.1076
R394 VPWR.n21 VPWR.n4 56.1076
R395 VPWR.n47 VPWR.n45 56.1076
R396 VPWR.n48 VPWR.n47 56.1076
R397 VPWR.n55 VPWR.n36 56.1076
R398 VPWR.n53 VPWR.n36 56.1076
R399 VPWR.n87 VPWR.n76 25.6005
R400 VPWR.n79 VPWR.n76 25.6005
R401 VPWR.n80 VPWR.n79 25.6005
R402 VPWR.n96 VPWR.n88 25.6005
R403 VPWR.n95 VPWR.n94 25.6005
R404 VPWR.n94 VPWR.n89 25.6005
R405 VPWR.n89 VPWR.n70 25.6005
R406 VPWR.n18 VPWR.n7 25.6005
R407 VPWR.n10 VPWR.n7 25.6005
R408 VPWR.n11 VPWR.n10 25.6005
R409 VPWR.n27 VPWR.n19 25.6005
R410 VPWR.n26 VPWR.n25 25.6005
R411 VPWR.n25 VPWR.n20 25.6005
R412 VPWR.n20 VPWR.n1 25.6005
R413 VPWR.n50 VPWR.n39 25.6005
R414 VPWR.n42 VPWR.n39 25.6005
R415 VPWR.n43 VPWR.n42 25.6005
R416 VPWR.n59 VPWR.n51 25.6005
R417 VPWR.n58 VPWR.n57 25.6005
R418 VPWR.n57 VPWR.n52 25.6005
R419 VPWR.n52 VPWR.n33 25.6005
R420 VPWR VPWR.n101 20.5112
R421 VPWR.n101 VPWR 18.865
R422 VPWR.n64 VPWR 18.865
R423 VPWR VPWR.n65 12.8005
R424 VPWR.n66 VPWR 12.8005
R425 VPWR VPWR.n69 12.8005
R426 VPWR VPWR.n100 12.8005
R427 VPWR VPWR.n0 12.8005
R428 VPWR VPWR.n31 12.8005
R429 VPWR VPWR.n32 12.8005
R430 VPWR VPWR.n63 12.8005
R431 VPWR.n68 VPWR.n67 10.5563
R432 VPWR.n67 VPWR.n65 10.1513
R433 VPWR.n67 VPWR.n66 10.1513
R434 VPWR.n101 VPWR.n68 2.32818
R435 VPWR.n64 VPWR 0.353587
R436 VPWR.n68 VPWR.n64 0.12975
C15 B VGND 3.32689f
C16 A VGND 2.28683f
C17 Y VGND 3.329f
C18 S VGND 3.87247f
C19 VPWR VGND 8.85893f
C20 SB VGND 5.55131f $ **FLOATING
C21 A.n0 VGND 0.00837f $ **FLOATING
C22 A.n1 VGND 0.00956f $ **FLOATING
C23 A.t0 VGND 0.02325f $ **FLOATING
C24 A.n2 VGND 0.00956f $ **FLOATING
C25 A.n3 VGND 0.15672f $ **FLOATING
C26 A.n4 VGND 1.29823f $ **FLOATING
C27 A.n5 VGND 0.18575f $ **FLOATING
C28 A.t1 VGND 0.02564f $ **FLOATING
C29 A.n6 VGND 0.00837f $ **FLOATING
C30 SB.n0 VGND 0.00584f $ **FLOATING
C31 SB.t3 VGND 0.02506f $ **FLOATING
C32 SB.t2 VGND 0.02412f $ **FLOATING
C33 SB.n1 VGND 1.71656f $ **FLOATING
C34 SB.n2 VGND 0.00667f $ **FLOATING
C35 SB.t1 VGND 0.01622f $ **FLOATING
C36 SB.n3 VGND 0.00667f $ **FLOATING
C37 SB.n4 VGND 0.19073f $ **FLOATING
C38 SB.n5 VGND 0.9314f $ **FLOATING
C39 SB.n6 VGND 0.21514f $ **FLOATING
C40 SB.t0 VGND 0.01788f $ **FLOATING
C41 SB.n7 VGND 0.00584f $ **FLOATING
C42 B.n0 VGND 0.01475f $ **FLOATING
C43 B.n1 VGND 0.01685f $ **FLOATING
C44 B.t1 VGND 0.04097f $ **FLOATING
C45 B.n2 VGND 0.01685f $ **FLOATING
C46 B.n3 VGND 0.42964f $ **FLOATING
C47 B.n4 VGND 3.44962f $ **FLOATING
C48 B.n5 VGND 0.48903f $ **FLOATING
C49 B.t0 VGND 0.04517f $ **FLOATING
C50 B.n6 VGND 0.01475f $ **FLOATING
C51 Y.n0 VGND 0.01076f $ **FLOATING
C52 Y.n1 VGND 0.0123f $ **FLOATING
C53 Y.t0 VGND 0.0299f $ **FLOATING
C54 Y.n2 VGND 0.0123f $ **FLOATING
C55 Y.n3 VGND 0.27578f $ **FLOATING
C56 Y.n4 VGND 1.21326f $ **FLOATING
C57 Y.n5 VGND 0.01076f $ **FLOATING
C58 Y.t2 VGND 0.03297f $ **FLOATING
C59 Y.n6 VGND 0.01076f $ **FLOATING
C60 Y.n7 VGND 0.27578f $ **FLOATING
C61 Y.n8 VGND 0.85864f $ **FLOATING
C62 Y.n9 VGND 0.0123f $ **FLOATING
C63 Y.t3 VGND 0.0299f $ **FLOATING
C64 Y.n10 VGND 0.0123f $ **FLOATING
C65 Y.n11 VGND 0.27578f $ **FLOATING
C66 Y.n12 VGND 1.4107f $ **FLOATING
C67 Y.n13 VGND 0.3173f $ **FLOATING
C68 Y.t1 VGND 0.03297f $ **FLOATING
C69 Y.n14 VGND 0.01076f $ **FLOATING
C70 S.t2 VGND 0.04738f $ **FLOATING
C71 S.n0 VGND 0.87224f $ **FLOATING
C72 S.t3 VGND 0.04559f $ **FLOATING
C73 S.n1 VGND 1.24793f $ **FLOATING
C74 S.t1 VGND 0.04738f $ **FLOATING
C75 S.n2 VGND 1.91718f $ **FLOATING
C76 S.t0 VGND 0.04559f $ **FLOATING
.ends

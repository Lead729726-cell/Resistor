.subckt chip_sc_dcdc PHI1 PHI1B PHI2 PHI2B OUT VPWR VGND FLYTOP FLYBOTTOM
XN_BOTTOM_CHARGE OUT PHI1 FLYBOTTOM VGND sky130_fd_pr__nfet_01v8 w=20 l=0.15 nf=1 m=1
XN_BOTTOM_TRANSFER FLYBOTTOM PHI2 VGND VGND sky130_fd_pr__nfet_01v8 w=20 l=0.15 nf=1 m=1
XN_TOP_CHARGE VPWR PHI1 FLYTOP VGND sky130_fd_pr__nfet_01v8 w=20 l=0.15 nf=1 m=1
XN_TOP_TRANSFER FLYTOP PHI2 OUT VGND sky130_fd_pr__nfet_01v8 w=20 l=0.15 nf=1 m=1
XP_BOTTOM_CHARGE OUT PHI1B FLYBOTTOM VPWR sky130_fd_pr__pfet_01v8_hvt w=20 l=0.15 nf=1 m=1
XP_BOTTOM_TRANSFER FLYBOTTOM PHI2B VGND VPWR sky130_fd_pr__pfet_01v8_hvt w=20 l=0.15 nf=1 m=1
XP_TOP_CHARGE VPWR PHI1B FLYTOP VPWR sky130_fd_pr__pfet_01v8_hvt w=20 l=0.15 nf=1 m=1
XP_TOP_TRANSFER FLYTOP PHI2B OUT VPWR sky130_fd_pr__pfet_01v8_hvt w=20 l=0.15 nf=1 m=1
.ends chip_sc_dcdc

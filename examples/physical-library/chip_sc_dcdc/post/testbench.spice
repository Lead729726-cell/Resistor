Resistor actual SKY130 chip reference chip_sc_dcdc
.options method=gear maxord=2
.include "./supported-tt.spice"
.option scale=1e-6
.include "./current-probe.spice"
.temp 27.0
VGND VGND 0 0
VDD VPWR VGND 1.8
VPHI1 PHI1 VGND PULSE(0 1.8 1e-07 100p 100p 75n 200n)
VPHI1B PHI1B VGND PULSE(1.8 0 1e-07 100p 100p 75n 200n)
VPHI2 PHI2 VGND PULSE(0 1.8 2e-07 100p 100p 75n 200n)
VPHI2B PHI2B VGND PULSE(1.8 0 2e-07 100p 100p 75n 200n)
CFLY FLYTOP FLYBOTTOM 1e-09
COUT OUT VGND 1e-09
RLOAD OUT VGND 50000
XU VPWR VGND OUT FLYBOTTOM FLYTOP PHI1B PHI2B PHI2 PHI1 chip_sc_dcdc
.control
save v(OUT) i(VDD) v(FLYTOP) v(FLYBOTTOM) v(PHI1) v(PHI2) i(v.xu.vregister_cf_bd21a7efb0ebfea5) i(v.xu.vregister_cf_847b774b0e28605f) i(v.xu.vregister_cf_4004e6ff98389088) i(v.xu.vregister_cf_612f062f6ff91579) i(v.xu.vregister_cf_546257d60bde50d8) i(v.xu.vregister_cf_83cc0bf26a3ada01) i(v.xu.vregister_cf_3d647028b3752380) i(v.xu.vregister_cf_a9ea7442b3608b4e) i(VGND) i(VPHI1) i(VPHI1B) i(VPHI2) i(VPHI2B) v(XU.FLYTOP.t1) v(XU.VPWR.t3) v(XU.PHI1B.t0) v(XU.VPWR.t2) v(XU.FLYTOP.t0) v(XU.VPWR.t0) v(XU.PHI1.t0) v(XU.VGND.t3) v(XU.OUT.t2) v(XU.FLYTOP.t3) v(XU.PHI2B.t0) v(XU.VPWR.t5) v(XU.VGND.t5) v(XU.FLYBOTTOM.t2) v(XU.PHI2.t0) v(XU.VGND.t4) v(XU.FLYBOTTOM.t0) v(XU.OUT.t0) v(XU.PHI1B.t1) v(XU.VPWR.t1) v(XU.VGND.t0) v(XU.FLYBOTTOM.t1) v(XU.PHI2B.t1) v(XU.VPWR.t4) v(XU.FLYBOTTOM.t3) v(XU.OUT.t3) v(XU.PHI1.t1) v(XU.VGND.t2) v(XU.OUT.t1) v(XU.FLYTOP.t2) v(XU.PHI2.t1) v(XU.VGND.t1) v(VGND) v(VPWR) v(PHI1B) v(PHI2B)
set num_threads=1
set numdgt=17
set noaskquit
set wr_singlescale
set wr_vecnames
tran 2e-09 2e-05 uic
let mos_wave_0 = v(OUT)
let mos_wave_1 = -i(VDD)
let mos_wave_2 = v(FLYTOP)
let mos_wave_3 = v(FLYBOTTOM)
let mos_wave_4 = v(PHI1)
let mos_wave_5 = v(PHI2)
wrdata waveform.dat mos_wave_0 mos_wave_1 mos_wave_2 mos_wave_3 mos_wave_4 mos_wave_5
write waveform.raw all
let register_flow_0 = i(v.xu.vregister_cf_bd21a7efb0ebfea5)
let register_flow_1 = i(v.xu.vregister_cf_847b774b0e28605f)
let register_flow_2 = i(v.xu.vregister_cf_4004e6ff98389088)
let register_flow_3 = i(v.xu.vregister_cf_612f062f6ff91579)
let register_flow_4 = i(v.xu.vregister_cf_546257d60bde50d8)
let register_flow_5 = i(v.xu.vregister_cf_83cc0bf26a3ada01)
let register_flow_6 = i(v.xu.vregister_cf_3d647028b3752380)
let register_flow_7 = i(v.xu.vregister_cf_a9ea7442b3608b4e)
let register_flow_8 = i(VGND)
let register_flow_9 = i(VDD)
let register_flow_10 = i(VPHI1)
let register_flow_11 = i(VPHI1B)
let register_flow_12 = i(VPHI2)
let register_flow_13 = i(VPHI2B)
wrdata current-flow.dat register_flow_0 register_flow_1 register_flow_2 register_flow_3 register_flow_4 register_flow_5 register_flow_6 register_flow_7 register_flow_8 register_flow_9 register_flow_10 register_flow_11 register_flow_12 register_flow_13
let register_voltage_0 = v(XU.FLYTOP.t1)
let register_voltage_1 = v(XU.VPWR.t3)
let register_voltage_2 = v(XU.PHI1B.t0)
let register_voltage_3 = v(XU.VPWR.t2)
let register_voltage_4 = v(XU.FLYTOP.t0)
let register_voltage_5 = v(XU.VPWR.t0)
let register_voltage_6 = v(XU.PHI1.t0)
let register_voltage_7 = v(XU.VGND.t3)
let register_voltage_8 = v(XU.OUT.t2)
let register_voltage_9 = v(XU.FLYTOP.t3)
let register_voltage_10 = v(XU.PHI2B.t0)
let register_voltage_11 = v(XU.VPWR.t5)
let register_voltage_12 = v(XU.VGND.t5)
let register_voltage_13 = v(XU.FLYBOTTOM.t2)
let register_voltage_14 = v(XU.PHI2.t0)
let register_voltage_15 = v(XU.VGND.t4)
let register_voltage_16 = v(XU.FLYBOTTOM.t0)
let register_voltage_17 = v(XU.OUT.t0)
let register_voltage_18 = v(XU.PHI1B.t1)
let register_voltage_19 = v(XU.VPWR.t1)
let register_voltage_20 = v(XU.VGND.t0)
let register_voltage_21 = v(XU.FLYBOTTOM.t1)
let register_voltage_22 = v(XU.PHI2B.t1)
let register_voltage_23 = v(XU.VPWR.t4)
let register_voltage_24 = v(XU.FLYBOTTOM.t3)
let register_voltage_25 = v(XU.OUT.t3)
let register_voltage_26 = v(XU.PHI1.t1)
let register_voltage_27 = v(XU.VGND.t2)
let register_voltage_28 = v(XU.OUT.t1)
let register_voltage_29 = v(XU.FLYTOP.t2)
let register_voltage_30 = v(XU.PHI2.t1)
let register_voltage_31 = v(XU.VGND.t1)
let register_voltage_32 = v(VGND)
let register_voltage_33 = 0*register_flow_0
let register_voltage_34 = v(VPWR)
let register_voltage_35 = v(PHI1)
let register_voltage_36 = v(PHI1B)
let register_voltage_37 = v(PHI2)
let register_voltage_38 = v(PHI2B)
wrdata node-voltages.dat register_voltage_0 register_voltage_1 register_voltage_2 register_voltage_3 register_voltage_4 register_voltage_5 register_voltage_6 register_voltage_7 register_voltage_8 register_voltage_9 register_voltage_10 register_voltage_11 register_voltage_12 register_voltage_13 register_voltage_14 register_voltage_15 register_voltage_16 register_voltage_17 register_voltage_18 register_voltage_19 register_voltage_20 register_voltage_21 register_voltage_22 register_voltage_23 register_voltage_24 register_voltage_25 register_voltage_26 register_voltage_27 register_voltage_28 register_voltage_29 register_voltage_30 register_voltage_31 register_voltage_32 register_voltage_33 register_voltage_34 register_voltage_35 register_voltage_36 register_voltage_37 register_voltage_38
quit
.endc
.end

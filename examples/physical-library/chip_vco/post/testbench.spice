Resistor actual SKY130 chip reference chip_vco
.options method=gear maxord=2
.include "./supported-tt.spice"
.option scale=1e-6
.include "./current-probe.spice"
.temp 27.0
VGND VGND 0 0
VDD VPWR VGND 1.8
VCTRL CTRL VGND 0.9
.ic v(xu.Q0)=0.1 v(xu.Q1)=1.5 v(OUT)=0.2
XU VPWR VGND OUT CTRL chip_vco
.control
save v(OUT) i(VDD) v(CTRL) i(v.xu.vregister_cf_b1c7faf46aa9f3ba) i(v.xu.vregister_cf_08343c6067bb09fa) i(v.xu.vregister_cf_f160244b58361bad) i(v.xu.vregister_cf_9b432e8cb234c8fd) i(v.xu.vregister_cf_31f5681e87749f12) i(v.xu.vregister_cf_d65add57bf698065) i(v.xu.vregister_cf_522949c820f09d07) i(v.xu.vregister_cf_c0d7d1185ef3831a) i(v.xu.vregister_cf_f3ec2b6ba7278775) i(v.xu.vregister_cf_afe480660cbc1eda) i(v.xu.vregister_cf_6e6dcf9202618a41) i(v.xu.vregister_cf_b632b9c7db1f37e2) i(v.xu.vregister_cf_820105d57b6322de) i(v.xu.vregister_cf_c41ef7786c74817d) i(VGND) i(VCTRL) v(XU.VGND.t13) v(XU.PBIAS.t2) v(XU.CTRL.t0) v(XU.VGND.t12) v(XU.P2.t1) v(XU.OUT.t0) v(XU.Q1.t2) v(XU.VPWR.t9) v(XU.VGND.t11) v(XU.N1.t1) v(XU.CTRL.t1) v(XU.VGND.t10) v(XU.P0.t1) v(XU.Q0.t0) v(XU.OUT.t2) v(XU.VPWR.t10) v(XU.N0.t1) v(XU.Q0.t1) v(XU.OUT.t3) v(XU.VGND.t2) v(XU.VPWR.t6) v(XU.P1.t1) v(XU.PBIAS.t3) v(XU.VPWR.t5) v(XU.P1.t0) v(XU.Q1.t1) v(XU.Q0.t3) v(XU.VPWR.t0) v(XU.N1.t0) v(XU.Q1.t0) v(XU.Q0.t4) v(XU.VGND.t3) v(XU.VPWR.t8) v(XU.P2.t0) v(XU.PBIAS.t4) v(XU.VPWR.t7) v(XU.VPWR.t4) v(XU.PBIAS.t1) v(XU.PBIAS.t0) v(XU.VPWR.t3) v(XU.VPWR.t2) v(XU.P0.t0) v(XU.PBIAS.t5) v(XU.VPWR.t1) v(XU.VGND.t9) v(XU.N2.t0) v(XU.CTRL.t2) v(XU.VGND.t8) v(XU.N2.t1) v(XU.OUT.t1) v(XU.Q1.t3) v(XU.VGND.t0) v(XU.VGND.t7) v(XU.N0.t0) v(XU.CTRL.t3) v(XU.VGND.t6) v(VGND) v(VPWR)
set num_threads=1
set numdgt=17
set noaskquit
set wr_singlescale
set wr_vecnames
tran 5e-10 3e-06 uic
let mos_wave_0 = v(OUT)
let mos_wave_1 = -i(VDD)
let mos_wave_2 = v(CTRL)
wrdata waveform.dat mos_wave_0 mos_wave_1 mos_wave_2
write waveform.raw all
let register_flow_0 = i(v.xu.vregister_cf_b1c7faf46aa9f3ba)
let register_flow_1 = i(v.xu.vregister_cf_08343c6067bb09fa)
let register_flow_2 = i(v.xu.vregister_cf_f160244b58361bad)
let register_flow_3 = i(v.xu.vregister_cf_9b432e8cb234c8fd)
let register_flow_4 = i(v.xu.vregister_cf_31f5681e87749f12)
let register_flow_5 = i(v.xu.vregister_cf_d65add57bf698065)
let register_flow_6 = i(v.xu.vregister_cf_522949c820f09d07)
let register_flow_7 = i(v.xu.vregister_cf_c0d7d1185ef3831a)
let register_flow_8 = i(v.xu.vregister_cf_f3ec2b6ba7278775)
let register_flow_9 = i(v.xu.vregister_cf_afe480660cbc1eda)
let register_flow_10 = i(v.xu.vregister_cf_6e6dcf9202618a41)
let register_flow_11 = i(v.xu.vregister_cf_b632b9c7db1f37e2)
let register_flow_12 = i(v.xu.vregister_cf_820105d57b6322de)
let register_flow_13 = i(v.xu.vregister_cf_c41ef7786c74817d)
let register_flow_14 = i(VGND)
let register_flow_15 = i(VDD)
let register_flow_16 = i(VCTRL)
wrdata current-flow.dat register_flow_0 register_flow_1 register_flow_2 register_flow_3 register_flow_4 register_flow_5 register_flow_6 register_flow_7 register_flow_8 register_flow_9 register_flow_10 register_flow_11 register_flow_12 register_flow_13 register_flow_14 register_flow_15 register_flow_16
let register_voltage_0 = v(XU.VGND.t13)
let register_voltage_1 = v(XU.PBIAS.t2)
let register_voltage_2 = v(XU.CTRL.t0)
let register_voltage_3 = v(XU.VGND.t12)
let register_voltage_4 = v(XU.P2.t1)
let register_voltage_5 = v(XU.OUT.t0)
let register_voltage_6 = v(XU.Q1.t2)
let register_voltage_7 = v(XU.VPWR.t9)
let register_voltage_8 = v(XU.VGND.t11)
let register_voltage_9 = v(XU.N1.t1)
let register_voltage_10 = v(XU.CTRL.t1)
let register_voltage_11 = v(XU.VGND.t10)
let register_voltage_12 = v(XU.P0.t1)
let register_voltage_13 = v(XU.Q0.t0)
let register_voltage_14 = v(XU.OUT.t2)
let register_voltage_15 = v(XU.VPWR.t10)
let register_voltage_16 = v(XU.N0.t1)
let register_voltage_17 = v(XU.Q0.t1)
let register_voltage_18 = v(XU.OUT.t3)
let register_voltage_19 = v(XU.VGND.t2)
let register_voltage_20 = v(XU.VPWR.t6)
let register_voltage_21 = v(XU.P1.t1)
let register_voltage_22 = v(XU.PBIAS.t3)
let register_voltage_23 = v(XU.VPWR.t5)
let register_voltage_24 = v(XU.P1.t0)
let register_voltage_25 = v(XU.Q1.t1)
let register_voltage_26 = v(XU.Q0.t3)
let register_voltage_27 = v(XU.VPWR.t0)
let register_voltage_28 = v(XU.N1.t0)
let register_voltage_29 = v(XU.Q1.t0)
let register_voltage_30 = v(XU.Q0.t4)
let register_voltage_31 = v(XU.VGND.t3)
let register_voltage_32 = v(XU.VPWR.t8)
let register_voltage_33 = v(XU.P2.t0)
let register_voltage_34 = v(XU.PBIAS.t4)
let register_voltage_35 = v(XU.VPWR.t7)
let register_voltage_36 = v(XU.VPWR.t4)
let register_voltage_37 = v(XU.PBIAS.t1)
let register_voltage_38 = v(XU.PBIAS.t0)
let register_voltage_39 = v(XU.VPWR.t3)
let register_voltage_40 = v(XU.VPWR.t2)
let register_voltage_41 = v(XU.P0.t0)
let register_voltage_42 = v(XU.PBIAS.t5)
let register_voltage_43 = v(XU.VPWR.t1)
let register_voltage_44 = v(XU.VGND.t9)
let register_voltage_45 = v(XU.N2.t0)
let register_voltage_46 = v(XU.CTRL.t2)
let register_voltage_47 = v(XU.VGND.t8)
let register_voltage_48 = v(XU.N2.t1)
let register_voltage_49 = v(XU.OUT.t1)
let register_voltage_50 = v(XU.Q1.t3)
let register_voltage_51 = v(XU.VGND.t0)
let register_voltage_52 = v(XU.VGND.t7)
let register_voltage_53 = v(XU.N0.t0)
let register_voltage_54 = v(XU.CTRL.t3)
let register_voltage_55 = v(XU.VGND.t6)
let register_voltage_56 = v(VGND)
let register_voltage_57 = 0*register_flow_0
let register_voltage_58 = v(VPWR)
let register_voltage_59 = v(CTRL)
wrdata node-voltages.dat register_voltage_0 register_voltage_1 register_voltage_2 register_voltage_3 register_voltage_4 register_voltage_5 register_voltage_6 register_voltage_7 register_voltage_8 register_voltage_9 register_voltage_10 register_voltage_11 register_voltage_12 register_voltage_13 register_voltage_14 register_voltage_15 register_voltage_16 register_voltage_17 register_voltage_18 register_voltage_19 register_voltage_20 register_voltage_21 register_voltage_22 register_voltage_23 register_voltage_24 register_voltage_25 register_voltage_26 register_voltage_27 register_voltage_28 register_voltage_29 register_voltage_30 register_voltage_31 register_voltage_32 register_voltage_33 register_voltage_34 register_voltage_35 register_voltage_36 register_voltage_37 register_voltage_38 register_voltage_39 register_voltage_40 register_voltage_41 register_voltage_42 register_voltage_43 register_voltage_44 register_voltage_45 register_voltage_46 register_voltage_47 register_voltage_48 register_voltage_49 register_voltage_50 register_voltage_51 register_voltage_52 register_voltage_53 register_voltage_54 register_voltage_55 register_voltage_56 register_voltage_57 register_voltage_58 register_voltage_59
quit
.endc
.end

.subckt chip_vco CTRL OUT VPWR VGND
XC_STAGE0_P0 Q0 VGND sky130_fd_pr__cap_mim_m3_1 w=15.625 l=15.625
XC_STAGE1_P0 Q1 VGND sky130_fd_pr__cap_mim_m3_1 w=15.625 l=15.625
XC_STAGE2_P0 OUT VGND sky130_fd_pr__cap_mim_m3_1 w=15.625 l=15.625
XN_BIAS register_cf_node_ec12ff604a1a174f CTRL register_cf_node_ec12ff604a1a174f_source VGND sky130_fd_pr__nfet_01v8 w=5 l=0.5 nf=1 m=1
Vregister_cf_ec12ff604a1a174f PBIAS register_cf_node_ec12ff604a1a174f 0
Vregister_cf_ec12ff604a1a174f_source VGND register_cf_node_ec12ff604a1a174f_source 0
XN_INV0 register_cf_node_7a24fdb14b83a7e9 OUT register_cf_node_7a24fdb14b83a7e9_source VGND sky130_fd_pr__nfet_01v8 w=4 l=0.15 nf=1 m=1
Vregister_cf_7a24fdb14b83a7e9 Q0 register_cf_node_7a24fdb14b83a7e9 0
Vregister_cf_7a24fdb14b83a7e9_source N0 register_cf_node_7a24fdb14b83a7e9_source 0
XN_INV1 register_cf_node_611e3da0498dfe8b Q0 register_cf_node_611e3da0498dfe8b_source VGND sky130_fd_pr__nfet_01v8 w=4 l=0.15 nf=1 m=1
Vregister_cf_611e3da0498dfe8b Q1 register_cf_node_611e3da0498dfe8b 0
Vregister_cf_611e3da0498dfe8b_source N1 register_cf_node_611e3da0498dfe8b_source 0
XN_INV2 register_cf_node_29f3fb9bee427e78 Q1 register_cf_node_29f3fb9bee427e78_source VGND sky130_fd_pr__nfet_01v8 w=4 l=0.15 nf=1 m=1
Vregister_cf_29f3fb9bee427e78 OUT register_cf_node_29f3fb9bee427e78 0
Vregister_cf_29f3fb9bee427e78_source N2 register_cf_node_29f3fb9bee427e78_source 0
XN_LIMIT0 register_cf_node_d29d998cf1bdc76b CTRL register_cf_node_d29d998cf1bdc76b_source VGND sky130_fd_pr__nfet_01v8 w=5 l=0.5 nf=1 m=1
Vregister_cf_d29d998cf1bdc76b N0 register_cf_node_d29d998cf1bdc76b 0
Vregister_cf_d29d998cf1bdc76b_source VGND register_cf_node_d29d998cf1bdc76b_source 0
XN_LIMIT1 register_cf_node_e404a067d3f3cf34 CTRL register_cf_node_e404a067d3f3cf34_source VGND sky130_fd_pr__nfet_01v8 w=5 l=0.5 nf=1 m=1
Vregister_cf_e404a067d3f3cf34 N1 register_cf_node_e404a067d3f3cf34 0
Vregister_cf_e404a067d3f3cf34_source VGND register_cf_node_e404a067d3f3cf34_source 0
XN_LIMIT2 register_cf_node_422b4a3416d28d86 CTRL register_cf_node_422b4a3416d28d86_source VGND sky130_fd_pr__nfet_01v8 w=5 l=0.5 nf=1 m=1
Vregister_cf_422b4a3416d28d86 N2 register_cf_node_422b4a3416d28d86 0
Vregister_cf_422b4a3416d28d86_source VGND register_cf_node_422b4a3416d28d86_source 0
XP_BIAS register_cf_node_382bd96dd739c377 PBIAS register_cf_node_382bd96dd739c377_source VPWR sky130_fd_pr__pfet_01v8_hvt w=10 l=0.5 nf=1 m=1
Vregister_cf_382bd96dd739c377 PBIAS register_cf_node_382bd96dd739c377 0
Vregister_cf_382bd96dd739c377_source VPWR register_cf_node_382bd96dd739c377_source 0
XP_INV0 register_cf_node_09ec041b09a3ac0c OUT register_cf_node_09ec041b09a3ac0c_source VPWR sky130_fd_pr__pfet_01v8_hvt w=8 l=0.15 nf=1 m=1
Vregister_cf_09ec041b09a3ac0c Q0 register_cf_node_09ec041b09a3ac0c 0
Vregister_cf_09ec041b09a3ac0c_source P0 register_cf_node_09ec041b09a3ac0c_source 0
XP_INV1 register_cf_node_c541b689b7cdb6ee Q0 register_cf_node_c541b689b7cdb6ee_source VPWR sky130_fd_pr__pfet_01v8_hvt w=8 l=0.15 nf=1 m=1
Vregister_cf_c541b689b7cdb6ee Q1 register_cf_node_c541b689b7cdb6ee 0
Vregister_cf_c541b689b7cdb6ee_source P1 register_cf_node_c541b689b7cdb6ee_source 0
XP_INV2 register_cf_node_92c43e96fc5b433e Q1 register_cf_node_92c43e96fc5b433e_source VPWR sky130_fd_pr__pfet_01v8_hvt w=8 l=0.15 nf=1 m=1
Vregister_cf_92c43e96fc5b433e OUT register_cf_node_92c43e96fc5b433e 0
Vregister_cf_92c43e96fc5b433e_source P2 register_cf_node_92c43e96fc5b433e_source 0
XP_LIMIT0 register_cf_node_e55af5006b029e00 PBIAS register_cf_node_e55af5006b029e00_source VPWR sky130_fd_pr__pfet_01v8_hvt w=10 l=0.5 nf=1 m=1
Vregister_cf_e55af5006b029e00 P0 register_cf_node_e55af5006b029e00 0
Vregister_cf_e55af5006b029e00_source VPWR register_cf_node_e55af5006b029e00_source 0
XP_LIMIT1 register_cf_node_9622e8be4cea711c PBIAS register_cf_node_9622e8be4cea711c_source VPWR sky130_fd_pr__pfet_01v8_hvt w=10 l=0.5 nf=1 m=1
Vregister_cf_9622e8be4cea711c P1 register_cf_node_9622e8be4cea711c 0
Vregister_cf_9622e8be4cea711c_source VPWR register_cf_node_9622e8be4cea711c_source 0
XP_LIMIT2 register_cf_node_8dad081a4c6c4078 PBIAS register_cf_node_8dad081a4c6c4078_source VPWR sky130_fd_pr__pfet_01v8_hvt w=10 l=0.5 nf=1 m=1
Vregister_cf_8dad081a4c6c4078 P2 register_cf_node_8dad081a4c6c4078 0
Vregister_cf_8dad081a4c6c4078_source VPWR register_cf_node_8dad081a4c6c4078_source 0
.ends chip_vco

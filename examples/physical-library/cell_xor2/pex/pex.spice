* NGSPICE file created from cell_xor2.ext - technology: sky130A

.subckt cell_xor2 VPWR VGND Y B A
X0 VPWR.t9 N2.t3 Y.t0 VPWR.t8 sky130_fd_pr__pfet_01v8_hvt ad=0.1885 pd=1.88 as=0.1885 ps=1.88 w=0.65 l=0.15
X1 N2__N1.t0 A.t0 N2.t1 VGND.t1 sky130_fd_pr__nfet_01v8 ad=0.1885 pd=1.88 as=0.1885 ps=1.88 w=0.65 l=0.15
X2 VPWR.t15 N1.t3 N3.t1 VPWR.t14 sky130_fd_pr__pfet_01v8_hvt ad=0.1885 pd=1.88 as=0.1885 ps=1.88 w=0.65 l=0.15
X3 VPWR.t5 B.t0 N3.t0 VPWR.t4 sky130_fd_pr__pfet_01v8_hvt ad=0.1885 pd=1.88 as=0.1885 ps=1.88 w=0.65 l=0.15
X4 VGND.t7 B.t1 N1__N1.t1 VGND.t6 sky130_fd_pr__nfet_01v8 ad=0.1885 pd=1.88 as=0.1885 ps=1.88 w=0.65 l=0.15
X5 VPWR.t13 N1.t4 N2.t2 VPWR.t12 sky130_fd_pr__pfet_01v8_hvt ad=0.1885 pd=1.88 as=0.1885 ps=1.88 w=0.65 l=0.15
X6 N4__N1.t1 N2.t4 Y.t1 VGND.t2 sky130_fd_pr__nfet_01v8 ad=0.1885 pd=1.88 as=0.1885 ps=1.88 w=0.65 l=0.15
X7 VGND.t4 N3.t3 N4__N1.t0 VGND.t3 sky130_fd_pr__nfet_01v8 ad=0.1885 pd=1.88 as=0.1885 ps=1.88 w=0.65 l=0.15
X8 VPWR.t1 A.t1 N1.t1 VPWR.t0 sky130_fd_pr__pfet_01v8_hvt ad=0.1885 pd=1.88 as=0.1885 ps=1.88 w=0.65 l=0.15
X9 N1__N1.t0 A.t2 N1.t0 VGND.t0 sky130_fd_pr__nfet_01v8 ad=0.1885 pd=1.88 as=0.1885 ps=1.88 w=0.65 l=0.15
X10 VPWR.t3 A.t3 N2.t0 VPWR.t2 sky130_fd_pr__pfet_01v8_hvt ad=0.1885 pd=1.88 as=0.1885 ps=1.88 w=0.65 l=0.15
X11 VGND.t11 N1.t5 N3__N1.t1 VGND.t10 sky130_fd_pr__nfet_01v8 ad=0.1885 pd=1.88 as=0.1885 ps=1.88 w=0.65 l=0.15
X12 VPWR.t11 N3.t4 Y.t2 VPWR.t10 sky130_fd_pr__pfet_01v8_hvt ad=0.1885 pd=1.88 as=0.1885 ps=1.88 w=0.65 l=0.15
X13 N3__N1.t0 B.t2 N3.t2 VGND.t5 sky130_fd_pr__nfet_01v8 ad=0.1885 pd=1.88 as=0.1885 ps=1.88 w=0.65 l=0.15
X14 VPWR.t7 B.t3 N1.t2 VPWR.t6 sky130_fd_pr__pfet_01v8_hvt ad=0.1885 pd=1.88 as=0.1885 ps=1.88 w=0.65 l=0.15
X15 VGND.t9 N1.t6 N2__N1.t1 VGND.t8 sky130_fd_pr__nfet_01v8 ad=0.1885 pd=1.88 as=0.1885 ps=1.88 w=0.65 l=0.15
C0 B N1__N1 0.33316f
C1 N2 N1__N1 0.03409f
C2 B N3 1.05596f
C3 Y N1__N1 0.14988f
C4 B N2 0.29973f
C5 N3 N2 0.1708f
C6 N1 N3__N1 0.42266f
C7 N1__N1 VPWR 0.0122f
C8 B Y 4.24891f
C9 B N2__N1 0.15663f
C10 N3 Y 1.19195f
C11 B VPWR 0.85648f
C12 Y N2 1.17829f
C13 N3 N2__N1 0.00306f
C14 N3 VPWR 1.01615f
C15 N2 N2__N1 1.30662f
C16 N2 VPWR 0.94638f
C17 Y N2__N1 0.14763f
C18 Y VPWR 0.52822f
C19 N2__N1 VPWR 0.0121f
C20 A N1 0.48342f
C21 B N3__N1 0.68586f
C22 N3 N3__N1 0.38898f
C23 N3__N1 N2 0.91385f
C24 Y N3__N1 0.15908f
C25 N3 N4__N1 1.06844f
C26 N2 N4__N1 0.6758f
C27 N3__N1 VPWR 0.0121f
C28 Y N4__N1 0.66826f
C29 N4__N1 VPWR 0.01242f
C30 N1 N1__N1 1.27643f
C31 B N1 0.54043f
C32 A N1__N1 0.65925f
C33 N3 N1 0.33125f
C34 N1 N2 3.67963f
C35 B A 2.69235f
C36 N1 Y 5.63105f
C37 A N2 0.3955f
C38 N1 N2__N1 0.40398f
C39 N1 VPWR 1.36821f
C40 A Y 0.00384f
C41 A N2__N1 0.57595f
C42 A VPWR 0.89523f
R0 N2.t2 N2.n2 700.484
R1 N2.n3 N2.t2 700.484
R2 N2.t0 N2.n0 700.484
R3 N2.n11 N2.t0 700.484
R4 N2 N2.t3 330.341
R5 N2 N2.t4 315.88
R6 N2.t1 N2.n6 255.345
R7 N2.n7 N2.t1 255.345
R8 N2.n1 N2 31.8666
R9 N2.n1 N2 31.0337
R10 N2 N2.n6 12.8005
R11 N2.n7 N2 12.8005
R12 N2 N2.n2 12.8005
R13 N2.n3 N2 12.8005
R14 N2 N2.n0 12.8005
R15 N2 N2.n11 12.8005
R16 N2.n10 N2.n9 12.5193
R17 N2.n9 N2.n8 11.7021
R18 N2.n5 N2.n4 11.7021
R19 N2.n8 N2.n6 10.1513
R20 N2.n8 N2.n7 10.1513
R21 N2.n4 N2.n2 10.1513
R22 N2.n4 N2.n3 10.1513
R23 N2.n10 N2.n0 10.1513
R24 N2.n11 N2.n10 10.1513
R25 N2.n5 N2.n1 5.31737
R26 N2.n9 N2.n5 0.817713
R27 Y.t0 Y.n1 700.484
R28 Y.n2 Y.t0 700.484
R29 Y.t2 Y.n0 700.484
R30 Y.n10 Y.t2 700.484
R31 Y.t1 Y.n5 255.345
R32 Y.n6 Y.t1 255.345
R33 Y Y.n5 12.8005
R34 Y.n6 Y 12.8005
R35 Y Y.n0 12.8005
R36 Y Y.n10 12.8005
R37 Y Y.n1 12.8005
R38 Y.n2 Y 12.8005
R39 Y.n9 Y.n8 11.686
R40 Y.n8 Y.n7 10.8688
R41 Y.n4 Y.n3 10.8688
R42 Y.n4 Y 10.1601
R43 Y.n7 Y.n5 10.1513
R44 Y.n7 Y.n6 10.1513
R45 Y.n9 Y.n0 10.1513
R46 Y.n10 Y.n9 10.1513
R47 Y.n3 Y.n1 10.1513
R48 Y.n3 Y.n2 10.1513
R49 Y.n8 Y.n4 0.817713
R50 VPWR.n55 VPWR.n43 832.942
R51 VPWR.n66 VPWR.n44 832.942
R52 VPWR.n68 VPWR.n41 832.942
R53 VPWR.n50 VPWR.n40 832.942
R54 VPWR.n92 VPWR.n80 832.942
R55 VPWR.n103 VPWR.n81 832.942
R56 VPWR.n105 VPWR.n78 832.942
R57 VPWR.n87 VPWR.n77 832.942
R58 VPWR.n129 VPWR.n117 832.942
R59 VPWR.n140 VPWR.n118 832.942
R60 VPWR.n142 VPWR.n115 832.942
R61 VPWR.n124 VPWR.n114 832.942
R62 VPWR.n166 VPWR.n154 832.942
R63 VPWR.n177 VPWR.n155 832.942
R64 VPWR.n179 VPWR.n152 832.942
R65 VPWR.n161 VPWR.n151 832.942
R66 VPWR.n203 VPWR.n191 832.942
R67 VPWR.n214 VPWR.n192 832.942
R68 VPWR.n216 VPWR.n189 832.942
R69 VPWR.n198 VPWR.n188 832.942
R70 VPWR.n240 VPWR.n228 832.942
R71 VPWR.n251 VPWR.n229 832.942
R72 VPWR.n253 VPWR.n226 832.942
R73 VPWR.n235 VPWR.n225 832.942
R74 VPWR.n277 VPWR.n265 832.942
R75 VPWR.n288 VPWR.n266 832.942
R76 VPWR.n290 VPWR.n263 832.942
R77 VPWR.n272 VPWR.n262 832.942
R78 VPWR.n18 VPWR.n6 832.942
R79 VPWR.n29 VPWR.n7 832.942
R80 VPWR.n31 VPWR.n4 832.942
R81 VPWR.n13 VPWR.n3 832.942
R82 VPWR.t1 VPWR.n34 700.484
R83 VPWR.n35 VPWR.t1 700.484
R84 VPWR.t7 VPWR.n71 700.484
R85 VPWR.n72 VPWR.t7 700.484
R86 VPWR.t3 VPWR.n108 700.484
R87 VPWR.n109 VPWR.t3 700.484
R88 VPWR.t13 VPWR.n145 700.484
R89 VPWR.n146 VPWR.t13 700.484
R90 VPWR.t5 VPWR.n182 700.484
R91 VPWR.n183 VPWR.t5 700.484
R92 VPWR.t15 VPWR.n219 700.484
R93 VPWR.n220 VPWR.t15 700.484
R94 VPWR.t9 VPWR.n256 700.484
R95 VPWR.n257 VPWR.t9 700.484
R96 VPWR.t11 VPWR.n0 700.484
R97 VPWR.n294 VPWR.t11 700.484
R98 VPWR.n66 VPWR.n43 240
R99 VPWR.n62 VPWR.n60 240
R100 VPWR.n68 VPWR.n40 240
R101 VPWR.n47 VPWR.n46 240
R102 VPWR.n103 VPWR.n80 240
R103 VPWR.n99 VPWR.n97 240
R104 VPWR.n105 VPWR.n77 240
R105 VPWR.n84 VPWR.n83 240
R106 VPWR.n140 VPWR.n117 240
R107 VPWR.n136 VPWR.n134 240
R108 VPWR.n142 VPWR.n114 240
R109 VPWR.n121 VPWR.n120 240
R110 VPWR.n177 VPWR.n154 240
R111 VPWR.n173 VPWR.n171 240
R112 VPWR.n179 VPWR.n151 240
R113 VPWR.n158 VPWR.n157 240
R114 VPWR.n214 VPWR.n191 240
R115 VPWR.n210 VPWR.n208 240
R116 VPWR.n216 VPWR.n188 240
R117 VPWR.n195 VPWR.n194 240
R118 VPWR.n251 VPWR.n228 240
R119 VPWR.n247 VPWR.n245 240
R120 VPWR.n253 VPWR.n225 240
R121 VPWR.n232 VPWR.n231 240
R122 VPWR.n288 VPWR.n265 240
R123 VPWR.n284 VPWR.n282 240
R124 VPWR.n290 VPWR.n262 240
R125 VPWR.n269 VPWR.n268 240
R126 VPWR.n29 VPWR.n6 240
R127 VPWR.n25 VPWR.n23 240
R128 VPWR.n31 VPWR.n3 240
R129 VPWR.n10 VPWR.n9 240
R130 VPWR.n53 VPWR.n52 207.394
R131 VPWR.n67 VPWR.n42 207.394
R132 VPWR.n90 VPWR.n89 207.394
R133 VPWR.n104 VPWR.n79 207.394
R134 VPWR.n127 VPWR.n126 207.394
R135 VPWR.n141 VPWR.n116 207.394
R136 VPWR.n164 VPWR.n163 207.394
R137 VPWR.n178 VPWR.n153 207.394
R138 VPWR.n201 VPWR.n200 207.394
R139 VPWR.n215 VPWR.n190 207.394
R140 VPWR.n238 VPWR.n237 207.394
R141 VPWR.n252 VPWR.n227 207.394
R142 VPWR.n275 VPWR.n274 207.394
R143 VPWR.n289 VPWR.n264 207.394
R144 VPWR.n16 VPWR.n15 207.394
R145 VPWR.n30 VPWR.n5 207.394
R146 VPWR.n50 VPWR.n49 185
R147 VPWR.n48 VPWR.n47 185
R148 VPWR.n46 VPWR.n45 185
R149 VPWR.n56 VPWR.n55 185
R150 VPWR.n57 VPWR.n43 185
R151 VPWR.n52 VPWR.n43 185
R152 VPWR.n66 VPWR.n65 185
R153 VPWR.n67 VPWR.n66 185
R154 VPWR.n64 VPWR.n44 185
R155 VPWR.n63 VPWR.n62 185
R156 VPWR.n60 VPWR.n58 185
R157 VPWR.n41 VPWR.n39 185
R158 VPWR.n69 VPWR.n68 185
R159 VPWR.n68 VPWR.n67 185
R160 VPWR.n40 VPWR.n38 185
R161 VPWR.n52 VPWR.n40 185
R162 VPWR.n87 VPWR.n86 185
R163 VPWR.n85 VPWR.n84 185
R164 VPWR.n83 VPWR.n82 185
R165 VPWR.n93 VPWR.n92 185
R166 VPWR.n94 VPWR.n80 185
R167 VPWR.n89 VPWR.n80 185
R168 VPWR.n103 VPWR.n102 185
R169 VPWR.n104 VPWR.n103 185
R170 VPWR.n101 VPWR.n81 185
R171 VPWR.n100 VPWR.n99 185
R172 VPWR.n97 VPWR.n95 185
R173 VPWR.n78 VPWR.n76 185
R174 VPWR.n106 VPWR.n105 185
R175 VPWR.n105 VPWR.n104 185
R176 VPWR.n77 VPWR.n75 185
R177 VPWR.n89 VPWR.n77 185
R178 VPWR.n124 VPWR.n123 185
R179 VPWR.n122 VPWR.n121 185
R180 VPWR.n120 VPWR.n119 185
R181 VPWR.n130 VPWR.n129 185
R182 VPWR.n131 VPWR.n117 185
R183 VPWR.n126 VPWR.n117 185
R184 VPWR.n140 VPWR.n139 185
R185 VPWR.n141 VPWR.n140 185
R186 VPWR.n138 VPWR.n118 185
R187 VPWR.n137 VPWR.n136 185
R188 VPWR.n134 VPWR.n132 185
R189 VPWR.n115 VPWR.n113 185
R190 VPWR.n143 VPWR.n142 185
R191 VPWR.n142 VPWR.n141 185
R192 VPWR.n114 VPWR.n112 185
R193 VPWR.n126 VPWR.n114 185
R194 VPWR.n161 VPWR.n160 185
R195 VPWR.n159 VPWR.n158 185
R196 VPWR.n157 VPWR.n156 185
R197 VPWR.n167 VPWR.n166 185
R198 VPWR.n168 VPWR.n154 185
R199 VPWR.n163 VPWR.n154 185
R200 VPWR.n177 VPWR.n176 185
R201 VPWR.n178 VPWR.n177 185
R202 VPWR.n175 VPWR.n155 185
R203 VPWR.n174 VPWR.n173 185
R204 VPWR.n171 VPWR.n169 185
R205 VPWR.n152 VPWR.n150 185
R206 VPWR.n180 VPWR.n179 185
R207 VPWR.n179 VPWR.n178 185
R208 VPWR.n151 VPWR.n149 185
R209 VPWR.n163 VPWR.n151 185
R210 VPWR.n198 VPWR.n197 185
R211 VPWR.n196 VPWR.n195 185
R212 VPWR.n194 VPWR.n193 185
R213 VPWR.n204 VPWR.n203 185
R214 VPWR.n205 VPWR.n191 185
R215 VPWR.n200 VPWR.n191 185
R216 VPWR.n214 VPWR.n213 185
R217 VPWR.n215 VPWR.n214 185
R218 VPWR.n212 VPWR.n192 185
R219 VPWR.n211 VPWR.n210 185
R220 VPWR.n208 VPWR.n206 185
R221 VPWR.n189 VPWR.n187 185
R222 VPWR.n217 VPWR.n216 185
R223 VPWR.n216 VPWR.n215 185
R224 VPWR.n188 VPWR.n186 185
R225 VPWR.n200 VPWR.n188 185
R226 VPWR.n235 VPWR.n234 185
R227 VPWR.n233 VPWR.n232 185
R228 VPWR.n231 VPWR.n230 185
R229 VPWR.n241 VPWR.n240 185
R230 VPWR.n242 VPWR.n228 185
R231 VPWR.n237 VPWR.n228 185
R232 VPWR.n251 VPWR.n250 185
R233 VPWR.n252 VPWR.n251 185
R234 VPWR.n249 VPWR.n229 185
R235 VPWR.n248 VPWR.n247 185
R236 VPWR.n245 VPWR.n243 185
R237 VPWR.n226 VPWR.n224 185
R238 VPWR.n254 VPWR.n253 185
R239 VPWR.n253 VPWR.n252 185
R240 VPWR.n225 VPWR.n223 185
R241 VPWR.n237 VPWR.n225 185
R242 VPWR.n272 VPWR.n271 185
R243 VPWR.n270 VPWR.n269 185
R244 VPWR.n268 VPWR.n267 185
R245 VPWR.n278 VPWR.n277 185
R246 VPWR.n279 VPWR.n265 185
R247 VPWR.n274 VPWR.n265 185
R248 VPWR.n288 VPWR.n287 185
R249 VPWR.n289 VPWR.n288 185
R250 VPWR.n286 VPWR.n266 185
R251 VPWR.n285 VPWR.n284 185
R252 VPWR.n282 VPWR.n280 185
R253 VPWR.n263 VPWR.n261 185
R254 VPWR.n291 VPWR.n290 185
R255 VPWR.n290 VPWR.n289 185
R256 VPWR.n262 VPWR.n260 185
R257 VPWR.n274 VPWR.n262 185
R258 VPWR.n13 VPWR.n12 185
R259 VPWR.n11 VPWR.n10 185
R260 VPWR.n9 VPWR.n8 185
R261 VPWR.n19 VPWR.n18 185
R262 VPWR.n20 VPWR.n6 185
R263 VPWR.n15 VPWR.n6 185
R264 VPWR.n29 VPWR.n28 185
R265 VPWR.n30 VPWR.n29 185
R266 VPWR.n27 VPWR.n7 185
R267 VPWR.n26 VPWR.n25 185
R268 VPWR.n23 VPWR.n21 185
R269 VPWR.n4 VPWR.n2 185
R270 VPWR.n32 VPWR.n31 185
R271 VPWR.n31 VPWR.n30 185
R272 VPWR.n3 VPWR.n1 185
R273 VPWR.n15 VPWR.n3 185
R274 VPWR.n57 VPWR.n56 88.8476
R275 VPWR.n49 VPWR.n38 88.8476
R276 VPWR.n65 VPWR.n64 88.8476
R277 VPWR.n69 VPWR.n39 88.8476
R278 VPWR.n94 VPWR.n93 88.8476
R279 VPWR.n86 VPWR.n75 88.8476
R280 VPWR.n102 VPWR.n101 88.8476
R281 VPWR.n106 VPWR.n76 88.8476
R282 VPWR.n131 VPWR.n130 88.8476
R283 VPWR.n123 VPWR.n112 88.8476
R284 VPWR.n139 VPWR.n138 88.8476
R285 VPWR.n143 VPWR.n113 88.8476
R286 VPWR.n168 VPWR.n167 88.8476
R287 VPWR.n160 VPWR.n149 88.8476
R288 VPWR.n176 VPWR.n175 88.8476
R289 VPWR.n180 VPWR.n150 88.8476
R290 VPWR.n205 VPWR.n204 88.8476
R291 VPWR.n197 VPWR.n186 88.8476
R292 VPWR.n213 VPWR.n212 88.8476
R293 VPWR.n217 VPWR.n187 88.8476
R294 VPWR.n242 VPWR.n241 88.8476
R295 VPWR.n234 VPWR.n223 88.8476
R296 VPWR.n250 VPWR.n249 88.8476
R297 VPWR.n254 VPWR.n224 88.8476
R298 VPWR.n279 VPWR.n278 88.8476
R299 VPWR.n271 VPWR.n260 88.8476
R300 VPWR.n287 VPWR.n286 88.8476
R301 VPWR.n291 VPWR.n261 88.8476
R302 VPWR.n20 VPWR.n19 88.8476
R303 VPWR.n12 VPWR.n1 88.8476
R304 VPWR.n28 VPWR.n27 88.8476
R305 VPWR.n32 VPWR.n2 88.8476
R306 VPWR.n61 VPWR.n44 72.7879
R307 VPWR.n59 VPWR.n41 72.7879
R308 VPWR.n55 VPWR.n54 72.7879
R309 VPWR.n51 VPWR.n47 72.7879
R310 VPWR.n51 VPWR.n50 72.7879
R311 VPWR.n54 VPWR.n46 72.7879
R312 VPWR.n62 VPWR.n61 72.7879
R313 VPWR.n60 VPWR.n59 72.7879
R314 VPWR.n98 VPWR.n81 72.7879
R315 VPWR.n96 VPWR.n78 72.7879
R316 VPWR.n92 VPWR.n91 72.7879
R317 VPWR.n88 VPWR.n84 72.7879
R318 VPWR.n88 VPWR.n87 72.7879
R319 VPWR.n91 VPWR.n83 72.7879
R320 VPWR.n99 VPWR.n98 72.7879
R321 VPWR.n97 VPWR.n96 72.7879
R322 VPWR.n135 VPWR.n118 72.7879
R323 VPWR.n133 VPWR.n115 72.7879
R324 VPWR.n129 VPWR.n128 72.7879
R325 VPWR.n125 VPWR.n121 72.7879
R326 VPWR.n125 VPWR.n124 72.7879
R327 VPWR.n128 VPWR.n120 72.7879
R328 VPWR.n136 VPWR.n135 72.7879
R329 VPWR.n134 VPWR.n133 72.7879
R330 VPWR.n172 VPWR.n155 72.7879
R331 VPWR.n170 VPWR.n152 72.7879
R332 VPWR.n166 VPWR.n165 72.7879
R333 VPWR.n162 VPWR.n158 72.7879
R334 VPWR.n162 VPWR.n161 72.7879
R335 VPWR.n165 VPWR.n157 72.7879
R336 VPWR.n173 VPWR.n172 72.7879
R337 VPWR.n171 VPWR.n170 72.7879
R338 VPWR.n209 VPWR.n192 72.7879
R339 VPWR.n207 VPWR.n189 72.7879
R340 VPWR.n203 VPWR.n202 72.7879
R341 VPWR.n199 VPWR.n195 72.7879
R342 VPWR.n199 VPWR.n198 72.7879
R343 VPWR.n202 VPWR.n194 72.7879
R344 VPWR.n210 VPWR.n209 72.7879
R345 VPWR.n208 VPWR.n207 72.7879
R346 VPWR.n246 VPWR.n229 72.7879
R347 VPWR.n244 VPWR.n226 72.7879
R348 VPWR.n240 VPWR.n239 72.7879
R349 VPWR.n236 VPWR.n232 72.7879
R350 VPWR.n236 VPWR.n235 72.7879
R351 VPWR.n239 VPWR.n231 72.7879
R352 VPWR.n247 VPWR.n246 72.7879
R353 VPWR.n245 VPWR.n244 72.7879
R354 VPWR.n283 VPWR.n266 72.7879
R355 VPWR.n281 VPWR.n263 72.7879
R356 VPWR.n277 VPWR.n276 72.7879
R357 VPWR.n273 VPWR.n269 72.7879
R358 VPWR.n273 VPWR.n272 72.7879
R359 VPWR.n276 VPWR.n268 72.7879
R360 VPWR.n284 VPWR.n283 72.7879
R361 VPWR.n282 VPWR.n281 72.7879
R362 VPWR.n24 VPWR.n7 72.7879
R363 VPWR.n22 VPWR.n4 72.7879
R364 VPWR.n18 VPWR.n17 72.7879
R365 VPWR.n14 VPWR.n10 72.7879
R366 VPWR.n14 VPWR.n13 72.7879
R367 VPWR.n17 VPWR.n9 72.7879
R368 VPWR.n25 VPWR.n24 72.7879
R369 VPWR.n23 VPWR.n22 72.7879
R370 VPWR.n52 VPWR.t6 56.8667
R371 VPWR.n67 VPWR.t6 56.8667
R372 VPWR.n89 VPWR.t2 56.8667
R373 VPWR.n104 VPWR.t2 56.8667
R374 VPWR.n126 VPWR.t12 56.8667
R375 VPWR.n141 VPWR.t12 56.8667
R376 VPWR.n163 VPWR.t4 56.8667
R377 VPWR.n178 VPWR.t4 56.8667
R378 VPWR.n200 VPWR.t14 56.8667
R379 VPWR.n215 VPWR.t14 56.8667
R380 VPWR.n237 VPWR.t8 56.8667
R381 VPWR.n252 VPWR.t8 56.8667
R382 VPWR.n274 VPWR.t10 56.8667
R383 VPWR.n289 VPWR.t10 56.8667
R384 VPWR.n15 VPWR.t0 56.8667
R385 VPWR.n30 VPWR.t0 56.8667
R386 VPWR.n53 VPWR.n51 56.1076
R387 VPWR.n54 VPWR.n53 56.1076
R388 VPWR.n61 VPWR.n42 56.1076
R389 VPWR.n59 VPWR.n42 56.1076
R390 VPWR.n90 VPWR.n88 56.1076
R391 VPWR.n91 VPWR.n90 56.1076
R392 VPWR.n98 VPWR.n79 56.1076
R393 VPWR.n96 VPWR.n79 56.1076
R394 VPWR.n127 VPWR.n125 56.1076
R395 VPWR.n128 VPWR.n127 56.1076
R396 VPWR.n135 VPWR.n116 56.1076
R397 VPWR.n133 VPWR.n116 56.1076
R398 VPWR.n164 VPWR.n162 56.1076
R399 VPWR.n165 VPWR.n164 56.1076
R400 VPWR.n172 VPWR.n153 56.1076
R401 VPWR.n170 VPWR.n153 56.1076
R402 VPWR.n201 VPWR.n199 56.1076
R403 VPWR.n202 VPWR.n201 56.1076
R404 VPWR.n209 VPWR.n190 56.1076
R405 VPWR.n207 VPWR.n190 56.1076
R406 VPWR.n238 VPWR.n236 56.1076
R407 VPWR.n239 VPWR.n238 56.1076
R408 VPWR.n246 VPWR.n227 56.1076
R409 VPWR.n244 VPWR.n227 56.1076
R410 VPWR.n275 VPWR.n273 56.1076
R411 VPWR.n276 VPWR.n275 56.1076
R412 VPWR.n283 VPWR.n264 56.1076
R413 VPWR.n281 VPWR.n264 56.1076
R414 VPWR.n16 VPWR.n14 56.1076
R415 VPWR.n17 VPWR.n16 56.1076
R416 VPWR.n24 VPWR.n5 56.1076
R417 VPWR.n22 VPWR.n5 56.1076
R418 VPWR.n56 VPWR.n45 25.6005
R419 VPWR.n48 VPWR.n45 25.6005
R420 VPWR.n49 VPWR.n48 25.6005
R421 VPWR.n65 VPWR.n57 25.6005
R422 VPWR.n64 VPWR.n63 25.6005
R423 VPWR.n63 VPWR.n58 25.6005
R424 VPWR.n58 VPWR.n39 25.6005
R425 VPWR.n93 VPWR.n82 25.6005
R426 VPWR.n85 VPWR.n82 25.6005
R427 VPWR.n86 VPWR.n85 25.6005
R428 VPWR.n102 VPWR.n94 25.6005
R429 VPWR.n101 VPWR.n100 25.6005
R430 VPWR.n100 VPWR.n95 25.6005
R431 VPWR.n95 VPWR.n76 25.6005
R432 VPWR.n130 VPWR.n119 25.6005
R433 VPWR.n122 VPWR.n119 25.6005
R434 VPWR.n123 VPWR.n122 25.6005
R435 VPWR.n139 VPWR.n131 25.6005
R436 VPWR.n138 VPWR.n137 25.6005
R437 VPWR.n137 VPWR.n132 25.6005
R438 VPWR.n132 VPWR.n113 25.6005
R439 VPWR.n167 VPWR.n156 25.6005
R440 VPWR.n159 VPWR.n156 25.6005
R441 VPWR.n160 VPWR.n159 25.6005
R442 VPWR.n176 VPWR.n168 25.6005
R443 VPWR.n175 VPWR.n174 25.6005
R444 VPWR.n174 VPWR.n169 25.6005
R445 VPWR.n169 VPWR.n150 25.6005
R446 VPWR.n204 VPWR.n193 25.6005
R447 VPWR.n196 VPWR.n193 25.6005
R448 VPWR.n197 VPWR.n196 25.6005
R449 VPWR.n213 VPWR.n205 25.6005
R450 VPWR.n212 VPWR.n211 25.6005
R451 VPWR.n211 VPWR.n206 25.6005
R452 VPWR.n206 VPWR.n187 25.6005
R453 VPWR.n241 VPWR.n230 25.6005
R454 VPWR.n233 VPWR.n230 25.6005
R455 VPWR.n234 VPWR.n233 25.6005
R456 VPWR.n250 VPWR.n242 25.6005
R457 VPWR.n249 VPWR.n248 25.6005
R458 VPWR.n248 VPWR.n243 25.6005
R459 VPWR.n243 VPWR.n224 25.6005
R460 VPWR.n278 VPWR.n267 25.6005
R461 VPWR.n270 VPWR.n267 25.6005
R462 VPWR.n271 VPWR.n270 25.6005
R463 VPWR.n287 VPWR.n279 25.6005
R464 VPWR.n286 VPWR.n285 25.6005
R465 VPWR.n285 VPWR.n280 25.6005
R466 VPWR.n280 VPWR.n261 25.6005
R467 VPWR.n19 VPWR.n8 25.6005
R468 VPWR.n11 VPWR.n8 25.6005
R469 VPWR.n12 VPWR.n11 25.6005
R470 VPWR.n28 VPWR.n20 25.6005
R471 VPWR.n27 VPWR.n26 25.6005
R472 VPWR.n26 VPWR.n21 25.6005
R473 VPWR.n21 VPWR.n2 25.6005
R474 VPWR.n70 VPWR 18.865
R475 VPWR.n107 VPWR 18.865
R476 VPWR.n144 VPWR 18.865
R477 VPWR.n181 VPWR 18.865
R478 VPWR.n218 VPWR 18.865
R479 VPWR.n255 VPWR 18.865
R480 VPWR.n292 VPWR 18.865
R481 VPWR.n33 VPWR 18.865
R482 VPWR VPWR.n34 12.8005
R483 VPWR.n35 VPWR 12.8005
R484 VPWR VPWR.n38 12.8005
R485 VPWR VPWR.n69 12.8005
R486 VPWR VPWR.n71 12.8005
R487 VPWR.n72 VPWR 12.8005
R488 VPWR VPWR.n75 12.8005
R489 VPWR VPWR.n106 12.8005
R490 VPWR VPWR.n108 12.8005
R491 VPWR.n109 VPWR 12.8005
R492 VPWR VPWR.n112 12.8005
R493 VPWR VPWR.n143 12.8005
R494 VPWR VPWR.n145 12.8005
R495 VPWR.n146 VPWR 12.8005
R496 VPWR VPWR.n149 12.8005
R497 VPWR VPWR.n180 12.8005
R498 VPWR VPWR.n182 12.8005
R499 VPWR.n183 VPWR 12.8005
R500 VPWR VPWR.n186 12.8005
R501 VPWR VPWR.n217 12.8005
R502 VPWR VPWR.n219 12.8005
R503 VPWR.n220 VPWR 12.8005
R504 VPWR VPWR.n223 12.8005
R505 VPWR VPWR.n254 12.8005
R506 VPWR VPWR.n256 12.8005
R507 VPWR.n257 VPWR 12.8005
R508 VPWR VPWR.n260 12.8005
R509 VPWR VPWR.n291 12.8005
R510 VPWR VPWR.n0 12.8005
R511 VPWR VPWR.n294 12.8005
R512 VPWR VPWR.n1 12.8005
R513 VPWR VPWR.n32 12.8005
R514 VPWR.n293 VPWR.n292 10.6855
R515 VPWR.n37 VPWR.n36 10.5563
R516 VPWR.n74 VPWR.n73 10.5563
R517 VPWR.n111 VPWR.n110 10.5563
R518 VPWR.n148 VPWR.n147 10.5563
R519 VPWR.n185 VPWR.n184 10.5563
R520 VPWR.n222 VPWR.n221 10.5563
R521 VPWR.n259 VPWR.n258 10.5563
R522 VPWR.n36 VPWR.n34 10.1513
R523 VPWR.n36 VPWR.n35 10.1513
R524 VPWR.n73 VPWR.n71 10.1513
R525 VPWR.n73 VPWR.n72 10.1513
R526 VPWR.n110 VPWR.n108 10.1513
R527 VPWR.n110 VPWR.n109 10.1513
R528 VPWR.n147 VPWR.n145 10.1513
R529 VPWR.n147 VPWR.n146 10.1513
R530 VPWR.n184 VPWR.n182 10.1513
R531 VPWR.n184 VPWR.n183 10.1513
R532 VPWR.n221 VPWR.n219 10.1513
R533 VPWR.n221 VPWR.n220 10.1513
R534 VPWR.n258 VPWR.n256 10.1513
R535 VPWR.n258 VPWR.n257 10.1513
R536 VPWR.n293 VPWR.n0 10.1513
R537 VPWR.n294 VPWR.n293 10.1513
R538 VPWR.n292 VPWR.n259 1.50567
R539 VPWR.n255 VPWR.n222 1.50567
R540 VPWR.n218 VPWR.n185 1.50567
R541 VPWR.n181 VPWR.n148 1.50567
R542 VPWR.n144 VPWR.n111 1.50567
R543 VPWR.n107 VPWR.n74 1.50567
R544 VPWR.n70 VPWR.n37 1.50567
R545 VPWR.n33 VPWR 0.353587
R546 VPWR.n259 VPWR.n255 0.12975
R547 VPWR.n222 VPWR.n218 0.12975
R548 VPWR.n185 VPWR.n181 0.12975
R549 VPWR.n148 VPWR.n144 0.12975
R550 VPWR.n111 VPWR.n107 0.12975
R551 VPWR.n74 VPWR.n70 0.12975
R552 VPWR.n37 VPWR.n33 0.12975
R553 A A.t1 330.341
R554 A A.t3 330.341
R555 A A.t2 315.88
R556 A A.t0 315.88
R557 A A.n2 30.1999
R558 A.n1 A 29.3827
R559 A.n2 A 29.3671
R560 A.n0 A 29.3671
R561 A.n2 A.n1 2.47564
R562 A.n1 A.n0 0.817713
R563 A.n0 A 0.567438
R564 N2__N1.t1 N2__N1.n1 255.345
R565 N2__N1.n2 N2__N1.t1 255.345
R566 N2__N1.t0 N2__N1.n0 255.345
R567 N2__N1.n5 N2__N1.t0 255.345
R568 N2__N1.n4 N2__N1.n3 25.6012
R569 N2__N1 N2__N1.n1 12.8005
R570 N2__N1.n2 N2__N1 12.8005
R571 N2__N1 N2__N1.n0 12.8005
R572 N2__N1 N2__N1.n5 12.8005
R573 N2__N1.n3 N2__N1.n1 10.1513
R574 N2__N1.n3 N2__N1.n2 10.1513
R575 N2__N1.n4 N2__N1.n0 10.1513
R576 N2__N1.n5 N2__N1.n4 10.1513
R577 VGND.n248 VGND.n247 3773.63
R578 VGND.n194 VGND.n193 3385.71
R579 VGND.n203 VGND.n202 3385.71
R580 VGND.n212 VGND.n211 3385.71
R581 VGND.n221 VGND.n220 3385.71
R582 VGND.n230 VGND.n229 3385.71
R583 VGND.n239 VGND.n238 3385.71
R584 VGND.n245 VGND.n9 1315.26
R585 VGND.n241 VGND.n10 1315.26
R586 VGND.n20 VGND.n8 1315.26
R587 VGND.n23 VGND.n15 1315.26
R588 VGND.n236 VGND.n32 1315.26
R589 VGND.n232 VGND.n33 1315.26
R590 VGND.n104 VGND.n31 1315.26
R591 VGND.n111 VGND.n110 1315.26
R592 VGND.n227 VGND.n42 1315.26
R593 VGND.n223 VGND.n43 1315.26
R594 VGND.n118 VGND.n41 1315.26
R595 VGND.n125 VGND.n124 1315.26
R596 VGND.n218 VGND.n52 1315.26
R597 VGND.n214 VGND.n53 1315.26
R598 VGND.n136 VGND.n51 1315.26
R599 VGND.n143 VGND.n142 1315.26
R600 VGND.n209 VGND.n62 1315.26
R601 VGND.n205 VGND.n63 1315.26
R602 VGND.n150 VGND.n61 1315.26
R603 VGND.n157 VGND.n156 1315.26
R604 VGND.n200 VGND.n72 1315.26
R605 VGND.n196 VGND.n73 1315.26
R606 VGND.n168 VGND.n71 1315.26
R607 VGND.n175 VGND.n174 1315.26
R608 VGND.n191 VGND.n82 1315.26
R609 VGND.n187 VGND.n83 1315.26
R610 VGND.n93 VGND.n81 1315.26
R611 VGND.n179 VGND.n88 1315.26
R612 VGND.n261 VGND.n249 1315.26
R613 VGND.n272 VGND.n250 1315.26
R614 VGND.n274 VGND.n5 1315.26
R615 VGND.n256 VGND.n4 1315.26
R616 VGND.n188 VGND.n187 585
R617 VGND.n86 VGND.n85 585
R618 VGND.n183 VGND.n182 585
R619 VGND.n181 VGND.n88 585
R620 VGND.n180 VGND.n179 585
R621 VGND.n179 VGND.n87 585
R622 VGND.n95 VGND.n81 585
R623 VGND.n192 VGND.n81 585
R624 VGND.n94 VGND.n93 585
R625 VGND.n92 VGND.n91 585
R626 VGND.n90 VGND.n89 585
R627 VGND.n84 VGND.n82 585
R628 VGND.n191 VGND.n190 585
R629 VGND.n192 VGND.n191 585
R630 VGND.n189 VGND.n83 585
R631 VGND.n87 VGND.n83 585
R632 VGND.n197 VGND.n196 585
R633 VGND.n76 VGND.n75 585
R634 VGND.n172 VGND.n171 585
R635 VGND.n174 VGND.n173 585
R636 VGND.n176 VGND.n175 585
R637 VGND.n175 VGND.n77 585
R638 VGND.n170 VGND.n71 585
R639 VGND.n201 VGND.n71 585
R640 VGND.n169 VGND.n168 585
R641 VGND.n167 VGND.n166 585
R642 VGND.n165 VGND.n164 585
R643 VGND.n74 VGND.n72 585
R644 VGND.n200 VGND.n199 585
R645 VGND.n201 VGND.n200 585
R646 VGND.n198 VGND.n73 585
R647 VGND.n77 VGND.n73 585
R648 VGND.n206 VGND.n205 585
R649 VGND.n66 VGND.n65 585
R650 VGND.n154 VGND.n153 585
R651 VGND.n156 VGND.n155 585
R652 VGND.n158 VGND.n157 585
R653 VGND.n157 VGND.n67 585
R654 VGND.n152 VGND.n61 585
R655 VGND.n210 VGND.n61 585
R656 VGND.n151 VGND.n150 585
R657 VGND.n149 VGND.n148 585
R658 VGND.n147 VGND.n146 585
R659 VGND.n64 VGND.n62 585
R660 VGND.n209 VGND.n208 585
R661 VGND.n210 VGND.n209 585
R662 VGND.n207 VGND.n63 585
R663 VGND.n67 VGND.n63 585
R664 VGND.n215 VGND.n214 585
R665 VGND.n56 VGND.n55 585
R666 VGND.n140 VGND.n139 585
R667 VGND.n142 VGND.n141 585
R668 VGND.n144 VGND.n143 585
R669 VGND.n143 VGND.n57 585
R670 VGND.n138 VGND.n51 585
R671 VGND.n219 VGND.n51 585
R672 VGND.n137 VGND.n136 585
R673 VGND.n135 VGND.n134 585
R674 VGND.n133 VGND.n132 585
R675 VGND.n54 VGND.n52 585
R676 VGND.n218 VGND.n217 585
R677 VGND.n219 VGND.n218 585
R678 VGND.n216 VGND.n53 585
R679 VGND.n57 VGND.n53 585
R680 VGND.n224 VGND.n223 585
R681 VGND.n46 VGND.n45 585
R682 VGND.n122 VGND.n121 585
R683 VGND.n124 VGND.n123 585
R684 VGND.n126 VGND.n125 585
R685 VGND.n125 VGND.n47 585
R686 VGND.n120 VGND.n41 585
R687 VGND.n228 VGND.n41 585
R688 VGND.n119 VGND.n118 585
R689 VGND.n117 VGND.n116 585
R690 VGND.n115 VGND.n114 585
R691 VGND.n44 VGND.n42 585
R692 VGND.n227 VGND.n226 585
R693 VGND.n228 VGND.n227 585
R694 VGND.n225 VGND.n43 585
R695 VGND.n47 VGND.n43 585
R696 VGND.n233 VGND.n232 585
R697 VGND.n36 VGND.n35 585
R698 VGND.n108 VGND.n107 585
R699 VGND.n110 VGND.n109 585
R700 VGND.n112 VGND.n111 585
R701 VGND.n111 VGND.n37 585
R702 VGND.n106 VGND.n31 585
R703 VGND.n237 VGND.n31 585
R704 VGND.n105 VGND.n104 585
R705 VGND.n103 VGND.n102 585
R706 VGND.n101 VGND.n100 585
R707 VGND.n34 VGND.n32 585
R708 VGND.n236 VGND.n235 585
R709 VGND.n237 VGND.n236 585
R710 VGND.n234 VGND.n33 585
R711 VGND.n37 VGND.n33 585
R712 VGND.n242 VGND.n241 585
R713 VGND.n13 VGND.n12 585
R714 VGND.n27 VGND.n26 585
R715 VGND.n25 VGND.n15 585
R716 VGND.n24 VGND.n23 585
R717 VGND.n23 VGND.n14 585
R718 VGND.n22 VGND.n8 585
R719 VGND.n246 VGND.n8 585
R720 VGND.n21 VGND.n20 585
R721 VGND.n19 VGND.n18 585
R722 VGND.n17 VGND.n16 585
R723 VGND.n11 VGND.n9 585
R724 VGND.n245 VGND.n244 585
R725 VGND.n246 VGND.n245 585
R726 VGND.n243 VGND.n10 585
R727 VGND.n14 VGND.n10 585
R728 VGND.n256 VGND.n255 585
R729 VGND.n254 VGND.n253 585
R730 VGND.n252 VGND.n251 585
R731 VGND.n262 VGND.n261 585
R732 VGND.n263 VGND.n249 585
R733 VGND.n258 VGND.n249 585
R734 VGND.n272 VGND.n271 585
R735 VGND.n273 VGND.n272 585
R736 VGND.n270 VGND.n250 585
R737 VGND.n269 VGND.n268 585
R738 VGND.n266 VGND.n264 585
R739 VGND.n5 VGND.n3 585
R740 VGND.n275 VGND.n274 585
R741 VGND.n274 VGND.n273 585
R742 VGND.n4 VGND.n2 585
R743 VGND.n258 VGND.n4 585
R744 VGND.n245 VGND.n10 394
R745 VGND.n18 VGND.n17 394
R746 VGND.n23 VGND.n8 394
R747 VGND.n27 VGND.n13 394
R748 VGND.n236 VGND.n33 394
R749 VGND.n102 VGND.n101 394
R750 VGND.n111 VGND.n31 394
R751 VGND.n107 VGND.n36 394
R752 VGND.n227 VGND.n43 394
R753 VGND.n116 VGND.n115 394
R754 VGND.n125 VGND.n41 394
R755 VGND.n121 VGND.n46 394
R756 VGND.n218 VGND.n53 394
R757 VGND.n134 VGND.n133 394
R758 VGND.n143 VGND.n51 394
R759 VGND.n139 VGND.n56 394
R760 VGND.n209 VGND.n63 394
R761 VGND.n148 VGND.n147 394
R762 VGND.n157 VGND.n61 394
R763 VGND.n153 VGND.n66 394
R764 VGND.n200 VGND.n73 394
R765 VGND.n166 VGND.n165 394
R766 VGND.n175 VGND.n71 394
R767 VGND.n171 VGND.n76 394
R768 VGND.n191 VGND.n83 394
R769 VGND.n91 VGND.n90 394
R770 VGND.n179 VGND.n81 394
R771 VGND.n183 VGND.n86 394
R772 VGND.n272 VGND.n249 394
R773 VGND.n268 VGND.n266 394
R774 VGND.n274 VGND.n4 394
R775 VGND.n253 VGND.n252 394
R776 VGND.n259 VGND.n258 359.421
R777 VGND.n273 VGND.n248 359.421
R778 VGND.t7 VGND.n160 255.345
R779 VGND.n161 VGND.t7 255.345
R780 VGND.t9 VGND.n128 255.345
R781 VGND.n129 VGND.t9 255.345
R782 VGND.t11 VGND.n96 255.345
R783 VGND.n97 VGND.t11 255.345
R784 VGND.t4 VGND.n0 255.345
R785 VGND.n278 VGND.t4 255.345
R786 VGND.n186 VGND.n185 218.815
R787 VGND.n185 VGND.n184 218.815
R788 VGND.n193 VGND.n80 218.815
R789 VGND.n193 VGND.n79 218.815
R790 VGND.n195 VGND.n194 218.815
R791 VGND.n194 VGND.n78 218.815
R792 VGND.n202 VGND.n70 218.815
R793 VGND.n202 VGND.n69 218.815
R794 VGND.n204 VGND.n203 218.815
R795 VGND.n203 VGND.n68 218.815
R796 VGND.n211 VGND.n60 218.815
R797 VGND.n211 VGND.n59 218.815
R798 VGND.n213 VGND.n212 218.815
R799 VGND.n212 VGND.n58 218.815
R800 VGND.n220 VGND.n50 218.815
R801 VGND.n220 VGND.n49 218.815
R802 VGND.n222 VGND.n221 218.815
R803 VGND.n221 VGND.n48 218.815
R804 VGND.n229 VGND.n40 218.815
R805 VGND.n229 VGND.n39 218.815
R806 VGND.n231 VGND.n230 218.815
R807 VGND.n230 VGND.n38 218.815
R808 VGND.n238 VGND.n30 218.815
R809 VGND.n238 VGND.n29 218.815
R810 VGND.n240 VGND.n239 218.815
R811 VGND.n239 VGND.n28 218.815
R812 VGND.n247 VGND.n7 218.815
R813 VGND.n247 VGND.n6 218.815
R814 VGND.n259 VGND.n257 218.815
R815 VGND.n260 VGND.n259 218.815
R816 VGND.n267 VGND.n248 218.815
R817 VGND.n265 VGND.n248 218.815
R818 VGND.n193 VGND.n192 161.995
R819 VGND.n185 VGND.n87 161.995
R820 VGND.n202 VGND.n201 161.995
R821 VGND.n194 VGND.n77 161.995
R822 VGND.n211 VGND.n210 161.995
R823 VGND.n203 VGND.n67 161.995
R824 VGND.n220 VGND.n219 161.995
R825 VGND.n212 VGND.n57 161.995
R826 VGND.n229 VGND.n228 161.995
R827 VGND.n221 VGND.n47 161.995
R828 VGND.n238 VGND.n237 161.995
R829 VGND.n230 VGND.n37 161.995
R830 VGND.n247 VGND.n246 161.995
R831 VGND.n239 VGND.n14 161.995
R832 VGND.n17 VGND.n6 147.374
R833 VGND.n20 VGND.n7 147.374
R834 VGND.n241 VGND.n240 147.374
R835 VGND.n28 VGND.n15 147.374
R836 VGND.n101 VGND.n29 147.374
R837 VGND.n104 VGND.n30 147.374
R838 VGND.n232 VGND.n231 147.374
R839 VGND.n110 VGND.n38 147.374
R840 VGND.n115 VGND.n39 147.374
R841 VGND.n118 VGND.n40 147.374
R842 VGND.n223 VGND.n222 147.374
R843 VGND.n124 VGND.n48 147.374
R844 VGND.n133 VGND.n49 147.374
R845 VGND.n136 VGND.n50 147.374
R846 VGND.n214 VGND.n213 147.374
R847 VGND.n142 VGND.n58 147.374
R848 VGND.n147 VGND.n59 147.374
R849 VGND.n150 VGND.n60 147.374
R850 VGND.n205 VGND.n204 147.374
R851 VGND.n156 VGND.n68 147.374
R852 VGND.n165 VGND.n69 147.374
R853 VGND.n168 VGND.n70 147.374
R854 VGND.n196 VGND.n195 147.374
R855 VGND.n174 VGND.n78 147.374
R856 VGND.n90 VGND.n79 147.374
R857 VGND.n93 VGND.n80 147.374
R858 VGND.n187 VGND.n186 147.374
R859 VGND.n184 VGND.n88 147.374
R860 VGND.n186 VGND.n86 147.374
R861 VGND.n184 VGND.n183 147.374
R862 VGND.n91 VGND.n80 147.374
R863 VGND.n82 VGND.n79 147.374
R864 VGND.n195 VGND.n76 147.374
R865 VGND.n171 VGND.n78 147.374
R866 VGND.n166 VGND.n70 147.374
R867 VGND.n72 VGND.n69 147.374
R868 VGND.n204 VGND.n66 147.374
R869 VGND.n153 VGND.n68 147.374
R870 VGND.n148 VGND.n60 147.374
R871 VGND.n62 VGND.n59 147.374
R872 VGND.n213 VGND.n56 147.374
R873 VGND.n139 VGND.n58 147.374
R874 VGND.n134 VGND.n50 147.374
R875 VGND.n52 VGND.n49 147.374
R876 VGND.n222 VGND.n46 147.374
R877 VGND.n121 VGND.n48 147.374
R878 VGND.n116 VGND.n40 147.374
R879 VGND.n42 VGND.n39 147.374
R880 VGND.n231 VGND.n36 147.374
R881 VGND.n107 VGND.n38 147.374
R882 VGND.n102 VGND.n30 147.374
R883 VGND.n32 VGND.n29 147.374
R884 VGND.n240 VGND.n13 147.374
R885 VGND.n28 VGND.n27 147.374
R886 VGND.n18 VGND.n7 147.374
R887 VGND.n9 VGND.n6 147.374
R888 VGND.n267 VGND.n250 147.374
R889 VGND.n265 VGND.n5 147.374
R890 VGND.n261 VGND.n260 147.374
R891 VGND.n257 VGND.n253 147.374
R892 VGND.n257 VGND.n256 147.374
R893 VGND.n260 VGND.n252 147.374
R894 VGND.n268 VGND.n267 147.374
R895 VGND.n266 VGND.n265 147.374
R896 VGND.n258 VGND.t3 98.5512
R897 VGND.n273 VGND.t3 98.5512
R898 VGND.n244 VGND.n11 85.4593
R899 VGND.n243 VGND.n242 85.4593
R900 VGND.n22 VGND.n21 85.4593
R901 VGND.n25 VGND.n24 85.4593
R902 VGND.n235 VGND.n34 85.4593
R903 VGND.n234 VGND.n233 85.4593
R904 VGND.n106 VGND.n105 85.4593
R905 VGND.n112 VGND.n109 85.4593
R906 VGND.n226 VGND.n44 85.4593
R907 VGND.n225 VGND.n224 85.4593
R908 VGND.n120 VGND.n119 85.4593
R909 VGND.n126 VGND.n123 85.4593
R910 VGND.n217 VGND.n54 85.4593
R911 VGND.n216 VGND.n215 85.4593
R912 VGND.n138 VGND.n137 85.4593
R913 VGND.n144 VGND.n141 85.4593
R914 VGND.n208 VGND.n64 85.4593
R915 VGND.n207 VGND.n206 85.4593
R916 VGND.n152 VGND.n151 85.4593
R917 VGND.n158 VGND.n155 85.4593
R918 VGND.n199 VGND.n74 85.4593
R919 VGND.n170 VGND.n169 85.4593
R920 VGND.n198 VGND.n197 85.4593
R921 VGND.n176 VGND.n173 85.4593
R922 VGND.n190 VGND.n84 85.4593
R923 VGND.n189 VGND.n188 85.4593
R924 VGND.n95 VGND.n94 85.4593
R925 VGND.n181 VGND.n180 85.4593
R926 VGND.n263 VGND.n262 85.4593
R927 VGND.n255 VGND.n2 85.4593
R928 VGND.n271 VGND.n270 85.4593
R929 VGND.n275 VGND.n3 85.4593
R930 VGND.n192 VGND.t0 44.4186
R931 VGND.n87 VGND.t0 44.4186
R932 VGND.n201 VGND.t6 44.4186
R933 VGND.n77 VGND.t6 44.4186
R934 VGND.n210 VGND.t1 44.4186
R935 VGND.n67 VGND.t1 44.4186
R936 VGND.n219 VGND.t8 44.4186
R937 VGND.n57 VGND.t8 44.4186
R938 VGND.n228 VGND.t5 44.4186
R939 VGND.n47 VGND.t5 44.4186
R940 VGND.n237 VGND.t10 44.4186
R941 VGND.n37 VGND.t10 44.4186
R942 VGND.n246 VGND.t2 44.4186
R943 VGND.n14 VGND.t2 44.4186
R944 VGND.n244 VGND.n243 25.6005
R945 VGND.n16 VGND.n11 25.6005
R946 VGND.n19 VGND.n16 25.6005
R947 VGND.n21 VGND.n19 25.6005
R948 VGND.n242 VGND.n12 25.6005
R949 VGND.n26 VGND.n12 25.6005
R950 VGND.n26 VGND.n25 25.6005
R951 VGND.n235 VGND.n234 25.6005
R952 VGND.n100 VGND.n34 25.6005
R953 VGND.n103 VGND.n100 25.6005
R954 VGND.n105 VGND.n103 25.6005
R955 VGND.n233 VGND.n35 25.6005
R956 VGND.n108 VGND.n35 25.6005
R957 VGND.n109 VGND.n108 25.6005
R958 VGND.n226 VGND.n225 25.6005
R959 VGND.n114 VGND.n44 25.6005
R960 VGND.n117 VGND.n114 25.6005
R961 VGND.n119 VGND.n117 25.6005
R962 VGND.n224 VGND.n45 25.6005
R963 VGND.n122 VGND.n45 25.6005
R964 VGND.n123 VGND.n122 25.6005
R965 VGND.n217 VGND.n216 25.6005
R966 VGND.n132 VGND.n54 25.6005
R967 VGND.n135 VGND.n132 25.6005
R968 VGND.n137 VGND.n135 25.6005
R969 VGND.n215 VGND.n55 25.6005
R970 VGND.n140 VGND.n55 25.6005
R971 VGND.n141 VGND.n140 25.6005
R972 VGND.n208 VGND.n207 25.6005
R973 VGND.n146 VGND.n64 25.6005
R974 VGND.n149 VGND.n146 25.6005
R975 VGND.n151 VGND.n149 25.6005
R976 VGND.n206 VGND.n65 25.6005
R977 VGND.n154 VGND.n65 25.6005
R978 VGND.n155 VGND.n154 25.6005
R979 VGND.n164 VGND.n74 25.6005
R980 VGND.n167 VGND.n164 25.6005
R981 VGND.n169 VGND.n167 25.6005
R982 VGND.n199 VGND.n198 25.6005
R983 VGND.n197 VGND.n75 25.6005
R984 VGND.n172 VGND.n75 25.6005
R985 VGND.n173 VGND.n172 25.6005
R986 VGND.n190 VGND.n189 25.6005
R987 VGND.n89 VGND.n84 25.6005
R988 VGND.n92 VGND.n89 25.6005
R989 VGND.n94 VGND.n92 25.6005
R990 VGND.n188 VGND.n85 25.6005
R991 VGND.n182 VGND.n85 25.6005
R992 VGND.n182 VGND.n181 25.6005
R993 VGND.n262 VGND.n251 25.6005
R994 VGND.n254 VGND.n251 25.6005
R995 VGND.n255 VGND.n254 25.6005
R996 VGND.n271 VGND.n263 25.6005
R997 VGND.n270 VGND.n269 25.6005
R998 VGND.n269 VGND.n264 25.6005
R999 VGND.n264 VGND.n3 25.6005
R1000 VGND VGND.n1 18.3598
R1001 VGND.n113 VGND 18.3598
R1002 VGND.n127 VGND 18.3598
R1003 VGND.n145 VGND 18.3598
R1004 VGND.n159 VGND 18.3598
R1005 VGND.n177 VGND 18.3598
R1006 VGND VGND.n178 18.3598
R1007 VGND.n276 VGND 18.3598
R1008 VGND VGND.n128 12.8005
R1009 VGND.n129 VGND 12.8005
R1010 VGND VGND.n96 12.8005
R1011 VGND.n97 VGND 12.8005
R1012 VGND VGND.n22 12.8005
R1013 VGND.n24 VGND 12.8005
R1014 VGND VGND.n106 12.8005
R1015 VGND VGND.n112 12.8005
R1016 VGND VGND.n120 12.8005
R1017 VGND VGND.n126 12.8005
R1018 VGND VGND.n138 12.8005
R1019 VGND VGND.n144 12.8005
R1020 VGND VGND.n152 12.8005
R1021 VGND VGND.n158 12.8005
R1022 VGND VGND.n170 12.8005
R1023 VGND VGND.n176 12.8005
R1024 VGND VGND.n95 12.8005
R1025 VGND.n180 VGND 12.8005
R1026 VGND VGND.n2 12.8005
R1027 VGND VGND.n275 12.8005
R1028 VGND VGND.n0 12.8005
R1029 VGND VGND.n278 12.8005
R1030 VGND VGND.n160 12.8005
R1031 VGND.n161 VGND 12.8005
R1032 VGND.n277 VGND.n276 10.1647
R1033 VGND.n130 VGND.n128 10.1513
R1034 VGND.n130 VGND.n129 10.1513
R1035 VGND.n98 VGND.n96 10.1513
R1036 VGND.n98 VGND.n97 10.1513
R1037 VGND.n277 VGND.n0 10.1513
R1038 VGND.n278 VGND.n277 10.1513
R1039 VGND.n162 VGND.n160 10.1513
R1040 VGND.n162 VGND.n161 10.1513
R1041 VGND.n131 VGND.n130 10.0354
R1042 VGND.n99 VGND.n98 10.0354
R1043 VGND.n163 VGND.n162 10.0354
R1044 VGND.n178 VGND.n177 1.64668
R1045 VGND.n276 VGND.n1 1.64668
R1046 VGND.n127 VGND.n113 1.64668
R1047 VGND.n159 VGND.n145 1.64668
R1048 VGND.n99 VGND.n1 1.50567
R1049 VGND.n131 VGND.n127 1.50567
R1050 VGND.n163 VGND.n159 1.50567
R1051 VGND.n178 VGND 1.18255
R1052 VGND.n177 VGND.n163 0.12975
R1053 VGND.n113 VGND.n99 0.12975
R1054 VGND.n145 VGND.n131 0.12975
R1055 N1.t1 N1.n8 700.484
R1056 N1.n9 N1.t1 700.484
R1057 N1.t2 N1.n4 700.484
R1058 N1.n5 N1.t2 700.484
R1059 N1 N1.t4 330.341
R1060 N1 N1.t3 330.341
R1061 N1 N1.t6 315.88
R1062 N1 N1.t5 315.88
R1063 N1.t0 N1.n0 255.345
R1064 N1.n13 N1.t0 255.345
R1065 N1.n1 N1 31.4499
R1066 N1.n2 N1 30.6327
R1067 N1.n3 N1 30.6171
R1068 N1.n1 N1 30.6171
R1069 N1 N1.n8 12.8005
R1070 N1.n9 N1 12.8005
R1071 N1 N1.n4 12.8005
R1072 N1.n5 N1 12.8005
R1073 N1 N1.n0 12.8005
R1074 N1 N1.n13 12.8005
R1075 N1.n11 N1.n10 12.1026
R1076 N1.n7 N1.n6 11.2854
R1077 N1.n12 N1.n11 11.2854
R1078 N1.n10 N1.n8 10.1513
R1079 N1.n10 N1.n9 10.1513
R1080 N1.n6 N1.n4 10.1513
R1081 N1.n6 N1.n5 10.1513
R1082 N1.n12 N1.n0 10.1513
R1083 N1.n13 N1.n12 10.1513
R1084 N1.n7 N1.n3 3.65945
R1085 N1.n2 N1.n1 2.47564
R1086 N1.n3 N1.n2 0.817713
R1087 N1.n11 N1.n7 0.817713
R1088 N3.t1 N3.n2 700.484
R1089 N3.n3 N3.t1 700.484
R1090 N3.t0 N3.n0 700.484
R1091 N3.n11 N3.t0 700.484
R1092 N3 N3.t4 330.341
R1093 N3 N3.t3 315.88
R1094 N3.t2 N3.n6 255.345
R1095 N3.n7 N3.t2 255.345
R1096 N3.n1 N3 30.1999
R1097 N3.n1 N3 29.3671
R1098 N3 N3.n6 12.8005
R1099 N3.n7 N3 12.8005
R1100 N3 N3.n2 12.8005
R1101 N3.n3 N3 12.8005
R1102 N3 N3.n0 12.8005
R1103 N3 N3.n11 12.8005
R1104 N3.n10 N3.n9 10.8526
R1105 N3.n8 N3.n6 10.1513
R1106 N3.n8 N3.n7 10.1513
R1107 N3.n4 N3.n2 10.1513
R1108 N3.n4 N3.n3 10.1513
R1109 N3.n10 N3.n0 10.1513
R1110 N3.n11 N3.n10 10.1513
R1111 N3.n9 N3.n8 10.0354
R1112 N3.n5 N3.n4 10.0354
R1113 N3.n5 N3.n1 3.65945
R1114 N3.n9 N3.n5 0.817713
R1115 B B.t3 330.341
R1116 B B.t0 330.341
R1117 B B.t1 315.88
R1118 B B.t2 315.88
R1119 B B.n2 30.6166
R1120 B.n1 B 29.7994
R1121 B.n2 B 29.7837
R1122 B.n0 B 29.7837
R1123 B.n2 B.n1 4.13356
R1124 B.n0 B 2.22536
R1125 B.n1 B.n0 0.817713
R1126 N1__N1.t1 N1__N1.n1 255.345
R1127 N1__N1.n2 N1__N1.t1 255.345
R1128 N1__N1.t0 N1__N1.n0 255.345
R1129 N1__N1.n5 N1__N1.t0 255.345
R1130 N1__N1.n4 N1__N1.n3 24.7679
R1131 N1__N1 N1__N1.n1 12.8005
R1132 N1__N1.n2 N1__N1 12.8005
R1133 N1__N1 N1__N1.n0 12.8005
R1134 N1__N1 N1__N1.n5 12.8005
R1135 N1__N1.n3 N1__N1.n1 10.1513
R1136 N1__N1.n3 N1__N1.n2 10.1513
R1137 N1__N1.n4 N1__N1.n0 10.1513
R1138 N1__N1.n5 N1__N1.n4 10.1513
R1139 N4__N1.t1 N4__N1.n1 255.345
R1140 N4__N1.n2 N4__N1.t1 255.345
R1141 N4__N1.t0 N4__N1.n0 255.345
R1142 N4__N1.n5 N4__N1.t0 255.345
R1143 N4__N1.n4 N4__N1.n3 22.2679
R1144 N4__N1 N4__N1.n1 12.8005
R1145 N4__N1.n2 N4__N1 12.8005
R1146 N4__N1 N4__N1.n0 12.8005
R1147 N4__N1 N4__N1.n5 12.8005
R1148 N4__N1.n3 N4__N1.n1 10.1513
R1149 N4__N1.n3 N4__N1.n2 10.1513
R1150 N4__N1.n4 N4__N1.n0 10.1513
R1151 N4__N1.n5 N4__N1.n4 10.1513
R1152 N3__N1.t1 N3__N1.n1 255.345
R1153 N3__N1.n2 N3__N1.t1 255.345
R1154 N3__N1.t0 N3__N1.n0 255.345
R1155 N3__N1.n5 N3__N1.t0 255.345
R1156 N3__N1.n4 N3__N1.n3 25.6012
R1157 N3__N1 N3__N1.n1 12.8005
R1158 N3__N1.n2 N3__N1 12.8005
R1159 N3__N1 N3__N1.n0 12.8005
R1160 N3__N1 N3__N1.n5 12.8005
R1161 N3__N1.n3 N3__N1.n1 10.1513
R1162 N3__N1.n3 N3__N1.n2 10.1513
R1163 N3__N1.n4 N3__N1.n0 10.1513
R1164 N3__N1.n5 N3__N1.n4 10.1513
C43 Y VGND 6.80983f
C44 B VGND 5.22518f
C45 A VGND 4.34746f
C46 VPWR VGND 25.7245f
C47 N4__N1 VGND 1.48464f $ **FLOATING
C48 N3__N1 VGND 2.34631f $ **FLOATING
C49 N3 VGND 5.12714f $ **FLOATING
C50 N2__N1 VGND 2.23395f $ **FLOATING
C51 N2 VGND 6.26329f $ **FLOATING
C52 N1__N1 VGND 2.11301f $ **FLOATING
C53 N1 VGND 7.30545f $ **FLOATING
C54 B.t3 VGND 0.04199f $ **FLOATING
C55 B.n0 VGND 1.28382f $ **FLOATING
C56 B.t1 VGND 0.04041f $ **FLOATING
C57 B.n1 VGND 1.87397f $ **FLOATING
C58 B.t0 VGND 0.04199f $ **FLOATING
C59 B.n2 VGND 2.46714f $ **FLOATING
C60 B.t2 VGND 0.04041f $ **FLOATING
C61 N1.n0 VGND 0.01001f $ **FLOATING
C62 N1.t5 VGND 0.03619f $ **FLOATING
C63 N1.t3 VGND 0.0376f $ **FLOATING
C64 N1.n1 VGND 1.97869f $ **FLOATING
C65 N1.t6 VGND 0.03619f $ **FLOATING
C66 N1.n2 VGND 1.33546f $ **FLOATING
C67 N1.t4 VGND 0.0376f $ **FLOATING
C68 N1.n3 VGND 1.65981f $ **FLOATING
C69 N1.n4 VGND 0.00876f $ **FLOATING
C70 N1.t2 VGND 0.02682f $ **FLOATING
C71 N1.n5 VGND 0.00876f $ **FLOATING
C72 N1.n6 VGND 0.25511f $ **FLOATING
C73 N1.n7 VGND 1.52153f $ **FLOATING
C74 N1.n8 VGND 0.00876f $ **FLOATING
C75 N1.t1 VGND 0.02682f $ **FLOATING
C76 N1.n9 VGND 0.00876f $ **FLOATING
C77 N1.n10 VGND 0.29037f $ **FLOATING
C78 N1.n11 VGND 1.22474f $ **FLOATING
C79 N1.n12 VGND 0.25511f $ **FLOATING
C80 N1.t0 VGND 0.02433f $ **FLOATING
C81 N1.n13 VGND 0.01001f $ **FLOATING
C82 A.t1 VGND 0.02495f $ **FLOATING
C83 A.n0 VGND 0.4206f $ **FLOATING
C84 A.t2 VGND 0.02401f $ **FLOATING
C85 A.n1 VGND 0.77128f $ **FLOATING
C86 A.t3 VGND 0.02495f $ **FLOATING
C87 A.n2 VGND 1.08592f $ **FLOATING
C88 A.t0 VGND 0.02401f $ **FLOATING
C89 Y.n0 VGND 0.01062f $ **FLOATING
C90 Y.n1 VGND 0.01062f $ **FLOATING
C91 Y.t0 VGND 0.03254f $ **FLOATING
C92 Y.n2 VGND 0.01062f $ **FLOATING
C93 Y.n3 VGND 0.27218f $ **FLOATING
C94 Y.n4 VGND 3.97291f $ **FLOATING
C95 Y.n5 VGND 0.01214f $ **FLOATING
C96 Y.t1 VGND 0.02951f $ **FLOATING
C97 Y.n6 VGND 0.01214f $ **FLOATING
C98 Y.n7 VGND 0.27218f $ **FLOATING
C99 Y.n8 VGND 1.39228f $ **FLOATING
C100 Y.n9 VGND 0.31315f $ **FLOATING
C101 Y.t2 VGND 0.03254f $ **FLOATING
C102 Y.n10 VGND 0.01062f $ **FLOATING
C103 N2.n0 VGND 0.00427f $ **FLOATING
C104 N2.t4 VGND 0.01764f $ **FLOATING
C105 N2.t3 VGND 0.01834f $ **FLOATING
C106 N2.n1 VGND 1.40137f $ **FLOATING
C107 N2.n2 VGND 0.00427f $ **FLOATING
C108 N2.t2 VGND 0.01308f $ **FLOATING
C109 N2.n3 VGND 0.00427f $ **FLOATING
C110 N2.n4 VGND 0.13953f $ **FLOATING
C111 N2.n5 VGND 0.98384f $ **FLOATING
C112 N2.n6 VGND 0.00488f $ **FLOATING
C113 N2.t1 VGND 0.01186f $ **FLOATING
C114 N2.n7 VGND 0.00488f $ **FLOATING
C115 N2.n8 VGND 0.13953f $ **FLOATING
C116 N2.n9 VGND 0.63451f $ **FLOATING
C117 N2.n10 VGND 0.15739f $ **FLOATING
C118 N2.t0 VGND 0.01308f $ **FLOATING
C119 N2.n11 VGND 0.00427f $ **FLOATING
.ends

* NGSPICE file created from cell_xor2.ext - technology: sky130A

.subckt cell_xor2 VPWR VGND Y B A
X0 register_cf_node_683eb4d351eb8286 N2.t3 register_cf_node_683eb4d351eb8286_source VPWR.t6 sky130_fd_pr__pfet_01v8_hvt ad=0.1885 pd=1.88 as=0.1885 ps=1.88 w=0.65 l=0.15
Vregister_cf_683eb4d351eb8286 VPWR.t7 register_cf_node_683eb4d351eb8286 0
Vregister_cf_683eb4d351eb8286_source Y.t1 register_cf_node_683eb4d351eb8286_source 0
X1 register_cf_node_01dead019619b2b8 A.t0 register_cf_node_01dead019619b2b8_source VGND.t1 sky130_fd_pr__nfet_01v8 ad=0.1885 pd=1.88 as=0.1885 ps=1.88 w=0.65 l=0.15
Vregister_cf_01dead019619b2b8 N2__N1.t0 register_cf_node_01dead019619b2b8 0
Vregister_cf_01dead019619b2b8_source N2.t0 register_cf_node_01dead019619b2b8_source 0
X2 register_cf_node_4ea80be5325e2b83 N1.t3 register_cf_node_4ea80be5325e2b83_source VPWR.t12 sky130_fd_pr__pfet_01v8_hvt ad=0.1885 pd=1.88 as=0.1885 ps=1.88 w=0.65 l=0.15
Vregister_cf_4ea80be5325e2b83 VPWR.t13 register_cf_node_4ea80be5325e2b83 0
Vregister_cf_4ea80be5325e2b83_source N3.t1 register_cf_node_4ea80be5325e2b83_source 0
X3 register_cf_node_5a8cab2fb1531f55 B.t0 register_cf_node_5a8cab2fb1531f55_source VPWR.t10 sky130_fd_pr__pfet_01v8_hvt ad=0.1885 pd=1.88 as=0.1885 ps=1.88 w=0.65 l=0.15
Vregister_cf_5a8cab2fb1531f55 VPWR.t11 register_cf_node_5a8cab2fb1531f55 0
Vregister_cf_5a8cab2fb1531f55_source N3.t2 register_cf_node_5a8cab2fb1531f55_source 0
X4 register_cf_node_7d87aa2c74760312 B.t1 register_cf_node_7d87aa2c74760312_source VGND.t8 sky130_fd_pr__nfet_01v8 ad=0.1885 pd=1.88 as=0.1885 ps=1.88 w=0.65 l=0.15
Vregister_cf_7d87aa2c74760312 VGND.t9 register_cf_node_7d87aa2c74760312 0
Vregister_cf_7d87aa2c74760312_source N1__N1.t1 register_cf_node_7d87aa2c74760312_source 0
X5 register_cf_node_8b48dd30c91e4b3f N1.t4 register_cf_node_8b48dd30c91e4b3f_source VPWR.t14 sky130_fd_pr__pfet_01v8_hvt ad=0.1885 pd=1.88 as=0.1885 ps=1.88 w=0.65 l=0.15
Vregister_cf_8b48dd30c91e4b3f VPWR.t15 register_cf_node_8b48dd30c91e4b3f 0
Vregister_cf_8b48dd30c91e4b3f_source N2.t2 register_cf_node_8b48dd30c91e4b3f_source 0
X6 register_cf_node_a5c0e43ae4e6aebc N2.t4 register_cf_node_a5c0e43ae4e6aebc_source VGND.t3 sky130_fd_pr__nfet_01v8 ad=0.1885 pd=1.88 as=0.1885 ps=1.88 w=0.65 l=0.15
Vregister_cf_a5c0e43ae4e6aebc N4__N1.t1 register_cf_node_a5c0e43ae4e6aebc 0
Vregister_cf_a5c0e43ae4e6aebc_source Y.t2 register_cf_node_a5c0e43ae4e6aebc_source 0
X7 register_cf_node_5b6050caedbba198 N3.t3 register_cf_node_5b6050caedbba198_source VGND.t6 sky130_fd_pr__nfet_01v8 ad=0.1885 pd=1.88 as=0.1885 ps=1.88 w=0.65 l=0.15
Vregister_cf_5b6050caedbba198 VGND.t7 register_cf_node_5b6050caedbba198 0
Vregister_cf_5b6050caedbba198_source N4__N1.t0 register_cf_node_5b6050caedbba198_source 0
X8 register_cf_node_10694f1af9a19748 A.t1 register_cf_node_10694f1af9a19748_source VPWR.t8 sky130_fd_pr__pfet_01v8_hvt ad=0.1885 pd=1.88 as=0.1885 ps=1.88 w=0.65 l=0.15
Vregister_cf_10694f1af9a19748 VPWR.t9 register_cf_node_10694f1af9a19748 0
Vregister_cf_10694f1af9a19748_source N1.t1 register_cf_node_10694f1af9a19748_source 0
X9 register_cf_node_c1972b280ed7cad0 A.t2 register_cf_node_c1972b280ed7cad0_source VGND.t0 sky130_fd_pr__nfet_01v8 ad=0.1885 pd=1.88 as=0.1885 ps=1.88 w=0.65 l=0.15
Vregister_cf_c1972b280ed7cad0 N1__N1.t0 register_cf_node_c1972b280ed7cad0 0
Vregister_cf_c1972b280ed7cad0_source N1.t0 register_cf_node_c1972b280ed7cad0_source 0
X10 register_cf_node_5cebfddc1237d460 A.t3 register_cf_node_5cebfddc1237d460_source VPWR.t0 sky130_fd_pr__pfet_01v8_hvt ad=0.1885 pd=1.88 as=0.1885 ps=1.88 w=0.65 l=0.15
Vregister_cf_5cebfddc1237d460 VPWR.t1 register_cf_node_5cebfddc1237d460 0
Vregister_cf_5cebfddc1237d460_source N2.t1 register_cf_node_5cebfddc1237d460_source 0
X11 register_cf_node_a53c911ea079998e N1.t5 register_cf_node_a53c911ea079998e_source VGND.t10 sky130_fd_pr__nfet_01v8 ad=0.1885 pd=1.88 as=0.1885 ps=1.88 w=0.65 l=0.15
Vregister_cf_a53c911ea079998e VGND.t11 register_cf_node_a53c911ea079998e 0
Vregister_cf_a53c911ea079998e_source N3__N1.t1 register_cf_node_a53c911ea079998e_source 0
X12 register_cf_node_099b6d51416137cb N3.t4 register_cf_node_099b6d51416137cb_source VPWR.t2 sky130_fd_pr__pfet_01v8_hvt ad=0.1885 pd=1.88 as=0.1885 ps=1.88 w=0.65 l=0.15
Vregister_cf_099b6d51416137cb VPWR.t3 register_cf_node_099b6d51416137cb 0
Vregister_cf_099b6d51416137cb_source Y.t0 register_cf_node_099b6d51416137cb_source 0
X13 register_cf_node_d002c0cfdff274bb B.t2 register_cf_node_d002c0cfdff274bb_source VGND.t2 sky130_fd_pr__nfet_01v8 ad=0.1885 pd=1.88 as=0.1885 ps=1.88 w=0.65 l=0.15
Vregister_cf_d002c0cfdff274bb N3__N1.t0 register_cf_node_d002c0cfdff274bb 0
Vregister_cf_d002c0cfdff274bb_source N3.t0 register_cf_node_d002c0cfdff274bb_source 0
X14 register_cf_node_add0247286d98b0f B.t3 register_cf_node_add0247286d98b0f_source VPWR.t4 sky130_fd_pr__pfet_01v8_hvt ad=0.1885 pd=1.88 as=0.1885 ps=1.88 w=0.65 l=0.15
Vregister_cf_add0247286d98b0f VPWR.t5 register_cf_node_add0247286d98b0f 0
Vregister_cf_add0247286d98b0f_source N1.t2 register_cf_node_add0247286d98b0f_source 0
X15 register_cf_node_1458ae15465185b8 N1.t6 register_cf_node_1458ae15465185b8_source VGND.t4 sky130_fd_pr__nfet_01v8 ad=0.1885 pd=1.88 as=0.1885 ps=1.88 w=0.65 l=0.15
Vregister_cf_1458ae15465185b8 VGND.t5 register_cf_node_1458ae15465185b8 0
Vregister_cf_1458ae15465185b8_source N2__N1.t1 register_cf_node_1458ae15465185b8_source 0
C0 B N2__N1 0.15663f
C1 N3 Y 1.19195f
C2 B VPWR 0.85648f
C3 Y N2 1.17829f
C4 N3 N2__N1 0.00306f
C5 N3 VPWR 1.01615f
C6 N2 N2__N1 1.30662f
C7 N2 VPWR 0.94638f
C8 Y N2__N1 0.14763f
C9 Y VPWR 0.52822f
C10 N2__N1 VPWR 0.0121f
C11 A N1 0.48342f
C12 B N3__N1 0.68586f
C13 N3 N3__N1 0.38898f
C14 N3__N1 N2 0.91385f
C15 Y N3__N1 0.15908f
C16 N3 N4__N1 1.06844f
C17 N2 N4__N1 0.6758f
C18 N3__N1 VPWR 0.0121f
C19 Y N4__N1 0.66826f
C20 N4__N1 VPWR 0.01242f
C21 N1 N1__N1 1.27643f
C22 B N1 0.54043f
C23 A N1__N1 0.65925f
C24 N3 N1 0.33125f
C25 N1 N2 3.67963f
C26 B A 2.69235f
C27 N1 Y 5.63105f
C28 A N2 0.3955f
C29 N1 N2__N1 0.40398f
C30 N1 VPWR 1.36821f
C31 A Y 0.00384f
C32 A N2__N1 0.57595f
C33 A VPWR 0.89523f
C34 B N1__N1 0.33316f
C35 N2 N1__N1 0.03409f
C36 B N3 1.05596f
C37 Y N1__N1 0.14988f
C38 B N2 0.29973f
C39 N1 N3__N1 0.42266f
C40 N3 N2 0.1708f
C41 N1__N1 VPWR 0.0122f
C42 B Y 4.24891f
C43 Y VGND 6.80983f
C44 B VGND 5.22518f
C45 A VGND 4.34746f
C46 VPWR VGND 25.7245f
C47 N4__N1 VGND 1.48464f $ **FLOATING
C48 N3__N1 VGND 2.34631f $ **FLOATING
C49 N3 VGND 5.12714f $ **FLOATING
C50 N2__N1 VGND 2.23395f $ **FLOATING
C51 N2 VGND 6.26329f $ **FLOATING
C52 N1__N1 VGND 2.11301f $ **FLOATING
C53 N1 VGND 7.30545f $ **FLOATING
C54 B.t3 VGND 0.04199f $ **FLOATING
C55 B.n0 VGND 1.28382f $ **FLOATING
C56 B.t1 VGND 0.04041f $ **FLOATING
C57 B.n1 VGND 1.87397f $ **FLOATING
C58 B.t0 VGND 0.04199f $ **FLOATING
C59 B.n2 VGND 2.46714f $ **FLOATING
C60 B.t2 VGND 0.04041f $ **FLOATING
C61 N1.n0 VGND 0.01001f $ **FLOATING
C62 N1.t5 VGND 0.03619f $ **FLOATING
C63 N1.t3 VGND 0.0376f $ **FLOATING
C64 N1.n1 VGND 1.97869f $ **FLOATING
C65 N1.t6 VGND 0.03619f $ **FLOATING
C66 N1.n2 VGND 1.33546f $ **FLOATING
C67 N1.t4 VGND 0.0376f $ **FLOATING
C68 N1.n3 VGND 1.65981f $ **FLOATING
C69 N1.n4 VGND 0.00876f $ **FLOATING
C70 N1.t2 VGND 0.02682f $ **FLOATING
C71 N1.n5 VGND 0.00876f $ **FLOATING
C72 N1.n6 VGND 0.25511f $ **FLOATING
C73 N1.n7 VGND 1.52153f $ **FLOATING
C74 N1.n8 VGND 0.00876f $ **FLOATING
C75 N1.t1 VGND 0.02682f $ **FLOATING
C76 N1.n9 VGND 0.00876f $ **FLOATING
C77 N1.n10 VGND 0.29037f $ **FLOATING
C78 N1.n11 VGND 1.22474f $ **FLOATING
C79 N1.n12 VGND 0.25511f $ **FLOATING
C80 N1.t0 VGND 0.02433f $ **FLOATING
C81 N1.n13 VGND 0.01001f $ **FLOATING
C82 A.t1 VGND 0.02495f $ **FLOATING
C83 A.n0 VGND 0.4206f $ **FLOATING
C84 A.t2 VGND 0.02401f $ **FLOATING
C85 A.n1 VGND 0.77128f $ **FLOATING
C86 A.t3 VGND 0.02495f $ **FLOATING
C87 A.n2 VGND 1.08592f $ **FLOATING
C88 A.t0 VGND 0.02401f $ **FLOATING
C89 Y.n0 VGND 0.01062f $ **FLOATING
C90 Y.n1 VGND 0.01062f $ **FLOATING
C91 Y.t1 VGND 0.03254f $ **FLOATING
C92 Y.n2 VGND 0.01062f $ **FLOATING
C93 Y.n3 VGND 0.27218f $ **FLOATING
C94 Y.n4 VGND 3.97291f $ **FLOATING
C95 Y.n5 VGND 0.01214f $ **FLOATING
C96 Y.t2 VGND 0.02951f $ **FLOATING
C97 Y.n6 VGND 0.01214f $ **FLOATING
C98 Y.n7 VGND 0.27218f $ **FLOATING
C99 Y.n8 VGND 1.39228f $ **FLOATING
C100 Y.n9 VGND 0.31315f $ **FLOATING
C101 Y.t0 VGND 0.03254f $ **FLOATING
C102 Y.n10 VGND 0.01062f $ **FLOATING
C103 N2.n0 VGND 0.00488f $ **FLOATING
C104 N2.t4 VGND 0.01764f $ **FLOATING
C105 N2.t3 VGND 0.01834f $ **FLOATING
C106 N2.n1 VGND 1.40137f $ **FLOATING
C107 N2.n2 VGND 0.00427f $ **FLOATING
C108 N2.t2 VGND 0.01308f $ **FLOATING
C109 N2.n3 VGND 0.00427f $ **FLOATING
C110 N2.n4 VGND 0.13953f $ **FLOATING
C111 N2.n5 VGND 0.98384f $ **FLOATING
C112 N2.n6 VGND 0.00427f $ **FLOATING
C113 N2.t1 VGND 0.01308f $ **FLOATING
C114 N2.n7 VGND 0.00427f $ **FLOATING
C115 N2.n8 VGND 0.15739f $ **FLOATING
C116 N2.n9 VGND 0.63451f $ **FLOATING
C117 N2.n10 VGND 0.13953f $ **FLOATING
C118 N2.t0 VGND 0.01186f $ **FLOATING
C119 N2.n11 VGND 0.00488f $ **FLOATING
rmesh_equiv_0 a a.n0 0.55668166616768899
rmesh_equiv_1 a a.n1 29.3827
rmesh_equiv_10 b b.n1 29.799399999999999
rmesh_equiv_100 vgnd vgnd.t11 132.69708595202945
rmesh_equiv_101 vgnd vgnd.t2 190.31340261058702
rmesh_equiv_102 vgnd vgnd.t3 189.22322821877236
rmesh_equiv_103 vgnd vgnd.t4 192.6476956192034
rmesh_equiv_104 vgnd vgnd.t5 132.61123329156118
rmesh_equiv_105 vgnd vgnd.t6 240.80434556337758
rmesh_equiv_106 vgnd vgnd.t7 132.75540128588085
rmesh_equiv_107 vgnd vgnd.t8 190.40451766812919
rmesh_equiv_108 vgnd vgnd.t9 132.45274746924926
rmesh_equiv_109 vgnd.n211 vgnd.t0 87639494.209030256
rmesh_equiv_11 b b.n2 15.097203646670627
rmesh_equiv_110 vgnd.n211 vgnd.t1 193.27496068226841
rmesh_equiv_111 vgnd.n211 vgnd.t10 2420117609.8749728
rmesh_equiv_112 vgnd.n211 vgnd.t2 3591305.4388721907
rmesh_equiv_113 vgnd.n211 vgnd.t3 1630606584369.8677
rmesh_equiv_114 vgnd.n211 vgnd.t4 5329.2760227752078
rmesh_equiv_115 vgnd.n211 vgnd.t6 1723434100255692
rmesh_equiv_116 vgnd.n211 vgnd.t8 130244.59837725187
rmesh_equiv_117 vgnd.t0 vgnd.t1 5877589.2222652733
rmesh_equiv_118 vgnd.t0 vgnd.t8 8365.0999235407799
rmesh_equiv_119 vgnd.t1 vgnd.t8 8734.9231598089955
rmesh_equiv_12 b b.t0 330.34100000000001
rmesh_equiv_120 vgnd.t10 vgnd.t2 8377.512459599513
rmesh_equiv_121 vgnd.t10 vgnd.t3 8376.1350998750568
rmesh_equiv_122 vgnd.t10 vgnd.t4 5645762.2346385103
rmesh_equiv_123 vgnd.t10 vgnd.t6 8852973.4871957693
rmesh_equiv_124 vgnd.t11 vgnd.t5 167129.39164662693
rmesh_equiv_125 vgnd.t11 vgnd.t7 110758.01986841994
rmesh_equiv_126 vgnd.t11 vgnd.t9 439999.76551424398
rmesh_equiv_127 vgnd.t2 vgnd.t3 5644530.216847308
rmesh_equiv_128 vgnd.t2 vgnd.t4 8377.9633424030035
rmesh_equiv_129 vgnd.t2 vgnd.t6 5965863224.6953611
rmesh_equiv_13 b b.t1 315.88
rmesh_equiv_130 vgnd.t3 vgnd.t4 3803954417.7623215
rmesh_equiv_131 vgnd.t3 vgnd.t6 13137.267252432117
rmesh_equiv_132 vgnd.t4 vgnd.t6 4020506737940.9146
rmesh_equiv_133 vgnd.t5 vgnd.t7 237954.7500990433
rmesh_equiv_134 vgnd.t5 vgnd.t9 240974.70572493775
rmesh_equiv_135 vgnd.t7 vgnd.t9 626460.93074971519
rmesh_equiv_136 vpwr vpwr.n148 1.9227529868551159
rmesh_equiv_137 vpwr vpwr.t0 117.18187411979875
rmesh_equiv_138 vpwr vpwr.t1 430.98280789836582
rmesh_equiv_139 vpwr vpwr.t10 117.18187411979875
rmesh_equiv_14 b b.t2 315.88
rmesh_equiv_140 vpwr vpwr.t11 444.66947254149648
rmesh_equiv_141 vpwr vpwr.t12 117.18187411979875
rmesh_equiv_142 vpwr vpwr.t13 415.48561986159854
rmesh_equiv_143 vpwr vpwr.t14 117.18187411979875
rmesh_equiv_144 vpwr vpwr.t15 500.04319233285042
rmesh_equiv_145 vpwr vpwr.t2 117.18187411979875
rmesh_equiv_146 vpwr vpwr.t3 393.52452733135925
rmesh_equiv_147 vpwr vpwr.t4 117.18187411979875
rmesh_equiv_148 vpwr vpwr.t5 390.44051272611034
rmesh_equiv_149 vpwr vpwr.t6 117.18187411979875
rmesh_equiv_15 b b.t3 330.34100000000001
rmesh_equiv_150 vpwr vpwr.t7 400.11768944874422
rmesh_equiv_151 vpwr vpwr.t8 117.18187411979875
rmesh_equiv_152 vpwr vpwr.t9 362.1089604615409
rmesh_equiv_153 vpwr.n148 vpwr.t1 2011.0418092736586
rmesh_equiv_154 vpwr.n148 vpwr.t11 1761.632191341351
rmesh_equiv_155 vpwr.n148 vpwr.t13 2448.8827383644693
rmesh_equiv_156 vpwr.n148 vpwr.t15 1221.3038835025977
rmesh_equiv_157 vpwr.n148 vpwr.t3 3665.0313353432184
rmesh_equiv_158 vpwr.n148 vpwr.t5 3903.8308169061984
rmesh_equiv_159 vpwr.n148 vpwr.t7 3173.5282906656012
rmesh_equiv_16 b.n0 b.n1 0.81771300000000002
rmesh_equiv_160 vpwr.n148 vpwr.t9 17697.820628012643
rmesh_equiv_161 vpwr.t1 vpwr.t5 2896970.5139602167
rmesh_equiv_162 vpwr.t1 vpwr.t9 13133270.094256096
rmesh_equiv_163 vpwr.t11 vpwr.t13 1817276.777073632
rmesh_equiv_164 vpwr.t11 vpwr.t3 2719761.231774881
rmesh_equiv_165 vpwr.t11 vpwr.t7 2355024.6705011656
rmesh_equiv_166 vpwr.t13 vpwr.t3 1258111.4687315768
rmesh_equiv_167 vpwr.t13 vpwr.t7 1089391.0511290655
rmesh_equiv_168 vpwr.t3 vpwr.t7 740414.33819871023
rmesh_equiv_169 vpwr.t5 vpwr.t9 6075208.9317598874
rmesh_equiv_17 b.n1 b.n2 4.1335600000000001
rmesh_equiv_170 y y.n0 12.8005
rmesh_equiv_171 y y.n1 12.8005
rmesh_equiv_172 y y.n10 12.8005
rmesh_equiv_173 y y.n2 12.8005
rmesh_equiv_174 y y.n4 10.1601
rmesh_equiv_175 y y.n5 12.8005
rmesh_equiv_176 y y.n6 12.8005
rmesh_equiv_177 y.n0 y.n9 10.151300000000001
rmesh_equiv_178 y.n0 y.t0 700.48400000000004
rmesh_equiv_179 y.n1 y.n3 10.151300000000001
rmesh_equiv_18 n1 n1.n0 12.8005
rmesh_equiv_180 y.n1 y.t1 700.48400000000004
rmesh_equiv_181 y.n10 y.n9 10.151300000000001
rmesh_equiv_182 y.n10 y.t0 700.48400000000004
rmesh_equiv_183 y.n2 y.n3 10.151300000000001
rmesh_equiv_184 y.n2 y.t1 700.48400000000004
rmesh_equiv_185 y.n3 y.n4 10.8688
rmesh_equiv_186 y.n4 y.n8 0.81771300000000002
rmesh_equiv_187 y.n5 y.n7 10.151300000000001
rmesh_equiv_188 y.n5 y.t2 255.34500000000003
rmesh_equiv_189 y.n6 y.n7 10.151300000000001
rmesh_equiv_19 n1 n1.n1 15.513956422736719
rmesh_equiv_190 y.n6 y.t2 255.34500000000003
rmesh_equiv_191 y.n7 y.n8 10.8688
rmesh_equiv_192 y.n8 y.n9 11.686
rmesh_equiv_2 a a.n2 14.888839177564758
rmesh_equiv_20 n1 n1.n13 12.8005
rmesh_equiv_21 n1 n1.n2 30.632700000000003
rmesh_equiv_22 n1 n1.n3 30.617100000000001
rmesh_equiv_23 n1 n1.n4 12.8005
rmesh_equiv_24 n1 n1.n5 12.8005
rmesh_equiv_25 n1 n1.n8 12.8005
rmesh_equiv_26 n1 n1.n9 12.8005
rmesh_equiv_27 n1 n1.t3 330.34100000000001
rmesh_equiv_28 n1 n1.t4 330.34100000000001
rmesh_equiv_29 n1 n1.t5 315.88
rmesh_equiv_3 a a.t0 315.88
rmesh_equiv_30 n1 n1.t6 315.88
rmesh_equiv_31 n1.n0 n1.n12 10.151300000000001
rmesh_equiv_32 n1.n0 n1.t0 255.34500000000003
rmesh_equiv_33 n1.n1 n1.n2 2.4756399999999998
rmesh_equiv_34 n1.n10 n1.n11 12.102600000000001
rmesh_equiv_35 n1.n10 n1.n8 10.151300000000001
rmesh_equiv_36 n1.n10 n1.n9 10.151300000000001
rmesh_equiv_37 n1.n11 n1.n12 11.285399999999999
rmesh_equiv_38 n1.n11 n1.n7 0.81771300000000002
rmesh_equiv_39 n1.n12 n1.n13 10.151300000000001
rmesh_equiv_4 a a.t1 330.34100000000001
rmesh_equiv_40 n1.n13 n1.t0 255.34500000000003
rmesh_equiv_41 n1.n2 n1.n3 0.81771300000000002
rmesh_equiv_42 n1.n3 n1.n7 3.6594500000000001
rmesh_equiv_43 n1.n4 n1.n6 10.151300000000001
rmesh_equiv_44 n1.n4 n1.t2 700.48400000000004
rmesh_equiv_45 n1.n5 n1.n6 10.151300000000001
rmesh_equiv_46 n1.n5 n1.t2 700.48400000000004
rmesh_equiv_47 n1.n6 n1.n7 11.285399999999999
rmesh_equiv_48 n1.n8 n1.t1 700.48400000000004
rmesh_equiv_49 n1.n9 n1.t1 700.48400000000004
rmesh_equiv_5 a a.t2 315.88
rmesh_equiv_50 n1__n1 n1__n1.t0 134.07275000000001
rmesh_equiv_51 n1__n1 n1__n1.t1 134.07275000000001
rmesh_equiv_52 n1__n1.t0 n1__n1.t1 20672.249182095649
rmesh_equiv_53 n2 n2.n0 12.8005
rmesh_equiv_54 n2 n2.n1 15.722317769867551
rmesh_equiv_55 n2 n2.n11 12.8005
rmesh_equiv_56 n2 n2.n2 12.8005
rmesh_equiv_57 n2 n2.n3 12.8005
rmesh_equiv_58 n2 n2.n6 12.8005
rmesh_equiv_59 n2 n2.n7 12.8005
rmesh_equiv_6 a a.t3 330.34100000000001
rmesh_equiv_60 n2 n2.t3 330.34100000000001
rmesh_equiv_61 n2 n2.t4 315.88
rmesh_equiv_62 n2.n0 n2.n10 10.151300000000001
rmesh_equiv_63 n2.n0 n2.t0 255.34500000000003
rmesh_equiv_64 n2.n1 n2.n5 5.3173700000000004
rmesh_equiv_65 n2.n10 n2.n11 10.151300000000001
rmesh_equiv_66 n2.n10 n2.n9 11.7021
rmesh_equiv_67 n2.n11 n2.t0 255.34500000000003
rmesh_equiv_68 n2.n2 n2.n4 10.151300000000001
rmesh_equiv_69 n2.n2 n2.t2 700.48400000000004
rmesh_equiv_7 a.n0 a.n1 0.81771300000000002
rmesh_equiv_70 n2.n3 n2.n4 10.151300000000001
rmesh_equiv_71 n2.n3 n2.t2 700.48400000000004
rmesh_equiv_72 n2.n4 n2.n5 11.7021
rmesh_equiv_73 n2.n5 n2.n9 0.81771300000000002
rmesh_equiv_74 n2.n6 n2.n8 10.151300000000001
rmesh_equiv_75 n2.n6 n2.t1 700.48400000000004
rmesh_equiv_76 n2.n7 n2.n8 10.151300000000001
rmesh_equiv_77 n2.n7 n2.t1 700.48400000000004
rmesh_equiv_78 n2.n8 n2.n9 12.519299999999999
rmesh_equiv_79 n2__n1 n2__n1.t0 134.07275000000001
rmesh_equiv_8 a.n1 a.n2 2.4756399999999998
rmesh_equiv_80 n2__n1 n2__n1.t1 134.07275000000001
rmesh_equiv_81 n2__n1.t0 n2__n1.t1 21037.918515486057
rmesh_equiv_82 n3 n3.t0 132.98773872464969
rmesh_equiv_83 n3 n3.t1 356.83634236426815
rmesh_equiv_84 n3 n3.t2 356.9260006352381
rmesh_equiv_85 n3 n3.t3 315.88
rmesh_equiv_86 n3 n3.t4 330.34100000000001
rmesh_equiv_87 n3.t0 n3.t1 106144.09219836524
rmesh_equiv_88 n3.t0 n3.t2 101818.15522945518
rmesh_equiv_89 n3.t1 n3.t2 295769.79209788376
rmesh_equiv_9 b b.n0 2.0706467054015332
rmesh_equiv_90 n3__n1 n3__n1.t0 134.07275000000001
rmesh_equiv_91 n3__n1 n3__n1.t1 134.07275000000001
rmesh_equiv_92 n3__n1.t0 n3__n1.t1 21037.918515486057
rmesh_equiv_93 n4__n1 n4__n1.t0 134.07275000000001
rmesh_equiv_94 n4__n1 n4__n1.t1 134.07275000000001
rmesh_equiv_95 n4__n1.t0 n4__n1.t1 19575.197299849129
rmesh_equiv_96 vgnd vgnd.n211 361.82106038988093
rmesh_equiv_97 vgnd vgnd.t0 190.31011845199177
rmesh_equiv_98 vgnd vgnd.t1 286.00669817177044
rmesh_equiv_99 vgnd vgnd.t10 190.30836118987148
.ends

* NGSPICE file created from cell_and2.ext - technology: sky130A

.subckt cell_and2 VGND Y B VPWR A
X0 VGND.t2 N.t3 Y.t1 VGND.t1 sky130_fd_pr__nfet_01v8 ad=0.1885 pd=1.88 as=0.1885 ps=1.88 w=0.65 l=0.15
X1 VGND.t4 B.t0 N1__N1.t1 VGND.t3 sky130_fd_pr__nfet_01v8 ad=0.1885 pd=1.88 as=0.1885 ps=1.88 w=0.65 l=0.15
X2 VPWR.t1 A.t0 N.t2 VPWR.t0 sky130_fd_pr__pfet_01v8_hvt ad=0.1885 pd=1.88 as=0.1885 ps=1.88 w=0.65 l=0.15
X3 N1__N1.t0 A.t1 N.t0 VGND.t0 sky130_fd_pr__nfet_01v8 ad=0.1885 pd=1.88 as=0.1885 ps=1.88 w=0.65 l=0.15
X4 VPWR.t5 N.t4 Y.t0 VPWR.t4 sky130_fd_pr__pfet_01v8_hvt ad=0.1885 pd=1.88 as=0.1885 ps=1.88 w=0.65 l=0.15
X5 VPWR.t3 B.t1 N.t1 VPWR.t2 sky130_fd_pr__pfet_01v8_hvt ad=0.1885 pd=1.88 as=0.1885 ps=1.88 w=0.65 l=0.15
C0 A N 0.39441f
C1 VPWR Y 0.27755f
C2 B N 0.3555f
C3 A Y 0.00192f
C4 B Y 1.69781f
C5 VPWR N1__N1 0.0122f
C6 A N1__N1 0.57599f
C7 N Y 2.88873f
C8 B N1__N1 0.34205f
C9 A VPWR 0.43865f
C10 B VPWR 0.43382f
C11 N N1__N1 1.27659f
C12 A B 0.7669f
C13 VPWR N 0.94521f
C14 Y N1__N1 0.16145f
R0 N.t2 N.n6 700.484
R1 N.n7 N.t2 700.484
R2 N.t1 N.n2 700.484
R3 N.n3 N.t1 700.484
R4 N N.t4 330.341
R5 N N.t3 315.88
R6 N.t0 N.n0 255.345
R7 N.n11 N.t0 255.345
R8 N.n1 N 31.4499
R9 N.n1 N 30.6171
R10 N N.n6 12.8005
R11 N.n7 N 12.8005
R12 N N.n2 12.8005
R13 N.n3 N 12.8005
R14 N N.n0 12.8005
R15 N N.n11 12.8005
R16 N.n9 N.n8 12.1026
R17 N.n5 N.n4 11.2854
R18 N.n10 N.n9 11.2854
R19 N.n8 N.n6 10.1513
R20 N.n8 N.n7 10.1513
R21 N.n4 N.n2 10.1513
R22 N.n4 N.n3 10.1513
R23 N.n10 N.n0 10.1513
R24 N.n11 N.n10 10.1513
R25 N.n5 N.n1 2.00152
R26 N.n9 N.n5 0.817713
R27 Y.t0 Y.n1 700.484
R28 Y.n2 Y.t0 700.484
R29 Y.t1 Y.n0 255.345
R30 Y.n6 Y.t1 255.345
R31 Y Y.n0 12.8005
R32 Y Y.n6 12.8005
R33 Y Y.n1 12.8005
R34 Y.n2 Y 12.8005
R35 Y.n5 Y.n4 11.686
R36 Y.n4 Y.n3 10.8688
R37 Y.n5 Y.n0 10.1513
R38 Y.n6 Y.n5 10.1513
R39 Y.n3 Y.n1 10.1513
R40 Y.n3 Y.n2 10.1513
R41 Y.n4 Y 3.52844
R42 VGND.n66 VGND.n65 3656.77
R43 VGND.n75 VGND.n74 3656.77
R44 VGND.n72 VGND.n12 1315.26
R45 VGND.n68 VGND.n13 1315.26
R46 VGND.n40 VGND.n11 1315.26
R47 VGND.n47 VGND.n46 1315.26
R48 VGND.n63 VGND.n22 1315.26
R49 VGND.n59 VGND.n23 1315.26
R50 VGND.n33 VGND.n21 1315.26
R51 VGND.n51 VGND.n28 1315.26
R52 VGND.n88 VGND.n76 1315.26
R53 VGND.n99 VGND.n77 1315.26
R54 VGND.n101 VGND.n8 1315.26
R55 VGND.n83 VGND.n7 1315.26
R56 VGND.n60 VGND.n59 585
R57 VGND.n26 VGND.n25 585
R58 VGND.n55 VGND.n54 585
R59 VGND.n53 VGND.n28 585
R60 VGND.n52 VGND.n51 585
R61 VGND.n51 VGND.n27 585
R62 VGND.n35 VGND.n21 585
R63 VGND.n64 VGND.n21 585
R64 VGND.n34 VGND.n33 585
R65 VGND.n32 VGND.n31 585
R66 VGND.n30 VGND.n29 585
R67 VGND.n24 VGND.n22 585
R68 VGND.n63 VGND.n62 585
R69 VGND.n64 VGND.n63 585
R70 VGND.n61 VGND.n23 585
R71 VGND.n27 VGND.n23 585
R72 VGND.n69 VGND.n68 585
R73 VGND.n16 VGND.n15 585
R74 VGND.n44 VGND.n43 585
R75 VGND.n46 VGND.n45 585
R76 VGND.n48 VGND.n47 585
R77 VGND.n47 VGND.n17 585
R78 VGND.n42 VGND.n11 585
R79 VGND.n73 VGND.n11 585
R80 VGND.n41 VGND.n40 585
R81 VGND.n39 VGND.n38 585
R82 VGND.n37 VGND.n36 585
R83 VGND.n14 VGND.n12 585
R84 VGND.n72 VGND.n71 585
R85 VGND.n73 VGND.n72 585
R86 VGND.n70 VGND.n13 585
R87 VGND.n17 VGND.n13 585
R88 VGND.n83 VGND.n82 585
R89 VGND.n81 VGND.n80 585
R90 VGND.n79 VGND.n78 585
R91 VGND.n89 VGND.n88 585
R92 VGND.n90 VGND.n76 585
R93 VGND.n85 VGND.n76 585
R94 VGND.n99 VGND.n98 585
R95 VGND.n100 VGND.n99 585
R96 VGND.n97 VGND.n77 585
R97 VGND.n96 VGND.n95 585
R98 VGND.n93 VGND.n91 585
R99 VGND.n8 VGND.n6 585
R100 VGND.n102 VGND.n101 585
R101 VGND.n101 VGND.n100 585
R102 VGND.n7 VGND.n5 585
R103 VGND.n85 VGND.n7 585
R104 VGND.n72 VGND.n13 394
R105 VGND.n38 VGND.n37 394
R106 VGND.n47 VGND.n11 394
R107 VGND.n43 VGND.n16 394
R108 VGND.n63 VGND.n23 394
R109 VGND.n31 VGND.n30 394
R110 VGND.n51 VGND.n21 394
R111 VGND.n55 VGND.n26 394
R112 VGND.n99 VGND.n76 394
R113 VGND.n95 VGND.n93 394
R114 VGND.n101 VGND.n7 394
R115 VGND.n80 VGND.n79 394
R116 VGND.t4 VGND.n1 255.345
R117 VGND.n2 VGND.t4 255.345
R118 VGND.t2 VGND.n0 255.345
R119 VGND.n105 VGND.t2 255.345
R120 VGND.n58 VGND.n57 218.815
R121 VGND.n57 VGND.n56 218.815
R122 VGND.n65 VGND.n20 218.815
R123 VGND.n65 VGND.n19 218.815
R124 VGND.n67 VGND.n66 218.815
R125 VGND.n66 VGND.n18 218.815
R126 VGND.n74 VGND.n10 218.815
R127 VGND.n74 VGND.n9 218.815
R128 VGND.n86 VGND.n84 218.815
R129 VGND.n87 VGND.n86 218.815
R130 VGND.n94 VGND.n75 218.815
R131 VGND.n92 VGND.n75 218.815
R132 VGND.n65 VGND.n64 174.425
R133 VGND.n57 VGND.n27 174.425
R134 VGND.n74 VGND.n73 174.425
R135 VGND.n66 VGND.n17 174.425
R136 VGND.n86 VGND.n85 174.425
R137 VGND.n100 VGND.n75 174.425
R138 VGND.n37 VGND.n9 147.374
R139 VGND.n40 VGND.n10 147.374
R140 VGND.n68 VGND.n67 147.374
R141 VGND.n46 VGND.n18 147.374
R142 VGND.n30 VGND.n19 147.374
R143 VGND.n33 VGND.n20 147.374
R144 VGND.n59 VGND.n58 147.374
R145 VGND.n56 VGND.n28 147.374
R146 VGND.n58 VGND.n26 147.374
R147 VGND.n56 VGND.n55 147.374
R148 VGND.n31 VGND.n20 147.374
R149 VGND.n22 VGND.n19 147.374
R150 VGND.n67 VGND.n16 147.374
R151 VGND.n43 VGND.n18 147.374
R152 VGND.n38 VGND.n10 147.374
R153 VGND.n12 VGND.n9 147.374
R154 VGND.n94 VGND.n77 147.374
R155 VGND.n92 VGND.n8 147.374
R156 VGND.n88 VGND.n87 147.374
R157 VGND.n84 VGND.n80 147.374
R158 VGND.n84 VGND.n83 147.374
R159 VGND.n87 VGND.n79 147.374
R160 VGND.n95 VGND.n94 147.374
R161 VGND.n93 VGND.n92 147.374
R162 VGND.n71 VGND.n14 85.4593
R163 VGND.n42 VGND.n41 85.4593
R164 VGND.n70 VGND.n69 85.4593
R165 VGND.n48 VGND.n45 85.4593
R166 VGND.n62 VGND.n24 85.4593
R167 VGND.n61 VGND.n60 85.4593
R168 VGND.n35 VGND.n34 85.4593
R169 VGND.n53 VGND.n52 85.4593
R170 VGND.n90 VGND.n89 85.4593
R171 VGND.n82 VGND.n5 85.4593
R172 VGND.n98 VGND.n97 85.4593
R173 VGND.n102 VGND.n6 85.4593
R174 VGND.n64 VGND.t0 47.8266
R175 VGND.n27 VGND.t0 47.8266
R176 VGND.n73 VGND.t3 47.8266
R177 VGND.n17 VGND.t3 47.8266
R178 VGND.n85 VGND.t1 47.8266
R179 VGND.n100 VGND.t1 47.8266
R180 VGND.n36 VGND.n14 25.6005
R181 VGND.n39 VGND.n36 25.6005
R182 VGND.n41 VGND.n39 25.6005
R183 VGND.n71 VGND.n70 25.6005
R184 VGND.n69 VGND.n15 25.6005
R185 VGND.n44 VGND.n15 25.6005
R186 VGND.n45 VGND.n44 25.6005
R187 VGND.n62 VGND.n61 25.6005
R188 VGND.n29 VGND.n24 25.6005
R189 VGND.n32 VGND.n29 25.6005
R190 VGND.n34 VGND.n32 25.6005
R191 VGND.n60 VGND.n25 25.6005
R192 VGND.n54 VGND.n25 25.6005
R193 VGND.n54 VGND.n53 25.6005
R194 VGND.n89 VGND.n78 25.6005
R195 VGND.n81 VGND.n78 25.6005
R196 VGND.n82 VGND.n81 25.6005
R197 VGND.n98 VGND.n90 25.6005
R198 VGND.n97 VGND.n96 25.6005
R199 VGND.n96 VGND.n91 25.6005
R200 VGND.n91 VGND.n6 25.6005
R201 VGND.n49 VGND 18.3598
R202 VGND VGND.n50 18.3598
R203 VGND.n103 VGND 18.3598
R204 VGND VGND.n42 12.8005
R205 VGND VGND.n48 12.8005
R206 VGND VGND.n35 12.8005
R207 VGND.n52 VGND 12.8005
R208 VGND VGND.n5 12.8005
R209 VGND VGND.n102 12.8005
R210 VGND VGND.n0 12.8005
R211 VGND VGND.n105 12.8005
R212 VGND VGND.n1 12.8005
R213 VGND.n2 VGND 12.8005
R214 VGND.n104 VGND.n103 10.1647
R215 VGND.n104 VGND.n0 10.1513
R216 VGND.n105 VGND.n104 10.1513
R217 VGND.n3 VGND.n1 10.1513
R218 VGND.n3 VGND.n2 10.1513
R219 VGND.n4 VGND.n3 10.0354
R220 VGND.n50 VGND.n49 1.64668
R221 VGND.n103 VGND.n4 1.50567
R222 VGND.n50 VGND 1.18255
R223 VGND.n49 VGND.n4 0.12975
R224 B B.t1 330.341
R225 B B.t0 315.88
R226 B B.n0 30.6166
R227 B.n0 B 29.7837
R228 B.n0 B 2.22536
R229 N1__N1.t1 N1__N1.n1 255.345
R230 N1__N1.n2 N1__N1.t1 255.345
R231 N1__N1.t0 N1__N1.n0 255.345
R232 N1__N1.n5 N1__N1.t0 255.345
R233 N1__N1.n4 N1__N1.n3 24.7679
R234 N1__N1 N1__N1.n1 12.8005
R235 N1__N1.n2 N1__N1 12.8005
R236 N1__N1 N1__N1.n0 12.8005
R237 N1__N1 N1__N1.n5 12.8005
R238 N1__N1.n3 N1__N1.n1 10.1513
R239 N1__N1.n3 N1__N1.n2 10.1513
R240 N1__N1.n4 N1__N1.n0 10.1513
R241 N1__N1.n5 N1__N1.n4 10.1513
R242 A A.t0 330.341
R243 A A.t1 315.88
R244 A A.n0 30.1999
R245 A.n0 A 29.3671
R246 A.n0 A 0.567438
R247 VPWR.n55 VPWR.n43 832.942
R248 VPWR.n66 VPWR.n44 832.942
R249 VPWR.n68 VPWR.n41 832.942
R250 VPWR.n50 VPWR.n40 832.942
R251 VPWR.n92 VPWR.n80 832.942
R252 VPWR.n103 VPWR.n81 832.942
R253 VPWR.n105 VPWR.n78 832.942
R254 VPWR.n87 VPWR.n77 832.942
R255 VPWR.n18 VPWR.n6 832.942
R256 VPWR.n29 VPWR.n7 832.942
R257 VPWR.n31 VPWR.n4 832.942
R258 VPWR.n13 VPWR.n3 832.942
R259 VPWR.t1 VPWR.n34 700.484
R260 VPWR.n35 VPWR.t1 700.484
R261 VPWR.t3 VPWR.n71 700.484
R262 VPWR.n72 VPWR.t3 700.484
R263 VPWR.t5 VPWR.n0 700.484
R264 VPWR.n109 VPWR.t5 700.484
R265 VPWR.n66 VPWR.n43 240
R266 VPWR.n62 VPWR.n60 240
R267 VPWR.n68 VPWR.n40 240
R268 VPWR.n47 VPWR.n46 240
R269 VPWR.n103 VPWR.n80 240
R270 VPWR.n99 VPWR.n97 240
R271 VPWR.n105 VPWR.n77 240
R272 VPWR.n84 VPWR.n83 240
R273 VPWR.n29 VPWR.n6 240
R274 VPWR.n25 VPWR.n23 240
R275 VPWR.n31 VPWR.n3 240
R276 VPWR.n10 VPWR.n9 240
R277 VPWR.n53 VPWR.n52 207.394
R278 VPWR.n67 VPWR.n42 207.394
R279 VPWR.n90 VPWR.n89 207.394
R280 VPWR.n104 VPWR.n79 207.394
R281 VPWR.n16 VPWR.n15 207.394
R282 VPWR.n30 VPWR.n5 207.394
R283 VPWR.n50 VPWR.n49 185
R284 VPWR.n48 VPWR.n47 185
R285 VPWR.n46 VPWR.n45 185
R286 VPWR.n56 VPWR.n55 185
R287 VPWR.n57 VPWR.n43 185
R288 VPWR.n52 VPWR.n43 185
R289 VPWR.n66 VPWR.n65 185
R290 VPWR.n67 VPWR.n66 185
R291 VPWR.n64 VPWR.n44 185
R292 VPWR.n63 VPWR.n62 185
R293 VPWR.n60 VPWR.n58 185
R294 VPWR.n41 VPWR.n39 185
R295 VPWR.n69 VPWR.n68 185
R296 VPWR.n68 VPWR.n67 185
R297 VPWR.n40 VPWR.n38 185
R298 VPWR.n52 VPWR.n40 185
R299 VPWR.n87 VPWR.n86 185
R300 VPWR.n85 VPWR.n84 185
R301 VPWR.n83 VPWR.n82 185
R302 VPWR.n93 VPWR.n92 185
R303 VPWR.n94 VPWR.n80 185
R304 VPWR.n89 VPWR.n80 185
R305 VPWR.n103 VPWR.n102 185
R306 VPWR.n104 VPWR.n103 185
R307 VPWR.n101 VPWR.n81 185
R308 VPWR.n100 VPWR.n99 185
R309 VPWR.n97 VPWR.n95 185
R310 VPWR.n78 VPWR.n76 185
R311 VPWR.n106 VPWR.n105 185
R312 VPWR.n105 VPWR.n104 185
R313 VPWR.n77 VPWR.n75 185
R314 VPWR.n89 VPWR.n77 185
R315 VPWR.n13 VPWR.n12 185
R316 VPWR.n11 VPWR.n10 185
R317 VPWR.n9 VPWR.n8 185
R318 VPWR.n19 VPWR.n18 185
R319 VPWR.n20 VPWR.n6 185
R320 VPWR.n15 VPWR.n6 185
R321 VPWR.n29 VPWR.n28 185
R322 VPWR.n30 VPWR.n29 185
R323 VPWR.n27 VPWR.n7 185
R324 VPWR.n26 VPWR.n25 185
R325 VPWR.n23 VPWR.n21 185
R326 VPWR.n4 VPWR.n2 185
R327 VPWR.n32 VPWR.n31 185
R328 VPWR.n31 VPWR.n30 185
R329 VPWR.n3 VPWR.n1 185
R330 VPWR.n15 VPWR.n3 185
R331 VPWR.n57 VPWR.n56 88.8476
R332 VPWR.n49 VPWR.n38 88.8476
R333 VPWR.n65 VPWR.n64 88.8476
R334 VPWR.n69 VPWR.n39 88.8476
R335 VPWR.n94 VPWR.n93 88.8476
R336 VPWR.n86 VPWR.n75 88.8476
R337 VPWR.n102 VPWR.n101 88.8476
R338 VPWR.n106 VPWR.n76 88.8476
R339 VPWR.n20 VPWR.n19 88.8476
R340 VPWR.n12 VPWR.n1 88.8476
R341 VPWR.n28 VPWR.n27 88.8476
R342 VPWR.n32 VPWR.n2 88.8476
R343 VPWR.n61 VPWR.n44 72.7879
R344 VPWR.n59 VPWR.n41 72.7879
R345 VPWR.n55 VPWR.n54 72.7879
R346 VPWR.n51 VPWR.n47 72.7879
R347 VPWR.n51 VPWR.n50 72.7879
R348 VPWR.n54 VPWR.n46 72.7879
R349 VPWR.n62 VPWR.n61 72.7879
R350 VPWR.n60 VPWR.n59 72.7879
R351 VPWR.n98 VPWR.n81 72.7879
R352 VPWR.n96 VPWR.n78 72.7879
R353 VPWR.n92 VPWR.n91 72.7879
R354 VPWR.n88 VPWR.n84 72.7879
R355 VPWR.n88 VPWR.n87 72.7879
R356 VPWR.n91 VPWR.n83 72.7879
R357 VPWR.n99 VPWR.n98 72.7879
R358 VPWR.n97 VPWR.n96 72.7879
R359 VPWR.n24 VPWR.n7 72.7879
R360 VPWR.n22 VPWR.n4 72.7879
R361 VPWR.n18 VPWR.n17 72.7879
R362 VPWR.n14 VPWR.n10 72.7879
R363 VPWR.n14 VPWR.n13 72.7879
R364 VPWR.n17 VPWR.n9 72.7879
R365 VPWR.n25 VPWR.n24 72.7879
R366 VPWR.n23 VPWR.n22 72.7879
R367 VPWR.n52 VPWR.t2 56.8667
R368 VPWR.n67 VPWR.t2 56.8667
R369 VPWR.n89 VPWR.t4 56.8667
R370 VPWR.n104 VPWR.t4 56.8667
R371 VPWR.n15 VPWR.t0 56.8667
R372 VPWR.n30 VPWR.t0 56.8667
R373 VPWR.n53 VPWR.n51 56.1076
R374 VPWR.n54 VPWR.n53 56.1076
R375 VPWR.n61 VPWR.n42 56.1076
R376 VPWR.n59 VPWR.n42 56.1076
R377 VPWR.n90 VPWR.n88 56.1076
R378 VPWR.n91 VPWR.n90 56.1076
R379 VPWR.n98 VPWR.n79 56.1076
R380 VPWR.n96 VPWR.n79 56.1076
R381 VPWR.n16 VPWR.n14 56.1076
R382 VPWR.n17 VPWR.n16 56.1076
R383 VPWR.n24 VPWR.n5 56.1076
R384 VPWR.n22 VPWR.n5 56.1076
R385 VPWR.n56 VPWR.n45 25.6005
R386 VPWR.n48 VPWR.n45 25.6005
R387 VPWR.n49 VPWR.n48 25.6005
R388 VPWR.n65 VPWR.n57 25.6005
R389 VPWR.n64 VPWR.n63 25.6005
R390 VPWR.n63 VPWR.n58 25.6005
R391 VPWR.n58 VPWR.n39 25.6005
R392 VPWR.n93 VPWR.n82 25.6005
R393 VPWR.n85 VPWR.n82 25.6005
R394 VPWR.n86 VPWR.n85 25.6005
R395 VPWR.n102 VPWR.n94 25.6005
R396 VPWR.n101 VPWR.n100 25.6005
R397 VPWR.n100 VPWR.n95 25.6005
R398 VPWR.n95 VPWR.n76 25.6005
R399 VPWR.n19 VPWR.n8 25.6005
R400 VPWR.n11 VPWR.n8 25.6005
R401 VPWR.n12 VPWR.n11 25.6005
R402 VPWR.n28 VPWR.n20 25.6005
R403 VPWR.n27 VPWR.n26 25.6005
R404 VPWR.n26 VPWR.n21 25.6005
R405 VPWR.n21 VPWR.n2 25.6005
R406 VPWR.n70 VPWR 18.865
R407 VPWR.n107 VPWR 18.865
R408 VPWR.n33 VPWR 18.865
R409 VPWR VPWR.n34 12.8005
R410 VPWR.n35 VPWR 12.8005
R411 VPWR VPWR.n38 12.8005
R412 VPWR VPWR.n69 12.8005
R413 VPWR VPWR.n71 12.8005
R414 VPWR.n72 VPWR 12.8005
R415 VPWR VPWR.n75 12.8005
R416 VPWR VPWR.n106 12.8005
R417 VPWR VPWR.n0 12.8005
R418 VPWR VPWR.n109 12.8005
R419 VPWR VPWR.n1 12.8005
R420 VPWR VPWR.n32 12.8005
R421 VPWR.n108 VPWR.n107 10.6855
R422 VPWR.n37 VPWR.n36 10.5563
R423 VPWR.n74 VPWR.n73 10.5563
R424 VPWR.n36 VPWR.n34 10.1513
R425 VPWR.n36 VPWR.n35 10.1513
R426 VPWR.n73 VPWR.n71 10.1513
R427 VPWR.n73 VPWR.n72 10.1513
R428 VPWR.n108 VPWR.n0 10.1513
R429 VPWR.n109 VPWR.n108 10.1513
R430 VPWR.n107 VPWR.n74 1.50567
R431 VPWR.n70 VPWR.n37 1.50567
R432 VPWR.n33 VPWR 0.353587
R433 VPWR.n74 VPWR.n70 0.12975
R434 VPWR.n37 VPWR.n33 0.12975
C15 Y VGND 2.95758f
C16 B VGND 2.20145f
C17 A VGND 1.65834f
C18 VPWR VGND 9.06148f
C19 N1__N1 VGND 2.14418f $ **FLOATING
C20 N VGND 5.34558f $ **FLOATING
C21 Y.n0 VGND 0.00841f $ **FLOATING
C22 Y.n1 VGND 0.00736f $ **FLOATING
C23 Y.t0 VGND 0.02255f $ **FLOATING
C24 Y.n2 VGND 0.00736f $ **FLOATING
C25 Y.n3 VGND 0.18867f $ **FLOATING
C26 Y.n4 VGND 1.59368f $ **FLOATING
C27 Y.n5 VGND 0.21707f $ **FLOATING
C28 Y.t1 VGND 0.02046f $ **FLOATING
C29 Y.n6 VGND 0.00841f $ **FLOATING
C30 N.n0 VGND 0.00536f $ **FLOATING
C31 N.t3 VGND 0.0194f $ **FLOATING
C32 N.t4 VGND 0.02016f $ **FLOATING
C33 N.n1 VGND 0.9907f $ **FLOATING
C34 N.n2 VGND 0.0047f $ **FLOATING
C35 N.t1 VGND 0.01438f $ **FLOATING
C36 N.n3 VGND 0.0047f $ **FLOATING
C37 N.n4 VGND 0.13677f $ **FLOATING
C38 N.n5 VGND 0.57059f $ **FLOATING
C39 N.n6 VGND 0.0047f $ **FLOATING
C40 N.t2 VGND 0.01438f $ **FLOATING
C41 N.n7 VGND 0.0047f $ **FLOATING
C42 N.n8 VGND 0.15567f $ **FLOATING
C43 N.n9 VGND 0.6566f $ **FLOATING
C44 N.n10 VGND 0.13677f $ **FLOATING
C45 N.t0 VGND 0.01304f $ **FLOATING
C46 N.n11 VGND 0.00536f $ **FLOATING
.ends

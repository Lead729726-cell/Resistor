* NGSPICE file created from cell_and2.ext - technology: sky130A

.subckt cell_and2 VGND Y B VPWR A
X0 register_cf_node_40ce504a4b3516cc N.t3 register_cf_node_40ce504a4b3516cc_source VGND.t1 sky130_fd_pr__nfet_01v8 ad=0.1885 pd=1.88 as=0.1885 ps=1.88 w=0.65 l=0.15
Vregister_cf_40ce504a4b3516cc VGND.t2 register_cf_node_40ce504a4b3516cc 0
Vregister_cf_40ce504a4b3516cc_source Y.t1 register_cf_node_40ce504a4b3516cc_source 0
X1 register_cf_node_fe93b93a1931efa0 B.t0 register_cf_node_fe93b93a1931efa0_source VGND.t3 sky130_fd_pr__nfet_01v8 ad=0.1885 pd=1.88 as=0.1885 ps=1.88 w=0.65 l=0.15
Vregister_cf_fe93b93a1931efa0 VGND.t4 register_cf_node_fe93b93a1931efa0 0
Vregister_cf_fe93b93a1931efa0_source N1__N1.t1 register_cf_node_fe93b93a1931efa0_source 0
X2 register_cf_node_27696c868a90a718 A.t0 register_cf_node_27696c868a90a718_source VPWR.t0 sky130_fd_pr__pfet_01v8_hvt ad=0.1885 pd=1.88 as=0.1885 ps=1.88 w=0.65 l=0.15
Vregister_cf_27696c868a90a718 VPWR.t1 register_cf_node_27696c868a90a718 0
Vregister_cf_27696c868a90a718_source N.t2 register_cf_node_27696c868a90a718_source 0
X3 register_cf_node_3178a65b5ffab5a2 A.t1 register_cf_node_3178a65b5ffab5a2_source VGND.t0 sky130_fd_pr__nfet_01v8 ad=0.1885 pd=1.88 as=0.1885 ps=1.88 w=0.65 l=0.15
Vregister_cf_3178a65b5ffab5a2 N1__N1.t0 register_cf_node_3178a65b5ffab5a2 0
Vregister_cf_3178a65b5ffab5a2_source N.t0 register_cf_node_3178a65b5ffab5a2_source 0
X4 register_cf_node_ce9430e841a29cbc N.t4 register_cf_node_ce9430e841a29cbc_source VPWR.t4 sky130_fd_pr__pfet_01v8_hvt ad=0.1885 pd=1.88 as=0.1885 ps=1.88 w=0.65 l=0.15
Vregister_cf_ce9430e841a29cbc VPWR.t5 register_cf_node_ce9430e841a29cbc 0
Vregister_cf_ce9430e841a29cbc_source Y.t0 register_cf_node_ce9430e841a29cbc_source 0
X5 register_cf_node_df18e494d2f4fbb0 B.t1 register_cf_node_df18e494d2f4fbb0_source VPWR.t2 sky130_fd_pr__pfet_01v8_hvt ad=0.1885 pd=1.88 as=0.1885 ps=1.88 w=0.65 l=0.15
Vregister_cf_df18e494d2f4fbb0 VPWR.t3 register_cf_node_df18e494d2f4fbb0 0
Vregister_cf_df18e494d2f4fbb0_source N.t1 register_cf_node_df18e494d2f4fbb0_source 0
C0 A N 0.39441f
C1 VPWR Y 0.27755f
C2 B N 0.3555f
C3 A Y 0.00192f
C4 B Y 1.69781f
C5 VPWR N1__N1 0.0122f
C6 A N1__N1 0.57599f
C7 N Y 2.88873f
C8 B N1__N1 0.34205f
C9 A VPWR 0.43865f
C10 B VPWR 0.43382f
C11 N N1__N1 1.27659f
C12 A B 0.7669f
C13 VPWR N 0.94521f
C14 Y N1__N1 0.16145f
C15 Y VGND 2.95758f
C16 B VGND 2.20145f
C17 A VGND 1.65834f
C18 VPWR VGND 9.06148f
C19 N1__N1 VGND 2.14418f $ **FLOATING
C20 N VGND 5.34558f $ **FLOATING
C21 Y.n0 VGND 0.00841f $ **FLOATING
C22 Y.n1 VGND 0.00736f $ **FLOATING
C23 Y.t0 VGND 0.02255f $ **FLOATING
C24 Y.n2 VGND 0.00736f $ **FLOATING
C25 Y.n3 VGND 0.18867f $ **FLOATING
C26 Y.n4 VGND 1.59368f $ **FLOATING
C27 Y.n5 VGND 0.21707f $ **FLOATING
C28 Y.t1 VGND 0.02046f $ **FLOATING
C29 Y.n6 VGND 0.00841f $ **FLOATING
C30 N.n0 VGND 0.00536f $ **FLOATING
C31 N.t3 VGND 0.0194f $ **FLOATING
C32 N.t4 VGND 0.02016f $ **FLOATING
C33 N.n1 VGND 0.9907f $ **FLOATING
C34 N.n2 VGND 0.0047f $ **FLOATING
C35 N.t1 VGND 0.01438f $ **FLOATING
C36 N.n3 VGND 0.0047f $ **FLOATING
C37 N.n4 VGND 0.13677f $ **FLOATING
C38 N.n5 VGND 0.57059f $ **FLOATING
C39 N.n6 VGND 0.0047f $ **FLOATING
C40 N.t2 VGND 0.01438f $ **FLOATING
C41 N.n7 VGND 0.0047f $ **FLOATING
C42 N.n8 VGND 0.15567f $ **FLOATING
C43 N.n9 VGND 0.6566f $ **FLOATING
C44 N.n10 VGND 0.13677f $ **FLOATING
C45 N.t0 VGND 0.01304f $ **FLOATING
C46 N.n11 VGND 0.00536f $ **FLOATING
rmesh_equiv_0 a a.t0 330.34100000000001
rmesh_equiv_1 a a.t1 315.88
rmesh_equiv_10 n n.n7 12.8005
rmesh_equiv_11 n n.t3 315.88
rmesh_equiv_12 n n.t4 330.34100000000001
rmesh_equiv_13 n.n0 n.n10 10.151300000000001
rmesh_equiv_14 n.n0 n.t0 255.34500000000003
rmesh_equiv_15 n.n1 n.n5 2.0015200000000002
rmesh_equiv_16 n.n10 n.n11 10.151300000000001
rmesh_equiv_17 n.n10 n.n9 11.285399999999999
rmesh_equiv_18 n.n11 n.t0 255.34500000000003
rmesh_equiv_19 n.n2 n.n4 10.151300000000001
rmesh_equiv_2 b b.t0 315.88
rmesh_equiv_20 n.n2 n.t1 700.48400000000004
rmesh_equiv_21 n.n3 n.n4 10.151300000000001
rmesh_equiv_22 n.n3 n.t1 700.48400000000004
rmesh_equiv_23 n.n4 n.n5 11.285399999999999
rmesh_equiv_24 n.n5 n.n9 0.81771300000000002
rmesh_equiv_25 n.n6 n.n8 10.151300000000001
rmesh_equiv_26 n.n6 n.t2 700.48400000000004
rmesh_equiv_27 n.n7 n.n8 10.151300000000001
rmesh_equiv_28 n.n7 n.t2 700.48400000000004
rmesh_equiv_29 n.n8 n.n9 12.102600000000001
rmesh_equiv_3 b b.t1 330.34100000000001
rmesh_equiv_30 n1__n1 n1__n1.t0 134.07275000000001
rmesh_equiv_31 n1__n1 n1__n1.t1 134.07275000000001
rmesh_equiv_32 n1__n1.t0 n1__n1.t1 20672.249182095649
rmesh_equiv_33 vgnd vgnd.t0 193.69819116526287
rmesh_equiv_34 vgnd vgnd.t1 193.6981911652629
rmesh_equiv_35 vgnd vgnd.t2 132.56314771746733
rmesh_equiv_36 vgnd vgnd.t3 193.69819116526284
rmesh_equiv_37 vgnd vgnd.t4 132.47983606102471
rmesh_equiv_38 vgnd.t0 vgnd.t1 6286230.9275900694
rmesh_equiv_39 vgnd.t0 vgnd.t3 9480.4399311524739
rmesh_equiv_4 n n.n0 12.8005
rmesh_equiv_40 vgnd.t1 vgnd.t3 9480.4399311524703
rmesh_equiv_41 vgnd.t2 vgnd.t4 121451.6888001778
rmesh_equiv_42 vpwr vpwr.t0 117.18187411979875
rmesh_equiv_43 vpwr vpwr.t1 354.87310762712247
rmesh_equiv_44 vpwr vpwr.t2 117.18187411979875
rmesh_equiv_45 vpwr vpwr.t3 355.05268971093238
rmesh_equiv_46 vpwr vpwr.t4 117.18187411979875
rmesh_equiv_47 vpwr vpwr.t5 355.13691347445138
rmesh_equiv_48 vpwr.t1 vpwr.t3 4418204.3413114324
rmesh_equiv_49 vpwr.t1 vpwr.t5 5102477.7073783781
rmesh_equiv_5 n n.n1 15.513956422736719
rmesh_equiv_50 vpwr.t3 vpwr.t5 1125517.6631811871
rmesh_equiv_51 y y.n0 12.8005
rmesh_equiv_52 y y.n1 12.8005
rmesh_equiv_53 y y.n2 12.8005
rmesh_equiv_54 y y.n4 3.5284399999999998
rmesh_equiv_55 y y.n6 12.8005
rmesh_equiv_56 y.n0 y.n5 10.151300000000001
rmesh_equiv_57 y.n0 y.t1 255.34500000000003
rmesh_equiv_58 y.n1 y.n3 10.151300000000001
rmesh_equiv_59 y.n1 y.t0 700.48400000000004
rmesh_equiv_6 n n.n11 12.8005
rmesh_equiv_60 y.n2 y.n3 10.151300000000001
rmesh_equiv_61 y.n2 y.t0 700.48400000000004
rmesh_equiv_62 y.n3 y.n4 10.8688
rmesh_equiv_63 y.n4 y.n5 11.686
rmesh_equiv_64 y.n5 y.n6 10.151300000000001
rmesh_equiv_65 y.n6 y.t1 255.34500000000003
rmesh_equiv_7 n n.n2 12.8005
rmesh_equiv_8 n n.n3 12.8005
rmesh_equiv_9 n n.n6 12.8005
.ends

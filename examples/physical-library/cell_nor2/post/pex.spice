* NGSPICE file created from cell_nor2.ext - technology: sky130A

.subckt cell_nor2 VPWR VGND B Y A
X0 VGND.t3 A.t0 Y.t2 VGND.t2 sky130_fd_pr__nfet_01v8 ad=0.1885 pd=1.88 as=0.1885 ps=1.88 w=0.65 l=0.15
X1 VGND.t1 B.t0 Y.t1 VGND.t0 sky130_fd_pr__nfet_01v8 ad=0.1885 pd=1.88 as=0.1885 ps=1.88 w=0.65 l=0.15
X2 VPWR.t2 A.t1 N.t1 VPWR.t1 sky130_fd_pr__pfet_01v8_hvt ad=0.1885 pd=1.88 as=0.1885 ps=1.88 w=0.65 l=0.15
X3 N.t0 B.t1 Y.t0 VPWR.t0 sky130_fd_pr__pfet_01v8_hvt ad=0.1885 pd=1.88 as=0.1885 ps=1.88 w=0.65 l=0.15
C0 A B 0.09238f
C1 N Y 0.40037f
C2 VPWR A 0.45398f
C3 N B 1.47427f
C4 N VPWR 0.38776f
C5 Y B 1.72823f
C6 N A 0.24971f
C7 VPWR Y 0.15155f
C8 VPWR B 0.32158f
C9 Y A 1.56867f
R0 A A.t1 330.341
R1 A A.t0 315.88
R2 A A.n0 31.0353
R3 A.n0 A 29.3671
R4 A.n0 A 0.567438
R5 Y.t0 Y.n1 700.484
R6 Y.n2 Y.t0 700.484
R7 Y.t2 Y.n5 255.345
R8 Y.n6 Y.t2 255.345
R9 Y.t1 Y.n0 255.345
R10 Y.n10 Y.t1 255.345
R11 Y Y.n5 12.8005
R12 Y.n6 Y 12.8005
R13 Y Y.n0 12.8005
R14 Y Y.n10 12.8005
R15 Y Y.n1 12.8005
R16 Y.n2 Y 12.8005
R17 Y.n9 Y.n8 11.2629
R18 Y.n8 Y.n7 10.4521
R19 Y.n4 Y.n3 10.4521
R20 Y.n7 Y.n5 10.1513
R21 Y.n7 Y.n6 10.1513
R22 Y.n9 Y.n0 10.1513
R23 Y.n10 Y.n9 10.1513
R24 Y.n3 Y.n1 10.1513
R25 Y.n3 Y.n2 10.1513
R26 Y.n4 Y 1.04801
R27 Y.n8 Y.n4 0.817713
R28 VGND.n42 VGND.n41 1651.52
R29 VGND.n39 VGND.n12 1315.26
R30 VGND.n35 VGND.n13 1315.26
R31 VGND.n23 VGND.n11 1315.26
R32 VGND.n27 VGND.n18 1315.26
R33 VGND.n55 VGND.n43 1315.26
R34 VGND.n66 VGND.n44 1315.26
R35 VGND.n68 VGND.n8 1315.26
R36 VGND.n50 VGND.n7 1315.26
R37 VGND.n36 VGND.n35 585
R38 VGND.n16 VGND.n15 585
R39 VGND.n31 VGND.n30 585
R40 VGND.n29 VGND.n18 585
R41 VGND.n28 VGND.n27 585
R42 VGND.n27 VGND.n17 585
R43 VGND.n25 VGND.n11 585
R44 VGND.n40 VGND.n11 585
R45 VGND.n24 VGND.n23 585
R46 VGND.n22 VGND.n21 585
R47 VGND.n20 VGND.n19 585
R48 VGND.n14 VGND.n12 585
R49 VGND.n39 VGND.n38 585
R50 VGND.n40 VGND.n39 585
R51 VGND.n37 VGND.n13 585
R52 VGND.n17 VGND.n13 585
R53 VGND.n50 VGND.n49 585
R54 VGND.n48 VGND.n47 585
R55 VGND.n46 VGND.n45 585
R56 VGND.n56 VGND.n55 585
R57 VGND.n57 VGND.n43 585
R58 VGND.n52 VGND.n43 585
R59 VGND.n66 VGND.n65 585
R60 VGND.n67 VGND.n66 585
R61 VGND.n64 VGND.n44 585
R62 VGND.n63 VGND.n62 585
R63 VGND.n60 VGND.n58 585
R64 VGND.n8 VGND.n6 585
R65 VGND.n69 VGND.n68 585
R66 VGND.n68 VGND.n67 585
R67 VGND.n7 VGND.n5 585
R68 VGND.n52 VGND.n7 585
R69 VGND.n39 VGND.n13 394
R70 VGND.n21 VGND.n20 394
R71 VGND.n27 VGND.n11 394
R72 VGND.n31 VGND.n16 394
R73 VGND.n66 VGND.n43 394
R74 VGND.n62 VGND.n60 394
R75 VGND.n68 VGND.n7 394
R76 VGND.n47 VGND.n46 394
R77 VGND.t3 VGND.n1 255.345
R78 VGND.n2 VGND.t3 255.345
R79 VGND.t1 VGND.n0 255.345
R80 VGND.n72 VGND.t1 255.345
R81 VGND.n34 VGND.n33 218.815
R82 VGND.n33 VGND.n32 218.815
R83 VGND.n41 VGND.n10 218.815
R84 VGND.n41 VGND.n9 218.815
R85 VGND.n53 VGND.n51 218.815
R86 VGND.n54 VGND.n53 218.815
R87 VGND.n61 VGND.n42 218.815
R88 VGND.n59 VGND.n42 218.815
R89 VGND.n53 VGND.n52 188.921
R90 VGND.n67 VGND.n42 188.921
R91 VGND.n41 VGND.n40 188.921
R92 VGND.n33 VGND.n17 188.921
R93 VGND.n20 VGND.n9 147.374
R94 VGND.n23 VGND.n10 147.374
R95 VGND.n35 VGND.n34 147.374
R96 VGND.n32 VGND.n18 147.374
R97 VGND.n34 VGND.n16 147.374
R98 VGND.n32 VGND.n31 147.374
R99 VGND.n21 VGND.n10 147.374
R100 VGND.n12 VGND.n9 147.374
R101 VGND.n61 VGND.n44 147.374
R102 VGND.n59 VGND.n8 147.374
R103 VGND.n55 VGND.n54 147.374
R104 VGND.n51 VGND.n47 147.374
R105 VGND.n51 VGND.n50 147.374
R106 VGND.n54 VGND.n46 147.374
R107 VGND.n62 VGND.n61 147.374
R108 VGND.n60 VGND.n59 147.374
R109 VGND.n38 VGND.n14 85.4593
R110 VGND.n37 VGND.n36 85.4593
R111 VGND.n25 VGND.n24 85.4593
R112 VGND.n29 VGND.n28 85.4593
R113 VGND.n57 VGND.n56 85.4593
R114 VGND.n49 VGND.n5 85.4593
R115 VGND.n65 VGND.n64 85.4593
R116 VGND.n69 VGND.n6 85.4593
R117 VGND.n52 VGND.t0 51.8011
R118 VGND.n67 VGND.t0 51.8011
R119 VGND.n40 VGND.t2 51.8011
R120 VGND.n17 VGND.t2 51.8011
R121 VGND.n38 VGND.n37 25.6005
R122 VGND.n19 VGND.n14 25.6005
R123 VGND.n22 VGND.n19 25.6005
R124 VGND.n24 VGND.n22 25.6005
R125 VGND.n36 VGND.n15 25.6005
R126 VGND.n30 VGND.n15 25.6005
R127 VGND.n30 VGND.n29 25.6005
R128 VGND.n56 VGND.n45 25.6005
R129 VGND.n48 VGND.n45 25.6005
R130 VGND.n49 VGND.n48 25.6005
R131 VGND.n65 VGND.n57 25.6005
R132 VGND.n64 VGND.n63 25.6005
R133 VGND.n63 VGND.n58 25.6005
R134 VGND.n58 VGND.n6 25.6005
R135 VGND VGND.n26 18.3598
R136 VGND.n70 VGND 18.3598
R137 VGND VGND.n25 12.8005
R138 VGND.n28 VGND 12.8005
R139 VGND VGND.n5 12.8005
R140 VGND VGND.n69 12.8005
R141 VGND VGND.n0 12.8005
R142 VGND VGND.n72 12.8005
R143 VGND VGND.n1 12.8005
R144 VGND.n2 VGND 12.8005
R145 VGND.n71 VGND.n70 10.1647
R146 VGND.n71 VGND.n0 10.1513
R147 VGND.n72 VGND.n71 10.1513
R148 VGND.n3 VGND.n1 10.1513
R149 VGND.n3 VGND.n2 10.1513
R150 VGND.n4 VGND.n3 10.0354
R151 VGND.n26 VGND 2.01797
R152 VGND.n70 VGND.n4 0.67025
R153 VGND.n26 VGND.n4 0.12975
R154 B B.t1 330.341
R155 B B.t0 315.88
R156 B B.n0 31.8557
R157 B.n0 B 30.2004
R158 B.n0 B 1.40286
R159 N.t1 N.n1 700.484
R160 N.n2 N.t1 700.484
R161 N.t0 N.n0 700.484
R162 N.n5 N.t0 700.484
R163 N.n4 N.n3 23.676
R164 N N.n1 12.8005
R165 N.n2 N 12.8005
R166 N N.n0 12.8005
R167 N N.n5 12.8005
R168 N.n3 N.n1 10.1513
R169 N.n3 N.n2 10.1513
R170 N.n4 N.n0 10.1513
R171 N.n5 N.n4 10.1513
R172 VPWR.n17 VPWR.n5 832.942
R173 VPWR.n28 VPWR.n6 832.942
R174 VPWR.n30 VPWR.n3 832.942
R175 VPWR.n12 VPWR.n2 832.942
R176 VPWR.n49 VPWR.n37 832.942
R177 VPWR.n60 VPWR.n38 832.942
R178 VPWR.n62 VPWR.n35 832.942
R179 VPWR.n44 VPWR.n34 832.942
R180 VPWR.t2 VPWR.n65 700.484
R181 VPWR.n66 VPWR.t2 700.484
R182 VPWR.n28 VPWR.n5 240
R183 VPWR.n24 VPWR.n22 240
R184 VPWR.n30 VPWR.n2 240
R185 VPWR.n9 VPWR.n8 240
R186 VPWR.n60 VPWR.n37 240
R187 VPWR.n56 VPWR.n54 240
R188 VPWR.n62 VPWR.n34 240
R189 VPWR.n41 VPWR.n40 240
R190 VPWR.n15 VPWR.n14 207.394
R191 VPWR.n29 VPWR.n4 207.394
R192 VPWR.n47 VPWR.n46 207.394
R193 VPWR.n61 VPWR.n36 207.394
R194 VPWR.n12 VPWR.n11 185
R195 VPWR.n10 VPWR.n9 185
R196 VPWR.n8 VPWR.n7 185
R197 VPWR.n18 VPWR.n17 185
R198 VPWR.n19 VPWR.n5 185
R199 VPWR.n14 VPWR.n5 185
R200 VPWR.n28 VPWR.n27 185
R201 VPWR.n29 VPWR.n28 185
R202 VPWR.n26 VPWR.n6 185
R203 VPWR.n25 VPWR.n24 185
R204 VPWR.n22 VPWR.n20 185
R205 VPWR.n3 VPWR.n1 185
R206 VPWR.n31 VPWR.n30 185
R207 VPWR.n30 VPWR.n29 185
R208 VPWR.n2 VPWR.n0 185
R209 VPWR.n14 VPWR.n2 185
R210 VPWR.n44 VPWR.n43 185
R211 VPWR.n42 VPWR.n41 185
R212 VPWR.n40 VPWR.n39 185
R213 VPWR.n50 VPWR.n49 185
R214 VPWR.n51 VPWR.n37 185
R215 VPWR.n46 VPWR.n37 185
R216 VPWR.n60 VPWR.n59 185
R217 VPWR.n61 VPWR.n60 185
R218 VPWR.n58 VPWR.n38 185
R219 VPWR.n57 VPWR.n56 185
R220 VPWR.n54 VPWR.n52 185
R221 VPWR.n35 VPWR.n33 185
R222 VPWR.n63 VPWR.n62 185
R223 VPWR.n62 VPWR.n61 185
R224 VPWR.n34 VPWR.n32 185
R225 VPWR.n46 VPWR.n34 185
R226 VPWR.n19 VPWR.n18 88.8476
R227 VPWR.n11 VPWR.n0 88.8476
R228 VPWR.n27 VPWR.n26 88.8476
R229 VPWR.n31 VPWR.n1 88.8476
R230 VPWR.n51 VPWR.n50 88.8476
R231 VPWR.n43 VPWR.n32 88.8476
R232 VPWR.n59 VPWR.n58 88.8476
R233 VPWR.n63 VPWR.n33 88.8476
R234 VPWR.n23 VPWR.n6 72.7879
R235 VPWR.n21 VPWR.n3 72.7879
R236 VPWR.n17 VPWR.n16 72.7879
R237 VPWR.n13 VPWR.n9 72.7879
R238 VPWR.n13 VPWR.n12 72.7879
R239 VPWR.n16 VPWR.n8 72.7879
R240 VPWR.n24 VPWR.n23 72.7879
R241 VPWR.n22 VPWR.n21 72.7879
R242 VPWR.n55 VPWR.n38 72.7879
R243 VPWR.n53 VPWR.n35 72.7879
R244 VPWR.n49 VPWR.n48 72.7879
R245 VPWR.n45 VPWR.n41 72.7879
R246 VPWR.n45 VPWR.n44 72.7879
R247 VPWR.n48 VPWR.n40 72.7879
R248 VPWR.n56 VPWR.n55 72.7879
R249 VPWR.n54 VPWR.n53 72.7879
R250 VPWR.n14 VPWR.t0 56.8667
R251 VPWR.n29 VPWR.t0 56.8667
R252 VPWR.n46 VPWR.t1 56.8667
R253 VPWR.n61 VPWR.t1 56.8667
R254 VPWR.n15 VPWR.n13 56.1076
R255 VPWR.n16 VPWR.n15 56.1076
R256 VPWR.n23 VPWR.n4 56.1076
R257 VPWR.n21 VPWR.n4 56.1076
R258 VPWR.n47 VPWR.n45 56.1076
R259 VPWR.n48 VPWR.n47 56.1076
R260 VPWR.n55 VPWR.n36 56.1076
R261 VPWR.n53 VPWR.n36 56.1076
R262 VPWR.n18 VPWR.n7 25.6005
R263 VPWR.n10 VPWR.n7 25.6005
R264 VPWR.n11 VPWR.n10 25.6005
R265 VPWR.n27 VPWR.n19 25.6005
R266 VPWR.n26 VPWR.n25 25.6005
R267 VPWR.n25 VPWR.n20 25.6005
R268 VPWR.n20 VPWR.n1 25.6005
R269 VPWR.n50 VPWR.n39 25.6005
R270 VPWR.n42 VPWR.n39 25.6005
R271 VPWR.n43 VPWR.n42 25.6005
R272 VPWR.n59 VPWR.n51 25.6005
R273 VPWR.n58 VPWR.n57 25.6005
R274 VPWR.n57 VPWR.n52 25.6005
R275 VPWR.n52 VPWR.n33 25.6005
R276 VPWR VPWR.n68 19.5477
R277 VPWR.n64 VPWR 18.865
R278 VPWR VPWR.n65 12.8005
R279 VPWR.n66 VPWR 12.8005
R280 VPWR VPWR.n0 12.8005
R281 VPWR VPWR.n31 12.8005
R282 VPWR VPWR.n32 12.8005
R283 VPWR VPWR.n63 12.8005
R284 VPWR.n68 VPWR.n67 10.5563
R285 VPWR.n67 VPWR.n65 10.1513
R286 VPWR.n67 VPWR.n66 10.1513
R287 VPWR.n64 VPWR 0.353587
R288 VPWR.n68 VPWR.n64 0.12975
C10 Y VGND 2.17208f
C11 B VGND 2.61573f
C12 A VGND 2.13838f
C13 VPWR VGND 4.46124f
C14 N VGND 1.6173f $ **FLOATING
.ends

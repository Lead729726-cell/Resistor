* NGSPICE file created from chip_ota.ext - technology: sky130A

.subckt chip_ota VGND BIAS OUT VPWR INN INP
X0 TAIL.t2 INN.t0 MIR.t2 VGND.t3 sky130_fd_pr__nfet_01v8 ad=2.9 pd=20.58 as=2.9 ps=20.58 w=10 l=1
X1 VGND.t2 BIAS.t0 TAIL.t1 VGND.t1 sky130_fd_pr__nfet_01v8 ad=0.58 pd=4.58 as=0.58 ps=4.58 w=2 l=1
X2 TAIL.t0 INP.t0 OUT.t0 VGND.t0 sky130_fd_pr__nfet_01v8 ad=2.9 pd=20.58 as=2.9 ps=20.58 w=10 l=1
X3 VPWR.t3 MIR.t0 MIR.t1 VPWR.t2 sky130_fd_pr__pfet_01v8_hvt ad=5.8 pd=40.58 as=5.8 ps=40.58 w=20 l=1
X4 VPWR.t1 MIR.t3 OUT.t1 VPWR.t0 sky130_fd_pr__pfet_01v8_hvt ad=5.8 pd=40.58 as=5.8 ps=40.58 w=20 l=1
C0 INP TAIL 0.9714f
C1 BIAS TAIL 2.39602f
C2 INP BIAS 0
C3 INN TAIL 1.09995f
C4 MIR TAIL 1.24985f
C5 VPWR TAIL 0.04677f
C6 TAIL OUT 1.16127f
C7 INP INN 0.37624f
C8 INP MIR 0.11267f
C9 INN BIAS 0
C10 MIR BIAS 0.07299f
C11 VPWR BIAS 0.00587f
C12 INP OUT 0.43696f
C13 BIAS OUT 1.62422f
C14 MIR INN 0.79371f
C15 VPWR INN 0.00367f
C16 VPWR MIR 5.35602f
C17 INN OUT 0.928f
C18 MIR OUT 1.38657f
C19 VPWR OUT 2.87278f
C20 BIAS VGND 5.40204f
C21 INN VGND 1.68209f
C22 OUT VGND 4.26016f
C23 INP VGND 1.55504f
C24 VPWR VGND 25.41188f
C25 TAIL VGND 6.88781f $ **FLOATING
C26 MIR VGND 6.13771f $ **FLOATING
C27 VPWR.n0 VGND 0.01029f $ **FLOATING
C28 VPWR.n1 VGND 0.00219f $ **FLOATING
C29 VPWR.n2 VGND 0.00219f $ **FLOATING
C30 VPWR.n3 VGND 0.00486f $ **FLOATING
C31 VPWR.n4 VGND 0.00486f $ **FLOATING
C32 VPWR.t2 VGND 0.28648f $ **FLOATING
C33 VPWR.n5 VGND 0.36863f $ **FLOATING
C34 VPWR.n6 VGND 0.00219f $ **FLOATING
C35 VPWR.n7 VGND 0.00486f $ **FLOATING
C36 VPWR.n8 VGND 0.00486f $ **FLOATING
C37 VPWR.n9 VGND 0.00486f $ **FLOATING
C38 VPWR.n10 VGND 0.36863f $ **FLOATING
C39 VPWR.n11 VGND 0.00485f $ **FLOATING
C40 VPWR.n12 VGND 0.00219f $ **FLOATING
C41 VPWR.n13 VGND 0.00219f $ **FLOATING
C42 VPWR.n42 VGND 0.00219f $ **FLOATING
C43 VPWR.n43 VGND 0.00485f $ **FLOATING
C44 VPWR.n44 VGND 0.00485f $ **FLOATING
C45 VPWR.n45 VGND 0.00219f $ **FLOATING
C46 VPWR.n46 VGND 0.00219f $ **FLOATING
C47 VPWR.n47 VGND 0.00219f $ **FLOATING
C48 VPWR.n48 VGND 0.00219f $ **FLOATING
C49 VPWR.n49 VGND 0.00219f $ **FLOATING
C50 VPWR.n50 VGND 0.00219f $ **FLOATING
C51 VPWR.n51 VGND 0.00219f $ **FLOATING
C52 VPWR.n52 VGND 0.00219f $ **FLOATING
C53 VPWR.n53 VGND 0.00219f $ **FLOATING
C54 VPWR.n54 VGND 0.00219f $ **FLOATING
C55 VPWR.n55 VGND 0.00219f $ **FLOATING
C56 VPWR.n56 VGND 0.00219f $ **FLOATING
C57 VPWR.n57 VGND 0.00219f $ **FLOATING
C58 VPWR.n58 VGND 0.00219f $ **FLOATING
C59 VPWR.n59 VGND 0.00219f $ **FLOATING
C60 VPWR.n60 VGND 0.00219f $ **FLOATING
C61 VPWR.n61 VGND 0.00219f $ **FLOATING
C62 VPWR.n62 VGND 0.00219f $ **FLOATING
C63 VPWR.n63 VGND 0.00219f $ **FLOATING
C64 VPWR.n64 VGND 0.00219f $ **FLOATING
C65 VPWR.n65 VGND 0.00219f $ **FLOATING
C66 VPWR.n66 VGND 0.00219f $ **FLOATING
C67 VPWR.n67 VGND 0.00219f $ **FLOATING
C68 VPWR.n68 VGND 0.00219f $ **FLOATING
C69 VPWR.n69 VGND 0.00219f $ **FLOATING
C70 VPWR.n70 VGND 0.00219f $ **FLOATING
C71 VPWR.n71 VGND 0.00219f $ **FLOATING
C72 VPWR.n72 VGND 0.00219f $ **FLOATING
C73 VPWR.n73 VGND 0.00219f $ **FLOATING
C74 VPWR.n74 VGND 0.00219f $ **FLOATING
C75 VPWR.n75 VGND 0.00219f $ **FLOATING
C76 VPWR.n76 VGND 0.00219f $ **FLOATING
C77 VPWR.n77 VGND 0.00219f $ **FLOATING
C78 VPWR.n78 VGND 0.00219f $ **FLOATING
C79 VPWR.n79 VGND 0.00219f $ **FLOATING
C80 VPWR.n80 VGND 0.00219f $ **FLOATING
C81 VPWR.n81 VGND 0.00219f $ **FLOATING
C82 VPWR.n82 VGND 0.00219f $ **FLOATING
C83 VPWR.n83 VGND 0.00219f $ **FLOATING
C84 VPWR.n84 VGND 0.00219f $ **FLOATING
C85 VPWR.n85 VGND 0.00219f $ **FLOATING
C86 VPWR.n86 VGND 0.00219f $ **FLOATING
C87 VPWR.n87 VGND 0.00219f $ **FLOATING
C88 VPWR.n88 VGND 0.00219f $ **FLOATING
C89 VPWR.n89 VGND 0.00219f $ **FLOATING
C90 VPWR.n90 VGND 0.00219f $ **FLOATING
C91 VPWR.n91 VGND 0.00219f $ **FLOATING
C92 VPWR.n92 VGND 0.00219f $ **FLOATING
C93 VPWR.n93 VGND 0.00219f $ **FLOATING
C94 VPWR.n94 VGND 0.00219f $ **FLOATING
C95 VPWR.n95 VGND 0.00219f $ **FLOATING
C96 VPWR.n96 VGND 0.00219f $ **FLOATING
C97 VPWR.n97 VGND 0.00219f $ **FLOATING
C98 VPWR.n98 VGND 0.00219f $ **FLOATING
C99 VPWR.n99 VGND 0.00219f $ **FLOATING
C100 VPWR.n100 VGND 0.00219f $ **FLOATING
C101 VPWR.n101 VGND 0.00219f $ **FLOATING
C102 VPWR.n102 VGND 0.00219f $ **FLOATING
C103 VPWR.n103 VGND 0.00219f $ **FLOATING
C104 VPWR.n104 VGND 0.00219f $ **FLOATING
C105 VPWR.n105 VGND 0.00219f $ **FLOATING
C106 VPWR.n106 VGND 0.00219f $ **FLOATING
C107 VPWR.n107 VGND 0.00219f $ **FLOATING
C108 VPWR.n108 VGND 0.00219f $ **FLOATING
C109 VPWR.n109 VGND 0.00219f $ **FLOATING
C110 VPWR.n110 VGND 0.00219f $ **FLOATING
C111 VPWR.n111 VGND 0.00219f $ **FLOATING
C112 VPWR.n112 VGND 0.00219f $ **FLOATING
C113 VPWR.n113 VGND 0.00219f $ **FLOATING
C114 VPWR.n114 VGND 0.00219f $ **FLOATING
C115 VPWR.n115 VGND 0.00219f $ **FLOATING
C116 VPWR.n116 VGND 0.00219f $ **FLOATING
C117 VPWR.n117 VGND 0.00219f $ **FLOATING
C118 VPWR.n118 VGND 0.00219f $ **FLOATING
C119 VPWR.n119 VGND 0.00219f $ **FLOATING
C120 VPWR.n120 VGND 0.00219f $ **FLOATING
C121 VPWR.n121 VGND 0.00219f $ **FLOATING
C122 VPWR.n122 VGND 0.00219f $ **FLOATING
C123 VPWR.n123 VGND 0.00219f $ **FLOATING
C124 VPWR.n124 VGND 0.00219f $ **FLOATING
C125 VPWR.n125 VGND 0.00219f $ **FLOATING
C126 VPWR.n126 VGND 0.00219f $ **FLOATING
C127 VPWR.n127 VGND 0.00219f $ **FLOATING
C128 VPWR.n128 VGND 0.00219f $ **FLOATING
C129 VPWR.n129 VGND 0.00219f $ **FLOATING
C130 VPWR.n130 VGND 0.00219f $ **FLOATING
C131 VPWR.n131 VGND 0.00219f $ **FLOATING
C132 VPWR.n132 VGND 0.00219f $ **FLOATING
C133 VPWR.n133 VGND 0.00219f $ **FLOATING
C134 VPWR.n134 VGND 0.00219f $ **FLOATING
C135 VPWR.n135 VGND 0.00219f $ **FLOATING
C136 VPWR.n136 VGND 0.00219f $ **FLOATING
C137 VPWR.n137 VGND 0.00219f $ **FLOATING
C138 VPWR.n138 VGND 0.00219f $ **FLOATING
C139 VPWR.n139 VGND 0.00219f $ **FLOATING
C140 VPWR.n140 VGND 0.00219f $ **FLOATING
C141 VPWR.n141 VGND 0.00219f $ **FLOATING
C142 VPWR.n142 VGND 0.00219f $ **FLOATING
C143 VPWR.n143 VGND 0.00219f $ **FLOATING
C144 VPWR.n144 VGND 0.00219f $ **FLOATING
C145 VPWR.n145 VGND 0.00219f $ **FLOATING
C146 VPWR.n146 VGND 0.00219f $ **FLOATING
C147 VPWR.n147 VGND 0.00219f $ **FLOATING
C148 VPWR.n148 VGND 0.00219f $ **FLOATING
C149 VPWR.n149 VGND 0.00219f $ **FLOATING
C150 VPWR.n150 VGND 0.00219f $ **FLOATING
C151 VPWR.n151 VGND 0.00219f $ **FLOATING
C152 VPWR.n152 VGND 0.00219f $ **FLOATING
C153 VPWR.n153 VGND 0.00219f $ **FLOATING
C154 VPWR.n154 VGND 0.00219f $ **FLOATING
C155 VPWR.n155 VGND 0.00219f $ **FLOATING
C156 VPWR.n156 VGND 0.00219f $ **FLOATING
C157 VPWR.n157 VGND 0.00219f $ **FLOATING
C158 VPWR.n159 VGND 0.44868f $ **FLOATING
C159 VPWR.n161 VGND 0.00219f $ **FLOATING
C160 VPWR.n162 VGND 0.00219f $ **FLOATING
C161 VPWR.n163 VGND 0.00485f $ **FLOATING
C162 VPWR.n164 VGND 0.00486f $ **FLOATING
C163 VPWR.n165 VGND 0.00486f $ **FLOATING
C164 VPWR.n166 VGND 0.00219f $ **FLOATING
C165 VPWR.n167 VGND 0.28648f $ **FLOATING
C166 VPWR.n168 VGND 0.00219f $ **FLOATING
C167 VPWR.n169 VGND 0.00219f $ **FLOATING
C168 VPWR.n170 VGND 0.00219f $ **FLOATING
C169 VPWR.n171 VGND 0.00219f $ **FLOATING
C170 VPWR.n172 VGND 0.00219f $ **FLOATING
C171 VPWR.n202 VGND 0.00219f $ **FLOATING
C172 VPWR.n203 VGND 0.00485f $ **FLOATING
C173 VPWR.n204 VGND 0.00485f $ **FLOATING
C174 VPWR.n205 VGND 0.00219f $ **FLOATING
C175 VPWR.n206 VGND 0.00219f $ **FLOATING
C176 VPWR.n207 VGND 0.00219f $ **FLOATING
C177 VPWR.n208 VGND 0.00219f $ **FLOATING
C178 VPWR.n209 VGND 0.00219f $ **FLOATING
C179 VPWR.n210 VGND 0.00219f $ **FLOATING
C180 VPWR.n211 VGND 0.00219f $ **FLOATING
C181 VPWR.n212 VGND 0.00219f $ **FLOATING
C182 VPWR.n213 VGND 0.00219f $ **FLOATING
C183 VPWR.n214 VGND 0.00219f $ **FLOATING
C184 VPWR.n215 VGND 0.00219f $ **FLOATING
C185 VPWR.n216 VGND 0.00219f $ **FLOATING
C186 VPWR.n217 VGND 0.00219f $ **FLOATING
C187 VPWR.n218 VGND 0.00219f $ **FLOATING
C188 VPWR.n219 VGND 0.00219f $ **FLOATING
C189 VPWR.n220 VGND 0.00219f $ **FLOATING
C190 VPWR.n221 VGND 0.00219f $ **FLOATING
C191 VPWR.n222 VGND 0.00219f $ **FLOATING
C192 VPWR.n223 VGND 0.00219f $ **FLOATING
C193 VPWR.n224 VGND 0.00219f $ **FLOATING
C194 VPWR.n225 VGND 0.00219f $ **FLOATING
C195 VPWR.n226 VGND 0.00219f $ **FLOATING
C196 VPWR.n227 VGND 0.00219f $ **FLOATING
C197 VPWR.n228 VGND 0.00219f $ **FLOATING
C198 VPWR.n229 VGND 0.00219f $ **FLOATING
C199 VPWR.n230 VGND 0.00219f $ **FLOATING
C200 VPWR.n231 VGND 0.00219f $ **FLOATING
C201 VPWR.n232 VGND 0.00219f $ **FLOATING
C202 VPWR.n233 VGND 0.00219f $ **FLOATING
C203 VPWR.n234 VGND 0.00219f $ **FLOATING
C204 VPWR.n235 VGND 0.00219f $ **FLOATING
C205 VPWR.n236 VGND 0.00219f $ **FLOATING
C206 VPWR.n237 VGND 0.00219f $ **FLOATING
C207 VPWR.n238 VGND 0.00219f $ **FLOATING
C208 VPWR.n239 VGND 0.00219f $ **FLOATING
C209 VPWR.n240 VGND 0.00219f $ **FLOATING
C210 VPWR.n241 VGND 0.00219f $ **FLOATING
C211 VPWR.n242 VGND 0.00219f $ **FLOATING
C212 VPWR.n243 VGND 0.00219f $ **FLOATING
C213 VPWR.n244 VGND 0.00219f $ **FLOATING
C214 VPWR.n245 VGND 0.00219f $ **FLOATING
C215 VPWR.n246 VGND 0.00219f $ **FLOATING
C216 VPWR.n247 VGND 0.00219f $ **FLOATING
C217 VPWR.n248 VGND 0.00219f $ **FLOATING
C218 VPWR.n249 VGND 0.00219f $ **FLOATING
C219 VPWR.n250 VGND 0.00219f $ **FLOATING
C220 VPWR.n251 VGND 0.00219f $ **FLOATING
C221 VPWR.n252 VGND 0.00219f $ **FLOATING
C222 VPWR.n253 VGND 0.00219f $ **FLOATING
C223 VPWR.n254 VGND 0.00219f $ **FLOATING
C224 VPWR.n255 VGND 0.00219f $ **FLOATING
C225 VPWR.n256 VGND 0.00219f $ **FLOATING
C226 VPWR.n257 VGND 0.00219f $ **FLOATING
C227 VPWR.n258 VGND 0.00219f $ **FLOATING
C228 VPWR.n259 VGND 0.00219f $ **FLOATING
C229 VPWR.n260 VGND 0.00219f $ **FLOATING
C230 VPWR.n261 VGND 0.00219f $ **FLOATING
C231 VPWR.n262 VGND 0.00219f $ **FLOATING
C232 VPWR.n263 VGND 0.00219f $ **FLOATING
C233 VPWR.n264 VGND 0.00219f $ **FLOATING
C234 VPWR.n265 VGND 0.00219f $ **FLOATING
C235 VPWR.n266 VGND 0.00219f $ **FLOATING
C236 VPWR.n267 VGND 0.00219f $ **FLOATING
C237 VPWR.n268 VGND 0.00219f $ **FLOATING
C238 VPWR.n269 VGND 0.00219f $ **FLOATING
C239 VPWR.n270 VGND 0.00219f $ **FLOATING
C240 VPWR.n271 VGND 0.00219f $ **FLOATING
C241 VPWR.n272 VGND 0.00219f $ **FLOATING
C242 VPWR.n273 VGND 0.00219f $ **FLOATING
C243 VPWR.n274 VGND 0.00219f $ **FLOATING
C244 VPWR.n275 VGND 0.00219f $ **FLOATING
C245 VPWR.n276 VGND 0.00219f $ **FLOATING
C246 VPWR.n277 VGND 0.00219f $ **FLOATING
C247 VPWR.n278 VGND 0.00219f $ **FLOATING
C248 VPWR.n279 VGND 0.00219f $ **FLOATING
C249 VPWR.n280 VGND 0.00219f $ **FLOATING
C250 VPWR.n281 VGND 0.00219f $ **FLOATING
C251 VPWR.n282 VGND 0.00219f $ **FLOATING
C252 VPWR.n283 VGND 0.00219f $ **FLOATING
C253 VPWR.n284 VGND 0.00219f $ **FLOATING
C254 VPWR.n285 VGND 0.00219f $ **FLOATING
C255 VPWR.n286 VGND 0.00219f $ **FLOATING
C256 VPWR.n287 VGND 0.00219f $ **FLOATING
C257 VPWR.n288 VGND 0.00219f $ **FLOATING
C258 VPWR.n289 VGND 0.00219f $ **FLOATING
C259 VPWR.n290 VGND 0.00219f $ **FLOATING
C260 VPWR.n291 VGND 0.00219f $ **FLOATING
C261 VPWR.n292 VGND 0.00219f $ **FLOATING
C262 VPWR.n293 VGND 0.00219f $ **FLOATING
C263 VPWR.n294 VGND 0.00219f $ **FLOATING
C264 VPWR.n295 VGND 0.00219f $ **FLOATING
C265 VPWR.n296 VGND 0.00219f $ **FLOATING
C266 VPWR.n297 VGND 0.00219f $ **FLOATING
C267 VPWR.n298 VGND 0.00219f $ **FLOATING
C268 VPWR.n299 VGND 0.00219f $ **FLOATING
C269 VPWR.n300 VGND 0.00219f $ **FLOATING
C270 VPWR.n301 VGND 0.00219f $ **FLOATING
C271 VPWR.n302 VGND 0.00219f $ **FLOATING
C272 VPWR.n303 VGND 0.00219f $ **FLOATING
C273 VPWR.n304 VGND 0.00219f $ **FLOATING
C274 VPWR.n305 VGND 0.00219f $ **FLOATING
C275 VPWR.n306 VGND 0.00219f $ **FLOATING
C276 VPWR.n307 VGND 0.00219f $ **FLOATING
C277 VPWR.n308 VGND 0.00219f $ **FLOATING
C278 VPWR.n309 VGND 0.00219f $ **FLOATING
C279 VPWR.n310 VGND 0.00219f $ **FLOATING
C280 VPWR.n311 VGND 0.00219f $ **FLOATING
C281 VPWR.n312 VGND 0.00219f $ **FLOATING
C282 VPWR.n313 VGND 0.00219f $ **FLOATING
C283 VPWR.n314 VGND 0.00219f $ **FLOATING
C284 VPWR.n315 VGND 0.00219f $ **FLOATING
C285 VPWR.n316 VGND 0.00219f $ **FLOATING
C286 VPWR.n317 VGND 0.00219f $ **FLOATING
C287 VPWR.n318 VGND 0.00219f $ **FLOATING
C288 VPWR.n319 VGND 0.00219f $ **FLOATING
C289 VPWR.n320 VGND 0.44868f $ **FLOATING
C290 VPWR.n322 VGND 0.00485f $ **FLOATING
C291 VPWR.n323 VGND 0.00485f $ **FLOATING
C292 VPWR.n324 VGND 0.00486f $ **FLOATING
C293 VPWR.n325 VGND 0.00219f $ **FLOATING
C294 VPWR.n326 VGND 0.00219f $ **FLOATING
C295 VPWR.n327 VGND 0.28648f $ **FLOATING
C296 VPWR.n328 VGND 0.00219f $ **FLOATING
C297 VPWR.n329 VGND 0.00219f $ **FLOATING
C298 VPWR.n330 VGND 0.21019f $ **FLOATING
C299 VPWR.n331 VGND 0.01013f $ **FLOATING
C300 VPWR.t3 VGND 0.01233f $ **FLOATING
C301 VPWR.n332 VGND 0.01029f $ **FLOATING
C302 VPWR.n333 VGND 0.59065f $ **FLOATING
C303 VPWR.n334 VGND 0.17885f $ **FLOATING
C304 VPWR.n335 VGND 0.00219f $ **FLOATING
C305 VPWR.n336 VGND 0.00219f $ **FLOATING
C306 VPWR.n337 VGND 0.00486f $ **FLOATING
C307 VPWR.n338 VGND 0.00486f $ **FLOATING
C308 VPWR.t0 VGND 0.28648f $ **FLOATING
C309 VPWR.n339 VGND 0.36863f $ **FLOATING
C310 VPWR.n340 VGND 0.00219f $ **FLOATING
C311 VPWR.n341 VGND 0.00486f $ **FLOATING
C312 VPWR.n342 VGND 0.00486f $ **FLOATING
C313 VPWR.n343 VGND 0.00486f $ **FLOATING
C314 VPWR.n344 VGND 0.36863f $ **FLOATING
C315 VPWR.n345 VGND 0.00485f $ **FLOATING
C316 VPWR.n346 VGND 0.00219f $ **FLOATING
C317 VPWR.n347 VGND 0.00219f $ **FLOATING
C318 VPWR.n376 VGND 0.00219f $ **FLOATING
C319 VPWR.n377 VGND 0.00485f $ **FLOATING
C320 VPWR.n378 VGND 0.00485f $ **FLOATING
C321 VPWR.n379 VGND 0.00219f $ **FLOATING
C322 VPWR.n380 VGND 0.00219f $ **FLOATING
C323 VPWR.n381 VGND 0.00219f $ **FLOATING
C324 VPWR.n382 VGND 0.00219f $ **FLOATING
C325 VPWR.n383 VGND 0.00219f $ **FLOATING
C326 VPWR.n384 VGND 0.00219f $ **FLOATING
C327 VPWR.n385 VGND 0.00219f $ **FLOATING
C328 VPWR.n386 VGND 0.00219f $ **FLOATING
C329 VPWR.n387 VGND 0.00219f $ **FLOATING
C330 VPWR.n388 VGND 0.00219f $ **FLOATING
C331 VPWR.n389 VGND 0.00219f $ **FLOATING
C332 VPWR.n390 VGND 0.00219f $ **FLOATING
C333 VPWR.n391 VGND 0.00219f $ **FLOATING
C334 VPWR.n392 VGND 0.00219f $ **FLOATING
C335 VPWR.n393 VGND 0.00219f $ **FLOATING
C336 VPWR.n394 VGND 0.00219f $ **FLOATING
C337 VPWR.n395 VGND 0.00219f $ **FLOATING
C338 VPWR.n396 VGND 0.00219f $ **FLOATING
C339 VPWR.n397 VGND 0.00219f $ **FLOATING
C340 VPWR.n398 VGND 0.00219f $ **FLOATING
C341 VPWR.n399 VGND 0.00219f $ **FLOATING
C342 VPWR.n400 VGND 0.00219f $ **FLOATING
C343 VPWR.n401 VGND 0.00219f $ **FLOATING
C344 VPWR.n402 VGND 0.00219f $ **FLOATING
C345 VPWR.n403 VGND 0.00219f $ **FLOATING
C346 VPWR.n404 VGND 0.00219f $ **FLOATING
C347 VPWR.n405 VGND 0.00219f $ **FLOATING
C348 VPWR.n406 VGND 0.00219f $ **FLOATING
C349 VPWR.n407 VGND 0.00219f $ **FLOATING
C350 VPWR.n408 VGND 0.00219f $ **FLOATING
C351 VPWR.n409 VGND 0.00219f $ **FLOATING
C352 VPWR.n410 VGND 0.00219f $ **FLOATING
C353 VPWR.n411 VGND 0.00219f $ **FLOATING
C354 VPWR.n412 VGND 0.00219f $ **FLOATING
C355 VPWR.n413 VGND 0.00219f $ **FLOATING
C356 VPWR.n414 VGND 0.00219f $ **FLOATING
C357 VPWR.n415 VGND 0.00219f $ **FLOATING
C358 VPWR.n416 VGND 0.00219f $ **FLOATING
C359 VPWR.n417 VGND 0.00219f $ **FLOATING
C360 VPWR.n418 VGND 0.00219f $ **FLOATING
C361 VPWR.n419 VGND 0.00219f $ **FLOATING
C362 VPWR.n420 VGND 0.00219f $ **FLOATING
C363 VPWR.n421 VGND 0.00219f $ **FLOATING
C364 VPWR.n422 VGND 0.00219f $ **FLOATING
C365 VPWR.n423 VGND 0.00219f $ **FLOATING
C366 VPWR.n424 VGND 0.00219f $ **FLOATING
C367 VPWR.n425 VGND 0.00219f $ **FLOATING
C368 VPWR.n426 VGND 0.00219f $ **FLOATING
C369 VPWR.n427 VGND 0.00219f $ **FLOATING
C370 VPWR.n428 VGND 0.00219f $ **FLOATING
C371 VPWR.n429 VGND 0.00219f $ **FLOATING
C372 VPWR.n430 VGND 0.00219f $ **FLOATING
C373 VPWR.n431 VGND 0.00219f $ **FLOATING
C374 VPWR.n432 VGND 0.00219f $ **FLOATING
C375 VPWR.n433 VGND 0.00219f $ **FLOATING
C376 VPWR.n434 VGND 0.00219f $ **FLOATING
C377 VPWR.n435 VGND 0.00219f $ **FLOATING
C378 VPWR.n436 VGND 0.00219f $ **FLOATING
C379 VPWR.n437 VGND 0.00219f $ **FLOATING
C380 VPWR.n438 VGND 0.00219f $ **FLOATING
C381 VPWR.n439 VGND 0.00219f $ **FLOATING
C382 VPWR.n440 VGND 0.00219f $ **FLOATING
C383 VPWR.n441 VGND 0.00219f $ **FLOATING
C384 VPWR.n442 VGND 0.00219f $ **FLOATING
C385 VPWR.n443 VGND 0.00219f $ **FLOATING
C386 VPWR.n444 VGND 0.00219f $ **FLOATING
C387 VPWR.n445 VGND 0.00219f $ **FLOATING
C388 VPWR.n446 VGND 0.00219f $ **FLOATING
C389 VPWR.n447 VGND 0.00219f $ **FLOATING
C390 VPWR.n448 VGND 0.00219f $ **FLOATING
C391 VPWR.n449 VGND 0.00219f $ **FLOATING
C392 VPWR.n450 VGND 0.00219f $ **FLOATING
C393 VPWR.n451 VGND 0.00219f $ **FLOATING
C394 VPWR.n452 VGND 0.00219f $ **FLOATING
C395 VPWR.n453 VGND 0.00219f $ **FLOATING
C396 VPWR.n454 VGND 0.00219f $ **FLOATING
C397 VPWR.n455 VGND 0.00219f $ **FLOATING
C398 VPWR.n456 VGND 0.00219f $ **FLOATING
C399 VPWR.n457 VGND 0.00219f $ **FLOATING
C400 VPWR.n458 VGND 0.00219f $ **FLOATING
C401 VPWR.n459 VGND 0.00219f $ **FLOATING
C402 VPWR.n460 VGND 0.00219f $ **FLOATING
C403 VPWR.n461 VGND 0.00219f $ **FLOATING
C404 VPWR.n462 VGND 0.00219f $ **FLOATING
C405 VPWR.n463 VGND 0.00219f $ **FLOATING
C406 VPWR.n464 VGND 0.00219f $ **FLOATING
C407 VPWR.n465 VGND 0.00219f $ **FLOATING
C408 VPWR.n466 VGND 0.00219f $ **FLOATING
C409 VPWR.n467 VGND 0.00219f $ **FLOATING
C410 VPWR.n468 VGND 0.00219f $ **FLOATING
C411 VPWR.n469 VGND 0.00219f $ **FLOATING
C412 VPWR.n470 VGND 0.00219f $ **FLOATING
C413 VPWR.n471 VGND 0.00219f $ **FLOATING
C414 VPWR.n472 VGND 0.00219f $ **FLOATING
C415 VPWR.n473 VGND 0.00219f $ **FLOATING
C416 VPWR.n474 VGND 0.00219f $ **FLOATING
C417 VPWR.n475 VGND 0.00219f $ **FLOATING
C418 VPWR.n476 VGND 0.00219f $ **FLOATING
C419 VPWR.n477 VGND 0.00219f $ **FLOATING
C420 VPWR.n478 VGND 0.00219f $ **FLOATING
C421 VPWR.n479 VGND 0.00219f $ **FLOATING
C422 VPWR.n480 VGND 0.00219f $ **FLOATING
C423 VPWR.n481 VGND 0.00219f $ **FLOATING
C424 VPWR.n482 VGND 0.00219f $ **FLOATING
C425 VPWR.n483 VGND 0.00219f $ **FLOATING
C426 VPWR.n484 VGND 0.00219f $ **FLOATING
C427 VPWR.n485 VGND 0.00219f $ **FLOATING
C428 VPWR.n486 VGND 0.00219f $ **FLOATING
C429 VPWR.n487 VGND 0.00219f $ **FLOATING
C430 VPWR.n488 VGND 0.00219f $ **FLOATING
C431 VPWR.n489 VGND 0.00219f $ **FLOATING
C432 VPWR.n490 VGND 0.00219f $ **FLOATING
C433 VPWR.n491 VGND 0.00219f $ **FLOATING
C434 VPWR.n493 VGND 0.44868f $ **FLOATING
C435 VPWR.n495 VGND 0.00219f $ **FLOATING
C436 VPWR.n496 VGND 0.00219f $ **FLOATING
C437 VPWR.n497 VGND 0.00485f $ **FLOATING
C438 VPWR.n498 VGND 0.00486f $ **FLOATING
C439 VPWR.n499 VGND 0.00486f $ **FLOATING
C440 VPWR.n500 VGND 0.00219f $ **FLOATING
C441 VPWR.n501 VGND 0.28648f $ **FLOATING
C442 VPWR.n502 VGND 0.00219f $ **FLOATING
C443 VPWR.n503 VGND 0.00219f $ **FLOATING
C444 VPWR.n504 VGND 0.00219f $ **FLOATING
C445 VPWR.n505 VGND 0.00219f $ **FLOATING
C446 VPWR.n506 VGND 0.00219f $ **FLOATING
C447 VPWR.n536 VGND 0.00219f $ **FLOATING
C448 VPWR.n537 VGND 0.00485f $ **FLOATING
C449 VPWR.n538 VGND 0.00485f $ **FLOATING
C450 VPWR.n539 VGND 0.00219f $ **FLOATING
C451 VPWR.n540 VGND 0.00219f $ **FLOATING
C452 VPWR.n541 VGND 0.00219f $ **FLOATING
C453 VPWR.n542 VGND 0.00219f $ **FLOATING
C454 VPWR.n543 VGND 0.00219f $ **FLOATING
C455 VPWR.n544 VGND 0.00219f $ **FLOATING
C456 VPWR.n545 VGND 0.00219f $ **FLOATING
C457 VPWR.n546 VGND 0.00219f $ **FLOATING
C458 VPWR.n547 VGND 0.00219f $ **FLOATING
C459 VPWR.n548 VGND 0.00219f $ **FLOATING
C460 VPWR.n549 VGND 0.00219f $ **FLOATING
C461 VPWR.n550 VGND 0.00219f $ **FLOATING
C462 VPWR.n551 VGND 0.00219f $ **FLOATING
C463 VPWR.n552 VGND 0.00219f $ **FLOATING
C464 VPWR.n553 VGND 0.00219f $ **FLOATING
C465 VPWR.n554 VGND 0.00219f $ **FLOATING
C466 VPWR.n555 VGND 0.00219f $ **FLOATING
C467 VPWR.n556 VGND 0.00219f $ **FLOATING
C468 VPWR.n557 VGND 0.00219f $ **FLOATING
C469 VPWR.n558 VGND 0.00219f $ **FLOATING
C470 VPWR.n559 VGND 0.00219f $ **FLOATING
C471 VPWR.n560 VGND 0.00219f $ **FLOATING
C472 VPWR.n561 VGND 0.00219f $ **FLOATING
C473 VPWR.n562 VGND 0.00219f $ **FLOATING
C474 VPWR.n563 VGND 0.00219f $ **FLOATING
C475 VPWR.n564 VGND 0.00219f $ **FLOATING
C476 VPWR.n565 VGND 0.00219f $ **FLOATING
C477 VPWR.n566 VGND 0.00219f $ **FLOATING
C478 VPWR.n567 VGND 0.00219f $ **FLOATING
C479 VPWR.n568 VGND 0.00219f $ **FLOATING
C480 VPWR.n569 VGND 0.00219f $ **FLOATING
C481 VPWR.n570 VGND 0.00219f $ **FLOATING
C482 VPWR.n571 VGND 0.00219f $ **FLOATING
C483 VPWR.n572 VGND 0.00219f $ **FLOATING
C484 VPWR.n573 VGND 0.00219f $ **FLOATING
C485 VPWR.n574 VGND 0.00219f $ **FLOATING
C486 VPWR.n575 VGND 0.00219f $ **FLOATING
C487 VPWR.n576 VGND 0.00219f $ **FLOATING
C488 VPWR.n577 VGND 0.00219f $ **FLOATING
C489 VPWR.n578 VGND 0.00219f $ **FLOATING
C490 VPWR.n579 VGND 0.00219f $ **FLOATING
C491 VPWR.n580 VGND 0.00219f $ **FLOATING
C492 VPWR.n581 VGND 0.00219f $ **FLOATING
C493 VPWR.n582 VGND 0.00219f $ **FLOATING
C494 VPWR.n583 VGND 0.00219f $ **FLOATING
C495 VPWR.n584 VGND 0.00219f $ **FLOATING
C496 VPWR.n585 VGND 0.00219f $ **FLOATING
C497 VPWR.n586 VGND 0.00219f $ **FLOATING
C498 VPWR.n587 VGND 0.00219f $ **FLOATING
C499 VPWR.n588 VGND 0.00219f $ **FLOATING
C500 VPWR.n589 VGND 0.00219f $ **FLOATING
C501 VPWR.n590 VGND 0.00219f $ **FLOATING
C502 VPWR.n591 VGND 0.00219f $ **FLOATING
C503 VPWR.n592 VGND 0.00219f $ **FLOATING
C504 VPWR.n593 VGND 0.00219f $ **FLOATING
C505 VPWR.n594 VGND 0.00219f $ **FLOATING
C506 VPWR.n595 VGND 0.00219f $ **FLOATING
C507 VPWR.n596 VGND 0.00219f $ **FLOATING
C508 VPWR.n597 VGND 0.00219f $ **FLOATING
C509 VPWR.n598 VGND 0.00219f $ **FLOATING
C510 VPWR.n599 VGND 0.00219f $ **FLOATING
C511 VPWR.n600 VGND 0.00219f $ **FLOATING
C512 VPWR.n601 VGND 0.00219f $ **FLOATING
C513 VPWR.n602 VGND 0.00219f $ **FLOATING
C514 VPWR.n603 VGND 0.00219f $ **FLOATING
C515 VPWR.n604 VGND 0.00219f $ **FLOATING
C516 VPWR.n605 VGND 0.00219f $ **FLOATING
C517 VPWR.n606 VGND 0.00219f $ **FLOATING
C518 VPWR.n607 VGND 0.00219f $ **FLOATING
C519 VPWR.n608 VGND 0.00219f $ **FLOATING
C520 VPWR.n609 VGND 0.00219f $ **FLOATING
C521 VPWR.n610 VGND 0.00219f $ **FLOATING
C522 VPWR.n611 VGND 0.00219f $ **FLOATING
C523 VPWR.n612 VGND 0.00219f $ **FLOATING
C524 VPWR.n613 VGND 0.00219f $ **FLOATING
C525 VPWR.n614 VGND 0.00219f $ **FLOATING
C526 VPWR.n615 VGND 0.00219f $ **FLOATING
C527 VPWR.n616 VGND 0.00219f $ **FLOATING
C528 VPWR.n617 VGND 0.00219f $ **FLOATING
C529 VPWR.n618 VGND 0.00219f $ **FLOATING
C530 VPWR.n619 VGND 0.00219f $ **FLOATING
C531 VPWR.n620 VGND 0.00219f $ **FLOATING
C532 VPWR.n621 VGND 0.00219f $ **FLOATING
C533 VPWR.n622 VGND 0.00219f $ **FLOATING
C534 VPWR.n623 VGND 0.00219f $ **FLOATING
C535 VPWR.n624 VGND 0.00219f $ **FLOATING
C536 VPWR.n625 VGND 0.00219f $ **FLOATING
C537 VPWR.n626 VGND 0.00219f $ **FLOATING
C538 VPWR.n627 VGND 0.00219f $ **FLOATING
C539 VPWR.n628 VGND 0.00219f $ **FLOATING
C540 VPWR.n629 VGND 0.00219f $ **FLOATING
C541 VPWR.n630 VGND 0.00219f $ **FLOATING
C542 VPWR.n631 VGND 0.00219f $ **FLOATING
C543 VPWR.n632 VGND 0.00219f $ **FLOATING
C544 VPWR.n633 VGND 0.00219f $ **FLOATING
C545 VPWR.n634 VGND 0.00219f $ **FLOATING
C546 VPWR.n635 VGND 0.00219f $ **FLOATING
C547 VPWR.n636 VGND 0.00219f $ **FLOATING
C548 VPWR.n637 VGND 0.00219f $ **FLOATING
C549 VPWR.n638 VGND 0.00219f $ **FLOATING
C550 VPWR.n639 VGND 0.00219f $ **FLOATING
C551 VPWR.n640 VGND 0.00219f $ **FLOATING
C552 VPWR.n641 VGND 0.00219f $ **FLOATING
C553 VPWR.n642 VGND 0.00219f $ **FLOATING
C554 VPWR.n643 VGND 0.00219f $ **FLOATING
C555 VPWR.n644 VGND 0.00219f $ **FLOATING
C556 VPWR.n645 VGND 0.00219f $ **FLOATING
C557 VPWR.n646 VGND 0.00219f $ **FLOATING
C558 VPWR.n647 VGND 0.00219f $ **FLOATING
C559 VPWR.n648 VGND 0.00219f $ **FLOATING
C560 VPWR.n649 VGND 0.00219f $ **FLOATING
C561 VPWR.n650 VGND 0.00219f $ **FLOATING
C562 VPWR.n651 VGND 0.00219f $ **FLOATING
C563 VPWR.n652 VGND 0.00219f $ **FLOATING
C564 VPWR.n653 VGND 0.00219f $ **FLOATING
C565 VPWR.n654 VGND 0.44868f $ **FLOATING
C566 VPWR.n656 VGND 0.00485f $ **FLOATING
C567 VPWR.n657 VGND 0.00485f $ **FLOATING
C568 VPWR.n658 VGND 0.00486f $ **FLOATING
C569 VPWR.n659 VGND 0.00219f $ **FLOATING
C570 VPWR.n660 VGND 0.00219f $ **FLOATING
C571 VPWR.n661 VGND 0.28648f $ **FLOATING
C572 VPWR.n662 VGND 0.00219f $ **FLOATING
C573 VPWR.n663 VGND 0.00219f $ **FLOATING
C574 VPWR.n664 VGND 0.24481f $ **FLOATING
C575 VPWR.n665 VGND 0.59188f $ **FLOATING
C576 VPWR.t1 VGND 0.01233f $ **FLOATING
C577 VPWR.n666 VGND 0.01013f $ **FLOATING
C578 OUT.n0 VGND 0.0181f $ **FLOATING
C579 OUT.n1 VGND 0.00882f $ **FLOATING
C580 OUT.t0 VGND 0.04841f $ **FLOATING
C581 OUT.n2 VGND 0.16512f $ **FLOATING
C582 OUT.n3 VGND 0.02914f $ **FLOATING
C583 OUT.n4 VGND 0.39037f $ **FLOATING
C584 OUT.n5 VGND 1.02397f $ **FLOATING
C585 OUT.n6 VGND 1.13702f $ **FLOATING
C586 OUT.t1 VGND 0.02168f $ **FLOATING
C587 OUT.n7 VGND 0.01782f $ **FLOATING
C588 BIAS.t0 VGND 0.26292f $ **FLOATING
C589 TAIL.n0 VGND 0.0218f $ **FLOATING
C590 TAIL.n1 VGND 0.00708f $ **FLOATING
C591 TAIL.t1 VGND 0.01153f $ **FLOATING
C592 TAIL.n2 VGND 0.00682f $ **FLOATING
C593 TAIL.n3 VGND 0.26003f $ **FLOATING
C594 TAIL.n4 VGND 0.0066f $ **FLOATING
C595 TAIL.t2 VGND 0.03622f $ **FLOATING
C596 TAIL.n5 VGND 0.12356f $ **FLOATING
C597 TAIL.n6 VGND 0.0218f $ **FLOATING
C598 TAIL.n7 VGND 0.31243f $ **FLOATING
C599 TAIL.n8 VGND 1.08581f $ **FLOATING
C600 TAIL.n9 VGND 0.32825f $ **FLOATING
C601 TAIL.t0 VGND 0.03622f $ **FLOATING
C602 TAIL.n10 VGND 0.12356f $ **FLOATING
C603 TAIL.n11 VGND 0.0066f $ **FLOATING
C604 MIR.n0 VGND 0.01709f $ **FLOATING
C605 MIR.t1 VGND 0.02047f $ **FLOATING
C606 MIR.t3 VGND 1.04143f $ **FLOATING
C607 MIR.t0 VGND 1.04143f $ **FLOATING
C608 MIR.n1 VGND 0.43357f $ **FLOATING
C609 MIR.n2 VGND 0.00833f $ **FLOATING
C610 MIR.t2 VGND 0.0457f $ **FLOATING
C611 MIR.n3 VGND 0.1559f $ **FLOATING
C612 MIR.n4 VGND 0.02751f $ **FLOATING
C613 MIR.n5 VGND 0.36186f $ **FLOATING
C614 MIR.n6 VGND 0.59176f $ **FLOATING
C615 MIR.n7 VGND 0.96255f $ **FLOATING
C616 MIR.n8 VGND 0.01682f $ **FLOATING
rmesh_equiv_0 bias bias.t0 139.911
rmesh_equiv_1 inn inn.t0 332.71199999999999
rmesh_equiv_10 mir.n0 mir.n7 11.4361
rmesh_equiv_100 vgnd.n396 vgnd.t1 1702.1973738927065
rmesh_equiv_1000 vpwr.n579 vpwr.n582 25.6005
rmesh_equiv_1001 vpwr.n58 vpwr.n59 240
rmesh_equiv_1002 vpwr.n580 vpwr.n581 240
rmesh_equiv_1003 vpwr.n580 vpwr.n654 185.00310000000002
rmesh_equiv_1004 vpwr.n581 vpwr.n582 185
rmesh_equiv_1005 vpwr.n581 vpwr.n584 240.00290767186621
rmesh_equiv_1006 vpwr.n581 vpwr.n654 185.00310000000002
rmesh_equiv_1007 vpwr.n582 vpwr.n583 25.6005
rmesh_equiv_1008 vpwr.n583 vpwr.n584 185
rmesh_equiv_1009 vpwr.n583 vpwr.n586 25.6005
rmesh_equiv_101 vgnd.n396 vgnd.t3 22070.03472060565
rmesh_equiv_1010 vpwr.n584 vpwr.n585 240
rmesh_equiv_1011 vpwr.n584 vpwr.n654 185.00310000000002
rmesh_equiv_1012 vpwr.n585 vpwr.n586 185
rmesh_equiv_1013 vpwr.n585 vpwr.n588 240.00290767186621
rmesh_equiv_1014 vpwr.n585 vpwr.n654 185.00310000000002
rmesh_equiv_1015 vpwr.n586 vpwr.n587 25.6005
rmesh_equiv_1016 vpwr.n587 vpwr.n588 185
rmesh_equiv_1017 vpwr.n587 vpwr.n590 25.6005
rmesh_equiv_1018 vpwr.n588 vpwr.n589 240
rmesh_equiv_1019 vpwr.n588 vpwr.n654 185.00310000000002
rmesh_equiv_102 vgnd.n417 vgnd.n422 7064.3763274988114
rmesh_equiv_1020 vpwr.n589 vpwr.n590 185
rmesh_equiv_1021 vpwr.n589 vpwr.n592 240.00290767186621
rmesh_equiv_1022 vpwr.n589 vpwr.n654 185.00310000000002
rmesh_equiv_1023 vpwr.n59 vpwr.n60 185
rmesh_equiv_1024 vpwr.n59 vpwr.n62 240.00290767186621
rmesh_equiv_1025 vpwr.n590 vpwr.n591 25.6005
rmesh_equiv_1026 vpwr.n591 vpwr.n592 185
rmesh_equiv_1027 vpwr.n591 vpwr.n594 25.6005
rmesh_equiv_1028 vpwr.n592 vpwr.n593 240
rmesh_equiv_1029 vpwr.n592 vpwr.n654 185.00310000000002
rmesh_equiv_103 vgnd.n417 vgnd.n423 606.3003310133729
rmesh_equiv_1030 vpwr.n593 vpwr.n594 185
rmesh_equiv_1031 vpwr.n593 vpwr.n596 240.00290767186621
rmesh_equiv_1032 vpwr.n593 vpwr.n654 185.00310000000002
rmesh_equiv_1033 vpwr.n594 vpwr.n595 25.6005
rmesh_equiv_1034 vpwr.n595 vpwr.n596 185
rmesh_equiv_1035 vpwr.n595 vpwr.n598 25.6005
rmesh_equiv_1036 vpwr.n596 vpwr.n597 240
rmesh_equiv_1037 vpwr.n596 vpwr.n654 185.00310000000002
rmesh_equiv_1038 vpwr.n597 vpwr.n598 185
rmesh_equiv_1039 vpwr.n597 vpwr.n600 240.00290767186621
rmesh_equiv_104 vgnd.n417 vgnd.n431 7488.437044687571
rmesh_equiv_1040 vpwr.n597 vpwr.n654 185.00310000000002
rmesh_equiv_1041 vpwr.n598 vpwr.n599 25.6005
rmesh_equiv_1042 vpwr.n599 vpwr.n600 185
rmesh_equiv_1043 vpwr.n599 vpwr.n602 25.6005
rmesh_equiv_1044 vpwr.n6 vpwr.t2 185
rmesh_equiv_1045 vpwr.n60 vpwr.n61 25.6005
rmesh_equiv_1046 vpwr.n600 vpwr.n601 240
rmesh_equiv_1047 vpwr.n600 vpwr.n654 185.00310000000002
rmesh_equiv_1048 vpwr.n601 vpwr.n602 185
rmesh_equiv_1049 vpwr.n601 vpwr.n604 240.00290767186621
rmesh_equiv_105 vgnd.n417 vgnd.n434 144.39747480608403
rmesh_equiv_1050 vpwr.n601 vpwr.n654 185.00310000000002
rmesh_equiv_1051 vpwr.n602 vpwr.n603 25.6005
rmesh_equiv_1052 vpwr.n603 vpwr.n604 185
rmesh_equiv_1053 vpwr.n603 vpwr.n606 25.6005
rmesh_equiv_1054 vpwr.n604 vpwr.n605 240
rmesh_equiv_1055 vpwr.n604 vpwr.n654 185.00310000000002
rmesh_equiv_1056 vpwr.n605 vpwr.n606 185
rmesh_equiv_1057 vpwr.n605 vpwr.n608 240.00290767186621
rmesh_equiv_1058 vpwr.n605 vpwr.n654 185.00310000000002
rmesh_equiv_1059 vpwr.n606 vpwr.n607 25.6005
rmesh_equiv_106 vgnd.n417 vgnd.n8 5043.4943514647921
rmesh_equiv_1060 vpwr.n607 vpwr.n608 185
rmesh_equiv_1061 vpwr.n607 vpwr.n610 25.6005
rmesh_equiv_1062 vpwr.n608 vpwr.n609 240
rmesh_equiv_1063 vpwr.n608 vpwr.n654 185.00310000000002
rmesh_equiv_1064 vpwr.n609 vpwr.n610 185
rmesh_equiv_1065 vpwr.n609 vpwr.n612 240.00290767186621
rmesh_equiv_1066 vpwr.n609 vpwr.n654 185.00310000000002
rmesh_equiv_1067 vpwr.n61 vpwr.n62 185
rmesh_equiv_1068 vpwr.n61 vpwr.n64 25.6005
rmesh_equiv_1069 vpwr.n610 vpwr.n611 25.6005
rmesh_equiv_107 vgnd.n417 vgnd.t1 1497.143977170376
rmesh_equiv_1070 vpwr.n611 vpwr.n612 185
rmesh_equiv_1071 vpwr.n611 vpwr.n614 25.6005
rmesh_equiv_1072 vpwr.n612 vpwr.n613 240
rmesh_equiv_1073 vpwr.n612 vpwr.n654 185.00310000000002
rmesh_equiv_1074 vpwr.n613 vpwr.n614 185
rmesh_equiv_1075 vpwr.n613 vpwr.n616 240.00290767186621
rmesh_equiv_1076 vpwr.n613 vpwr.n654 185.00310000000002
rmesh_equiv_1077 vpwr.n614 vpwr.n615 25.6005
rmesh_equiv_1078 vpwr.n615 vpwr.n616 185
rmesh_equiv_1079 vpwr.n615 vpwr.n618 25.6005
rmesh_equiv_108 vgnd.n422 vgnd.n423 363.19219365569234
rmesh_equiv_1080 vpwr.n616 vpwr.n617 240
rmesh_equiv_1081 vpwr.n616 vpwr.n654 185.00310000000002
rmesh_equiv_1082 vpwr.n617 vpwr.n618 185
rmesh_equiv_1083 vpwr.n617 vpwr.n620 240.00290767186621
rmesh_equiv_1084 vpwr.n617 vpwr.n654 185.00310000000002
rmesh_equiv_1085 vpwr.n618 vpwr.n619 25.6005
rmesh_equiv_1086 vpwr.n619 vpwr.n620 185
rmesh_equiv_1087 vpwr.n619 vpwr.n622 25.6005
rmesh_equiv_1088 vpwr.n62 vpwr.n63 240
rmesh_equiv_1089 vpwr.n620 vpwr.n621 240
rmesh_equiv_109 vgnd.n422 vgnd.n429 2252.0649625306792
rmesh_equiv_1090 vpwr.n620 vpwr.n654 185.00310000000002
rmesh_equiv_1091 vpwr.n621 vpwr.n622 185
rmesh_equiv_1092 vpwr.n621 vpwr.n624 240.00290767186621
rmesh_equiv_1093 vpwr.n621 vpwr.n654 185.00310000000002
rmesh_equiv_1094 vpwr.n622 vpwr.n623 25.6005
rmesh_equiv_1095 vpwr.n623 vpwr.n624 185
rmesh_equiv_1096 vpwr.n623 vpwr.n626 25.6005
rmesh_equiv_1097 vpwr.n624 vpwr.n625 240
rmesh_equiv_1098 vpwr.n624 vpwr.n654 185.00310000000002
rmesh_equiv_1099 vpwr.n625 vpwr.n626 185
rmesh_equiv_11 mir.n0 mir.t1 381.113
rmesh_equiv_110 vgnd.n422 vgnd.n431 5823.1414974461768
rmesh_equiv_1100 vpwr.n625 vpwr.n628 240.00290767186621
rmesh_equiv_1101 vpwr.n625 vpwr.n654 185.00310000000002
rmesh_equiv_1102 vpwr.n626 vpwr.n627 25.6005
rmesh_equiv_1103 vpwr.n627 vpwr.n628 185
rmesh_equiv_1104 vpwr.n627 vpwr.n630 25.6005
rmesh_equiv_1105 vpwr.n628 vpwr.n629 240
rmesh_equiv_1106 vpwr.n628 vpwr.n654 185.00310000000002
rmesh_equiv_1107 vpwr.n629 vpwr.n630 185
rmesh_equiv_1108 vpwr.n629 vpwr.n632 240.00290767186621
rmesh_equiv_1109 vpwr.n629 vpwr.n654 185.00310000000002
rmesh_equiv_111 vgnd.n422 vgnd.n434 52001.154181945654
rmesh_equiv_1110 vpwr.n63 vpwr.n64 185
rmesh_equiv_1111 vpwr.n63 vpwr.n66 240.00290767186621
rmesh_equiv_1112 vpwr.n630 vpwr.n631 25.6005
rmesh_equiv_1113 vpwr.n631 vpwr.n632 185
rmesh_equiv_1114 vpwr.n631 vpwr.n634 25.6005
rmesh_equiv_1115 vpwr.n632 vpwr.n633 240
rmesh_equiv_1116 vpwr.n632 vpwr.n654 185.00310000000002
rmesh_equiv_1117 vpwr.n633 vpwr.n634 185
rmesh_equiv_1118 vpwr.n633 vpwr.n636 240.00290767186621
rmesh_equiv_1119 vpwr.n633 vpwr.n654 185.00310000000002
rmesh_equiv_112 vgnd.n422 vgnd.n8 199009.67917733258
rmesh_equiv_1120 vpwr.n634 vpwr.n635 25.6005
rmesh_equiv_1121 vpwr.n635 vpwr.n636 185
rmesh_equiv_1122 vpwr.n635 vpwr.n638 25.6005
rmesh_equiv_1123 vpwr.n636 vpwr.n637 240
rmesh_equiv_1124 vpwr.n636 vpwr.n654 185.00310000000002
rmesh_equiv_1125 vpwr.n637 vpwr.n638 185
rmesh_equiv_1126 vpwr.n637 vpwr.n640 240.00290767186621
rmesh_equiv_1127 vpwr.n637 vpwr.n654 185.00310000000002
rmesh_equiv_1128 vpwr.n638 vpwr.n639 25.6005
rmesh_equiv_1129 vpwr.n639 vpwr.n640 185
rmesh_equiv_113 vgnd.n422 vgnd.t1 678.80620441491476
rmesh_equiv_1130 vpwr.n639 vpwr.n642 25.6005
rmesh_equiv_1131 vpwr.n64 vpwr.n65 25.6005
rmesh_equiv_1132 vpwr.n640 vpwr.n641 240
rmesh_equiv_1133 vpwr.n640 vpwr.n654 185.00310000000002
rmesh_equiv_1134 vpwr.n641 vpwr.n642 185
rmesh_equiv_1135 vpwr.n641 vpwr.n644 240.00290767186621
rmesh_equiv_1136 vpwr.n641 vpwr.n654 185.00310000000002
rmesh_equiv_1137 vpwr.n642 vpwr.n643 25.6005
rmesh_equiv_1138 vpwr.n643 vpwr.n644 185
rmesh_equiv_1139 vpwr.n643 vpwr.n646 25.6005
rmesh_equiv_114 vgnd.n423 vgnd.n429 51.92378332058675
rmesh_equiv_1140 vpwr.n644 vpwr.n645 240
rmesh_equiv_1141 vpwr.n644 vpwr.n654 185.00310000000002
rmesh_equiv_1142 vpwr.n645 vpwr.n646 185
rmesh_equiv_1143 vpwr.n645 vpwr.n648 240.00290767186621
rmesh_equiv_1144 vpwr.n645 vpwr.n654 185.00310000000002
rmesh_equiv_1145 vpwr.n646 vpwr.n647 25.6005
rmesh_equiv_1146 vpwr.n647 vpwr.n648 185
rmesh_equiv_1147 vpwr.n647 vpwr.n650 25.6005
rmesh_equiv_1148 vpwr.n648 vpwr.n649 240
rmesh_equiv_1149 vpwr.n648 vpwr.n654 185.00310000000002
rmesh_equiv_115 vgnd.n423 vgnd.n431 18025.667999668098
rmesh_equiv_1150 vpwr.n649 vpwr.n650 185
rmesh_equiv_1151 vpwr.n649 vpwr.n654 185.00310000000002
rmesh_equiv_1152 vpwr.n65 vpwr.n66 185
rmesh_equiv_1153 vpwr.n65 vpwr.n68 25.6005
rmesh_equiv_1154 vpwr.n650 vpwr.n651 25.6005
rmesh_equiv_1155 vpwr.n651 vpwr.n652 25.6005
rmesh_equiv_1156 vpwr.n652 vpwr.n653 185
rmesh_equiv_1157 vpwr.n653 vpwr.n654 185
rmesh_equiv_1158 vpwr.n654 vpwr.n656 185.00310000000002
rmesh_equiv_1159 vpwr.n656 vpwr.n657 185
rmesh_equiv_116 vgnd.n423 vgnd.t1 1356.4926447355358
rmesh_equiv_1160 vpwr.n657 vpwr.n658 81.318100000000001
rmesh_equiv_1161 vpwr.n658 vpwr.n659 25.6005
rmesh_equiv_1162 vpwr.n659 vpwr.n660 185
rmesh_equiv_1163 vpwr.n66 vpwr.n67 240
rmesh_equiv_1164 vpwr.n660 vpwr.n661 185
rmesh_equiv_1165 vpwr.n661 vpwr.n662 185
rmesh_equiv_1166 vpwr.n661 vpwr.t0 14.556599999999998
rmesh_equiv_1167 vpwr.n662 vpwr.n663 185
rmesh_equiv_1168 vpwr.n664 vpwr.n665 13.7324
rmesh_equiv_1169 vpwr.n665 vpwr.n666 2.4407800000000002
rmesh_equiv_117 vgnd.n429 vgnd.n431 2307.724524257218
rmesh_equiv_1170 vpwr.n666 vpwr.t1 387.11000000000001
rmesh_equiv_1171 vpwr.n67 vpwr.n68 185
rmesh_equiv_1172 vpwr.n67 vpwr.n70 240.00290767186621
rmesh_equiv_1173 vpwr.n68 vpwr.n69 25.6005
rmesh_equiv_1174 vpwr.n69 vpwr.n70 185
rmesh_equiv_1175 vpwr.n69 vpwr.n72 25.6005
rmesh_equiv_1176 vpwr.n70 vpwr.n71 240
rmesh_equiv_1177 vpwr.n71 vpwr.n72 185
rmesh_equiv_1178 vpwr.n71 vpwr.n74 240.00290767186621
rmesh_equiv_1179 vpwr.n72 vpwr.n73 25.6005
rmesh_equiv_118 vgnd.n429 vgnd.n434 237314.33442843962
rmesh_equiv_1180 vpwr.n73 vpwr.n74 185
rmesh_equiv_1181 vpwr.n73 vpwr.n76 25.6005
rmesh_equiv_1182 vpwr.n74 vpwr.n75 240
rmesh_equiv_1183 vpwr.n75 vpwr.n76 185
rmesh_equiv_1184 vpwr.n75 vpwr.n78 240.00290767186621
rmesh_equiv_1185 vpwr.n76 vpwr.n77 25.6005
rmesh_equiv_1186 vpwr.n77 vpwr.n78 185
rmesh_equiv_1187 vpwr.n77 vpwr.n80 25.6005
rmesh_equiv_1188 vpwr.n78 vpwr.n79 240
rmesh_equiv_1189 vpwr.n79 vpwr.n80 185
rmesh_equiv_119 vgnd.n429 vgnd.n7 2899.469733602929
rmesh_equiv_1190 vpwr.n79 vpwr.n82 240.00290767186621
rmesh_equiv_1191 vpwr.n8 vpwr.n9 185
rmesh_equiv_1192 vpwr.n80 vpwr.n81 25.6005
rmesh_equiv_1193 vpwr.n81 vpwr.n82 185
rmesh_equiv_1194 vpwr.n81 vpwr.n84 25.6005
rmesh_equiv_1195 vpwr.n82 vpwr.n83 240
rmesh_equiv_1196 vpwr.n83 vpwr.n84 185
rmesh_equiv_1197 vpwr.n83 vpwr.n86 240.00290767186621
rmesh_equiv_1198 vpwr.n84 vpwr.n85 25.6005
rmesh_equiv_1199 vpwr.n85 vpwr.n86 185
rmesh_equiv_12 mir.n1 mir.n6 0.39353700000000003
rmesh_equiv_120 vgnd.n429 vgnd.n8 412445.84577118082
rmesh_equiv_1200 vpwr.n85 vpwr.n88 25.6005
rmesh_equiv_1201 vpwr.n86 vpwr.n87 240
rmesh_equiv_1202 vpwr.n87 vpwr.n88 185
rmesh_equiv_1203 vpwr.n87 vpwr.n90 240.00290767186621
rmesh_equiv_1204 vpwr.n88 vpwr.n89 25.6005
rmesh_equiv_1205 vpwr.n89 vpwr.n90 185
rmesh_equiv_1206 vpwr.n89 vpwr.n92 25.6005
rmesh_equiv_1207 vpwr.n90 vpwr.n91 240
rmesh_equiv_1208 vpwr.n91 vpwr.n92 185
rmesh_equiv_1209 vpwr.n91 vpwr.n94 240.00290767186621
rmesh_equiv_121 vgnd.n431 vgnd.n434 2659.5852940723689
rmesh_equiv_1210 vpwr.n92 vpwr.n93 25.6005
rmesh_equiv_1211 vpwr.n93 vpwr.n94 185
rmesh_equiv_1212 vpwr.n93 vpwr.n96 25.6005
rmesh_equiv_1213 vpwr.n94 vpwr.n95 240
rmesh_equiv_1214 vpwr.n95 vpwr.n96 185
rmesh_equiv_1215 vpwr.n95 vpwr.n98 240.00290767186621
rmesh_equiv_1216 vpwr.n96 vpwr.n97 25.6005
rmesh_equiv_1217 vpwr.n97 vpwr.n98 185
rmesh_equiv_1218 vpwr.n98 vpwr.n99 240
rmesh_equiv_122 vgnd.n431 vgnd.n7 625.05779240000004
rmesh_equiv_123 vgnd.n431 vgnd.n8 728.77169194796761
rmesh_equiv_124 vgnd.n431 vgnd.t1 42120.146047528156
rmesh_equiv_125 vgnd.n434 vgnd.n7 2326.6040592634731
rmesh_equiv_126 vgnd.n434 vgnd.n8 421.54028733241512
rmesh_equiv_127 vgnd.n434 vgnd.t1 7412.5734132833768
rmesh_equiv_128 vgnd.n7 vgnd.n8 1217.5209931309223
rmesh_equiv_129 vgnd.n7 vgnd.t0 1706734.8825038536
rmesh_equiv_13 mir.n2 mir.n3 13.389300000000002
rmesh_equiv_130 vgnd.n7 vgnd.t3 19760.8787180248
rmesh_equiv_131 vgnd.n8 vgnd.t1 28368.098363634344
rmesh_equiv_132 vgnd.t0 vgnd.t3 2022.6987145013834
rmesh_equiv_133 vpwr vpwr.n0 22.8553
rmesh_equiv_134 vpwr vpwr.n1 25.6005
rmesh_equiv_135 vpwr vpwr.n2 185
rmesh_equiv_136 vpwr vpwr.n329 25.6005
rmesh_equiv_137 vpwr vpwr.n330 2.0088604725843036
rmesh_equiv_138 vpwr vpwr.n331 4.8770699999999998
rmesh_equiv_139 vpwr vpwr.n332 22.8553
rmesh_equiv_14 mir.n2 mir.n5 0.75515399999999999
rmesh_equiv_140 vpwr vpwr.n335 25.6005
rmesh_equiv_141 vpwr vpwr.n336 185
rmesh_equiv_142 vpwr vpwr.n663 25.6005
rmesh_equiv_143 vpwr vpwr.n664 18.864999999999998
rmesh_equiv_144 vpwr vpwr.n666 4.8770699999999998
rmesh_equiv_145 vpwr.n0 vpwr.n665 11.4361
rmesh_equiv_146 vpwr.n0 vpwr.t1 381.113
rmesh_equiv_147 vpwr.n1 vpwr.n164 25.6005
rmesh_equiv_148 vpwr.n1 vpwr.n166 185
rmesh_equiv_149 vpwr.n10 vpwr.n159 22.905000000000001
rmesh_equiv_15 mir.n3 mir.n4 14.121399999999998
rmesh_equiv_150 vpwr.n10 vpwr.n165 185
rmesh_equiv_151 vpwr.n10 vpwr.n167 14.556599999999998
rmesh_equiv_152 vpwr.n10 vpwr.n9 185
rmesh_equiv_153 vpwr.n100 vpwr.n101 25.6005
rmesh_equiv_154 vpwr.n100 vpwr.n97 25.6005
rmesh_equiv_155 vpwr.n100 vpwr.n99 185
rmesh_equiv_156 vpwr.n101 vpwr.n102 185
rmesh_equiv_157 vpwr.n101 vpwr.n104 25.6005
rmesh_equiv_158 vpwr.n102 vpwr.n103 240
rmesh_equiv_159 vpwr.n102 vpwr.n159 185.00310000000002
rmesh_equiv_16 mir.n3 mir.t2 1.7404999999999999
rmesh_equiv_160 vpwr.n102 vpwr.n99 240.00290767186621
rmesh_equiv_161 vpwr.n103 vpwr.n104 185
rmesh_equiv_162 vpwr.n103 vpwr.n106 240.00290767186621
rmesh_equiv_163 vpwr.n103 vpwr.n159 185.00310000000002
rmesh_equiv_164 vpwr.n104 vpwr.n105 25.6005
rmesh_equiv_165 vpwr.n105 vpwr.n106 185
rmesh_equiv_166 vpwr.n105 vpwr.n108 25.6005
rmesh_equiv_167 vpwr.n106 vpwr.n107 240
rmesh_equiv_168 vpwr.n106 vpwr.n159 185.00310000000002
rmesh_equiv_169 vpwr.n107 vpwr.n108 185
rmesh_equiv_17 mir.n4 mir.n5 1.13588
rmesh_equiv_170 vpwr.n107 vpwr.n110 240.00290767186621
rmesh_equiv_171 vpwr.n107 vpwr.n159 185.00310000000002
rmesh_equiv_172 vpwr.n108 vpwr.n109 25.6005
rmesh_equiv_173 vpwr.n109 vpwr.n110 185
rmesh_equiv_174 vpwr.n109 vpwr.n112 25.6005
rmesh_equiv_175 vpwr.n11 vpwr.n159 185
rmesh_equiv_176 vpwr.n11 vpwr.n161 240
rmesh_equiv_177 vpwr.n11 vpwr.n163 185
rmesh_equiv_178 vpwr.n11 vpwr.n165 762.35400000000004
rmesh_equiv_179 vpwr.n110 vpwr.n111 240
rmesh_equiv_18 mir.n5 mir.n6 13.999400000000001
rmesh_equiv_180 vpwr.n110 vpwr.n159 185.00310000000002
rmesh_equiv_181 vpwr.n111 vpwr.n112 185
rmesh_equiv_182 vpwr.n111 vpwr.n114 240.00290767186621
rmesh_equiv_183 vpwr.n111 vpwr.n159 185.00310000000002
rmesh_equiv_184 vpwr.n112 vpwr.n113 25.6005
rmesh_equiv_185 vpwr.n113 vpwr.n114 185
rmesh_equiv_186 vpwr.n113 vpwr.n116 25.6005
rmesh_equiv_187 vpwr.n114 vpwr.n115 240
rmesh_equiv_188 vpwr.n114 vpwr.n159 185.00310000000002
rmesh_equiv_189 vpwr.n115 vpwr.n116 185
rmesh_equiv_19 mir.n6 mir.n7 13.0823
rmesh_equiv_190 vpwr.n115 vpwr.n118 240.00290767186621
rmesh_equiv_191 vpwr.n115 vpwr.n159 185.00310000000002
rmesh_equiv_192 vpwr.n116 vpwr.n117 25.6005
rmesh_equiv_193 vpwr.n117 vpwr.n118 185
rmesh_equiv_194 vpwr.n117 vpwr.n120 25.6005
rmesh_equiv_195 vpwr.n118 vpwr.n119 240
rmesh_equiv_196 vpwr.n118 vpwr.n159 185.00310000000002
rmesh_equiv_197 vpwr.n119 vpwr.n120 185
rmesh_equiv_198 vpwr.n119 vpwr.n122 240.00290767186621
rmesh_equiv_199 vpwr.n119 vpwr.n159 185.00310000000002
rmesh_equiv_2 inp inp.t0 332.71199999999999
rmesh_equiv_20 mir.n7 mir.n8 2.4407800000000002
rmesh_equiv_200 vpwr.n12 vpwr.n13 185
rmesh_equiv_201 vpwr.n12 vpwr.n156 25.6005
rmesh_equiv_202 vpwr.n12 vpwr.n162 25.6005
rmesh_equiv_203 vpwr.n120 vpwr.n121 25.6005
rmesh_equiv_204 vpwr.n121 vpwr.n122 185
rmesh_equiv_205 vpwr.n121 vpwr.n124 25.6005
rmesh_equiv_206 vpwr.n122 vpwr.n123 240
rmesh_equiv_207 vpwr.n122 vpwr.n159 185.00310000000002
rmesh_equiv_208 vpwr.n123 vpwr.n124 185
rmesh_equiv_209 vpwr.n123 vpwr.n126 240.00290767186621
rmesh_equiv_21 mir.n8 mir.t1 387.11000000000001
rmesh_equiv_210 vpwr.n123 vpwr.n159 185.00310000000002
rmesh_equiv_211 vpwr.n124 vpwr.n125 25.6005
rmesh_equiv_212 vpwr.n125 vpwr.n126 185
rmesh_equiv_213 vpwr.n125 vpwr.n128 25.6005
rmesh_equiv_214 vpwr.n126 vpwr.n127 240
rmesh_equiv_215 vpwr.n126 vpwr.n159 185.00310000000002
rmesh_equiv_216 vpwr.n127 vpwr.n128 185
rmesh_equiv_217 vpwr.n127 vpwr.n130 240.00290767186621
rmesh_equiv_218 vpwr.n127 vpwr.n159 185.00310000000002
rmesh_equiv_219 vpwr.n128 vpwr.n129 25.6005
rmesh_equiv_22 out out.n0 22.8553
rmesh_equiv_220 vpwr.n129 vpwr.n130 185
rmesh_equiv_221 vpwr.n129 vpwr.n132 25.6005
rmesh_equiv_222 vpwr.n13 vpwr.n157 240
rmesh_equiv_223 vpwr.n13 vpwr.n159 185.00310000000002
rmesh_equiv_224 vpwr.n13 vpwr.n161 240.00290767186621
rmesh_equiv_225 vpwr.n130 vpwr.n131 240
rmesh_equiv_226 vpwr.n130 vpwr.n159 185.00310000000002
rmesh_equiv_227 vpwr.n131 vpwr.n132 185
rmesh_equiv_228 vpwr.n131 vpwr.n134 240.00290767186621
rmesh_equiv_229 vpwr.n131 vpwr.n159 185.00310000000002
rmesh_equiv_23 out out.n1 6.3200399999999997
rmesh_equiv_230 vpwr.n132 vpwr.n133 25.6005
rmesh_equiv_231 vpwr.n133 vpwr.n134 185
rmesh_equiv_232 vpwr.n133 vpwr.n136 25.6005
rmesh_equiv_233 vpwr.n134 vpwr.n135 240
rmesh_equiv_234 vpwr.n134 vpwr.n159 185.00310000000002
rmesh_equiv_235 vpwr.n135 vpwr.n136 185
rmesh_equiv_236 vpwr.n135 vpwr.n138 240.00290767186621
rmesh_equiv_237 vpwr.n135 vpwr.n159 185.00310000000002
rmesh_equiv_238 vpwr.n136 vpwr.n137 25.6005
rmesh_equiv_239 vpwr.n137 vpwr.n138 185
rmesh_equiv_24 out out.n3 33.130400000000002
rmesh_equiv_240 vpwr.n137 vpwr.n140 25.6005
rmesh_equiv_241 vpwr.n138 vpwr.n139 240
rmesh_equiv_242 vpwr.n138 vpwr.n159 185.00310000000002
rmesh_equiv_243 vpwr.n139 vpwr.n140 185
rmesh_equiv_244 vpwr.n139 vpwr.n142 240.00290767186621
rmesh_equiv_245 vpwr.n139 vpwr.n159 185.00310000000002
rmesh_equiv_246 vpwr.n140 vpwr.n141 25.6005
rmesh_equiv_247 vpwr.n141 vpwr.n142 185
rmesh_equiv_248 vpwr.n141 vpwr.n144 25.6005
rmesh_equiv_249 vpwr.n142 vpwr.n143 240
rmesh_equiv_25 out out.n5 0.25606299999999999
rmesh_equiv_250 vpwr.n142 vpwr.n159 185.00310000000002
rmesh_equiv_251 vpwr.n143 vpwr.n144 185
rmesh_equiv_252 vpwr.n143 vpwr.n146 240.00290767186621
rmesh_equiv_253 vpwr.n143 vpwr.n159 185.00310000000002
rmesh_equiv_254 vpwr.n144 vpwr.n145 25.6005
rmesh_equiv_255 vpwr.n145 vpwr.n146 185
rmesh_equiv_256 vpwr.n145 vpwr.n148 25.6005
rmesh_equiv_257 vpwr.n146 vpwr.n147 240
rmesh_equiv_258 vpwr.n146 vpwr.n159 185.00310000000002
rmesh_equiv_259 vpwr.n147 vpwr.n148 185
rmesh_equiv_26 out out.n7 4.8770699999999998
rmesh_equiv_260 vpwr.n147 vpwr.n150 240.00290767186621
rmesh_equiv_261 vpwr.n147 vpwr.n159 185.00310000000002
rmesh_equiv_262 vpwr.n148 vpwr.n149 25.6005
rmesh_equiv_263 vpwr.n149 vpwr.n150 185
rmesh_equiv_264 vpwr.n149 vpwr.n152 25.6005
rmesh_equiv_265 vpwr.n150 vpwr.n151 240
rmesh_equiv_266 vpwr.n150 vpwr.n159 185.00310000000002
rmesh_equiv_267 vpwr.n151 vpwr.n152 185
rmesh_equiv_268 vpwr.n151 vpwr.n153 240.00290767186621
rmesh_equiv_269 vpwr.n151 vpwr.n159 185.00310000000002
rmesh_equiv_27 out.n0 out.n6 11.4361
rmesh_equiv_270 vpwr.n152 vpwr.n154 25.6005
rmesh_equiv_271 vpwr.n153 vpwr.n154 185
rmesh_equiv_272 vpwr.n153 vpwr.n159 185.00310000000002
rmesh_equiv_273 vpwr.n153 vpwr.n42 240
rmesh_equiv_274 vpwr.n154 vpwr.n155 25.6005
rmesh_equiv_275 vpwr.n155 vpwr.n156 25.6005
rmesh_equiv_276 vpwr.n155 vpwr.n42 185
rmesh_equiv_277 vpwr.n156 vpwr.n157 185
rmesh_equiv_278 vpwr.n157 vpwr.n159 185.00310000000002
rmesh_equiv_279 vpwr.n157 vpwr.n42 240.00290767186621
rmesh_equiv_28 out.n0 out.t1 381.113
rmesh_equiv_280 vpwr.n159 vpwr.n161 185.00310000000002
rmesh_equiv_281 vpwr.n159 vpwr.n42 185.00310000000002
rmesh_equiv_282 vpwr.n159 vpwr.n43 185.00310000000002
rmesh_equiv_283 vpwr.n159 vpwr.n46 185.00310000000002
rmesh_equiv_284 vpwr.n159 vpwr.n47 185.00310000000002
rmesh_equiv_285 vpwr.n159 vpwr.n50 185.00310000000002
rmesh_equiv_286 vpwr.n159 vpwr.n51 185.00310000000002
rmesh_equiv_287 vpwr.n159 vpwr.n54 185.00310000000002
rmesh_equiv_288 vpwr.n159 vpwr.n55 185.00310000000002
rmesh_equiv_289 vpwr.n159 vpwr.n58 185.00310000000002
rmesh_equiv_29 out.n1 out.n2 13.389300000000002
rmesh_equiv_290 vpwr.n159 vpwr.n59 185.00310000000002
rmesh_equiv_291 vpwr.n159 vpwr.n62 185.00310000000002
rmesh_equiv_292 vpwr.n159 vpwr.n63 185.00310000000002
rmesh_equiv_293 vpwr.n159 vpwr.n66 185.00310000000002
rmesh_equiv_294 vpwr.n159 vpwr.n67 185.00310000000002
rmesh_equiv_295 vpwr.n159 vpwr.n70 185.00310000000002
rmesh_equiv_296 vpwr.n159 vpwr.n71 185.00310000000002
rmesh_equiv_297 vpwr.n159 vpwr.n74 185.00310000000002
rmesh_equiv_298 vpwr.n159 vpwr.n75 185.00310000000002
rmesh_equiv_299 vpwr.n159 vpwr.n78 185.00310000000002
rmesh_equiv_3 mir mir.n0 22.8553
rmesh_equiv_30 out.n1 out.n4 0.75515399999999999
rmesh_equiv_300 vpwr.n159 vpwr.n79 185.00310000000002
rmesh_equiv_301 vpwr.n159 vpwr.n82 185.00310000000002
rmesh_equiv_302 vpwr.n159 vpwr.n83 185.00310000000002
rmesh_equiv_303 vpwr.n159 vpwr.n86 185.00310000000002
rmesh_equiv_304 vpwr.n159 vpwr.n87 185.00310000000002
rmesh_equiv_305 vpwr.n159 vpwr.n90 185.00310000000002
rmesh_equiv_306 vpwr.n159 vpwr.n91 185.00310000000002
rmesh_equiv_307 vpwr.n159 vpwr.n94 185.00310000000002
rmesh_equiv_308 vpwr.n159 vpwr.n95 185.00310000000002
rmesh_equiv_309 vpwr.n159 vpwr.n98 185.00310000000002
rmesh_equiv_31 out.n2 out.n3 14.121399999999998
rmesh_equiv_310 vpwr.n159 vpwr.n99 185.00310000000002
rmesh_equiv_311 vpwr.n161 vpwr.n162 185
rmesh_equiv_312 vpwr.n162 vpwr.n163 25.6005
rmesh_equiv_313 vpwr.n163 vpwr.n164 81.318100000000001
rmesh_equiv_314 vpwr.n164 vpwr.n165 185
rmesh_equiv_315 vpwr.n165 vpwr.n166 240
rmesh_equiv_316 vpwr.n166 vpwr.n167 185
rmesh_equiv_317 vpwr.n166 vpwr.n2 240
rmesh_equiv_318 vpwr.n167 vpwr.n168 185
rmesh_equiv_319 vpwr.n167 vpwr.t2 14.556599999999998
rmesh_equiv_32 out.n2 out.t0 1.7404999999999999
rmesh_equiv_320 vpwr.n168 vpwr.n169 185
rmesh_equiv_321 vpwr.n168 vpwr.n6 240
rmesh_equiv_322 vpwr.n168 vpwr.n9 240
rmesh_equiv_323 vpwr.n169 vpwr.n170 25.6005
rmesh_equiv_324 vpwr.n169 vpwr.n8 25.6005
rmesh_equiv_325 vpwr.n170 vpwr.n325 25.6005
rmesh_equiv_326 vpwr.n170 vpwr.n6 185
rmesh_equiv_327 vpwr.n171 vpwr.n172 185
rmesh_equiv_328 vpwr.n171 vpwr.n318 25.6005
rmesh_equiv_329 vpwr.n171 vpwr.n323 25.6005
rmesh_equiv_33 out.n3 out.n4 1.13588
rmesh_equiv_330 vpwr.n172 vpwr.n319 240
rmesh_equiv_331 vpwr.n172 vpwr.n320 185.00310000000002
rmesh_equiv_332 vpwr.n172 vpwr.n322 240.00290767186621
rmesh_equiv_333 vpwr.n2 vpwr.n328 240
rmesh_equiv_334 vpwr.n2 vpwr.t2 185
rmesh_equiv_335 vpwr.n202 vpwr.n315 240.00290767186621
rmesh_equiv_336 vpwr.n202 vpwr.n317 185
rmesh_equiv_337 vpwr.n202 vpwr.n319 240
rmesh_equiv_338 vpwr.n202 vpwr.n320 185.00310000000002
rmesh_equiv_339 vpwr.n203 vpwr.n204 185
rmesh_equiv_34 out.n4 out.n5 13.9156
rmesh_equiv_340 vpwr.n203 vpwr.n206 240.00290767186621
rmesh_equiv_341 vpwr.n203 vpwr.n320 185.00310000000002
rmesh_equiv_342 vpwr.n203 vpwr.n4 762.35400000000004
rmesh_equiv_343 vpwr.n204 vpwr.n205 25.6005
rmesh_equiv_344 vpwr.n204 vpwr.n3 81.318100000000001
rmesh_equiv_345 vpwr.n205 vpwr.n206 185
rmesh_equiv_346 vpwr.n205 vpwr.n208 25.6005
rmesh_equiv_347 vpwr.n206 vpwr.n207 240
rmesh_equiv_348 vpwr.n206 vpwr.n320 185.00310000000002
rmesh_equiv_349 vpwr.n207 vpwr.n208 185
rmesh_equiv_35 out.n5 out.n6 16.6904
rmesh_equiv_350 vpwr.n207 vpwr.n210 240.00290767186621
rmesh_equiv_351 vpwr.n207 vpwr.n320 185.00310000000002
rmesh_equiv_352 vpwr.n208 vpwr.n209 25.6005
rmesh_equiv_353 vpwr.n209 vpwr.n210 185
rmesh_equiv_354 vpwr.n209 vpwr.n212 25.6005
rmesh_equiv_355 vpwr.n210 vpwr.n211 240
rmesh_equiv_356 vpwr.n210 vpwr.n320 185.00310000000002
rmesh_equiv_357 vpwr.n211 vpwr.n212 185
rmesh_equiv_358 vpwr.n211 vpwr.n214 240.00290767186621
rmesh_equiv_359 vpwr.n211 vpwr.n320 185.00310000000002
rmesh_equiv_36 out.n6 out.n7 2.4407800000000002
rmesh_equiv_360 vpwr.n212 vpwr.n213 25.6005
rmesh_equiv_361 vpwr.n213 vpwr.n214 185
rmesh_equiv_362 vpwr.n213 vpwr.n216 25.6005
rmesh_equiv_363 vpwr.n214 vpwr.n215 240
rmesh_equiv_364 vpwr.n214 vpwr.n320 185.00310000000002
rmesh_equiv_365 vpwr.n215 vpwr.n216 185
rmesh_equiv_366 vpwr.n215 vpwr.n218 240.00290767186621
rmesh_equiv_367 vpwr.n215 vpwr.n320 185.00310000000002
rmesh_equiv_368 vpwr.n216 vpwr.n217 25.6005
rmesh_equiv_369 vpwr.n217 vpwr.n218 185
rmesh_equiv_37 out.n7 out.t1 387.11000000000001
rmesh_equiv_370 vpwr.n217 vpwr.n220 25.6005
rmesh_equiv_371 vpwr.n218 vpwr.n219 240
rmesh_equiv_372 vpwr.n218 vpwr.n320 185.00310000000002
rmesh_equiv_373 vpwr.n219 vpwr.n220 185
rmesh_equiv_374 vpwr.n219 vpwr.n222 240.00290767186621
rmesh_equiv_375 vpwr.n219 vpwr.n320 185.00310000000002
rmesh_equiv_376 vpwr.n220 vpwr.n221 25.6005
rmesh_equiv_377 vpwr.n221 vpwr.n222 185
rmesh_equiv_378 vpwr.n221 vpwr.n224 25.6005
rmesh_equiv_379 vpwr.n222 vpwr.n223 240
rmesh_equiv_38 tail tail.n0 33.130400000000002
rmesh_equiv_380 vpwr.n222 vpwr.n320 185.00310000000002
rmesh_equiv_381 vpwr.n223 vpwr.n224 185
rmesh_equiv_382 vpwr.n223 vpwr.n226 240.00290767186621
rmesh_equiv_383 vpwr.n223 vpwr.n320 185.00310000000002
rmesh_equiv_384 vpwr.n224 vpwr.n225 25.6005
rmesh_equiv_385 vpwr.n225 vpwr.n226 185
rmesh_equiv_386 vpwr.n225 vpwr.n228 25.6005
rmesh_equiv_387 vpwr.n226 vpwr.n227 240
rmesh_equiv_388 vpwr.n226 vpwr.n320 185.00310000000002
rmesh_equiv_389 vpwr.n227 vpwr.n228 185
rmesh_equiv_39 tail tail.n1 19.837
rmesh_equiv_390 vpwr.n227 vpwr.n230 240.00290767186621
rmesh_equiv_391 vpwr.n227 vpwr.n320 185.00310000000002
rmesh_equiv_392 vpwr.n228 vpwr.n229 25.6005
rmesh_equiv_393 vpwr.n229 vpwr.n230 185
rmesh_equiv_394 vpwr.n229 vpwr.n232 25.6005
rmesh_equiv_395 vpwr.n230 vpwr.n231 240
rmesh_equiv_396 vpwr.n230 vpwr.n320 185.00310000000002
rmesh_equiv_397 vpwr.n231 vpwr.n232 185
rmesh_equiv_398 vpwr.n231 vpwr.n234 240.00290767186621
rmesh_equiv_399 vpwr.n231 vpwr.n320 185.00310000000002
rmesh_equiv_4 mir mir.n1 13.41820371623824
rmesh_equiv_40 tail tail.n11 6.3200399999999997
rmesh_equiv_400 vpwr.n232 vpwr.n233 25.6005
rmesh_equiv_401 vpwr.n233 vpwr.n234 185
rmesh_equiv_402 vpwr.n233 vpwr.n236 25.6005
rmesh_equiv_403 vpwr.n234 vpwr.n235 240
rmesh_equiv_404 vpwr.n234 vpwr.n320 185.00310000000002
rmesh_equiv_405 vpwr.n235 vpwr.n236 185
rmesh_equiv_406 vpwr.n235 vpwr.n238 240.00290767186621
rmesh_equiv_407 vpwr.n235 vpwr.n320 185.00310000000002
rmesh_equiv_408 vpwr.n236 vpwr.n237 25.6005
rmesh_equiv_409 vpwr.n237 vpwr.n238 185
rmesh_equiv_41 tail tail.n2 4.2590000000000003
rmesh_equiv_410 vpwr.n237 vpwr.n240 25.6005
rmesh_equiv_411 vpwr.n238 vpwr.n239 240
rmesh_equiv_412 vpwr.n238 vpwr.n320 185.00310000000002
rmesh_equiv_413 vpwr.n239 vpwr.n240 185
rmesh_equiv_414 vpwr.n239 vpwr.n242 240.00290767186621
rmesh_equiv_415 vpwr.n239 vpwr.n320 185.00310000000002
rmesh_equiv_416 vpwr.n240 vpwr.n241 25.6005
rmesh_equiv_417 vpwr.n241 vpwr.n242 185
rmesh_equiv_418 vpwr.n241 vpwr.n244 25.6005
rmesh_equiv_419 vpwr.n242 vpwr.n243 240
rmesh_equiv_42 tail tail.n4 6.3200399999999997
rmesh_equiv_420 vpwr.n242 vpwr.n320 185.00310000000002
rmesh_equiv_421 vpwr.n243 vpwr.n244 185
rmesh_equiv_422 vpwr.n243 vpwr.n246 240.00290767186621
rmesh_equiv_423 vpwr.n243 vpwr.n320 185.00310000000002
rmesh_equiv_424 vpwr.n244 vpwr.n245 25.6005
rmesh_equiv_425 vpwr.n245 vpwr.n246 185
rmesh_equiv_426 vpwr.n245 vpwr.n248 25.6005
rmesh_equiv_427 vpwr.n246 vpwr.n247 240
rmesh_equiv_428 vpwr.n246 vpwr.n320 185.00310000000002
rmesh_equiv_429 vpwr.n247 vpwr.n248 185
rmesh_equiv_43 tail tail.n6 33.130400000000002
rmesh_equiv_430 vpwr.n247 vpwr.n250 240.00290767186621
rmesh_equiv_431 vpwr.n247 vpwr.n320 185.00310000000002
rmesh_equiv_432 vpwr.n248 vpwr.n249 25.6005
rmesh_equiv_433 vpwr.n249 vpwr.n250 185
rmesh_equiv_434 vpwr.n249 vpwr.n252 25.6005
rmesh_equiv_435 vpwr.n250 vpwr.n251 240
rmesh_equiv_436 vpwr.n250 vpwr.n320 185.00310000000002
rmesh_equiv_437 vpwr.n251 vpwr.n252 185
rmesh_equiv_438 vpwr.n251 vpwr.n254 240.00290767186621
rmesh_equiv_439 vpwr.n251 vpwr.n320 185.00310000000002
rmesh_equiv_44 tail.n0 tail.n10 14.121399999999998
rmesh_equiv_440 vpwr.n252 vpwr.n253 25.6005
rmesh_equiv_441 vpwr.n253 vpwr.n254 185
rmesh_equiv_442 vpwr.n253 vpwr.n256 25.6005
rmesh_equiv_443 vpwr.n254 vpwr.n255 240
rmesh_equiv_444 vpwr.n254 vpwr.n320 185.00310000000002
rmesh_equiv_445 vpwr.n255 vpwr.n256 185
rmesh_equiv_446 vpwr.n255 vpwr.n258 240.00290767186621
rmesh_equiv_447 vpwr.n255 vpwr.n320 185.00310000000002
rmesh_equiv_448 vpwr.n256 vpwr.n257 25.6005
rmesh_equiv_449 vpwr.n257 vpwr.n258 185
rmesh_equiv_45 tail.n0 tail.n9 1.13588
rmesh_equiv_450 vpwr.n257 vpwr.n260 25.6005
rmesh_equiv_451 vpwr.n258 vpwr.n259 240
rmesh_equiv_452 vpwr.n258 vpwr.n320 185.00310000000002
rmesh_equiv_453 vpwr.n259 vpwr.n260 185
rmesh_equiv_454 vpwr.n259 vpwr.n262 240.00290767186621
rmesh_equiv_455 vpwr.n259 vpwr.n320 185.00310000000002
rmesh_equiv_456 vpwr.n260 vpwr.n261 25.6005
rmesh_equiv_457 vpwr.n261 vpwr.n262 185
rmesh_equiv_458 vpwr.n261 vpwr.n264 25.6005
rmesh_equiv_459 vpwr.n262 vpwr.n263 240
rmesh_equiv_46 tail.n1 tail.n3 14.189499999999999
rmesh_equiv_460 vpwr.n262 vpwr.n320 185.00310000000002
rmesh_equiv_461 vpwr.n263 vpwr.n264 185
rmesh_equiv_462 vpwr.n263 vpwr.n266 240.00290767186621
rmesh_equiv_463 vpwr.n263 vpwr.n320 185.00310000000002
rmesh_equiv_464 vpwr.n264 vpwr.n265 25.6005
rmesh_equiv_465 vpwr.n265 vpwr.n266 185
rmesh_equiv_466 vpwr.n265 vpwr.n268 25.6005
rmesh_equiv_467 vpwr.n266 vpwr.n267 240
rmesh_equiv_468 vpwr.n266 vpwr.n320 185.00310000000002
rmesh_equiv_469 vpwr.n267 vpwr.n268 185
rmesh_equiv_47 tail.n1 tail.t1 174.91200000000001
rmesh_equiv_470 vpwr.n267 vpwr.n270 240.00290767186621
rmesh_equiv_471 vpwr.n267 vpwr.n320 185.00310000000002
rmesh_equiv_472 vpwr.n268 vpwr.n269 25.6005
rmesh_equiv_473 vpwr.n269 vpwr.n270 185
rmesh_equiv_474 vpwr.n269 vpwr.n272 25.6005
rmesh_equiv_475 vpwr.n270 vpwr.n271 240
rmesh_equiv_476 vpwr.n270 vpwr.n320 185.00310000000002
rmesh_equiv_477 vpwr.n271 vpwr.n272 185
rmesh_equiv_478 vpwr.n271 vpwr.n274 240.00290767186621
rmesh_equiv_479 vpwr.n271 vpwr.n320 185.00310000000002
rmesh_equiv_48 tail.n10 tail.n11 13.389300000000002
rmesh_equiv_480 vpwr.n272 vpwr.n273 25.6005
rmesh_equiv_481 vpwr.n273 vpwr.n274 185
rmesh_equiv_482 vpwr.n273 vpwr.n276 25.6005
rmesh_equiv_483 vpwr.n274 vpwr.n275 240
rmesh_equiv_484 vpwr.n274 vpwr.n320 185.00310000000002
rmesh_equiv_485 vpwr.n275 vpwr.n276 185
rmesh_equiv_486 vpwr.n275 vpwr.n278 240.00290767186621
rmesh_equiv_487 vpwr.n275 vpwr.n320 185.00310000000002
rmesh_equiv_488 vpwr.n276 vpwr.n277 25.6005
rmesh_equiv_489 vpwr.n277 vpwr.n278 185
rmesh_equiv_49 tail.n10 tail.t0 1.7404999999999999
rmesh_equiv_490 vpwr.n277 vpwr.n280 25.6005
rmesh_equiv_491 vpwr.n278 vpwr.n279 240
rmesh_equiv_492 vpwr.n278 vpwr.n320 185.00310000000002
rmesh_equiv_493 vpwr.n279 vpwr.n280 185
rmesh_equiv_494 vpwr.n279 vpwr.n282 240.00290767186621
rmesh_equiv_495 vpwr.n279 vpwr.n320 185.00310000000002
rmesh_equiv_496 vpwr.n280 vpwr.n281 25.6005
rmesh_equiv_497 vpwr.n281 vpwr.n282 185
rmesh_equiv_498 vpwr.n281 vpwr.n284 25.6005
rmesh_equiv_499 vpwr.n282 vpwr.n283 240
rmesh_equiv_5 mir mir.n2 6.3200399999999997
rmesh_equiv_50 tail.n11 tail.n9 0.75515399999999999
rmesh_equiv_500 vpwr.n282 vpwr.n320 185.00310000000002
rmesh_equiv_501 vpwr.n283 vpwr.n284 185
rmesh_equiv_502 vpwr.n283 vpwr.n286 240.00290767186621
rmesh_equiv_503 vpwr.n283 vpwr.n320 185.00310000000002
rmesh_equiv_504 vpwr.n284 vpwr.n285 25.6005
rmesh_equiv_505 vpwr.n285 vpwr.n286 185
rmesh_equiv_506 vpwr.n285 vpwr.n288 25.6005
rmesh_equiv_507 vpwr.n286 vpwr.n287 240
rmesh_equiv_508 vpwr.n286 vpwr.n320 185.00310000000002
rmesh_equiv_509 vpwr.n287 vpwr.n288 185
rmesh_equiv_51 tail.n2 tail.n3 3.0467200000000001
rmesh_equiv_510 vpwr.n287 vpwr.n290 240.00290767186621
rmesh_equiv_511 vpwr.n287 vpwr.n320 185.00310000000002
rmesh_equiv_512 vpwr.n288 vpwr.n289 25.6005
rmesh_equiv_513 vpwr.n289 vpwr.n290 185
rmesh_equiv_514 vpwr.n289 vpwr.n292 25.6005
rmesh_equiv_515 vpwr.n290 vpwr.n291 240
rmesh_equiv_516 vpwr.n290 vpwr.n320 185.00310000000002
rmesh_equiv_517 vpwr.n291 vpwr.n292 185
rmesh_equiv_518 vpwr.n291 vpwr.n294 240.00290767186621
rmesh_equiv_519 vpwr.n291 vpwr.n320 185.00310000000002
rmesh_equiv_52 tail.n2 tail.t1 181.41
rmesh_equiv_520 vpwr.n292 vpwr.n293 25.6005
rmesh_equiv_521 vpwr.n293 vpwr.n294 185
rmesh_equiv_522 vpwr.n293 vpwr.n296 25.6005
rmesh_equiv_523 vpwr.n294 vpwr.n295 240
rmesh_equiv_524 vpwr.n294 vpwr.n320 185.00310000000002
rmesh_equiv_525 vpwr.n295 vpwr.n296 185
rmesh_equiv_526 vpwr.n295 vpwr.n298 240.00290767186621
rmesh_equiv_527 vpwr.n295 vpwr.n320 185.00310000000002
rmesh_equiv_528 vpwr.n296 vpwr.n297 25.6005
rmesh_equiv_529 vpwr.n297 vpwr.n298 185
rmesh_equiv_53 tail.n3 tail.n8 17.248200000000001
rmesh_equiv_530 vpwr.n297 vpwr.n300 25.6005
rmesh_equiv_531 vpwr.n298 vpwr.n299 240
rmesh_equiv_532 vpwr.n298 vpwr.n320 185.00310000000002
rmesh_equiv_533 vpwr.n299 vpwr.n300 185
rmesh_equiv_534 vpwr.n299 vpwr.n302 240.00290767186621
rmesh_equiv_535 vpwr.n299 vpwr.n320 185.00310000000002
rmesh_equiv_536 vpwr.n3 vpwr.n329 25.6005
rmesh_equiv_537 vpwr.n3 vpwr.n4 185
rmesh_equiv_538 vpwr.n300 vpwr.n301 25.6005
rmesh_equiv_539 vpwr.n301 vpwr.n302 185
rmesh_equiv_54 tail.n4 tail.n5 13.389300000000002
rmesh_equiv_540 vpwr.n301 vpwr.n304 25.6005
rmesh_equiv_541 vpwr.n302 vpwr.n303 240
rmesh_equiv_542 vpwr.n302 vpwr.n320 185.00310000000002
rmesh_equiv_543 vpwr.n303 vpwr.n304 185
rmesh_equiv_544 vpwr.n303 vpwr.n306 240.00290767186621
rmesh_equiv_545 vpwr.n303 vpwr.n320 185.00310000000002
rmesh_equiv_546 vpwr.n304 vpwr.n305 25.6005
rmesh_equiv_547 vpwr.n305 vpwr.n306 185
rmesh_equiv_548 vpwr.n305 vpwr.n308 25.6005
rmesh_equiv_549 vpwr.n306 vpwr.n307 240
rmesh_equiv_55 tail.n4 tail.n7 0.75515399999999999
rmesh_equiv_550 vpwr.n306 vpwr.n320 185.00310000000002
rmesh_equiv_551 vpwr.n307 vpwr.n308 185
rmesh_equiv_552 vpwr.n307 vpwr.n310 240.00290767186621
rmesh_equiv_553 vpwr.n307 vpwr.n320 185.00310000000002
rmesh_equiv_554 vpwr.n308 vpwr.n309 25.6005
rmesh_equiv_555 vpwr.n309 vpwr.n310 185
rmesh_equiv_556 vpwr.n309 vpwr.n312 25.6005
rmesh_equiv_557 vpwr.n310 vpwr.n311 240
rmesh_equiv_558 vpwr.n310 vpwr.n320 185.00310000000002
rmesh_equiv_559 vpwr.n311 vpwr.n312 185
rmesh_equiv_56 tail.n5 tail.n6 14.121399999999998
rmesh_equiv_560 vpwr.n311 vpwr.n314 240.00290767186621
rmesh_equiv_561 vpwr.n311 vpwr.n320 185.00310000000002
rmesh_equiv_562 vpwr.n312 vpwr.n313 25.6005
rmesh_equiv_563 vpwr.n313 vpwr.n314 185
rmesh_equiv_564 vpwr.n313 vpwr.n316 25.6005
rmesh_equiv_565 vpwr.n314 vpwr.n315 240
rmesh_equiv_566 vpwr.n314 vpwr.n320 185.00310000000002
rmesh_equiv_567 vpwr.n315 vpwr.n316 185
rmesh_equiv_568 vpwr.n315 vpwr.n320 185.00310000000002
rmesh_equiv_569 vpwr.n316 vpwr.n317 25.6005
rmesh_equiv_57 tail.n5 tail.t2 1.7404999999999999
rmesh_equiv_570 vpwr.n317 vpwr.n318 25.6005
rmesh_equiv_571 vpwr.n318 vpwr.n319 185
rmesh_equiv_572 vpwr.n319 vpwr.n320 185
rmesh_equiv_573 vpwr.n320 vpwr.n322 185.00310000000002
rmesh_equiv_574 vpwr.n320 vpwr.n5 22.905000000000001
rmesh_equiv_575 vpwr.n322 vpwr.n323 185
rmesh_equiv_576 vpwr.n322 vpwr.n7 762.35400000000004
rmesh_equiv_577 vpwr.n323 vpwr.n324 81.318100000000001
rmesh_equiv_578 vpwr.n324 vpwr.n325 25.6005
rmesh_equiv_579 vpwr.n324 vpwr.n7 185
rmesh_equiv_58 tail.n6 tail.n7 1.13588
rmesh_equiv_580 vpwr.n325 vpwr.n326 185
rmesh_equiv_581 vpwr.n326 vpwr.n327 185
rmesh_equiv_582 vpwr.n326 vpwr.n6 240
rmesh_equiv_583 vpwr.n326 vpwr.n7 240
rmesh_equiv_584 vpwr.n327 vpwr.n328 185
rmesh_equiv_585 vpwr.n327 vpwr.n5 14.556599999999998
rmesh_equiv_586 vpwr.n327 vpwr.t2 14.556599999999998
rmesh_equiv_587 vpwr.n328 vpwr.n329 185
rmesh_equiv_588 vpwr.n328 vpwr.n4 240
rmesh_equiv_589 vpwr.n330 vpwr.n334 0.12975
rmesh_equiv_59 tail.n7 tail.n8 14.748999999999999
rmesh_equiv_590 vpwr.n331 vpwr.n333 2.4407800000000002
rmesh_equiv_591 vpwr.n331 vpwr.t3 387.11000000000001
rmesh_equiv_592 vpwr.n332 vpwr.n333 11.4361
rmesh_equiv_593 vpwr.n332 vpwr.t3 381.113
rmesh_equiv_594 vpwr.n333 vpwr.n334 13.6031
rmesh_equiv_595 vpwr.n334 vpwr.n664 0.78305000000000002
rmesh_equiv_596 vpwr.n335 vpwr.n498 25.6005
rmesh_equiv_597 vpwr.n335 vpwr.n500 185
rmesh_equiv_598 vpwr.n336 vpwr.n500 240
rmesh_equiv_599 vpwr.n336 vpwr.n662 240
rmesh_equiv_6 mir mir.n4 33.130400000000002
rmesh_equiv_60 tail.n8 tail.n9 15.659599999999999
rmesh_equiv_600 vpwr.n336 vpwr.t0 185
rmesh_equiv_601 vpwr.n337 vpwr.n338 185
rmesh_equiv_602 vpwr.n337 vpwr.n538 81.318100000000001
rmesh_equiv_603 vpwr.n337 vpwr.n663 25.6005
rmesh_equiv_604 vpwr.n338 vpwr.n339 185
rmesh_equiv_605 vpwr.n338 vpwr.n537 762.35400000000004
rmesh_equiv_606 vpwr.n338 vpwr.n662 240
rmesh_equiv_607 vpwr.n339 vpwr.n341 185
rmesh_equiv_608 vpwr.n339 vpwr.n654 22.905000000000001
rmesh_equiv_609 vpwr.n339 vpwr.n661 14.556599999999998
rmesh_equiv_61 vgnd vgnd.n14 1966.9103415427812
rmesh_equiv_610 vpwr.n340 vpwr.n502 240
rmesh_equiv_611 vpwr.n340 vpwr.n504 185
rmesh_equiv_612 vpwr.n340 vpwr.n660 240
rmesh_equiv_613 vpwr.n340 vpwr.t0 185
rmesh_equiv_614 vpwr.n341 vpwr.n656 762.35400000000004
rmesh_equiv_615 vpwr.n341 vpwr.n658 185
rmesh_equiv_616 vpwr.n341 vpwr.n660 240
rmesh_equiv_617 vpwr.n342 vpwr.n343 185
rmesh_equiv_618 vpwr.n342 vpwr.n378 81.318100000000001
rmesh_equiv_619 vpwr.n342 vpwr.n503 25.6005
rmesh_equiv_62 vgnd vgnd.n396 39647.259385977341
rmesh_equiv_620 vpwr.n343 vpwr.n344 185
rmesh_equiv_621 vpwr.n343 vpwr.n377 762.35400000000004
rmesh_equiv_622 vpwr.n343 vpwr.n502 240
rmesh_equiv_623 vpwr.n344 vpwr.n493 22.905000000000001
rmesh_equiv_624 vpwr.n344 vpwr.n499 185
rmesh_equiv_625 vpwr.n344 vpwr.n501 14.556599999999998
rmesh_equiv_626 vpwr.n345 vpwr.n493 185
rmesh_equiv_627 vpwr.n345 vpwr.n495 240
rmesh_equiv_628 vpwr.n345 vpwr.n497 185
rmesh_equiv_629 vpwr.n345 vpwr.n499 762.35400000000004
rmesh_equiv_63 vgnd vgnd.n429 169.28838209519608
rmesh_equiv_630 vpwr.n346 vpwr.n347 185
rmesh_equiv_631 vpwr.n346 vpwr.n490 25.6005
rmesh_equiv_632 vpwr.n346 vpwr.n496 25.6005
rmesh_equiv_633 vpwr.n347 vpwr.n491 240
rmesh_equiv_634 vpwr.n347 vpwr.n493 185.00310000000002
rmesh_equiv_635 vpwr.n347 vpwr.n495 240.00290767186621
rmesh_equiv_636 vpwr.n376 vpwr.n487 240
rmesh_equiv_637 vpwr.n376 vpwr.n489 185
rmesh_equiv_638 vpwr.n376 vpwr.n491 240.00290767186621
rmesh_equiv_639 vpwr.n376 vpwr.n493 185.00310000000002
rmesh_equiv_64 vgnd vgnd.n434 135.84077757686242
rmesh_equiv_640 vpwr.n377 vpwr.n378 185
rmesh_equiv_641 vpwr.n377 vpwr.n380 240.00290767186621
rmesh_equiv_642 vpwr.n377 vpwr.n493 185.00310000000002
rmesh_equiv_643 vpwr.n378 vpwr.n379 25.6005
rmesh_equiv_644 vpwr.n379 vpwr.n380 185
rmesh_equiv_645 vpwr.n379 vpwr.n382 25.6005
rmesh_equiv_646 vpwr.n380 vpwr.n381 240
rmesh_equiv_647 vpwr.n380 vpwr.n493 185.00310000000002
rmesh_equiv_648 vpwr.n381 vpwr.n382 185
rmesh_equiv_649 vpwr.n381 vpwr.n384 240.00290767186621
rmesh_equiv_65 vgnd vgnd.n7 329.15822228725062
rmesh_equiv_650 vpwr.n381 vpwr.n493 185.00310000000002
rmesh_equiv_651 vpwr.n382 vpwr.n383 25.6005
rmesh_equiv_652 vpwr.n383 vpwr.n384 185
rmesh_equiv_653 vpwr.n383 vpwr.n386 25.6005
rmesh_equiv_654 vpwr.n384 vpwr.n385 240
rmesh_equiv_655 vpwr.n384 vpwr.n493 185.00310000000002
rmesh_equiv_656 vpwr.n385 vpwr.n386 185
rmesh_equiv_657 vpwr.n385 vpwr.n388 240.00290767186621
rmesh_equiv_658 vpwr.n385 vpwr.n493 185.00310000000002
rmesh_equiv_659 vpwr.n386 vpwr.n387 25.6005
rmesh_equiv_66 vgnd vgnd.n8 4263.4645263279936
rmesh_equiv_660 vpwr.n387 vpwr.n388 185
rmesh_equiv_661 vpwr.n387 vpwr.n390 25.6005
rmesh_equiv_662 vpwr.n388 vpwr.n389 240
rmesh_equiv_663 vpwr.n388 vpwr.n493 185.00310000000002
rmesh_equiv_664 vpwr.n389 vpwr.n390 185
rmesh_equiv_665 vpwr.n389 vpwr.n392 240.00290767186621
rmesh_equiv_666 vpwr.n389 vpwr.n493 185.00310000000002
rmesh_equiv_667 vpwr.n390 vpwr.n391 25.6005
rmesh_equiv_668 vpwr.n391 vpwr.n392 185
rmesh_equiv_669 vpwr.n391 vpwr.n394 25.6005
rmesh_equiv_67 vgnd vgnd.t0 133.64863068407334
rmesh_equiv_670 vpwr.n392 vpwr.n393 240
rmesh_equiv_671 vpwr.n392 vpwr.n493 185.00310000000002
rmesh_equiv_672 vpwr.n393 vpwr.n394 185
rmesh_equiv_673 vpwr.n393 vpwr.n396 240.00290767186621
rmesh_equiv_674 vpwr.n393 vpwr.n493 185.00310000000002
rmesh_equiv_675 vpwr.n394 vpwr.n395 25.6005
rmesh_equiv_676 vpwr.n395 vpwr.n396 185
rmesh_equiv_677 vpwr.n395 vpwr.n398 25.6005
rmesh_equiv_678 vpwr.n396 vpwr.n397 240
rmesh_equiv_679 vpwr.n396 vpwr.n493 185.00310000000002
rmesh_equiv_68 vgnd vgnd.t2 93.092709988519033
rmesh_equiv_680 vpwr.n397 vpwr.n398 185
rmesh_equiv_681 vpwr.n397 vpwr.n400 240.00290767186621
rmesh_equiv_682 vpwr.n397 vpwr.n493 185.00310000000002
rmesh_equiv_683 vpwr.n398 vpwr.n399 25.6005
rmesh_equiv_684 vpwr.n399 vpwr.n400 185
rmesh_equiv_685 vpwr.n399 vpwr.n402 25.6005
rmesh_equiv_686 vpwr.n4 vpwr.n5 185
rmesh_equiv_687 vpwr.n400 vpwr.n401 240
rmesh_equiv_688 vpwr.n400 vpwr.n493 185.00310000000002
rmesh_equiv_689 vpwr.n401 vpwr.n402 185
rmesh_equiv_69 vgnd vgnd.t3 134.25243441441958
rmesh_equiv_690 vpwr.n401 vpwr.n404 240.00290767186621
rmesh_equiv_691 vpwr.n401 vpwr.n493 185.00310000000002
rmesh_equiv_692 vpwr.n402 vpwr.n403 25.6005
rmesh_equiv_693 vpwr.n403 vpwr.n404 185
rmesh_equiv_694 vpwr.n403 vpwr.n406 25.6005
rmesh_equiv_695 vpwr.n404 vpwr.n405 240
rmesh_equiv_696 vpwr.n404 vpwr.n493 185.00310000000002
rmesh_equiv_697 vpwr.n405 vpwr.n406 185
rmesh_equiv_698 vpwr.n405 vpwr.n408 240.00290767186621
rmesh_equiv_699 vpwr.n405 vpwr.n493 185.00310000000002
rmesh_equiv_7 mir mir.n8 4.8770699999999998
rmesh_equiv_70 vgnd.n11 vgnd.n14 5940.2059399182508
rmesh_equiv_700 vpwr.n406 vpwr.n407 25.6005
rmesh_equiv_701 vpwr.n407 vpwr.n408 185
rmesh_equiv_702 vpwr.n407 vpwr.n410 25.6005
rmesh_equiv_703 vpwr.n408 vpwr.n409 240
rmesh_equiv_704 vpwr.n408 vpwr.n493 185.00310000000002
rmesh_equiv_705 vpwr.n409 vpwr.n410 185
rmesh_equiv_706 vpwr.n409 vpwr.n412 240.00290767186621
rmesh_equiv_707 vpwr.n409 vpwr.n493 185.00310000000002
rmesh_equiv_708 vpwr.n410 vpwr.n411 25.6005
rmesh_equiv_709 vpwr.n411 vpwr.n412 185
rmesh_equiv_71 vgnd.n11 vgnd.n17 2642.7522752213208
rmesh_equiv_710 vpwr.n411 vpwr.n414 25.6005
rmesh_equiv_711 vpwr.n412 vpwr.n413 240
rmesh_equiv_712 vpwr.n412 vpwr.n493 185.00310000000002
rmesh_equiv_713 vpwr.n413 vpwr.n414 185
rmesh_equiv_714 vpwr.n413 vpwr.n416 240.00290767186621
rmesh_equiv_715 vpwr.n413 vpwr.n493 185.00310000000002
rmesh_equiv_716 vpwr.n414 vpwr.n415 25.6005
rmesh_equiv_717 vpwr.n415 vpwr.n416 185
rmesh_equiv_718 vpwr.n415 vpwr.n418 25.6005
rmesh_equiv_719 vpwr.n416 vpwr.n417 240
rmesh_equiv_72 vgnd.n11 vgnd.n417 3151.0190558452073
rmesh_equiv_720 vpwr.n416 vpwr.n493 185.00310000000002
rmesh_equiv_721 vpwr.n417 vpwr.n418 185
rmesh_equiv_722 vpwr.n417 vpwr.n420 240.00290767186621
rmesh_equiv_723 vpwr.n417 vpwr.n493 185.00310000000002
rmesh_equiv_724 vpwr.n418 vpwr.n419 25.6005
rmesh_equiv_725 vpwr.n419 vpwr.n420 185
rmesh_equiv_726 vpwr.n419 vpwr.n422 25.6005
rmesh_equiv_727 vpwr.n420 vpwr.n421 240
rmesh_equiv_728 vpwr.n420 vpwr.n493 185.00310000000002
rmesh_equiv_729 vpwr.n421 vpwr.n422 185
rmesh_equiv_73 vgnd.n11 vgnd.n422 941.74972225133979
rmesh_equiv_730 vpwr.n421 vpwr.n424 240.00290767186621
rmesh_equiv_731 vpwr.n421 vpwr.n493 185.00310000000002
rmesh_equiv_732 vpwr.n422 vpwr.n423 25.6005
rmesh_equiv_733 vpwr.n423 vpwr.n424 185
rmesh_equiv_734 vpwr.n423 vpwr.n426 25.6005
rmesh_equiv_735 vpwr.n424 vpwr.n425 240
rmesh_equiv_736 vpwr.n424 vpwr.n493 185.00310000000002
rmesh_equiv_737 vpwr.n425 vpwr.n426 185
rmesh_equiv_738 vpwr.n425 vpwr.n428 240.00290767186621
rmesh_equiv_739 vpwr.n425 vpwr.n493 185.00310000000002
rmesh_equiv_74 vgnd.n11 vgnd.n423 5385.6056076638588
rmesh_equiv_740 vpwr.n426 vpwr.n427 25.6005
rmesh_equiv_741 vpwr.n427 vpwr.n428 185
rmesh_equiv_742 vpwr.n427 vpwr.n430 25.6005
rmesh_equiv_743 vpwr.n428 vpwr.n429 240
rmesh_equiv_744 vpwr.n428 vpwr.n493 185.00310000000002
rmesh_equiv_745 vpwr.n429 vpwr.n430 185
rmesh_equiv_746 vpwr.n429 vpwr.n432 240.00290767186621
rmesh_equiv_747 vpwr.n429 vpwr.n493 185.00310000000002
rmesh_equiv_748 vpwr.n43 vpwr.n44 185
rmesh_equiv_749 vpwr.n43 vpwr.n46 240.00290767186621
rmesh_equiv_75 vgnd.n11 vgnd.n429 3343.8020382752461
rmesh_equiv_750 vpwr.n43 vpwr.n9 762.35400000000004
rmesh_equiv_751 vpwr.n430 vpwr.n431 25.6005
rmesh_equiv_752 vpwr.n431 vpwr.n432 185
rmesh_equiv_753 vpwr.n431 vpwr.n434 25.6005
rmesh_equiv_754 vpwr.n432 vpwr.n433 240
rmesh_equiv_755 vpwr.n432 vpwr.n493 185.00310000000002
rmesh_equiv_756 vpwr.n433 vpwr.n434 185
rmesh_equiv_757 vpwr.n433 vpwr.n436 240.00290767186621
rmesh_equiv_758 vpwr.n433 vpwr.n493 185.00310000000002
rmesh_equiv_759 vpwr.n434 vpwr.n435 25.6005
rmesh_equiv_76 vgnd.n11 vgnd.n431 159.92997981441442
rmesh_equiv_760 vpwr.n435 vpwr.n436 185
rmesh_equiv_761 vpwr.n435 vpwr.n438 25.6005
rmesh_equiv_762 vpwr.n436 vpwr.n437 240
rmesh_equiv_763 vpwr.n436 vpwr.n493 185.00310000000002
rmesh_equiv_764 vpwr.n437 vpwr.n438 185
rmesh_equiv_765 vpwr.n437 vpwr.n440 240.00290767186621
rmesh_equiv_766 vpwr.n437 vpwr.n493 185.00310000000002
rmesh_equiv_767 vpwr.n438 vpwr.n439 25.6005
rmesh_equiv_768 vpwr.n439 vpwr.n440 185
rmesh_equiv_769 vpwr.n439 vpwr.n442 25.6005
rmesh_equiv_77 vgnd.n11 vgnd.n434 2255.4737063715265
rmesh_equiv_770 vpwr.n44 vpwr.n45 25.6005
rmesh_equiv_771 vpwr.n44 vpwr.n8 81.318100000000001
rmesh_equiv_772 vpwr.n440 vpwr.n441 240
rmesh_equiv_773 vpwr.n440 vpwr.n493 185.00310000000002
rmesh_equiv_774 vpwr.n441 vpwr.n442 185
rmesh_equiv_775 vpwr.n441 vpwr.n444 240.00290767186621
rmesh_equiv_776 vpwr.n441 vpwr.n493 185.00310000000002
rmesh_equiv_777 vpwr.n442 vpwr.n443 25.6005
rmesh_equiv_778 vpwr.n443 vpwr.n444 185
rmesh_equiv_779 vpwr.n443 vpwr.n446 25.6005
rmesh_equiv_78 vgnd.n11 vgnd.n8 4696.7804438428211
rmesh_equiv_780 vpwr.n444 vpwr.n445 240
rmesh_equiv_781 vpwr.n444 vpwr.n493 185.00310000000002
rmesh_equiv_782 vpwr.n445 vpwr.n446 185
rmesh_equiv_783 vpwr.n445 vpwr.n448 240.00290767186621
rmesh_equiv_784 vpwr.n445 vpwr.n493 185.00310000000002
rmesh_equiv_785 vpwr.n446 vpwr.n447 25.6005
rmesh_equiv_786 vpwr.n447 vpwr.n448 185
rmesh_equiv_787 vpwr.n447 vpwr.n450 25.6005
rmesh_equiv_788 vpwr.n448 vpwr.n449 240
rmesh_equiv_789 vpwr.n448 vpwr.n493 185.00310000000002
rmesh_equiv_79 vgnd.n11 vgnd.t1 286.00596443069145
rmesh_equiv_790 vpwr.n449 vpwr.n450 185
rmesh_equiv_791 vpwr.n449 vpwr.n452 240.00290767186621
rmesh_equiv_792 vpwr.n449 vpwr.n493 185.00310000000002
rmesh_equiv_793 vpwr.n45 vpwr.n46 185
rmesh_equiv_794 vpwr.n45 vpwr.n48 25.6005
rmesh_equiv_795 vpwr.n450 vpwr.n451 25.6005
rmesh_equiv_796 vpwr.n451 vpwr.n452 185
rmesh_equiv_797 vpwr.n451 vpwr.n454 25.6005
rmesh_equiv_798 vpwr.n452 vpwr.n453 240
rmesh_equiv_799 vpwr.n452 vpwr.n493 185.00310000000002
rmesh_equiv_8 mir mir.t0 572.84699999999998
rmesh_equiv_80 vgnd.n14 vgnd.n422 4000.7540860304121
rmesh_equiv_800 vpwr.n453 vpwr.n454 185
rmesh_equiv_801 vpwr.n453 vpwr.n456 240.00290767186621
rmesh_equiv_802 vpwr.n453 vpwr.n493 185.00310000000002
rmesh_equiv_803 vpwr.n454 vpwr.n455 25.6005
rmesh_equiv_804 vpwr.n455 vpwr.n456 185
rmesh_equiv_805 vpwr.n455 vpwr.n458 25.6005
rmesh_equiv_806 vpwr.n456 vpwr.n457 240
rmesh_equiv_807 vpwr.n456 vpwr.n493 185.00310000000002
rmesh_equiv_808 vpwr.n457 vpwr.n458 185
rmesh_equiv_809 vpwr.n457 vpwr.n460 240.00290767186621
rmesh_equiv_81 vgnd.n14 vgnd.n423 12140.364430545695
rmesh_equiv_810 vpwr.n457 vpwr.n493 185.00310000000002
rmesh_equiv_811 vpwr.n458 vpwr.n459 25.6005
rmesh_equiv_812 vpwr.n459 vpwr.n460 185
rmesh_equiv_813 vpwr.n459 vpwr.n462 25.6005
rmesh_equiv_814 vpwr.n46 vpwr.n47 240
rmesh_equiv_815 vpwr.n460 vpwr.n461 240
rmesh_equiv_816 vpwr.n460 vpwr.n493 185.00310000000002
rmesh_equiv_817 vpwr.n461 vpwr.n462 185
rmesh_equiv_818 vpwr.n461 vpwr.n464 240.00290767186621
rmesh_equiv_819 vpwr.n461 vpwr.n493 185.00310000000002
rmesh_equiv_82 vgnd.n14 vgnd.n429 476.38846873551876
rmesh_equiv_820 vpwr.n462 vpwr.n463 25.6005
rmesh_equiv_821 vpwr.n463 vpwr.n464 185
rmesh_equiv_822 vpwr.n463 vpwr.n466 25.6005
rmesh_equiv_823 vpwr.n464 vpwr.n465 240
rmesh_equiv_824 vpwr.n464 vpwr.n493 185.00310000000002
rmesh_equiv_825 vpwr.n465 vpwr.n466 185
rmesh_equiv_826 vpwr.n465 vpwr.n468 240.00290767186621
rmesh_equiv_827 vpwr.n465 vpwr.n493 185.00310000000002
rmesh_equiv_828 vpwr.n466 vpwr.n467 25.6005
rmesh_equiv_829 vpwr.n467 vpwr.n468 185
rmesh_equiv_83 vgnd.n14 vgnd.n431 735.72356688445086
rmesh_equiv_830 vpwr.n467 vpwr.n470 25.6005
rmesh_equiv_831 vpwr.n468 vpwr.n469 240
rmesh_equiv_832 vpwr.n468 vpwr.n493 185.00310000000002
rmesh_equiv_833 vpwr.n469 vpwr.n470 185
rmesh_equiv_834 vpwr.n469 vpwr.n472 240.00290767186621
rmesh_equiv_835 vpwr.n469 vpwr.n493 185.00310000000002
rmesh_equiv_836 vpwr.n47 vpwr.n48 185
rmesh_equiv_837 vpwr.n47 vpwr.n50 240.00290767186621
rmesh_equiv_838 vpwr.n470 vpwr.n471 25.6005
rmesh_equiv_839 vpwr.n471 vpwr.n472 185
rmesh_equiv_84 vgnd.n14 vgnd.n434 310856.08631745767
rmesh_equiv_840 vpwr.n471 vpwr.n474 25.6005
rmesh_equiv_841 vpwr.n472 vpwr.n473 240
rmesh_equiv_842 vpwr.n472 vpwr.n493 185.00310000000002
rmesh_equiv_843 vpwr.n473 vpwr.n474 185
rmesh_equiv_844 vpwr.n473 vpwr.n476 240.00290767186621
rmesh_equiv_845 vpwr.n473 vpwr.n493 185.00310000000002
rmesh_equiv_846 vpwr.n474 vpwr.n475 25.6005
rmesh_equiv_847 vpwr.n475 vpwr.n476 185
rmesh_equiv_848 vpwr.n475 vpwr.n478 25.6005
rmesh_equiv_849 vpwr.n476 vpwr.n477 240
rmesh_equiv_85 vgnd.n14 vgnd.n7 1194.2697545307717
rmesh_equiv_850 vpwr.n476 vpwr.n493 185.00310000000002
rmesh_equiv_851 vpwr.n477 vpwr.n478 185
rmesh_equiv_852 vpwr.n477 vpwr.n480 240.00290767186621
rmesh_equiv_853 vpwr.n477 vpwr.n493 185.00310000000002
rmesh_equiv_854 vpwr.n478 vpwr.n479 25.6005
rmesh_equiv_855 vpwr.n479 vpwr.n480 185
rmesh_equiv_856 vpwr.n479 vpwr.n482 25.6005
rmesh_equiv_857 vpwr.n48 vpwr.n49 25.6005
rmesh_equiv_858 vpwr.n480 vpwr.n481 240
rmesh_equiv_859 vpwr.n480 vpwr.n493 185.00310000000002
rmesh_equiv_86 vgnd.n14 vgnd.n8 4359.0635051445988
rmesh_equiv_860 vpwr.n481 vpwr.n482 185
rmesh_equiv_861 vpwr.n481 vpwr.n484 240.00290767186621
rmesh_equiv_862 vpwr.n481 vpwr.n493 185.00310000000002
rmesh_equiv_863 vpwr.n482 vpwr.n483 25.6005
rmesh_equiv_864 vpwr.n483 vpwr.n484 185
rmesh_equiv_865 vpwr.n483 vpwr.n486 25.6005
rmesh_equiv_866 vpwr.n484 vpwr.n485 240
rmesh_equiv_867 vpwr.n484 vpwr.n493 185.00310000000002
rmesh_equiv_868 vpwr.n485 vpwr.n486 185
rmesh_equiv_869 vpwr.n485 vpwr.n487 240.00290767186621
rmesh_equiv_87 vgnd.n17 vgnd.n396 3299.1361787344881
rmesh_equiv_870 vpwr.n485 vpwr.n493 185.00310000000002
rmesh_equiv_871 vpwr.n486 vpwr.n488 25.6005
rmesh_equiv_872 vpwr.n487 vpwr.n488 185
rmesh_equiv_873 vpwr.n487 vpwr.n493 185.00310000000002
rmesh_equiv_874 vpwr.n488 vpwr.n489 25.6005
rmesh_equiv_875 vpwr.n489 vpwr.n490 25.6005
rmesh_equiv_876 vpwr.n49 vpwr.n50 185
rmesh_equiv_877 vpwr.n49 vpwr.n52 25.6005
rmesh_equiv_878 vpwr.n490 vpwr.n491 185
rmesh_equiv_879 vpwr.n491 vpwr.n493 185.00310000000002
rmesh_equiv_88 vgnd.n17 vgnd.n417 371.07040527335664
rmesh_equiv_880 vpwr.n493 vpwr.n495 185.00310000000002
rmesh_equiv_881 vpwr.n495 vpwr.n496 185
rmesh_equiv_882 vpwr.n496 vpwr.n497 25.6005
rmesh_equiv_883 vpwr.n497 vpwr.n498 81.318100000000001
rmesh_equiv_884 vpwr.n498 vpwr.n499 185
rmesh_equiv_885 vpwr.n499 vpwr.n500 240
rmesh_equiv_886 vpwr.n5 vpwr.n7 185
rmesh_equiv_887 vpwr.n50 vpwr.n51 240
rmesh_equiv_888 vpwr.n500 vpwr.n501 185
rmesh_equiv_889 vpwr.n501 vpwr.n502 185
rmesh_equiv_89 vgnd.n17 vgnd.n422 6425.6075900116157
rmesh_equiv_890 vpwr.n501 vpwr.t0 14.556599999999998
rmesh_equiv_891 vpwr.n502 vpwr.n503 185
rmesh_equiv_892 vpwr.n503 vpwr.n504 25.6005
rmesh_equiv_893 vpwr.n504 vpwr.n659 25.6005
rmesh_equiv_894 vpwr.n505 vpwr.n506 185
rmesh_equiv_895 vpwr.n505 vpwr.n652 25.6005
rmesh_equiv_896 vpwr.n505 vpwr.n657 25.6005
rmesh_equiv_897 vpwr.n506 vpwr.n653 240
rmesh_equiv_898 vpwr.n506 vpwr.n654 185.00310000000002
rmesh_equiv_899 vpwr.n506 vpwr.n656 240.00290767186621
rmesh_equiv_9 mir mir.t3 572.84699999999998
rmesh_equiv_90 vgnd.n17 vgnd.n423 4222.8435405157115
rmesh_equiv_900 vpwr.n51 vpwr.n52 185
rmesh_equiv_901 vpwr.n51 vpwr.n54 240.00290767186621
rmesh_equiv_902 vpwr.n52 vpwr.n53 25.6005
rmesh_equiv_903 vpwr.n53 vpwr.n54 185
rmesh_equiv_904 vpwr.n53 vpwr.n56 25.6005
rmesh_equiv_905 vpwr.n536 vpwr.n649 240.00290767186621
rmesh_equiv_906 vpwr.n536 vpwr.n651 185
rmesh_equiv_907 vpwr.n536 vpwr.n653 240
rmesh_equiv_908 vpwr.n536 vpwr.n654 185.00310000000002
rmesh_equiv_909 vpwr.n537 vpwr.n538 185
rmesh_equiv_91 vgnd.n17 vgnd.n431 14541.232354154981
rmesh_equiv_910 vpwr.n537 vpwr.n540 240.00290767186621
rmesh_equiv_911 vpwr.n537 vpwr.n654 185.00310000000002
rmesh_equiv_912 vpwr.n538 vpwr.n539 25.6005
rmesh_equiv_913 vpwr.n539 vpwr.n540 185
rmesh_equiv_914 vpwr.n539 vpwr.n542 25.6005
rmesh_equiv_915 vpwr.n54 vpwr.n55 240
rmesh_equiv_916 vpwr.n540 vpwr.n541 240
rmesh_equiv_917 vpwr.n540 vpwr.n654 185.00310000000002
rmesh_equiv_918 vpwr.n541 vpwr.n542 185
rmesh_equiv_919 vpwr.n541 vpwr.n544 240.00290767186621
rmesh_equiv_92 vgnd.n17 vgnd.n434 1513.717614291691
rmesh_equiv_920 vpwr.n541 vpwr.n654 185.00310000000002
rmesh_equiv_921 vpwr.n542 vpwr.n543 25.6005
rmesh_equiv_922 vpwr.n543 vpwr.n544 185
rmesh_equiv_923 vpwr.n543 vpwr.n546 25.6005
rmesh_equiv_924 vpwr.n544 vpwr.n545 240
rmesh_equiv_925 vpwr.n544 vpwr.n654 185.00310000000002
rmesh_equiv_926 vpwr.n545 vpwr.n546 185
rmesh_equiv_927 vpwr.n545 vpwr.n548 240.00290767186621
rmesh_equiv_928 vpwr.n545 vpwr.n654 185.00310000000002
rmesh_equiv_929 vpwr.n546 vpwr.n547 25.6005
rmesh_equiv_93 vgnd.n17 vgnd.n8 9793.5821325419893
rmesh_equiv_930 vpwr.n547 vpwr.n548 185
rmesh_equiv_931 vpwr.n547 vpwr.n550 25.6005
rmesh_equiv_932 vpwr.n548 vpwr.n549 240
rmesh_equiv_933 vpwr.n548 vpwr.n654 185.00310000000002
rmesh_equiv_934 vpwr.n549 vpwr.n550 185
rmesh_equiv_935 vpwr.n549 vpwr.n552 240.00290767186621
rmesh_equiv_936 vpwr.n549 vpwr.n654 185.00310000000002
rmesh_equiv_937 vpwr.n55 vpwr.n56 185
rmesh_equiv_938 vpwr.n55 vpwr.n58 240.00290767186621
rmesh_equiv_939 vpwr.n550 vpwr.n551 25.6005
rmesh_equiv_94 vgnd.n17 vgnd.t1 561.63818523152702
rmesh_equiv_940 vpwr.n551 vpwr.n552 185
rmesh_equiv_941 vpwr.n551 vpwr.n554 25.6005
rmesh_equiv_942 vpwr.n552 vpwr.n553 240
rmesh_equiv_943 vpwr.n552 vpwr.n654 185.00310000000002
rmesh_equiv_944 vpwr.n553 vpwr.n554 185
rmesh_equiv_945 vpwr.n553 vpwr.n556 240.00290767186621
rmesh_equiv_946 vpwr.n553 vpwr.n654 185.00310000000002
rmesh_equiv_947 vpwr.n554 vpwr.n555 25.6005
rmesh_equiv_948 vpwr.n555 vpwr.n556 185
rmesh_equiv_949 vpwr.n555 vpwr.n558 25.6005
rmesh_equiv_95 vgnd.n396 vgnd.n417 424.09304358761949
rmesh_equiv_950 vpwr.n556 vpwr.n557 240
rmesh_equiv_951 vpwr.n556 vpwr.n654 185.00310000000002
rmesh_equiv_952 vpwr.n557 vpwr.n558 185
rmesh_equiv_953 vpwr.n557 vpwr.n560 240.00290767186621
rmesh_equiv_954 vpwr.n557 vpwr.n654 185.00310000000002
rmesh_equiv_955 vpwr.n558 vpwr.n559 25.6005
rmesh_equiv_956 vpwr.n559 vpwr.n560 185
rmesh_equiv_957 vpwr.n559 vpwr.n562 25.6005
rmesh_equiv_958 vpwr.n56 vpwr.n57 25.6005
rmesh_equiv_959 vpwr.n560 vpwr.n561 240
rmesh_equiv_96 vgnd.n396 vgnd.n422 6737.727880780436
rmesh_equiv_960 vpwr.n560 vpwr.n654 185.00310000000002
rmesh_equiv_961 vpwr.n561 vpwr.n562 185
rmesh_equiv_962 vpwr.n561 vpwr.n564 240.00290767186621
rmesh_equiv_963 vpwr.n561 vpwr.n654 185.00310000000002
rmesh_equiv_964 vpwr.n562 vpwr.n563 25.6005
rmesh_equiv_965 vpwr.n563 vpwr.n564 185
rmesh_equiv_966 vpwr.n563 vpwr.n566 25.6005
rmesh_equiv_967 vpwr.n564 vpwr.n565 240
rmesh_equiv_968 vpwr.n564 vpwr.n654 185.00310000000002
rmesh_equiv_969 vpwr.n565 vpwr.n566 185
rmesh_equiv_97 vgnd.n396 vgnd.n423 577.78826014515914
rmesh_equiv_970 vpwr.n565 vpwr.n568 240.00290767186621
rmesh_equiv_971 vpwr.n565 vpwr.n654 185.00310000000002
rmesh_equiv_972 vpwr.n566 vpwr.n567 25.6005
rmesh_equiv_973 vpwr.n567 vpwr.n568 185
rmesh_equiv_974 vpwr.n567 vpwr.n570 25.6005
rmesh_equiv_975 vpwr.n568 vpwr.n569 240
rmesh_equiv_976 vpwr.n568 vpwr.n654 185.00310000000002
rmesh_equiv_977 vpwr.n569 vpwr.n570 185
rmesh_equiv_978 vpwr.n569 vpwr.n572 240.00290767186621
rmesh_equiv_979 vpwr.n569 vpwr.n654 185.00310000000002
rmesh_equiv_98 vgnd.n396 vgnd.n7 144872.40315891572
rmesh_equiv_980 vpwr.n57 vpwr.n58 185
rmesh_equiv_981 vpwr.n57 vpwr.n60 25.6005
rmesh_equiv_982 vpwr.n570 vpwr.n571 25.6005
rmesh_equiv_983 vpwr.n571 vpwr.n572 185
rmesh_equiv_984 vpwr.n571 vpwr.n574 25.6005
rmesh_equiv_985 vpwr.n572 vpwr.n573 240
rmesh_equiv_986 vpwr.n572 vpwr.n654 185.00310000000002
rmesh_equiv_987 vpwr.n573 vpwr.n574 185
rmesh_equiv_988 vpwr.n573 vpwr.n576 240.00290767186621
rmesh_equiv_989 vpwr.n573 vpwr.n654 185.00310000000002
rmesh_equiv_99 vgnd.n396 vgnd.t0 1906175.2593709521
rmesh_equiv_990 vpwr.n574 vpwr.n575 25.6005
rmesh_equiv_991 vpwr.n575 vpwr.n576 185
rmesh_equiv_992 vpwr.n575 vpwr.n578 25.6005
rmesh_equiv_993 vpwr.n576 vpwr.n577 240
rmesh_equiv_994 vpwr.n576 vpwr.n654 185.00310000000002
rmesh_equiv_995 vpwr.n577 vpwr.n578 185
rmesh_equiv_996 vpwr.n577 vpwr.n580 240.00290767186621
rmesh_equiv_997 vpwr.n577 vpwr.n654 185.00310000000002
rmesh_equiv_998 vpwr.n578 vpwr.n579 25.6005
rmesh_equiv_999 vpwr.n579 vpwr.n580 185
.ends

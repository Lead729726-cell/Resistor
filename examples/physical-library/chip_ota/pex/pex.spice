* NGSPICE file created from chip_ota.ext - technology: sky130A

.subckt chip_ota VGND BIAS OUT VPWR INN INP
X0 TAIL.t2 INN.t0 MIR.t2 VGND.t3 sky130_fd_pr__nfet_01v8 ad=2.9 pd=20.58 as=2.9 ps=20.58 w=10 l=1
X1 VGND.t2 BIAS.t0 TAIL.t1 VGND.t1 sky130_fd_pr__nfet_01v8 ad=0.58 pd=4.58 as=0.58 ps=4.58 w=2 l=1
X2 TAIL.t0 INP.t0 OUT.t0 VGND.t0 sky130_fd_pr__nfet_01v8 ad=2.9 pd=20.58 as=2.9 ps=20.58 w=10 l=1
X3 VPWR.t3 MIR.t0 MIR.t1 VPWR.t2 sky130_fd_pr__pfet_01v8_hvt ad=5.8 pd=40.58 as=5.8 ps=40.58 w=20 l=1
X4 VPWR.t1 MIR.t3 OUT.t1 VPWR.t0 sky130_fd_pr__pfet_01v8_hvt ad=5.8 pd=40.58 as=5.8 ps=40.58 w=20 l=1
C0 TAIL OUT 1.16127f
C1 INP INN 0.37624f
C2 INP MIR 0.11267f
C3 INN BIAS 0
C4 MIR BIAS 0.07299f
C5 VPWR BIAS 0.00587f
C6 INP OUT 0.43696f
C7 BIAS OUT 1.62422f
C8 MIR INN 0.79371f
C9 VPWR INN 0.00367f
C10 VPWR MIR 5.35602f
C11 INN OUT 0.928f
C12 MIR OUT 1.38657f
C13 VPWR OUT 2.87278f
C14 INP TAIL 0.9714f
C15 BIAS TAIL 2.39602f
C16 INP BIAS 0
C17 INN TAIL 1.09995f
C18 MIR TAIL 1.24985f
C19 VPWR TAIL 0.04677f
R0 INN INN.t0 332.712
R1 MIR MIR.t0 572.847
R2 MIR MIR.t3 572.847
R3 MIR.n8 MIR.t1 387.11
R4 MIR.t1 MIR.n0 381.113
R5 MIR.n4 MIR 33.1304
R6 MIR.n1 MIR 27.3061
R7 MIR.n1 MIR 26.3826
R8 MIR MIR.n0 22.8553
R9 MIR.n4 MIR.n3 14.1214
R10 MIR.n6 MIR.n5 13.9994
R11 MIR.n3 MIR.n2 13.3893
R12 MIR.n7 MIR.n6 13.0823
R13 MIR.n7 MIR.n0 11.4361
R14 MIR MIR.n2 6.32004
R15 MIR MIR.n8 4.87707
R16 MIR.n8 MIR.n7 2.44078
R17 MIR.n3 MIR.t2 1.7405
R18 MIR.n5 MIR.n4 1.13588
R19 MIR.n5 MIR.n2 0.755154
R20 MIR.n6 MIR.n1 0.393537
R21 TAIL.n2 TAIL.t1 181.41
R22 TAIL.t1 TAIL.n1 174.912
R23 TAIL.n6 TAIL 33.1304
R24 TAIL TAIL.n0 33.1304
R25 TAIL TAIL.n1 19.837
R26 TAIL.n8 TAIL.n3 17.2482
R27 TAIL.n9 TAIL.n8 15.6596
R28 TAIL.n8 TAIL.n7 14.749
R29 TAIL.n3 TAIL.n1 14.1895
R30 TAIL.n6 TAIL.n5 14.1214
R31 TAIL.n10 TAIL.n0 14.1214
R32 TAIL.n5 TAIL.n4 13.3893
R33 TAIL.n11 TAIL.n10 13.3893
R34 TAIL TAIL.n4 6.32004
R35 TAIL TAIL.n11 6.32004
R36 TAIL.n2 TAIL 4.259
R37 TAIL.n3 TAIL.n2 3.04672
R38 TAIL.n5 TAIL.t2 1.7405
R39 TAIL.n10 TAIL.t0 1.7405
R40 TAIL.n7 TAIL.n6 1.13588
R41 TAIL.n9 TAIL.n0 1.13588
R42 TAIL.n7 TAIL.n4 0.755154
R43 TAIL.n11 TAIL.n9 0.755154
R44 VGND.n396 VGND.n395 11884.9
R45 VGND.n395 VGND.n7 10641.4
R46 VGND.n410 VGND.n24 1210.97
R47 VGND.n408 VGND.n397 1210.97
R48 VGND.n426 VGND.n14 1210.97
R49 VGND.n436 VGND.n8 1210.97
R50 VGND.n392 VGND.n43 1118.26
R51 VGND.n211 VGND.n147 1118.26
R52 VGND.n111 VGND.n41 1118.26
R53 VGND.n149 VGND.n144 1118.26
R54 VGND.n229 VGND.n124 1118.26
R55 VGND.n377 VGND.n122 1118.26
R56 VGND.n315 VGND.n119 1118.26
R57 VGND.n293 VGND.n126 1118.26
R58 VGND.n395 VGND.n394 954.418
R59 VGND.n287 VGND.n213 681.567
R60 VGND.n408 VGND.n407 585
R61 VGND.n409 VGND.n408 585
R62 VGND.n19 VGND.n18 585
R63 VGND.n20 VGND.n19 585
R64 VGND.n417 VGND.n416 585
R65 VGND.n416 VGND.n415 585
R66 VGND.n418 VGND.n17 585
R67 VGND.n21 VGND.n17 585
R68 VGND.n420 VGND.n419 585
R69 VGND.n421 VGND.n420 585
R70 VGND.n10 VGND.n9 585
R71 VGND.n11 VGND.n10 585
R72 VGND.n433 VGND.n432 585
R73 VGND.n432 VGND.n431 585
R74 VGND.n434 VGND.n8 585
R75 VGND.n12 VGND.n8 585
R76 VGND.n436 VGND.n435 585
R77 VGND.n438 VGND.n5 585
R78 VGND VGND.n439 585
R79 VGND.n425 VGND.n0 585
R80 VGND.n427 VGND.n426 585
R81 VGND.n426 VGND.n7 585
R82 VGND.n428 VGND.n14 585
R83 VGND.n14 VGND.n12 585
R84 VGND.n430 VGND.n429 585
R85 VGND.n431 VGND.n430 585
R86 VGND.n424 VGND.n13 585
R87 VGND.n13 VGND.n11 585
R88 VGND.n423 VGND.n422 585
R89 VGND.n422 VGND.n421 585
R90 VGND.n16 VGND.n15 585
R91 VGND.n21 VGND.n16 585
R92 VGND.n414 VGND.n413 585
R93 VGND.n415 VGND.n414 585
R94 VGND.n412 VGND.n22 585
R95 VGND.n22 VGND.n20 585
R96 VGND.n411 VGND.n410 585
R97 VGND.n410 VGND.n409 585
R98 VGND.n24 VGND.n23 585
R99 VGND.n401 VGND.n399 585
R100 VGND.n402 VGND.n398 585
R101 VGND.n402 VGND.n396 585
R102 VGND.n405 VGND.n404 585
R103 VGND.n406 VGND.n397 585
R104 VGND.n211 VGND.n210 585
R105 VGND.n209 VGND.n146 585
R106 VGND.n208 VGND.n145 585
R107 VGND.n213 VGND.n145 585
R108 VGND.n207 VGND.n206 585
R109 VGND.n205 VGND.n204 585
R110 VGND.n203 VGND.n202 585
R111 VGND.n201 VGND.n200 585
R112 VGND.n199 VGND.n198 585
R113 VGND.n197 VGND.n196 585
R114 VGND.n195 VGND.n194 585
R115 VGND.n193 VGND.n192 585
R116 VGND.n191 VGND.n190 585
R117 VGND.n189 VGND.n188 585
R118 VGND.n187 VGND.n186 585
R119 VGND.n185 VGND.n184 585
R120 VGND.n183 VGND.n182 585
R121 VGND.n181 VGND.n180 585
R122 VGND.n179 VGND.n178 585
R123 VGND.n177 VGND.n176 585
R124 VGND.n175 VGND.n174 585
R125 VGND.n173 VGND.n172 585
R126 VGND.n171 VGND.n170 585
R127 VGND.n169 VGND.n168 585
R128 VGND.n167 VGND.n166 585
R129 VGND.n165 VGND.n164 585
R130 VGND.n163 VGND.n162 585
R131 VGND.n161 VGND.n160 585
R132 VGND.n159 VGND.n158 585
R133 VGND.n157 VGND.n156 585
R134 VGND.n155 VGND.n154 585
R135 VGND.n153 VGND.n152 585
R136 VGND.n151 VGND.n144 585
R137 VGND.n213 VGND.n144 585
R138 VGND.n150 VGND.n149 585
R139 VGND.n149 VGND.n129 585
R140 VGND.n115 VGND.n50 585
R141 VGND.n50 VGND.n48 585
R142 VGND.n387 VGND 585
R143 VGND.t3 VGND.n387 585
R144 VGND.n114 VGND.n49 585
R145 VGND.n49 VGND.n42 585
R146 VGND.n113 VGND.n41 585
R147 VGND.n393 VGND.n41 585
R148 VGND.n112 VGND.n111 585
R149 VGND.n110 VGND.n109 585
R150 VGND.n108 VGND.n107 585
R151 VGND.n106 VGND.n105 585
R152 VGND.n104 VGND.n103 585
R153 VGND.n102 VGND.n101 585
R154 VGND.n100 VGND.n99 585
R155 VGND.n98 VGND.n97 585
R156 VGND.n96 VGND.n95 585
R157 VGND.n94 VGND.n93 585
R158 VGND.n92 VGND.n91 585
R159 VGND.n90 VGND.n89 585
R160 VGND.n88 VGND.n87 585
R161 VGND.n86 VGND.n85 585
R162 VGND.n84 VGND.n83 585
R163 VGND.n82 VGND.n81 585
R164 VGND.n80 VGND.n79 585
R165 VGND.n78 VGND.n77 585
R166 VGND.n76 VGND.n75 585
R167 VGND.n74 VGND.n73 585
R168 VGND.n72 VGND.n71 585
R169 VGND.n70 VGND.n69 585
R170 VGND.n68 VGND.n67 585
R171 VGND.n66 VGND.n65 585
R172 VGND.n64 VGND.n63 585
R173 VGND.n62 VGND.n61 585
R174 VGND.n60 VGND.n59 585
R175 VGND.n58 VGND.n57 585
R176 VGND.n56 VGND.n55 585
R177 VGND.n54 VGND.n53 585
R178 VGND.n52 VGND.n51 585
R179 VGND.n45 VGND.n43 585
R180 VGND.n392 VGND.n391 585
R181 VGND.n393 VGND.n392 585
R182 VGND.n390 VGND.n44 585
R183 VGND.n44 VGND.n42 585
R184 VGND.n389 VGND.n388 585
R185 VGND.n388 VGND.t3 585
R186 VGND.n47 VGND.n46 585
R187 VGND.n48 VGND.n47 585
R188 VGND.n148 VGND.n147 585
R189 VGND.n147 VGND.n129 585
R190 VGND.n291 VGND.n126 585
R191 VGND.n290 VGND.n289 585
R192 VGND.n128 VGND.n127 585
R193 VGND.n285 VGND.n284 585
R194 VGND.n283 VGND.n228 585
R195 VGND.n282 VGND.n281 585
R196 VGND.n280 VGND.n279 585
R197 VGND.n278 VGND.n277 585
R198 VGND.n276 VGND.n275 585
R199 VGND.n274 VGND.n273 585
R200 VGND.n272 VGND.n271 585
R201 VGND.n270 VGND.n269 585
R202 VGND.n268 VGND.n267 585
R203 VGND.n266 VGND.n265 585
R204 VGND.n264 VGND.n263 585
R205 VGND.n262 VGND.n261 585
R206 VGND.n260 VGND.n259 585
R207 VGND.n258 VGND.n257 585
R208 VGND.n256 VGND.n255 585
R209 VGND.n254 VGND.n253 585
R210 VGND.n252 VGND.n251 585
R211 VGND.n250 VGND.n249 585
R212 VGND.n248 VGND.n247 585
R213 VGND.n246 VGND.n245 585
R214 VGND.n244 VGND.n243 585
R215 VGND.n242 VGND.n241 585
R216 VGND.n240 VGND.n239 585
R217 VGND.n238 VGND.n237 585
R218 VGND.n236 VGND.n235 585
R219 VGND.n234 VGND.n233 585
R220 VGND.n232 VGND.n231 585
R221 VGND.n230 VGND.n229 585
R222 VGND.n124 VGND.n123 585
R223 VGND.n125 VGND.n124 585
R224 VGND.n297 VGND.n296 585
R225 VGND.n296 VGND.n295 585
R226 VGND.n298 VGND.n121 585
R227 VGND.n121 VGND.t0 585
R228 VGND.n381 VGND.n380 585
R229 VGND.n382 VGND.n381 585
R230 VGND.n379 VGND.n122 585
R231 VGND.n122 VGND.n120 585
R232 VGND.n378 VGND.n377 585
R233 VGND.n300 VGND.n299 585
R234 VGND.n374 VGND.n373 585
R235 VGND.n375 VGND.n374 585
R236 VGND.n372 VGND.n316 585
R237 VGND.n371 VGND.n370 585
R238 VGND.n369 VGND.n368 585
R239 VGND.n367 VGND.n366 585
R240 VGND.n365 VGND.n364 585
R241 VGND.n363 VGND.n362 585
R242 VGND.n361 VGND.n360 585
R243 VGND.n359 VGND.n358 585
R244 VGND.n357 VGND.n356 585
R245 VGND.n355 VGND.n354 585
R246 VGND.n353 VGND.n352 585
R247 VGND.n351 VGND.n350 585
R248 VGND.n349 VGND.n348 585
R249 VGND.n347 VGND.n346 585
R250 VGND.n345 VGND.n344 585
R251 VGND.n343 VGND.n342 585
R252 VGND.n341 VGND.n340 585
R253 VGND.n339 VGND.n338 585
R254 VGND.n337 VGND.n336 585
R255 VGND.n335 VGND.n334 585
R256 VGND.n333 VGND.n332 585
R257 VGND.n331 VGND.n330 585
R258 VGND.n329 VGND.n328 585
R259 VGND.n327 VGND.n326 585
R260 VGND.n325 VGND.n324 585
R261 VGND.n323 VGND.n322 585
R262 VGND.n321 VGND.n320 585
R263 VGND.n319 VGND.n318 585
R264 VGND.n317 VGND.n315 585
R265 VGND.n375 VGND.n315 585
R266 VGND.n119 VGND.n118 585
R267 VGND.n120 VGND.n119 585
R268 VGND.n384 VGND.n383 585
R269 VGND.n383 VGND.n382 585
R270 VGND VGND.n117 585
R271 VGND.t0 VGND.n117 585
R272 VGND.n294 VGND.n116 585
R273 VGND.n295 VGND.n294 585
R274 VGND.n293 VGND.n292 585
R275 VGND.n293 VGND.n125 585
R276 VGND.n392 VGND.n44 394
R277 VGND.n388 VGND.n44 394
R278 VGND.n388 VGND.n47 394
R279 VGND.n147 VGND.n47 394
R280 VGND.n53 VGND.n52 394
R281 VGND.n57 VGND.n56 394
R282 VGND.n61 VGND.n60 394
R283 VGND.n65 VGND.n64 394
R284 VGND.n69 VGND.n68 394
R285 VGND.n73 VGND.n72 394
R286 VGND.n77 VGND.n76 394
R287 VGND.n81 VGND.n80 394
R288 VGND.n85 VGND.n84 394
R289 VGND.n89 VGND.n88 394
R290 VGND.n93 VGND.n92 394
R291 VGND.n97 VGND.n96 394
R292 VGND.n101 VGND.n100 394
R293 VGND.n105 VGND.n104 394
R294 VGND.n109 VGND.n108 394
R295 VGND.n49 VGND.n41 394
R296 VGND.n387 VGND.n49 394
R297 VGND.n387 VGND.n50 394
R298 VGND.n149 VGND.n50 394
R299 VGND.n146 VGND.n145 394
R300 VGND.n206 VGND.n145 394
R301 VGND.n204 VGND.n203 394
R302 VGND.n200 VGND.n199 394
R303 VGND.n196 VGND.n195 394
R304 VGND.n192 VGND.n191 394
R305 VGND.n188 VGND.n187 394
R306 VGND.n184 VGND.n183 394
R307 VGND.n180 VGND.n179 394
R308 VGND.n176 VGND.n175 394
R309 VGND.n172 VGND.n171 394
R310 VGND.n168 VGND.n167 394
R311 VGND.n164 VGND.n163 394
R312 VGND.n160 VGND.n159 394
R313 VGND.n156 VGND.n155 394
R314 VGND.n152 VGND.n144 394
R315 VGND.n402 VGND.n401 394
R316 VGND.n404 VGND.n402 394
R317 VGND.n410 VGND.n22 394
R318 VGND.n414 VGND.n22 394
R319 VGND.n414 VGND.n16 394
R320 VGND.n422 VGND.n16 394
R321 VGND.n422 VGND.n13 394
R322 VGND.n430 VGND.n13 394
R323 VGND.n430 VGND.n14 394
R324 VGND.n426 VGND.n425 394
R325 VGND.n439 VGND.n438 394
R326 VGND.n408 VGND.n19 394
R327 VGND.n416 VGND.n19 394
R328 VGND.n416 VGND.n17 394
R329 VGND.n420 VGND.n17 394
R330 VGND.n420 VGND.n10 394
R331 VGND.n432 VGND.n10 394
R332 VGND.n432 VGND.n8 394
R333 VGND.n296 VGND.n124 394
R334 VGND.n296 VGND.n121 394
R335 VGND.n381 VGND.n121 394
R336 VGND.n381 VGND.n122 394
R337 VGND.n374 VGND.n300 394
R338 VGND.n374 VGND.n316 394
R339 VGND.n370 VGND.n369 394
R340 VGND.n366 VGND.n365 394
R341 VGND.n362 VGND.n361 394
R342 VGND.n358 VGND.n357 394
R343 VGND.n354 VGND.n353 394
R344 VGND.n350 VGND.n349 394
R345 VGND.n346 VGND.n345 394
R346 VGND.n342 VGND.n341 394
R347 VGND.n338 VGND.n337 394
R348 VGND.n334 VGND.n333 394
R349 VGND.n330 VGND.n329 394
R350 VGND.n326 VGND.n325 394
R351 VGND.n322 VGND.n321 394
R352 VGND.n318 VGND.n315 394
R353 VGND.n294 VGND.n293 394
R354 VGND.n294 VGND.n117 394
R355 VGND.n383 VGND.n117 394
R356 VGND.n383 VGND.n119 394
R357 VGND.n233 VGND.n232 394
R358 VGND.n237 VGND.n236 394
R359 VGND.n241 VGND.n240 394
R360 VGND.n245 VGND.n244 394
R361 VGND.n249 VGND.n248 394
R362 VGND.n253 VGND.n252 394
R363 VGND.n257 VGND.n256 394
R364 VGND.n261 VGND.n260 394
R365 VGND.n265 VGND.n264 394
R366 VGND.n269 VGND.n268 394
R367 VGND.n273 VGND.n272 394
R368 VGND.n277 VGND.n276 394
R369 VGND.n281 VGND.n280 394
R370 VGND.n285 VGND.n228 394
R371 VGND.n289 VGND.n128 394
R372 VGND.n409 VGND.n396 291.863
R373 VGND.n12 VGND.n7 291.863
R374 VGND.n437 VGND.n7 218.815
R375 VGND.n7 VGND.n6 218.815
R376 VGND.n400 VGND.n396 218.815
R377 VGND.n403 VGND.n396 218.815
R378 VGND.n213 VGND.n212 218.815
R379 VGND.n213 VGND.n130 218.815
R380 VGND.n213 VGND.n131 218.815
R381 VGND.n213 VGND.n132 218.815
R382 VGND.n213 VGND.n133 218.815
R383 VGND.n213 VGND.n134 218.815
R384 VGND.n213 VGND.n135 218.815
R385 VGND.n213 VGND.n136 218.815
R386 VGND.n213 VGND.n137 218.815
R387 VGND.n213 VGND.n138 218.815
R388 VGND.n213 VGND.n139 218.815
R389 VGND.n213 VGND.n140 218.815
R390 VGND.n213 VGND.n141 218.815
R391 VGND.n213 VGND.n142 218.815
R392 VGND.n213 VGND.n143 218.815
R393 VGND.n394 VGND.n40 218.815
R394 VGND.n394 VGND.n39 218.815
R395 VGND.n394 VGND.n38 218.815
R396 VGND.n394 VGND.n37 218.815
R397 VGND.n394 VGND.n36 218.815
R398 VGND.n394 VGND.n35 218.815
R399 VGND.n394 VGND.n34 218.815
R400 VGND.n394 VGND.n33 218.815
R401 VGND.n394 VGND.n32 218.815
R402 VGND.n394 VGND.n31 218.815
R403 VGND.n394 VGND.n30 218.815
R404 VGND.n394 VGND.n29 218.815
R405 VGND.n394 VGND.n28 218.815
R406 VGND.n394 VGND.n27 218.815
R407 VGND.n394 VGND.n26 218.815
R408 VGND.n394 VGND.n25 218.815
R409 VGND.n288 VGND.n287 218.815
R410 VGND.n287 VGND.n286 218.815
R411 VGND.n287 VGND.n227 218.815
R412 VGND.n287 VGND.n226 218.815
R413 VGND.n287 VGND.n225 218.815
R414 VGND.n287 VGND.n224 218.815
R415 VGND.n287 VGND.n223 218.815
R416 VGND.n287 VGND.n222 218.815
R417 VGND.n287 VGND.n221 218.815
R418 VGND.n287 VGND.n220 218.815
R419 VGND.n287 VGND.n219 218.815
R420 VGND.n287 VGND.n218 218.815
R421 VGND.n287 VGND.n217 218.815
R422 VGND.n287 VGND.n216 218.815
R423 VGND.n287 VGND.n215 218.815
R424 VGND.n287 VGND.n214 218.815
R425 VGND.n376 VGND.n375 218.815
R426 VGND.n375 VGND.n301 218.815
R427 VGND.n375 VGND.n302 218.815
R428 VGND.n375 VGND.n303 218.815
R429 VGND.n375 VGND.n304 218.815
R430 VGND.n375 VGND.n305 218.815
R431 VGND.n375 VGND.n306 218.815
R432 VGND.n375 VGND.n307 218.815
R433 VGND.n375 VGND.n308 218.815
R434 VGND.n375 VGND.n309 218.815
R435 VGND.n375 VGND.n310 218.815
R436 VGND.n375 VGND.n311 218.815
R437 VGND.n375 VGND.n312 218.815
R438 VGND.n375 VGND.n313 218.815
R439 VGND.n375 VGND.n314 218.815
R440 VGND.n2 VGND.t2 181.41
R441 VGND.t2 VGND.n1 174.912
R442 VGND.n409 VGND.n20 166.779
R443 VGND.n415 VGND.n20 166.779
R444 VGND.n415 VGND.n21 166.779
R445 VGND.n421 VGND.n11 166.779
R446 VGND.n431 VGND.n11 166.779
R447 VGND.n431 VGND.n12 166.779
R448 VGND.n52 VGND.n25 147.374
R449 VGND.n56 VGND.n26 147.374
R450 VGND.n60 VGND.n27 147.374
R451 VGND.n64 VGND.n28 147.374
R452 VGND.n68 VGND.n29 147.374
R453 VGND.n72 VGND.n30 147.374
R454 VGND.n76 VGND.n31 147.374
R455 VGND.n80 VGND.n32 147.374
R456 VGND.n84 VGND.n33 147.374
R457 VGND.n88 VGND.n34 147.374
R458 VGND.n92 VGND.n35 147.374
R459 VGND.n96 VGND.n36 147.374
R460 VGND.n100 VGND.n37 147.374
R461 VGND.n104 VGND.n38 147.374
R462 VGND.n108 VGND.n39 147.374
R463 VGND.n111 VGND.n40 147.374
R464 VGND.n212 VGND.n211 147.374
R465 VGND.n206 VGND.n130 147.374
R466 VGND.n203 VGND.n131 147.374
R467 VGND.n199 VGND.n132 147.374
R468 VGND.n195 VGND.n133 147.374
R469 VGND.n191 VGND.n134 147.374
R470 VGND.n187 VGND.n135 147.374
R471 VGND.n183 VGND.n136 147.374
R472 VGND.n179 VGND.n137 147.374
R473 VGND.n175 VGND.n138 147.374
R474 VGND.n171 VGND.n139 147.374
R475 VGND.n167 VGND.n140 147.374
R476 VGND.n163 VGND.n141 147.374
R477 VGND.n159 VGND.n142 147.374
R478 VGND.n155 VGND.n143 147.374
R479 VGND.n400 VGND.n24 147.374
R480 VGND.n404 VGND.n403 147.374
R481 VGND.n439 VGND.n6 147.374
R482 VGND.n437 VGND.n436 147.374
R483 VGND.n438 VGND.n437 147.374
R484 VGND.n425 VGND.n6 147.374
R485 VGND.n401 VGND.n400 147.374
R486 VGND.n403 VGND.n397 147.374
R487 VGND.n212 VGND.n146 147.374
R488 VGND.n204 VGND.n130 147.374
R489 VGND.n200 VGND.n131 147.374
R490 VGND.n196 VGND.n132 147.374
R491 VGND.n192 VGND.n133 147.374
R492 VGND.n188 VGND.n134 147.374
R493 VGND.n184 VGND.n135 147.374
R494 VGND.n180 VGND.n136 147.374
R495 VGND.n176 VGND.n137 147.374
R496 VGND.n172 VGND.n138 147.374
R497 VGND.n168 VGND.n139 147.374
R498 VGND.n164 VGND.n140 147.374
R499 VGND.n160 VGND.n141 147.374
R500 VGND.n156 VGND.n142 147.374
R501 VGND.n152 VGND.n143 147.374
R502 VGND.n109 VGND.n40 147.374
R503 VGND.n105 VGND.n39 147.374
R504 VGND.n101 VGND.n38 147.374
R505 VGND.n97 VGND.n37 147.374
R506 VGND.n93 VGND.n36 147.374
R507 VGND.n89 VGND.n35 147.374
R508 VGND.n85 VGND.n34 147.374
R509 VGND.n81 VGND.n33 147.374
R510 VGND.n77 VGND.n32 147.374
R511 VGND.n73 VGND.n31 147.374
R512 VGND.n69 VGND.n30 147.374
R513 VGND.n65 VGND.n29 147.374
R514 VGND.n61 VGND.n28 147.374
R515 VGND.n57 VGND.n27 147.374
R516 VGND.n53 VGND.n26 147.374
R517 VGND.n43 VGND.n25 147.374
R518 VGND.n377 VGND.n376 147.374
R519 VGND.n316 VGND.n301 147.374
R520 VGND.n369 VGND.n302 147.374
R521 VGND.n365 VGND.n303 147.374
R522 VGND.n361 VGND.n304 147.374
R523 VGND.n357 VGND.n305 147.374
R524 VGND.n353 VGND.n306 147.374
R525 VGND.n349 VGND.n307 147.374
R526 VGND.n345 VGND.n308 147.374
R527 VGND.n341 VGND.n309 147.374
R528 VGND.n337 VGND.n310 147.374
R529 VGND.n333 VGND.n311 147.374
R530 VGND.n329 VGND.n312 147.374
R531 VGND.n325 VGND.n313 147.374
R532 VGND.n321 VGND.n314 147.374
R533 VGND.n229 VGND.n214 147.374
R534 VGND.n233 VGND.n215 147.374
R535 VGND.n237 VGND.n216 147.374
R536 VGND.n241 VGND.n217 147.374
R537 VGND.n245 VGND.n218 147.374
R538 VGND.n249 VGND.n219 147.374
R539 VGND.n253 VGND.n220 147.374
R540 VGND.n257 VGND.n221 147.374
R541 VGND.n261 VGND.n222 147.374
R542 VGND.n265 VGND.n223 147.374
R543 VGND.n269 VGND.n224 147.374
R544 VGND.n273 VGND.n225 147.374
R545 VGND.n277 VGND.n226 147.374
R546 VGND.n281 VGND.n227 147.374
R547 VGND.n286 VGND.n285 147.374
R548 VGND.n289 VGND.n288 147.374
R549 VGND.n288 VGND.n126 147.374
R550 VGND.n286 VGND.n128 147.374
R551 VGND.n228 VGND.n227 147.374
R552 VGND.n280 VGND.n226 147.374
R553 VGND.n276 VGND.n225 147.374
R554 VGND.n272 VGND.n224 147.374
R555 VGND.n268 VGND.n223 147.374
R556 VGND.n264 VGND.n222 147.374
R557 VGND.n260 VGND.n221 147.374
R558 VGND.n256 VGND.n220 147.374
R559 VGND.n252 VGND.n219 147.374
R560 VGND.n248 VGND.n218 147.374
R561 VGND.n244 VGND.n217 147.374
R562 VGND.n240 VGND.n216 147.374
R563 VGND.n236 VGND.n215 147.374
R564 VGND.n232 VGND.n214 147.374
R565 VGND.n376 VGND.n300 147.374
R566 VGND.n370 VGND.n301 147.374
R567 VGND.n366 VGND.n302 147.374
R568 VGND.n362 VGND.n303 147.374
R569 VGND.n358 VGND.n304 147.374
R570 VGND.n354 VGND.n305 147.374
R571 VGND.n350 VGND.n306 147.374
R572 VGND.n346 VGND.n307 147.374
R573 VGND.n342 VGND.n308 147.374
R574 VGND.n338 VGND.n309 147.374
R575 VGND.n334 VGND.n310 147.374
R576 VGND.n330 VGND.n311 147.374
R577 VGND.n326 VGND.n312 147.374
R578 VGND.n322 VGND.n313 147.374
R579 VGND.n318 VGND.n314 147.374
R580 VGND.n21 VGND.t1 83.3896
R581 VGND.n421 VGND.t1 83.3896
R582 VGND.n411 VGND.n23 78.6829
R583 VGND.n407 VGND.n406 78.6829
R584 VGND.n428 VGND.n427 78.6829
R585 VGND.n435 VGND.n434 78.6829
R586 VGND.n391 VGND.n45 72.6593
R587 VGND.n113 VGND.n112 72.6593
R588 VGND.n210 VGND.n148 72.6593
R589 VGND.n151 VGND.n150 72.6593
R590 VGND.n230 VGND.n123 72.6593
R591 VGND.n292 VGND.n291 72.6593
R592 VGND.n379 VGND.n378 72.6593
R593 VGND.n317 VGND.n118 72.6593
R594 VGND.n394 VGND.n393 67.2769
R595 VGND.n213 VGND.n129 67.2769
R596 VGND.n287 VGND.n125 67.2769
R597 VGND.n375 VGND.n120 67.2769
R598 VGND.n393 VGND.n42 42.7556
R599 VGND.t3 VGND.n42 42.7556
R600 VGND.t3 VGND.n48 42.7556
R601 VGND.n129 VGND.n48 42.7556
R602 VGND.n295 VGND.n125 42.7556
R603 VGND.n295 VGND.t0 42.7556
R604 VGND.n382 VGND.t0 42.7556
R605 VGND.n382 VGND.n120 42.7556
R606 VGND.n51 VGND.n45 25.6005
R607 VGND.n54 VGND.n51 25.6005
R608 VGND.n55 VGND.n54 25.6005
R609 VGND.n58 VGND.n55 25.6005
R610 VGND.n59 VGND.n58 25.6005
R611 VGND.n62 VGND.n59 25.6005
R612 VGND.n63 VGND.n62 25.6005
R613 VGND.n66 VGND.n63 25.6005
R614 VGND.n67 VGND.n66 25.6005
R615 VGND.n70 VGND.n67 25.6005
R616 VGND.n71 VGND.n70 25.6005
R617 VGND.n74 VGND.n71 25.6005
R618 VGND.n75 VGND.n74 25.6005
R619 VGND.n78 VGND.n75 25.6005
R620 VGND.n79 VGND.n78 25.6005
R621 VGND.n82 VGND.n79 25.6005
R622 VGND.n83 VGND.n82 25.6005
R623 VGND.n86 VGND.n83 25.6005
R624 VGND.n87 VGND.n86 25.6005
R625 VGND.n90 VGND.n87 25.6005
R626 VGND.n91 VGND.n90 25.6005
R627 VGND.n94 VGND.n91 25.6005
R628 VGND.n95 VGND.n94 25.6005
R629 VGND.n98 VGND.n95 25.6005
R630 VGND.n99 VGND.n98 25.6005
R631 VGND.n102 VGND.n99 25.6005
R632 VGND.n103 VGND.n102 25.6005
R633 VGND.n106 VGND.n103 25.6005
R634 VGND.n107 VGND.n106 25.6005
R635 VGND.n110 VGND.n107 25.6005
R636 VGND.n112 VGND.n110 25.6005
R637 VGND.n391 VGND.n390 25.6005
R638 VGND.n390 VGND.n389 25.6005
R639 VGND.n389 VGND.n46 25.6005
R640 VGND.n148 VGND.n46 25.6005
R641 VGND.n210 VGND.n209 25.6005
R642 VGND.n209 VGND.n208 25.6005
R643 VGND.n208 VGND.n207 25.6005
R644 VGND.n207 VGND.n205 25.6005
R645 VGND.n205 VGND.n202 25.6005
R646 VGND.n202 VGND.n201 25.6005
R647 VGND.n201 VGND.n198 25.6005
R648 VGND.n198 VGND.n197 25.6005
R649 VGND.n197 VGND.n194 25.6005
R650 VGND.n194 VGND.n193 25.6005
R651 VGND.n193 VGND.n190 25.6005
R652 VGND.n190 VGND.n189 25.6005
R653 VGND.n189 VGND.n186 25.6005
R654 VGND.n186 VGND.n185 25.6005
R655 VGND.n185 VGND.n182 25.6005
R656 VGND.n182 VGND.n181 25.6005
R657 VGND.n181 VGND.n178 25.6005
R658 VGND.n178 VGND.n177 25.6005
R659 VGND.n177 VGND.n174 25.6005
R660 VGND.n174 VGND.n173 25.6005
R661 VGND.n173 VGND.n170 25.6005
R662 VGND.n170 VGND.n169 25.6005
R663 VGND.n169 VGND.n166 25.6005
R664 VGND.n166 VGND.n165 25.6005
R665 VGND.n165 VGND.n162 25.6005
R666 VGND.n162 VGND.n161 25.6005
R667 VGND.n161 VGND.n158 25.6005
R668 VGND.n158 VGND.n157 25.6005
R669 VGND.n157 VGND.n154 25.6005
R670 VGND.n154 VGND.n153 25.6005
R671 VGND.n153 VGND.n151 25.6005
R672 VGND.n114 VGND.n113 25.6005
R673 VGND VGND.n114 25.6005
R674 VGND VGND.n115 25.6005
R675 VGND.n150 VGND.n115 25.6005
R676 VGND.n399 VGND.n23 25.6005
R677 VGND.n399 VGND.n398 25.6005
R678 VGND.n405 VGND.n398 25.6005
R679 VGND.n406 VGND.n405 25.6005
R680 VGND.n412 VGND.n411 25.6005
R681 VGND.n413 VGND.n412 25.6005
R682 VGND.n413 VGND.n15 25.6005
R683 VGND.n423 VGND.n15 25.6005
R684 VGND.n424 VGND.n423 25.6005
R685 VGND.n429 VGND.n424 25.6005
R686 VGND.n429 VGND.n428 25.6005
R687 VGND.n427 VGND.n0 25.6005
R688 VGND VGND.n0 25.6005
R689 VGND VGND.n5 25.6005
R690 VGND.n435 VGND.n5 25.6005
R691 VGND.n407 VGND.n18 25.6005
R692 VGND.n417 VGND.n18 25.6005
R693 VGND.n418 VGND.n417 25.6005
R694 VGND.n419 VGND.n418 25.6005
R695 VGND.n419 VGND.n9 25.6005
R696 VGND.n433 VGND.n9 25.6005
R697 VGND.n434 VGND.n433 25.6005
R698 VGND.n231 VGND.n230 25.6005
R699 VGND.n234 VGND.n231 25.6005
R700 VGND.n235 VGND.n234 25.6005
R701 VGND.n238 VGND.n235 25.6005
R702 VGND.n239 VGND.n238 25.6005
R703 VGND.n242 VGND.n239 25.6005
R704 VGND.n243 VGND.n242 25.6005
R705 VGND.n246 VGND.n243 25.6005
R706 VGND.n247 VGND.n246 25.6005
R707 VGND.n250 VGND.n247 25.6005
R708 VGND.n251 VGND.n250 25.6005
R709 VGND.n254 VGND.n251 25.6005
R710 VGND.n255 VGND.n254 25.6005
R711 VGND.n258 VGND.n255 25.6005
R712 VGND.n259 VGND.n258 25.6005
R713 VGND.n262 VGND.n259 25.6005
R714 VGND.n263 VGND.n262 25.6005
R715 VGND.n266 VGND.n263 25.6005
R716 VGND.n267 VGND.n266 25.6005
R717 VGND.n270 VGND.n267 25.6005
R718 VGND.n271 VGND.n270 25.6005
R719 VGND.n274 VGND.n271 25.6005
R720 VGND.n275 VGND.n274 25.6005
R721 VGND.n278 VGND.n275 25.6005
R722 VGND.n279 VGND.n278 25.6005
R723 VGND.n282 VGND.n279 25.6005
R724 VGND.n283 VGND.n282 25.6005
R725 VGND.n284 VGND.n283 25.6005
R726 VGND.n284 VGND.n127 25.6005
R727 VGND.n290 VGND.n127 25.6005
R728 VGND.n291 VGND.n290 25.6005
R729 VGND.n297 VGND.n123 25.6005
R730 VGND.n298 VGND.n297 25.6005
R731 VGND.n380 VGND.n298 25.6005
R732 VGND.n380 VGND.n379 25.6005
R733 VGND.n378 VGND.n299 25.6005
R734 VGND.n373 VGND.n299 25.6005
R735 VGND.n373 VGND.n372 25.6005
R736 VGND.n372 VGND.n371 25.6005
R737 VGND.n371 VGND.n368 25.6005
R738 VGND.n368 VGND.n367 25.6005
R739 VGND.n367 VGND.n364 25.6005
R740 VGND.n364 VGND.n363 25.6005
R741 VGND.n363 VGND.n360 25.6005
R742 VGND.n360 VGND.n359 25.6005
R743 VGND.n359 VGND.n356 25.6005
R744 VGND.n356 VGND.n355 25.6005
R745 VGND.n355 VGND.n352 25.6005
R746 VGND.n352 VGND.n351 25.6005
R747 VGND.n351 VGND.n348 25.6005
R748 VGND.n348 VGND.n347 25.6005
R749 VGND.n347 VGND.n344 25.6005
R750 VGND.n344 VGND.n343 25.6005
R751 VGND.n343 VGND.n340 25.6005
R752 VGND.n340 VGND.n339 25.6005
R753 VGND.n339 VGND.n336 25.6005
R754 VGND.n336 VGND.n335 25.6005
R755 VGND.n335 VGND.n332 25.6005
R756 VGND.n332 VGND.n331 25.6005
R757 VGND.n331 VGND.n328 25.6005
R758 VGND.n328 VGND.n327 25.6005
R759 VGND.n327 VGND.n324 25.6005
R760 VGND.n324 VGND.n323 25.6005
R761 VGND.n323 VGND.n320 25.6005
R762 VGND.n320 VGND.n319 25.6005
R763 VGND.n319 VGND.n317 25.6005
R764 VGND.n292 VGND.n116 25.6005
R765 VGND VGND.n116 25.6005
R766 VGND VGND.n384 25.6005
R767 VGND.n384 VGND.n118 25.6005
R768 VGND VGND.n4 21.4848
R769 VGND VGND.n386 20.0959
R770 VGND.n385 VGND 20.0959
R771 VGND VGND.n1 19.837
R772 VGND.n3 VGND.n1 14.1895
R773 VGND.n4 VGND.n3 13.2116
R774 VGND.n2 VGND 4.259
R775 VGND.n3 VGND.n2 3.04672
R776 VGND.n386 VGND.n4 2.78173
R777 VGND.n386 VGND.n385 0.911125
R778 VGND.n385 VGND 0.397062
R779 BIAS BIAS.t0 139.911
R780 INP INP.t0 332.712
R781 OUT.n7 OUT.t1 387.11
R782 OUT.t1 OUT.n0 381.113
R783 OUT.n3 OUT 33.1304
R784 OUT OUT.n0 22.8553
R785 OUT.n6 OUT.n5 16.6904
R786 OUT.n3 OUT.n2 14.1214
R787 OUT.n5 OUT.n4 13.9156
R788 OUT.n2 OUT.n1 13.3893
R789 OUT.n6 OUT.n0 11.4361
R790 OUT OUT.n1 6.32004
R791 OUT OUT.n7 4.87707
R792 OUT.n7 OUT.n6 2.44078
R793 OUT.n2 OUT.t0 1.7405
R794 OUT.n4 OUT.n3 1.13588
R795 OUT.n4 OUT.n1 0.755154
R796 OUT.n5 OUT 0.256063
R797 VPWR.n377 VPWR.n343 762.354
R798 VPWR.n656 VPWR.n341 762.354
R799 VPWR.n537 VPWR.n338 762.354
R800 VPWR.n499 VPWR.n345 762.354
R801 VPWR.n43 VPWR.n9 762.354
R802 VPWR.n322 VPWR.n7 762.354
R803 VPWR.n203 VPWR.n4 762.354
R804 VPWR.n165 VPWR.n11 762.354
R805 VPWR.t3 VPWR.n331 387.11
R806 VPWR.n666 VPWR.t1 387.11
R807 VPWR.n332 VPWR.t3 381.113
R808 VPWR.t1 VPWR.n0 381.113
R809 VPWR.n502 VPWR.n343 240
R810 VPWR.n502 VPWR.n340 240
R811 VPWR.n660 VPWR.n340 240
R812 VPWR.n660 VPWR.n341 240
R813 VPWR.n653 VPWR.n506 240
R814 VPWR.n653 VPWR.n536 240
R815 VPWR.n649 VPWR.n648 240
R816 VPWR.n645 VPWR.n644 240
R817 VPWR.n641 VPWR.n640 240
R818 VPWR.n637 VPWR.n636 240
R819 VPWR.n633 VPWR.n632 240
R820 VPWR.n629 VPWR.n628 240
R821 VPWR.n625 VPWR.n624 240
R822 VPWR.n621 VPWR.n620 240
R823 VPWR.n617 VPWR.n616 240
R824 VPWR.n613 VPWR.n612 240
R825 VPWR.n609 VPWR.n608 240
R826 VPWR.n605 VPWR.n604 240
R827 VPWR.n601 VPWR.n600 240
R828 VPWR.n597 VPWR.n596 240
R829 VPWR.n593 VPWR.n592 240
R830 VPWR.n589 VPWR.n588 240
R831 VPWR.n585 VPWR.n584 240
R832 VPWR.n581 VPWR.n580 240
R833 VPWR.n577 VPWR.n576 240
R834 VPWR.n573 VPWR.n572 240
R835 VPWR.n569 VPWR.n568 240
R836 VPWR.n565 VPWR.n564 240
R837 VPWR.n561 VPWR.n560 240
R838 VPWR.n557 VPWR.n556 240
R839 VPWR.n553 VPWR.n552 240
R840 VPWR.n549 VPWR.n548 240
R841 VPWR.n545 VPWR.n544 240
R842 VPWR.n541 VPWR.n540 240
R843 VPWR.n500 VPWR.n499 240
R844 VPWR.n500 VPWR.n336 240
R845 VPWR.n662 VPWR.n336 240
R846 VPWR.n662 VPWR.n338 240
R847 VPWR.n381 VPWR.n380 240
R848 VPWR.n385 VPWR.n384 240
R849 VPWR.n389 VPWR.n388 240
R850 VPWR.n393 VPWR.n392 240
R851 VPWR.n397 VPWR.n396 240
R852 VPWR.n401 VPWR.n400 240
R853 VPWR.n405 VPWR.n404 240
R854 VPWR.n409 VPWR.n408 240
R855 VPWR.n413 VPWR.n412 240
R856 VPWR.n417 VPWR.n416 240
R857 VPWR.n421 VPWR.n420 240
R858 VPWR.n425 VPWR.n424 240
R859 VPWR.n429 VPWR.n428 240
R860 VPWR.n433 VPWR.n432 240
R861 VPWR.n437 VPWR.n436 240
R862 VPWR.n441 VPWR.n440 240
R863 VPWR.n445 VPWR.n444 240
R864 VPWR.n449 VPWR.n448 240
R865 VPWR.n453 VPWR.n452 240
R866 VPWR.n457 VPWR.n456 240
R867 VPWR.n461 VPWR.n460 240
R868 VPWR.n465 VPWR.n464 240
R869 VPWR.n469 VPWR.n468 240
R870 VPWR.n473 VPWR.n472 240
R871 VPWR.n477 VPWR.n476 240
R872 VPWR.n481 VPWR.n480 240
R873 VPWR.n485 VPWR.n484 240
R874 VPWR.n487 VPWR.n376 240
R875 VPWR.n491 VPWR.n347 240
R876 VPWR.n495 VPWR.n345 240
R877 VPWR.n168 VPWR.n9 240
R878 VPWR.n168 VPWR.n6 240
R879 VPWR.n326 VPWR.n6 240
R880 VPWR.n326 VPWR.n7 240
R881 VPWR.n319 VPWR.n172 240
R882 VPWR.n319 VPWR.n202 240
R883 VPWR.n315 VPWR.n314 240
R884 VPWR.n311 VPWR.n310 240
R885 VPWR.n307 VPWR.n306 240
R886 VPWR.n303 VPWR.n302 240
R887 VPWR.n299 VPWR.n298 240
R888 VPWR.n295 VPWR.n294 240
R889 VPWR.n291 VPWR.n290 240
R890 VPWR.n287 VPWR.n286 240
R891 VPWR.n283 VPWR.n282 240
R892 VPWR.n279 VPWR.n278 240
R893 VPWR.n275 VPWR.n274 240
R894 VPWR.n271 VPWR.n270 240
R895 VPWR.n267 VPWR.n266 240
R896 VPWR.n263 VPWR.n262 240
R897 VPWR.n259 VPWR.n258 240
R898 VPWR.n255 VPWR.n254 240
R899 VPWR.n251 VPWR.n250 240
R900 VPWR.n247 VPWR.n246 240
R901 VPWR.n243 VPWR.n242 240
R902 VPWR.n239 VPWR.n238 240
R903 VPWR.n235 VPWR.n234 240
R904 VPWR.n231 VPWR.n230 240
R905 VPWR.n227 VPWR.n226 240
R906 VPWR.n223 VPWR.n222 240
R907 VPWR.n219 VPWR.n218 240
R908 VPWR.n215 VPWR.n214 240
R909 VPWR.n211 VPWR.n210 240
R910 VPWR.n207 VPWR.n206 240
R911 VPWR.n166 VPWR.n165 240
R912 VPWR.n166 VPWR.n2 240
R913 VPWR.n328 VPWR.n2 240
R914 VPWR.n328 VPWR.n4 240
R915 VPWR.n47 VPWR.n46 240
R916 VPWR.n51 VPWR.n50 240
R917 VPWR.n55 VPWR.n54 240
R918 VPWR.n59 VPWR.n58 240
R919 VPWR.n63 VPWR.n62 240
R920 VPWR.n67 VPWR.n66 240
R921 VPWR.n71 VPWR.n70 240
R922 VPWR.n75 VPWR.n74 240
R923 VPWR.n79 VPWR.n78 240
R924 VPWR.n83 VPWR.n82 240
R925 VPWR.n87 VPWR.n86 240
R926 VPWR.n91 VPWR.n90 240
R927 VPWR.n95 VPWR.n94 240
R928 VPWR.n99 VPWR.n98 240
R929 VPWR.n103 VPWR.n102 240
R930 VPWR.n107 VPWR.n106 240
R931 VPWR.n111 VPWR.n110 240
R932 VPWR.n115 VPWR.n114 240
R933 VPWR.n119 VPWR.n118 240
R934 VPWR.n123 VPWR.n122 240
R935 VPWR.n127 VPWR.n126 240
R936 VPWR.n131 VPWR.n130 240
R937 VPWR.n135 VPWR.n134 240
R938 VPWR.n139 VPWR.n138 240
R939 VPWR.n143 VPWR.n142 240
R940 VPWR.n147 VPWR.n146 240
R941 VPWR.n151 VPWR.n150 240
R942 VPWR.n153 VPWR.n42 240
R943 VPWR.n157 VPWR.n13 240
R944 VPWR.n161 VPWR.n11 240
R945 VPWR.n497 VPWR.n345 185
R946 VPWR.n493 VPWR.n345 185
R947 VPWR.n496 VPWR.n495 185
R948 VPWR.n347 VPWR.n346 185
R949 VPWR.n491 VPWR.n490 185
R950 VPWR.n489 VPWR.n376 185
R951 VPWR.n488 VPWR.n487 185
R952 VPWR.n486 VPWR.n485 185
R953 VPWR.n484 VPWR.n483 185
R954 VPWR.n482 VPWR.n481 185
R955 VPWR.n480 VPWR.n479 185
R956 VPWR.n478 VPWR.n477 185
R957 VPWR.n476 VPWR.n475 185
R958 VPWR.n474 VPWR.n473 185
R959 VPWR.n472 VPWR.n471 185
R960 VPWR.n470 VPWR.n469 185
R961 VPWR.n468 VPWR.n467 185
R962 VPWR.n466 VPWR.n465 185
R963 VPWR.n464 VPWR.n463 185
R964 VPWR.n462 VPWR.n461 185
R965 VPWR.n460 VPWR.n459 185
R966 VPWR.n458 VPWR.n457 185
R967 VPWR.n456 VPWR.n455 185
R968 VPWR.n454 VPWR.n453 185
R969 VPWR.n452 VPWR.n451 185
R970 VPWR.n450 VPWR.n449 185
R971 VPWR.n448 VPWR.n447 185
R972 VPWR.n446 VPWR.n445 185
R973 VPWR.n444 VPWR.n443 185
R974 VPWR.n442 VPWR.n441 185
R975 VPWR.n440 VPWR.n439 185
R976 VPWR.n438 VPWR.n437 185
R977 VPWR.n436 VPWR.n435 185
R978 VPWR.n434 VPWR.n433 185
R979 VPWR.n432 VPWR.n431 185
R980 VPWR.n430 VPWR.n429 185
R981 VPWR.n428 VPWR.n427 185
R982 VPWR.n426 VPWR.n425 185
R983 VPWR.n424 VPWR.n423 185
R984 VPWR.n422 VPWR.n421 185
R985 VPWR.n420 VPWR.n419 185
R986 VPWR.n418 VPWR.n417 185
R987 VPWR.n416 VPWR.n415 185
R988 VPWR.n414 VPWR.n413 185
R989 VPWR.n412 VPWR.n411 185
R990 VPWR.n410 VPWR.n409 185
R991 VPWR.n408 VPWR.n407 185
R992 VPWR.n406 VPWR.n405 185
R993 VPWR.n404 VPWR.n403 185
R994 VPWR.n402 VPWR.n401 185
R995 VPWR.n400 VPWR.n399 185
R996 VPWR.n398 VPWR.n397 185
R997 VPWR.n396 VPWR.n395 185
R998 VPWR.n394 VPWR.n393 185
R999 VPWR.n392 VPWR.n391 185
R1000 VPWR.n390 VPWR.n389 185
R1001 VPWR.n388 VPWR.n387 185
R1002 VPWR.n386 VPWR.n385 185
R1003 VPWR.n384 VPWR.n383 185
R1004 VPWR.n382 VPWR.n381 185
R1005 VPWR.n380 VPWR.n379 185
R1006 VPWR.n378 VPWR.n377 185
R1007 VPWR.n343 VPWR.n342 185
R1008 VPWR.n344 VPWR.n343 185
R1009 VPWR.n503 VPWR.n502 185
R1010 VPWR.n502 VPWR.n501 185
R1011 VPWR.n504 VPWR.n340 185
R1012 VPWR.n340 VPWR.t0 185
R1013 VPWR.n660 VPWR.n659 185
R1014 VPWR.n661 VPWR.n660 185
R1015 VPWR.n658 VPWR.n341 185
R1016 VPWR.n341 VPWR.n339 185
R1017 VPWR.n657 VPWR.n656 185
R1018 VPWR.n506 VPWR.n505 185
R1019 VPWR.n653 VPWR.n652 185
R1020 VPWR.n654 VPWR.n653 185
R1021 VPWR.n651 VPWR.n536 185
R1022 VPWR.n650 VPWR.n649 185
R1023 VPWR.n648 VPWR.n647 185
R1024 VPWR.n646 VPWR.n645 185
R1025 VPWR.n644 VPWR.n643 185
R1026 VPWR.n642 VPWR.n641 185
R1027 VPWR.n640 VPWR.n639 185
R1028 VPWR.n638 VPWR.n637 185
R1029 VPWR.n636 VPWR.n635 185
R1030 VPWR.n634 VPWR.n633 185
R1031 VPWR.n632 VPWR.n631 185
R1032 VPWR.n630 VPWR.n629 185
R1033 VPWR.n628 VPWR.n627 185
R1034 VPWR.n626 VPWR.n625 185
R1035 VPWR.n624 VPWR.n623 185
R1036 VPWR.n622 VPWR.n621 185
R1037 VPWR.n620 VPWR.n619 185
R1038 VPWR.n618 VPWR.n617 185
R1039 VPWR.n616 VPWR.n615 185
R1040 VPWR.n614 VPWR.n613 185
R1041 VPWR.n612 VPWR.n611 185
R1042 VPWR.n610 VPWR.n609 185
R1043 VPWR.n608 VPWR.n607 185
R1044 VPWR.n606 VPWR.n605 185
R1045 VPWR.n604 VPWR.n603 185
R1046 VPWR.n602 VPWR.n601 185
R1047 VPWR.n600 VPWR.n599 185
R1048 VPWR.n598 VPWR.n597 185
R1049 VPWR.n596 VPWR.n595 185
R1050 VPWR.n594 VPWR.n593 185
R1051 VPWR.n592 VPWR.n591 185
R1052 VPWR.n590 VPWR.n589 185
R1053 VPWR.n588 VPWR.n587 185
R1054 VPWR.n586 VPWR.n585 185
R1055 VPWR.n584 VPWR.n583 185
R1056 VPWR.n582 VPWR.n581 185
R1057 VPWR.n580 VPWR.n579 185
R1058 VPWR.n578 VPWR.n577 185
R1059 VPWR.n576 VPWR.n575 185
R1060 VPWR.n574 VPWR.n573 185
R1061 VPWR.n572 VPWR.n571 185
R1062 VPWR.n570 VPWR.n569 185
R1063 VPWR.n568 VPWR.n567 185
R1064 VPWR.n566 VPWR.n565 185
R1065 VPWR.n564 VPWR.n563 185
R1066 VPWR.n562 VPWR.n561 185
R1067 VPWR.n560 VPWR.n559 185
R1068 VPWR.n558 VPWR.n557 185
R1069 VPWR.n556 VPWR.n555 185
R1070 VPWR.n554 VPWR.n553 185
R1071 VPWR.n552 VPWR.n551 185
R1072 VPWR.n550 VPWR.n549 185
R1073 VPWR.n548 VPWR.n547 185
R1074 VPWR.n546 VPWR.n545 185
R1075 VPWR.n544 VPWR.n543 185
R1076 VPWR.n542 VPWR.n541 185
R1077 VPWR.n540 VPWR.n539 185
R1078 VPWR.n538 VPWR.n537 185
R1079 VPWR.n338 VPWR.n337 185
R1080 VPWR.n339 VPWR.n338 185
R1081 VPWR.n663 VPWR.n662 185
R1082 VPWR.n662 VPWR.n661 185
R1083 VPWR VPWR.n336 185
R1084 VPWR.t0 VPWR.n336 185
R1085 VPWR.n500 VPWR.n335 185
R1086 VPWR.n501 VPWR.n500 185
R1087 VPWR.n499 VPWR.n498 185
R1088 VPWR.n499 VPWR.n344 185
R1089 VPWR.n163 VPWR.n11 185
R1090 VPWR.n159 VPWR.n11 185
R1091 VPWR.n162 VPWR.n161 185
R1092 VPWR.n13 VPWR.n12 185
R1093 VPWR.n157 VPWR.n156 185
R1094 VPWR.n155 VPWR.n42 185
R1095 VPWR.n154 VPWR.n153 185
R1096 VPWR.n152 VPWR.n151 185
R1097 VPWR.n150 VPWR.n149 185
R1098 VPWR.n148 VPWR.n147 185
R1099 VPWR.n146 VPWR.n145 185
R1100 VPWR.n144 VPWR.n143 185
R1101 VPWR.n142 VPWR.n141 185
R1102 VPWR.n140 VPWR.n139 185
R1103 VPWR.n138 VPWR.n137 185
R1104 VPWR.n136 VPWR.n135 185
R1105 VPWR.n134 VPWR.n133 185
R1106 VPWR.n132 VPWR.n131 185
R1107 VPWR.n130 VPWR.n129 185
R1108 VPWR.n128 VPWR.n127 185
R1109 VPWR.n126 VPWR.n125 185
R1110 VPWR.n124 VPWR.n123 185
R1111 VPWR.n122 VPWR.n121 185
R1112 VPWR.n120 VPWR.n119 185
R1113 VPWR.n118 VPWR.n117 185
R1114 VPWR.n116 VPWR.n115 185
R1115 VPWR.n114 VPWR.n113 185
R1116 VPWR.n112 VPWR.n111 185
R1117 VPWR.n110 VPWR.n109 185
R1118 VPWR.n108 VPWR.n107 185
R1119 VPWR.n106 VPWR.n105 185
R1120 VPWR.n104 VPWR.n103 185
R1121 VPWR.n102 VPWR.n101 185
R1122 VPWR.n100 VPWR.n99 185
R1123 VPWR.n98 VPWR.n97 185
R1124 VPWR.n96 VPWR.n95 185
R1125 VPWR.n94 VPWR.n93 185
R1126 VPWR.n92 VPWR.n91 185
R1127 VPWR.n90 VPWR.n89 185
R1128 VPWR.n88 VPWR.n87 185
R1129 VPWR.n86 VPWR.n85 185
R1130 VPWR.n84 VPWR.n83 185
R1131 VPWR.n82 VPWR.n81 185
R1132 VPWR.n80 VPWR.n79 185
R1133 VPWR.n78 VPWR.n77 185
R1134 VPWR.n76 VPWR.n75 185
R1135 VPWR.n74 VPWR.n73 185
R1136 VPWR.n72 VPWR.n71 185
R1137 VPWR.n70 VPWR.n69 185
R1138 VPWR.n68 VPWR.n67 185
R1139 VPWR.n66 VPWR.n65 185
R1140 VPWR.n64 VPWR.n63 185
R1141 VPWR.n62 VPWR.n61 185
R1142 VPWR.n60 VPWR.n59 185
R1143 VPWR.n58 VPWR.n57 185
R1144 VPWR.n56 VPWR.n55 185
R1145 VPWR.n54 VPWR.n53 185
R1146 VPWR.n52 VPWR.n51 185
R1147 VPWR.n50 VPWR.n49 185
R1148 VPWR.n48 VPWR.n47 185
R1149 VPWR.n46 VPWR.n45 185
R1150 VPWR.n44 VPWR.n43 185
R1151 VPWR.n9 VPWR.n8 185
R1152 VPWR.n10 VPWR.n9 185
R1153 VPWR.n169 VPWR.n168 185
R1154 VPWR.n168 VPWR.n167 185
R1155 VPWR.n170 VPWR.n6 185
R1156 VPWR.n6 VPWR.t2 185
R1157 VPWR.n326 VPWR.n325 185
R1158 VPWR.n327 VPWR.n326 185
R1159 VPWR.n324 VPWR.n7 185
R1160 VPWR.n7 VPWR.n5 185
R1161 VPWR.n323 VPWR.n322 185
R1162 VPWR.n172 VPWR.n171 185
R1163 VPWR.n319 VPWR.n318 185
R1164 VPWR.n320 VPWR.n319 185
R1165 VPWR.n317 VPWR.n202 185
R1166 VPWR.n316 VPWR.n315 185
R1167 VPWR.n314 VPWR.n313 185
R1168 VPWR.n312 VPWR.n311 185
R1169 VPWR.n310 VPWR.n309 185
R1170 VPWR.n308 VPWR.n307 185
R1171 VPWR.n306 VPWR.n305 185
R1172 VPWR.n304 VPWR.n303 185
R1173 VPWR.n302 VPWR.n301 185
R1174 VPWR.n300 VPWR.n299 185
R1175 VPWR.n298 VPWR.n297 185
R1176 VPWR.n296 VPWR.n295 185
R1177 VPWR.n294 VPWR.n293 185
R1178 VPWR.n292 VPWR.n291 185
R1179 VPWR.n290 VPWR.n289 185
R1180 VPWR.n288 VPWR.n287 185
R1181 VPWR.n286 VPWR.n285 185
R1182 VPWR.n284 VPWR.n283 185
R1183 VPWR.n282 VPWR.n281 185
R1184 VPWR.n280 VPWR.n279 185
R1185 VPWR.n278 VPWR.n277 185
R1186 VPWR.n276 VPWR.n275 185
R1187 VPWR.n274 VPWR.n273 185
R1188 VPWR.n272 VPWR.n271 185
R1189 VPWR.n270 VPWR.n269 185
R1190 VPWR.n268 VPWR.n267 185
R1191 VPWR.n266 VPWR.n265 185
R1192 VPWR.n264 VPWR.n263 185
R1193 VPWR.n262 VPWR.n261 185
R1194 VPWR.n260 VPWR.n259 185
R1195 VPWR.n258 VPWR.n257 185
R1196 VPWR.n256 VPWR.n255 185
R1197 VPWR.n254 VPWR.n253 185
R1198 VPWR.n252 VPWR.n251 185
R1199 VPWR.n250 VPWR.n249 185
R1200 VPWR.n248 VPWR.n247 185
R1201 VPWR.n246 VPWR.n245 185
R1202 VPWR.n244 VPWR.n243 185
R1203 VPWR.n242 VPWR.n241 185
R1204 VPWR.n240 VPWR.n239 185
R1205 VPWR.n238 VPWR.n237 185
R1206 VPWR.n236 VPWR.n235 185
R1207 VPWR.n234 VPWR.n233 185
R1208 VPWR.n232 VPWR.n231 185
R1209 VPWR.n230 VPWR.n229 185
R1210 VPWR.n228 VPWR.n227 185
R1211 VPWR.n226 VPWR.n225 185
R1212 VPWR.n224 VPWR.n223 185
R1213 VPWR.n222 VPWR.n221 185
R1214 VPWR.n220 VPWR.n219 185
R1215 VPWR.n218 VPWR.n217 185
R1216 VPWR.n216 VPWR.n215 185
R1217 VPWR.n214 VPWR.n213 185
R1218 VPWR.n212 VPWR.n211 185
R1219 VPWR.n210 VPWR.n209 185
R1220 VPWR.n208 VPWR.n207 185
R1221 VPWR.n206 VPWR.n205 185
R1222 VPWR.n204 VPWR.n203 185
R1223 VPWR.n4 VPWR.n3 185
R1224 VPWR.n5 VPWR.n4 185
R1225 VPWR.n329 VPWR.n328 185
R1226 VPWR.n328 VPWR.n327 185
R1227 VPWR VPWR.n2 185
R1228 VPWR.t2 VPWR.n2 185
R1229 VPWR.n166 VPWR.n1 185
R1230 VPWR.n167 VPWR.n166 185
R1231 VPWR.n165 VPWR.n164 185
R1232 VPWR.n165 VPWR.n10 185
R1233 VPWR.n378 VPWR.n342 81.3181
R1234 VPWR.n498 VPWR.n497 81.3181
R1235 VPWR.n658 VPWR.n657 81.3181
R1236 VPWR.n538 VPWR.n337 81.3181
R1237 VPWR.n44 VPWR.n8 81.3181
R1238 VPWR.n164 VPWR.n163 81.3181
R1239 VPWR.n324 VPWR.n323 81.3181
R1240 VPWR.n204 VPWR.n3 81.3181
R1241 VPWR.n656 VPWR.n655 72.7879
R1242 VPWR.n536 VPWR.n507 72.7879
R1243 VPWR.n648 VPWR.n508 72.7879
R1244 VPWR.n644 VPWR.n509 72.7879
R1245 VPWR.n640 VPWR.n510 72.7879
R1246 VPWR.n636 VPWR.n511 72.7879
R1247 VPWR.n632 VPWR.n512 72.7879
R1248 VPWR.n628 VPWR.n513 72.7879
R1249 VPWR.n624 VPWR.n514 72.7879
R1250 VPWR.n620 VPWR.n515 72.7879
R1251 VPWR.n616 VPWR.n516 72.7879
R1252 VPWR.n612 VPWR.n517 72.7879
R1253 VPWR.n608 VPWR.n518 72.7879
R1254 VPWR.n604 VPWR.n519 72.7879
R1255 VPWR.n600 VPWR.n520 72.7879
R1256 VPWR.n596 VPWR.n521 72.7879
R1257 VPWR.n592 VPWR.n522 72.7879
R1258 VPWR.n588 VPWR.n523 72.7879
R1259 VPWR.n584 VPWR.n524 72.7879
R1260 VPWR.n580 VPWR.n525 72.7879
R1261 VPWR.n576 VPWR.n526 72.7879
R1262 VPWR.n572 VPWR.n527 72.7879
R1263 VPWR.n568 VPWR.n528 72.7879
R1264 VPWR.n564 VPWR.n529 72.7879
R1265 VPWR.n560 VPWR.n530 72.7879
R1266 VPWR.n556 VPWR.n531 72.7879
R1267 VPWR.n552 VPWR.n532 72.7879
R1268 VPWR.n548 VPWR.n533 72.7879
R1269 VPWR.n544 VPWR.n534 72.7879
R1270 VPWR.n540 VPWR.n535 72.7879
R1271 VPWR.n377 VPWR.n348 72.7879
R1272 VPWR.n381 VPWR.n349 72.7879
R1273 VPWR.n385 VPWR.n350 72.7879
R1274 VPWR.n389 VPWR.n351 72.7879
R1275 VPWR.n393 VPWR.n352 72.7879
R1276 VPWR.n397 VPWR.n353 72.7879
R1277 VPWR.n401 VPWR.n354 72.7879
R1278 VPWR.n405 VPWR.n355 72.7879
R1279 VPWR.n409 VPWR.n356 72.7879
R1280 VPWR.n413 VPWR.n357 72.7879
R1281 VPWR.n417 VPWR.n358 72.7879
R1282 VPWR.n421 VPWR.n359 72.7879
R1283 VPWR.n425 VPWR.n360 72.7879
R1284 VPWR.n429 VPWR.n361 72.7879
R1285 VPWR.n433 VPWR.n362 72.7879
R1286 VPWR.n437 VPWR.n363 72.7879
R1287 VPWR.n441 VPWR.n364 72.7879
R1288 VPWR.n445 VPWR.n365 72.7879
R1289 VPWR.n449 VPWR.n366 72.7879
R1290 VPWR.n453 VPWR.n367 72.7879
R1291 VPWR.n457 VPWR.n368 72.7879
R1292 VPWR.n461 VPWR.n369 72.7879
R1293 VPWR.n465 VPWR.n370 72.7879
R1294 VPWR.n469 VPWR.n371 72.7879
R1295 VPWR.n473 VPWR.n372 72.7879
R1296 VPWR.n477 VPWR.n373 72.7879
R1297 VPWR.n481 VPWR.n374 72.7879
R1298 VPWR.n485 VPWR.n375 72.7879
R1299 VPWR.n492 VPWR.n376 72.7879
R1300 VPWR.n494 VPWR.n347 72.7879
R1301 VPWR.n495 VPWR.n494 72.7879
R1302 VPWR.n492 VPWR.n491 72.7879
R1303 VPWR.n487 VPWR.n375 72.7879
R1304 VPWR.n484 VPWR.n374 72.7879
R1305 VPWR.n480 VPWR.n373 72.7879
R1306 VPWR.n476 VPWR.n372 72.7879
R1307 VPWR.n472 VPWR.n371 72.7879
R1308 VPWR.n468 VPWR.n370 72.7879
R1309 VPWR.n464 VPWR.n369 72.7879
R1310 VPWR.n460 VPWR.n368 72.7879
R1311 VPWR.n456 VPWR.n367 72.7879
R1312 VPWR.n452 VPWR.n366 72.7879
R1313 VPWR.n448 VPWR.n365 72.7879
R1314 VPWR.n444 VPWR.n364 72.7879
R1315 VPWR.n440 VPWR.n363 72.7879
R1316 VPWR.n436 VPWR.n362 72.7879
R1317 VPWR.n432 VPWR.n361 72.7879
R1318 VPWR.n428 VPWR.n360 72.7879
R1319 VPWR.n424 VPWR.n359 72.7879
R1320 VPWR.n420 VPWR.n358 72.7879
R1321 VPWR.n416 VPWR.n357 72.7879
R1322 VPWR.n412 VPWR.n356 72.7879
R1323 VPWR.n408 VPWR.n355 72.7879
R1324 VPWR.n404 VPWR.n354 72.7879
R1325 VPWR.n400 VPWR.n353 72.7879
R1326 VPWR.n396 VPWR.n352 72.7879
R1327 VPWR.n392 VPWR.n351 72.7879
R1328 VPWR.n388 VPWR.n350 72.7879
R1329 VPWR.n384 VPWR.n349 72.7879
R1330 VPWR.n380 VPWR.n348 72.7879
R1331 VPWR.n655 VPWR.n506 72.7879
R1332 VPWR.n649 VPWR.n507 72.7879
R1333 VPWR.n645 VPWR.n508 72.7879
R1334 VPWR.n641 VPWR.n509 72.7879
R1335 VPWR.n637 VPWR.n510 72.7879
R1336 VPWR.n633 VPWR.n511 72.7879
R1337 VPWR.n629 VPWR.n512 72.7879
R1338 VPWR.n625 VPWR.n513 72.7879
R1339 VPWR.n621 VPWR.n514 72.7879
R1340 VPWR.n617 VPWR.n515 72.7879
R1341 VPWR.n613 VPWR.n516 72.7879
R1342 VPWR.n609 VPWR.n517 72.7879
R1343 VPWR.n605 VPWR.n518 72.7879
R1344 VPWR.n601 VPWR.n519 72.7879
R1345 VPWR.n597 VPWR.n520 72.7879
R1346 VPWR.n593 VPWR.n521 72.7879
R1347 VPWR.n589 VPWR.n522 72.7879
R1348 VPWR.n585 VPWR.n523 72.7879
R1349 VPWR.n581 VPWR.n524 72.7879
R1350 VPWR.n577 VPWR.n525 72.7879
R1351 VPWR.n573 VPWR.n526 72.7879
R1352 VPWR.n569 VPWR.n527 72.7879
R1353 VPWR.n565 VPWR.n528 72.7879
R1354 VPWR.n561 VPWR.n529 72.7879
R1355 VPWR.n557 VPWR.n530 72.7879
R1356 VPWR.n553 VPWR.n531 72.7879
R1357 VPWR.n549 VPWR.n532 72.7879
R1358 VPWR.n545 VPWR.n533 72.7879
R1359 VPWR.n541 VPWR.n534 72.7879
R1360 VPWR.n537 VPWR.n535 72.7879
R1361 VPWR.n322 VPWR.n321 72.7879
R1362 VPWR.n202 VPWR.n173 72.7879
R1363 VPWR.n314 VPWR.n174 72.7879
R1364 VPWR.n310 VPWR.n175 72.7879
R1365 VPWR.n306 VPWR.n176 72.7879
R1366 VPWR.n302 VPWR.n177 72.7879
R1367 VPWR.n298 VPWR.n178 72.7879
R1368 VPWR.n294 VPWR.n179 72.7879
R1369 VPWR.n290 VPWR.n180 72.7879
R1370 VPWR.n286 VPWR.n181 72.7879
R1371 VPWR.n282 VPWR.n182 72.7879
R1372 VPWR.n278 VPWR.n183 72.7879
R1373 VPWR.n274 VPWR.n184 72.7879
R1374 VPWR.n270 VPWR.n185 72.7879
R1375 VPWR.n266 VPWR.n186 72.7879
R1376 VPWR.n262 VPWR.n187 72.7879
R1377 VPWR.n258 VPWR.n188 72.7879
R1378 VPWR.n254 VPWR.n189 72.7879
R1379 VPWR.n250 VPWR.n190 72.7879
R1380 VPWR.n246 VPWR.n191 72.7879
R1381 VPWR.n242 VPWR.n192 72.7879
R1382 VPWR.n238 VPWR.n193 72.7879
R1383 VPWR.n234 VPWR.n194 72.7879
R1384 VPWR.n230 VPWR.n195 72.7879
R1385 VPWR.n226 VPWR.n196 72.7879
R1386 VPWR.n222 VPWR.n197 72.7879
R1387 VPWR.n218 VPWR.n198 72.7879
R1388 VPWR.n214 VPWR.n199 72.7879
R1389 VPWR.n210 VPWR.n200 72.7879
R1390 VPWR.n206 VPWR.n201 72.7879
R1391 VPWR.n43 VPWR.n14 72.7879
R1392 VPWR.n47 VPWR.n15 72.7879
R1393 VPWR.n51 VPWR.n16 72.7879
R1394 VPWR.n55 VPWR.n17 72.7879
R1395 VPWR.n59 VPWR.n18 72.7879
R1396 VPWR.n63 VPWR.n19 72.7879
R1397 VPWR.n67 VPWR.n20 72.7879
R1398 VPWR.n71 VPWR.n21 72.7879
R1399 VPWR.n75 VPWR.n22 72.7879
R1400 VPWR.n79 VPWR.n23 72.7879
R1401 VPWR.n83 VPWR.n24 72.7879
R1402 VPWR.n87 VPWR.n25 72.7879
R1403 VPWR.n91 VPWR.n26 72.7879
R1404 VPWR.n95 VPWR.n27 72.7879
R1405 VPWR.n99 VPWR.n28 72.7879
R1406 VPWR.n103 VPWR.n29 72.7879
R1407 VPWR.n107 VPWR.n30 72.7879
R1408 VPWR.n111 VPWR.n31 72.7879
R1409 VPWR.n115 VPWR.n32 72.7879
R1410 VPWR.n119 VPWR.n33 72.7879
R1411 VPWR.n123 VPWR.n34 72.7879
R1412 VPWR.n127 VPWR.n35 72.7879
R1413 VPWR.n131 VPWR.n36 72.7879
R1414 VPWR.n135 VPWR.n37 72.7879
R1415 VPWR.n139 VPWR.n38 72.7879
R1416 VPWR.n143 VPWR.n39 72.7879
R1417 VPWR.n147 VPWR.n40 72.7879
R1418 VPWR.n151 VPWR.n41 72.7879
R1419 VPWR.n158 VPWR.n42 72.7879
R1420 VPWR.n160 VPWR.n13 72.7879
R1421 VPWR.n161 VPWR.n160 72.7879
R1422 VPWR.n158 VPWR.n157 72.7879
R1423 VPWR.n153 VPWR.n41 72.7879
R1424 VPWR.n150 VPWR.n40 72.7879
R1425 VPWR.n146 VPWR.n39 72.7879
R1426 VPWR.n142 VPWR.n38 72.7879
R1427 VPWR.n138 VPWR.n37 72.7879
R1428 VPWR.n134 VPWR.n36 72.7879
R1429 VPWR.n130 VPWR.n35 72.7879
R1430 VPWR.n126 VPWR.n34 72.7879
R1431 VPWR.n122 VPWR.n33 72.7879
R1432 VPWR.n118 VPWR.n32 72.7879
R1433 VPWR.n114 VPWR.n31 72.7879
R1434 VPWR.n110 VPWR.n30 72.7879
R1435 VPWR.n106 VPWR.n29 72.7879
R1436 VPWR.n102 VPWR.n28 72.7879
R1437 VPWR.n98 VPWR.n27 72.7879
R1438 VPWR.n94 VPWR.n26 72.7879
R1439 VPWR.n90 VPWR.n25 72.7879
R1440 VPWR.n86 VPWR.n24 72.7879
R1441 VPWR.n82 VPWR.n23 72.7879
R1442 VPWR.n78 VPWR.n22 72.7879
R1443 VPWR.n74 VPWR.n21 72.7879
R1444 VPWR.n70 VPWR.n20 72.7879
R1445 VPWR.n66 VPWR.n19 72.7879
R1446 VPWR.n62 VPWR.n18 72.7879
R1447 VPWR.n58 VPWR.n17 72.7879
R1448 VPWR.n54 VPWR.n16 72.7879
R1449 VPWR.n50 VPWR.n15 72.7879
R1450 VPWR.n46 VPWR.n14 72.7879
R1451 VPWR.n321 VPWR.n172 72.7879
R1452 VPWR.n315 VPWR.n173 72.7879
R1453 VPWR.n311 VPWR.n174 72.7879
R1454 VPWR.n307 VPWR.n175 72.7879
R1455 VPWR.n303 VPWR.n176 72.7879
R1456 VPWR.n299 VPWR.n177 72.7879
R1457 VPWR.n295 VPWR.n178 72.7879
R1458 VPWR.n291 VPWR.n179 72.7879
R1459 VPWR.n287 VPWR.n180 72.7879
R1460 VPWR.n283 VPWR.n181 72.7879
R1461 VPWR.n279 VPWR.n182 72.7879
R1462 VPWR.n275 VPWR.n183 72.7879
R1463 VPWR.n271 VPWR.n184 72.7879
R1464 VPWR.n267 VPWR.n185 72.7879
R1465 VPWR.n263 VPWR.n186 72.7879
R1466 VPWR.n259 VPWR.n187 72.7879
R1467 VPWR.n255 VPWR.n188 72.7879
R1468 VPWR.n251 VPWR.n189 72.7879
R1469 VPWR.n247 VPWR.n190 72.7879
R1470 VPWR.n243 VPWR.n191 72.7879
R1471 VPWR.n239 VPWR.n192 72.7879
R1472 VPWR.n235 VPWR.n193 72.7879
R1473 VPWR.n231 VPWR.n194 72.7879
R1474 VPWR.n227 VPWR.n195 72.7879
R1475 VPWR.n223 VPWR.n196 72.7879
R1476 VPWR.n219 VPWR.n197 72.7879
R1477 VPWR.n215 VPWR.n198 72.7879
R1478 VPWR.n211 VPWR.n199 72.7879
R1479 VPWR.n207 VPWR.n200 72.7879
R1480 VPWR.n203 VPWR.n201 72.7879
R1481 VPWR.n494 VPWR.n493 56.1076
R1482 VPWR.n493 VPWR.n492 56.1076
R1483 VPWR.n493 VPWR.n375 56.1076
R1484 VPWR.n493 VPWR.n374 56.1076
R1485 VPWR.n493 VPWR.n373 56.1076
R1486 VPWR.n493 VPWR.n372 56.1076
R1487 VPWR.n493 VPWR.n371 56.1076
R1488 VPWR.n493 VPWR.n370 56.1076
R1489 VPWR.n493 VPWR.n369 56.1076
R1490 VPWR.n493 VPWR.n368 56.1076
R1491 VPWR.n493 VPWR.n367 56.1076
R1492 VPWR.n493 VPWR.n366 56.1076
R1493 VPWR.n493 VPWR.n365 56.1076
R1494 VPWR.n493 VPWR.n364 56.1076
R1495 VPWR.n493 VPWR.n363 56.1076
R1496 VPWR.n493 VPWR.n362 56.1076
R1497 VPWR.n493 VPWR.n361 56.1076
R1498 VPWR.n493 VPWR.n360 56.1076
R1499 VPWR.n493 VPWR.n359 56.1076
R1500 VPWR.n493 VPWR.n358 56.1076
R1501 VPWR.n493 VPWR.n357 56.1076
R1502 VPWR.n493 VPWR.n356 56.1076
R1503 VPWR.n493 VPWR.n355 56.1076
R1504 VPWR.n493 VPWR.n354 56.1076
R1505 VPWR.n493 VPWR.n353 56.1076
R1506 VPWR.n493 VPWR.n352 56.1076
R1507 VPWR.n493 VPWR.n351 56.1076
R1508 VPWR.n493 VPWR.n350 56.1076
R1509 VPWR.n493 VPWR.n349 56.1076
R1510 VPWR.n493 VPWR.n348 56.1076
R1511 VPWR.n655 VPWR.n654 56.1076
R1512 VPWR.n654 VPWR.n507 56.1076
R1513 VPWR.n654 VPWR.n508 56.1076
R1514 VPWR.n654 VPWR.n509 56.1076
R1515 VPWR.n654 VPWR.n510 56.1076
R1516 VPWR.n654 VPWR.n511 56.1076
R1517 VPWR.n654 VPWR.n512 56.1076
R1518 VPWR.n654 VPWR.n513 56.1076
R1519 VPWR.n654 VPWR.n514 56.1076
R1520 VPWR.n654 VPWR.n515 56.1076
R1521 VPWR.n654 VPWR.n516 56.1076
R1522 VPWR.n654 VPWR.n517 56.1076
R1523 VPWR.n654 VPWR.n518 56.1076
R1524 VPWR.n654 VPWR.n519 56.1076
R1525 VPWR.n654 VPWR.n520 56.1076
R1526 VPWR.n654 VPWR.n521 56.1076
R1527 VPWR.n654 VPWR.n522 56.1076
R1528 VPWR.n654 VPWR.n523 56.1076
R1529 VPWR.n654 VPWR.n524 56.1076
R1530 VPWR.n654 VPWR.n525 56.1076
R1531 VPWR.n654 VPWR.n526 56.1076
R1532 VPWR.n654 VPWR.n527 56.1076
R1533 VPWR.n654 VPWR.n528 56.1076
R1534 VPWR.n654 VPWR.n529 56.1076
R1535 VPWR.n654 VPWR.n530 56.1076
R1536 VPWR.n654 VPWR.n531 56.1076
R1537 VPWR.n654 VPWR.n532 56.1076
R1538 VPWR.n654 VPWR.n533 56.1076
R1539 VPWR.n654 VPWR.n534 56.1076
R1540 VPWR.n654 VPWR.n535 56.1076
R1541 VPWR.n160 VPWR.n159 56.1076
R1542 VPWR.n159 VPWR.n158 56.1076
R1543 VPWR.n159 VPWR.n41 56.1076
R1544 VPWR.n159 VPWR.n40 56.1076
R1545 VPWR.n159 VPWR.n39 56.1076
R1546 VPWR.n159 VPWR.n38 56.1076
R1547 VPWR.n159 VPWR.n37 56.1076
R1548 VPWR.n159 VPWR.n36 56.1076
R1549 VPWR.n159 VPWR.n35 56.1076
R1550 VPWR.n159 VPWR.n34 56.1076
R1551 VPWR.n159 VPWR.n33 56.1076
R1552 VPWR.n159 VPWR.n32 56.1076
R1553 VPWR.n159 VPWR.n31 56.1076
R1554 VPWR.n159 VPWR.n30 56.1076
R1555 VPWR.n159 VPWR.n29 56.1076
R1556 VPWR.n159 VPWR.n28 56.1076
R1557 VPWR.n159 VPWR.n27 56.1076
R1558 VPWR.n159 VPWR.n26 56.1076
R1559 VPWR.n159 VPWR.n25 56.1076
R1560 VPWR.n159 VPWR.n24 56.1076
R1561 VPWR.n159 VPWR.n23 56.1076
R1562 VPWR.n159 VPWR.n22 56.1076
R1563 VPWR.n159 VPWR.n21 56.1076
R1564 VPWR.n159 VPWR.n20 56.1076
R1565 VPWR.n159 VPWR.n19 56.1076
R1566 VPWR.n159 VPWR.n18 56.1076
R1567 VPWR.n159 VPWR.n17 56.1076
R1568 VPWR.n159 VPWR.n16 56.1076
R1569 VPWR.n159 VPWR.n15 56.1076
R1570 VPWR.n159 VPWR.n14 56.1076
R1571 VPWR.n321 VPWR.n320 56.1076
R1572 VPWR.n320 VPWR.n173 56.1076
R1573 VPWR.n320 VPWR.n174 56.1076
R1574 VPWR.n320 VPWR.n175 56.1076
R1575 VPWR.n320 VPWR.n176 56.1076
R1576 VPWR.n320 VPWR.n177 56.1076
R1577 VPWR.n320 VPWR.n178 56.1076
R1578 VPWR.n320 VPWR.n179 56.1076
R1579 VPWR.n320 VPWR.n180 56.1076
R1580 VPWR.n320 VPWR.n181 56.1076
R1581 VPWR.n320 VPWR.n182 56.1076
R1582 VPWR.n320 VPWR.n183 56.1076
R1583 VPWR.n320 VPWR.n184 56.1076
R1584 VPWR.n320 VPWR.n185 56.1076
R1585 VPWR.n320 VPWR.n186 56.1076
R1586 VPWR.n320 VPWR.n187 56.1076
R1587 VPWR.n320 VPWR.n188 56.1076
R1588 VPWR.n320 VPWR.n189 56.1076
R1589 VPWR.n320 VPWR.n190 56.1076
R1590 VPWR.n320 VPWR.n191 56.1076
R1591 VPWR.n320 VPWR.n192 56.1076
R1592 VPWR.n320 VPWR.n193 56.1076
R1593 VPWR.n320 VPWR.n194 56.1076
R1594 VPWR.n320 VPWR.n195 56.1076
R1595 VPWR.n320 VPWR.n196 56.1076
R1596 VPWR.n320 VPWR.n197 56.1076
R1597 VPWR.n320 VPWR.n198 56.1076
R1598 VPWR.n320 VPWR.n199 56.1076
R1599 VPWR.n320 VPWR.n200 56.1076
R1600 VPWR.n320 VPWR.n201 56.1076
R1601 VPWR.n379 VPWR.n378 25.6005
R1602 VPWR.n382 VPWR.n379 25.6005
R1603 VPWR.n383 VPWR.n382 25.6005
R1604 VPWR.n386 VPWR.n383 25.6005
R1605 VPWR.n387 VPWR.n386 25.6005
R1606 VPWR.n390 VPWR.n387 25.6005
R1607 VPWR.n391 VPWR.n390 25.6005
R1608 VPWR.n394 VPWR.n391 25.6005
R1609 VPWR.n395 VPWR.n394 25.6005
R1610 VPWR.n398 VPWR.n395 25.6005
R1611 VPWR.n399 VPWR.n398 25.6005
R1612 VPWR.n402 VPWR.n399 25.6005
R1613 VPWR.n403 VPWR.n402 25.6005
R1614 VPWR.n406 VPWR.n403 25.6005
R1615 VPWR.n407 VPWR.n406 25.6005
R1616 VPWR.n410 VPWR.n407 25.6005
R1617 VPWR.n411 VPWR.n410 25.6005
R1618 VPWR.n414 VPWR.n411 25.6005
R1619 VPWR.n415 VPWR.n414 25.6005
R1620 VPWR.n418 VPWR.n415 25.6005
R1621 VPWR.n419 VPWR.n418 25.6005
R1622 VPWR.n422 VPWR.n419 25.6005
R1623 VPWR.n423 VPWR.n422 25.6005
R1624 VPWR.n426 VPWR.n423 25.6005
R1625 VPWR.n427 VPWR.n426 25.6005
R1626 VPWR.n430 VPWR.n427 25.6005
R1627 VPWR.n431 VPWR.n430 25.6005
R1628 VPWR.n434 VPWR.n431 25.6005
R1629 VPWR.n435 VPWR.n434 25.6005
R1630 VPWR.n438 VPWR.n435 25.6005
R1631 VPWR.n439 VPWR.n438 25.6005
R1632 VPWR.n442 VPWR.n439 25.6005
R1633 VPWR.n443 VPWR.n442 25.6005
R1634 VPWR.n446 VPWR.n443 25.6005
R1635 VPWR.n447 VPWR.n446 25.6005
R1636 VPWR.n450 VPWR.n447 25.6005
R1637 VPWR.n451 VPWR.n450 25.6005
R1638 VPWR.n454 VPWR.n451 25.6005
R1639 VPWR.n455 VPWR.n454 25.6005
R1640 VPWR.n458 VPWR.n455 25.6005
R1641 VPWR.n459 VPWR.n458 25.6005
R1642 VPWR.n462 VPWR.n459 25.6005
R1643 VPWR.n463 VPWR.n462 25.6005
R1644 VPWR.n466 VPWR.n463 25.6005
R1645 VPWR.n467 VPWR.n466 25.6005
R1646 VPWR.n470 VPWR.n467 25.6005
R1647 VPWR.n471 VPWR.n470 25.6005
R1648 VPWR.n474 VPWR.n471 25.6005
R1649 VPWR.n475 VPWR.n474 25.6005
R1650 VPWR.n478 VPWR.n475 25.6005
R1651 VPWR.n479 VPWR.n478 25.6005
R1652 VPWR.n482 VPWR.n479 25.6005
R1653 VPWR.n483 VPWR.n482 25.6005
R1654 VPWR.n486 VPWR.n483 25.6005
R1655 VPWR.n488 VPWR.n486 25.6005
R1656 VPWR.n489 VPWR.n488 25.6005
R1657 VPWR.n490 VPWR.n489 25.6005
R1658 VPWR.n490 VPWR.n346 25.6005
R1659 VPWR.n496 VPWR.n346 25.6005
R1660 VPWR.n497 VPWR.n496 25.6005
R1661 VPWR.n503 VPWR.n342 25.6005
R1662 VPWR.n504 VPWR.n503 25.6005
R1663 VPWR.n659 VPWR.n504 25.6005
R1664 VPWR.n659 VPWR.n658 25.6005
R1665 VPWR.n657 VPWR.n505 25.6005
R1666 VPWR.n652 VPWR.n505 25.6005
R1667 VPWR.n652 VPWR.n651 25.6005
R1668 VPWR.n651 VPWR.n650 25.6005
R1669 VPWR.n650 VPWR.n647 25.6005
R1670 VPWR.n647 VPWR.n646 25.6005
R1671 VPWR.n646 VPWR.n643 25.6005
R1672 VPWR.n643 VPWR.n642 25.6005
R1673 VPWR.n642 VPWR.n639 25.6005
R1674 VPWR.n639 VPWR.n638 25.6005
R1675 VPWR.n638 VPWR.n635 25.6005
R1676 VPWR.n635 VPWR.n634 25.6005
R1677 VPWR.n634 VPWR.n631 25.6005
R1678 VPWR.n631 VPWR.n630 25.6005
R1679 VPWR.n630 VPWR.n627 25.6005
R1680 VPWR.n627 VPWR.n626 25.6005
R1681 VPWR.n626 VPWR.n623 25.6005
R1682 VPWR.n623 VPWR.n622 25.6005
R1683 VPWR.n622 VPWR.n619 25.6005
R1684 VPWR.n619 VPWR.n618 25.6005
R1685 VPWR.n618 VPWR.n615 25.6005
R1686 VPWR.n615 VPWR.n614 25.6005
R1687 VPWR.n614 VPWR.n611 25.6005
R1688 VPWR.n611 VPWR.n610 25.6005
R1689 VPWR.n610 VPWR.n607 25.6005
R1690 VPWR.n607 VPWR.n606 25.6005
R1691 VPWR.n606 VPWR.n603 25.6005
R1692 VPWR.n603 VPWR.n602 25.6005
R1693 VPWR.n602 VPWR.n599 25.6005
R1694 VPWR.n599 VPWR.n598 25.6005
R1695 VPWR.n598 VPWR.n595 25.6005
R1696 VPWR.n595 VPWR.n594 25.6005
R1697 VPWR.n594 VPWR.n591 25.6005
R1698 VPWR.n591 VPWR.n590 25.6005
R1699 VPWR.n590 VPWR.n587 25.6005
R1700 VPWR.n587 VPWR.n586 25.6005
R1701 VPWR.n586 VPWR.n583 25.6005
R1702 VPWR.n583 VPWR.n582 25.6005
R1703 VPWR.n582 VPWR.n579 25.6005
R1704 VPWR.n579 VPWR.n578 25.6005
R1705 VPWR.n578 VPWR.n575 25.6005
R1706 VPWR.n575 VPWR.n574 25.6005
R1707 VPWR.n574 VPWR.n571 25.6005
R1708 VPWR.n571 VPWR.n570 25.6005
R1709 VPWR.n570 VPWR.n567 25.6005
R1710 VPWR.n567 VPWR.n566 25.6005
R1711 VPWR.n566 VPWR.n563 25.6005
R1712 VPWR.n563 VPWR.n562 25.6005
R1713 VPWR.n562 VPWR.n559 25.6005
R1714 VPWR.n559 VPWR.n558 25.6005
R1715 VPWR.n558 VPWR.n555 25.6005
R1716 VPWR.n555 VPWR.n554 25.6005
R1717 VPWR.n554 VPWR.n551 25.6005
R1718 VPWR.n551 VPWR.n550 25.6005
R1719 VPWR.n550 VPWR.n547 25.6005
R1720 VPWR.n547 VPWR.n546 25.6005
R1721 VPWR.n546 VPWR.n543 25.6005
R1722 VPWR.n543 VPWR.n542 25.6005
R1723 VPWR.n542 VPWR.n539 25.6005
R1724 VPWR.n539 VPWR.n538 25.6005
R1725 VPWR.n498 VPWR.n335 25.6005
R1726 VPWR VPWR.n335 25.6005
R1727 VPWR VPWR.n663 25.6005
R1728 VPWR.n663 VPWR.n337 25.6005
R1729 VPWR.n45 VPWR.n44 25.6005
R1730 VPWR.n48 VPWR.n45 25.6005
R1731 VPWR.n49 VPWR.n48 25.6005
R1732 VPWR.n52 VPWR.n49 25.6005
R1733 VPWR.n53 VPWR.n52 25.6005
R1734 VPWR.n56 VPWR.n53 25.6005
R1735 VPWR.n57 VPWR.n56 25.6005
R1736 VPWR.n60 VPWR.n57 25.6005
R1737 VPWR.n61 VPWR.n60 25.6005
R1738 VPWR.n64 VPWR.n61 25.6005
R1739 VPWR.n65 VPWR.n64 25.6005
R1740 VPWR.n68 VPWR.n65 25.6005
R1741 VPWR.n69 VPWR.n68 25.6005
R1742 VPWR.n72 VPWR.n69 25.6005
R1743 VPWR.n73 VPWR.n72 25.6005
R1744 VPWR.n76 VPWR.n73 25.6005
R1745 VPWR.n77 VPWR.n76 25.6005
R1746 VPWR.n80 VPWR.n77 25.6005
R1747 VPWR.n81 VPWR.n80 25.6005
R1748 VPWR.n84 VPWR.n81 25.6005
R1749 VPWR.n85 VPWR.n84 25.6005
R1750 VPWR.n88 VPWR.n85 25.6005
R1751 VPWR.n89 VPWR.n88 25.6005
R1752 VPWR.n92 VPWR.n89 25.6005
R1753 VPWR.n93 VPWR.n92 25.6005
R1754 VPWR.n96 VPWR.n93 25.6005
R1755 VPWR.n97 VPWR.n96 25.6005
R1756 VPWR.n100 VPWR.n97 25.6005
R1757 VPWR.n101 VPWR.n100 25.6005
R1758 VPWR.n104 VPWR.n101 25.6005
R1759 VPWR.n105 VPWR.n104 25.6005
R1760 VPWR.n108 VPWR.n105 25.6005
R1761 VPWR.n109 VPWR.n108 25.6005
R1762 VPWR.n112 VPWR.n109 25.6005
R1763 VPWR.n113 VPWR.n112 25.6005
R1764 VPWR.n116 VPWR.n113 25.6005
R1765 VPWR.n117 VPWR.n116 25.6005
R1766 VPWR.n120 VPWR.n117 25.6005
R1767 VPWR.n121 VPWR.n120 25.6005
R1768 VPWR.n124 VPWR.n121 25.6005
R1769 VPWR.n125 VPWR.n124 25.6005
R1770 VPWR.n128 VPWR.n125 25.6005
R1771 VPWR.n129 VPWR.n128 25.6005
R1772 VPWR.n132 VPWR.n129 25.6005
R1773 VPWR.n133 VPWR.n132 25.6005
R1774 VPWR.n136 VPWR.n133 25.6005
R1775 VPWR.n137 VPWR.n136 25.6005
R1776 VPWR.n140 VPWR.n137 25.6005
R1777 VPWR.n141 VPWR.n140 25.6005
R1778 VPWR.n144 VPWR.n141 25.6005
R1779 VPWR.n145 VPWR.n144 25.6005
R1780 VPWR.n148 VPWR.n145 25.6005
R1781 VPWR.n149 VPWR.n148 25.6005
R1782 VPWR.n152 VPWR.n149 25.6005
R1783 VPWR.n154 VPWR.n152 25.6005
R1784 VPWR.n155 VPWR.n154 25.6005
R1785 VPWR.n156 VPWR.n155 25.6005
R1786 VPWR.n156 VPWR.n12 25.6005
R1787 VPWR.n162 VPWR.n12 25.6005
R1788 VPWR.n163 VPWR.n162 25.6005
R1789 VPWR.n169 VPWR.n8 25.6005
R1790 VPWR.n170 VPWR.n169 25.6005
R1791 VPWR.n325 VPWR.n170 25.6005
R1792 VPWR.n325 VPWR.n324 25.6005
R1793 VPWR.n323 VPWR.n171 25.6005
R1794 VPWR.n318 VPWR.n171 25.6005
R1795 VPWR.n318 VPWR.n317 25.6005
R1796 VPWR.n317 VPWR.n316 25.6005
R1797 VPWR.n316 VPWR.n313 25.6005
R1798 VPWR.n313 VPWR.n312 25.6005
R1799 VPWR.n312 VPWR.n309 25.6005
R1800 VPWR.n309 VPWR.n308 25.6005
R1801 VPWR.n308 VPWR.n305 25.6005
R1802 VPWR.n305 VPWR.n304 25.6005
R1803 VPWR.n304 VPWR.n301 25.6005
R1804 VPWR.n301 VPWR.n300 25.6005
R1805 VPWR.n300 VPWR.n297 25.6005
R1806 VPWR.n297 VPWR.n296 25.6005
R1807 VPWR.n296 VPWR.n293 25.6005
R1808 VPWR.n293 VPWR.n292 25.6005
R1809 VPWR.n292 VPWR.n289 25.6005
R1810 VPWR.n289 VPWR.n288 25.6005
R1811 VPWR.n288 VPWR.n285 25.6005
R1812 VPWR.n285 VPWR.n284 25.6005
R1813 VPWR.n284 VPWR.n281 25.6005
R1814 VPWR.n281 VPWR.n280 25.6005
R1815 VPWR.n280 VPWR.n277 25.6005
R1816 VPWR.n277 VPWR.n276 25.6005
R1817 VPWR.n276 VPWR.n273 25.6005
R1818 VPWR.n273 VPWR.n272 25.6005
R1819 VPWR.n272 VPWR.n269 25.6005
R1820 VPWR.n269 VPWR.n268 25.6005
R1821 VPWR.n268 VPWR.n265 25.6005
R1822 VPWR.n265 VPWR.n264 25.6005
R1823 VPWR.n264 VPWR.n261 25.6005
R1824 VPWR.n261 VPWR.n260 25.6005
R1825 VPWR.n260 VPWR.n257 25.6005
R1826 VPWR.n257 VPWR.n256 25.6005
R1827 VPWR.n256 VPWR.n253 25.6005
R1828 VPWR.n253 VPWR.n252 25.6005
R1829 VPWR.n252 VPWR.n249 25.6005
R1830 VPWR.n249 VPWR.n248 25.6005
R1831 VPWR.n248 VPWR.n245 25.6005
R1832 VPWR.n245 VPWR.n244 25.6005
R1833 VPWR.n244 VPWR.n241 25.6005
R1834 VPWR.n241 VPWR.n240 25.6005
R1835 VPWR.n240 VPWR.n237 25.6005
R1836 VPWR.n237 VPWR.n236 25.6005
R1837 VPWR.n236 VPWR.n233 25.6005
R1838 VPWR.n233 VPWR.n232 25.6005
R1839 VPWR.n232 VPWR.n229 25.6005
R1840 VPWR.n229 VPWR.n228 25.6005
R1841 VPWR.n228 VPWR.n225 25.6005
R1842 VPWR.n225 VPWR.n224 25.6005
R1843 VPWR.n224 VPWR.n221 25.6005
R1844 VPWR.n221 VPWR.n220 25.6005
R1845 VPWR.n220 VPWR.n217 25.6005
R1846 VPWR.n217 VPWR.n216 25.6005
R1847 VPWR.n216 VPWR.n213 25.6005
R1848 VPWR.n213 VPWR.n212 25.6005
R1849 VPWR.n212 VPWR.n209 25.6005
R1850 VPWR.n209 VPWR.n208 25.6005
R1851 VPWR.n208 VPWR.n205 25.6005
R1852 VPWR.n205 VPWR.n204 25.6005
R1853 VPWR.n164 VPWR.n1 25.6005
R1854 VPWR VPWR.n1 25.6005
R1855 VPWR VPWR.n329 25.6005
R1856 VPWR.n329 VPWR.n3 25.6005
R1857 VPWR.n493 VPWR.n344 22.905
R1858 VPWR.n654 VPWR.n339 22.905
R1859 VPWR.n159 VPWR.n10 22.905
R1860 VPWR.n320 VPWR.n5 22.905
R1861 VPWR.n332 VPWR 22.8553
R1862 VPWR VPWR.n0 22.8553
R1863 VPWR.n664 VPWR 18.865
R1864 VPWR.n330 VPWR 18.865
R1865 VPWR.n501 VPWR.n344 14.5566
R1866 VPWR.n501 VPWR.t0 14.5566
R1867 VPWR.n661 VPWR.t0 14.5566
R1868 VPWR.n661 VPWR.n339 14.5566
R1869 VPWR.n167 VPWR.n10 14.5566
R1870 VPWR.n167 VPWR.t2 14.5566
R1871 VPWR.n327 VPWR.t2 14.5566
R1872 VPWR.n327 VPWR.n5 14.5566
R1873 VPWR.n665 VPWR.n664 13.7324
R1874 VPWR.n334 VPWR.n333 13.6031
R1875 VPWR.n333 VPWR.n332 11.4361
R1876 VPWR.n665 VPWR.n0 11.4361
R1877 VPWR VPWR.n331 4.87707
R1878 VPWR VPWR.n666 4.87707
R1879 VPWR.n333 VPWR.n331 2.44078
R1880 VPWR.n666 VPWR.n665 2.44078
R1881 VPWR.n330 VPWR 2.24827
R1882 VPWR.n664 VPWR.n334 0.78305
R1883 VPWR.n334 VPWR.n330 0.12975
C20 BIAS VGND 5.40204f
C21 INN VGND 1.68209f
C22 OUT VGND 4.26016f
C23 INP VGND 1.55504f
C24 VPWR VGND 25.41188f
C25 TAIL VGND 6.88781f $ **FLOATING
C26 MIR VGND 6.13771f $ **FLOATING
C27 VPWR.n0 VGND 0.01029f $ **FLOATING
C28 VPWR.n1 VGND 0.00219f $ **FLOATING
C29 VPWR.n2 VGND 0.00219f $ **FLOATING
C30 VPWR.n3 VGND 0.00486f $ **FLOATING
C31 VPWR.n4 VGND 0.00486f $ **FLOATING
C32 VPWR.t2 VGND 0.28648f $ **FLOATING
C33 VPWR.n5 VGND 0.36863f $ **FLOATING
C34 VPWR.n6 VGND 0.00219f $ **FLOATING
C35 VPWR.n7 VGND 0.00486f $ **FLOATING
C36 VPWR.n8 VGND 0.00486f $ **FLOATING
C37 VPWR.n9 VGND 0.00486f $ **FLOATING
C38 VPWR.n10 VGND 0.36863f $ **FLOATING
C39 VPWR.n11 VGND 0.00485f $ **FLOATING
C40 VPWR.n12 VGND 0.00219f $ **FLOATING
C41 VPWR.n13 VGND 0.00219f $ **FLOATING
C42 VPWR.n42 VGND 0.00219f $ **FLOATING
C43 VPWR.n43 VGND 0.00485f $ **FLOATING
C44 VPWR.n44 VGND 0.00485f $ **FLOATING
C45 VPWR.n45 VGND 0.00219f $ **FLOATING
C46 VPWR.n46 VGND 0.00219f $ **FLOATING
C47 VPWR.n47 VGND 0.00219f $ **FLOATING
C48 VPWR.n48 VGND 0.00219f $ **FLOATING
C49 VPWR.n49 VGND 0.00219f $ **FLOATING
C50 VPWR.n50 VGND 0.00219f $ **FLOATING
C51 VPWR.n51 VGND 0.00219f $ **FLOATING
C52 VPWR.n52 VGND 0.00219f $ **FLOATING
C53 VPWR.n53 VGND 0.00219f $ **FLOATING
C54 VPWR.n54 VGND 0.00219f $ **FLOATING
C55 VPWR.n55 VGND 0.00219f $ **FLOATING
C56 VPWR.n56 VGND 0.00219f $ **FLOATING
C57 VPWR.n57 VGND 0.00219f $ **FLOATING
C58 VPWR.n58 VGND 0.00219f $ **FLOATING
C59 VPWR.n59 VGND 0.00219f $ **FLOATING
C60 VPWR.n60 VGND 0.00219f $ **FLOATING
C61 VPWR.n61 VGND 0.00219f $ **FLOATING
C62 VPWR.n62 VGND 0.00219f $ **FLOATING
C63 VPWR.n63 VGND 0.00219f $ **FLOATING
C64 VPWR.n64 VGND 0.00219f $ **FLOATING
C65 VPWR.n65 VGND 0.00219f $ **FLOATING
C66 VPWR.n66 VGND 0.00219f $ **FLOATING
C67 VPWR.n67 VGND 0.00219f $ **FLOATING
C68 VPWR.n68 VGND 0.00219f $ **FLOATING
C69 VPWR.n69 VGND 0.00219f $ **FLOATING
C70 VPWR.n70 VGND 0.00219f $ **FLOATING
C71 VPWR.n71 VGND 0.00219f $ **FLOATING
C72 VPWR.n72 VGND 0.00219f $ **FLOATING
C73 VPWR.n73 VGND 0.00219f $ **FLOATING
C74 VPWR.n74 VGND 0.00219f $ **FLOATING
C75 VPWR.n75 VGND 0.00219f $ **FLOATING
C76 VPWR.n76 VGND 0.00219f $ **FLOATING
C77 VPWR.n77 VGND 0.00219f $ **FLOATING
C78 VPWR.n78 VGND 0.00219f $ **FLOATING
C79 VPWR.n79 VGND 0.00219f $ **FLOATING
C80 VPWR.n80 VGND 0.00219f $ **FLOATING
C81 VPWR.n81 VGND 0.00219f $ **FLOATING
C82 VPWR.n82 VGND 0.00219f $ **FLOATING
C83 VPWR.n83 VGND 0.00219f $ **FLOATING
C84 VPWR.n84 VGND 0.00219f $ **FLOATING
C85 VPWR.n85 VGND 0.00219f $ **FLOATING
C86 VPWR.n86 VGND 0.00219f $ **FLOATING
C87 VPWR.n87 VGND 0.00219f $ **FLOATING
C88 VPWR.n88 VGND 0.00219f $ **FLOATING
C89 VPWR.n89 VGND 0.00219f $ **FLOATING
C90 VPWR.n90 VGND 0.00219f $ **FLOATING
C91 VPWR.n91 VGND 0.00219f $ **FLOATING
C92 VPWR.n92 VGND 0.00219f $ **FLOATING
C93 VPWR.n93 VGND 0.00219f $ **FLOATING
C94 VPWR.n94 VGND 0.00219f $ **FLOATING
C95 VPWR.n95 VGND 0.00219f $ **FLOATING
C96 VPWR.n96 VGND 0.00219f $ **FLOATING
C97 VPWR.n97 VGND 0.00219f $ **FLOATING
C98 VPWR.n98 VGND 0.00219f $ **FLOATING
C99 VPWR.n99 VGND 0.00219f $ **FLOATING
C100 VPWR.n100 VGND 0.00219f $ **FLOATING
C101 VPWR.n101 VGND 0.00219f $ **FLOATING
C102 VPWR.n102 VGND 0.00219f $ **FLOATING
C103 VPWR.n103 VGND 0.00219f $ **FLOATING
C104 VPWR.n104 VGND 0.00219f $ **FLOATING
C105 VPWR.n105 VGND 0.00219f $ **FLOATING
C106 VPWR.n106 VGND 0.00219f $ **FLOATING
C107 VPWR.n107 VGND 0.00219f $ **FLOATING
C108 VPWR.n108 VGND 0.00219f $ **FLOATING
C109 VPWR.n109 VGND 0.00219f $ **FLOATING
C110 VPWR.n110 VGND 0.00219f $ **FLOATING
C111 VPWR.n111 VGND 0.00219f $ **FLOATING
C112 VPWR.n112 VGND 0.00219f $ **FLOATING
C113 VPWR.n113 VGND 0.00219f $ **FLOATING
C114 VPWR.n114 VGND 0.00219f $ **FLOATING
C115 VPWR.n115 VGND 0.00219f $ **FLOATING
C116 VPWR.n116 VGND 0.00219f $ **FLOATING
C117 VPWR.n117 VGND 0.00219f $ **FLOATING
C118 VPWR.n118 VGND 0.00219f $ **FLOATING
C119 VPWR.n119 VGND 0.00219f $ **FLOATING
C120 VPWR.n120 VGND 0.00219f $ **FLOATING
C121 VPWR.n121 VGND 0.00219f $ **FLOATING
C122 VPWR.n122 VGND 0.00219f $ **FLOATING
C123 VPWR.n123 VGND 0.00219f $ **FLOATING
C124 VPWR.n124 VGND 0.00219f $ **FLOATING
C125 VPWR.n125 VGND 0.00219f $ **FLOATING
C126 VPWR.n126 VGND 0.00219f $ **FLOATING
C127 VPWR.n127 VGND 0.00219f $ **FLOATING
C128 VPWR.n128 VGND 0.00219f $ **FLOATING
C129 VPWR.n129 VGND 0.00219f $ **FLOATING
C130 VPWR.n130 VGND 0.00219f $ **FLOATING
C131 VPWR.n131 VGND 0.00219f $ **FLOATING
C132 VPWR.n132 VGND 0.00219f $ **FLOATING
C133 VPWR.n133 VGND 0.00219f $ **FLOATING
C134 VPWR.n134 VGND 0.00219f $ **FLOATING
C135 VPWR.n135 VGND 0.00219f $ **FLOATING
C136 VPWR.n136 VGND 0.00219f $ **FLOATING
C137 VPWR.n137 VGND 0.00219f $ **FLOATING
C138 VPWR.n138 VGND 0.00219f $ **FLOATING
C139 VPWR.n139 VGND 0.00219f $ **FLOATING
C140 VPWR.n140 VGND 0.00219f $ **FLOATING
C141 VPWR.n141 VGND 0.00219f $ **FLOATING
C142 VPWR.n142 VGND 0.00219f $ **FLOATING
C143 VPWR.n143 VGND 0.00219f $ **FLOATING
C144 VPWR.n144 VGND 0.00219f $ **FLOATING
C145 VPWR.n145 VGND 0.00219f $ **FLOATING
C146 VPWR.n146 VGND 0.00219f $ **FLOATING
C147 VPWR.n147 VGND 0.00219f $ **FLOATING
C148 VPWR.n148 VGND 0.00219f $ **FLOATING
C149 VPWR.n149 VGND 0.00219f $ **FLOATING
C150 VPWR.n150 VGND 0.00219f $ **FLOATING
C151 VPWR.n151 VGND 0.00219f $ **FLOATING
C152 VPWR.n152 VGND 0.00219f $ **FLOATING
C153 VPWR.n153 VGND 0.00219f $ **FLOATING
C154 VPWR.n154 VGND 0.00219f $ **FLOATING
C155 VPWR.n155 VGND 0.00219f $ **FLOATING
C156 VPWR.n156 VGND 0.00219f $ **FLOATING
C157 VPWR.n157 VGND 0.00219f $ **FLOATING
C158 VPWR.n159 VGND 0.44868f $ **FLOATING
C159 VPWR.n161 VGND 0.00219f $ **FLOATING
C160 VPWR.n162 VGND 0.00219f $ **FLOATING
C161 VPWR.n163 VGND 0.00485f $ **FLOATING
C162 VPWR.n164 VGND 0.00486f $ **FLOATING
C163 VPWR.n165 VGND 0.00486f $ **FLOATING
C164 VPWR.n166 VGND 0.00219f $ **FLOATING
C165 VPWR.n167 VGND 0.28648f $ **FLOATING
C166 VPWR.n168 VGND 0.00219f $ **FLOATING
C167 VPWR.n169 VGND 0.00219f $ **FLOATING
C168 VPWR.n170 VGND 0.00219f $ **FLOATING
C169 VPWR.n171 VGND 0.00219f $ **FLOATING
C170 VPWR.n172 VGND 0.00219f $ **FLOATING
C171 VPWR.n202 VGND 0.00219f $ **FLOATING
C172 VPWR.n203 VGND 0.00485f $ **FLOATING
C173 VPWR.n204 VGND 0.00485f $ **FLOATING
C174 VPWR.n205 VGND 0.00219f $ **FLOATING
C175 VPWR.n206 VGND 0.00219f $ **FLOATING
C176 VPWR.n207 VGND 0.00219f $ **FLOATING
C177 VPWR.n208 VGND 0.00219f $ **FLOATING
C178 VPWR.n209 VGND 0.00219f $ **FLOATING
C179 VPWR.n210 VGND 0.00219f $ **FLOATING
C180 VPWR.n211 VGND 0.00219f $ **FLOATING
C181 VPWR.n212 VGND 0.00219f $ **FLOATING
C182 VPWR.n213 VGND 0.00219f $ **FLOATING
C183 VPWR.n214 VGND 0.00219f $ **FLOATING
C184 VPWR.n215 VGND 0.00219f $ **FLOATING
C185 VPWR.n216 VGND 0.00219f $ **FLOATING
C186 VPWR.n217 VGND 0.00219f $ **FLOATING
C187 VPWR.n218 VGND 0.00219f $ **FLOATING
C188 VPWR.n219 VGND 0.00219f $ **FLOATING
C189 VPWR.n220 VGND 0.00219f $ **FLOATING
C190 VPWR.n221 VGND 0.00219f $ **FLOATING
C191 VPWR.n222 VGND 0.00219f $ **FLOATING
C192 VPWR.n223 VGND 0.00219f $ **FLOATING
C193 VPWR.n224 VGND 0.00219f $ **FLOATING
C194 VPWR.n225 VGND 0.00219f $ **FLOATING
C195 VPWR.n226 VGND 0.00219f $ **FLOATING
C196 VPWR.n227 VGND 0.00219f $ **FLOATING
C197 VPWR.n228 VGND 0.00219f $ **FLOATING
C198 VPWR.n229 VGND 0.00219f $ **FLOATING
C199 VPWR.n230 VGND 0.00219f $ **FLOATING
C200 VPWR.n231 VGND 0.00219f $ **FLOATING
C201 VPWR.n232 VGND 0.00219f $ **FLOATING
C202 VPWR.n233 VGND 0.00219f $ **FLOATING
C203 VPWR.n234 VGND 0.00219f $ **FLOATING
C204 VPWR.n235 VGND 0.00219f $ **FLOATING
C205 VPWR.n236 VGND 0.00219f $ **FLOATING
C206 VPWR.n237 VGND 0.00219f $ **FLOATING
C207 VPWR.n238 VGND 0.00219f $ **FLOATING
C208 VPWR.n239 VGND 0.00219f $ **FLOATING
C209 VPWR.n240 VGND 0.00219f $ **FLOATING
C210 VPWR.n241 VGND 0.00219f $ **FLOATING
C211 VPWR.n242 VGND 0.00219f $ **FLOATING
C212 VPWR.n243 VGND 0.00219f $ **FLOATING
C213 VPWR.n244 VGND 0.00219f $ **FLOATING
C214 VPWR.n245 VGND 0.00219f $ **FLOATING
C215 VPWR.n246 VGND 0.00219f $ **FLOATING
C216 VPWR.n247 VGND 0.00219f $ **FLOATING
C217 VPWR.n248 VGND 0.00219f $ **FLOATING
C218 VPWR.n249 VGND 0.00219f $ **FLOATING
C219 VPWR.n250 VGND 0.00219f $ **FLOATING
C220 VPWR.n251 VGND 0.00219f $ **FLOATING
C221 VPWR.n252 VGND 0.00219f $ **FLOATING
C222 VPWR.n253 VGND 0.00219f $ **FLOATING
C223 VPWR.n254 VGND 0.00219f $ **FLOATING
C224 VPWR.n255 VGND 0.00219f $ **FLOATING
C225 VPWR.n256 VGND 0.00219f $ **FLOATING
C226 VPWR.n257 VGND 0.00219f $ **FLOATING
C227 VPWR.n258 VGND 0.00219f $ **FLOATING
C228 VPWR.n259 VGND 0.00219f $ **FLOATING
C229 VPWR.n260 VGND 0.00219f $ **FLOATING
C230 VPWR.n261 VGND 0.00219f $ **FLOATING
C231 VPWR.n262 VGND 0.00219f $ **FLOATING
C232 VPWR.n263 VGND 0.00219f $ **FLOATING
C233 VPWR.n264 VGND 0.00219f $ **FLOATING
C234 VPWR.n265 VGND 0.00219f $ **FLOATING
C235 VPWR.n266 VGND 0.00219f $ **FLOATING
C236 VPWR.n267 VGND 0.00219f $ **FLOATING
C237 VPWR.n268 VGND 0.00219f $ **FLOATING
C238 VPWR.n269 VGND 0.00219f $ **FLOATING
C239 VPWR.n270 VGND 0.00219f $ **FLOATING
C240 VPWR.n271 VGND 0.00219f $ **FLOATING
C241 VPWR.n272 VGND 0.00219f $ **FLOATING
C242 VPWR.n273 VGND 0.00219f $ **FLOATING
C243 VPWR.n274 VGND 0.00219f $ **FLOATING
C244 VPWR.n275 VGND 0.00219f $ **FLOATING
C245 VPWR.n276 VGND 0.00219f $ **FLOATING
C246 VPWR.n277 VGND 0.00219f $ **FLOATING
C247 VPWR.n278 VGND 0.00219f $ **FLOATING
C248 VPWR.n279 VGND 0.00219f $ **FLOATING
C249 VPWR.n280 VGND 0.00219f $ **FLOATING
C250 VPWR.n281 VGND 0.00219f $ **FLOATING
C251 VPWR.n282 VGND 0.00219f $ **FLOATING
C252 VPWR.n283 VGND 0.00219f $ **FLOATING
C253 VPWR.n284 VGND 0.00219f $ **FLOATING
C254 VPWR.n285 VGND 0.00219f $ **FLOATING
C255 VPWR.n286 VGND 0.00219f $ **FLOATING
C256 VPWR.n287 VGND 0.00219f $ **FLOATING
C257 VPWR.n288 VGND 0.00219f $ **FLOATING
C258 VPWR.n289 VGND 0.00219f $ **FLOATING
C259 VPWR.n290 VGND 0.00219f $ **FLOATING
C260 VPWR.n291 VGND 0.00219f $ **FLOATING
C261 VPWR.n292 VGND 0.00219f $ **FLOATING
C262 VPWR.n293 VGND 0.00219f $ **FLOATING
C263 VPWR.n294 VGND 0.00219f $ **FLOATING
C264 VPWR.n295 VGND 0.00219f $ **FLOATING
C265 VPWR.n296 VGND 0.00219f $ **FLOATING
C266 VPWR.n297 VGND 0.00219f $ **FLOATING
C267 VPWR.n298 VGND 0.00219f $ **FLOATING
C268 VPWR.n299 VGND 0.00219f $ **FLOATING
C269 VPWR.n300 VGND 0.00219f $ **FLOATING
C270 VPWR.n301 VGND 0.00219f $ **FLOATING
C271 VPWR.n302 VGND 0.00219f $ **FLOATING
C272 VPWR.n303 VGND 0.00219f $ **FLOATING
C273 VPWR.n304 VGND 0.00219f $ **FLOATING
C274 VPWR.n305 VGND 0.00219f $ **FLOATING
C275 VPWR.n306 VGND 0.00219f $ **FLOATING
C276 VPWR.n307 VGND 0.00219f $ **FLOATING
C277 VPWR.n308 VGND 0.00219f $ **FLOATING
C278 VPWR.n309 VGND 0.00219f $ **FLOATING
C279 VPWR.n310 VGND 0.00219f $ **FLOATING
C280 VPWR.n311 VGND 0.00219f $ **FLOATING
C281 VPWR.n312 VGND 0.00219f $ **FLOATING
C282 VPWR.n313 VGND 0.00219f $ **FLOATING
C283 VPWR.n314 VGND 0.00219f $ **FLOATING
C284 VPWR.n315 VGND 0.00219f $ **FLOATING
C285 VPWR.n316 VGND 0.00219f $ **FLOATING
C286 VPWR.n317 VGND 0.00219f $ **FLOATING
C287 VPWR.n318 VGND 0.00219f $ **FLOATING
C288 VPWR.n319 VGND 0.00219f $ **FLOATING
C289 VPWR.n320 VGND 0.44868f $ **FLOATING
C290 VPWR.n322 VGND 0.00485f $ **FLOATING
C291 VPWR.n323 VGND 0.00485f $ **FLOATING
C292 VPWR.n324 VGND 0.00486f $ **FLOATING
C293 VPWR.n325 VGND 0.00219f $ **FLOATING
C294 VPWR.n326 VGND 0.00219f $ **FLOATING
C295 VPWR.n327 VGND 0.28648f $ **FLOATING
C296 VPWR.n328 VGND 0.00219f $ **FLOATING
C297 VPWR.n329 VGND 0.00219f $ **FLOATING
C298 VPWR.n330 VGND 0.21019f $ **FLOATING
C299 VPWR.n331 VGND 0.01013f $ **FLOATING
C300 VPWR.t3 VGND 0.01233f $ **FLOATING
C301 VPWR.n332 VGND 0.01029f $ **FLOATING
C302 VPWR.n333 VGND 0.59065f $ **FLOATING
C303 VPWR.n334 VGND 0.17885f $ **FLOATING
C304 VPWR.n335 VGND 0.00219f $ **FLOATING
C305 VPWR.n336 VGND 0.00219f $ **FLOATING
C306 VPWR.n337 VGND 0.00486f $ **FLOATING
C307 VPWR.n338 VGND 0.00486f $ **FLOATING
C308 VPWR.t0 VGND 0.28648f $ **FLOATING
C309 VPWR.n339 VGND 0.36863f $ **FLOATING
C310 VPWR.n340 VGND 0.00219f $ **FLOATING
C311 VPWR.n341 VGND 0.00486f $ **FLOATING
C312 VPWR.n342 VGND 0.00486f $ **FLOATING
C313 VPWR.n343 VGND 0.00486f $ **FLOATING
C314 VPWR.n344 VGND 0.36863f $ **FLOATING
C315 VPWR.n345 VGND 0.00485f $ **FLOATING
C316 VPWR.n346 VGND 0.00219f $ **FLOATING
C317 VPWR.n347 VGND 0.00219f $ **FLOATING
C318 VPWR.n376 VGND 0.00219f $ **FLOATING
C319 VPWR.n377 VGND 0.00485f $ **FLOATING
C320 VPWR.n378 VGND 0.00485f $ **FLOATING
C321 VPWR.n379 VGND 0.00219f $ **FLOATING
C322 VPWR.n380 VGND 0.00219f $ **FLOATING
C323 VPWR.n381 VGND 0.00219f $ **FLOATING
C324 VPWR.n382 VGND 0.00219f $ **FLOATING
C325 VPWR.n383 VGND 0.00219f $ **FLOATING
C326 VPWR.n384 VGND 0.00219f $ **FLOATING
C327 VPWR.n385 VGND 0.00219f $ **FLOATING
C328 VPWR.n386 VGND 0.00219f $ **FLOATING
C329 VPWR.n387 VGND 0.00219f $ **FLOATING
C330 VPWR.n388 VGND 0.00219f $ **FLOATING
C331 VPWR.n389 VGND 0.00219f $ **FLOATING
C332 VPWR.n390 VGND 0.00219f $ **FLOATING
C333 VPWR.n391 VGND 0.00219f $ **FLOATING
C334 VPWR.n392 VGND 0.00219f $ **FLOATING
C335 VPWR.n393 VGND 0.00219f $ **FLOATING
C336 VPWR.n394 VGND 0.00219f $ **FLOATING
C337 VPWR.n395 VGND 0.00219f $ **FLOATING
C338 VPWR.n396 VGND 0.00219f $ **FLOATING
C339 VPWR.n397 VGND 0.00219f $ **FLOATING
C340 VPWR.n398 VGND 0.00219f $ **FLOATING
C341 VPWR.n399 VGND 0.00219f $ **FLOATING
C342 VPWR.n400 VGND 0.00219f $ **FLOATING
C343 VPWR.n401 VGND 0.00219f $ **FLOATING
C344 VPWR.n402 VGND 0.00219f $ **FLOATING
C345 VPWR.n403 VGND 0.00219f $ **FLOATING
C346 VPWR.n404 VGND 0.00219f $ **FLOATING
C347 VPWR.n405 VGND 0.00219f $ **FLOATING
C348 VPWR.n406 VGND 0.00219f $ **FLOATING
C349 VPWR.n407 VGND 0.00219f $ **FLOATING
C350 VPWR.n408 VGND 0.00219f $ **FLOATING
C351 VPWR.n409 VGND 0.00219f $ **FLOATING
C352 VPWR.n410 VGND 0.00219f $ **FLOATING
C353 VPWR.n411 VGND 0.00219f $ **FLOATING
C354 VPWR.n412 VGND 0.00219f $ **FLOATING
C355 VPWR.n413 VGND 0.00219f $ **FLOATING
C356 VPWR.n414 VGND 0.00219f $ **FLOATING
C357 VPWR.n415 VGND 0.00219f $ **FLOATING
C358 VPWR.n416 VGND 0.00219f $ **FLOATING
C359 VPWR.n417 VGND 0.00219f $ **FLOATING
C360 VPWR.n418 VGND 0.00219f $ **FLOATING
C361 VPWR.n419 VGND 0.00219f $ **FLOATING
C362 VPWR.n420 VGND 0.00219f $ **FLOATING
C363 VPWR.n421 VGND 0.00219f $ **FLOATING
C364 VPWR.n422 VGND 0.00219f $ **FLOATING
C365 VPWR.n423 VGND 0.00219f $ **FLOATING
C366 VPWR.n424 VGND 0.00219f $ **FLOATING
C367 VPWR.n425 VGND 0.00219f $ **FLOATING
C368 VPWR.n426 VGND 0.00219f $ **FLOATING
C369 VPWR.n427 VGND 0.00219f $ **FLOATING
C370 VPWR.n428 VGND 0.00219f $ **FLOATING
C371 VPWR.n429 VGND 0.00219f $ **FLOATING
C372 VPWR.n430 VGND 0.00219f $ **FLOATING
C373 VPWR.n431 VGND 0.00219f $ **FLOATING
C374 VPWR.n432 VGND 0.00219f $ **FLOATING
C375 VPWR.n433 VGND 0.00219f $ **FLOATING
C376 VPWR.n434 VGND 0.00219f $ **FLOATING
C377 VPWR.n435 VGND 0.00219f $ **FLOATING
C378 VPWR.n436 VGND 0.00219f $ **FLOATING
C379 VPWR.n437 VGND 0.00219f $ **FLOATING
C380 VPWR.n438 VGND 0.00219f $ **FLOATING
C381 VPWR.n439 VGND 0.00219f $ **FLOATING
C382 VPWR.n440 VGND 0.00219f $ **FLOATING
C383 VPWR.n441 VGND 0.00219f $ **FLOATING
C384 VPWR.n442 VGND 0.00219f $ **FLOATING
C385 VPWR.n443 VGND 0.00219f $ **FLOATING
C386 VPWR.n444 VGND 0.00219f $ **FLOATING
C387 VPWR.n445 VGND 0.00219f $ **FLOATING
C388 VPWR.n446 VGND 0.00219f $ **FLOATING
C389 VPWR.n447 VGND 0.00219f $ **FLOATING
C390 VPWR.n448 VGND 0.00219f $ **FLOATING
C391 VPWR.n449 VGND 0.00219f $ **FLOATING
C392 VPWR.n450 VGND 0.00219f $ **FLOATING
C393 VPWR.n451 VGND 0.00219f $ **FLOATING
C394 VPWR.n452 VGND 0.00219f $ **FLOATING
C395 VPWR.n453 VGND 0.00219f $ **FLOATING
C396 VPWR.n454 VGND 0.00219f $ **FLOATING
C397 VPWR.n455 VGND 0.00219f $ **FLOATING
C398 VPWR.n456 VGND 0.00219f $ **FLOATING
C399 VPWR.n457 VGND 0.00219f $ **FLOATING
C400 VPWR.n458 VGND 0.00219f $ **FLOATING
C401 VPWR.n459 VGND 0.00219f $ **FLOATING
C402 VPWR.n460 VGND 0.00219f $ **FLOATING
C403 VPWR.n461 VGND 0.00219f $ **FLOATING
C404 VPWR.n462 VGND 0.00219f $ **FLOATING
C405 VPWR.n463 VGND 0.00219f $ **FLOATING
C406 VPWR.n464 VGND 0.00219f $ **FLOATING
C407 VPWR.n465 VGND 0.00219f $ **FLOATING
C408 VPWR.n466 VGND 0.00219f $ **FLOATING
C409 VPWR.n467 VGND 0.00219f $ **FLOATING
C410 VPWR.n468 VGND 0.00219f $ **FLOATING
C411 VPWR.n469 VGND 0.00219f $ **FLOATING
C412 VPWR.n470 VGND 0.00219f $ **FLOATING
C413 VPWR.n471 VGND 0.00219f $ **FLOATING
C414 VPWR.n472 VGND 0.00219f $ **FLOATING
C415 VPWR.n473 VGND 0.00219f $ **FLOATING
C416 VPWR.n474 VGND 0.00219f $ **FLOATING
C417 VPWR.n475 VGND 0.00219f $ **FLOATING
C418 VPWR.n476 VGND 0.00219f $ **FLOATING
C419 VPWR.n477 VGND 0.00219f $ **FLOATING
C420 VPWR.n478 VGND 0.00219f $ **FLOATING
C421 VPWR.n479 VGND 0.00219f $ **FLOATING
C422 VPWR.n480 VGND 0.00219f $ **FLOATING
C423 VPWR.n481 VGND 0.00219f $ **FLOATING
C424 VPWR.n482 VGND 0.00219f $ **FLOATING
C425 VPWR.n483 VGND 0.00219f $ **FLOATING
C426 VPWR.n484 VGND 0.00219f $ **FLOATING
C427 VPWR.n485 VGND 0.00219f $ **FLOATING
C428 VPWR.n486 VGND 0.00219f $ **FLOATING
C429 VPWR.n487 VGND 0.00219f $ **FLOATING
C430 VPWR.n488 VGND 0.00219f $ **FLOATING
C431 VPWR.n489 VGND 0.00219f $ **FLOATING
C432 VPWR.n490 VGND 0.00219f $ **FLOATING
C433 VPWR.n491 VGND 0.00219f $ **FLOATING
C434 VPWR.n493 VGND 0.44868f $ **FLOATING
C435 VPWR.n495 VGND 0.00219f $ **FLOATING
C436 VPWR.n496 VGND 0.00219f $ **FLOATING
C437 VPWR.n497 VGND 0.00485f $ **FLOATING
C438 VPWR.n498 VGND 0.00486f $ **FLOATING
C439 VPWR.n499 VGND 0.00486f $ **FLOATING
C440 VPWR.n500 VGND 0.00219f $ **FLOATING
C441 VPWR.n501 VGND 0.28648f $ **FLOATING
C442 VPWR.n502 VGND 0.00219f $ **FLOATING
C443 VPWR.n503 VGND 0.00219f $ **FLOATING
C444 VPWR.n504 VGND 0.00219f $ **FLOATING
C445 VPWR.n505 VGND 0.00219f $ **FLOATING
C446 VPWR.n506 VGND 0.00219f $ **FLOATING
C447 VPWR.n536 VGND 0.00219f $ **FLOATING
C448 VPWR.n537 VGND 0.00485f $ **FLOATING
C449 VPWR.n538 VGND 0.00485f $ **FLOATING
C450 VPWR.n539 VGND 0.00219f $ **FLOATING
C451 VPWR.n540 VGND 0.00219f $ **FLOATING
C452 VPWR.n541 VGND 0.00219f $ **FLOATING
C453 VPWR.n542 VGND 0.00219f $ **FLOATING
C454 VPWR.n543 VGND 0.00219f $ **FLOATING
C455 VPWR.n544 VGND 0.00219f $ **FLOATING
C456 VPWR.n545 VGND 0.00219f $ **FLOATING
C457 VPWR.n546 VGND 0.00219f $ **FLOATING
C458 VPWR.n547 VGND 0.00219f $ **FLOATING
C459 VPWR.n548 VGND 0.00219f $ **FLOATING
C460 VPWR.n549 VGND 0.00219f $ **FLOATING
C461 VPWR.n550 VGND 0.00219f $ **FLOATING
C462 VPWR.n551 VGND 0.00219f $ **FLOATING
C463 VPWR.n552 VGND 0.00219f $ **FLOATING
C464 VPWR.n553 VGND 0.00219f $ **FLOATING
C465 VPWR.n554 VGND 0.00219f $ **FLOATING
C466 VPWR.n555 VGND 0.00219f $ **FLOATING
C467 VPWR.n556 VGND 0.00219f $ **FLOATING
C468 VPWR.n557 VGND 0.00219f $ **FLOATING
C469 VPWR.n558 VGND 0.00219f $ **FLOATING
C470 VPWR.n559 VGND 0.00219f $ **FLOATING
C471 VPWR.n560 VGND 0.00219f $ **FLOATING
C472 VPWR.n561 VGND 0.00219f $ **FLOATING
C473 VPWR.n562 VGND 0.00219f $ **FLOATING
C474 VPWR.n563 VGND 0.00219f $ **FLOATING
C475 VPWR.n564 VGND 0.00219f $ **FLOATING
C476 VPWR.n565 VGND 0.00219f $ **FLOATING
C477 VPWR.n566 VGND 0.00219f $ **FLOATING
C478 VPWR.n567 VGND 0.00219f $ **FLOATING
C479 VPWR.n568 VGND 0.00219f $ **FLOATING
C480 VPWR.n569 VGND 0.00219f $ **FLOATING
C481 VPWR.n570 VGND 0.00219f $ **FLOATING
C482 VPWR.n571 VGND 0.00219f $ **FLOATING
C483 VPWR.n572 VGND 0.00219f $ **FLOATING
C484 VPWR.n573 VGND 0.00219f $ **FLOATING
C485 VPWR.n574 VGND 0.00219f $ **FLOATING
C486 VPWR.n575 VGND 0.00219f $ **FLOATING
C487 VPWR.n576 VGND 0.00219f $ **FLOATING
C488 VPWR.n577 VGND 0.00219f $ **FLOATING
C489 VPWR.n578 VGND 0.00219f $ **FLOATING
C490 VPWR.n579 VGND 0.00219f $ **FLOATING
C491 VPWR.n580 VGND 0.00219f $ **FLOATING
C492 VPWR.n581 VGND 0.00219f $ **FLOATING
C493 VPWR.n582 VGND 0.00219f $ **FLOATING
C494 VPWR.n583 VGND 0.00219f $ **FLOATING
C495 VPWR.n584 VGND 0.00219f $ **FLOATING
C496 VPWR.n585 VGND 0.00219f $ **FLOATING
C497 VPWR.n586 VGND 0.00219f $ **FLOATING
C498 VPWR.n587 VGND 0.00219f $ **FLOATING
C499 VPWR.n588 VGND 0.00219f $ **FLOATING
C500 VPWR.n589 VGND 0.00219f $ **FLOATING
C501 VPWR.n590 VGND 0.00219f $ **FLOATING
C502 VPWR.n591 VGND 0.00219f $ **FLOATING
C503 VPWR.n592 VGND 0.00219f $ **FLOATING
C504 VPWR.n593 VGND 0.00219f $ **FLOATING
C505 VPWR.n594 VGND 0.00219f $ **FLOATING
C506 VPWR.n595 VGND 0.00219f $ **FLOATING
C507 VPWR.n596 VGND 0.00219f $ **FLOATING
C508 VPWR.n597 VGND 0.00219f $ **FLOATING
C509 VPWR.n598 VGND 0.00219f $ **FLOATING
C510 VPWR.n599 VGND 0.00219f $ **FLOATING
C511 VPWR.n600 VGND 0.00219f $ **FLOATING
C512 VPWR.n601 VGND 0.00219f $ **FLOATING
C513 VPWR.n602 VGND 0.00219f $ **FLOATING
C514 VPWR.n603 VGND 0.00219f $ **FLOATING
C515 VPWR.n604 VGND 0.00219f $ **FLOATING
C516 VPWR.n605 VGND 0.00219f $ **FLOATING
C517 VPWR.n606 VGND 0.00219f $ **FLOATING
C518 VPWR.n607 VGND 0.00219f $ **FLOATING
C519 VPWR.n608 VGND 0.00219f $ **FLOATING
C520 VPWR.n609 VGND 0.00219f $ **FLOATING
C521 VPWR.n610 VGND 0.00219f $ **FLOATING
C522 VPWR.n611 VGND 0.00219f $ **FLOATING
C523 VPWR.n612 VGND 0.00219f $ **FLOATING
C524 VPWR.n613 VGND 0.00219f $ **FLOATING
C525 VPWR.n614 VGND 0.00219f $ **FLOATING
C526 VPWR.n615 VGND 0.00219f $ **FLOATING
C527 VPWR.n616 VGND 0.00219f $ **FLOATING
C528 VPWR.n617 VGND 0.00219f $ **FLOATING
C529 VPWR.n618 VGND 0.00219f $ **FLOATING
C530 VPWR.n619 VGND 0.00219f $ **FLOATING
C531 VPWR.n620 VGND 0.00219f $ **FLOATING
C532 VPWR.n621 VGND 0.00219f $ **FLOATING
C533 VPWR.n622 VGND 0.00219f $ **FLOATING
C534 VPWR.n623 VGND 0.00219f $ **FLOATING
C535 VPWR.n624 VGND 0.00219f $ **FLOATING
C536 VPWR.n625 VGND 0.00219f $ **FLOATING
C537 VPWR.n626 VGND 0.00219f $ **FLOATING
C538 VPWR.n627 VGND 0.00219f $ **FLOATING
C539 VPWR.n628 VGND 0.00219f $ **FLOATING
C540 VPWR.n629 VGND 0.00219f $ **FLOATING
C541 VPWR.n630 VGND 0.00219f $ **FLOATING
C542 VPWR.n631 VGND 0.00219f $ **FLOATING
C543 VPWR.n632 VGND 0.00219f $ **FLOATING
C544 VPWR.n633 VGND 0.00219f $ **FLOATING
C545 VPWR.n634 VGND 0.00219f $ **FLOATING
C546 VPWR.n635 VGND 0.00219f $ **FLOATING
C547 VPWR.n636 VGND 0.00219f $ **FLOATING
C548 VPWR.n637 VGND 0.00219f $ **FLOATING
C549 VPWR.n638 VGND 0.00219f $ **FLOATING
C550 VPWR.n639 VGND 0.00219f $ **FLOATING
C551 VPWR.n640 VGND 0.00219f $ **FLOATING
C552 VPWR.n641 VGND 0.00219f $ **FLOATING
C553 VPWR.n642 VGND 0.00219f $ **FLOATING
C554 VPWR.n643 VGND 0.00219f $ **FLOATING
C555 VPWR.n644 VGND 0.00219f $ **FLOATING
C556 VPWR.n645 VGND 0.00219f $ **FLOATING
C557 VPWR.n646 VGND 0.00219f $ **FLOATING
C558 VPWR.n647 VGND 0.00219f $ **FLOATING
C559 VPWR.n648 VGND 0.00219f $ **FLOATING
C560 VPWR.n649 VGND 0.00219f $ **FLOATING
C561 VPWR.n650 VGND 0.00219f $ **FLOATING
C562 VPWR.n651 VGND 0.00219f $ **FLOATING
C563 VPWR.n652 VGND 0.00219f $ **FLOATING
C564 VPWR.n653 VGND 0.00219f $ **FLOATING
C565 VPWR.n654 VGND 0.44868f $ **FLOATING
C566 VPWR.n656 VGND 0.00485f $ **FLOATING
C567 VPWR.n657 VGND 0.00485f $ **FLOATING
C568 VPWR.n658 VGND 0.00486f $ **FLOATING
C569 VPWR.n659 VGND 0.00219f $ **FLOATING
C570 VPWR.n660 VGND 0.00219f $ **FLOATING
C571 VPWR.n661 VGND 0.28648f $ **FLOATING
C572 VPWR.n662 VGND 0.00219f $ **FLOATING
C573 VPWR.n663 VGND 0.00219f $ **FLOATING
C574 VPWR.n664 VGND 0.24481f $ **FLOATING
C575 VPWR.n665 VGND 0.59188f $ **FLOATING
C576 VPWR.t1 VGND 0.01233f $ **FLOATING
C577 VPWR.n666 VGND 0.01013f $ **FLOATING
C578 OUT.n0 VGND 0.0181f $ **FLOATING
C579 OUT.n1 VGND 0.00882f $ **FLOATING
C580 OUT.t0 VGND 0.04841f $ **FLOATING
C581 OUT.n2 VGND 0.16512f $ **FLOATING
C582 OUT.n3 VGND 0.02914f $ **FLOATING
C583 OUT.n4 VGND 0.39037f $ **FLOATING
C584 OUT.n5 VGND 1.02397f $ **FLOATING
C585 OUT.n6 VGND 1.13702f $ **FLOATING
C586 OUT.t1 VGND 0.02168f $ **FLOATING
C587 OUT.n7 VGND 0.01782f $ **FLOATING
C588 BIAS.t0 VGND 0.26292f $ **FLOATING
C589 TAIL.n0 VGND 0.0218f $ **FLOATING
C590 TAIL.n1 VGND 0.00708f $ **FLOATING
C591 TAIL.t1 VGND 0.01153f $ **FLOATING
C592 TAIL.n2 VGND 0.00682f $ **FLOATING
C593 TAIL.n3 VGND 0.26003f $ **FLOATING
C594 TAIL.n4 VGND 0.0066f $ **FLOATING
C595 TAIL.t2 VGND 0.03622f $ **FLOATING
C596 TAIL.n5 VGND 0.12356f $ **FLOATING
C597 TAIL.n6 VGND 0.0218f $ **FLOATING
C598 TAIL.n7 VGND 0.31243f $ **FLOATING
C599 TAIL.n8 VGND 1.08581f $ **FLOATING
C600 TAIL.n9 VGND 0.32825f $ **FLOATING
C601 TAIL.t0 VGND 0.03622f $ **FLOATING
C602 TAIL.n10 VGND 0.12356f $ **FLOATING
C603 TAIL.n11 VGND 0.0066f $ **FLOATING
C604 MIR.n0 VGND 0.01709f $ **FLOATING
C605 MIR.t1 VGND 0.02047f $ **FLOATING
C606 MIR.t3 VGND 1.04143f $ **FLOATING
C607 MIR.t0 VGND 1.04143f $ **FLOATING
C608 MIR.n1 VGND 0.43357f $ **FLOATING
C609 MIR.n2 VGND 0.00833f $ **FLOATING
C610 MIR.t2 VGND 0.0457f $ **FLOATING
C611 MIR.n3 VGND 0.1559f $ **FLOATING
C612 MIR.n4 VGND 0.02751f $ **FLOATING
C613 MIR.n5 VGND 0.36186f $ **FLOATING
C614 MIR.n6 VGND 0.59176f $ **FLOATING
C615 MIR.n7 VGND 0.96255f $ **FLOATING
C616 MIR.n8 VGND 0.01682f $ **FLOATING
.ends

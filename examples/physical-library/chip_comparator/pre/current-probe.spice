.subckt chip_comparator INP INN BIAS OUT VPWR VGND
XN_OUT register_cf_node_11c997d2fb65d3f3 PRE register_cf_node_11c997d2fb65d3f3_source VGND sky130_fd_pr__nfet_01v8 w=4 l=0.15 nf=1 m=1
Vregister_cf_11c997d2fb65d3f3 OUT register_cf_node_11c997d2fb65d3f3 0
Vregister_cf_11c997d2fb65d3f3_source VGND register_cf_node_11c997d2fb65d3f3_source 0
XPREAMP_N_INN register_cf_node_314b861c19c15af8 INN register_cf_node_314b861c19c15af8_source VGND sky130_fd_pr__nfet_01v8 w=10 l=1 nf=1 m=1
Vregister_cf_314b861c19c15af8 PREAMP__MIR register_cf_node_314b861c19c15af8 0
Vregister_cf_314b861c19c15af8_source PREAMP__TAIL register_cf_node_314b861c19c15af8_source 0
XPREAMP_N_INP register_cf_node_65e710f4d88146f8 INP register_cf_node_65e710f4d88146f8_source VGND sky130_fd_pr__nfet_01v8 w=10 l=1 nf=1 m=1
Vregister_cf_65e710f4d88146f8 PRE register_cf_node_65e710f4d88146f8 0
Vregister_cf_65e710f4d88146f8_source PREAMP__TAIL register_cf_node_65e710f4d88146f8_source 0
XPREAMP_N_TAIL register_cf_node_eb25d7e166e1c344 BIAS register_cf_node_eb25d7e166e1c344_source VGND sky130_fd_pr__nfet_01v8 w=2 l=1 nf=1 m=1
Vregister_cf_eb25d7e166e1c344 PREAMP__TAIL register_cf_node_eb25d7e166e1c344 0
Vregister_cf_eb25d7e166e1c344_source VGND register_cf_node_eb25d7e166e1c344_source 0
XPREAMP_P_DIODE register_cf_node_3ddc016d0bf4ff09 PREAMP__MIR register_cf_node_3ddc016d0bf4ff09_source VPWR sky130_fd_pr__pfet_01v8_hvt w=20 l=1 nf=1 m=1
Vregister_cf_3ddc016d0bf4ff09 PREAMP__MIR register_cf_node_3ddc016d0bf4ff09 0
Vregister_cf_3ddc016d0bf4ff09_source VPWR register_cf_node_3ddc016d0bf4ff09_source 0
XPREAMP_P_MIRROR register_cf_node_edba3ff3939efe08 PREAMP__MIR register_cf_node_edba3ff3939efe08_source VPWR sky130_fd_pr__pfet_01v8_hvt w=20 l=1 nf=1 m=1
Vregister_cf_edba3ff3939efe08 PRE register_cf_node_edba3ff3939efe08 0
Vregister_cf_edba3ff3939efe08_source VPWR register_cf_node_edba3ff3939efe08_source 0
XP_OUT register_cf_node_7c299422efe0f5e4 PRE register_cf_node_7c299422efe0f5e4_source VPWR sky130_fd_pr__pfet_01v8_hvt w=8 l=0.15 nf=1 m=1
Vregister_cf_7c299422efe0f5e4 OUT register_cf_node_7c299422efe0f5e4 0
Vregister_cf_7c299422efe0f5e4_source VPWR register_cf_node_7c299422efe0f5e4_source 0
.ends chip_comparator

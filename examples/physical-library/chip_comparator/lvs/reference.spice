.subckt chip_comparator INP INN BIAS OUT VPWR VGND
XN_OUT OUT PRE VGND VGND sky130_fd_pr__nfet_01v8 w=4 l=0.15 nf=1 m=1
XPREAMP_N_INN PREAMP__MIR INN PREAMP__TAIL VGND sky130_fd_pr__nfet_01v8 w=10 l=1 nf=1 m=1
XPREAMP_N_INP PRE INP PREAMP__TAIL VGND sky130_fd_pr__nfet_01v8 w=10 l=1 nf=1 m=1
XPREAMP_N_TAIL PREAMP__TAIL BIAS VGND VGND sky130_fd_pr__nfet_01v8 w=2 l=1 nf=1 m=1
XPREAMP_P_DIODE PREAMP__MIR PREAMP__MIR VPWR VPWR sky130_fd_pr__pfet_01v8_hvt w=20 l=1 nf=1 m=1
XPREAMP_P_MIRROR PRE PREAMP__MIR VPWR VPWR sky130_fd_pr__pfet_01v8_hvt w=20 l=1 nf=1 m=1
XP_OUT OUT PRE VPWR VPWR sky130_fd_pr__pfet_01v8_hvt w=8 l=0.15 nf=1 m=1
.ends chip_comparator

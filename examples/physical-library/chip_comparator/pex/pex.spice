* NGSPICE file created from chip_comparator.ext - technology: sky130A

.subckt chip_comparator VPWR VGND OUT BIAS INN INP
X0 PREAMP__TAIL.t0 INN.t0 PREAMP__MIR.t0 VGND.t0 sky130_fd_pr__nfet_01v8 ad=2.9 pd=20.58 as=2.9 ps=20.58 w=10 l=1
X1 VGND.t5 BIAS.t0 PREAMP__TAIL.t2 VGND.t4 sky130_fd_pr__nfet_01v8 ad=0.58 pd=4.58 as=0.58 ps=4.58 w=2 l=1
X2 PREAMP__TAIL.t1 INP.t0 PRE.t0 VGND.t1 sky130_fd_pr__nfet_01v8 ad=2.9 pd=20.58 as=2.9 ps=20.58 w=10 l=1
X3 VGND.t3 PRE.t2 OUT.t0 VGND.t2 sky130_fd_pr__nfet_01v8 ad=1.16 pd=8.58 as=1.16 ps=8.58 w=4 l=0.15
X4 VPWR.t5 PREAMP__MIR.t1 PREAMP__MIR.t2 VPWR.t4 sky130_fd_pr__pfet_01v8_hvt ad=5.8 pd=40.58 as=5.8 ps=40.58 w=20 l=1
X5 VPWR.t3 PREAMP__MIR.t3 PRE.t1 VPWR.t2 sky130_fd_pr__pfet_01v8_hvt ad=5.8 pd=40.58 as=5.8 ps=40.58 w=20 l=1
X6 VPWR.t1 PRE.t3 OUT.t1 VPWR.t0 sky130_fd_pr__pfet_01v8_hvt ad=2.32 pd=16.58 as=2.32 ps=16.58 w=8 l=0.15
C0 PREAMP__MIR PRE 1.00101f
C1 VPWR PREAMP__TAIL 0.04669f
C2 BIAS OUT 2.52098f
C3 BIAS PREAMP__MIR 0.49365f
C4 OUT PREAMP__MIR 0.00193f
C5 INP INN 0.37624f
C6 PRE INN 0.07209f
C7 VPWR PRE 3.32899f
C8 BIAS INN 0.85526f
C9 VPWR BIAS 0.00788f
C10 OUT INN 0
C11 VPWR OUT 2.0503f
C12 PREAMP__MIR INN 0.79371f
C13 VPWR PREAMP__MIR 5.35602f
C14 INP PREAMP__TAIL 0.97136f
C15 PRE PREAMP__TAIL 3.14823f
C16 BIAS PREAMP__TAIL 0.53514f
C17 OUT PREAMP__TAIL 0.24253f
C18 PREAMP__MIR PREAMP__TAIL 1.2497f
C19 VPWR INN 0.00367f
C20 INP PRE 0.43662f
C21 INP BIAS 0
C22 BIAS PRE 0.15464f
C23 INP OUT 0
C24 OUT PRE 3.93902f
C25 INN PREAMP__TAIL 1.09987f
C26 INP PREAMP__MIR 0.11267f
R0 INN INN.t0 332.712
R1 PREAMP__MIR PREAMP__MIR.t1 572.847
R2 PREAMP__MIR PREAMP__MIR.t3 572.847
R3 PREAMP__MIR.t2 PREAMP__MIR.n2 387.11
R4 PREAMP__MIR.n3 PREAMP__MIR.t2 381.113
R5 PREAMP__MIR PREAMP__MIR.n8 33.1304
R6 PREAMP__MIR.n1 PREAMP__MIR 27.3061
R7 PREAMP__MIR.n1 PREAMP__MIR 26.3826
R8 PREAMP__MIR.n3 PREAMP__MIR 22.8553
R9 PREAMP__MIR.n8 PREAMP__MIR.n7 14.1214
R10 PREAMP__MIR.n6 PREAMP__MIR.n5 13.9994
R11 PREAMP__MIR.n7 PREAMP__MIR.n0 13.3893
R12 PREAMP__MIR.n5 PREAMP__MIR.n4 13.0823
R13 PREAMP__MIR.n4 PREAMP__MIR.n3 11.4361
R14 PREAMP__MIR PREAMP__MIR.n0 6.32004
R15 PREAMP__MIR PREAMP__MIR.n2 4.87707
R16 PREAMP__MIR.n4 PREAMP__MIR.n2 2.44078
R17 PREAMP__MIR.n7 PREAMP__MIR.t0 1.7405
R18 PREAMP__MIR.n8 PREAMP__MIR.n6 1.13588
R19 PREAMP__MIR.n6 PREAMP__MIR.n0 0.755154
R20 PREAMP__MIR.n5 PREAMP__MIR.n1 0.393537
R21 PREAMP__TAIL.n2 PREAMP__TAIL.t2 181.41
R22 PREAMP__TAIL.t2 PREAMP__TAIL.n1 174.912
R23 PREAMP__TAIL PREAMP__TAIL.n11 33.1304
R24 PREAMP__TAIL.n6 PREAMP__TAIL 26.3913
R25 PREAMP__TAIL PREAMP__TAIL.n1 19.837
R26 PREAMP__TAIL.n8 PREAMP__TAIL.n3 17.6649
R27 PREAMP__TAIL.n8 PREAMP__TAIL.n7 16.0763
R28 PREAMP__TAIL.n9 PREAMP__TAIL.n8 15.1656
R29 PREAMP__TAIL.n5 PREAMP__TAIL.n4 14.9853
R30 PREAMP__TAIL.n3 PREAMP__TAIL.n1 14.1895
R31 PREAMP__TAIL.n11 PREAMP__TAIL.n10 14.1214
R32 PREAMP__TAIL.n10 PREAMP__TAIL.n0 13.3893
R33 PREAMP__TAIL.n6 PREAMP__TAIL.n5 11.2487
R34 PREAMP__TAIL PREAMP__TAIL.n4 7.07333
R35 PREAMP__TAIL PREAMP__TAIL.n0 6.32004
R36 PREAMP__TAIL.n2 PREAMP__TAIL 4.259
R37 PREAMP__TAIL.n7 PREAMP__TAIL.n6 3.15014
R38 PREAMP__TAIL.n3 PREAMP__TAIL.n2 3.04672
R39 PREAMP__TAIL.n5 PREAMP__TAIL.t1 1.7405
R40 PREAMP__TAIL.n10 PREAMP__TAIL.t0 1.7405
R41 PREAMP__TAIL.n11 PREAMP__TAIL.n9 1.13588
R42 PREAMP__TAIL.n9 PREAMP__TAIL.n0 0.755154
R43 PREAMP__TAIL.n7 PREAMP__TAIL.n4 0.243373
R44 VGND.n446 VGND.n9 6533.74
R45 VGND.n447 VGND.n446 5967.96
R46 VGND.n448 VGND.n9 3633.97
R47 VGND.n447 VGND.n10 2973.85
R48 VGND.n448 VGND.n447 2525.4
R49 VGND.n487 VGND.n450 1286.29
R50 VGND.n522 VGND.n451 1286.29
R51 VGND.n524 VGND.n8 1286.29
R52 VGND.n482 VGND.n7 1286.29
R53 VGND.n130 VGND.n120 1210.97
R54 VGND.n134 VGND.n122 1210.97
R55 VGND.n158 VGND.n110 1210.97
R56 VGND.n161 VGND.n160 1210.97
R57 VGND.n132 VGND.n9 1133.39
R58 VGND.n351 VGND.n187 1118.26
R59 VGND.n340 VGND.n262 1118.26
R60 VGND.n255 VGND.n185 1118.26
R61 VGND.n342 VGND.n260 1118.26
R62 VGND.n443 VGND.n29 1118.26
R63 VGND.n433 VGND.n355 1118.26
R64 VGND.n97 VGND.n27 1118.26
R65 VGND.n435 VGND.n168 1118.26
R66 VGND.n446 VGND.n445 897.612
R67 VGND.n354 VGND.n353 658.967
R68 VGND.n431 VGND.n355 585
R69 VGND.n430 VGND.n429 585
R70 VGND.n427 VGND.n356 585
R71 VGND.n427 VGND.n354 585
R72 VGND.n426 VGND.n425 585
R73 VGND.n424 VGND.n423 585
R74 VGND.n422 VGND.n358 585
R75 VGND.n420 VGND.n419 585
R76 VGND.n418 VGND.n359 585
R77 VGND.n417 VGND.n416 585
R78 VGND.n414 VGND.n360 585
R79 VGND.n412 VGND.n411 585
R80 VGND.n410 VGND.n361 585
R81 VGND.n409 VGND.n408 585
R82 VGND.n406 VGND.n362 585
R83 VGND.n404 VGND.n403 585
R84 VGND.n402 VGND.n363 585
R85 VGND.n401 VGND.n400 585
R86 VGND.n398 VGND.n364 585
R87 VGND.n396 VGND.n395 585
R88 VGND.n394 VGND.n365 585
R89 VGND.n393 VGND.n392 585
R90 VGND.n390 VGND.n366 585
R91 VGND.n388 VGND.n387 585
R92 VGND.n386 VGND.n367 585
R93 VGND.n385 VGND.n384 585
R94 VGND.n382 VGND.n368 585
R95 VGND.n380 VGND.n379 585
R96 VGND.n378 VGND.n369 585
R97 VGND.n377 VGND.n376 585
R98 VGND.n374 VGND.n370 585
R99 VGND.n372 VGND.n371 585
R100 VGND.n168 VGND.n167 585
R101 VGND.n354 VGND.n168 585
R102 VGND.n436 VGND.n435 585
R103 VGND.n435 VGND.n434 585
R104 VGND.n437 VGND.n36 585
R105 VGND.n36 VGND.n34 585
R106 VGND.n438 VGND 585
R107 VGND.t0 VGND.n438 585
R108 VGND.n100 VGND.n35 585
R109 VGND.n35 VGND.n28 585
R110 VGND.n99 VGND.n27 585
R111 VGND.n444 VGND.n27 585
R112 VGND.n98 VGND.n97 585
R113 VGND.n96 VGND.n95 585
R114 VGND.n94 VGND.n93 585
R115 VGND.n92 VGND.n91 585
R116 VGND.n90 VGND.n89 585
R117 VGND.n88 VGND.n87 585
R118 VGND.n86 VGND.n85 585
R119 VGND.n84 VGND.n83 585
R120 VGND.n82 VGND.n81 585
R121 VGND.n80 VGND.n79 585
R122 VGND.n78 VGND.n77 585
R123 VGND.n76 VGND.n75 585
R124 VGND.n74 VGND.n73 585
R125 VGND.n72 VGND.n71 585
R126 VGND.n70 VGND.n69 585
R127 VGND.n68 VGND.n67 585
R128 VGND.n66 VGND.n65 585
R129 VGND.n64 VGND.n63 585
R130 VGND.n62 VGND.n61 585
R131 VGND.n60 VGND.n59 585
R132 VGND.n58 VGND.n57 585
R133 VGND.n56 VGND.n55 585
R134 VGND.n54 VGND.n53 585
R135 VGND.n52 VGND.n51 585
R136 VGND.n50 VGND.n49 585
R137 VGND.n48 VGND.n47 585
R138 VGND.n46 VGND.n45 585
R139 VGND.n44 VGND.n43 585
R140 VGND.n42 VGND.n41 585
R141 VGND.n40 VGND.n39 585
R142 VGND.n38 VGND.n37 585
R143 VGND.n31 VGND.n29 585
R144 VGND.n443 VGND.n442 585
R145 VGND.n444 VGND.n443 585
R146 VGND.n441 VGND.n30 585
R147 VGND.n30 VGND.n28 585
R148 VGND.n440 VGND.n439 585
R149 VGND.n439 VGND.t0 585
R150 VGND.n33 VGND.n32 585
R151 VGND.n34 VGND.n33 585
R152 VGND.n433 VGND.n432 585
R153 VGND.n434 VGND.n433 585
R154 VGND.n338 VGND.n262 585
R155 VGND.n337 VGND.n336 585
R156 VGND.n334 VGND.n263 585
R157 VGND.n334 VGND.n261 585
R158 VGND.n333 VGND.n332 585
R159 VGND.n331 VGND.n330 585
R160 VGND.n329 VGND.n265 585
R161 VGND.n327 VGND.n326 585
R162 VGND.n325 VGND.n266 585
R163 VGND.n324 VGND.n323 585
R164 VGND.n321 VGND.n267 585
R165 VGND.n319 VGND.n318 585
R166 VGND.n317 VGND.n268 585
R167 VGND.n316 VGND.n315 585
R168 VGND.n313 VGND.n269 585
R169 VGND.n311 VGND.n310 585
R170 VGND.n309 VGND.n270 585
R171 VGND.n308 VGND.n307 585
R172 VGND.n305 VGND.n271 585
R173 VGND.n303 VGND.n302 585
R174 VGND.n301 VGND.n272 585
R175 VGND.n300 VGND.n299 585
R176 VGND.n297 VGND.n273 585
R177 VGND.n295 VGND.n294 585
R178 VGND.n293 VGND.n274 585
R179 VGND.n292 VGND.n291 585
R180 VGND.n289 VGND.n275 585
R181 VGND.n287 VGND.n286 585
R182 VGND.n285 VGND.n276 585
R183 VGND.n284 VGND.n283 585
R184 VGND.n281 VGND.n277 585
R185 VGND.n279 VGND.n278 585
R186 VGND.n260 VGND.n259 585
R187 VGND.n261 VGND.n260 585
R188 VGND.n343 VGND.n342 585
R189 VGND.n342 VGND.n341 585
R190 VGND.n344 VGND.n194 585
R191 VGND.n194 VGND.n192 585
R192 VGND.n346 VGND 585
R193 VGND.t1 VGND.n346 585
R194 VGND.n258 VGND.n193 585
R195 VGND.n193 VGND.n186 585
R196 VGND.n257 VGND.n185 585
R197 VGND.n352 VGND.n185 585
R198 VGND.n256 VGND.n255 585
R199 VGND.n254 VGND.n253 585
R200 VGND.n252 VGND.n251 585
R201 VGND.n250 VGND.n249 585
R202 VGND.n248 VGND.n247 585
R203 VGND.n246 VGND.n245 585
R204 VGND.n244 VGND.n243 585
R205 VGND.n242 VGND.n241 585
R206 VGND.n240 VGND.n239 585
R207 VGND.n238 VGND.n237 585
R208 VGND.n236 VGND.n235 585
R209 VGND.n234 VGND.n233 585
R210 VGND.n232 VGND.n231 585
R211 VGND.n230 VGND.n229 585
R212 VGND.n228 VGND.n227 585
R213 VGND.n226 VGND.n225 585
R214 VGND.n224 VGND.n223 585
R215 VGND.n222 VGND.n221 585
R216 VGND.n220 VGND.n219 585
R217 VGND.n218 VGND.n217 585
R218 VGND.n216 VGND.n215 585
R219 VGND.n214 VGND.n213 585
R220 VGND.n212 VGND.n211 585
R221 VGND.n210 VGND.n209 585
R222 VGND.n208 VGND.n207 585
R223 VGND.n206 VGND.n205 585
R224 VGND.n204 VGND.n203 585
R225 VGND.n202 VGND.n201 585
R226 VGND.n200 VGND.n199 585
R227 VGND.n198 VGND.n197 585
R228 VGND.n196 VGND.n195 585
R229 VGND.n189 VGND.n187 585
R230 VGND.n351 VGND.n350 585
R231 VGND.n352 VGND.n351 585
R232 VGND.n349 VGND.n188 585
R233 VGND.n188 VGND.n186 585
R234 VGND.n348 VGND.n347 585
R235 VGND.n347 VGND.t1 585
R236 VGND.n191 VGND.n190 585
R237 VGND.n192 VGND.n191 585
R238 VGND.n340 VGND.n339 585
R239 VGND.n341 VGND.n340 585
R240 VGND.n136 VGND.n122 585
R241 VGND.n122 VGND.n121 585
R242 VGND.n138 VGND.n137 585
R243 VGND.n139 VGND.n138 585
R244 VGND.n116 VGND.n115 585
R245 VGND.n117 VGND.n116 585
R246 VGND.n147 VGND.n146 585
R247 VGND.n146 VGND.n145 585
R248 VGND.n148 VGND.n114 585
R249 VGND.n114 VGND.n113 585
R250 VGND.n151 VGND.n150 585
R251 VGND.n152 VGND.n151 585
R252 VGND.n149 VGND.n104 585
R253 VGND.n106 VGND.n104 585
R254 VGND.n160 VGND.n105 585
R255 VGND.n160 VGND.n159 585
R256 VGND.n161 VGND.n103 585
R257 VGND.n164 VGND.n163 585
R258 VGND VGND.n102 585
R259 VGND.n109 VGND.n101 585
R260 VGND.n156 VGND.n110 585
R261 VGND.n110 VGND.n10 585
R262 VGND.n158 VGND.n157 585
R263 VGND.n159 VGND.n158 585
R264 VGND.n155 VGND.n107 585
R265 VGND.n107 VGND.n106 585
R266 VGND.n154 VGND.n153 585
R267 VGND.n153 VGND.n152 585
R268 VGND.n112 VGND.n111 585
R269 VGND.n113 VGND.n112 585
R270 VGND.n144 VGND.n143 585
R271 VGND.n145 VGND.n144 585
R272 VGND.n142 VGND.n118 585
R273 VGND.n118 VGND.n117 585
R274 VGND.n141 VGND.n140 585
R275 VGND.n140 VGND.n139 585
R276 VGND.n120 VGND.n119 585
R277 VGND.n121 VGND.n120 585
R278 VGND.n130 VGND.n129 585
R279 VGND.n128 VGND.n126 585
R280 VGND.n127 VGND.n125 585
R281 VGND.n132 VGND.n125 585
R282 VGND.n124 VGND.n123 585
R283 VGND.n135 VGND.n134 585
R284 VGND.n482 VGND.n481 585
R285 VGND.n480 VGND.n459 585
R286 VGND.n479 VGND.n478 585
R287 VGND.n477 VGND.n476 585
R288 VGND.n475 VGND.n474 585
R289 VGND.n473 VGND.n472 585
R290 VGND.n471 VGND.n470 585
R291 VGND.n469 VGND.n468 585
R292 VGND.n467 VGND.n466 585
R293 VGND.n465 VGND.n464 585
R294 VGND.n463 VGND.n462 585
R295 VGND.n461 VGND.n460 585
R296 VGND.n453 VGND.n452 585
R297 VGND.n488 VGND.n487 585
R298 VGND.n489 VGND.n450 585
R299 VGND.n484 VGND.n450 585
R300 VGND.n522 VGND.n521 585
R301 VGND.n523 VGND.n522 585
R302 VGND.n520 VGND.n451 585
R303 VGND.n519 VGND.n518 585
R304 VGND.n516 VGND.n490 585
R305 VGND.n516 VGND.n449 585
R306 VGND.n515 VGND.n514 585
R307 VGND.n513 VGND.n512 585
R308 VGND.n511 VGND.n492 585
R309 VGND.n509 VGND.n508 585
R310 VGND.n507 VGND.n493 585
R311 VGND.n506 VGND.n505 585
R312 VGND.n503 VGND.n494 585
R313 VGND.n501 VGND.n500 585
R314 VGND.n499 VGND.n495 585
R315 VGND.n498 VGND.n497 585
R316 VGND.n8 VGND.n6 585
R317 VGND.n449 VGND.n8 585
R318 VGND.n525 VGND.n524 585
R319 VGND.n524 VGND.n523 585
R320 VGND.n7 VGND.n5 585
R321 VGND.n484 VGND.n7 585
R322 VGND.n449 VGND.n448 496.565
R323 VGND.n126 VGND.n125 394
R324 VGND.n125 VGND.n124 394
R325 VGND.n140 VGND.n120 394
R326 VGND.n140 VGND.n118 394
R327 VGND.n144 VGND.n118 394
R328 VGND.n144 VGND.n112 394
R329 VGND.n153 VGND.n112 394
R330 VGND.n153 VGND.n107 394
R331 VGND.n158 VGND.n107 394
R332 VGND.n110 VGND.n109 394
R333 VGND.n163 VGND.n102 394
R334 VGND.n138 VGND.n122 394
R335 VGND.n138 VGND.n116 394
R336 VGND.n146 VGND.n116 394
R337 VGND.n146 VGND.n114 394
R338 VGND.n151 VGND.n114 394
R339 VGND.n151 VGND.n104 394
R340 VGND.n160 VGND.n104 394
R341 VGND.n351 VGND.n188 394
R342 VGND.n347 VGND.n188 394
R343 VGND.n347 VGND.n191 394
R344 VGND.n340 VGND.n191 394
R345 VGND.n197 VGND.n196 394
R346 VGND.n201 VGND.n200 394
R347 VGND.n205 VGND.n204 394
R348 VGND.n209 VGND.n208 394
R349 VGND.n213 VGND.n212 394
R350 VGND.n217 VGND.n216 394
R351 VGND.n221 VGND.n220 394
R352 VGND.n225 VGND.n224 394
R353 VGND.n229 VGND.n228 394
R354 VGND.n233 VGND.n232 394
R355 VGND.n237 VGND.n236 394
R356 VGND.n241 VGND.n240 394
R357 VGND.n245 VGND.n244 394
R358 VGND.n249 VGND.n248 394
R359 VGND.n253 VGND.n252 394
R360 VGND.n193 VGND.n185 394
R361 VGND.n346 VGND.n193 394
R362 VGND.n346 VGND.n194 394
R363 VGND.n342 VGND.n194 394
R364 VGND.n336 VGND.n334 394
R365 VGND.n334 VGND.n333 394
R366 VGND.n330 VGND.n329 394
R367 VGND.n327 VGND.n266 394
R368 VGND.n323 VGND.n321 394
R369 VGND.n319 VGND.n268 394
R370 VGND.n315 VGND.n313 394
R371 VGND.n311 VGND.n270 394
R372 VGND.n307 VGND.n305 394
R373 VGND.n303 VGND.n272 394
R374 VGND.n299 VGND.n297 394
R375 VGND.n295 VGND.n274 394
R376 VGND.n291 VGND.n289 394
R377 VGND.n287 VGND.n276 394
R378 VGND.n283 VGND.n281 394
R379 VGND.n279 VGND.n260 394
R380 VGND.n443 VGND.n30 394
R381 VGND.n439 VGND.n30 394
R382 VGND.n439 VGND.n33 394
R383 VGND.n433 VGND.n33 394
R384 VGND.n39 VGND.n38 394
R385 VGND.n43 VGND.n42 394
R386 VGND.n47 VGND.n46 394
R387 VGND.n51 VGND.n50 394
R388 VGND.n55 VGND.n54 394
R389 VGND.n59 VGND.n58 394
R390 VGND.n63 VGND.n62 394
R391 VGND.n67 VGND.n66 394
R392 VGND.n71 VGND.n70 394
R393 VGND.n75 VGND.n74 394
R394 VGND.n79 VGND.n78 394
R395 VGND.n83 VGND.n82 394
R396 VGND.n87 VGND.n86 394
R397 VGND.n91 VGND.n90 394
R398 VGND.n95 VGND.n94 394
R399 VGND.n35 VGND.n27 394
R400 VGND.n438 VGND.n35 394
R401 VGND.n438 VGND.n36 394
R402 VGND.n435 VGND.n36 394
R403 VGND.n429 VGND.n427 394
R404 VGND.n427 VGND.n426 394
R405 VGND.n423 VGND.n422 394
R406 VGND.n420 VGND.n359 394
R407 VGND.n416 VGND.n414 394
R408 VGND.n412 VGND.n361 394
R409 VGND.n408 VGND.n406 394
R410 VGND.n404 VGND.n363 394
R411 VGND.n400 VGND.n398 394
R412 VGND.n396 VGND.n365 394
R413 VGND.n392 VGND.n390 394
R414 VGND.n388 VGND.n367 394
R415 VGND.n384 VGND.n382 394
R416 VGND.n380 VGND.n369 394
R417 VGND.n376 VGND.n374 394
R418 VGND.n372 VGND.n168 394
R419 VGND.n522 VGND.n450 394
R420 VGND.n518 VGND.n516 394
R421 VGND.n516 VGND.n515 394
R422 VGND.n512 VGND.n511 394
R423 VGND.n509 VGND.n493 394
R424 VGND.n505 VGND.n503 394
R425 VGND.n501 VGND.n495 394
R426 VGND.n497 VGND.n8 394
R427 VGND.n524 VGND.n7 394
R428 VGND.n460 VGND.n453 394
R429 VGND.n464 VGND.n463 394
R430 VGND.n468 VGND.n467 394
R431 VGND.n472 VGND.n471 394
R432 VGND.n476 VGND.n475 394
R433 VGND.n478 VGND.n459 394
R434 VGND.n485 VGND.n484 267.714
R435 VGND.n523 VGND.n449 267.714
R436 VGND.n428 VGND.n354 218.815
R437 VGND.n357 VGND.n354 218.815
R438 VGND.n421 VGND.n354 218.815
R439 VGND.n415 VGND.n354 218.815
R440 VGND.n413 VGND.n354 218.815
R441 VGND.n407 VGND.n354 218.815
R442 VGND.n405 VGND.n354 218.815
R443 VGND.n399 VGND.n354 218.815
R444 VGND.n397 VGND.n354 218.815
R445 VGND.n391 VGND.n354 218.815
R446 VGND.n389 VGND.n354 218.815
R447 VGND.n383 VGND.n354 218.815
R448 VGND.n381 VGND.n354 218.815
R449 VGND.n375 VGND.n354 218.815
R450 VGND.n373 VGND.n354 218.815
R451 VGND.n445 VGND.n26 218.815
R452 VGND.n445 VGND.n25 218.815
R453 VGND.n445 VGND.n24 218.815
R454 VGND.n445 VGND.n23 218.815
R455 VGND.n445 VGND.n22 218.815
R456 VGND.n445 VGND.n21 218.815
R457 VGND.n445 VGND.n20 218.815
R458 VGND.n445 VGND.n19 218.815
R459 VGND.n445 VGND.n18 218.815
R460 VGND.n445 VGND.n17 218.815
R461 VGND.n445 VGND.n16 218.815
R462 VGND.n445 VGND.n15 218.815
R463 VGND.n445 VGND.n14 218.815
R464 VGND.n445 VGND.n13 218.815
R465 VGND.n445 VGND.n12 218.815
R466 VGND.n445 VGND.n11 218.815
R467 VGND.n335 VGND.n261 218.815
R468 VGND.n264 VGND.n261 218.815
R469 VGND.n328 VGND.n261 218.815
R470 VGND.n322 VGND.n261 218.815
R471 VGND.n320 VGND.n261 218.815
R472 VGND.n314 VGND.n261 218.815
R473 VGND.n312 VGND.n261 218.815
R474 VGND.n306 VGND.n261 218.815
R475 VGND.n304 VGND.n261 218.815
R476 VGND.n298 VGND.n261 218.815
R477 VGND.n296 VGND.n261 218.815
R478 VGND.n290 VGND.n261 218.815
R479 VGND.n288 VGND.n261 218.815
R480 VGND.n282 VGND.n261 218.815
R481 VGND.n280 VGND.n261 218.815
R482 VGND.n353 VGND.n184 218.815
R483 VGND.n353 VGND.n183 218.815
R484 VGND.n353 VGND.n182 218.815
R485 VGND.n353 VGND.n181 218.815
R486 VGND.n353 VGND.n180 218.815
R487 VGND.n353 VGND.n179 218.815
R488 VGND.n353 VGND.n178 218.815
R489 VGND.n353 VGND.n177 218.815
R490 VGND.n353 VGND.n176 218.815
R491 VGND.n353 VGND.n175 218.815
R492 VGND.n353 VGND.n174 218.815
R493 VGND.n353 VGND.n173 218.815
R494 VGND.n353 VGND.n172 218.815
R495 VGND.n353 VGND.n171 218.815
R496 VGND.n353 VGND.n170 218.815
R497 VGND.n353 VGND.n169 218.815
R498 VGND.n162 VGND.n10 218.815
R499 VGND.n108 VGND.n10 218.815
R500 VGND.n132 VGND.n131 218.815
R501 VGND.n133 VGND.n132 218.815
R502 VGND.n485 VGND.n483 218.815
R503 VGND.n485 VGND.n458 218.815
R504 VGND.n485 VGND.n457 218.815
R505 VGND.n485 VGND.n456 218.815
R506 VGND.n485 VGND.n455 218.815
R507 VGND.n485 VGND.n454 218.815
R508 VGND.n486 VGND.n485 218.815
R509 VGND.n517 VGND.n449 218.815
R510 VGND.n491 VGND.n449 218.815
R511 VGND.n510 VGND.n449 218.815
R512 VGND.n504 VGND.n449 218.815
R513 VGND.n502 VGND.n449 218.815
R514 VGND.n496 VGND.n449 218.815
R515 VGND.n132 VGND.n121 203.736
R516 VGND.n159 VGND.n10 203.736
R517 VGND.t5 VGND.n1 181.41
R518 VGND.n2 VGND.t5 174.912
R519 VGND.n131 VGND.n130 147.374
R520 VGND.n133 VGND.n124 147.374
R521 VGND.n108 VGND.n102 147.374
R522 VGND.n162 VGND.n161 147.374
R523 VGND.n196 VGND.n169 147.374
R524 VGND.n200 VGND.n170 147.374
R525 VGND.n204 VGND.n171 147.374
R526 VGND.n208 VGND.n172 147.374
R527 VGND.n212 VGND.n173 147.374
R528 VGND.n216 VGND.n174 147.374
R529 VGND.n220 VGND.n175 147.374
R530 VGND.n224 VGND.n176 147.374
R531 VGND.n228 VGND.n177 147.374
R532 VGND.n232 VGND.n178 147.374
R533 VGND.n236 VGND.n179 147.374
R534 VGND.n240 VGND.n180 147.374
R535 VGND.n244 VGND.n181 147.374
R536 VGND.n248 VGND.n182 147.374
R537 VGND.n252 VGND.n183 147.374
R538 VGND.n255 VGND.n184 147.374
R539 VGND.n335 VGND.n262 147.374
R540 VGND.n333 VGND.n264 147.374
R541 VGND.n329 VGND.n328 147.374
R542 VGND.n322 VGND.n266 147.374
R543 VGND.n321 VGND.n320 147.374
R544 VGND.n314 VGND.n268 147.374
R545 VGND.n313 VGND.n312 147.374
R546 VGND.n306 VGND.n270 147.374
R547 VGND.n305 VGND.n304 147.374
R548 VGND.n298 VGND.n272 147.374
R549 VGND.n297 VGND.n296 147.374
R550 VGND.n290 VGND.n274 147.374
R551 VGND.n289 VGND.n288 147.374
R552 VGND.n282 VGND.n276 147.374
R553 VGND.n281 VGND.n280 147.374
R554 VGND.n38 VGND.n11 147.374
R555 VGND.n42 VGND.n12 147.374
R556 VGND.n46 VGND.n13 147.374
R557 VGND.n50 VGND.n14 147.374
R558 VGND.n54 VGND.n15 147.374
R559 VGND.n58 VGND.n16 147.374
R560 VGND.n62 VGND.n17 147.374
R561 VGND.n66 VGND.n18 147.374
R562 VGND.n70 VGND.n19 147.374
R563 VGND.n74 VGND.n20 147.374
R564 VGND.n78 VGND.n21 147.374
R565 VGND.n82 VGND.n22 147.374
R566 VGND.n86 VGND.n23 147.374
R567 VGND.n90 VGND.n24 147.374
R568 VGND.n94 VGND.n25 147.374
R569 VGND.n97 VGND.n26 147.374
R570 VGND.n428 VGND.n355 147.374
R571 VGND.n426 VGND.n357 147.374
R572 VGND.n422 VGND.n421 147.374
R573 VGND.n415 VGND.n359 147.374
R574 VGND.n414 VGND.n413 147.374
R575 VGND.n407 VGND.n361 147.374
R576 VGND.n406 VGND.n405 147.374
R577 VGND.n399 VGND.n363 147.374
R578 VGND.n398 VGND.n397 147.374
R579 VGND.n391 VGND.n365 147.374
R580 VGND.n390 VGND.n389 147.374
R581 VGND.n383 VGND.n367 147.374
R582 VGND.n382 VGND.n381 147.374
R583 VGND.n375 VGND.n369 147.374
R584 VGND.n374 VGND.n373 147.374
R585 VGND.n429 VGND.n428 147.374
R586 VGND.n423 VGND.n357 147.374
R587 VGND.n421 VGND.n420 147.374
R588 VGND.n416 VGND.n415 147.374
R589 VGND.n413 VGND.n412 147.374
R590 VGND.n408 VGND.n407 147.374
R591 VGND.n405 VGND.n404 147.374
R592 VGND.n400 VGND.n399 147.374
R593 VGND.n397 VGND.n396 147.374
R594 VGND.n392 VGND.n391 147.374
R595 VGND.n389 VGND.n388 147.374
R596 VGND.n384 VGND.n383 147.374
R597 VGND.n381 VGND.n380 147.374
R598 VGND.n376 VGND.n375 147.374
R599 VGND.n373 VGND.n372 147.374
R600 VGND.n95 VGND.n26 147.374
R601 VGND.n91 VGND.n25 147.374
R602 VGND.n87 VGND.n24 147.374
R603 VGND.n83 VGND.n23 147.374
R604 VGND.n79 VGND.n22 147.374
R605 VGND.n75 VGND.n21 147.374
R606 VGND.n71 VGND.n20 147.374
R607 VGND.n67 VGND.n19 147.374
R608 VGND.n63 VGND.n18 147.374
R609 VGND.n59 VGND.n17 147.374
R610 VGND.n55 VGND.n16 147.374
R611 VGND.n51 VGND.n15 147.374
R612 VGND.n47 VGND.n14 147.374
R613 VGND.n43 VGND.n13 147.374
R614 VGND.n39 VGND.n12 147.374
R615 VGND.n29 VGND.n11 147.374
R616 VGND.n336 VGND.n335 147.374
R617 VGND.n330 VGND.n264 147.374
R618 VGND.n328 VGND.n327 147.374
R619 VGND.n323 VGND.n322 147.374
R620 VGND.n320 VGND.n319 147.374
R621 VGND.n315 VGND.n314 147.374
R622 VGND.n312 VGND.n311 147.374
R623 VGND.n307 VGND.n306 147.374
R624 VGND.n304 VGND.n303 147.374
R625 VGND.n299 VGND.n298 147.374
R626 VGND.n296 VGND.n295 147.374
R627 VGND.n291 VGND.n290 147.374
R628 VGND.n288 VGND.n287 147.374
R629 VGND.n283 VGND.n282 147.374
R630 VGND.n280 VGND.n279 147.374
R631 VGND.n253 VGND.n184 147.374
R632 VGND.n249 VGND.n183 147.374
R633 VGND.n245 VGND.n182 147.374
R634 VGND.n241 VGND.n181 147.374
R635 VGND.n237 VGND.n180 147.374
R636 VGND.n233 VGND.n179 147.374
R637 VGND.n229 VGND.n178 147.374
R638 VGND.n225 VGND.n177 147.374
R639 VGND.n221 VGND.n176 147.374
R640 VGND.n217 VGND.n175 147.374
R641 VGND.n213 VGND.n174 147.374
R642 VGND.n209 VGND.n173 147.374
R643 VGND.n205 VGND.n172 147.374
R644 VGND.n201 VGND.n171 147.374
R645 VGND.n197 VGND.n170 147.374
R646 VGND.n187 VGND.n169 147.374
R647 VGND.n163 VGND.n162 147.374
R648 VGND.n109 VGND.n108 147.374
R649 VGND.n131 VGND.n126 147.374
R650 VGND.n134 VGND.n133 147.374
R651 VGND.n517 VGND.n451 147.374
R652 VGND.n515 VGND.n491 147.374
R653 VGND.n511 VGND.n510 147.374
R654 VGND.n504 VGND.n493 147.374
R655 VGND.n503 VGND.n502 147.374
R656 VGND.n496 VGND.n495 147.374
R657 VGND.n487 VGND.n486 147.374
R658 VGND.n460 VGND.n454 147.374
R659 VGND.n464 VGND.n455 147.374
R660 VGND.n468 VGND.n456 147.374
R661 VGND.n472 VGND.n457 147.374
R662 VGND.n476 VGND.n458 147.374
R663 VGND.n483 VGND.n459 147.374
R664 VGND.n483 VGND.n482 147.374
R665 VGND.n478 VGND.n458 147.374
R666 VGND.n475 VGND.n457 147.374
R667 VGND.n471 VGND.n456 147.374
R668 VGND.n467 VGND.n455 147.374
R669 VGND.n463 VGND.n454 147.374
R670 VGND.n486 VGND.n453 147.374
R671 VGND.n518 VGND.n517 147.374
R672 VGND.n512 VGND.n491 147.374
R673 VGND.n510 VGND.n509 147.374
R674 VGND.n505 VGND.n504 147.374
R675 VGND.n502 VGND.n501 147.374
R676 VGND.n497 VGND.n496 147.374
R677 VGND.n139 VGND.n121 116.421
R678 VGND.n139 VGND.n117 116.421
R679 VGND.n145 VGND.n117 116.421
R680 VGND.n152 VGND.n113 116.421
R681 VGND.n152 VGND.n106 116.421
R682 VGND.n159 VGND.n106 116.421
R683 VGND.n489 VGND.n488 83.577
R684 VGND.n481 VGND.n5 83.577
R685 VGND.n521 VGND.n520 83.577
R686 VGND.n525 VGND.n6 83.577
R687 VGND.n129 VGND.n119 78.6829
R688 VGND.n157 VGND.n156 78.6829
R689 VGND.n136 VGND.n135 78.6829
R690 VGND.n105 VGND.n103 78.6829
R691 VGND.n484 VGND.t2 73.4058
R692 VGND.n523 VGND.t2 73.4058
R693 VGND.n350 VGND.n189 72.6593
R694 VGND.n257 VGND.n256 72.6593
R695 VGND.n339 VGND.n338 72.6593
R696 VGND.n343 VGND.n259 72.6593
R697 VGND.n442 VGND.n31 72.6593
R698 VGND.n432 VGND.n431 72.6593
R699 VGND.n99 VGND.n98 72.6593
R700 VGND.n436 VGND.n167 72.6593
R701 VGND.n445 VGND.n444 65.0461
R702 VGND.n434 VGND.n354 65.0461
R703 VGND.n353 VGND.n352 65.0461
R704 VGND.n341 VGND.n261 65.0461
R705 VGND.n145 VGND.t4 58.2106
R706 VGND.t4 VGND.n113 58.2106
R707 VGND.n444 VGND.n28 41.3379
R708 VGND.t0 VGND.n28 41.3379
R709 VGND.t0 VGND.n34 41.3379
R710 VGND.n434 VGND.n34 41.3379
R711 VGND.n352 VGND.n186 41.3379
R712 VGND.t1 VGND.n186 41.3379
R713 VGND.t1 VGND.n192 41.3379
R714 VGND.n341 VGND.n192 41.3379
R715 VGND.n528 VGND.n0 37.4189
R716 VGND VGND.n0 31.7518
R717 VGND.n529 VGND.n528 31.4732
R718 VGND.n195 VGND.n189 25.6005
R719 VGND.n198 VGND.n195 25.6005
R720 VGND.n199 VGND.n198 25.6005
R721 VGND.n202 VGND.n199 25.6005
R722 VGND.n203 VGND.n202 25.6005
R723 VGND.n206 VGND.n203 25.6005
R724 VGND.n207 VGND.n206 25.6005
R725 VGND.n210 VGND.n207 25.6005
R726 VGND.n211 VGND.n210 25.6005
R727 VGND.n214 VGND.n211 25.6005
R728 VGND.n215 VGND.n214 25.6005
R729 VGND.n218 VGND.n215 25.6005
R730 VGND.n219 VGND.n218 25.6005
R731 VGND.n222 VGND.n219 25.6005
R732 VGND.n223 VGND.n222 25.6005
R733 VGND.n226 VGND.n223 25.6005
R734 VGND.n227 VGND.n226 25.6005
R735 VGND.n230 VGND.n227 25.6005
R736 VGND.n231 VGND.n230 25.6005
R737 VGND.n234 VGND.n231 25.6005
R738 VGND.n235 VGND.n234 25.6005
R739 VGND.n238 VGND.n235 25.6005
R740 VGND.n239 VGND.n238 25.6005
R741 VGND.n242 VGND.n239 25.6005
R742 VGND.n243 VGND.n242 25.6005
R743 VGND.n246 VGND.n243 25.6005
R744 VGND.n247 VGND.n246 25.6005
R745 VGND.n250 VGND.n247 25.6005
R746 VGND.n251 VGND.n250 25.6005
R747 VGND.n254 VGND.n251 25.6005
R748 VGND.n256 VGND.n254 25.6005
R749 VGND.n350 VGND.n349 25.6005
R750 VGND.n349 VGND.n348 25.6005
R751 VGND.n348 VGND.n190 25.6005
R752 VGND.n339 VGND.n190 25.6005
R753 VGND.n338 VGND.n337 25.6005
R754 VGND.n337 VGND.n263 25.6005
R755 VGND.n332 VGND.n263 25.6005
R756 VGND.n332 VGND.n331 25.6005
R757 VGND.n331 VGND.n265 25.6005
R758 VGND.n326 VGND.n265 25.6005
R759 VGND.n326 VGND.n325 25.6005
R760 VGND.n325 VGND.n324 25.6005
R761 VGND.n324 VGND.n267 25.6005
R762 VGND.n318 VGND.n267 25.6005
R763 VGND.n318 VGND.n317 25.6005
R764 VGND.n317 VGND.n316 25.6005
R765 VGND.n316 VGND.n269 25.6005
R766 VGND.n310 VGND.n269 25.6005
R767 VGND.n310 VGND.n309 25.6005
R768 VGND.n309 VGND.n308 25.6005
R769 VGND.n308 VGND.n271 25.6005
R770 VGND.n302 VGND.n271 25.6005
R771 VGND.n302 VGND.n301 25.6005
R772 VGND.n301 VGND.n300 25.6005
R773 VGND.n300 VGND.n273 25.6005
R774 VGND.n294 VGND.n273 25.6005
R775 VGND.n294 VGND.n293 25.6005
R776 VGND.n293 VGND.n292 25.6005
R777 VGND.n292 VGND.n275 25.6005
R778 VGND.n286 VGND.n275 25.6005
R779 VGND.n286 VGND.n285 25.6005
R780 VGND.n285 VGND.n284 25.6005
R781 VGND.n284 VGND.n277 25.6005
R782 VGND.n278 VGND.n277 25.6005
R783 VGND.n278 VGND.n259 25.6005
R784 VGND.n258 VGND.n257 25.6005
R785 VGND VGND.n258 25.6005
R786 VGND VGND.n344 25.6005
R787 VGND.n344 VGND.n343 25.6005
R788 VGND.n141 VGND.n119 25.6005
R789 VGND.n142 VGND.n141 25.6005
R790 VGND.n143 VGND.n142 25.6005
R791 VGND.n143 VGND.n111 25.6005
R792 VGND.n154 VGND.n111 25.6005
R793 VGND.n155 VGND.n154 25.6005
R794 VGND.n157 VGND.n155 25.6005
R795 VGND.n129 VGND.n128 25.6005
R796 VGND.n128 VGND.n127 25.6005
R797 VGND.n127 VGND.n123 25.6005
R798 VGND.n135 VGND.n123 25.6005
R799 VGND.n137 VGND.n136 25.6005
R800 VGND.n137 VGND.n115 25.6005
R801 VGND.n147 VGND.n115 25.6005
R802 VGND.n148 VGND.n147 25.6005
R803 VGND.n150 VGND.n148 25.6005
R804 VGND.n150 VGND.n149 25.6005
R805 VGND.n149 VGND.n105 25.6005
R806 VGND.n156 VGND.n101 25.6005
R807 VGND VGND.n101 25.6005
R808 VGND VGND.n164 25.6005
R809 VGND.n164 VGND.n103 25.6005
R810 VGND.n442 VGND.n441 25.6005
R811 VGND.n441 VGND.n440 25.6005
R812 VGND.n440 VGND.n32 25.6005
R813 VGND.n432 VGND.n32 25.6005
R814 VGND.n37 VGND.n31 25.6005
R815 VGND.n40 VGND.n37 25.6005
R816 VGND.n41 VGND.n40 25.6005
R817 VGND.n44 VGND.n41 25.6005
R818 VGND.n45 VGND.n44 25.6005
R819 VGND.n48 VGND.n45 25.6005
R820 VGND.n49 VGND.n48 25.6005
R821 VGND.n52 VGND.n49 25.6005
R822 VGND.n53 VGND.n52 25.6005
R823 VGND.n56 VGND.n53 25.6005
R824 VGND.n57 VGND.n56 25.6005
R825 VGND.n60 VGND.n57 25.6005
R826 VGND.n61 VGND.n60 25.6005
R827 VGND.n64 VGND.n61 25.6005
R828 VGND.n65 VGND.n64 25.6005
R829 VGND.n68 VGND.n65 25.6005
R830 VGND.n69 VGND.n68 25.6005
R831 VGND.n72 VGND.n69 25.6005
R832 VGND.n73 VGND.n72 25.6005
R833 VGND.n76 VGND.n73 25.6005
R834 VGND.n77 VGND.n76 25.6005
R835 VGND.n80 VGND.n77 25.6005
R836 VGND.n81 VGND.n80 25.6005
R837 VGND.n84 VGND.n81 25.6005
R838 VGND.n85 VGND.n84 25.6005
R839 VGND.n88 VGND.n85 25.6005
R840 VGND.n89 VGND.n88 25.6005
R841 VGND.n92 VGND.n89 25.6005
R842 VGND.n93 VGND.n92 25.6005
R843 VGND.n96 VGND.n93 25.6005
R844 VGND.n98 VGND.n96 25.6005
R845 VGND.n100 VGND.n99 25.6005
R846 VGND VGND.n100 25.6005
R847 VGND VGND.n437 25.6005
R848 VGND.n437 VGND.n436 25.6005
R849 VGND.n431 VGND.n430 25.6005
R850 VGND.n430 VGND.n356 25.6005
R851 VGND.n425 VGND.n356 25.6005
R852 VGND.n425 VGND.n424 25.6005
R853 VGND.n424 VGND.n358 25.6005
R854 VGND.n419 VGND.n358 25.6005
R855 VGND.n419 VGND.n418 25.6005
R856 VGND.n418 VGND.n417 25.6005
R857 VGND.n417 VGND.n360 25.6005
R858 VGND.n411 VGND.n360 25.6005
R859 VGND.n411 VGND.n410 25.6005
R860 VGND.n410 VGND.n409 25.6005
R861 VGND.n409 VGND.n362 25.6005
R862 VGND.n403 VGND.n362 25.6005
R863 VGND.n403 VGND.n402 25.6005
R864 VGND.n402 VGND.n401 25.6005
R865 VGND.n401 VGND.n364 25.6005
R866 VGND.n395 VGND.n364 25.6005
R867 VGND.n395 VGND.n394 25.6005
R868 VGND.n394 VGND.n393 25.6005
R869 VGND.n393 VGND.n366 25.6005
R870 VGND.n387 VGND.n366 25.6005
R871 VGND.n387 VGND.n386 25.6005
R872 VGND.n386 VGND.n385 25.6005
R873 VGND.n385 VGND.n368 25.6005
R874 VGND.n379 VGND.n368 25.6005
R875 VGND.n379 VGND.n378 25.6005
R876 VGND.n378 VGND.n377 25.6005
R877 VGND.n377 VGND.n370 25.6005
R878 VGND.n371 VGND.n370 25.6005
R879 VGND.n371 VGND.n167 25.6005
R880 VGND.n488 VGND.n452 25.6005
R881 VGND.n461 VGND.n452 25.6005
R882 VGND.n462 VGND.n461 25.6005
R883 VGND.n465 VGND.n462 25.6005
R884 VGND.n466 VGND.n465 25.6005
R885 VGND.n469 VGND.n466 25.6005
R886 VGND.n470 VGND.n469 25.6005
R887 VGND.n473 VGND.n470 25.6005
R888 VGND.n474 VGND.n473 25.6005
R889 VGND.n477 VGND.n474 25.6005
R890 VGND.n479 VGND.n477 25.6005
R891 VGND.n480 VGND.n479 25.6005
R892 VGND.n481 VGND.n480 25.6005
R893 VGND.n521 VGND.n489 25.6005
R894 VGND.n520 VGND.n519 25.6005
R895 VGND.n519 VGND.n490 25.6005
R896 VGND.n514 VGND.n490 25.6005
R897 VGND.n514 VGND.n513 25.6005
R898 VGND.n513 VGND.n492 25.6005
R899 VGND.n508 VGND.n492 25.6005
R900 VGND.n508 VGND.n507 25.6005
R901 VGND.n507 VGND.n506 25.6005
R902 VGND.n506 VGND.n494 25.6005
R903 VGND.n500 VGND.n494 25.6005
R904 VGND.n500 VGND.n499 25.6005
R905 VGND.n499 VGND.n498 25.6005
R906 VGND.n498 VGND.n6 25.6005
R907 VGND.n165 VGND 21.4848
R908 VGND.n526 VGND 21.1376
R909 VGND VGND.n166 20.0959
R910 VGND VGND.n345 20.0959
R911 VGND.n2 VGND 19.837
R912 VGND.n3 VGND.n2 14.1895
R913 VGND.n527 VGND.n526 13.5241
R914 VGND.n4 VGND.n3 13.0823
R915 VGND VGND.n5 12.8005
R916 VGND VGND.n525 12.8005
R917 VGND VGND.n529 5.41685
R918 VGND.n528 VGND.t3 4.3505
R919 VGND VGND.n1 4.259
R920 VGND.n3 VGND.n1 3.04672
R921 VGND.n166 VGND.n165 2.78173
R922 VGND.n527 VGND.n0 2.60127
R923 VGND.n529 VGND.n527 1.70582
R924 VGND.n526 VGND.n4 1.55561
R925 VGND.n345 VGND.n166 0.911125
R926 VGND.n345 VGND 0.397062
R927 VGND.n165 VGND.n4 0.12975
R928 BIAS BIAS.t0 139.911
R929 INP INP.t0 332.712
R930 PRE PRE.t3 1511.24
R931 PRE PRE.t2 854.114
R932 PRE.t1 PRE.n2 387.11
R933 PRE.n3 PRE.t1 381.113
R934 PRE.n1 PRE 34.6443
R935 PRE PRE.n8 33.1304
R936 PRE.n1 PRE 33.1171
R937 PRE.n3 PRE 22.8553
R938 PRE.n6 PRE.n5 17.5237
R939 PRE.n5 PRE.n4 14.749
R940 PRE.n8 PRE.n7 14.1214
R941 PRE.n7 PRE.n0 13.3893
R942 PRE.n4 PRE.n3 11.4361
R943 PRE PRE.n0 6.32004
R944 PRE PRE.n2 4.87707
R945 PRE.n4 PRE.n2 2.44078
R946 PRE.n5 PRE.n1 2.15134
R947 PRE.n7 PRE.t0 1.7405
R948 PRE.n8 PRE.n6 1.13588
R949 PRE.n6 PRE.n0 0.755154
R950 OUT.n2 OUT.n1 54.4415
R951 OUT.n3 OUT.n2 48.279
R952 OUT.n7 OUT.n0 37.4189
R953 OUT OUT.n0 31.7518
R954 OUT.n8 OUT.n7 31.4732
R955 OUT OUT.n1 20.2395
R956 OUT.n3 OUT 17.9488
R957 OUT.n6 OUT.n5 15.462
R958 OUT.n5 OUT.n4 14.6448
R959 OUT OUT.n8 5.41685
R960 OUT.n5 OUT 4.85031
R961 OUT.n7 OUT.t0 4.3505
R962 OUT.n2 OUT.t1 3.57113
R963 OUT.n6 OUT.n0 2.60127
R964 OUT.n4 OUT.n3 2.38164
R965 OUT.n8 OUT.n6 1.70582
R966 OUT.n4 OUT.n1 0.71089
R967 VPWR.n741 VPWR.n674 787.059
R968 VPWR.n806 VPWR.n675 787.059
R969 VPWR.n808 VPWR.n672 787.059
R970 VPWR.n736 VPWR.n671 787.059
R971 VPWR.n377 VPWR.n343 762.354
R972 VPWR.n656 VPWR.n341 762.354
R973 VPWR.n537 VPWR.n338 762.354
R974 VPWR.n499 VPWR.n345 762.354
R975 VPWR.n43 VPWR.n9 762.354
R976 VPWR.n322 VPWR.n7 762.354
R977 VPWR.n203 VPWR.n4 762.354
R978 VPWR.n165 VPWR.n11 762.354
R979 VPWR.t5 VPWR.n331 387.11
R980 VPWR.t3 VPWR.n665 387.11
R981 VPWR.n332 VPWR.t5 381.113
R982 VPWR.n666 VPWR.t3 381.113
R983 VPWR.n502 VPWR.n343 240
R984 VPWR.n502 VPWR.n340 240
R985 VPWR.n660 VPWR.n340 240
R986 VPWR.n660 VPWR.n341 240
R987 VPWR.n653 VPWR.n506 240
R988 VPWR.n653 VPWR.n536 240
R989 VPWR.n649 VPWR.n648 240
R990 VPWR.n645 VPWR.n644 240
R991 VPWR.n641 VPWR.n640 240
R992 VPWR.n637 VPWR.n636 240
R993 VPWR.n633 VPWR.n632 240
R994 VPWR.n629 VPWR.n628 240
R995 VPWR.n625 VPWR.n624 240
R996 VPWR.n621 VPWR.n620 240
R997 VPWR.n617 VPWR.n616 240
R998 VPWR.n613 VPWR.n612 240
R999 VPWR.n609 VPWR.n608 240
R1000 VPWR.n605 VPWR.n604 240
R1001 VPWR.n601 VPWR.n600 240
R1002 VPWR.n597 VPWR.n596 240
R1003 VPWR.n593 VPWR.n592 240
R1004 VPWR.n589 VPWR.n588 240
R1005 VPWR.n585 VPWR.n584 240
R1006 VPWR.n581 VPWR.n580 240
R1007 VPWR.n577 VPWR.n576 240
R1008 VPWR.n573 VPWR.n572 240
R1009 VPWR.n569 VPWR.n568 240
R1010 VPWR.n565 VPWR.n564 240
R1011 VPWR.n561 VPWR.n560 240
R1012 VPWR.n557 VPWR.n556 240
R1013 VPWR.n553 VPWR.n552 240
R1014 VPWR.n549 VPWR.n548 240
R1015 VPWR.n545 VPWR.n544 240
R1016 VPWR.n541 VPWR.n540 240
R1017 VPWR.n500 VPWR.n499 240
R1018 VPWR.n500 VPWR.n336 240
R1019 VPWR.n662 VPWR.n336 240
R1020 VPWR.n662 VPWR.n338 240
R1021 VPWR.n381 VPWR.n380 240
R1022 VPWR.n385 VPWR.n384 240
R1023 VPWR.n389 VPWR.n388 240
R1024 VPWR.n393 VPWR.n392 240
R1025 VPWR.n397 VPWR.n396 240
R1026 VPWR.n401 VPWR.n400 240
R1027 VPWR.n405 VPWR.n404 240
R1028 VPWR.n409 VPWR.n408 240
R1029 VPWR.n413 VPWR.n412 240
R1030 VPWR.n417 VPWR.n416 240
R1031 VPWR.n421 VPWR.n420 240
R1032 VPWR.n425 VPWR.n424 240
R1033 VPWR.n429 VPWR.n428 240
R1034 VPWR.n433 VPWR.n432 240
R1035 VPWR.n437 VPWR.n436 240
R1036 VPWR.n441 VPWR.n440 240
R1037 VPWR.n445 VPWR.n444 240
R1038 VPWR.n449 VPWR.n448 240
R1039 VPWR.n453 VPWR.n452 240
R1040 VPWR.n457 VPWR.n456 240
R1041 VPWR.n461 VPWR.n460 240
R1042 VPWR.n465 VPWR.n464 240
R1043 VPWR.n469 VPWR.n468 240
R1044 VPWR.n473 VPWR.n472 240
R1045 VPWR.n477 VPWR.n476 240
R1046 VPWR.n481 VPWR.n480 240
R1047 VPWR.n485 VPWR.n484 240
R1048 VPWR.n487 VPWR.n376 240
R1049 VPWR.n491 VPWR.n347 240
R1050 VPWR.n495 VPWR.n345 240
R1051 VPWR.n806 VPWR.n674 240
R1052 VPWR.n802 VPWR.n800 240
R1053 VPWR.n800 VPWR.n799 240
R1054 VPWR.n796 VPWR.n795 240
R1055 VPWR.n793 VPWR.n747 240
R1056 VPWR.n789 VPWR.n787 240
R1057 VPWR.n785 VPWR.n749 240
R1058 VPWR.n781 VPWR.n779 240
R1059 VPWR.n777 VPWR.n751 240
R1060 VPWR.n773 VPWR.n771 240
R1061 VPWR.n769 VPWR.n753 240
R1062 VPWR.n765 VPWR.n763 240
R1063 VPWR.n761 VPWR.n755 240
R1064 VPWR.n757 VPWR.n672 240
R1065 VPWR.n808 VPWR.n671 240
R1066 VPWR.n690 VPWR.n677 240
R1067 VPWR.n694 VPWR.n693 240
R1068 VPWR.n698 VPWR.n697 240
R1069 VPWR.n702 VPWR.n701 240
R1070 VPWR.n706 VPWR.n705 240
R1071 VPWR.n710 VPWR.n709 240
R1072 VPWR.n714 VPWR.n713 240
R1073 VPWR.n718 VPWR.n717 240
R1074 VPWR.n722 VPWR.n721 240
R1075 VPWR.n726 VPWR.n725 240
R1076 VPWR.n730 VPWR.n729 240
R1077 VPWR.n732 VPWR.n689 240
R1078 VPWR.n168 VPWR.n9 240
R1079 VPWR.n168 VPWR.n6 240
R1080 VPWR.n326 VPWR.n6 240
R1081 VPWR.n326 VPWR.n7 240
R1082 VPWR.n319 VPWR.n172 240
R1083 VPWR.n319 VPWR.n202 240
R1084 VPWR.n315 VPWR.n314 240
R1085 VPWR.n311 VPWR.n310 240
R1086 VPWR.n307 VPWR.n306 240
R1087 VPWR.n303 VPWR.n302 240
R1088 VPWR.n299 VPWR.n298 240
R1089 VPWR.n295 VPWR.n294 240
R1090 VPWR.n291 VPWR.n290 240
R1091 VPWR.n287 VPWR.n286 240
R1092 VPWR.n283 VPWR.n282 240
R1093 VPWR.n279 VPWR.n278 240
R1094 VPWR.n275 VPWR.n274 240
R1095 VPWR.n271 VPWR.n270 240
R1096 VPWR.n267 VPWR.n266 240
R1097 VPWR.n263 VPWR.n262 240
R1098 VPWR.n259 VPWR.n258 240
R1099 VPWR.n255 VPWR.n254 240
R1100 VPWR.n251 VPWR.n250 240
R1101 VPWR.n247 VPWR.n246 240
R1102 VPWR.n243 VPWR.n242 240
R1103 VPWR.n239 VPWR.n238 240
R1104 VPWR.n235 VPWR.n234 240
R1105 VPWR.n231 VPWR.n230 240
R1106 VPWR.n227 VPWR.n226 240
R1107 VPWR.n223 VPWR.n222 240
R1108 VPWR.n219 VPWR.n218 240
R1109 VPWR.n215 VPWR.n214 240
R1110 VPWR.n211 VPWR.n210 240
R1111 VPWR.n207 VPWR.n206 240
R1112 VPWR.n166 VPWR.n165 240
R1113 VPWR.n166 VPWR.n2 240
R1114 VPWR.n328 VPWR.n2 240
R1115 VPWR.n328 VPWR.n4 240
R1116 VPWR.n47 VPWR.n46 240
R1117 VPWR.n51 VPWR.n50 240
R1118 VPWR.n55 VPWR.n54 240
R1119 VPWR.n59 VPWR.n58 240
R1120 VPWR.n63 VPWR.n62 240
R1121 VPWR.n67 VPWR.n66 240
R1122 VPWR.n71 VPWR.n70 240
R1123 VPWR.n75 VPWR.n74 240
R1124 VPWR.n79 VPWR.n78 240
R1125 VPWR.n83 VPWR.n82 240
R1126 VPWR.n87 VPWR.n86 240
R1127 VPWR.n91 VPWR.n90 240
R1128 VPWR.n95 VPWR.n94 240
R1129 VPWR.n99 VPWR.n98 240
R1130 VPWR.n103 VPWR.n102 240
R1131 VPWR.n107 VPWR.n106 240
R1132 VPWR.n111 VPWR.n110 240
R1133 VPWR.n115 VPWR.n114 240
R1134 VPWR.n119 VPWR.n118 240
R1135 VPWR.n123 VPWR.n122 240
R1136 VPWR.n127 VPWR.n126 240
R1137 VPWR.n131 VPWR.n130 240
R1138 VPWR.n135 VPWR.n134 240
R1139 VPWR.n139 VPWR.n138 240
R1140 VPWR.n143 VPWR.n142 240
R1141 VPWR.n147 VPWR.n146 240
R1142 VPWR.n151 VPWR.n150 240
R1143 VPWR.n153 VPWR.n42 240
R1144 VPWR.n157 VPWR.n13 240
R1145 VPWR.n161 VPWR.n11 240
R1146 VPWR.n497 VPWR.n345 185
R1147 VPWR.n493 VPWR.n345 185
R1148 VPWR.n496 VPWR.n495 185
R1149 VPWR.n347 VPWR.n346 185
R1150 VPWR.n491 VPWR.n490 185
R1151 VPWR.n489 VPWR.n376 185
R1152 VPWR.n488 VPWR.n487 185
R1153 VPWR.n486 VPWR.n485 185
R1154 VPWR.n484 VPWR.n483 185
R1155 VPWR.n482 VPWR.n481 185
R1156 VPWR.n480 VPWR.n479 185
R1157 VPWR.n478 VPWR.n477 185
R1158 VPWR.n476 VPWR.n475 185
R1159 VPWR.n474 VPWR.n473 185
R1160 VPWR.n472 VPWR.n471 185
R1161 VPWR.n470 VPWR.n469 185
R1162 VPWR.n468 VPWR.n467 185
R1163 VPWR.n466 VPWR.n465 185
R1164 VPWR.n464 VPWR.n463 185
R1165 VPWR.n462 VPWR.n461 185
R1166 VPWR.n460 VPWR.n459 185
R1167 VPWR.n458 VPWR.n457 185
R1168 VPWR.n456 VPWR.n455 185
R1169 VPWR.n454 VPWR.n453 185
R1170 VPWR.n452 VPWR.n451 185
R1171 VPWR.n450 VPWR.n449 185
R1172 VPWR.n448 VPWR.n447 185
R1173 VPWR.n446 VPWR.n445 185
R1174 VPWR.n444 VPWR.n443 185
R1175 VPWR.n442 VPWR.n441 185
R1176 VPWR.n440 VPWR.n439 185
R1177 VPWR.n438 VPWR.n437 185
R1178 VPWR.n436 VPWR.n435 185
R1179 VPWR.n434 VPWR.n433 185
R1180 VPWR.n432 VPWR.n431 185
R1181 VPWR.n430 VPWR.n429 185
R1182 VPWR.n428 VPWR.n427 185
R1183 VPWR.n426 VPWR.n425 185
R1184 VPWR.n424 VPWR.n423 185
R1185 VPWR.n422 VPWR.n421 185
R1186 VPWR.n420 VPWR.n419 185
R1187 VPWR.n418 VPWR.n417 185
R1188 VPWR.n416 VPWR.n415 185
R1189 VPWR.n414 VPWR.n413 185
R1190 VPWR.n412 VPWR.n411 185
R1191 VPWR.n410 VPWR.n409 185
R1192 VPWR.n408 VPWR.n407 185
R1193 VPWR.n406 VPWR.n405 185
R1194 VPWR.n404 VPWR.n403 185
R1195 VPWR.n402 VPWR.n401 185
R1196 VPWR.n400 VPWR.n399 185
R1197 VPWR.n398 VPWR.n397 185
R1198 VPWR.n396 VPWR.n395 185
R1199 VPWR.n394 VPWR.n393 185
R1200 VPWR.n392 VPWR.n391 185
R1201 VPWR.n390 VPWR.n389 185
R1202 VPWR.n388 VPWR.n387 185
R1203 VPWR.n386 VPWR.n385 185
R1204 VPWR.n384 VPWR.n383 185
R1205 VPWR.n382 VPWR.n381 185
R1206 VPWR.n380 VPWR.n379 185
R1207 VPWR.n378 VPWR.n377 185
R1208 VPWR.n343 VPWR.n342 185
R1209 VPWR.n344 VPWR.n343 185
R1210 VPWR.n503 VPWR.n502 185
R1211 VPWR.n502 VPWR.n501 185
R1212 VPWR.n504 VPWR.n340 185
R1213 VPWR.n340 VPWR.t2 185
R1214 VPWR.n660 VPWR.n659 185
R1215 VPWR.n661 VPWR.n660 185
R1216 VPWR.n658 VPWR.n341 185
R1217 VPWR.n341 VPWR.n339 185
R1218 VPWR.n657 VPWR.n656 185
R1219 VPWR.n506 VPWR.n505 185
R1220 VPWR.n653 VPWR.n652 185
R1221 VPWR.n654 VPWR.n653 185
R1222 VPWR.n651 VPWR.n536 185
R1223 VPWR.n650 VPWR.n649 185
R1224 VPWR.n648 VPWR.n647 185
R1225 VPWR.n646 VPWR.n645 185
R1226 VPWR.n644 VPWR.n643 185
R1227 VPWR.n642 VPWR.n641 185
R1228 VPWR.n640 VPWR.n639 185
R1229 VPWR.n638 VPWR.n637 185
R1230 VPWR.n636 VPWR.n635 185
R1231 VPWR.n634 VPWR.n633 185
R1232 VPWR.n632 VPWR.n631 185
R1233 VPWR.n630 VPWR.n629 185
R1234 VPWR.n628 VPWR.n627 185
R1235 VPWR.n626 VPWR.n625 185
R1236 VPWR.n624 VPWR.n623 185
R1237 VPWR.n622 VPWR.n621 185
R1238 VPWR.n620 VPWR.n619 185
R1239 VPWR.n618 VPWR.n617 185
R1240 VPWR.n616 VPWR.n615 185
R1241 VPWR.n614 VPWR.n613 185
R1242 VPWR.n612 VPWR.n611 185
R1243 VPWR.n610 VPWR.n609 185
R1244 VPWR.n608 VPWR.n607 185
R1245 VPWR.n606 VPWR.n605 185
R1246 VPWR.n604 VPWR.n603 185
R1247 VPWR.n602 VPWR.n601 185
R1248 VPWR.n600 VPWR.n599 185
R1249 VPWR.n598 VPWR.n597 185
R1250 VPWR.n596 VPWR.n595 185
R1251 VPWR.n594 VPWR.n593 185
R1252 VPWR.n592 VPWR.n591 185
R1253 VPWR.n590 VPWR.n589 185
R1254 VPWR.n588 VPWR.n587 185
R1255 VPWR.n586 VPWR.n585 185
R1256 VPWR.n584 VPWR.n583 185
R1257 VPWR.n582 VPWR.n581 185
R1258 VPWR.n580 VPWR.n579 185
R1259 VPWR.n578 VPWR.n577 185
R1260 VPWR.n576 VPWR.n575 185
R1261 VPWR.n574 VPWR.n573 185
R1262 VPWR.n572 VPWR.n571 185
R1263 VPWR.n570 VPWR.n569 185
R1264 VPWR.n568 VPWR.n567 185
R1265 VPWR.n566 VPWR.n565 185
R1266 VPWR.n564 VPWR.n563 185
R1267 VPWR.n562 VPWR.n561 185
R1268 VPWR.n560 VPWR.n559 185
R1269 VPWR.n558 VPWR.n557 185
R1270 VPWR.n556 VPWR.n555 185
R1271 VPWR.n554 VPWR.n553 185
R1272 VPWR.n552 VPWR.n551 185
R1273 VPWR.n550 VPWR.n549 185
R1274 VPWR.n548 VPWR.n547 185
R1275 VPWR.n546 VPWR.n545 185
R1276 VPWR.n544 VPWR.n543 185
R1277 VPWR.n542 VPWR.n541 185
R1278 VPWR.n540 VPWR.n539 185
R1279 VPWR.n538 VPWR.n537 185
R1280 VPWR.n338 VPWR.n337 185
R1281 VPWR.n339 VPWR.n338 185
R1282 VPWR.n663 VPWR.n662 185
R1283 VPWR.n662 VPWR.n661 185
R1284 VPWR VPWR.n336 185
R1285 VPWR.t2 VPWR.n336 185
R1286 VPWR.n500 VPWR.n335 185
R1287 VPWR.n501 VPWR.n500 185
R1288 VPWR.n499 VPWR.n498 185
R1289 VPWR.n499 VPWR.n344 185
R1290 VPWR.n736 VPWR.n735 185
R1291 VPWR.n734 VPWR.n689 185
R1292 VPWR.n733 VPWR.n732 185
R1293 VPWR.n731 VPWR.n730 185
R1294 VPWR.n729 VPWR.n728 185
R1295 VPWR.n727 VPWR.n726 185
R1296 VPWR.n725 VPWR.n724 185
R1297 VPWR.n723 VPWR.n722 185
R1298 VPWR.n721 VPWR.n720 185
R1299 VPWR.n719 VPWR.n718 185
R1300 VPWR.n717 VPWR.n716 185
R1301 VPWR.n715 VPWR.n714 185
R1302 VPWR.n713 VPWR.n712 185
R1303 VPWR.n711 VPWR.n710 185
R1304 VPWR.n709 VPWR.n708 185
R1305 VPWR.n707 VPWR.n706 185
R1306 VPWR.n705 VPWR.n704 185
R1307 VPWR.n703 VPWR.n702 185
R1308 VPWR.n701 VPWR.n700 185
R1309 VPWR.n699 VPWR.n698 185
R1310 VPWR.n697 VPWR.n696 185
R1311 VPWR.n695 VPWR.n694 185
R1312 VPWR.n693 VPWR.n692 185
R1313 VPWR.n691 VPWR.n690 185
R1314 VPWR.n677 VPWR.n676 185
R1315 VPWR.n742 VPWR.n741 185
R1316 VPWR.n743 VPWR.n674 185
R1317 VPWR.n738 VPWR.n674 185
R1318 VPWR.n806 VPWR.n805 185
R1319 VPWR.n807 VPWR.n806 185
R1320 VPWR.n804 VPWR.n675 185
R1321 VPWR.n803 VPWR.n802 185
R1322 VPWR.n800 VPWR.n744 185
R1323 VPWR.n800 VPWR.n673 185
R1324 VPWR.n799 VPWR.n798 185
R1325 VPWR.n797 VPWR.n796 185
R1326 VPWR.n795 VPWR.n746 185
R1327 VPWR.n793 VPWR.n792 185
R1328 VPWR.n791 VPWR.n747 185
R1329 VPWR.n790 VPWR.n789 185
R1330 VPWR.n787 VPWR.n748 185
R1331 VPWR.n785 VPWR.n784 185
R1332 VPWR.n783 VPWR.n749 185
R1333 VPWR.n782 VPWR.n781 185
R1334 VPWR.n779 VPWR.n750 185
R1335 VPWR.n777 VPWR.n776 185
R1336 VPWR.n775 VPWR.n751 185
R1337 VPWR.n774 VPWR.n773 185
R1338 VPWR.n771 VPWR.n752 185
R1339 VPWR.n769 VPWR.n768 185
R1340 VPWR.n767 VPWR.n753 185
R1341 VPWR.n766 VPWR.n765 185
R1342 VPWR.n763 VPWR.n754 185
R1343 VPWR.n761 VPWR.n760 185
R1344 VPWR.n759 VPWR.n755 185
R1345 VPWR.n758 VPWR.n757 185
R1346 VPWR.n672 VPWR.n670 185
R1347 VPWR.n673 VPWR.n672 185
R1348 VPWR.n809 VPWR.n808 185
R1349 VPWR.n808 VPWR.n807 185
R1350 VPWR.n671 VPWR.n669 185
R1351 VPWR.n738 VPWR.n671 185
R1352 VPWR.n163 VPWR.n11 185
R1353 VPWR.n159 VPWR.n11 185
R1354 VPWR.n162 VPWR.n161 185
R1355 VPWR.n13 VPWR.n12 185
R1356 VPWR.n157 VPWR.n156 185
R1357 VPWR.n155 VPWR.n42 185
R1358 VPWR.n154 VPWR.n153 185
R1359 VPWR.n152 VPWR.n151 185
R1360 VPWR.n150 VPWR.n149 185
R1361 VPWR.n148 VPWR.n147 185
R1362 VPWR.n146 VPWR.n145 185
R1363 VPWR.n144 VPWR.n143 185
R1364 VPWR.n142 VPWR.n141 185
R1365 VPWR.n140 VPWR.n139 185
R1366 VPWR.n138 VPWR.n137 185
R1367 VPWR.n136 VPWR.n135 185
R1368 VPWR.n134 VPWR.n133 185
R1369 VPWR.n132 VPWR.n131 185
R1370 VPWR.n130 VPWR.n129 185
R1371 VPWR.n128 VPWR.n127 185
R1372 VPWR.n126 VPWR.n125 185
R1373 VPWR.n124 VPWR.n123 185
R1374 VPWR.n122 VPWR.n121 185
R1375 VPWR.n120 VPWR.n119 185
R1376 VPWR.n118 VPWR.n117 185
R1377 VPWR.n116 VPWR.n115 185
R1378 VPWR.n114 VPWR.n113 185
R1379 VPWR.n112 VPWR.n111 185
R1380 VPWR.n110 VPWR.n109 185
R1381 VPWR.n108 VPWR.n107 185
R1382 VPWR.n106 VPWR.n105 185
R1383 VPWR.n104 VPWR.n103 185
R1384 VPWR.n102 VPWR.n101 185
R1385 VPWR.n100 VPWR.n99 185
R1386 VPWR.n98 VPWR.n97 185
R1387 VPWR.n96 VPWR.n95 185
R1388 VPWR.n94 VPWR.n93 185
R1389 VPWR.n92 VPWR.n91 185
R1390 VPWR.n90 VPWR.n89 185
R1391 VPWR.n88 VPWR.n87 185
R1392 VPWR.n86 VPWR.n85 185
R1393 VPWR.n84 VPWR.n83 185
R1394 VPWR.n82 VPWR.n81 185
R1395 VPWR.n80 VPWR.n79 185
R1396 VPWR.n78 VPWR.n77 185
R1397 VPWR.n76 VPWR.n75 185
R1398 VPWR.n74 VPWR.n73 185
R1399 VPWR.n72 VPWR.n71 185
R1400 VPWR.n70 VPWR.n69 185
R1401 VPWR.n68 VPWR.n67 185
R1402 VPWR.n66 VPWR.n65 185
R1403 VPWR.n64 VPWR.n63 185
R1404 VPWR.n62 VPWR.n61 185
R1405 VPWR.n60 VPWR.n59 185
R1406 VPWR.n58 VPWR.n57 185
R1407 VPWR.n56 VPWR.n55 185
R1408 VPWR.n54 VPWR.n53 185
R1409 VPWR.n52 VPWR.n51 185
R1410 VPWR.n50 VPWR.n49 185
R1411 VPWR.n48 VPWR.n47 185
R1412 VPWR.n46 VPWR.n45 185
R1413 VPWR.n44 VPWR.n43 185
R1414 VPWR.n9 VPWR.n8 185
R1415 VPWR.n10 VPWR.n9 185
R1416 VPWR.n169 VPWR.n168 185
R1417 VPWR.n168 VPWR.n167 185
R1418 VPWR.n170 VPWR.n6 185
R1419 VPWR.n6 VPWR.t4 185
R1420 VPWR.n326 VPWR.n325 185
R1421 VPWR.n327 VPWR.n326 185
R1422 VPWR.n324 VPWR.n7 185
R1423 VPWR.n7 VPWR.n5 185
R1424 VPWR.n323 VPWR.n322 185
R1425 VPWR.n172 VPWR.n171 185
R1426 VPWR.n319 VPWR.n318 185
R1427 VPWR.n320 VPWR.n319 185
R1428 VPWR.n317 VPWR.n202 185
R1429 VPWR.n316 VPWR.n315 185
R1430 VPWR.n314 VPWR.n313 185
R1431 VPWR.n312 VPWR.n311 185
R1432 VPWR.n310 VPWR.n309 185
R1433 VPWR.n308 VPWR.n307 185
R1434 VPWR.n306 VPWR.n305 185
R1435 VPWR.n304 VPWR.n303 185
R1436 VPWR.n302 VPWR.n301 185
R1437 VPWR.n300 VPWR.n299 185
R1438 VPWR.n298 VPWR.n297 185
R1439 VPWR.n296 VPWR.n295 185
R1440 VPWR.n294 VPWR.n293 185
R1441 VPWR.n292 VPWR.n291 185
R1442 VPWR.n290 VPWR.n289 185
R1443 VPWR.n288 VPWR.n287 185
R1444 VPWR.n286 VPWR.n285 185
R1445 VPWR.n284 VPWR.n283 185
R1446 VPWR.n282 VPWR.n281 185
R1447 VPWR.n280 VPWR.n279 185
R1448 VPWR.n278 VPWR.n277 185
R1449 VPWR.n276 VPWR.n275 185
R1450 VPWR.n274 VPWR.n273 185
R1451 VPWR.n272 VPWR.n271 185
R1452 VPWR.n270 VPWR.n269 185
R1453 VPWR.n268 VPWR.n267 185
R1454 VPWR.n266 VPWR.n265 185
R1455 VPWR.n264 VPWR.n263 185
R1456 VPWR.n262 VPWR.n261 185
R1457 VPWR.n260 VPWR.n259 185
R1458 VPWR.n258 VPWR.n257 185
R1459 VPWR.n256 VPWR.n255 185
R1460 VPWR.n254 VPWR.n253 185
R1461 VPWR.n252 VPWR.n251 185
R1462 VPWR.n250 VPWR.n249 185
R1463 VPWR.n248 VPWR.n247 185
R1464 VPWR.n246 VPWR.n245 185
R1465 VPWR.n244 VPWR.n243 185
R1466 VPWR.n242 VPWR.n241 185
R1467 VPWR.n240 VPWR.n239 185
R1468 VPWR.n238 VPWR.n237 185
R1469 VPWR.n236 VPWR.n235 185
R1470 VPWR.n234 VPWR.n233 185
R1471 VPWR.n232 VPWR.n231 185
R1472 VPWR.n230 VPWR.n229 185
R1473 VPWR.n228 VPWR.n227 185
R1474 VPWR.n226 VPWR.n225 185
R1475 VPWR.n224 VPWR.n223 185
R1476 VPWR.n222 VPWR.n221 185
R1477 VPWR.n220 VPWR.n219 185
R1478 VPWR.n218 VPWR.n217 185
R1479 VPWR.n216 VPWR.n215 185
R1480 VPWR.n214 VPWR.n213 185
R1481 VPWR.n212 VPWR.n211 185
R1482 VPWR.n210 VPWR.n209 185
R1483 VPWR.n208 VPWR.n207 185
R1484 VPWR.n206 VPWR.n205 185
R1485 VPWR.n204 VPWR.n203 185
R1486 VPWR.n4 VPWR.n3 185
R1487 VPWR.n5 VPWR.n4 185
R1488 VPWR.n329 VPWR.n328 185
R1489 VPWR.n328 VPWR.n327 185
R1490 VPWR VPWR.n2 185
R1491 VPWR.t4 VPWR.n2 185
R1492 VPWR.n166 VPWR.n1 185
R1493 VPWR.n167 VPWR.n166 185
R1494 VPWR.n165 VPWR.n164 185
R1495 VPWR.n165 VPWR.n10 185
R1496 VPWR.n743 VPWR.n742 83.9534
R1497 VPWR.n735 VPWR.n669 83.9534
R1498 VPWR.n805 VPWR.n804 83.9534
R1499 VPWR.n809 VPWR.n670 83.9534
R1500 VPWR.n378 VPWR.n342 81.3181
R1501 VPWR.n498 VPWR.n497 81.3181
R1502 VPWR.n658 VPWR.n657 81.3181
R1503 VPWR.n538 VPWR.n337 81.3181
R1504 VPWR.n44 VPWR.n8 81.3181
R1505 VPWR.n164 VPWR.n163 81.3181
R1506 VPWR.n324 VPWR.n323 81.3181
R1507 VPWR.n204 VPWR.n3 81.3181
R1508 VPWR.n656 VPWR.n655 72.7879
R1509 VPWR.n536 VPWR.n507 72.7879
R1510 VPWR.n648 VPWR.n508 72.7879
R1511 VPWR.n644 VPWR.n509 72.7879
R1512 VPWR.n640 VPWR.n510 72.7879
R1513 VPWR.n636 VPWR.n511 72.7879
R1514 VPWR.n632 VPWR.n512 72.7879
R1515 VPWR.n628 VPWR.n513 72.7879
R1516 VPWR.n624 VPWR.n514 72.7879
R1517 VPWR.n620 VPWR.n515 72.7879
R1518 VPWR.n616 VPWR.n516 72.7879
R1519 VPWR.n612 VPWR.n517 72.7879
R1520 VPWR.n608 VPWR.n518 72.7879
R1521 VPWR.n604 VPWR.n519 72.7879
R1522 VPWR.n600 VPWR.n520 72.7879
R1523 VPWR.n596 VPWR.n521 72.7879
R1524 VPWR.n592 VPWR.n522 72.7879
R1525 VPWR.n588 VPWR.n523 72.7879
R1526 VPWR.n584 VPWR.n524 72.7879
R1527 VPWR.n580 VPWR.n525 72.7879
R1528 VPWR.n576 VPWR.n526 72.7879
R1529 VPWR.n572 VPWR.n527 72.7879
R1530 VPWR.n568 VPWR.n528 72.7879
R1531 VPWR.n564 VPWR.n529 72.7879
R1532 VPWR.n560 VPWR.n530 72.7879
R1533 VPWR.n556 VPWR.n531 72.7879
R1534 VPWR.n552 VPWR.n532 72.7879
R1535 VPWR.n548 VPWR.n533 72.7879
R1536 VPWR.n544 VPWR.n534 72.7879
R1537 VPWR.n540 VPWR.n535 72.7879
R1538 VPWR.n377 VPWR.n348 72.7879
R1539 VPWR.n381 VPWR.n349 72.7879
R1540 VPWR.n385 VPWR.n350 72.7879
R1541 VPWR.n389 VPWR.n351 72.7879
R1542 VPWR.n393 VPWR.n352 72.7879
R1543 VPWR.n397 VPWR.n353 72.7879
R1544 VPWR.n401 VPWR.n354 72.7879
R1545 VPWR.n405 VPWR.n355 72.7879
R1546 VPWR.n409 VPWR.n356 72.7879
R1547 VPWR.n413 VPWR.n357 72.7879
R1548 VPWR.n417 VPWR.n358 72.7879
R1549 VPWR.n421 VPWR.n359 72.7879
R1550 VPWR.n425 VPWR.n360 72.7879
R1551 VPWR.n429 VPWR.n361 72.7879
R1552 VPWR.n433 VPWR.n362 72.7879
R1553 VPWR.n437 VPWR.n363 72.7879
R1554 VPWR.n441 VPWR.n364 72.7879
R1555 VPWR.n445 VPWR.n365 72.7879
R1556 VPWR.n449 VPWR.n366 72.7879
R1557 VPWR.n453 VPWR.n367 72.7879
R1558 VPWR.n457 VPWR.n368 72.7879
R1559 VPWR.n461 VPWR.n369 72.7879
R1560 VPWR.n465 VPWR.n370 72.7879
R1561 VPWR.n469 VPWR.n371 72.7879
R1562 VPWR.n473 VPWR.n372 72.7879
R1563 VPWR.n477 VPWR.n373 72.7879
R1564 VPWR.n481 VPWR.n374 72.7879
R1565 VPWR.n485 VPWR.n375 72.7879
R1566 VPWR.n492 VPWR.n376 72.7879
R1567 VPWR.n494 VPWR.n347 72.7879
R1568 VPWR.n495 VPWR.n494 72.7879
R1569 VPWR.n492 VPWR.n491 72.7879
R1570 VPWR.n487 VPWR.n375 72.7879
R1571 VPWR.n484 VPWR.n374 72.7879
R1572 VPWR.n480 VPWR.n373 72.7879
R1573 VPWR.n476 VPWR.n372 72.7879
R1574 VPWR.n472 VPWR.n371 72.7879
R1575 VPWR.n468 VPWR.n370 72.7879
R1576 VPWR.n464 VPWR.n369 72.7879
R1577 VPWR.n460 VPWR.n368 72.7879
R1578 VPWR.n456 VPWR.n367 72.7879
R1579 VPWR.n452 VPWR.n366 72.7879
R1580 VPWR.n448 VPWR.n365 72.7879
R1581 VPWR.n444 VPWR.n364 72.7879
R1582 VPWR.n440 VPWR.n363 72.7879
R1583 VPWR.n436 VPWR.n362 72.7879
R1584 VPWR.n432 VPWR.n361 72.7879
R1585 VPWR.n428 VPWR.n360 72.7879
R1586 VPWR.n424 VPWR.n359 72.7879
R1587 VPWR.n420 VPWR.n358 72.7879
R1588 VPWR.n416 VPWR.n357 72.7879
R1589 VPWR.n412 VPWR.n356 72.7879
R1590 VPWR.n408 VPWR.n355 72.7879
R1591 VPWR.n404 VPWR.n354 72.7879
R1592 VPWR.n400 VPWR.n353 72.7879
R1593 VPWR.n396 VPWR.n352 72.7879
R1594 VPWR.n392 VPWR.n351 72.7879
R1595 VPWR.n388 VPWR.n350 72.7879
R1596 VPWR.n384 VPWR.n349 72.7879
R1597 VPWR.n380 VPWR.n348 72.7879
R1598 VPWR.n655 VPWR.n506 72.7879
R1599 VPWR.n649 VPWR.n507 72.7879
R1600 VPWR.n645 VPWR.n508 72.7879
R1601 VPWR.n641 VPWR.n509 72.7879
R1602 VPWR.n637 VPWR.n510 72.7879
R1603 VPWR.n633 VPWR.n511 72.7879
R1604 VPWR.n629 VPWR.n512 72.7879
R1605 VPWR.n625 VPWR.n513 72.7879
R1606 VPWR.n621 VPWR.n514 72.7879
R1607 VPWR.n617 VPWR.n515 72.7879
R1608 VPWR.n613 VPWR.n516 72.7879
R1609 VPWR.n609 VPWR.n517 72.7879
R1610 VPWR.n605 VPWR.n518 72.7879
R1611 VPWR.n601 VPWR.n519 72.7879
R1612 VPWR.n597 VPWR.n520 72.7879
R1613 VPWR.n593 VPWR.n521 72.7879
R1614 VPWR.n589 VPWR.n522 72.7879
R1615 VPWR.n585 VPWR.n523 72.7879
R1616 VPWR.n581 VPWR.n524 72.7879
R1617 VPWR.n577 VPWR.n525 72.7879
R1618 VPWR.n573 VPWR.n526 72.7879
R1619 VPWR.n569 VPWR.n527 72.7879
R1620 VPWR.n565 VPWR.n528 72.7879
R1621 VPWR.n561 VPWR.n529 72.7879
R1622 VPWR.n557 VPWR.n530 72.7879
R1623 VPWR.n553 VPWR.n531 72.7879
R1624 VPWR.n549 VPWR.n532 72.7879
R1625 VPWR.n545 VPWR.n533 72.7879
R1626 VPWR.n541 VPWR.n534 72.7879
R1627 VPWR.n537 VPWR.n535 72.7879
R1628 VPWR.n801 VPWR.n675 72.7879
R1629 VPWR.n799 VPWR.n745 72.7879
R1630 VPWR.n795 VPWR.n794 72.7879
R1631 VPWR.n788 VPWR.n747 72.7879
R1632 VPWR.n787 VPWR.n786 72.7879
R1633 VPWR.n780 VPWR.n749 72.7879
R1634 VPWR.n779 VPWR.n778 72.7879
R1635 VPWR.n772 VPWR.n751 72.7879
R1636 VPWR.n771 VPWR.n770 72.7879
R1637 VPWR.n764 VPWR.n753 72.7879
R1638 VPWR.n763 VPWR.n762 72.7879
R1639 VPWR.n756 VPWR.n755 72.7879
R1640 VPWR.n741 VPWR.n740 72.7879
R1641 VPWR.n690 VPWR.n678 72.7879
R1642 VPWR.n694 VPWR.n679 72.7879
R1643 VPWR.n698 VPWR.n680 72.7879
R1644 VPWR.n702 VPWR.n681 72.7879
R1645 VPWR.n706 VPWR.n682 72.7879
R1646 VPWR.n710 VPWR.n683 72.7879
R1647 VPWR.n714 VPWR.n684 72.7879
R1648 VPWR.n718 VPWR.n685 72.7879
R1649 VPWR.n722 VPWR.n686 72.7879
R1650 VPWR.n726 VPWR.n687 72.7879
R1651 VPWR.n730 VPWR.n688 72.7879
R1652 VPWR.n737 VPWR.n689 72.7879
R1653 VPWR.n737 VPWR.n736 72.7879
R1654 VPWR.n732 VPWR.n688 72.7879
R1655 VPWR.n729 VPWR.n687 72.7879
R1656 VPWR.n725 VPWR.n686 72.7879
R1657 VPWR.n721 VPWR.n685 72.7879
R1658 VPWR.n717 VPWR.n684 72.7879
R1659 VPWR.n713 VPWR.n683 72.7879
R1660 VPWR.n709 VPWR.n682 72.7879
R1661 VPWR.n705 VPWR.n681 72.7879
R1662 VPWR.n701 VPWR.n680 72.7879
R1663 VPWR.n697 VPWR.n679 72.7879
R1664 VPWR.n693 VPWR.n678 72.7879
R1665 VPWR.n740 VPWR.n677 72.7879
R1666 VPWR.n802 VPWR.n801 72.7879
R1667 VPWR.n796 VPWR.n745 72.7879
R1668 VPWR.n794 VPWR.n793 72.7879
R1669 VPWR.n789 VPWR.n788 72.7879
R1670 VPWR.n786 VPWR.n785 72.7879
R1671 VPWR.n781 VPWR.n780 72.7879
R1672 VPWR.n778 VPWR.n777 72.7879
R1673 VPWR.n773 VPWR.n772 72.7879
R1674 VPWR.n770 VPWR.n769 72.7879
R1675 VPWR.n765 VPWR.n764 72.7879
R1676 VPWR.n762 VPWR.n761 72.7879
R1677 VPWR.n757 VPWR.n756 72.7879
R1678 VPWR.n322 VPWR.n321 72.7879
R1679 VPWR.n202 VPWR.n173 72.7879
R1680 VPWR.n314 VPWR.n174 72.7879
R1681 VPWR.n310 VPWR.n175 72.7879
R1682 VPWR.n306 VPWR.n176 72.7879
R1683 VPWR.n302 VPWR.n177 72.7879
R1684 VPWR.n298 VPWR.n178 72.7879
R1685 VPWR.n294 VPWR.n179 72.7879
R1686 VPWR.n290 VPWR.n180 72.7879
R1687 VPWR.n286 VPWR.n181 72.7879
R1688 VPWR.n282 VPWR.n182 72.7879
R1689 VPWR.n278 VPWR.n183 72.7879
R1690 VPWR.n274 VPWR.n184 72.7879
R1691 VPWR.n270 VPWR.n185 72.7879
R1692 VPWR.n266 VPWR.n186 72.7879
R1693 VPWR.n262 VPWR.n187 72.7879
R1694 VPWR.n258 VPWR.n188 72.7879
R1695 VPWR.n254 VPWR.n189 72.7879
R1696 VPWR.n250 VPWR.n190 72.7879
R1697 VPWR.n246 VPWR.n191 72.7879
R1698 VPWR.n242 VPWR.n192 72.7879
R1699 VPWR.n238 VPWR.n193 72.7879
R1700 VPWR.n234 VPWR.n194 72.7879
R1701 VPWR.n230 VPWR.n195 72.7879
R1702 VPWR.n226 VPWR.n196 72.7879
R1703 VPWR.n222 VPWR.n197 72.7879
R1704 VPWR.n218 VPWR.n198 72.7879
R1705 VPWR.n214 VPWR.n199 72.7879
R1706 VPWR.n210 VPWR.n200 72.7879
R1707 VPWR.n206 VPWR.n201 72.7879
R1708 VPWR.n43 VPWR.n14 72.7879
R1709 VPWR.n47 VPWR.n15 72.7879
R1710 VPWR.n51 VPWR.n16 72.7879
R1711 VPWR.n55 VPWR.n17 72.7879
R1712 VPWR.n59 VPWR.n18 72.7879
R1713 VPWR.n63 VPWR.n19 72.7879
R1714 VPWR.n67 VPWR.n20 72.7879
R1715 VPWR.n71 VPWR.n21 72.7879
R1716 VPWR.n75 VPWR.n22 72.7879
R1717 VPWR.n79 VPWR.n23 72.7879
R1718 VPWR.n83 VPWR.n24 72.7879
R1719 VPWR.n87 VPWR.n25 72.7879
R1720 VPWR.n91 VPWR.n26 72.7879
R1721 VPWR.n95 VPWR.n27 72.7879
R1722 VPWR.n99 VPWR.n28 72.7879
R1723 VPWR.n103 VPWR.n29 72.7879
R1724 VPWR.n107 VPWR.n30 72.7879
R1725 VPWR.n111 VPWR.n31 72.7879
R1726 VPWR.n115 VPWR.n32 72.7879
R1727 VPWR.n119 VPWR.n33 72.7879
R1728 VPWR.n123 VPWR.n34 72.7879
R1729 VPWR.n127 VPWR.n35 72.7879
R1730 VPWR.n131 VPWR.n36 72.7879
R1731 VPWR.n135 VPWR.n37 72.7879
R1732 VPWR.n139 VPWR.n38 72.7879
R1733 VPWR.n143 VPWR.n39 72.7879
R1734 VPWR.n147 VPWR.n40 72.7879
R1735 VPWR.n151 VPWR.n41 72.7879
R1736 VPWR.n158 VPWR.n42 72.7879
R1737 VPWR.n160 VPWR.n13 72.7879
R1738 VPWR.n161 VPWR.n160 72.7879
R1739 VPWR.n158 VPWR.n157 72.7879
R1740 VPWR.n153 VPWR.n41 72.7879
R1741 VPWR.n150 VPWR.n40 72.7879
R1742 VPWR.n146 VPWR.n39 72.7879
R1743 VPWR.n142 VPWR.n38 72.7879
R1744 VPWR.n138 VPWR.n37 72.7879
R1745 VPWR.n134 VPWR.n36 72.7879
R1746 VPWR.n130 VPWR.n35 72.7879
R1747 VPWR.n126 VPWR.n34 72.7879
R1748 VPWR.n122 VPWR.n33 72.7879
R1749 VPWR.n118 VPWR.n32 72.7879
R1750 VPWR.n114 VPWR.n31 72.7879
R1751 VPWR.n110 VPWR.n30 72.7879
R1752 VPWR.n106 VPWR.n29 72.7879
R1753 VPWR.n102 VPWR.n28 72.7879
R1754 VPWR.n98 VPWR.n27 72.7879
R1755 VPWR.n94 VPWR.n26 72.7879
R1756 VPWR.n90 VPWR.n25 72.7879
R1757 VPWR.n86 VPWR.n24 72.7879
R1758 VPWR.n82 VPWR.n23 72.7879
R1759 VPWR.n78 VPWR.n22 72.7879
R1760 VPWR.n74 VPWR.n21 72.7879
R1761 VPWR.n70 VPWR.n20 72.7879
R1762 VPWR.n66 VPWR.n19 72.7879
R1763 VPWR.n62 VPWR.n18 72.7879
R1764 VPWR.n58 VPWR.n17 72.7879
R1765 VPWR.n54 VPWR.n16 72.7879
R1766 VPWR.n50 VPWR.n15 72.7879
R1767 VPWR.n46 VPWR.n14 72.7879
R1768 VPWR.n321 VPWR.n172 72.7879
R1769 VPWR.n315 VPWR.n173 72.7879
R1770 VPWR.n311 VPWR.n174 72.7879
R1771 VPWR.n307 VPWR.n175 72.7879
R1772 VPWR.n303 VPWR.n176 72.7879
R1773 VPWR.n299 VPWR.n177 72.7879
R1774 VPWR.n295 VPWR.n178 72.7879
R1775 VPWR.n291 VPWR.n179 72.7879
R1776 VPWR.n287 VPWR.n180 72.7879
R1777 VPWR.n283 VPWR.n181 72.7879
R1778 VPWR.n279 VPWR.n182 72.7879
R1779 VPWR.n275 VPWR.n183 72.7879
R1780 VPWR.n271 VPWR.n184 72.7879
R1781 VPWR.n267 VPWR.n185 72.7879
R1782 VPWR.n263 VPWR.n186 72.7879
R1783 VPWR.n259 VPWR.n187 72.7879
R1784 VPWR.n255 VPWR.n188 72.7879
R1785 VPWR.n251 VPWR.n189 72.7879
R1786 VPWR.n247 VPWR.n190 72.7879
R1787 VPWR.n243 VPWR.n191 72.7879
R1788 VPWR.n239 VPWR.n192 72.7879
R1789 VPWR.n235 VPWR.n193 72.7879
R1790 VPWR.n231 VPWR.n194 72.7879
R1791 VPWR.n227 VPWR.n195 72.7879
R1792 VPWR.n223 VPWR.n196 72.7879
R1793 VPWR.n219 VPWR.n197 72.7879
R1794 VPWR.n215 VPWR.n198 72.7879
R1795 VPWR.n211 VPWR.n199 72.7879
R1796 VPWR.n207 VPWR.n200 72.7879
R1797 VPWR.n203 VPWR.n201 72.7879
R1798 VPWR.n739 VPWR.n738 57.8023
R1799 VPWR.n807 VPWR.n673 57.8023
R1800 VPWR.n494 VPWR.n493 56.1076
R1801 VPWR.n493 VPWR.n492 56.1076
R1802 VPWR.n493 VPWR.n375 56.1076
R1803 VPWR.n493 VPWR.n374 56.1076
R1804 VPWR.n493 VPWR.n373 56.1076
R1805 VPWR.n493 VPWR.n372 56.1076
R1806 VPWR.n493 VPWR.n371 56.1076
R1807 VPWR.n493 VPWR.n370 56.1076
R1808 VPWR.n493 VPWR.n369 56.1076
R1809 VPWR.n493 VPWR.n368 56.1076
R1810 VPWR.n493 VPWR.n367 56.1076
R1811 VPWR.n493 VPWR.n366 56.1076
R1812 VPWR.n493 VPWR.n365 56.1076
R1813 VPWR.n493 VPWR.n364 56.1076
R1814 VPWR.n493 VPWR.n363 56.1076
R1815 VPWR.n493 VPWR.n362 56.1076
R1816 VPWR.n493 VPWR.n361 56.1076
R1817 VPWR.n493 VPWR.n360 56.1076
R1818 VPWR.n493 VPWR.n359 56.1076
R1819 VPWR.n493 VPWR.n358 56.1076
R1820 VPWR.n493 VPWR.n357 56.1076
R1821 VPWR.n493 VPWR.n356 56.1076
R1822 VPWR.n493 VPWR.n355 56.1076
R1823 VPWR.n493 VPWR.n354 56.1076
R1824 VPWR.n493 VPWR.n353 56.1076
R1825 VPWR.n493 VPWR.n352 56.1076
R1826 VPWR.n493 VPWR.n351 56.1076
R1827 VPWR.n493 VPWR.n350 56.1076
R1828 VPWR.n493 VPWR.n349 56.1076
R1829 VPWR.n493 VPWR.n348 56.1076
R1830 VPWR.n655 VPWR.n654 56.1076
R1831 VPWR.n654 VPWR.n507 56.1076
R1832 VPWR.n654 VPWR.n508 56.1076
R1833 VPWR.n654 VPWR.n509 56.1076
R1834 VPWR.n654 VPWR.n510 56.1076
R1835 VPWR.n654 VPWR.n511 56.1076
R1836 VPWR.n654 VPWR.n512 56.1076
R1837 VPWR.n654 VPWR.n513 56.1076
R1838 VPWR.n654 VPWR.n514 56.1076
R1839 VPWR.n654 VPWR.n515 56.1076
R1840 VPWR.n654 VPWR.n516 56.1076
R1841 VPWR.n654 VPWR.n517 56.1076
R1842 VPWR.n654 VPWR.n518 56.1076
R1843 VPWR.n654 VPWR.n519 56.1076
R1844 VPWR.n654 VPWR.n520 56.1076
R1845 VPWR.n654 VPWR.n521 56.1076
R1846 VPWR.n654 VPWR.n522 56.1076
R1847 VPWR.n654 VPWR.n523 56.1076
R1848 VPWR.n654 VPWR.n524 56.1076
R1849 VPWR.n654 VPWR.n525 56.1076
R1850 VPWR.n654 VPWR.n526 56.1076
R1851 VPWR.n654 VPWR.n527 56.1076
R1852 VPWR.n654 VPWR.n528 56.1076
R1853 VPWR.n654 VPWR.n529 56.1076
R1854 VPWR.n654 VPWR.n530 56.1076
R1855 VPWR.n654 VPWR.n531 56.1076
R1856 VPWR.n654 VPWR.n532 56.1076
R1857 VPWR.n654 VPWR.n533 56.1076
R1858 VPWR.n654 VPWR.n534 56.1076
R1859 VPWR.n654 VPWR.n535 56.1076
R1860 VPWR.n739 VPWR.n737 56.1076
R1861 VPWR.n739 VPWR.n688 56.1076
R1862 VPWR.n739 VPWR.n687 56.1076
R1863 VPWR.n739 VPWR.n686 56.1076
R1864 VPWR.n739 VPWR.n685 56.1076
R1865 VPWR.n739 VPWR.n684 56.1076
R1866 VPWR.n739 VPWR.n683 56.1076
R1867 VPWR.n739 VPWR.n682 56.1076
R1868 VPWR.n739 VPWR.n681 56.1076
R1869 VPWR.n739 VPWR.n680 56.1076
R1870 VPWR.n739 VPWR.n679 56.1076
R1871 VPWR.n739 VPWR.n678 56.1076
R1872 VPWR.n740 VPWR.n739 56.1076
R1873 VPWR.n801 VPWR.n673 56.1076
R1874 VPWR.n745 VPWR.n673 56.1076
R1875 VPWR.n794 VPWR.n673 56.1076
R1876 VPWR.n788 VPWR.n673 56.1076
R1877 VPWR.n786 VPWR.n673 56.1076
R1878 VPWR.n780 VPWR.n673 56.1076
R1879 VPWR.n778 VPWR.n673 56.1076
R1880 VPWR.n772 VPWR.n673 56.1076
R1881 VPWR.n770 VPWR.n673 56.1076
R1882 VPWR.n764 VPWR.n673 56.1076
R1883 VPWR.n762 VPWR.n673 56.1076
R1884 VPWR.n756 VPWR.n673 56.1076
R1885 VPWR.n160 VPWR.n159 56.1076
R1886 VPWR.n159 VPWR.n158 56.1076
R1887 VPWR.n159 VPWR.n41 56.1076
R1888 VPWR.n159 VPWR.n40 56.1076
R1889 VPWR.n159 VPWR.n39 56.1076
R1890 VPWR.n159 VPWR.n38 56.1076
R1891 VPWR.n159 VPWR.n37 56.1076
R1892 VPWR.n159 VPWR.n36 56.1076
R1893 VPWR.n159 VPWR.n35 56.1076
R1894 VPWR.n159 VPWR.n34 56.1076
R1895 VPWR.n159 VPWR.n33 56.1076
R1896 VPWR.n159 VPWR.n32 56.1076
R1897 VPWR.n159 VPWR.n31 56.1076
R1898 VPWR.n159 VPWR.n30 56.1076
R1899 VPWR.n159 VPWR.n29 56.1076
R1900 VPWR.n159 VPWR.n28 56.1076
R1901 VPWR.n159 VPWR.n27 56.1076
R1902 VPWR.n159 VPWR.n26 56.1076
R1903 VPWR.n159 VPWR.n25 56.1076
R1904 VPWR.n159 VPWR.n24 56.1076
R1905 VPWR.n159 VPWR.n23 56.1076
R1906 VPWR.n159 VPWR.n22 56.1076
R1907 VPWR.n159 VPWR.n21 56.1076
R1908 VPWR.n159 VPWR.n20 56.1076
R1909 VPWR.n159 VPWR.n19 56.1076
R1910 VPWR.n159 VPWR.n18 56.1076
R1911 VPWR.n159 VPWR.n17 56.1076
R1912 VPWR.n159 VPWR.n16 56.1076
R1913 VPWR.n159 VPWR.n15 56.1076
R1914 VPWR.n159 VPWR.n14 56.1076
R1915 VPWR.n321 VPWR.n320 56.1076
R1916 VPWR.n320 VPWR.n173 56.1076
R1917 VPWR.n320 VPWR.n174 56.1076
R1918 VPWR.n320 VPWR.n175 56.1076
R1919 VPWR.n320 VPWR.n176 56.1076
R1920 VPWR.n320 VPWR.n177 56.1076
R1921 VPWR.n320 VPWR.n178 56.1076
R1922 VPWR.n320 VPWR.n179 56.1076
R1923 VPWR.n320 VPWR.n180 56.1076
R1924 VPWR.n320 VPWR.n181 56.1076
R1925 VPWR.n320 VPWR.n182 56.1076
R1926 VPWR.n320 VPWR.n183 56.1076
R1927 VPWR.n320 VPWR.n184 56.1076
R1928 VPWR.n320 VPWR.n185 56.1076
R1929 VPWR.n320 VPWR.n186 56.1076
R1930 VPWR.n320 VPWR.n187 56.1076
R1931 VPWR.n320 VPWR.n188 56.1076
R1932 VPWR.n320 VPWR.n189 56.1076
R1933 VPWR.n320 VPWR.n190 56.1076
R1934 VPWR.n320 VPWR.n191 56.1076
R1935 VPWR.n320 VPWR.n192 56.1076
R1936 VPWR.n320 VPWR.n193 56.1076
R1937 VPWR.n320 VPWR.n194 56.1076
R1938 VPWR.n320 VPWR.n195 56.1076
R1939 VPWR.n320 VPWR.n196 56.1076
R1940 VPWR.n320 VPWR.n197 56.1076
R1941 VPWR.n320 VPWR.n198 56.1076
R1942 VPWR.n320 VPWR.n199 56.1076
R1943 VPWR.n320 VPWR.n200 56.1076
R1944 VPWR.n320 VPWR.n201 56.1076
R1945 VPWR.n812 VPWR.n0 54.4415
R1946 VPWR.n813 VPWR.n812 48.279
R1947 VPWR.n379 VPWR.n378 25.6005
R1948 VPWR.n382 VPWR.n379 25.6005
R1949 VPWR.n383 VPWR.n382 25.6005
R1950 VPWR.n386 VPWR.n383 25.6005
R1951 VPWR.n387 VPWR.n386 25.6005
R1952 VPWR.n390 VPWR.n387 25.6005
R1953 VPWR.n391 VPWR.n390 25.6005
R1954 VPWR.n394 VPWR.n391 25.6005
R1955 VPWR.n395 VPWR.n394 25.6005
R1956 VPWR.n398 VPWR.n395 25.6005
R1957 VPWR.n399 VPWR.n398 25.6005
R1958 VPWR.n402 VPWR.n399 25.6005
R1959 VPWR.n403 VPWR.n402 25.6005
R1960 VPWR.n406 VPWR.n403 25.6005
R1961 VPWR.n407 VPWR.n406 25.6005
R1962 VPWR.n410 VPWR.n407 25.6005
R1963 VPWR.n411 VPWR.n410 25.6005
R1964 VPWR.n414 VPWR.n411 25.6005
R1965 VPWR.n415 VPWR.n414 25.6005
R1966 VPWR.n418 VPWR.n415 25.6005
R1967 VPWR.n419 VPWR.n418 25.6005
R1968 VPWR.n422 VPWR.n419 25.6005
R1969 VPWR.n423 VPWR.n422 25.6005
R1970 VPWR.n426 VPWR.n423 25.6005
R1971 VPWR.n427 VPWR.n426 25.6005
R1972 VPWR.n430 VPWR.n427 25.6005
R1973 VPWR.n431 VPWR.n430 25.6005
R1974 VPWR.n434 VPWR.n431 25.6005
R1975 VPWR.n435 VPWR.n434 25.6005
R1976 VPWR.n438 VPWR.n435 25.6005
R1977 VPWR.n439 VPWR.n438 25.6005
R1978 VPWR.n442 VPWR.n439 25.6005
R1979 VPWR.n443 VPWR.n442 25.6005
R1980 VPWR.n446 VPWR.n443 25.6005
R1981 VPWR.n447 VPWR.n446 25.6005
R1982 VPWR.n450 VPWR.n447 25.6005
R1983 VPWR.n451 VPWR.n450 25.6005
R1984 VPWR.n454 VPWR.n451 25.6005
R1985 VPWR.n455 VPWR.n454 25.6005
R1986 VPWR.n458 VPWR.n455 25.6005
R1987 VPWR.n459 VPWR.n458 25.6005
R1988 VPWR.n462 VPWR.n459 25.6005
R1989 VPWR.n463 VPWR.n462 25.6005
R1990 VPWR.n466 VPWR.n463 25.6005
R1991 VPWR.n467 VPWR.n466 25.6005
R1992 VPWR.n470 VPWR.n467 25.6005
R1993 VPWR.n471 VPWR.n470 25.6005
R1994 VPWR.n474 VPWR.n471 25.6005
R1995 VPWR.n475 VPWR.n474 25.6005
R1996 VPWR.n478 VPWR.n475 25.6005
R1997 VPWR.n479 VPWR.n478 25.6005
R1998 VPWR.n482 VPWR.n479 25.6005
R1999 VPWR.n483 VPWR.n482 25.6005
R2000 VPWR.n486 VPWR.n483 25.6005
R2001 VPWR.n488 VPWR.n486 25.6005
R2002 VPWR.n489 VPWR.n488 25.6005
R2003 VPWR.n490 VPWR.n489 25.6005
R2004 VPWR.n490 VPWR.n346 25.6005
R2005 VPWR.n496 VPWR.n346 25.6005
R2006 VPWR.n497 VPWR.n496 25.6005
R2007 VPWR.n503 VPWR.n342 25.6005
R2008 VPWR.n504 VPWR.n503 25.6005
R2009 VPWR.n659 VPWR.n504 25.6005
R2010 VPWR.n659 VPWR.n658 25.6005
R2011 VPWR.n657 VPWR.n505 25.6005
R2012 VPWR.n652 VPWR.n505 25.6005
R2013 VPWR.n652 VPWR.n651 25.6005
R2014 VPWR.n651 VPWR.n650 25.6005
R2015 VPWR.n650 VPWR.n647 25.6005
R2016 VPWR.n647 VPWR.n646 25.6005
R2017 VPWR.n646 VPWR.n643 25.6005
R2018 VPWR.n643 VPWR.n642 25.6005
R2019 VPWR.n642 VPWR.n639 25.6005
R2020 VPWR.n639 VPWR.n638 25.6005
R2021 VPWR.n638 VPWR.n635 25.6005
R2022 VPWR.n635 VPWR.n634 25.6005
R2023 VPWR.n634 VPWR.n631 25.6005
R2024 VPWR.n631 VPWR.n630 25.6005
R2025 VPWR.n630 VPWR.n627 25.6005
R2026 VPWR.n627 VPWR.n626 25.6005
R2027 VPWR.n626 VPWR.n623 25.6005
R2028 VPWR.n623 VPWR.n622 25.6005
R2029 VPWR.n622 VPWR.n619 25.6005
R2030 VPWR.n619 VPWR.n618 25.6005
R2031 VPWR.n618 VPWR.n615 25.6005
R2032 VPWR.n615 VPWR.n614 25.6005
R2033 VPWR.n614 VPWR.n611 25.6005
R2034 VPWR.n611 VPWR.n610 25.6005
R2035 VPWR.n610 VPWR.n607 25.6005
R2036 VPWR.n607 VPWR.n606 25.6005
R2037 VPWR.n606 VPWR.n603 25.6005
R2038 VPWR.n603 VPWR.n602 25.6005
R2039 VPWR.n602 VPWR.n599 25.6005
R2040 VPWR.n599 VPWR.n598 25.6005
R2041 VPWR.n598 VPWR.n595 25.6005
R2042 VPWR.n595 VPWR.n594 25.6005
R2043 VPWR.n594 VPWR.n591 25.6005
R2044 VPWR.n591 VPWR.n590 25.6005
R2045 VPWR.n590 VPWR.n587 25.6005
R2046 VPWR.n587 VPWR.n586 25.6005
R2047 VPWR.n586 VPWR.n583 25.6005
R2048 VPWR.n583 VPWR.n582 25.6005
R2049 VPWR.n582 VPWR.n579 25.6005
R2050 VPWR.n579 VPWR.n578 25.6005
R2051 VPWR.n578 VPWR.n575 25.6005
R2052 VPWR.n575 VPWR.n574 25.6005
R2053 VPWR.n574 VPWR.n571 25.6005
R2054 VPWR.n571 VPWR.n570 25.6005
R2055 VPWR.n570 VPWR.n567 25.6005
R2056 VPWR.n567 VPWR.n566 25.6005
R2057 VPWR.n566 VPWR.n563 25.6005
R2058 VPWR.n563 VPWR.n562 25.6005
R2059 VPWR.n562 VPWR.n559 25.6005
R2060 VPWR.n559 VPWR.n558 25.6005
R2061 VPWR.n558 VPWR.n555 25.6005
R2062 VPWR.n555 VPWR.n554 25.6005
R2063 VPWR.n554 VPWR.n551 25.6005
R2064 VPWR.n551 VPWR.n550 25.6005
R2065 VPWR.n550 VPWR.n547 25.6005
R2066 VPWR.n547 VPWR.n546 25.6005
R2067 VPWR.n546 VPWR.n543 25.6005
R2068 VPWR.n543 VPWR.n542 25.6005
R2069 VPWR.n542 VPWR.n539 25.6005
R2070 VPWR.n539 VPWR.n538 25.6005
R2071 VPWR.n498 VPWR.n335 25.6005
R2072 VPWR VPWR.n335 25.6005
R2073 VPWR VPWR.n663 25.6005
R2074 VPWR.n663 VPWR.n337 25.6005
R2075 VPWR.n742 VPWR.n676 25.6005
R2076 VPWR.n691 VPWR.n676 25.6005
R2077 VPWR.n692 VPWR.n691 25.6005
R2078 VPWR.n695 VPWR.n692 25.6005
R2079 VPWR.n696 VPWR.n695 25.6005
R2080 VPWR.n699 VPWR.n696 25.6005
R2081 VPWR.n700 VPWR.n699 25.6005
R2082 VPWR.n703 VPWR.n700 25.6005
R2083 VPWR.n704 VPWR.n703 25.6005
R2084 VPWR.n707 VPWR.n704 25.6005
R2085 VPWR.n708 VPWR.n707 25.6005
R2086 VPWR.n711 VPWR.n708 25.6005
R2087 VPWR.n712 VPWR.n711 25.6005
R2088 VPWR.n715 VPWR.n712 25.6005
R2089 VPWR.n716 VPWR.n715 25.6005
R2090 VPWR.n719 VPWR.n716 25.6005
R2091 VPWR.n720 VPWR.n719 25.6005
R2092 VPWR.n723 VPWR.n720 25.6005
R2093 VPWR.n724 VPWR.n723 25.6005
R2094 VPWR.n727 VPWR.n724 25.6005
R2095 VPWR.n728 VPWR.n727 25.6005
R2096 VPWR.n731 VPWR.n728 25.6005
R2097 VPWR.n733 VPWR.n731 25.6005
R2098 VPWR.n734 VPWR.n733 25.6005
R2099 VPWR.n735 VPWR.n734 25.6005
R2100 VPWR.n805 VPWR.n743 25.6005
R2101 VPWR.n804 VPWR.n803 25.6005
R2102 VPWR.n803 VPWR.n744 25.6005
R2103 VPWR.n798 VPWR.n744 25.6005
R2104 VPWR.n798 VPWR.n797 25.6005
R2105 VPWR.n797 VPWR.n746 25.6005
R2106 VPWR.n792 VPWR.n746 25.6005
R2107 VPWR.n792 VPWR.n791 25.6005
R2108 VPWR.n791 VPWR.n790 25.6005
R2109 VPWR.n790 VPWR.n748 25.6005
R2110 VPWR.n784 VPWR.n748 25.6005
R2111 VPWR.n784 VPWR.n783 25.6005
R2112 VPWR.n783 VPWR.n782 25.6005
R2113 VPWR.n782 VPWR.n750 25.6005
R2114 VPWR.n776 VPWR.n750 25.6005
R2115 VPWR.n776 VPWR.n775 25.6005
R2116 VPWR.n775 VPWR.n774 25.6005
R2117 VPWR.n774 VPWR.n752 25.6005
R2118 VPWR.n768 VPWR.n752 25.6005
R2119 VPWR.n768 VPWR.n767 25.6005
R2120 VPWR.n767 VPWR.n766 25.6005
R2121 VPWR.n766 VPWR.n754 25.6005
R2122 VPWR.n760 VPWR.n754 25.6005
R2123 VPWR.n760 VPWR.n759 25.6005
R2124 VPWR.n759 VPWR.n758 25.6005
R2125 VPWR.n758 VPWR.n670 25.6005
R2126 VPWR.n45 VPWR.n44 25.6005
R2127 VPWR.n48 VPWR.n45 25.6005
R2128 VPWR.n49 VPWR.n48 25.6005
R2129 VPWR.n52 VPWR.n49 25.6005
R2130 VPWR.n53 VPWR.n52 25.6005
R2131 VPWR.n56 VPWR.n53 25.6005
R2132 VPWR.n57 VPWR.n56 25.6005
R2133 VPWR.n60 VPWR.n57 25.6005
R2134 VPWR.n61 VPWR.n60 25.6005
R2135 VPWR.n64 VPWR.n61 25.6005
R2136 VPWR.n65 VPWR.n64 25.6005
R2137 VPWR.n68 VPWR.n65 25.6005
R2138 VPWR.n69 VPWR.n68 25.6005
R2139 VPWR.n72 VPWR.n69 25.6005
R2140 VPWR.n73 VPWR.n72 25.6005
R2141 VPWR.n76 VPWR.n73 25.6005
R2142 VPWR.n77 VPWR.n76 25.6005
R2143 VPWR.n80 VPWR.n77 25.6005
R2144 VPWR.n81 VPWR.n80 25.6005
R2145 VPWR.n84 VPWR.n81 25.6005
R2146 VPWR.n85 VPWR.n84 25.6005
R2147 VPWR.n88 VPWR.n85 25.6005
R2148 VPWR.n89 VPWR.n88 25.6005
R2149 VPWR.n92 VPWR.n89 25.6005
R2150 VPWR.n93 VPWR.n92 25.6005
R2151 VPWR.n96 VPWR.n93 25.6005
R2152 VPWR.n97 VPWR.n96 25.6005
R2153 VPWR.n100 VPWR.n97 25.6005
R2154 VPWR.n101 VPWR.n100 25.6005
R2155 VPWR.n104 VPWR.n101 25.6005
R2156 VPWR.n105 VPWR.n104 25.6005
R2157 VPWR.n108 VPWR.n105 25.6005
R2158 VPWR.n109 VPWR.n108 25.6005
R2159 VPWR.n112 VPWR.n109 25.6005
R2160 VPWR.n113 VPWR.n112 25.6005
R2161 VPWR.n116 VPWR.n113 25.6005
R2162 VPWR.n117 VPWR.n116 25.6005
R2163 VPWR.n120 VPWR.n117 25.6005
R2164 VPWR.n121 VPWR.n120 25.6005
R2165 VPWR.n124 VPWR.n121 25.6005
R2166 VPWR.n125 VPWR.n124 25.6005
R2167 VPWR.n128 VPWR.n125 25.6005
R2168 VPWR.n129 VPWR.n128 25.6005
R2169 VPWR.n132 VPWR.n129 25.6005
R2170 VPWR.n133 VPWR.n132 25.6005
R2171 VPWR.n136 VPWR.n133 25.6005
R2172 VPWR.n137 VPWR.n136 25.6005
R2173 VPWR.n140 VPWR.n137 25.6005
R2174 VPWR.n141 VPWR.n140 25.6005
R2175 VPWR.n144 VPWR.n141 25.6005
R2176 VPWR.n145 VPWR.n144 25.6005
R2177 VPWR.n148 VPWR.n145 25.6005
R2178 VPWR.n149 VPWR.n148 25.6005
R2179 VPWR.n152 VPWR.n149 25.6005
R2180 VPWR.n154 VPWR.n152 25.6005
R2181 VPWR.n155 VPWR.n154 25.6005
R2182 VPWR.n156 VPWR.n155 25.6005
R2183 VPWR.n156 VPWR.n12 25.6005
R2184 VPWR.n162 VPWR.n12 25.6005
R2185 VPWR.n163 VPWR.n162 25.6005
R2186 VPWR.n169 VPWR.n8 25.6005
R2187 VPWR.n170 VPWR.n169 25.6005
R2188 VPWR.n325 VPWR.n170 25.6005
R2189 VPWR.n325 VPWR.n324 25.6005
R2190 VPWR.n323 VPWR.n171 25.6005
R2191 VPWR.n318 VPWR.n171 25.6005
R2192 VPWR.n318 VPWR.n317 25.6005
R2193 VPWR.n317 VPWR.n316 25.6005
R2194 VPWR.n316 VPWR.n313 25.6005
R2195 VPWR.n313 VPWR.n312 25.6005
R2196 VPWR.n312 VPWR.n309 25.6005
R2197 VPWR.n309 VPWR.n308 25.6005
R2198 VPWR.n308 VPWR.n305 25.6005
R2199 VPWR.n305 VPWR.n304 25.6005
R2200 VPWR.n304 VPWR.n301 25.6005
R2201 VPWR.n301 VPWR.n300 25.6005
R2202 VPWR.n300 VPWR.n297 25.6005
R2203 VPWR.n297 VPWR.n296 25.6005
R2204 VPWR.n296 VPWR.n293 25.6005
R2205 VPWR.n293 VPWR.n292 25.6005
R2206 VPWR.n292 VPWR.n289 25.6005
R2207 VPWR.n289 VPWR.n288 25.6005
R2208 VPWR.n288 VPWR.n285 25.6005
R2209 VPWR.n285 VPWR.n284 25.6005
R2210 VPWR.n284 VPWR.n281 25.6005
R2211 VPWR.n281 VPWR.n280 25.6005
R2212 VPWR.n280 VPWR.n277 25.6005
R2213 VPWR.n277 VPWR.n276 25.6005
R2214 VPWR.n276 VPWR.n273 25.6005
R2215 VPWR.n273 VPWR.n272 25.6005
R2216 VPWR.n272 VPWR.n269 25.6005
R2217 VPWR.n269 VPWR.n268 25.6005
R2218 VPWR.n268 VPWR.n265 25.6005
R2219 VPWR.n265 VPWR.n264 25.6005
R2220 VPWR.n264 VPWR.n261 25.6005
R2221 VPWR.n261 VPWR.n260 25.6005
R2222 VPWR.n260 VPWR.n257 25.6005
R2223 VPWR.n257 VPWR.n256 25.6005
R2224 VPWR.n256 VPWR.n253 25.6005
R2225 VPWR.n253 VPWR.n252 25.6005
R2226 VPWR.n252 VPWR.n249 25.6005
R2227 VPWR.n249 VPWR.n248 25.6005
R2228 VPWR.n248 VPWR.n245 25.6005
R2229 VPWR.n245 VPWR.n244 25.6005
R2230 VPWR.n244 VPWR.n241 25.6005
R2231 VPWR.n241 VPWR.n240 25.6005
R2232 VPWR.n240 VPWR.n237 25.6005
R2233 VPWR.n237 VPWR.n236 25.6005
R2234 VPWR.n236 VPWR.n233 25.6005
R2235 VPWR.n233 VPWR.n232 25.6005
R2236 VPWR.n232 VPWR.n229 25.6005
R2237 VPWR.n229 VPWR.n228 25.6005
R2238 VPWR.n228 VPWR.n225 25.6005
R2239 VPWR.n225 VPWR.n224 25.6005
R2240 VPWR.n224 VPWR.n221 25.6005
R2241 VPWR.n221 VPWR.n220 25.6005
R2242 VPWR.n220 VPWR.n217 25.6005
R2243 VPWR.n217 VPWR.n216 25.6005
R2244 VPWR.n216 VPWR.n213 25.6005
R2245 VPWR.n213 VPWR.n212 25.6005
R2246 VPWR.n212 VPWR.n209 25.6005
R2247 VPWR.n209 VPWR.n208 25.6005
R2248 VPWR.n208 VPWR.n205 25.6005
R2249 VPWR.n205 VPWR.n204 25.6005
R2250 VPWR.n164 VPWR.n1 25.6005
R2251 VPWR VPWR.n1 25.6005
R2252 VPWR VPWR.n329 25.6005
R2253 VPWR.n329 VPWR.n3 25.6005
R2254 VPWR.n493 VPWR.n344 22.905
R2255 VPWR.n654 VPWR.n339 22.905
R2256 VPWR.n159 VPWR.n10 22.905
R2257 VPWR.n320 VPWR.n5 22.905
R2258 VPWR.n332 VPWR 22.8553
R2259 VPWR.n666 VPWR 22.8553
R2260 VPWR.n810 VPWR 20.9483
R2261 VPWR VPWR.n0 20.2395
R2262 VPWR.n664 VPWR 18.865
R2263 VPWR.n330 VPWR 18.865
R2264 VPWR VPWR.n813 17.9488
R2265 VPWR.n738 VPWR.t0 15.8494
R2266 VPWR.n807 VPWR.t0 15.8494
R2267 VPWR.n501 VPWR.n344 14.5566
R2268 VPWR.n501 VPWR.t2 14.5566
R2269 VPWR.n661 VPWR.t2 14.5566
R2270 VPWR.n661 VPWR.n339 14.5566
R2271 VPWR.n167 VPWR.n10 14.5566
R2272 VPWR.n167 VPWR.t4 14.5566
R2273 VPWR.n327 VPWR.t4 14.5566
R2274 VPWR.n327 VPWR.n5 14.5566
R2275 VPWR.n811 VPWR.n810 14.0449
R2276 VPWR.n334 VPWR.n333 13.6031
R2277 VPWR.n668 VPWR.n667 13.6031
R2278 VPWR VPWR.n669 12.8005
R2279 VPWR VPWR.n809 12.8005
R2280 VPWR.n333 VPWR.n332 11.4361
R2281 VPWR.n667 VPWR.n666 11.4361
R2282 VPWR VPWR.n331 4.87707
R2283 VPWR VPWR.n665 4.87707
R2284 VPWR.n812 VPWR.t1 3.57113
R2285 VPWR.n333 VPWR.n331 2.44078
R2286 VPWR.n667 VPWR.n665 2.44078
R2287 VPWR.n813 VPWR.n811 2.38164
R2288 VPWR.n330 VPWR 2.24827
R2289 VPWR.n810 VPWR.n668 1.65549
R2290 VPWR.n664 VPWR.n334 0.78305
R2291 VPWR.n811 VPWR.n0 0.71089
R2292 VPWR.n668 VPWR.n664 0.12975
R2293 VPWR.n334 VPWR.n330 0.12975
C27 OUT VGND 6.18849f
C28 BIAS VGND 4.93242f
C29 INN VGND 1.68213f
C30 INP VGND 1.55504f
C31 VPWR VGND 32.30439f
C32 PREAMP__TAIL VGND 7.08905f $ **FLOATING
C33 PRE VGND 8.82241f $ **FLOATING
C34 PREAMP__MIR VGND 6.11882f $ **FLOATING
C35 VPWR.n0 VGND 0.01497f $ **FLOATING
C36 VPWR.n1 VGND 0.00232f $ **FLOATING
C37 VPWR.n2 VGND 0.00232f $ **FLOATING
C38 VPWR.n3 VGND 0.00513f $ **FLOATING
C39 VPWR.n4 VGND 0.00513f $ **FLOATING
C40 VPWR.t4 VGND 0.3025f $ **FLOATING
C41 VPWR.n5 VGND 0.38925f $ **FLOATING
C42 VPWR.n6 VGND 0.00232f $ **FLOATING
C43 VPWR.n7 VGND 0.00513f $ **FLOATING
C44 VPWR.n8 VGND 0.00513f $ **FLOATING
C45 VPWR.n9 VGND 0.00513f $ **FLOATING
C46 VPWR.n10 VGND 0.38925f $ **FLOATING
C47 VPWR.n11 VGND 0.00513f $ **FLOATING
C48 VPWR.n12 VGND 0.00232f $ **FLOATING
C49 VPWR.n13 VGND 0.00232f $ **FLOATING
C50 VPWR.n42 VGND 0.00232f $ **FLOATING
C51 VPWR.n43 VGND 0.00513f $ **FLOATING
C52 VPWR.n44 VGND 0.00513f $ **FLOATING
C53 VPWR.n45 VGND 0.00232f $ **FLOATING
C54 VPWR.n46 VGND 0.00232f $ **FLOATING
C55 VPWR.n47 VGND 0.00232f $ **FLOATING
C56 VPWR.n48 VGND 0.00232f $ **FLOATING
C57 VPWR.n49 VGND 0.00232f $ **FLOATING
C58 VPWR.n50 VGND 0.00232f $ **FLOATING
C59 VPWR.n51 VGND 0.00232f $ **FLOATING
C60 VPWR.n52 VGND 0.00232f $ **FLOATING
C61 VPWR.n53 VGND 0.00232f $ **FLOATING
C62 VPWR.n54 VGND 0.00232f $ **FLOATING
C63 VPWR.n55 VGND 0.00232f $ **FLOATING
C64 VPWR.n56 VGND 0.00232f $ **FLOATING
C65 VPWR.n57 VGND 0.00232f $ **FLOATING
C66 VPWR.n58 VGND 0.00232f $ **FLOATING
C67 VPWR.n59 VGND 0.00232f $ **FLOATING
C68 VPWR.n60 VGND 0.00232f $ **FLOATING
C69 VPWR.n61 VGND 0.00232f $ **FLOATING
C70 VPWR.n62 VGND 0.00232f $ **FLOATING
C71 VPWR.n63 VGND 0.00232f $ **FLOATING
C72 VPWR.n64 VGND 0.00232f $ **FLOATING
C73 VPWR.n65 VGND 0.00232f $ **FLOATING
C74 VPWR.n66 VGND 0.00232f $ **FLOATING
C75 VPWR.n67 VGND 0.00232f $ **FLOATING
C76 VPWR.n68 VGND 0.00232f $ **FLOATING
C77 VPWR.n69 VGND 0.00232f $ **FLOATING
C78 VPWR.n70 VGND 0.00232f $ **FLOATING
C79 VPWR.n71 VGND 0.00232f $ **FLOATING
C80 VPWR.n72 VGND 0.00232f $ **FLOATING
C81 VPWR.n73 VGND 0.00232f $ **FLOATING
C82 VPWR.n74 VGND 0.00232f $ **FLOATING
C83 VPWR.n75 VGND 0.00232f $ **FLOATING
C84 VPWR.n76 VGND 0.00232f $ **FLOATING
C85 VPWR.n77 VGND 0.00232f $ **FLOATING
C86 VPWR.n78 VGND 0.00232f $ **FLOATING
C87 VPWR.n79 VGND 0.00232f $ **FLOATING
C88 VPWR.n80 VGND 0.00232f $ **FLOATING
C89 VPWR.n81 VGND 0.00232f $ **FLOATING
C90 VPWR.n82 VGND 0.00232f $ **FLOATING
C91 VPWR.n83 VGND 0.00232f $ **FLOATING
C92 VPWR.n84 VGND 0.00232f $ **FLOATING
C93 VPWR.n85 VGND 0.00232f $ **FLOATING
C94 VPWR.n86 VGND 0.00232f $ **FLOATING
C95 VPWR.n87 VGND 0.00232f $ **FLOATING
C96 VPWR.n88 VGND 0.00232f $ **FLOATING
C97 VPWR.n89 VGND 0.00232f $ **FLOATING
C98 VPWR.n90 VGND 0.00232f $ **FLOATING
C99 VPWR.n91 VGND 0.00232f $ **FLOATING
C100 VPWR.n92 VGND 0.00232f $ **FLOATING
C101 VPWR.n93 VGND 0.00232f $ **FLOATING
C102 VPWR.n94 VGND 0.00232f $ **FLOATING
C103 VPWR.n95 VGND 0.00232f $ **FLOATING
C104 VPWR.n96 VGND 0.00232f $ **FLOATING
C105 VPWR.n97 VGND 0.00232f $ **FLOATING
C106 VPWR.n98 VGND 0.00232f $ **FLOATING
C107 VPWR.n99 VGND 0.00232f $ **FLOATING
C108 VPWR.n100 VGND 0.00232f $ **FLOATING
C109 VPWR.n101 VGND 0.00232f $ **FLOATING
C110 VPWR.n102 VGND 0.00232f $ **FLOATING
C111 VPWR.n103 VGND 0.00232f $ **FLOATING
C112 VPWR.n104 VGND 0.00232f $ **FLOATING
C113 VPWR.n105 VGND 0.00232f $ **FLOATING
C114 VPWR.n106 VGND 0.00232f $ **FLOATING
C115 VPWR.n107 VGND 0.00232f $ **FLOATING
C116 VPWR.n108 VGND 0.00232f $ **FLOATING
C117 VPWR.n109 VGND 0.00232f $ **FLOATING
C118 VPWR.n110 VGND 0.00232f $ **FLOATING
C119 VPWR.n111 VGND 0.00232f $ **FLOATING
C120 VPWR.n112 VGND 0.00232f $ **FLOATING
C121 VPWR.n113 VGND 0.00232f $ **FLOATING
C122 VPWR.n114 VGND 0.00232f $ **FLOATING
C123 VPWR.n115 VGND 0.00232f $ **FLOATING
C124 VPWR.n116 VGND 0.00232f $ **FLOATING
C125 VPWR.n117 VGND 0.00232f $ **FLOATING
C126 VPWR.n118 VGND 0.00232f $ **FLOATING
C127 VPWR.n119 VGND 0.00232f $ **FLOATING
C128 VPWR.n120 VGND 0.00232f $ **FLOATING
C129 VPWR.n121 VGND 0.00232f $ **FLOATING
C130 VPWR.n122 VGND 0.00232f $ **FLOATING
C131 VPWR.n123 VGND 0.00232f $ **FLOATING
C132 VPWR.n124 VGND 0.00232f $ **FLOATING
C133 VPWR.n125 VGND 0.00232f $ **FLOATING
C134 VPWR.n126 VGND 0.00232f $ **FLOATING
C135 VPWR.n127 VGND 0.00232f $ **FLOATING
C136 VPWR.n128 VGND 0.00232f $ **FLOATING
C137 VPWR.n129 VGND 0.00232f $ **FLOATING
C138 VPWR.n130 VGND 0.00232f $ **FLOATING
C139 VPWR.n131 VGND 0.00232f $ **FLOATING
C140 VPWR.n132 VGND 0.00232f $ **FLOATING
C141 VPWR.n133 VGND 0.00232f $ **FLOATING
C142 VPWR.n134 VGND 0.00232f $ **FLOATING
C143 VPWR.n135 VGND 0.00232f $ **FLOATING
C144 VPWR.n136 VGND 0.00232f $ **FLOATING
C145 VPWR.n137 VGND 0.00232f $ **FLOATING
C146 VPWR.n138 VGND 0.00232f $ **FLOATING
C147 VPWR.n139 VGND 0.00232f $ **FLOATING
C148 VPWR.n140 VGND 0.00232f $ **FLOATING
C149 VPWR.n141 VGND 0.00232f $ **FLOATING
C150 VPWR.n142 VGND 0.00232f $ **FLOATING
C151 VPWR.n143 VGND 0.00232f $ **FLOATING
C152 VPWR.n144 VGND 0.00232f $ **FLOATING
C153 VPWR.n145 VGND 0.00232f $ **FLOATING
C154 VPWR.n146 VGND 0.00232f $ **FLOATING
C155 VPWR.n147 VGND 0.00232f $ **FLOATING
C156 VPWR.n148 VGND 0.00232f $ **FLOATING
C157 VPWR.n149 VGND 0.00232f $ **FLOATING
C158 VPWR.n150 VGND 0.00232f $ **FLOATING
C159 VPWR.n151 VGND 0.00232f $ **FLOATING
C160 VPWR.n152 VGND 0.00232f $ **FLOATING
C161 VPWR.n153 VGND 0.00232f $ **FLOATING
C162 VPWR.n154 VGND 0.00232f $ **FLOATING
C163 VPWR.n155 VGND 0.00232f $ **FLOATING
C164 VPWR.n156 VGND 0.00232f $ **FLOATING
C165 VPWR.n157 VGND 0.00232f $ **FLOATING
C166 VPWR.n159 VGND 0.47377f $ **FLOATING
C167 VPWR.n161 VGND 0.00232f $ **FLOATING
C168 VPWR.n162 VGND 0.00232f $ **FLOATING
C169 VPWR.n163 VGND 0.00513f $ **FLOATING
C170 VPWR.n164 VGND 0.00513f $ **FLOATING
C171 VPWR.n165 VGND 0.00513f $ **FLOATING
C172 VPWR.n166 VGND 0.00232f $ **FLOATING
C173 VPWR.n167 VGND 0.3025f $ **FLOATING
C174 VPWR.n168 VGND 0.00232f $ **FLOATING
C175 VPWR.n169 VGND 0.00232f $ **FLOATING
C176 VPWR.n170 VGND 0.00232f $ **FLOATING
C177 VPWR.n171 VGND 0.00232f $ **FLOATING
C178 VPWR.n172 VGND 0.00232f $ **FLOATING
C179 VPWR.n202 VGND 0.00232f $ **FLOATING
C180 VPWR.n203 VGND 0.00513f $ **FLOATING
C181 VPWR.n204 VGND 0.00513f $ **FLOATING
C182 VPWR.n205 VGND 0.00232f $ **FLOATING
C183 VPWR.n206 VGND 0.00232f $ **FLOATING
C184 VPWR.n207 VGND 0.00232f $ **FLOATING
C185 VPWR.n208 VGND 0.00232f $ **FLOATING
C186 VPWR.n209 VGND 0.00232f $ **FLOATING
C187 VPWR.n210 VGND 0.00232f $ **FLOATING
C188 VPWR.n211 VGND 0.00232f $ **FLOATING
C189 VPWR.n212 VGND 0.00232f $ **FLOATING
C190 VPWR.n213 VGND 0.00232f $ **FLOATING
C191 VPWR.n214 VGND 0.00232f $ **FLOATING
C192 VPWR.n215 VGND 0.00232f $ **FLOATING
C193 VPWR.n216 VGND 0.00232f $ **FLOATING
C194 VPWR.n217 VGND 0.00232f $ **FLOATING
C195 VPWR.n218 VGND 0.00232f $ **FLOATING
C196 VPWR.n219 VGND 0.00232f $ **FLOATING
C197 VPWR.n220 VGND 0.00232f $ **FLOATING
C198 VPWR.n221 VGND 0.00232f $ **FLOATING
C199 VPWR.n222 VGND 0.00232f $ **FLOATING
C200 VPWR.n223 VGND 0.00232f $ **FLOATING
C201 VPWR.n224 VGND 0.00232f $ **FLOATING
C202 VPWR.n225 VGND 0.00232f $ **FLOATING
C203 VPWR.n226 VGND 0.00232f $ **FLOATING
C204 VPWR.n227 VGND 0.00232f $ **FLOATING
C205 VPWR.n228 VGND 0.00232f $ **FLOATING
C206 VPWR.n229 VGND 0.00232f $ **FLOATING
C207 VPWR.n230 VGND 0.00232f $ **FLOATING
C208 VPWR.n231 VGND 0.00232f $ **FLOATING
C209 VPWR.n232 VGND 0.00232f $ **FLOATING
C210 VPWR.n233 VGND 0.00232f $ **FLOATING
C211 VPWR.n234 VGND 0.00232f $ **FLOATING
C212 VPWR.n235 VGND 0.00232f $ **FLOATING
C213 VPWR.n236 VGND 0.00232f $ **FLOATING
C214 VPWR.n237 VGND 0.00232f $ **FLOATING
C215 VPWR.n238 VGND 0.00232f $ **FLOATING
C216 VPWR.n239 VGND 0.00232f $ **FLOATING
C217 VPWR.n240 VGND 0.00232f $ **FLOATING
C218 VPWR.n241 VGND 0.00232f $ **FLOATING
C219 VPWR.n242 VGND 0.00232f $ **FLOATING
C220 VPWR.n243 VGND 0.00232f $ **FLOATING
C221 VPWR.n244 VGND 0.00232f $ **FLOATING
C222 VPWR.n245 VGND 0.00232f $ **FLOATING
C223 VPWR.n246 VGND 0.00232f $ **FLOATING
C224 VPWR.n247 VGND 0.00232f $ **FLOATING
C225 VPWR.n248 VGND 0.00232f $ **FLOATING
C226 VPWR.n249 VGND 0.00232f $ **FLOATING
C227 VPWR.n250 VGND 0.00232f $ **FLOATING
C228 VPWR.n251 VGND 0.00232f $ **FLOATING
C229 VPWR.n252 VGND 0.00232f $ **FLOATING
C230 VPWR.n253 VGND 0.00232f $ **FLOATING
C231 VPWR.n254 VGND 0.00232f $ **FLOATING
C232 VPWR.n255 VGND 0.00232f $ **FLOATING
C233 VPWR.n256 VGND 0.00232f $ **FLOATING
C234 VPWR.n257 VGND 0.00232f $ **FLOATING
C235 VPWR.n258 VGND 0.00232f $ **FLOATING
C236 VPWR.n259 VGND 0.00232f $ **FLOATING
C237 VPWR.n260 VGND 0.00232f $ **FLOATING
C238 VPWR.n261 VGND 0.00232f $ **FLOATING
C239 VPWR.n262 VGND 0.00232f $ **FLOATING
C240 VPWR.n263 VGND 0.00232f $ **FLOATING
C241 VPWR.n264 VGND 0.00232f $ **FLOATING
C242 VPWR.n265 VGND 0.00232f $ **FLOATING
C243 VPWR.n266 VGND 0.00232f $ **FLOATING
C244 VPWR.n267 VGND 0.00232f $ **FLOATING
C245 VPWR.n268 VGND 0.00232f $ **FLOATING
C246 VPWR.n269 VGND 0.00232f $ **FLOATING
C247 VPWR.n270 VGND 0.00232f $ **FLOATING
C248 VPWR.n271 VGND 0.00232f $ **FLOATING
C249 VPWR.n272 VGND 0.00232f $ **FLOATING
C250 VPWR.n273 VGND 0.00232f $ **FLOATING
C251 VPWR.n274 VGND 0.00232f $ **FLOATING
C252 VPWR.n275 VGND 0.00232f $ **FLOATING
C253 VPWR.n276 VGND 0.00232f $ **FLOATING
C254 VPWR.n277 VGND 0.00232f $ **FLOATING
C255 VPWR.n278 VGND 0.00232f $ **FLOATING
C256 VPWR.n279 VGND 0.00232f $ **FLOATING
C257 VPWR.n280 VGND 0.00232f $ **FLOATING
C258 VPWR.n281 VGND 0.00232f $ **FLOATING
C259 VPWR.n282 VGND 0.00232f $ **FLOATING
C260 VPWR.n283 VGND 0.00232f $ **FLOATING
C261 VPWR.n284 VGND 0.00232f $ **FLOATING
C262 VPWR.n285 VGND 0.00232f $ **FLOATING
C263 VPWR.n286 VGND 0.00232f $ **FLOATING
C264 VPWR.n287 VGND 0.00232f $ **FLOATING
C265 VPWR.n288 VGND 0.00232f $ **FLOATING
C266 VPWR.n289 VGND 0.00232f $ **FLOATING
C267 VPWR.n290 VGND 0.00232f $ **FLOATING
C268 VPWR.n291 VGND 0.00232f $ **FLOATING
C269 VPWR.n292 VGND 0.00232f $ **FLOATING
C270 VPWR.n293 VGND 0.00232f $ **FLOATING
C271 VPWR.n294 VGND 0.00232f $ **FLOATING
C272 VPWR.n295 VGND 0.00232f $ **FLOATING
C273 VPWR.n296 VGND 0.00232f $ **FLOATING
C274 VPWR.n297 VGND 0.00232f $ **FLOATING
C275 VPWR.n298 VGND 0.00232f $ **FLOATING
C276 VPWR.n299 VGND 0.00232f $ **FLOATING
C277 VPWR.n300 VGND 0.00232f $ **FLOATING
C278 VPWR.n301 VGND 0.00232f $ **FLOATING
C279 VPWR.n302 VGND 0.00232f $ **FLOATING
C280 VPWR.n303 VGND 0.00232f $ **FLOATING
C281 VPWR.n304 VGND 0.00232f $ **FLOATING
C282 VPWR.n305 VGND 0.00232f $ **FLOATING
C283 VPWR.n306 VGND 0.00232f $ **FLOATING
C284 VPWR.n307 VGND 0.00232f $ **FLOATING
C285 VPWR.n308 VGND 0.00232f $ **FLOATING
C286 VPWR.n309 VGND 0.00232f $ **FLOATING
C287 VPWR.n310 VGND 0.00232f $ **FLOATING
C288 VPWR.n311 VGND 0.00232f $ **FLOATING
C289 VPWR.n312 VGND 0.00232f $ **FLOATING
C290 VPWR.n313 VGND 0.00232f $ **FLOATING
C291 VPWR.n314 VGND 0.00232f $ **FLOATING
C292 VPWR.n315 VGND 0.00232f $ **FLOATING
C293 VPWR.n316 VGND 0.00232f $ **FLOATING
C294 VPWR.n317 VGND 0.00232f $ **FLOATING
C295 VPWR.n318 VGND 0.00232f $ **FLOATING
C296 VPWR.n319 VGND 0.00232f $ **FLOATING
C297 VPWR.n320 VGND 0.47377f $ **FLOATING
C298 VPWR.n322 VGND 0.00513f $ **FLOATING
C299 VPWR.n323 VGND 0.00513f $ **FLOATING
C300 VPWR.n324 VGND 0.00513f $ **FLOATING
C301 VPWR.n325 VGND 0.00232f $ **FLOATING
C302 VPWR.n326 VGND 0.00232f $ **FLOATING
C303 VPWR.n327 VGND 0.3025f $ **FLOATING
C304 VPWR.n328 VGND 0.00232f $ **FLOATING
C305 VPWR.n329 VGND 0.00232f $ **FLOATING
C306 VPWR.n330 VGND 0.22194f $ **FLOATING
C307 VPWR.n331 VGND 0.0107f $ **FLOATING
C308 VPWR.t5 VGND 0.01302f $ **FLOATING
C309 VPWR.n332 VGND 0.01087f $ **FLOATING
C310 VPWR.n333 VGND 0.62369f $ **FLOATING
C311 VPWR.n334 VGND 0.18885f $ **FLOATING
C312 VPWR.n335 VGND 0.00232f $ **FLOATING
C313 VPWR.n336 VGND 0.00232f $ **FLOATING
C314 VPWR.n337 VGND 0.00513f $ **FLOATING
C315 VPWR.n338 VGND 0.00513f $ **FLOATING
C316 VPWR.t2 VGND 0.3025f $ **FLOATING
C317 VPWR.n339 VGND 0.38925f $ **FLOATING
C318 VPWR.n340 VGND 0.00232f $ **FLOATING
C319 VPWR.n341 VGND 0.00513f $ **FLOATING
C320 VPWR.n342 VGND 0.00513f $ **FLOATING
C321 VPWR.n343 VGND 0.00513f $ **FLOATING
C322 VPWR.n344 VGND 0.38925f $ **FLOATING
C323 VPWR.n345 VGND 0.00513f $ **FLOATING
C324 VPWR.n346 VGND 0.00232f $ **FLOATING
C325 VPWR.n347 VGND 0.00232f $ **FLOATING
C326 VPWR.n376 VGND 0.00232f $ **FLOATING
C327 VPWR.n377 VGND 0.00513f $ **FLOATING
C328 VPWR.n378 VGND 0.00513f $ **FLOATING
C329 VPWR.n379 VGND 0.00232f $ **FLOATING
C330 VPWR.n380 VGND 0.00232f $ **FLOATING
C331 VPWR.n381 VGND 0.00232f $ **FLOATING
C332 VPWR.n382 VGND 0.00232f $ **FLOATING
C333 VPWR.n383 VGND 0.00232f $ **FLOATING
C334 VPWR.n384 VGND 0.00232f $ **FLOATING
C335 VPWR.n385 VGND 0.00232f $ **FLOATING
C336 VPWR.n386 VGND 0.00232f $ **FLOATING
C337 VPWR.n387 VGND 0.00232f $ **FLOATING
C338 VPWR.n388 VGND 0.00232f $ **FLOATING
C339 VPWR.n389 VGND 0.00232f $ **FLOATING
C340 VPWR.n390 VGND 0.00232f $ **FLOATING
C341 VPWR.n391 VGND 0.00232f $ **FLOATING
C342 VPWR.n392 VGND 0.00232f $ **FLOATING
C343 VPWR.n393 VGND 0.00232f $ **FLOATING
C344 VPWR.n394 VGND 0.00232f $ **FLOATING
C345 VPWR.n395 VGND 0.00232f $ **FLOATING
C346 VPWR.n396 VGND 0.00232f $ **FLOATING
C347 VPWR.n397 VGND 0.00232f $ **FLOATING
C348 VPWR.n398 VGND 0.00232f $ **FLOATING
C349 VPWR.n399 VGND 0.00232f $ **FLOATING
C350 VPWR.n400 VGND 0.00232f $ **FLOATING
C351 VPWR.n401 VGND 0.00232f $ **FLOATING
C352 VPWR.n402 VGND 0.00232f $ **FLOATING
C353 VPWR.n403 VGND 0.00232f $ **FLOATING
C354 VPWR.n404 VGND 0.00232f $ **FLOATING
C355 VPWR.n405 VGND 0.00232f $ **FLOATING
C356 VPWR.n406 VGND 0.00232f $ **FLOATING
C357 VPWR.n407 VGND 0.00232f $ **FLOATING
C358 VPWR.n408 VGND 0.00232f $ **FLOATING
C359 VPWR.n409 VGND 0.00232f $ **FLOATING
C360 VPWR.n410 VGND 0.00232f $ **FLOATING
C361 VPWR.n411 VGND 0.00232f $ **FLOATING
C362 VPWR.n412 VGND 0.00232f $ **FLOATING
C363 VPWR.n413 VGND 0.00232f $ **FLOATING
C364 VPWR.n414 VGND 0.00232f $ **FLOATING
C365 VPWR.n415 VGND 0.00232f $ **FLOATING
C366 VPWR.n416 VGND 0.00232f $ **FLOATING
C367 VPWR.n417 VGND 0.00232f $ **FLOATING
C368 VPWR.n418 VGND 0.00232f $ **FLOATING
C369 VPWR.n419 VGND 0.00232f $ **FLOATING
C370 VPWR.n420 VGND 0.00232f $ **FLOATING
C371 VPWR.n421 VGND 0.00232f $ **FLOATING
C372 VPWR.n422 VGND 0.00232f $ **FLOATING
C373 VPWR.n423 VGND 0.00232f $ **FLOATING
C374 VPWR.n424 VGND 0.00232f $ **FLOATING
C375 VPWR.n425 VGND 0.00232f $ **FLOATING
C376 VPWR.n426 VGND 0.00232f $ **FLOATING
C377 VPWR.n427 VGND 0.00232f $ **FLOATING
C378 VPWR.n428 VGND 0.00232f $ **FLOATING
C379 VPWR.n429 VGND 0.00232f $ **FLOATING
C380 VPWR.n430 VGND 0.00232f $ **FLOATING
C381 VPWR.n431 VGND 0.00232f $ **FLOATING
C382 VPWR.n432 VGND 0.00232f $ **FLOATING
C383 VPWR.n433 VGND 0.00232f $ **FLOATING
C384 VPWR.n434 VGND 0.00232f $ **FLOATING
C385 VPWR.n435 VGND 0.00232f $ **FLOATING
C386 VPWR.n436 VGND 0.00232f $ **FLOATING
C387 VPWR.n437 VGND 0.00232f $ **FLOATING
C388 VPWR.n438 VGND 0.00232f $ **FLOATING
C389 VPWR.n439 VGND 0.00232f $ **FLOATING
C390 VPWR.n440 VGND 0.00232f $ **FLOATING
C391 VPWR.n441 VGND 0.00232f $ **FLOATING
C392 VPWR.n442 VGND 0.00232f $ **FLOATING
C393 VPWR.n443 VGND 0.00232f $ **FLOATING
C394 VPWR.n444 VGND 0.00232f $ **FLOATING
C395 VPWR.n445 VGND 0.00232f $ **FLOATING
C396 VPWR.n446 VGND 0.00232f $ **FLOATING
C397 VPWR.n447 VGND 0.00232f $ **FLOATING
C398 VPWR.n448 VGND 0.00232f $ **FLOATING
C399 VPWR.n449 VGND 0.00232f $ **FLOATING
C400 VPWR.n450 VGND 0.00232f $ **FLOATING
C401 VPWR.n451 VGND 0.00232f $ **FLOATING
C402 VPWR.n452 VGND 0.00232f $ **FLOATING
C403 VPWR.n453 VGND 0.00232f $ **FLOATING
C404 VPWR.n454 VGND 0.00232f $ **FLOATING
C405 VPWR.n455 VGND 0.00232f $ **FLOATING
C406 VPWR.n456 VGND 0.00232f $ **FLOATING
C407 VPWR.n457 VGND 0.00232f $ **FLOATING
C408 VPWR.n458 VGND 0.00232f $ **FLOATING
C409 VPWR.n459 VGND 0.00232f $ **FLOATING
C410 VPWR.n460 VGND 0.00232f $ **FLOATING
C411 VPWR.n461 VGND 0.00232f $ **FLOATING
C412 VPWR.n462 VGND 0.00232f $ **FLOATING
C413 VPWR.n463 VGND 0.00232f $ **FLOATING
C414 VPWR.n464 VGND 0.00232f $ **FLOATING
C415 VPWR.n465 VGND 0.00232f $ **FLOATING
C416 VPWR.n466 VGND 0.00232f $ **FLOATING
C417 VPWR.n467 VGND 0.00232f $ **FLOATING
C418 VPWR.n468 VGND 0.00232f $ **FLOATING
C419 VPWR.n469 VGND 0.00232f $ **FLOATING
C420 VPWR.n470 VGND 0.00232f $ **FLOATING
C421 VPWR.n471 VGND 0.00232f $ **FLOATING
C422 VPWR.n472 VGND 0.00232f $ **FLOATING
C423 VPWR.n473 VGND 0.00232f $ **FLOATING
C424 VPWR.n474 VGND 0.00232f $ **FLOATING
C425 VPWR.n475 VGND 0.00232f $ **FLOATING
C426 VPWR.n476 VGND 0.00232f $ **FLOATING
C427 VPWR.n477 VGND 0.00232f $ **FLOATING
C428 VPWR.n478 VGND 0.00232f $ **FLOATING
C429 VPWR.n479 VGND 0.00232f $ **FLOATING
C430 VPWR.n480 VGND 0.00232f $ **FLOATING
C431 VPWR.n481 VGND 0.00232f $ **FLOATING
C432 VPWR.n482 VGND 0.00232f $ **FLOATING
C433 VPWR.n483 VGND 0.00232f $ **FLOATING
C434 VPWR.n484 VGND 0.00232f $ **FLOATING
C435 VPWR.n485 VGND 0.00232f $ **FLOATING
C436 VPWR.n486 VGND 0.00232f $ **FLOATING
C437 VPWR.n487 VGND 0.00232f $ **FLOATING
C438 VPWR.n488 VGND 0.00232f $ **FLOATING
C439 VPWR.n489 VGND 0.00232f $ **FLOATING
C440 VPWR.n490 VGND 0.00232f $ **FLOATING
C441 VPWR.n491 VGND 0.00232f $ **FLOATING
C442 VPWR.n493 VGND 0.47377f $ **FLOATING
C443 VPWR.n495 VGND 0.00232f $ **FLOATING
C444 VPWR.n496 VGND 0.00232f $ **FLOATING
C445 VPWR.n497 VGND 0.00513f $ **FLOATING
C446 VPWR.n498 VGND 0.00513f $ **FLOATING
C447 VPWR.n499 VGND 0.00513f $ **FLOATING
C448 VPWR.n500 VGND 0.00232f $ **FLOATING
C449 VPWR.n501 VGND 0.3025f $ **FLOATING
C450 VPWR.n502 VGND 0.00232f $ **FLOATING
C451 VPWR.n503 VGND 0.00232f $ **FLOATING
C452 VPWR.n504 VGND 0.00232f $ **FLOATING
C453 VPWR.n505 VGND 0.00232f $ **FLOATING
C454 VPWR.n506 VGND 0.00232f $ **FLOATING
C455 VPWR.n536 VGND 0.00232f $ **FLOATING
C456 VPWR.n537 VGND 0.00513f $ **FLOATING
C457 VPWR.n538 VGND 0.00513f $ **FLOATING
C458 VPWR.n539 VGND 0.00232f $ **FLOATING
C459 VPWR.n540 VGND 0.00232f $ **FLOATING
C460 VPWR.n541 VGND 0.00232f $ **FLOATING
C461 VPWR.n542 VGND 0.00232f $ **FLOATING
C462 VPWR.n543 VGND 0.00232f $ **FLOATING
C463 VPWR.n544 VGND 0.00232f $ **FLOATING
C464 VPWR.n545 VGND 0.00232f $ **FLOATING
C465 VPWR.n546 VGND 0.00232f $ **FLOATING
C466 VPWR.n547 VGND 0.00232f $ **FLOATING
C467 VPWR.n548 VGND 0.00232f $ **FLOATING
C468 VPWR.n549 VGND 0.00232f $ **FLOATING
C469 VPWR.n550 VGND 0.00232f $ **FLOATING
C470 VPWR.n551 VGND 0.00232f $ **FLOATING
C471 VPWR.n552 VGND 0.00232f $ **FLOATING
C472 VPWR.n553 VGND 0.00232f $ **FLOATING
C473 VPWR.n554 VGND 0.00232f $ **FLOATING
C474 VPWR.n555 VGND 0.00232f $ **FLOATING
C475 VPWR.n556 VGND 0.00232f $ **FLOATING
C476 VPWR.n557 VGND 0.00232f $ **FLOATING
C477 VPWR.n558 VGND 0.00232f $ **FLOATING
C478 VPWR.n559 VGND 0.00232f $ **FLOATING
C479 VPWR.n560 VGND 0.00232f $ **FLOATING
C480 VPWR.n561 VGND 0.00232f $ **FLOATING
C481 VPWR.n562 VGND 0.00232f $ **FLOATING
C482 VPWR.n563 VGND 0.00232f $ **FLOATING
C483 VPWR.n564 VGND 0.00232f $ **FLOATING
C484 VPWR.n565 VGND 0.00232f $ **FLOATING
C485 VPWR.n566 VGND 0.00232f $ **FLOATING
C486 VPWR.n567 VGND 0.00232f $ **FLOATING
C487 VPWR.n568 VGND 0.00232f $ **FLOATING
C488 VPWR.n569 VGND 0.00232f $ **FLOATING
C489 VPWR.n570 VGND 0.00232f $ **FLOATING
C490 VPWR.n571 VGND 0.00232f $ **FLOATING
C491 VPWR.n572 VGND 0.00232f $ **FLOATING
C492 VPWR.n573 VGND 0.00232f $ **FLOATING
C493 VPWR.n574 VGND 0.00232f $ **FLOATING
C494 VPWR.n575 VGND 0.00232f $ **FLOATING
C495 VPWR.n576 VGND 0.00232f $ **FLOATING
C496 VPWR.n577 VGND 0.00232f $ **FLOATING
C497 VPWR.n578 VGND 0.00232f $ **FLOATING
C498 VPWR.n579 VGND 0.00232f $ **FLOATING
C499 VPWR.n580 VGND 0.00232f $ **FLOATING
C500 VPWR.n581 VGND 0.00232f $ **FLOATING
C501 VPWR.n582 VGND 0.00232f $ **FLOATING
C502 VPWR.n583 VGND 0.00232f $ **FLOATING
C503 VPWR.n584 VGND 0.00232f $ **FLOATING
C504 VPWR.n585 VGND 0.00232f $ **FLOATING
C505 VPWR.n586 VGND 0.00232f $ **FLOATING
C506 VPWR.n587 VGND 0.00232f $ **FLOATING
C507 VPWR.n588 VGND 0.00232f $ **FLOATING
C508 VPWR.n589 VGND 0.00232f $ **FLOATING
C509 VPWR.n590 VGND 0.00232f $ **FLOATING
C510 VPWR.n591 VGND 0.00232f $ **FLOATING
C511 VPWR.n592 VGND 0.00232f $ **FLOATING
C512 VPWR.n593 VGND 0.00232f $ **FLOATING
C513 VPWR.n594 VGND 0.00232f $ **FLOATING
C514 VPWR.n595 VGND 0.00232f $ **FLOATING
C515 VPWR.n596 VGND 0.00232f $ **FLOATING
C516 VPWR.n597 VGND 0.00232f $ **FLOATING
C517 VPWR.n598 VGND 0.00232f $ **FLOATING
C518 VPWR.n599 VGND 0.00232f $ **FLOATING
C519 VPWR.n600 VGND 0.00232f $ **FLOATING
C520 VPWR.n601 VGND 0.00232f $ **FLOATING
C521 VPWR.n602 VGND 0.00232f $ **FLOATING
C522 VPWR.n603 VGND 0.00232f $ **FLOATING
C523 VPWR.n604 VGND 0.00232f $ **FLOATING
C524 VPWR.n605 VGND 0.00232f $ **FLOATING
C525 VPWR.n606 VGND 0.00232f $ **FLOATING
C526 VPWR.n607 VGND 0.00232f $ **FLOATING
C527 VPWR.n608 VGND 0.00232f $ **FLOATING
C528 VPWR.n609 VGND 0.00232f $ **FLOATING
C529 VPWR.n610 VGND 0.00232f $ **FLOATING
C530 VPWR.n611 VGND 0.00232f $ **FLOATING
C531 VPWR.n612 VGND 0.00232f $ **FLOATING
C532 VPWR.n613 VGND 0.00232f $ **FLOATING
C533 VPWR.n614 VGND 0.00232f $ **FLOATING
C534 VPWR.n615 VGND 0.00232f $ **FLOATING
C535 VPWR.n616 VGND 0.00232f $ **FLOATING
C536 VPWR.n617 VGND 0.00232f $ **FLOATING
C537 VPWR.n618 VGND 0.00232f $ **FLOATING
C538 VPWR.n619 VGND 0.00232f $ **FLOATING
C539 VPWR.n620 VGND 0.00232f $ **FLOATING
C540 VPWR.n621 VGND 0.00232f $ **FLOATING
C541 VPWR.n622 VGND 0.00232f $ **FLOATING
C542 VPWR.n623 VGND 0.00232f $ **FLOATING
C543 VPWR.n624 VGND 0.00232f $ **FLOATING
C544 VPWR.n625 VGND 0.00232f $ **FLOATING
C545 VPWR.n626 VGND 0.00232f $ **FLOATING
C546 VPWR.n627 VGND 0.00232f $ **FLOATING
C547 VPWR.n628 VGND 0.00232f $ **FLOATING
C548 VPWR.n629 VGND 0.00232f $ **FLOATING
C549 VPWR.n630 VGND 0.00232f $ **FLOATING
C550 VPWR.n631 VGND 0.00232f $ **FLOATING
C551 VPWR.n632 VGND 0.00232f $ **FLOATING
C552 VPWR.n633 VGND 0.00232f $ **FLOATING
C553 VPWR.n634 VGND 0.00232f $ **FLOATING
C554 VPWR.n635 VGND 0.00232f $ **FLOATING
C555 VPWR.n636 VGND 0.00232f $ **FLOATING
C556 VPWR.n637 VGND 0.00232f $ **FLOATING
C557 VPWR.n638 VGND 0.00232f $ **FLOATING
C558 VPWR.n639 VGND 0.00232f $ **FLOATING
C559 VPWR.n640 VGND 0.00232f $ **FLOATING
C560 VPWR.n641 VGND 0.00232f $ **FLOATING
C561 VPWR.n642 VGND 0.00232f $ **FLOATING
C562 VPWR.n643 VGND 0.00232f $ **FLOATING
C563 VPWR.n644 VGND 0.00232f $ **FLOATING
C564 VPWR.n645 VGND 0.00232f $ **FLOATING
C565 VPWR.n646 VGND 0.00232f $ **FLOATING
C566 VPWR.n647 VGND 0.00232f $ **FLOATING
C567 VPWR.n648 VGND 0.00232f $ **FLOATING
C568 VPWR.n649 VGND 0.00232f $ **FLOATING
C569 VPWR.n650 VGND 0.00232f $ **FLOATING
C570 VPWR.n651 VGND 0.00232f $ **FLOATING
C571 VPWR.n652 VGND 0.00232f $ **FLOATING
C572 VPWR.n653 VGND 0.00232f $ **FLOATING
C573 VPWR.n654 VGND 0.47377f $ **FLOATING
C574 VPWR.n656 VGND 0.00513f $ **FLOATING
C575 VPWR.n657 VGND 0.00513f $ **FLOATING
C576 VPWR.n658 VGND 0.00513f $ **FLOATING
C577 VPWR.n659 VGND 0.00232f $ **FLOATING
C578 VPWR.n660 VGND 0.00232f $ **FLOATING
C579 VPWR.n661 VGND 0.3025f $ **FLOATING
C580 VPWR.n662 VGND 0.00232f $ **FLOATING
C581 VPWR.n663 VGND 0.00232f $ **FLOATING
C582 VPWR.n664 VGND 0.12195f $ **FLOATING
C583 VPWR.n665 VGND 0.0107f $ **FLOATING
C584 VPWR.t3 VGND 0.01302f $ **FLOATING
C585 VPWR.n666 VGND 0.01087f $ **FLOATING
C586 VPWR.n667 VGND 0.62369f $ **FLOATING
C587 VPWR.n668 VGND 0.24839f $ **FLOATING
C588 VPWR.n669 VGND 0.00464f $ **FLOATING
C589 VPWR.n670 VGND 0.00528f $ **FLOATING
C590 VPWR.n671 VGND 0.00522f $ **FLOATING
C591 VPWR.n672 VGND 0.00528f $ **FLOATING
C592 VPWR.t0 VGND 0.06946f $ **FLOATING
C593 VPWR.n673 VGND 0.23493f $ **FLOATING
C594 VPWR.n674 VGND 0.00522f $ **FLOATING
C595 VPWR.n675 VGND 0.00528f $ **FLOATING
C596 VPWR.n676 VGND 0.00232f $ **FLOATING
C597 VPWR.n677 VGND 0.00232f $ **FLOATING
C598 VPWR.n689 VGND 0.00232f $ **FLOATING
C599 VPWR.n690 VGND 0.00232f $ **FLOATING
C600 VPWR.n691 VGND 0.00232f $ **FLOATING
C601 VPWR.n692 VGND 0.00232f $ **FLOATING
C602 VPWR.n693 VGND 0.00232f $ **FLOATING
C603 VPWR.n694 VGND 0.00232f $ **FLOATING
C604 VPWR.n695 VGND 0.00232f $ **FLOATING
C605 VPWR.n696 VGND 0.00232f $ **FLOATING
C606 VPWR.n697 VGND 0.00232f $ **FLOATING
C607 VPWR.n698 VGND 0.00232f $ **FLOATING
C608 VPWR.n699 VGND 0.00232f $ **FLOATING
C609 VPWR.n700 VGND 0.00232f $ **FLOATING
C610 VPWR.n701 VGND 0.00232f $ **FLOATING
C611 VPWR.n702 VGND 0.00232f $ **FLOATING
C612 VPWR.n703 VGND 0.00232f $ **FLOATING
C613 VPWR.n704 VGND 0.00232f $ **FLOATING
C614 VPWR.n705 VGND 0.00232f $ **FLOATING
C615 VPWR.n706 VGND 0.00232f $ **FLOATING
C616 VPWR.n707 VGND 0.00232f $ **FLOATING
C617 VPWR.n708 VGND 0.00232f $ **FLOATING
C618 VPWR.n709 VGND 0.00232f $ **FLOATING
C619 VPWR.n710 VGND 0.00232f $ **FLOATING
C620 VPWR.n711 VGND 0.00232f $ **FLOATING
C621 VPWR.n712 VGND 0.00232f $ **FLOATING
C622 VPWR.n713 VGND 0.00232f $ **FLOATING
C623 VPWR.n714 VGND 0.00232f $ **FLOATING
C624 VPWR.n715 VGND 0.00232f $ **FLOATING
C625 VPWR.n716 VGND 0.00232f $ **FLOATING
C626 VPWR.n717 VGND 0.00232f $ **FLOATING
C627 VPWR.n718 VGND 0.00232f $ **FLOATING
C628 VPWR.n719 VGND 0.00232f $ **FLOATING
C629 VPWR.n720 VGND 0.00232f $ **FLOATING
C630 VPWR.n721 VGND 0.00232f $ **FLOATING
C631 VPWR.n722 VGND 0.00232f $ **FLOATING
C632 VPWR.n723 VGND 0.00232f $ **FLOATING
C633 VPWR.n724 VGND 0.00232f $ **FLOATING
C634 VPWR.n725 VGND 0.00232f $ **FLOATING
C635 VPWR.n726 VGND 0.00232f $ **FLOATING
C636 VPWR.n727 VGND 0.00232f $ **FLOATING
C637 VPWR.n728 VGND 0.00232f $ **FLOATING
C638 VPWR.n729 VGND 0.00232f $ **FLOATING
C639 VPWR.n730 VGND 0.00232f $ **FLOATING
C640 VPWR.n731 VGND 0.00232f $ **FLOATING
C641 VPWR.n732 VGND 0.00232f $ **FLOATING
C642 VPWR.n733 VGND 0.00232f $ **FLOATING
C643 VPWR.n734 VGND 0.00232f $ **FLOATING
C644 VPWR.n735 VGND 0.00528f $ **FLOATING
C645 VPWR.n736 VGND 0.00528f $ **FLOATING
C646 VPWR.n738 VGND 0.16139f $ **FLOATING
C647 VPWR.n739 VGND 0.23493f $ **FLOATING
C648 VPWR.n741 VGND 0.00528f $ **FLOATING
C649 VPWR.n742 VGND 0.00528f $ **FLOATING
C650 VPWR.n743 VGND 0.00522f $ **FLOATING
C651 VPWR.n744 VGND 0.00232f $ **FLOATING
C652 VPWR.n746 VGND 0.00232f $ **FLOATING
C653 VPWR.n747 VGND 0.00232f $ **FLOATING
C654 VPWR.n748 VGND 0.00232f $ **FLOATING
C655 VPWR.n749 VGND 0.00232f $ **FLOATING
C656 VPWR.n750 VGND 0.00232f $ **FLOATING
C657 VPWR.n751 VGND 0.00232f $ **FLOATING
C658 VPWR.n752 VGND 0.00232f $ **FLOATING
C659 VPWR.n753 VGND 0.00232f $ **FLOATING
C660 VPWR.n754 VGND 0.00232f $ **FLOATING
C661 VPWR.n755 VGND 0.00232f $ **FLOATING
C662 VPWR.n757 VGND 0.00232f $ **FLOATING
C663 VPWR.n758 VGND 0.00232f $ **FLOATING
C664 VPWR.n759 VGND 0.00232f $ **FLOATING
C665 VPWR.n760 VGND 0.00232f $ **FLOATING
C666 VPWR.n761 VGND 0.00232f $ **FLOATING
C667 VPWR.n763 VGND 0.00232f $ **FLOATING
C668 VPWR.n765 VGND 0.00232f $ **FLOATING
C669 VPWR.n766 VGND 0.00232f $ **FLOATING
C670 VPWR.n767 VGND 0.00232f $ **FLOATING
C671 VPWR.n768 VGND 0.00232f $ **FLOATING
C672 VPWR.n769 VGND 0.00232f $ **FLOATING
C673 VPWR.n771 VGND 0.00232f $ **FLOATING
C674 VPWR.n773 VGND 0.00232f $ **FLOATING
C675 VPWR.n774 VGND 0.00232f $ **FLOATING
C676 VPWR.n775 VGND 0.00232f $ **FLOATING
C677 VPWR.n776 VGND 0.00232f $ **FLOATING
C678 VPWR.n777 VGND 0.00232f $ **FLOATING
C679 VPWR.n779 VGND 0.00232f $ **FLOATING
C680 VPWR.n781 VGND 0.00232f $ **FLOATING
C681 VPWR.n782 VGND 0.00232f $ **FLOATING
C682 VPWR.n783 VGND 0.00232f $ **FLOATING
C683 VPWR.n784 VGND 0.00232f $ **FLOATING
C684 VPWR.n785 VGND 0.00232f $ **FLOATING
C685 VPWR.n787 VGND 0.00232f $ **FLOATING
C686 VPWR.n789 VGND 0.00232f $ **FLOATING
C687 VPWR.n790 VGND 0.00232f $ **FLOATING
C688 VPWR.n791 VGND 0.00232f $ **FLOATING
C689 VPWR.n792 VGND 0.00232f $ **FLOATING
C690 VPWR.n793 VGND 0.00232f $ **FLOATING
C691 VPWR.n795 VGND 0.00232f $ **FLOATING
C692 VPWR.n796 VGND 0.00232f $ **FLOATING
C693 VPWR.n797 VGND 0.00232f $ **FLOATING
C694 VPWR.n798 VGND 0.00232f $ **FLOATING
C695 VPWR.n799 VGND 0.00232f $ **FLOATING
C696 VPWR.n800 VGND 0.00232f $ **FLOATING
C697 VPWR.n802 VGND 0.00232f $ **FLOATING
C698 VPWR.n803 VGND 0.00232f $ **FLOATING
C699 VPWR.n804 VGND 0.00528f $ **FLOATING
C700 VPWR.n805 VGND 0.00522f $ **FLOATING
C701 VPWR.n806 VGND 0.00522f $ **FLOATING
C702 VPWR.n807 VGND 0.16139f $ **FLOATING
C703 VPWR.n808 VGND 0.00522f $ **FLOATING
C704 VPWR.n809 VGND 0.00464f $ **FLOATING
C705 VPWR.n810 VGND 0.38291f $ **FLOATING
C706 VPWR.n811 VGND 0.21315f $ **FLOATING
C707 VPWR.t1 VGND 0.02326f $ **FLOATING
C708 VPWR.n812 VGND 0.07208f $ **FLOATING
C709 VPWR.n813 VGND 0.00447f $ **FLOATING
C710 OUT.n0 VGND 0.02736f $ **FLOATING
C711 OUT.n1 VGND 0.07741f $ **FLOATING
C712 OUT.t1 VGND 0.12025f $ **FLOATING
C713 OUT.n2 VGND 0.3727f $ **FLOATING
C714 OUT.n3 VGND 0.02309f $ **FLOATING
C715 OUT.n4 VGND 1.16117f $ **FLOATING
C716 OUT.n5 VGND 3.76656f $ **FLOATING
C717 OUT.n6 VGND 0.95171f $ **FLOATING
C718 OUT.t0 VGND 0.06012f $ **FLOATING
C719 OUT.n7 VGND 0.18816f $ **FLOATING
C720 OUT.n8 VGND 0.00846f $ **FLOATING
C721 PRE.n0 VGND 0.01969f $ **FLOATING
C722 PRE.t2 VGND 0.08647f $ **FLOATING
C723 PRE.t3 VGND 0.15427f $ **FLOATING
C724 PRE.n1 VGND 2.41908f $ **FLOATING
C725 PRE.n2 VGND 0.03976f $ **FLOATING
C726 PRE.t1 VGND 0.04839f $ **FLOATING
C727 PRE.n3 VGND 0.04039f $ **FLOATING
C728 PRE.n4 VGND 2.39591f $ **FLOATING
C729 PRE.n5 VGND 2.90118f $ **FLOATING
C730 PRE.n6 VGND 1.13511f $ **FLOATING
C731 PRE.t0 VGND 0.10803f $ **FLOATING
C732 PRE.n7 VGND 0.36849f $ **FLOATING
C733 PRE.n8 VGND 0.06503f $ **FLOATING
C734 BIAS.t0 VGND 0.27875f $ **FLOATING
C735 PREAMP__TAIL.n0 VGND 0.00831f $ **FLOATING
C736 PREAMP__TAIL.n1 VGND 0.0089f $ **FLOATING
C737 PREAMP__TAIL.t2 VGND 0.01451f $ **FLOATING
C738 PREAMP__TAIL.n2 VGND 0.00858f $ **FLOATING
C739 PREAMP__TAIL.n3 VGND 0.34017f $ **FLOATING
C740 PREAMP__TAIL.n4 VGND 0.02584f $ **FLOATING
C741 PREAMP__TAIL.t1 VGND 0.04556f $ **FLOATING
C742 PREAMP__TAIL.n5 VGND 0.1554f $ **FLOATING
C743 PREAMP__TAIL.n6 VGND 0.00989f $ **FLOATING
C744 PREAMP__TAIL.n7 VGND 0.426f $ **FLOATING
C745 PREAMP__TAIL.n8 VGND 1.40798f $ **FLOATING
C746 PREAMP__TAIL.n9 VGND 0.40581f $ **FLOATING
C747 PREAMP__TAIL.t0 VGND 0.04556f $ **FLOATING
C748 PREAMP__TAIL.n10 VGND 0.1554f $ **FLOATING
C749 PREAMP__TAIL.n11 VGND 0.02742f $ **FLOATING
C750 PREAMP__MIR.n0 VGND 0.00833f $ **FLOATING
C751 PREAMP__MIR.t3 VGND 1.04143f $ **FLOATING
C752 PREAMP__MIR.t1 VGND 1.04143f $ **FLOATING
C753 PREAMP__MIR.n1 VGND 0.43357f $ **FLOATING
C754 PREAMP__MIR.n2 VGND 0.01682f $ **FLOATING
C755 PREAMP__MIR.t2 VGND 0.02047f $ **FLOATING
C756 PREAMP__MIR.n3 VGND 0.01709f $ **FLOATING
C757 PREAMP__MIR.n4 VGND 0.96255f $ **FLOATING
C758 PREAMP__MIR.n5 VGND 0.59176f $ **FLOATING
C759 PREAMP__MIR.n6 VGND 0.36186f $ **FLOATING
C760 PREAMP__MIR.t0 VGND 0.0457f $ **FLOATING
C761 PREAMP__MIR.n7 VGND 0.1559f $ **FLOATING
C762 PREAMP__MIR.n8 VGND 0.02751f $ **FLOATING
.ends

Resistor analog SoC soc_sensor_afe
.include "/workspace/.runtime/eda/runs/82b7e8a730af41bd94c909e28eb5c6e3/supported-tt.spice"
.options method=gear maxord=2
.include "/workspace/.runtime/eda/runs/82b7e8a730af41bd94c909e28eb5c6e3/current-probe.spice"
.temp 27.0
VGND VGND 0 0
VDD VPWR VGND 1.8
VIN VIN VGND DC 0.9 AC 1 SIN(0.9 0.025 5000)
VGAIN GAIN VGND PULSE(0 1.8 100u 2n 2n 1 2)
VCLK CLK VGND PULSE(0 1.8 250n 2n 2n 498n 1u)
VRESET RESET VGND PWL(0 1.8 5u 1.8 5.002u 0)
CLOAD OUT VGND 50f
.nodeset v(VCM)=0.9 v(OUT)=0.9
XU VIN GAIN CLK RESET OUT DATA VCM BIAS VPWR VGND soc_sensor_afe
.control
save v(OUT) i(VDD) v(VIN) v(GAIN) v(CLK) v(RESET) v(DATA) v(VCM) v(BIAS) i(v.xu.xbias_source.vregister_cf_11c943ab1f38f9d8) i(v.xu.xbias_source.vregister_cf_a977a4ed402b1f2c) i(v.xu.xbias_source.vregister_cf_2bb5df4ceb7170aa) i(v.xu.xbias_source.vregister_cf_75cf7e6789df38e5) i(v.xu.xbias_source.vregister_cf_a7caf04976bf19e0) i(v.xu.xbias_source.xvcm_buffer.vregister_cf_54f0040858166f9d) i(v.xu.xbias_source.xvcm_buffer.vregister_cf_9a9b80f42fc6e7ca) i(v.xu.xbias_source.xvcm_buffer.vregister_cf_5e86041922791634) i(v.xu.xbias_source.xvcm_buffer.vregister_cf_a901034b015257ed) i(v.xu.xbias_source.xvcm_buffer.xfirst.vregister_cf_44a7d6fa5e5059ca) i(v.xu.xbias_source.xvcm_buffer.xfirst.vregister_cf_59dd6b01ffe7cfb0) i(v.xu.xbias_source.xvcm_buffer.xfirst.vregister_cf_65e04b8a37108d24) i(v.xu.xbias_source.xvcm_buffer.xfirst.vregister_cf_bbed48e6e9d221df) i(v.xu.xbias_source.xvcm_buffer.xfirst.vregister_cf_0c41c8aa9e8c91bb) i(v.xu.xbias_source.xvcm_buffer.xfirst.vregister_cf_dee31e44c859f504) i(v.xu.xbias_source.xvcm_buffer.xfirst.vregister_cf_76752659b10f5142) i(v.xu.xcomparator.vregister_cf_20dcc8d7af24a4f7) i(v.xu.xcomparator.vregister_cf_b2327db240c1f8e8) i(v.xu.xcomparator.xpreamp.vregister_cf_f5e6bb569eae4e57) i(v.xu.xcomparator.xpreamp.vregister_cf_8dfc281901a76fd7) i(v.xu.xcomparator.xpreamp.vregister_cf_982336a84ede3d8c) i(v.xu.xcomparator.xpreamp.vregister_cf_fa301aca43866ffd) i(v.xu.xcomparator.xpreamp.vregister_cf_ba06122c33a0aac9) i(v.xu.xfilter.vregister_cf_9374be5899781063) i(v.xu.xfilter.vregister_cf_39c04da5432ef959) i(v.xu.xfilter.vregister_cf_b36236e90435ccd8) i(v.xu.xfilter.vregister_cf_903c32a535bb697f) i(v.xu.xfilter.xbuffer0.vregister_cf_54f0040858166f9d) i(v.xu.xfilter.xbuffer0.vregister_cf_9a9b80f42fc6e7ca) i(v.xu.xfilter.xbuffer0.vregister_cf_5e86041922791634) i(v.xu.xfilter.xbuffer0.vregister_cf_a901034b015257ed) i(v.xu.xfilter.xbuffer0.xfirst.vregister_cf_44a7d6fa5e5059ca) i(v.xu.xfilter.xbuffer0.xfirst.vregister_cf_59dd6b01ffe7cfb0) i(v.xu.xfilter.xbuffer0.xfirst.vregister_cf_65e04b8a37108d24) i(v.xu.xfilter.xbuffer0.xfirst.vregister_cf_bbed48e6e9d221df) i(v.xu.xfilter.xbuffer0.xfirst.vregister_cf_0c41c8aa9e8c91bb) i(v.xu.xfilter.xbuffer0.xfirst.vregister_cf_dee31e44c859f504) i(v.xu.xfilter.xbuffer0.xfirst.vregister_cf_76752659b10f5142) i(v.xu.xfilter.xbuffer1.vregister_cf_54f0040858166f9d) i(v.xu.xfilter.xbuffer1.vregister_cf_9a9b80f42fc6e7ca) i(v.xu.xfilter.xbuffer1.vregister_cf_5e86041922791634) i(v.xu.xfilter.xbuffer1.vregister_cf_a901034b015257ed) i(v.xu.xfilter.xbuffer1.xfirst.vregister_cf_44a7d6fa5e5059ca) i(v.xu.xfilter.xbuffer1.xfirst.vregister_cf_59dd6b01ffe7cfb0) i(v.xu.xfilter.xbuffer1.xfirst.vregister_cf_65e04b8a37108d24) i(v.xu.xfilter.xbuffer1.xfirst.vregister_cf_bbed48e6e9d221df) i(v.xu.xfilter.xbuffer1.xfirst.vregister_cf_0c41c8aa9e8c91bb) i(v.xu.xfilter.xbuffer1.xfirst.vregister_cf_dee31e44c859f504) i(v.xu.xfilter.xbuffer1.xfirst.vregister_cf_76752659b10f5142) i(v.xu.xpga.vregister_cf_396c97f6815217b7) i(v.xu.xpga.vregister_cf_58a90f8abcf17bdb) i(v.xu.xpga.vregister_cf_59c8c4c927c8fe6a) i(v.xu.xpga.vregister_cf_58071531a6efd575) i(v.xu.xpga.xgain2.vregister_cf_c6be1d2e3dfe1517) i(v.xu.xpga.xgain2.vregister_cf_338a38f16827216e) i(v.xu.xpga.xgain2.xamp.vregister_cf_54f0040858166f9d) i(VGND) i(VIN) i(VGAIN) i(VCLK) i(VRESET) v(XU.XBIAS_SOURCE.VCM_RAW) v(VGND) v(VPWR) v(XU.XBIAS_SOURCE.XVCM_BUFFER.PRE) v(XU.XBIAS_SOURCE.XVCM_BUFFER.COMP) v(XU.XBIAS_SOURCE.XVCM_BUFFER.XFIRST.MIR) v(XU.XBIAS_SOURCE.XVCM_BUFFER.XFIRST.TAIL) v(XU.CMP) v(XU.XCOMPARATOR.PRE) v(XU.XCOMPARATOR.XPREAMP.MIR) v(XU.XCOMPARATOR.XPREAMP.TAIL) v(XU.XFILTER.FILTER0) v(XU.XFILTER.FILTER1) v(XU.AMPLIFIED) v(XU.XFILTER.MID) v(XU.XFILTER.XBUFFER0.PRE) v(XU.XFILTER.XBUFFER0.COMP) v(XU.XFILTER.XBUFFER0.XFIRST.MIR) v(XU.XFILTER.XBUFFER0.XFIRST.TAIL) v(XU.XFILTER.XBUFFER1.PRE) v(XU.XFILTER.XBUFFER1.COMP) v(XU.XFILTER.XBUFFER1.XFIRST.MIR) v(XU.XFILTER.XBUFFER1.XFIRST.TAIL) v(XU.XPGA.V8) v(XU.XPGA.SELECTED) v(XU.XPGA.V2) v(XU.XPGA.GAINB) v(XU.XPGA.XGAIN2.FB) v(XU.XPGA.XGAIN2.XAMP.PRE) v(XU.XPGA.XGAIN2.XAMP.COMP)
set num_threads=1
set numdgt=17
set wr_singlescale
set wr_vecnames
set noaskquit
tran 2e-08 0.0002
let mos_wave_0 = v(OUT)
let mos_wave_1 = -i(VDD)
let mos_wave_2 = v(VIN)
let mos_wave_3 = v(GAIN)
let mos_wave_4 = v(CLK)
let mos_wave_5 = v(RESET)
let mos_wave_6 = v(DATA)
let mos_wave_7 = v(VCM)
let mos_wave_8 = v(BIAS)
wrdata waveform.dat mos_wave_0 mos_wave_1 mos_wave_2 mos_wave_3 mos_wave_4 mos_wave_5 mos_wave_6 mos_wave_7 mos_wave_8
write waveform.raw all
let register_flow_0 = i(v.xu.xbias_source.vregister_cf_11c943ab1f38f9d8)
let register_flow_1 = i(v.xu.xbias_source.vregister_cf_a977a4ed402b1f2c)
let register_flow_2 = i(v.xu.xbias_source.vregister_cf_2bb5df4ceb7170aa)
let register_flow_3 = i(v.xu.xbias_source.vregister_cf_75cf7e6789df38e5)
let register_flow_4 = i(v.xu.xbias_source.vregister_cf_a7caf04976bf19e0)
let register_flow_5 = i(v.xu.xbias_source.xvcm_buffer.vregister_cf_54f0040858166f9d)
let register_flow_6 = i(v.xu.xbias_source.xvcm_buffer.vregister_cf_9a9b80f42fc6e7ca)
let register_flow_7 = i(v.xu.xbias_source.xvcm_buffer.vregister_cf_5e86041922791634)
let register_flow_8 = i(v.xu.xbias_source.xvcm_buffer.vregister_cf_a901034b015257ed)
let register_flow_9 = i(v.xu.xbias_source.xvcm_buffer.xfirst.vregister_cf_44a7d6fa5e5059ca)
let register_flow_10 = i(v.xu.xbias_source.xvcm_buffer.xfirst.vregister_cf_59dd6b01ffe7cfb0)
let register_flow_11 = i(v.xu.xbias_source.xvcm_buffer.xfirst.vregister_cf_65e04b8a37108d24)
let register_flow_12 = i(v.xu.xbias_source.xvcm_buffer.xfirst.vregister_cf_bbed48e6e9d221df)
let register_flow_13 = i(v.xu.xbias_source.xvcm_buffer.xfirst.vregister_cf_0c41c8aa9e8c91bb)
let register_flow_14 = i(v.xu.xbias_source.xvcm_buffer.xfirst.vregister_cf_dee31e44c859f504)
let register_flow_15 = i(v.xu.xbias_source.xvcm_buffer.xfirst.vregister_cf_76752659b10f5142)
let register_flow_16 = i(v.xu.xcomparator.vregister_cf_20dcc8d7af24a4f7)
let register_flow_17 = i(v.xu.xcomparator.vregister_cf_b2327db240c1f8e8)
let register_flow_18 = i(v.xu.xcomparator.xpreamp.vregister_cf_f5e6bb569eae4e57)
let register_flow_19 = i(v.xu.xcomparator.xpreamp.vregister_cf_8dfc281901a76fd7)
let register_flow_20 = i(v.xu.xcomparator.xpreamp.vregister_cf_982336a84ede3d8c)
let register_flow_21 = i(v.xu.xcomparator.xpreamp.vregister_cf_fa301aca43866ffd)
let register_flow_22 = i(v.xu.xcomparator.xpreamp.vregister_cf_ba06122c33a0aac9)
let register_flow_23 = i(v.xu.xfilter.vregister_cf_9374be5899781063)
let register_flow_24 = i(v.xu.xfilter.vregister_cf_39c04da5432ef959)
let register_flow_25 = i(v.xu.xfilter.vregister_cf_b36236e90435ccd8)
let register_flow_26 = i(v.xu.xfilter.vregister_cf_903c32a535bb697f)
let register_flow_27 = i(v.xu.xfilter.xbuffer0.vregister_cf_54f0040858166f9d)
let register_flow_28 = i(v.xu.xfilter.xbuffer0.vregister_cf_9a9b80f42fc6e7ca)
let register_flow_29 = i(v.xu.xfilter.xbuffer0.vregister_cf_5e86041922791634)
let register_flow_30 = i(v.xu.xfilter.xbuffer0.vregister_cf_a901034b015257ed)
let register_flow_31 = i(v.xu.xfilter.xbuffer0.xfirst.vregister_cf_44a7d6fa5e5059ca)
let register_flow_32 = i(v.xu.xfilter.xbuffer0.xfirst.vregister_cf_59dd6b01ffe7cfb0)
let register_flow_33 = i(v.xu.xfilter.xbuffer0.xfirst.vregister_cf_65e04b8a37108d24)
let register_flow_34 = i(v.xu.xfilter.xbuffer0.xfirst.vregister_cf_bbed48e6e9d221df)
let register_flow_35 = i(v.xu.xfilter.xbuffer0.xfirst.vregister_cf_0c41c8aa9e8c91bb)
let register_flow_36 = i(v.xu.xfilter.xbuffer0.xfirst.vregister_cf_dee31e44c859f504)
let register_flow_37 = i(v.xu.xfilter.xbuffer0.xfirst.vregister_cf_76752659b10f5142)
let register_flow_38 = i(v.xu.xfilter.xbuffer1.vregister_cf_54f0040858166f9d)
let register_flow_39 = i(v.xu.xfilter.xbuffer1.vregister_cf_9a9b80f42fc6e7ca)
let register_flow_40 = i(v.xu.xfilter.xbuffer1.vregister_cf_5e86041922791634)
let register_flow_41 = i(v.xu.xfilter.xbuffer1.vregister_cf_a901034b015257ed)
let register_flow_42 = i(v.xu.xfilter.xbuffer1.xfirst.vregister_cf_44a7d6fa5e5059ca)
let register_flow_43 = i(v.xu.xfilter.xbuffer1.xfirst.vregister_cf_59dd6b01ffe7cfb0)
let register_flow_44 = i(v.xu.xfilter.xbuffer1.xfirst.vregister_cf_65e04b8a37108d24)
let register_flow_45 = i(v.xu.xfilter.xbuffer1.xfirst.vregister_cf_bbed48e6e9d221df)
let register_flow_46 = i(v.xu.xfilter.xbuffer1.xfirst.vregister_cf_0c41c8aa9e8c91bb)
let register_flow_47 = i(v.xu.xfilter.xbuffer1.xfirst.vregister_cf_dee31e44c859f504)
let register_flow_48 = i(v.xu.xfilter.xbuffer1.xfirst.vregister_cf_76752659b10f5142)
let register_flow_49 = i(v.xu.xpga.vregister_cf_396c97f6815217b7)
let register_flow_50 = i(v.xu.xpga.vregister_cf_58a90f8abcf17bdb)
let register_flow_51 = i(v.xu.xpga.vregister_cf_59c8c4c927c8fe6a)
let register_flow_52 = i(v.xu.xpga.vregister_cf_58071531a6efd575)
let register_flow_53 = i(v.xu.xpga.xgain2.vregister_cf_c6be1d2e3dfe1517)
let register_flow_54 = i(v.xu.xpga.xgain2.vregister_cf_338a38f16827216e)
let register_flow_55 = i(v.xu.xpga.xgain2.xamp.vregister_cf_54f0040858166f9d)
let register_flow_56 = i(VGND)
let register_flow_57 = i(VDD)
let register_flow_58 = i(VIN)
let register_flow_59 = i(VGAIN)
let register_flow_60 = i(VCLK)
let register_flow_61 = i(VRESET)
wrdata current-flow.dat register_flow_0 register_flow_1 register_flow_2 register_flow_3 register_flow_4 register_flow_5 register_flow_6 register_flow_7 register_flow_8 register_flow_9 register_flow_10 register_flow_11 register_flow_12 register_flow_13 register_flow_14 register_flow_15 register_flow_16 register_flow_17 register_flow_18 register_flow_19 register_flow_20 register_flow_21 register_flow_22 register_flow_23 register_flow_24 register_flow_25 register_flow_26 register_flow_27 register_flow_28 register_flow_29 register_flow_30 register_flow_31 register_flow_32 register_flow_33 register_flow_34 register_flow_35 register_flow_36 register_flow_37 register_flow_38 register_flow_39 register_flow_40 register_flow_41 register_flow_42 register_flow_43 register_flow_44 register_flow_45 register_flow_46 register_flow_47 register_flow_48 register_flow_49 register_flow_50 register_flow_51 register_flow_52 register_flow_53 register_flow_54 register_flow_55 register_flow_56 register_flow_57 register_flow_58 register_flow_59 register_flow_60 register_flow_61
let register_voltage_0 = v(XU.XBIAS_SOURCE.VCM_RAW)
let register_voltage_1 = v(VGND)
let register_voltage_2 = v(BIAS)
let register_voltage_3 = v(VPWR)
let register_voltage_4 = v(XU.XBIAS_SOURCE.XVCM_BUFFER.PRE)
let register_voltage_5 = v(XU.XBIAS_SOURCE.XVCM_BUFFER.COMP)
let register_voltage_6 = v(VCM)
let register_voltage_7 = v(XU.XBIAS_SOURCE.XVCM_BUFFER.XFIRST.MIR)
let register_voltage_8 = v(XU.XBIAS_SOURCE.XVCM_BUFFER.XFIRST.TAIL)
let register_voltage_9 = v(XU.CMP)
let register_voltage_10 = v(XU.XCOMPARATOR.PRE)
let register_voltage_11 = v(XU.XCOMPARATOR.XPREAMP.MIR)
let register_voltage_12 = v(XU.XCOMPARATOR.XPREAMP.TAIL)
let register_voltage_13 = v(OUT)
let register_voltage_14 = v(XU.XFILTER.FILTER0)
let register_voltage_15 = v(XU.XFILTER.FILTER1)
let register_voltage_16 = v(XU.AMPLIFIED)
let register_voltage_17 = v(XU.XFILTER.MID)
let register_voltage_18 = v(XU.XFILTER.XBUFFER0.PRE)
let register_voltage_19 = v(XU.XFILTER.XBUFFER0.COMP)
let register_voltage_20 = v(XU.XFILTER.XBUFFER0.XFIRST.MIR)
let register_voltage_21 = v(XU.XFILTER.XBUFFER0.XFIRST.TAIL)
let register_voltage_22 = v(XU.XFILTER.XBUFFER1.PRE)
let register_voltage_23 = v(XU.XFILTER.XBUFFER1.COMP)
let register_voltage_24 = v(XU.XFILTER.XBUFFER1.XFIRST.MIR)
let register_voltage_25 = v(XU.XFILTER.XBUFFER1.XFIRST.TAIL)
let register_voltage_26 = v(XU.XPGA.V8)
let register_voltage_27 = v(XU.XPGA.SELECTED)
let register_voltage_28 = v(GAIN)
let register_voltage_29 = v(XU.XPGA.V2)
let register_voltage_30 = v(XU.XPGA.GAINB)
let register_voltage_31 = v(XU.XPGA.XGAIN2.FB)
let register_voltage_32 = v(XU.XPGA.XGAIN2.XAMP.PRE)
let register_voltage_33 = v(XU.XPGA.XGAIN2.XAMP.COMP)
let register_voltage_34 = 0*register_flow_0
let register_voltage_35 = v(VIN)
let register_voltage_36 = v(CLK)
let register_voltage_37 = v(RESET)
wrdata node-voltages.dat register_voltage_0 register_voltage_1 register_voltage_2 register_voltage_3 register_voltage_4 register_voltage_5 register_voltage_6 register_voltage_7 register_voltage_8 register_voltage_9 register_voltage_10 register_voltage_11 register_voltage_12 register_voltage_13 register_voltage_14 register_voltage_15 register_voltage_16 register_voltage_17 register_voltage_18 register_voltage_19 register_voltage_20 register_voltage_21 register_voltage_22 register_voltage_23 register_voltage_24 register_voltage_25 register_voltage_26 register_voltage_27 register_voltage_28 register_voltage_29 register_voltage_30 register_voltage_31 register_voltage_32 register_voltage_33 register_voltage_34 register_voltage_35 register_voltage_36 register_voltage_37
quit
.endc
.end

* NGSPICE file created from cell_nor2.ext - technology: sky130A

.subckt cell_nor2 Y VPWR VGND B A
X0 register_cf_node_e04c4332effa44b9 A.t0 register_cf_node_e04c4332effa44b9_source VGND.t2 sky130_fd_pr__nfet_01v8 ad=0.1885 pd=1.88 as=0.1885 ps=1.88 w=0.65 l=0.15
Vregister_cf_e04c4332effa44b9 VGND.t3 register_cf_node_e04c4332effa44b9 0
Vregister_cf_e04c4332effa44b9_source Y.t2 register_cf_node_e04c4332effa44b9_source 0
X1 register_cf_node_3a52c45e6ae8d7e3 B.t0 register_cf_node_3a52c45e6ae8d7e3_source VGND.t0 sky130_fd_pr__nfet_01v8 ad=0.1885 pd=1.88 as=0.1885 ps=1.88 w=0.65 l=0.15
Vregister_cf_3a52c45e6ae8d7e3 VGND.t1 register_cf_node_3a52c45e6ae8d7e3 0
Vregister_cf_3a52c45e6ae8d7e3_source Y.t1 register_cf_node_3a52c45e6ae8d7e3_source 0
X2 register_cf_node_0944a8cd6e6c28dc B.t1 register_cf_node_0944a8cd6e6c28dc_source VPWR.t0 sky130_fd_pr__pfet_01v8_hvt ad=0.1885 pd=1.88 as=0.1885 ps=1.88 w=0.65 l=0.15
Vregister_cf_0944a8cd6e6c28dc N.t0 register_cf_node_0944a8cd6e6c28dc 0
Vregister_cf_0944a8cd6e6c28dc_source Y.t0 register_cf_node_0944a8cd6e6c28dc_source 0
X3 register_cf_node_da7cac648640c3f6 A.t1 register_cf_node_da7cac648640c3f6_source VPWR.t1 sky130_fd_pr__pfet_01v8_hvt ad=0.1885 pd=1.88 as=0.1885 ps=1.88 w=0.65 l=0.15
Vregister_cf_da7cac648640c3f6 VPWR.t2 register_cf_node_da7cac648640c3f6 0
Vregister_cf_da7cac648640c3f6_source N.t1 register_cf_node_da7cac648640c3f6_source 0
C0 Y B 2.48873f
C1 N A 1.66442f
C2 VPWR Y 0.15171f
C3 VPWR B 0.32156f
C4 Y A 2.25481f
C5 A B 0.27151f
C6 N Y 0.33489f
C7 VPWR A 0.42211f
C8 N B 0.51683f
C9 N VPWR 0.42312f
C10 Y VGND 2.79746f
C11 B VGND 4.24661f
C12 A VGND 2.67636f
C13 VPWR VGND 5.43412f
C14 N VGND 1.73972f $ **FLOATING
C15 B.t0 VGND 0.0203f $ **FLOATING
C16 B.t1 VGND 0.02109f $ **FLOATING
C17 B.n0 VGND 2.10484f $ **FLOATING
C18 Y.n0 VGND 0.01132f $ **FLOATING
C19 Y.t1 VGND 0.02754f $ **FLOATING
C20 Y.n1 VGND 0.01132f $ **FLOATING
C21 Y.n2 VGND 0.28673f $ **FLOATING
C22 Y.n3 VGND 0.01132f $ **FLOATING
C23 Y.t2 VGND 0.02754f $ **FLOATING
C24 Y.n4 VGND 0.01132f $ **FLOATING
C25 Y.n5 VGND 0.25397f $ **FLOATING
C26 Y.n6 VGND 1.68669f $ **FLOATING
C27 Y.n7 VGND 0.00991f $ **FLOATING
C28 Y.t0 VGND 0.03036f $ **FLOATING
C29 Y.n8 VGND 0.00991f $ **FLOATING
C30 Y.n9 VGND 0.25397f $ **FLOATING
C31 Y.n10 VGND 1.9134f $ **FLOATING
C32 A.t0 VGND 0.02329f $ **FLOATING
C33 A.t1 VGND 0.0242f $ **FLOATING
C34 A.n0 VGND 1.95424f $ **FLOATING
rmesh_equiv_0 a a.n0 3.8563397837893119
rmesh_equiv_1 a a.t0 315.88
rmesh_equiv_10 vgnd vgnd.t1 132.66274840232151
rmesh_equiv_11 vgnd vgnd.t2 197.24486192307512
rmesh_equiv_12 vgnd vgnd.t3 132.63878093725467
rmesh_equiv_13 vgnd.t0 vgnd.t2 4875.6602786888898
rmesh_equiv_14 vgnd.t1 vgnd.t3 76444.044314413171
rmesh_equiv_15 vpwr vpwr.t0 117.18187411979874
rmesh_equiv_16 vpwr vpwr.t1 117.18187411979875
rmesh_equiv_17 vpwr vpwr.t2 355.0129089747727
rmesh_equiv_18 y y.n0 12.8005
rmesh_equiv_19 y y.n1 12.8005
rmesh_equiv_2 a a.t1 330.34100000000001
rmesh_equiv_20 y y.n10 4.7864199999999997
rmesh_equiv_21 y y.n3 12.8005
rmesh_equiv_22 y y.n4 12.8005
rmesh_equiv_23 y y.n7 12.8005
rmesh_equiv_24 y y.n8 12.8005
rmesh_equiv_25 y.n0 y.n2 10.151300000000001
rmesh_equiv_26 y.n0 y.t1 255.34500000000003
rmesh_equiv_27 y.n1 y.n2 10.151300000000001
rmesh_equiv_28 y.n1 y.t1 255.34500000000003
rmesh_equiv_29 y.n10 y.n6 0.55314200000000002
rmesh_equiv_3 b b.n0 4.1125019013625499
rmesh_equiv_30 y.n10 y.n9 10.8688
rmesh_equiv_31 y.n2 y.n6 11.4171
rmesh_equiv_32 y.n3 y.n5 10.151300000000001
rmesh_equiv_33 y.n3 y.t2 255.34500000000003
rmesh_equiv_34 y.n4 y.n5 10.151300000000001
rmesh_equiv_35 y.n4 y.t2 255.34500000000003
rmesh_equiv_36 y.n5 y.n6 10.8688
rmesh_equiv_37 y.n7 y.n9 10.151300000000001
rmesh_equiv_38 y.n7 y.t0 700.48400000000004
rmesh_equiv_39 y.n8 y.n9 10.151300000000001
rmesh_equiv_4 b b.t0 315.88
rmesh_equiv_40 y.n8 y.t0 700.48400000000004
rmesh_equiv_5 b b.t1 330.34100000000001
rmesh_equiv_6 n n.t0 356.64225000000005
rmesh_equiv_7 n n.t1 356.64224999999999
rmesh_equiv_8 n.t0 n.t1 135186.72178377246
rmesh_equiv_9 vgnd vgnd.t0 197.24486192307509
.ends

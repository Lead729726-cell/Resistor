Register actual transistor digital adder16
.options klu noinit method=gear maxord=2
.include "/workspace/.runtime/eda/runs/996e56fa908c406fb1304bb4673c84a0/supported-tt.spice"
.option scale=1e-6
.include "/workspace/.runtime/eda/runs/996e56fa908c406fb1304bb4673c84a0/current-probe.spice"
.temp 27.0
VGND VGND 0 0
VDD VPWR VGND 1.8
VA0 A0 VGND PWL(0 0 2e-07 0 2.001e-07 1.8 6e-07 1.8 6.001e-07 0 9e-07 0 9.001e-07 1.8 1e-06 1.8 1.0001e-06 0 1.3e-06 0 1.3001e-06 1.8 1.5e-06 1.8 1.5001e-06 0 1.7e-06 0 1.7001e-06 1.8 1.9e-06 1.8 1.9001e-06 0 2.1e-06 0 2.1001e-06 1.8 2.3e-06 1.8 2.3001e-06 0 2.5e-06 0 2.5001e-06 1.8 2.7e-06 1.8 2.7001e-06 0 2.9e-06 0 2.9001e-06 1.8 3.1e-06 1.8 3.1001e-06 0 3.3e-06 0 3.3001e-06 1.8 3.5e-06 1.8 3.5001e-06 0 3.7e-06 0 3.7001e-06 1.8 3.9e-06 1.8 3.9001e-06 0 4.1e-06 0 4.1001e-06 1.8 4.3e-06 1.8 4.3001e-06 0 4.5e-06 0 4.5001e-06 1.8 4.7e-06 1.8 4.7001e-06 0 4.9e-06 0 4.9001e-06 1.8 5.1e-06 1.8 5.1001e-06 0 5.3e-06 0 5.3001e-06 1.8 5.5e-06 1.8 5.5001e-06 0 5.7e-06 0 5.7001e-06 1.8 5.9e-06 1.8 5.9001e-06 0 6.1e-06 0 6.1001e-06 1.8 6.3e-06 1.8 6.3001e-06 0 6.5e-06 0 6.5001e-06 1.8 6.7e-06 1.8 6.7001e-06 0 6.9e-06 0 6.9001e-06 1.8 7e-06 1.8)
VA1 A1 VGND PWL(0 0 2e-07 0 2.001e-07 1.8 6e-07 1.8 6.001e-07 0 7e-07 0 7.001e-07 1.8 9e-07 1.8 9.001e-07 0 1.1e-06 0 1.1001e-06 1.8 1.2e-06 1.8 1.2001e-06 0 1.7e-06 0 1.7001e-06 1.8 1.9e-06 1.8 1.9001e-06 0 2.1e-06 0 2.1001e-06 1.8 2.3e-06 1.8 2.3001e-06 0 2.5e-06 0 2.5001e-06 1.8 2.7e-06 1.8 2.7001e-06 0 2.9e-06 0 2.9001e-06 1.8 3.1e-06 1.8 3.1001e-06 0 3.3e-06 0 3.3001e-06 1.8 3.5e-06 1.8 3.5001e-06 0 3.7e-06 0 3.7001e-06 1.8 3.9e-06 1.8 3.9001e-06 0 4.1e-06 0 4.1001e-06 1.8 4.3e-06 1.8 4.3001e-06 0 4.5e-06 0 4.5001e-06 1.8 4.7e-06 1.8 4.7001e-06 0 4.9e-06 0 4.9001e-06 1.8 5.1e-06 1.8 5.1001e-06 0 5.3e-06 0 5.3001e-06 1.8 5.5e-06 1.8 5.5001e-06 0 5.7e-06 0 5.7001e-06 1.8 5.9e-06 1.8 5.9001e-06 0 6.1e-06 0 6.1001e-06 1.8 6.3e-06 1.8 6.3001e-06 0 6.5e-06 0 6.5001e-06 1.8 6.7e-06 1.8 6.7001e-06 0 6.9e-06 0 6.9001e-06 1.8 7e-06 1.8)
VA2 A2 VGND PWL(0 0 2e-07 0 2.001e-07 1.8 6e-07 1.8 6.001e-07 0 1.5e-06 0 1.5001e-06 1.8 1.6e-06 1.8 1.6001e-06 0 2.1e-06 0 2.1001e-06 1.8 2.3e-06 1.8 2.3001e-06 0 2.5e-06 0 2.5001e-06 1.8 2.7e-06 1.8 2.7001e-06 0 2.9e-06 0 2.9001e-06 1.8 3.1e-06 1.8 3.1001e-06 0 3.3e-06 0 3.3001e-06 1.8 3.5e-06 1.8 3.5001e-06 0 3.7e-06 0 3.7001e-06 1.8 3.9e-06 1.8 3.9001e-06 0 4.1e-06 0 4.1001e-06 1.8 4.3e-06 1.8 4.3001e-06 0 4.5e-06 0 4.5001e-06 1.8 4.7e-06 1.8 4.7001e-06 0 4.9e-06 0 4.9001e-06 1.8 5.1e-06 1.8 5.1001e-06 0 5.3e-06 0 5.3001e-06 1.8 5.5e-06 1.8 5.5001e-06 0 5.7e-06 0 5.7001e-06 1.8 5.9e-06 1.8 5.9001e-06 0 6.1e-06 0 6.1001e-06 1.8 6.3e-06 1.8 6.3001e-06 0 6.5e-06 0 6.5001e-06 1.8 6.7e-06 1.8 6.7001e-06 0 6.9e-06 0 6.9001e-06 1.8 7e-06 1.8)
VA3 A3 VGND PWL(0 0 2e-07 0 2.001e-07 1.8 6e-07 1.8 6.001e-07 0 7e-07 0 7.001e-07 1.8 9e-07 1.8 9.001e-07 0 1.9e-06 0 1.9001e-06 1.8 2e-06 1.8 2.0001e-06 0 2.5e-06 0 2.5001e-06 1.8 2.7e-06 1.8 2.7001e-06 0 2.9e-06 0 2.9001e-06 1.8 3.1e-06 1.8 3.1001e-06 0 3.3e-06 0 3.3001e-06 1.8 3.5e-06 1.8 3.5001e-06 0 3.7e-06 0 3.7001e-06 1.8 3.9e-06 1.8 3.9001e-06 0 4.1e-06 0 4.1001e-06 1.8 4.3e-06 1.8 4.3001e-06 0 4.5e-06 0 4.5001e-06 1.8 4.7e-06 1.8 4.7001e-06 0 4.9e-06 0 4.9001e-06 1.8 5.1e-06 1.8 5.1001e-06 0 5.3e-06 0 5.3001e-06 1.8 5.5e-06 1.8 5.5001e-06 0 5.7e-06 0 5.7001e-06 1.8 5.9e-06 1.8 5.9001e-06 0 6.1e-06 0 6.1001e-06 1.8 6.3e-06 1.8 6.3001e-06 0 6.5e-06 0 6.5001e-06 1.8 6.7e-06 1.8 6.7001e-06 0 6.9e-06 0 6.9001e-06 1.8 7e-06 1.8)
VA4 A4 VGND PWL(0 0 2e-07 0 2.001e-07 1.8 6e-07 1.8 6.001e-07 0 2.3e-06 0 2.3001e-06 1.8 2.4e-06 1.8 2.4001e-06 0 2.9e-06 0 2.9001e-06 1.8 3.1e-06 1.8 3.1001e-06 0 3.3e-06 0 3.3001e-06 1.8 3.5e-06 1.8 3.5001e-06 0 3.7e-06 0 3.7001e-06 1.8 3.9e-06 1.8 3.9001e-06 0 4.1e-06 0 4.1001e-06 1.8 4.3e-06 1.8 4.3001e-06 0 4.5e-06 0 4.5001e-06 1.8 4.7e-06 1.8 4.7001e-06 0 4.9e-06 0 4.9001e-06 1.8 5.1e-06 1.8 5.1001e-06 0 5.3e-06 0 5.3001e-06 1.8 5.5e-06 1.8 5.5001e-06 0 5.7e-06 0 5.7001e-06 1.8 5.9e-06 1.8 5.9001e-06 0 6.1e-06 0 6.1001e-06 1.8 6.3e-06 1.8 6.3001e-06 0 6.5e-06 0 6.5001e-06 1.8 6.7e-06 1.8 6.7001e-06 0 6.9e-06 0 6.9001e-06 1.8 7e-06 1.8)
VA5 A5 VGND PWL(0 0 2e-07 0 2.001e-07 1.8 6e-07 1.8 6.001e-07 0 7e-07 0 7.001e-07 1.8 9e-07 1.8 9.001e-07 0 2.7e-06 0 2.7001e-06 1.8 2.8e-06 1.8 2.8001e-06 0 3.3e-06 0 3.3001e-06 1.8 3.5e-06 1.8 3.5001e-06 0 3.7e-06 0 3.7001e-06 1.8 3.9e-06 1.8 3.9001e-06 0 4.1e-06 0 4.1001e-06 1.8 4.3e-06 1.8 4.3001e-06 0 4.5e-06 0 4.5001e-06 1.8 4.7e-06 1.8 4.7001e-06 0 4.9e-06 0 4.9001e-06 1.8 5.1e-06 1.8 5.1001e-06 0 5.3e-06 0 5.3001e-06 1.8 5.5e-06 1.8 5.5001e-06 0 5.7e-06 0 5.7001e-06 1.8 5.9e-06 1.8 5.9001e-06 0 6.1e-06 0 6.1001e-06 1.8 6.3e-06 1.8 6.3001e-06 0 6.5e-06 0 6.5001e-06 1.8 6.7e-06 1.8 6.7001e-06 0 6.9e-06 0 6.9001e-06 1.8 7e-06 1.8)
VA6 A6 VGND PWL(0 0 2e-07 0 2.001e-07 1.8 6e-07 1.8 6.001e-07 0 3.1e-06 0 3.1001e-06 1.8 3.2e-06 1.8 3.2001e-06 0 3.7e-06 0 3.7001e-06 1.8 3.9e-06 1.8 3.9001e-06 0 4.1e-06 0 4.1001e-06 1.8 4.3e-06 1.8 4.3001e-06 0 4.5e-06 0 4.5001e-06 1.8 4.7e-06 1.8 4.7001e-06 0 4.9e-06 0 4.9001e-06 1.8 5.1e-06 1.8 5.1001e-06 0 5.3e-06 0 5.3001e-06 1.8 5.5e-06 1.8 5.5001e-06 0 5.7e-06 0 5.7001e-06 1.8 5.9e-06 1.8 5.9001e-06 0 6.1e-06 0 6.1001e-06 1.8 6.3e-06 1.8 6.3001e-06 0 6.5e-06 0 6.5001e-06 1.8 6.7e-06 1.8 6.7001e-06 0 6.9e-06 0 6.9001e-06 1.8 7e-06 1.8)
VA7 A7 VGND PWL(0 0 2e-07 0 2.001e-07 1.8 6e-07 1.8 6.001e-07 0 7e-07 0 7.001e-07 1.8 9e-07 1.8 9.001e-07 0 3.5e-06 0 3.5001e-06 1.8 3.6e-06 1.8 3.6001e-06 0 4.1e-06 0 4.1001e-06 1.8 4.3e-06 1.8 4.3001e-06 0 4.5e-06 0 4.5001e-06 1.8 4.7e-06 1.8 4.7001e-06 0 4.9e-06 0 4.9001e-06 1.8 5.1e-06 1.8 5.1001e-06 0 5.3e-06 0 5.3001e-06 1.8 5.5e-06 1.8 5.5001e-06 0 5.7e-06 0 5.7001e-06 1.8 5.9e-06 1.8 5.9001e-06 0 6.1e-06 0 6.1001e-06 1.8 6.3e-06 1.8 6.3001e-06 0 6.5e-06 0 6.5001e-06 1.8 6.7e-06 1.8 6.7001e-06 0 6.9e-06 0 6.9001e-06 1.8 7e-06 1.8)
VA8 A8 VGND PWL(0 0 2e-07 0 2.001e-07 1.8 6e-07 1.8 6.001e-07 0 3.9e-06 0 3.9001e-06 1.8 4e-06 1.8 4.0001e-06 0 4.5e-06 0 4.5001e-06 1.8 4.7e-06 1.8 4.7001e-06 0 4.9e-06 0 4.9001e-06 1.8 5.1e-06 1.8 5.1001e-06 0 5.3e-06 0 5.3001e-06 1.8 5.5e-06 1.8 5.5001e-06 0 5.7e-06 0 5.7001e-06 1.8 5.9e-06 1.8 5.9001e-06 0 6.1e-06 0 6.1001e-06 1.8 6.3e-06 1.8 6.3001e-06 0 6.5e-06 0 6.5001e-06 1.8 6.7e-06 1.8 6.7001e-06 0 6.9e-06 0 6.9001e-06 1.8 7e-06 1.8)
VA9 A9 VGND PWL(0 0 2e-07 0 2.001e-07 1.8 6e-07 1.8 6.001e-07 0 7e-07 0 7.001e-07 1.8 9e-07 1.8 9.001e-07 0 4.3e-06 0 4.3001e-06 1.8 4.4e-06 1.8 4.4001e-06 0 4.9e-06 0 4.9001e-06 1.8 5.1e-06 1.8 5.1001e-06 0 5.3e-06 0 5.3001e-06 1.8 5.5e-06 1.8 5.5001e-06 0 5.7e-06 0 5.7001e-06 1.8 5.9e-06 1.8 5.9001e-06 0 6.1e-06 0 6.1001e-06 1.8 6.3e-06 1.8 6.3001e-06 0 6.5e-06 0 6.5001e-06 1.8 6.7e-06 1.8 6.7001e-06 0 6.9e-06 0 6.9001e-06 1.8 7e-06 1.8)
VA10 A10 VGND PWL(0 0 2e-07 0 2.001e-07 1.8 6e-07 1.8 6.001e-07 0 4.7e-06 0 4.7001e-06 1.8 4.8e-06 1.8 4.8001e-06 0 5.3e-06 0 5.3001e-06 1.8 5.5e-06 1.8 5.5001e-06 0 5.7e-06 0 5.7001e-06 1.8 5.9e-06 1.8 5.9001e-06 0 6.1e-06 0 6.1001e-06 1.8 6.3e-06 1.8 6.3001e-06 0 6.5e-06 0 6.5001e-06 1.8 6.7e-06 1.8 6.7001e-06 0 6.9e-06 0 6.9001e-06 1.8 7e-06 1.8)
VA11 A11 VGND PWL(0 0 2e-07 0 2.001e-07 1.8 6e-07 1.8 6.001e-07 0 7e-07 0 7.001e-07 1.8 9e-07 1.8 9.001e-07 0 5.1e-06 0 5.1001e-06 1.8 5.2e-06 1.8 5.2001e-06 0 5.7e-06 0 5.7001e-06 1.8 5.9e-06 1.8 5.9001e-06 0 6.1e-06 0 6.1001e-06 1.8 6.3e-06 1.8 6.3001e-06 0 6.5e-06 0 6.5001e-06 1.8 6.7e-06 1.8 6.7001e-06 0 6.9e-06 0 6.9001e-06 1.8 7e-06 1.8)
VA12 A12 VGND PWL(0 0 2e-07 0 2.001e-07 1.8 6e-07 1.8 6.001e-07 0 5.5e-06 0 5.5001e-06 1.8 5.6e-06 1.8 5.6001e-06 0 6.1e-06 0 6.1001e-06 1.8 6.3e-06 1.8 6.3001e-06 0 6.5e-06 0 6.5001e-06 1.8 6.7e-06 1.8 6.7001e-06 0 6.9e-06 0 6.9001e-06 1.8 7e-06 1.8)
VA13 A13 VGND PWL(0 0 2e-07 0 2.001e-07 1.8 6e-07 1.8 6.001e-07 0 7e-07 0 7.001e-07 1.8 9e-07 1.8 9.001e-07 0 5.9e-06 0 5.9001e-06 1.8 6e-06 1.8 6.0001e-06 0 6.5e-06 0 6.5001e-06 1.8 6.7e-06 1.8 6.7001e-06 0 6.9e-06 0 6.9001e-06 1.8 7e-06 1.8)
VA14 A14 VGND PWL(0 0 2e-07 0 2.001e-07 1.8 6e-07 1.8 6.001e-07 0 6.3e-06 0 6.3001e-06 1.8 6.4e-06 1.8 6.4001e-06 0 6.9e-06 0 6.9001e-06 1.8 7e-06 1.8)
VA15 A15 VGND PWL(0 0 2e-07 0 2.001e-07 1.8 5e-07 1.8 5.001e-07 0 6e-07 0 6.001e-07 1.8 9e-07 1.8 9.001e-07 0 6.7e-06 0 6.7001e-06 1.8 6.8e-06 1.8 6.8001e-06 0 7e-06 0)
VB0 B0 VGND PWL(0 0 3e-07 0 3.001e-07 1.8 6e-07 1.8 6.001e-07 0 7e-07 0 7.001e-07 1.8 9e-07 1.8 9.001e-07 0 1e-06 0 1.0001e-06 1.8 1.1e-06 1.8 1.1001e-06 0 1.4e-06 0 1.4001e-06 1.8 1.5e-06 1.8 1.5001e-06 0 1.8e-06 0 1.8001e-06 1.8 1.9e-06 1.8 1.9001e-06 0 2.2e-06 0 2.2001e-06 1.8 2.3e-06 1.8 2.3001e-06 0 2.6e-06 0 2.6001e-06 1.8 2.7e-06 1.8 2.7001e-06 0 3e-06 0 3.0001e-06 1.8 3.1e-06 1.8 3.1001e-06 0 3.4e-06 0 3.4001e-06 1.8 3.5e-06 1.8 3.5001e-06 0 3.8e-06 0 3.8001e-06 1.8 3.9e-06 1.8 3.9001e-06 0 4.2e-06 0 4.2001e-06 1.8 4.3e-06 1.8 4.3001e-06 0 4.6e-06 0 4.6001e-06 1.8 4.7e-06 1.8 4.7001e-06 0 5e-06 0 5.0001e-06 1.8 5.1e-06 1.8 5.1001e-06 0 5.4e-06 0 5.4001e-06 1.8 5.5e-06 1.8 5.5001e-06 0 5.8e-06 0 5.8001e-06 1.8 5.9e-06 1.8 5.9001e-06 0 6.2e-06 0 6.2001e-06 1.8 6.3e-06 1.8 6.3001e-06 0 6.6e-06 0 6.6001e-06 1.8 6.7e-06 1.8 6.7001e-06 0 7e-06 0)
VB1 B1 VGND PWL(0 0 3e-07 0 3.001e-07 1.8 5e-07 1.8 5.001e-07 0 1.2e-06 0 1.2001e-06 1.8 1.3e-06 1.8 1.3001e-06 0 7e-06 0)
VB2 B2 VGND PWL(0 0 3e-07 0 3.001e-07 1.8 5e-07 1.8 5.001e-07 0 7e-07 0 7.001e-07 1.8 9e-07 1.8 9.001e-07 0 1.6e-06 0 1.6001e-06 1.8 1.7e-06 1.8 1.7001e-06 0 7e-06 0)
VB3 B3 VGND PWL(0 0 3e-07 0 3.001e-07 1.8 5e-07 1.8 5.001e-07 0 2e-06 0 2.0001e-06 1.8 2.1e-06 1.8 2.1001e-06 0 7e-06 0)
VB4 B4 VGND PWL(0 0 3e-07 0 3.001e-07 1.8 5e-07 1.8 5.001e-07 0 7e-07 0 7.001e-07 1.8 9e-07 1.8 9.001e-07 0 2.4e-06 0 2.4001e-06 1.8 2.5e-06 1.8 2.5001e-06 0 7e-06 0)
VB5 B5 VGND PWL(0 0 3e-07 0 3.001e-07 1.8 5e-07 1.8 5.001e-07 0 2.8e-06 0 2.8001e-06 1.8 2.9e-06 1.8 2.9001e-06 0 7e-06 0)
VB6 B6 VGND PWL(0 0 3e-07 0 3.001e-07 1.8 5e-07 1.8 5.001e-07 0 7e-07 0 7.001e-07 1.8 9e-07 1.8 9.001e-07 0 3.2e-06 0 3.2001e-06 1.8 3.3e-06 1.8 3.3001e-06 0 7e-06 0)
VB7 B7 VGND PWL(0 0 3e-07 0 3.001e-07 1.8 5e-07 1.8 5.001e-07 0 3.6e-06 0 3.6001e-06 1.8 3.7e-06 1.8 3.7001e-06 0 7e-06 0)
VB8 B8 VGND PWL(0 0 3e-07 0 3.001e-07 1.8 5e-07 1.8 5.001e-07 0 7e-07 0 7.001e-07 1.8 9e-07 1.8 9.001e-07 0 4e-06 0 4.0001e-06 1.8 4.1e-06 1.8 4.1001e-06 0 7e-06 0)
VB9 B9 VGND PWL(0 0 3e-07 0 3.001e-07 1.8 5e-07 1.8 5.001e-07 0 4.4e-06 0 4.4001e-06 1.8 4.5e-06 1.8 4.5001e-06 0 7e-06 0)
VB10 B10 VGND PWL(0 0 3e-07 0 3.001e-07 1.8 5e-07 1.8 5.001e-07 0 7e-07 0 7.001e-07 1.8 9e-07 1.8 9.001e-07 0 4.8e-06 0 4.8001e-06 1.8 4.9e-06 1.8 4.9001e-06 0 7e-06 0)
VB11 B11 VGND PWL(0 0 3e-07 0 3.001e-07 1.8 5e-07 1.8 5.001e-07 0 5.2e-06 0 5.2001e-06 1.8 5.3e-06 1.8 5.3001e-06 0 7e-06 0)
VB12 B12 VGND PWL(0 0 3e-07 0 3.001e-07 1.8 5e-07 1.8 5.001e-07 0 7e-07 0 7.001e-07 1.8 9e-07 1.8 9.001e-07 0 5.6e-06 0 5.6001e-06 1.8 5.7e-06 1.8 5.7001e-06 0 7e-06 0)
VB13 B13 VGND PWL(0 0 3e-07 0 3.001e-07 1.8 5e-07 1.8 5.001e-07 0 6e-06 0 6.0001e-06 1.8 6.1e-06 1.8 6.1001e-06 0 7e-06 0)
VB14 B14 VGND PWL(0 0 3e-07 0 3.001e-07 1.8 5e-07 1.8 5.001e-07 0 7e-07 0 7.001e-07 1.8 9e-07 1.8 9.001e-07 0 6.4e-06 0 6.4001e-06 1.8 6.5e-06 1.8 6.5001e-06 0 7e-06 0)
VB15 B15 VGND PWL(0 0 3e-07 0 3.001e-07 1.8 5e-07 1.8 5.001e-07 0 6e-07 0 6.001e-07 1.8 7e-07 1.8 7.001e-07 0 6.8e-06 0 6.8001e-06 1.8 6.9e-06 1.8 6.9001e-06 0 7e-06 0)
VCIN CIN VGND PWL(0 0 1e-07 0 1.001e-07 1.8 3e-07 1.8 3.001e-07 0 4e-07 0 4.001e-07 1.8 5e-07 1.8 5.001e-07 0 8e-07 0 8.001e-07 1.8 9e-07 1.8 9.001e-07 0 1.3e-06 0 1.3001e-06 1.8 1.4e-06 1.8 1.4001e-06 0 1.7e-06 0 1.7001e-06 1.8 1.8e-06 1.8 1.8001e-06 0 2.1e-06 0 2.1001e-06 1.8 2.2e-06 1.8 2.2001e-06 0 2.5e-06 0 2.5001e-06 1.8 2.6e-06 1.8 2.6001e-06 0 2.9e-06 0 2.9001e-06 1.8 3e-06 1.8 3.0001e-06 0 3.3e-06 0 3.3001e-06 1.8 3.4e-06 1.8 3.4001e-06 0 3.7e-06 0 3.7001e-06 1.8 3.8e-06 1.8 3.8001e-06 0 4.1e-06 0 4.1001e-06 1.8 4.2e-06 1.8 4.2001e-06 0 4.5e-06 0 4.5001e-06 1.8 4.6e-06 1.8 4.6001e-06 0 4.9e-06 0 4.9001e-06 1.8 5e-06 1.8 5.0001e-06 0 5.3e-06 0 5.3001e-06 1.8 5.4e-06 1.8 5.4001e-06 0 5.7e-06 0 5.7001e-06 1.8 5.8e-06 1.8 5.8001e-06 0 6.1e-06 0 6.1001e-06 1.8 6.2e-06 1.8 6.2001e-06 0 6.5e-06 0 6.5001e-06 1.8 6.6e-06 1.8 6.6001e-06 0 6.9e-06 0 6.9001e-06 1.8 7e-06 1.8)
CLOAD_S0 S0 VGND 5e-15
CLOAD_S1 S1 VGND 5e-15
CLOAD_S2 S2 VGND 5e-15
CLOAD_S3 S3 VGND 5e-15
CLOAD_S4 S4 VGND 5e-15
CLOAD_S5 S5 VGND 5e-15
CLOAD_S6 S6 VGND 5e-15
CLOAD_S7 S7 VGND 5e-15
CLOAD_S8 S8 VGND 5e-15
CLOAD_S9 S9 VGND 5e-15
CLOAD_S10 S10 VGND 5e-15
CLOAD_S11 S11 VGND 5e-15
CLOAD_S12 S12 VGND 5e-15
CLOAD_S13 S13 VGND 5e-15
CLOAD_S14 S14 VGND 5e-15
CLOAD_S15 S15 VGND 5e-15
CLOAD_COUT COUT VGND 5e-15
XU A0 A1 A2 A3 A4 A5 A6 A7 A8 A9 A10 A11 A12 A13 A14 A15 B0 B1 B2 B3 B4 B5 B6 B7 B8 B9 B10 B11 B12 B13 B14 B15 CIN S0 S1 S2 S3 S4 S5 S6 S7 S8 S9 S10 S11 S12 S13 S14 S15 COUT VPWR VGND adder16
.control
save v(A0) v(A1) v(A2) v(A3) v(A4) v(A5) v(A6) v(A7) v(A8) v(A9) v(A10) v(A11) v(A12) v(A13) v(A14) v(A15) v(B0) v(B1) v(B2) v(B3) v(B4) v(B5) v(B6) v(B7) v(B8) v(B9) v(B10) v(B11) v(B12) v(B13) v(B14) v(B15) v(CIN) v(S0) v(S1) v(S2) v(S3) v(S4) v(S5) v(S6) v(S7) v(S8) v(S9) v(S10) v(S11) v(S12) v(S13) v(S14) v(S15) v(COUT) i(VDD) i(v.xu.xbit0.xn1.vregister_cf_377cff7a8fc053f0) i(v.xu.xbit0.xn1.vregister_cf_12c0ec391985518a) i(v.xu.xbit0.xn1.vregister_cf_1c0f6f4ae9f406c8) i(v.xu.xbit0.xn1.vregister_cf_092f3ee2a80b5958) i(v.xu.xbit0.xn2.vregister_cf_377cff7a8fc053f0) i(v.xu.xbit0.xn2.vregister_cf_12c0ec391985518a) i(v.xu.xbit0.xn2.vregister_cf_1c0f6f4ae9f406c8) i(v.xu.xbit0.xn2.vregister_cf_092f3ee2a80b5958) i(v.xu.xbit0.xn3.vregister_cf_377cff7a8fc053f0) i(v.xu.xbit0.xn3.vregister_cf_12c0ec391985518a) i(v.xu.xbit0.xn3.vregister_cf_1c0f6f4ae9f406c8) i(v.xu.xbit0.xn3.vregister_cf_092f3ee2a80b5958) i(v.xu.xbit0.xn4.vregister_cf_377cff7a8fc053f0) i(v.xu.xbit0.xn4.vregister_cf_12c0ec391985518a) i(v.xu.xbit0.xn4.vregister_cf_1c0f6f4ae9f406c8) i(v.xu.xbit0.xn4.vregister_cf_092f3ee2a80b5958) i(v.xu.xbit0.xn5.vregister_cf_377cff7a8fc053f0) i(v.xu.xbit0.xn5.vregister_cf_12c0ec391985518a) i(v.xu.xbit0.xn5.vregister_cf_1c0f6f4ae9f406c8) i(v.xu.xbit0.xn5.vregister_cf_092f3ee2a80b5958) i(v.xu.xbit0.xn6.vregister_cf_377cff7a8fc053f0) i(v.xu.xbit0.xn6.vregister_cf_12c0ec391985518a) i(v.xu.xbit0.xn6.vregister_cf_1c0f6f4ae9f406c8) i(v.xu.xbit0.xn6.vregister_cf_092f3ee2a80b5958) i(v.xu.xbit0.xn7.vregister_cf_377cff7a8fc053f0) i(v.xu.xbit0.xn7.vregister_cf_12c0ec391985518a) i(v.xu.xbit0.xn7.vregister_cf_1c0f6f4ae9f406c8) i(v.xu.xbit0.xn7.vregister_cf_092f3ee2a80b5958) i(v.xu.xbit0.xn8.vregister_cf_377cff7a8fc053f0) i(v.xu.xbit0.xn8.vregister_cf_12c0ec391985518a) i(v.xu.xbit0.xn8.vregister_cf_1c0f6f4ae9f406c8) i(v.xu.xbit0.xn8.vregister_cf_092f3ee2a80b5958) i(v.xu.xbit0.xn9.vregister_cf_377cff7a8fc053f0) i(v.xu.xbit0.xn9.vregister_cf_12c0ec391985518a) i(v.xu.xbit0.xn9.vregister_cf_1c0f6f4ae9f406c8) i(v.xu.xbit0.xn9.vregister_cf_092f3ee2a80b5958) i(v.xu.xbit1.xn1.vregister_cf_377cff7a8fc053f0) i(v.xu.xbit1.xn1.vregister_cf_12c0ec391985518a) i(v.xu.xbit1.xn1.vregister_cf_1c0f6f4ae9f406c8) i(v.xu.xbit1.xn1.vregister_cf_092f3ee2a80b5958) i(v.xu.xbit1.xn2.vregister_cf_377cff7a8fc053f0) i(v.xu.xbit1.xn2.vregister_cf_12c0ec391985518a) i(v.xu.xbit1.xn2.vregister_cf_1c0f6f4ae9f406c8) i(v.xu.xbit1.xn2.vregister_cf_092f3ee2a80b5958) i(v.xu.xbit1.xn3.vregister_cf_377cff7a8fc053f0) i(v.xu.xbit1.xn3.vregister_cf_12c0ec391985518a) i(v.xu.xbit1.xn3.vregister_cf_1c0f6f4ae9f406c8) i(v.xu.xbit1.xn3.vregister_cf_092f3ee2a80b5958) i(v.xu.xbit1.xn4.vregister_cf_377cff7a8fc053f0) i(v.xu.xbit1.xn4.vregister_cf_12c0ec391985518a) i(v.xu.xbit1.xn4.vregister_cf_1c0f6f4ae9f406c8) i(v.xu.xbit1.xn4.vregister_cf_092f3ee2a80b5958) i(v.xu.xbit1.xn5.vregister_cf_377cff7a8fc053f0) i(v.xu.xbit1.xn5.vregister_cf_12c0ec391985518a) i(v.xu.xbit1.xn5.vregister_cf_1c0f6f4ae9f406c8) i(v.xu.xbit1.xn5.vregister_cf_092f3ee2a80b5958) i(VGND) i(VA0) i(VA1) i(VA2) i(VA3) i(VA4) i(VA5) v(XU.XBIT0.N1) v(XU.XBIT0.XN1.N1) v(VGND) v(VPWR) v(XU.XBIT0.N2) v(XU.XBIT0.XN2.N1) v(XU.XBIT0.N3) v(XU.XBIT0.XN3.N1) v(XU.XBIT0.P) v(XU.XBIT0.XN4.N1) v(XU.XBIT0.N5) v(XU.XBIT0.XN5.N1) v(XU.XBIT0.N6) v(XU.XBIT0.XN6.N1) v(XU.XBIT0.N7) v(XU.XBIT0.XN7.N1) v(XU.XBIT0.XN8.N1) v(XU.C1) v(XU.XBIT0.XN9.N1) v(XU.XBIT1.N1) v(XU.XBIT1.XN1.N1) v(XU.XBIT1.N2) v(XU.XBIT1.XN2.N1) v(XU.XBIT1.N3) v(XU.XBIT1.XN3.N1) v(XU.XBIT1.P) v(XU.XBIT1.XN4.N1) v(XU.XBIT1.N5) v(XU.XBIT1.XN5.N1)
set num_threads=1
set noaskquit
set wr_singlescale
set wr_vecnames
tran 1e-09 7e-06
let mos_wave_0 = v(A0)
let mos_wave_1 = v(A1)
let mos_wave_2 = v(A2)
let mos_wave_3 = v(A3)
let mos_wave_4 = v(A4)
let mos_wave_5 = v(A5)
let mos_wave_6 = v(A6)
let mos_wave_7 = v(A7)
let mos_wave_8 = v(A8)
let mos_wave_9 = v(A9)
let mos_wave_10 = v(A10)
let mos_wave_11 = v(A11)
let mos_wave_12 = v(A12)
let mos_wave_13 = v(A13)
let mos_wave_14 = v(A14)
let mos_wave_15 = v(A15)
let mos_wave_16 = v(B0)
let mos_wave_17 = v(B1)
let mos_wave_18 = v(B2)
let mos_wave_19 = v(B3)
let mos_wave_20 = v(B4)
let mos_wave_21 = v(B5)
let mos_wave_22 = v(B6)
let mos_wave_23 = v(B7)
let mos_wave_24 = v(B8)
let mos_wave_25 = v(B9)
let mos_wave_26 = v(B10)
let mos_wave_27 = v(B11)
let mos_wave_28 = v(B12)
let mos_wave_29 = v(B13)
let mos_wave_30 = v(B14)
let mos_wave_31 = v(B15)
let mos_wave_32 = v(CIN)
let mos_wave_33 = v(S0)
let mos_wave_34 = v(S1)
let mos_wave_35 = v(S2)
let mos_wave_36 = v(S3)
let mos_wave_37 = v(S4)
let mos_wave_38 = v(S5)
let mos_wave_39 = v(S6)
let mos_wave_40 = v(S7)
let mos_wave_41 = v(S8)
let mos_wave_42 = v(S9)
let mos_wave_43 = v(S10)
let mos_wave_44 = v(S11)
let mos_wave_45 = v(S12)
let mos_wave_46 = v(S13)
let mos_wave_47 = v(S14)
let mos_wave_48 = v(S15)
let mos_wave_49 = v(COUT)
let mos_wave_50 = -i(VDD)
wrdata waveform.dat mos_wave_0 mos_wave_1 mos_wave_2 mos_wave_3 mos_wave_4 mos_wave_5 mos_wave_6 mos_wave_7 mos_wave_8 mos_wave_9 mos_wave_10 mos_wave_11 mos_wave_12 mos_wave_13 mos_wave_14 mos_wave_15 mos_wave_16 mos_wave_17 mos_wave_18 mos_wave_19 mos_wave_20 mos_wave_21 mos_wave_22 mos_wave_23 mos_wave_24 mos_wave_25 mos_wave_26 mos_wave_27 mos_wave_28 mos_wave_29 mos_wave_30 mos_wave_31 mos_wave_32 mos_wave_33 mos_wave_34 mos_wave_35 mos_wave_36 mos_wave_37 mos_wave_38 mos_wave_39 mos_wave_40 mos_wave_41 mos_wave_42 mos_wave_43 mos_wave_44 mos_wave_45 mos_wave_46 mos_wave_47 mos_wave_48 mos_wave_49 mos_wave_50
write waveform.raw all
let register_flow_0 = i(v.xu.xbit0.xn1.vregister_cf_377cff7a8fc053f0)
let register_flow_1 = i(v.xu.xbit0.xn1.vregister_cf_12c0ec391985518a)
let register_flow_2 = i(v.xu.xbit0.xn1.vregister_cf_1c0f6f4ae9f406c8)
let register_flow_3 = i(v.xu.xbit0.xn1.vregister_cf_092f3ee2a80b5958)
let register_flow_4 = i(v.xu.xbit0.xn2.vregister_cf_377cff7a8fc053f0)
let register_flow_5 = i(v.xu.xbit0.xn2.vregister_cf_12c0ec391985518a)
let register_flow_6 = i(v.xu.xbit0.xn2.vregister_cf_1c0f6f4ae9f406c8)
let register_flow_7 = i(v.xu.xbit0.xn2.vregister_cf_092f3ee2a80b5958)
let register_flow_8 = i(v.xu.xbit0.xn3.vregister_cf_377cff7a8fc053f0)
let register_flow_9 = i(v.xu.xbit0.xn3.vregister_cf_12c0ec391985518a)
let register_flow_10 = i(v.xu.xbit0.xn3.vregister_cf_1c0f6f4ae9f406c8)
let register_flow_11 = i(v.xu.xbit0.xn3.vregister_cf_092f3ee2a80b5958)
let register_flow_12 = i(v.xu.xbit0.xn4.vregister_cf_377cff7a8fc053f0)
let register_flow_13 = i(v.xu.xbit0.xn4.vregister_cf_12c0ec391985518a)
let register_flow_14 = i(v.xu.xbit0.xn4.vregister_cf_1c0f6f4ae9f406c8)
let register_flow_15 = i(v.xu.xbit0.xn4.vregister_cf_092f3ee2a80b5958)
let register_flow_16 = i(v.xu.xbit0.xn5.vregister_cf_377cff7a8fc053f0)
let register_flow_17 = i(v.xu.xbit0.xn5.vregister_cf_12c0ec391985518a)
let register_flow_18 = i(v.xu.xbit0.xn5.vregister_cf_1c0f6f4ae9f406c8)
let register_flow_19 = i(v.xu.xbit0.xn5.vregister_cf_092f3ee2a80b5958)
let register_flow_20 = i(v.xu.xbit0.xn6.vregister_cf_377cff7a8fc053f0)
let register_flow_21 = i(v.xu.xbit0.xn6.vregister_cf_12c0ec391985518a)
let register_flow_22 = i(v.xu.xbit0.xn6.vregister_cf_1c0f6f4ae9f406c8)
let register_flow_23 = i(v.xu.xbit0.xn6.vregister_cf_092f3ee2a80b5958)
let register_flow_24 = i(v.xu.xbit0.xn7.vregister_cf_377cff7a8fc053f0)
let register_flow_25 = i(v.xu.xbit0.xn7.vregister_cf_12c0ec391985518a)
let register_flow_26 = i(v.xu.xbit0.xn7.vregister_cf_1c0f6f4ae9f406c8)
let register_flow_27 = i(v.xu.xbit0.xn7.vregister_cf_092f3ee2a80b5958)
let register_flow_28 = i(v.xu.xbit0.xn8.vregister_cf_377cff7a8fc053f0)
let register_flow_29 = i(v.xu.xbit0.xn8.vregister_cf_12c0ec391985518a)
let register_flow_30 = i(v.xu.xbit0.xn8.vregister_cf_1c0f6f4ae9f406c8)
let register_flow_31 = i(v.xu.xbit0.xn8.vregister_cf_092f3ee2a80b5958)
let register_flow_32 = i(v.xu.xbit0.xn9.vregister_cf_377cff7a8fc053f0)
let register_flow_33 = i(v.xu.xbit0.xn9.vregister_cf_12c0ec391985518a)
let register_flow_34 = i(v.xu.xbit0.xn9.vregister_cf_1c0f6f4ae9f406c8)
let register_flow_35 = i(v.xu.xbit0.xn9.vregister_cf_092f3ee2a80b5958)
let register_flow_36 = i(v.xu.xbit1.xn1.vregister_cf_377cff7a8fc053f0)
let register_flow_37 = i(v.xu.xbit1.xn1.vregister_cf_12c0ec391985518a)
let register_flow_38 = i(v.xu.xbit1.xn1.vregister_cf_1c0f6f4ae9f406c8)
let register_flow_39 = i(v.xu.xbit1.xn1.vregister_cf_092f3ee2a80b5958)
let register_flow_40 = i(v.xu.xbit1.xn2.vregister_cf_377cff7a8fc053f0)
let register_flow_41 = i(v.xu.xbit1.xn2.vregister_cf_12c0ec391985518a)
let register_flow_42 = i(v.xu.xbit1.xn2.vregister_cf_1c0f6f4ae9f406c8)
let register_flow_43 = i(v.xu.xbit1.xn2.vregister_cf_092f3ee2a80b5958)
let register_flow_44 = i(v.xu.xbit1.xn3.vregister_cf_377cff7a8fc053f0)
let register_flow_45 = i(v.xu.xbit1.xn3.vregister_cf_12c0ec391985518a)
let register_flow_46 = i(v.xu.xbit1.xn3.vregister_cf_1c0f6f4ae9f406c8)
let register_flow_47 = i(v.xu.xbit1.xn3.vregister_cf_092f3ee2a80b5958)
let register_flow_48 = i(v.xu.xbit1.xn4.vregister_cf_377cff7a8fc053f0)
let register_flow_49 = i(v.xu.xbit1.xn4.vregister_cf_12c0ec391985518a)
let register_flow_50 = i(v.xu.xbit1.xn4.vregister_cf_1c0f6f4ae9f406c8)
let register_flow_51 = i(v.xu.xbit1.xn4.vregister_cf_092f3ee2a80b5958)
let register_flow_52 = i(v.xu.xbit1.xn5.vregister_cf_377cff7a8fc053f0)
let register_flow_53 = i(v.xu.xbit1.xn5.vregister_cf_12c0ec391985518a)
let register_flow_54 = i(v.xu.xbit1.xn5.vregister_cf_1c0f6f4ae9f406c8)
let register_flow_55 = i(v.xu.xbit1.xn5.vregister_cf_092f3ee2a80b5958)
let register_flow_56 = i(VGND)
let register_flow_57 = i(VDD)
let register_flow_58 = i(VA0)
let register_flow_59 = i(VA1)
let register_flow_60 = i(VA2)
let register_flow_61 = i(VA3)
let register_flow_62 = i(VA4)
let register_flow_63 = i(VA5)
wrdata current-flow.dat register_flow_0 register_flow_1 register_flow_2 register_flow_3 register_flow_4 register_flow_5 register_flow_6 register_flow_7 register_flow_8 register_flow_9 register_flow_10 register_flow_11 register_flow_12 register_flow_13 register_flow_14 register_flow_15 register_flow_16 register_flow_17 register_flow_18 register_flow_19 register_flow_20 register_flow_21 register_flow_22 register_flow_23 register_flow_24 register_flow_25 register_flow_26 register_flow_27 register_flow_28 register_flow_29 register_flow_30 register_flow_31 register_flow_32 register_flow_33 register_flow_34 register_flow_35 register_flow_36 register_flow_37 register_flow_38 register_flow_39 register_flow_40 register_flow_41 register_flow_42 register_flow_43 register_flow_44 register_flow_45 register_flow_46 register_flow_47 register_flow_48 register_flow_49 register_flow_50 register_flow_51 register_flow_52 register_flow_53 register_flow_54 register_flow_55 register_flow_56 register_flow_57 register_flow_58 register_flow_59 register_flow_60 register_flow_61 register_flow_62 register_flow_63
let register_voltage_0 = v(XU.XBIT0.N1)
let register_voltage_1 = v(XU.XBIT0.XN1.N1)
let register_voltage_2 = v(A0)
let register_voltage_3 = v(VGND)
let register_voltage_4 = v(B0)
let register_voltage_5 = v(VPWR)
let register_voltage_6 = v(XU.XBIT0.N2)
let register_voltage_7 = v(XU.XBIT0.XN2.N1)
let register_voltage_8 = v(XU.XBIT0.N3)
let register_voltage_9 = v(XU.XBIT0.XN3.N1)
let register_voltage_10 = v(XU.XBIT0.P)
let register_voltage_11 = v(XU.XBIT0.XN4.N1)
let register_voltage_12 = v(XU.XBIT0.N5)
let register_voltage_13 = v(XU.XBIT0.XN5.N1)
let register_voltage_14 = v(CIN)
let register_voltage_15 = v(XU.XBIT0.N6)
let register_voltage_16 = v(XU.XBIT0.XN6.N1)
let register_voltage_17 = v(XU.XBIT0.N7)
let register_voltage_18 = v(XU.XBIT0.XN7.N1)
let register_voltage_19 = v(S0)
let register_voltage_20 = v(XU.XBIT0.XN8.N1)
let register_voltage_21 = v(XU.C1)
let register_voltage_22 = v(XU.XBIT0.XN9.N1)
let register_voltage_23 = v(XU.XBIT1.N1)
let register_voltage_24 = v(XU.XBIT1.XN1.N1)
let register_voltage_25 = v(A1)
let register_voltage_26 = v(B1)
let register_voltage_27 = v(XU.XBIT1.N2)
let register_voltage_28 = v(XU.XBIT1.XN2.N1)
let register_voltage_29 = v(XU.XBIT1.N3)
let register_voltage_30 = v(XU.XBIT1.XN3.N1)
let register_voltage_31 = v(XU.XBIT1.P)
let register_voltage_32 = v(XU.XBIT1.XN4.N1)
let register_voltage_33 = v(XU.XBIT1.N5)
let register_voltage_34 = v(XU.XBIT1.XN5.N1)
let register_voltage_35 = 0*register_flow_0
let register_voltage_36 = v(A2)
let register_voltage_37 = v(A3)
let register_voltage_38 = v(A4)
let register_voltage_39 = v(A5)
wrdata node-voltages.dat register_voltage_0 register_voltage_1 register_voltage_2 register_voltage_3 register_voltage_4 register_voltage_5 register_voltage_6 register_voltage_7 register_voltage_8 register_voltage_9 register_voltage_10 register_voltage_11 register_voltage_12 register_voltage_13 register_voltage_14 register_voltage_15 register_voltage_16 register_voltage_17 register_voltage_18 register_voltage_19 register_voltage_20 register_voltage_21 register_voltage_22 register_voltage_23 register_voltage_24 register_voltage_25 register_voltage_26 register_voltage_27 register_voltage_28 register_voltage_29 register_voltage_30 register_voltage_31 register_voltage_32 register_voltage_33 register_voltage_34 register_voltage_35 register_voltage_36 register_voltage_37 register_voltage_38 register_voltage_39
quit
.endc
.end

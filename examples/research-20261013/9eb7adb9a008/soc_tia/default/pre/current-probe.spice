.subckt SOC_OTA_FIRST INP INN BIAS OUT VPWR VGND
XN_INN0 register_cf_node_44a7d6fa5e5059ca INN register_cf_node_44a7d6fa5e5059ca_source VGND sky130_fd_pr__nfet_01v8 w=5 l=1 nf=1 m=1
Vregister_cf_44a7d6fa5e5059ca MIR register_cf_node_44a7d6fa5e5059ca 0
Vregister_cf_44a7d6fa5e5059ca_source TAIL register_cf_node_44a7d6fa5e5059ca_source 0
XN_INN1 register_cf_node_59dd6b01ffe7cfb0 INN register_cf_node_59dd6b01ffe7cfb0_source VGND sky130_fd_pr__nfet_01v8 w=5 l=1 nf=1 m=1
Vregister_cf_59dd6b01ffe7cfb0 MIR register_cf_node_59dd6b01ffe7cfb0 0
Vregister_cf_59dd6b01ffe7cfb0_source TAIL register_cf_node_59dd6b01ffe7cfb0_source 0
XN_INP0 register_cf_node_65e04b8a37108d24 INP register_cf_node_65e04b8a37108d24_source VGND sky130_fd_pr__nfet_01v8 w=5 l=1 nf=1 m=1
Vregister_cf_65e04b8a37108d24 OUT register_cf_node_65e04b8a37108d24 0
Vregister_cf_65e04b8a37108d24_source TAIL register_cf_node_65e04b8a37108d24_source 0
XN_INP1 register_cf_node_bbed48e6e9d221df INP register_cf_node_bbed48e6e9d221df_source VGND sky130_fd_pr__nfet_01v8 w=5 l=1 nf=1 m=1
Vregister_cf_bbed48e6e9d221df OUT register_cf_node_bbed48e6e9d221df 0
Vregister_cf_bbed48e6e9d221df_source TAIL register_cf_node_bbed48e6e9d221df_source 0
XN_TAIL register_cf_node_0c41c8aa9e8c91bb BIAS register_cf_node_0c41c8aa9e8c91bb_source VGND sky130_fd_pr__nfet_01v8 w=2 l=1 nf=1 m=1
Vregister_cf_0c41c8aa9e8c91bb TAIL register_cf_node_0c41c8aa9e8c91bb 0
Vregister_cf_0c41c8aa9e8c91bb_source VGND register_cf_node_0c41c8aa9e8c91bb_source 0
XP_DIODE register_cf_node_dee31e44c859f504 MIR register_cf_node_dee31e44c859f504_source VPWR sky130_fd_pr__pfet_01v8_hvt w=20 l=1 nf=1 m=1
Vregister_cf_dee31e44c859f504 MIR register_cf_node_dee31e44c859f504 0
Vregister_cf_dee31e44c859f504_source VPWR register_cf_node_dee31e44c859f504_source 0
XP_MIRROR register_cf_node_76752659b10f5142 MIR register_cf_node_76752659b10f5142_source VPWR sky130_fd_pr__pfet_01v8_hvt w=20 l=1 nf=1 m=1
Vregister_cf_76752659b10f5142 OUT register_cf_node_76752659b10f5142 0
Vregister_cf_76752659b10f5142_source VPWR register_cf_node_76752659b10f5142_source 0
.ends SOC_OTA_FIRST
.subckt SOC_OTA INP INN BIAS OUT VPWR VGND
CC_MILLER register_cf_node_54f0040858166f9d COMP 5e-12
Vregister_cf_54f0040858166f9d PRE register_cf_node_54f0040858166f9d 0
XFIRST INP INN BIAS PRE VPWR VGND SOC_OTA_FIRST
XN_SECOND register_cf_node_9a9b80f42fc6e7ca BIAS register_cf_node_9a9b80f42fc6e7ca_source VGND sky130_fd_pr__nfet_01v8 w=2 l=1 nf=1 m=1
Vregister_cf_9a9b80f42fc6e7ca OUT register_cf_node_9a9b80f42fc6e7ca 0
Vregister_cf_9a9b80f42fc6e7ca_source VGND register_cf_node_9a9b80f42fc6e7ca_source 0
XP_SECOND register_cf_node_5e86041922791634 PRE register_cf_node_5e86041922791634_source VPWR sky130_fd_pr__pfet_01v8_hvt w=40 l=1 nf=1 m=1
Vregister_cf_5e86041922791634 OUT register_cf_node_5e86041922791634 0
Vregister_cf_5e86041922791634_source VPWR register_cf_node_5e86041922791634_source 0
RR_ZERO register_cf_node_a901034b015257ed OUT 5000
Vregister_cf_a901034b015257ed COMP register_cf_node_a901034b015257ed 0
.ends SOC_OTA
.subckt soc_tia IIN VCM BIAS OUT VPWR VGND
XAMP VCM IIN BIAS OUT VPWR VGND SOC_OTA
CC_FEEDBACK register_cf_node_f32b84a4cada83e7 IIN 1e-12
Vregister_cf_f32b84a4cada83e7 OUT register_cf_node_f32b84a4cada83e7 0
RR_FEEDBACK register_cf_node_3229d4b321b024e6 IIN 100000
Vregister_cf_3229d4b321b024e6 OUT register_cf_node_3229d4b321b024e6 0
.ends soc_tia

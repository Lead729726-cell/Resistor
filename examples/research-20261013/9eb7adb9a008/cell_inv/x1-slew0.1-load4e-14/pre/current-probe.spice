.subckt cell_inv A Y VPWR VGND
XMN register_cf_node_5b95bc930a2384e5 A register_cf_node_5b95bc930a2384e5_source VGND sky130_fd_pr__nfet_01v8 w=0.65 l=0.15 nf=1 m=1
Vregister_cf_5b95bc930a2384e5 Y register_cf_node_5b95bc930a2384e5 0
Vregister_cf_5b95bc930a2384e5_source VGND register_cf_node_5b95bc930a2384e5_source 0
XMP register_cf_node_76c207a29be41fc5 A register_cf_node_76c207a29be41fc5_source VPWR sky130_fd_pr__pfet_01v8_hvt w=0.65 l=0.15 nf=1 m=1
Vregister_cf_76c207a29be41fc5 Y register_cf_node_76c207a29be41fc5 0
Vregister_cf_76c207a29be41fc5_source VPWR register_cf_node_76c207a29be41fc5_source 0
.ends cell_inv

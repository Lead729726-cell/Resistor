* NGSPICE file created from cell_inv.ext - technology: sky130A

.subckt cell_inv Y VPWR VGND A
X0 VPWR.t1 A.t0 Y.t0 VPWR.t0 sky130_fd_pr__pfet_01v8_hvt ad=0.1885 pd=1.88 as=0.1885 ps=1.88 w=0.65 l=0.15
X1 VGND.t1 A.t1 Y.t1 VGND.t0 sky130_fd_pr__nfet_01v8 ad=0.1885 pd=1.88 as=0.1885 ps=1.88 w=0.65 l=0.15
C0 A VPWR 0.42022f
C1 Y VPWR 0.28701f
C2 Y A 1.41228f
R0 A A.t0 330.341
R1 A A.t1 315.88
R2 A.n0 A 30.352
R3 A.n0 A 29.7837
R4 A A.n0 4.88904
R5 Y.t0 Y.n3 700.484
R6 Y.n4 Y.t0 700.484
R7 Y.t1 Y.n0 255.345
R8 Y.n1 Y.t1 255.345
R9 Y Y.n0 12.8005
R10 Y.n1 Y 12.8005
R11 Y Y.n3 12.8005
R12 Y.n4 Y 12.8005
R13 Y.n6 Y.n2 10.5881
R14 Y.n2 Y.n0 10.1513
R15 Y.n2 Y.n1 10.1513
R16 Y.n5 Y.n3 10.1513
R17 Y.n5 Y.n4 10.1513
R18 Y.n6 Y.n5 10.0354
R19 Y Y.n6 4.22948
R20 VPWR.n20 VPWR.n8 832.942
R21 VPWR.n31 VPWR.n9 832.942
R22 VPWR.n33 VPWR.n6 832.942
R23 VPWR.n15 VPWR.n5 832.942
R24 VPWR.t1 VPWR.n0 700.484
R25 VPWR.n1 VPWR.t1 700.484
R26 VPWR.n31 VPWR.n8 240
R27 VPWR.n27 VPWR.n25 240
R28 VPWR.n33 VPWR.n5 240
R29 VPWR.n12 VPWR.n11 240
R30 VPWR.n18 VPWR.n17 207.394
R31 VPWR.n32 VPWR.n7 207.394
R32 VPWR.n15 VPWR.n14 185
R33 VPWR.n13 VPWR.n12 185
R34 VPWR.n11 VPWR.n10 185
R35 VPWR.n21 VPWR.n20 185
R36 VPWR.n22 VPWR.n8 185
R37 VPWR.n17 VPWR.n8 185
R38 VPWR.n31 VPWR.n30 185
R39 VPWR.n32 VPWR.n31 185
R40 VPWR.n29 VPWR.n9 185
R41 VPWR.n28 VPWR.n27 185
R42 VPWR.n25 VPWR.n23 185
R43 VPWR.n6 VPWR.n4 185
R44 VPWR.n34 VPWR.n33 185
R45 VPWR.n33 VPWR.n32 185
R46 VPWR.n5 VPWR.n3 185
R47 VPWR.n17 VPWR.n5 185
R48 VPWR.n22 VPWR.n21 88.8476
R49 VPWR.n14 VPWR.n3 88.8476
R50 VPWR.n30 VPWR.n29 88.8476
R51 VPWR.n34 VPWR.n4 88.8476
R52 VPWR.n26 VPWR.n9 72.7879
R53 VPWR.n24 VPWR.n6 72.7879
R54 VPWR.n20 VPWR.n19 72.7879
R55 VPWR.n16 VPWR.n12 72.7879
R56 VPWR.n16 VPWR.n15 72.7879
R57 VPWR.n19 VPWR.n11 72.7879
R58 VPWR.n27 VPWR.n26 72.7879
R59 VPWR.n25 VPWR.n24 72.7879
R60 VPWR.n17 VPWR.t0 56.8667
R61 VPWR.n32 VPWR.t0 56.8667
R62 VPWR.n18 VPWR.n16 56.1076
R63 VPWR.n19 VPWR.n18 56.1076
R64 VPWR.n26 VPWR.n7 56.1076
R65 VPWR.n24 VPWR.n7 56.1076
R66 VPWR.n21 VPWR.n10 25.6005
R67 VPWR.n13 VPWR.n10 25.6005
R68 VPWR.n14 VPWR.n13 25.6005
R69 VPWR.n30 VPWR.n22 25.6005
R70 VPWR.n29 VPWR.n28 25.6005
R71 VPWR.n28 VPWR.n23 25.6005
R72 VPWR.n23 VPWR.n4 25.6005
R73 VPWR.n35 VPWR 18.865
R74 VPWR VPWR.n0 12.8005
R75 VPWR.n1 VPWR 12.8005
R76 VPWR VPWR.n3 12.8005
R77 VPWR VPWR.n34 12.8005
R78 VPWR.n35 VPWR.n2 10.6503
R79 VPWR.n2 VPWR.n0 10.1513
R80 VPWR.n2 VPWR.n1 10.1513
R81 VPWR VPWR.n35 4.46447
R82 VGND.n20 VGND.n8 1315.26
R83 VGND.n31 VGND.n9 1315.26
R84 VGND.n33 VGND.n6 1315.26
R85 VGND.n15 VGND.n5 1315.26
R86 VGND.n15 VGND.n14 585
R87 VGND.n13 VGND.n12 585
R88 VGND.n11 VGND.n10 585
R89 VGND.n21 VGND.n20 585
R90 VGND.n22 VGND.n8 585
R91 VGND.n17 VGND.n8 585
R92 VGND.n31 VGND.n30 585
R93 VGND.n32 VGND.n31 585
R94 VGND.n29 VGND.n9 585
R95 VGND.n28 VGND.n27 585
R96 VGND.n25 VGND.n23 585
R97 VGND.n6 VGND.n4 585
R98 VGND.n34 VGND.n33 585
R99 VGND.n33 VGND.n32 585
R100 VGND.n5 VGND.n3 585
R101 VGND.n17 VGND.n5 585
R102 VGND.n31 VGND.n8 394
R103 VGND.n27 VGND.n25 394
R104 VGND.n33 VGND.n5 394
R105 VGND.n12 VGND.n11 394
R106 VGND.t1 VGND.n0 255.345
R107 VGND.n1 VGND.t1 255.345
R108 VGND.n18 VGND.n17 224.713
R109 VGND.n32 VGND.n7 224.713
R110 VGND.n18 VGND.n16 218.815
R111 VGND.n19 VGND.n18 218.815
R112 VGND.n26 VGND.n7 218.815
R113 VGND.n24 VGND.n7 218.815
R114 VGND.n26 VGND.n9 147.374
R115 VGND.n24 VGND.n6 147.374
R116 VGND.n20 VGND.n19 147.374
R117 VGND.n16 VGND.n12 147.374
R118 VGND.n16 VGND.n15 147.374
R119 VGND.n19 VGND.n11 147.374
R120 VGND.n27 VGND.n26 147.374
R121 VGND.n25 VGND.n24 147.374
R122 VGND.n22 VGND.n21 85.4593
R123 VGND.n14 VGND.n3 85.4593
R124 VGND.n30 VGND.n29 85.4593
R125 VGND.n34 VGND.n4 85.4593
R126 VGND.n17 VGND.t0 61.615
R127 VGND.n32 VGND.t0 61.615
R128 VGND.n21 VGND.n10 25.6005
R129 VGND.n13 VGND.n10 25.6005
R130 VGND.n14 VGND.n13 25.6005
R131 VGND.n30 VGND.n22 25.6005
R132 VGND.n29 VGND.n28 25.6005
R133 VGND.n28 VGND.n23 25.6005
R134 VGND.n23 VGND.n4 25.6005
R135 VGND.n35 VGND 18.3598
R136 VGND VGND.n0 12.8005
R137 VGND.n1 VGND 12.8005
R138 VGND VGND.n3 12.8005
R139 VGND VGND.n34 12.8005
R140 VGND.n2 VGND.n0 10.1513
R141 VGND.n2 VGND.n1 10.1513
R142 VGND.n35 VGND.n2 10.1294
R143 VGND VGND.n35 5.15812
C3 Y VGND 1.84472f
C4 A VGND 2.96549f
C5 VPWR VGND 3.30035f
.ends

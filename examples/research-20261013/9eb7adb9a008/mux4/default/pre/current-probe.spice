.subckt mux4 D0 D1 D2 D3 S0 S1 Y VPWR VGND
XMN_BUF1 register_cf_node_a2951e1166e489f2 MUX_RAW register_cf_node_a2951e1166e489f2_source VGND sky130_fd_pr__nfet_01v8 w=0.65 l=0.15 nf=1 m=1
Vregister_cf_a2951e1166e489f2 BUF_N register_cf_node_a2951e1166e489f2 0
Vregister_cf_a2951e1166e489f2_source VGND register_cf_node_a2951e1166e489f2_source 0
XMN_BUF2 register_cf_node_31c54237ba73ade6 BUF_N register_cf_node_31c54237ba73ade6_source VGND sky130_fd_pr__nfet_01v8 w=0.65 l=0.15 nf=1 m=1
Vregister_cf_31c54237ba73ade6 Y register_cf_node_31c54237ba73ade6 0
Vregister_cf_31c54237ba73ade6_source VGND register_cf_node_31c54237ba73ade6_source 0
XMN_D0 register_cf_node_61f397c5f25f8303 S0B register_cf_node_61f397c5f25f8303_source VGND sky130_fd_pr__nfet_01v8 w=0.65 l=0.15 nf=1 m=1
Vregister_cf_61f397c5f25f8303 N01 register_cf_node_61f397c5f25f8303 0
Vregister_cf_61f397c5f25f8303_source D0 register_cf_node_61f397c5f25f8303_source 0
XMN_D1 register_cf_node_a580d7e313f389b0 S0 register_cf_node_a580d7e313f389b0_source VGND sky130_fd_pr__nfet_01v8 w=0.65 l=0.15 nf=1 m=1
Vregister_cf_a580d7e313f389b0 N01 register_cf_node_a580d7e313f389b0 0
Vregister_cf_a580d7e313f389b0_source D1 register_cf_node_a580d7e313f389b0_source 0
XMN_D2 register_cf_node_bbe435fffc616a7e S0B register_cf_node_bbe435fffc616a7e_source VGND sky130_fd_pr__nfet_01v8 w=0.65 l=0.15 nf=1 m=1
Vregister_cf_bbe435fffc616a7e N23 register_cf_node_bbe435fffc616a7e 0
Vregister_cf_bbe435fffc616a7e_source D2 register_cf_node_bbe435fffc616a7e_source 0
XMN_D3 register_cf_node_db9da729a7529eb5 S0 register_cf_node_db9da729a7529eb5_source VGND sky130_fd_pr__nfet_01v8 w=0.65 l=0.15 nf=1 m=1
Vregister_cf_db9da729a7529eb5 N23 register_cf_node_db9da729a7529eb5 0
Vregister_cf_db9da729a7529eb5_source D3 register_cf_node_db9da729a7529eb5_source 0
XMN_HIGH register_cf_node_966a02a40af77492 S1 register_cf_node_966a02a40af77492_source VGND sky130_fd_pr__nfet_01v8 w=0.65 l=0.15 nf=1 m=1
Vregister_cf_966a02a40af77492 MUX_RAW register_cf_node_966a02a40af77492 0
Vregister_cf_966a02a40af77492_source N23 register_cf_node_966a02a40af77492_source 0
XMN_LOW register_cf_node_1e7095ce7b8b3c8d S1B register_cf_node_1e7095ce7b8b3c8d_source VGND sky130_fd_pr__nfet_01v8 w=0.65 l=0.15 nf=1 m=1
Vregister_cf_1e7095ce7b8b3c8d MUX_RAW register_cf_node_1e7095ce7b8b3c8d 0
Vregister_cf_1e7095ce7b8b3c8d_source N01 register_cf_node_1e7095ce7b8b3c8d_source 0
XMN_SEL0 register_cf_node_08fe9758ec08b584 S0 register_cf_node_08fe9758ec08b584_source VGND sky130_fd_pr__nfet_01v8 w=0.65 l=0.15 nf=1 m=1
Vregister_cf_08fe9758ec08b584 S0B register_cf_node_08fe9758ec08b584 0
Vregister_cf_08fe9758ec08b584_source VGND register_cf_node_08fe9758ec08b584_source 0
XMN_SEL1 register_cf_node_c376c5e0b6449ebc S1 register_cf_node_c376c5e0b6449ebc_source VGND sky130_fd_pr__nfet_01v8 w=0.65 l=0.15 nf=1 m=1
Vregister_cf_c376c5e0b6449ebc S1B register_cf_node_c376c5e0b6449ebc 0
Vregister_cf_c376c5e0b6449ebc_source VGND register_cf_node_c376c5e0b6449ebc_source 0
XMP_BUF1 register_cf_node_87b92f1d813ed277 MUX_RAW register_cf_node_87b92f1d813ed277_source VPWR sky130_fd_pr__pfet_01v8_hvt w=0.65 l=0.15 nf=1 m=1
Vregister_cf_87b92f1d813ed277 BUF_N register_cf_node_87b92f1d813ed277 0
Vregister_cf_87b92f1d813ed277_source VPWR register_cf_node_87b92f1d813ed277_source 0
XMP_BUF2 register_cf_node_3a045d2e145fed3a BUF_N register_cf_node_3a045d2e145fed3a_source VPWR sky130_fd_pr__pfet_01v8_hvt w=0.65 l=0.15 nf=1 m=1
Vregister_cf_3a045d2e145fed3a Y register_cf_node_3a045d2e145fed3a 0
Vregister_cf_3a045d2e145fed3a_source VPWR register_cf_node_3a045d2e145fed3a_source 0
XMP_D0 register_cf_node_260a3e95bf06e15a S0 register_cf_node_260a3e95bf06e15a_source VPWR sky130_fd_pr__pfet_01v8_hvt w=0.65 l=0.15 nf=1 m=1
Vregister_cf_260a3e95bf06e15a N01 register_cf_node_260a3e95bf06e15a 0
Vregister_cf_260a3e95bf06e15a_source D0 register_cf_node_260a3e95bf06e15a_source 0
XMP_D1 register_cf_node_c61da402cc828ef1 S0B register_cf_node_c61da402cc828ef1_source VPWR sky130_fd_pr__pfet_01v8_hvt w=0.65 l=0.15 nf=1 m=1
Vregister_cf_c61da402cc828ef1 N01 register_cf_node_c61da402cc828ef1 0
Vregister_cf_c61da402cc828ef1_source D1 register_cf_node_c61da402cc828ef1_source 0
XMP_D2 register_cf_node_ddfbd7c48e1aec83 S0 register_cf_node_ddfbd7c48e1aec83_source VPWR sky130_fd_pr__pfet_01v8_hvt w=0.65 l=0.15 nf=1 m=1
Vregister_cf_ddfbd7c48e1aec83 N23 register_cf_node_ddfbd7c48e1aec83 0
Vregister_cf_ddfbd7c48e1aec83_source D2 register_cf_node_ddfbd7c48e1aec83_source 0
XMP_D3 register_cf_node_704e6d351313fc95 S0B register_cf_node_704e6d351313fc95_source VPWR sky130_fd_pr__pfet_01v8_hvt w=0.65 l=0.15 nf=1 m=1
Vregister_cf_704e6d351313fc95 N23 register_cf_node_704e6d351313fc95 0
Vregister_cf_704e6d351313fc95_source D3 register_cf_node_704e6d351313fc95_source 0
XMP_HIGH register_cf_node_17ec022deafaca12 S1B register_cf_node_17ec022deafaca12_source VPWR sky130_fd_pr__pfet_01v8_hvt w=0.65 l=0.15 nf=1 m=1
Vregister_cf_17ec022deafaca12 MUX_RAW register_cf_node_17ec022deafaca12 0
Vregister_cf_17ec022deafaca12_source N23 register_cf_node_17ec022deafaca12_source 0
XMP_LOW register_cf_node_a3525c4273e3ebad S1 register_cf_node_a3525c4273e3ebad_source VPWR sky130_fd_pr__pfet_01v8_hvt w=0.65 l=0.15 nf=1 m=1
Vregister_cf_a3525c4273e3ebad MUX_RAW register_cf_node_a3525c4273e3ebad 0
Vregister_cf_a3525c4273e3ebad_source N01 register_cf_node_a3525c4273e3ebad_source 0
XMP_SEL0 register_cf_node_fbc1dfdee2dce7b5 S0 register_cf_node_fbc1dfdee2dce7b5_source VPWR sky130_fd_pr__pfet_01v8_hvt w=0.65 l=0.15 nf=1 m=1
Vregister_cf_fbc1dfdee2dce7b5 S0B register_cf_node_fbc1dfdee2dce7b5 0
Vregister_cf_fbc1dfdee2dce7b5_source VPWR register_cf_node_fbc1dfdee2dce7b5_source 0
XMP_SEL1 register_cf_node_4ae46e669b515b57 S1 register_cf_node_4ae46e669b515b57_source VPWR sky130_fd_pr__pfet_01v8_hvt w=0.65 l=0.15 nf=1 m=1
Vregister_cf_4ae46e669b515b57 S1B register_cf_node_4ae46e669b515b57 0
Vregister_cf_4ae46e669b515b57_source VPWR register_cf_node_4ae46e669b515b57_source 0
.ends mux4

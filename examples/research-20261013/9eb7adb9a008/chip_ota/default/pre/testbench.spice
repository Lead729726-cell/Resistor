Resistor actual SKY130 chip reference chip_ota
.options method=gear maxord=2
.include "/workspace/.runtime/eda/runs/bbc8bebc6b86453eb5281623f901e663/supported-tt.spice"
.option scale=1e-6
.include "/workspace/.runtime/eda/runs/bbc8bebc6b86453eb5281623f901e663/reference.spice"
.temp 27.0
VGND VGND 0 0
VDD VPWR VGND 1.8
VBIAS BIAS VGND 0.9
VINN INN VGND 0.9
VINP INP VGND DC 0.9 AC 1
RLOAD OUT VGND 100meg
COUT OUT VGND 1e-12
XU INP INN BIAS OUT VPWR VGND chip_ota
.control
set num_threads=1
set numdgt=17
set noaskquit
set wr_singlescale
set wr_vecnames
ac dec 40 10 1e9
let mos_wave_0 = mag(v(OUT))
let mos_wave_1 = 180/pi*ph(v(OUT))
wrdata waveform.dat mos_wave_0 mos_wave_1
write waveform.raw all
quit
.endc
.end

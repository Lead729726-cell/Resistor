.subckt cell_nand2 A0 A1 Y VPWR VGND
XMN0 register_cf_node_8dd6ddba12b4ea2a A0 register_cf_node_8dd6ddba12b4ea2a_source VGND sky130_fd_pr__nfet_01v8 w=2.6 l=0.15 nf=1 m=1
Vregister_cf_8dd6ddba12b4ea2a Y register_cf_node_8dd6ddba12b4ea2a 0
Vregister_cf_8dd6ddba12b4ea2a_source N1 register_cf_node_8dd6ddba12b4ea2a_source 0
XMN1 register_cf_node_b3aaab7e90eeda51 A1 register_cf_node_b3aaab7e90eeda51_source VGND sky130_fd_pr__nfet_01v8 w=2.6 l=0.15 nf=1 m=1
Vregister_cf_b3aaab7e90eeda51 N1 register_cf_node_b3aaab7e90eeda51 0
Vregister_cf_b3aaab7e90eeda51_source VGND register_cf_node_b3aaab7e90eeda51_source 0
XMP0 register_cf_node_1081c1c6d1534062 A0 register_cf_node_1081c1c6d1534062_source VPWR sky130_fd_pr__pfet_01v8_hvt w=2.6 l=0.15 nf=1 m=1
Vregister_cf_1081c1c6d1534062 Y register_cf_node_1081c1c6d1534062 0
Vregister_cf_1081c1c6d1534062_source VPWR register_cf_node_1081c1c6d1534062_source 0
XMP1 register_cf_node_f486d5533d96e09c A1 register_cf_node_f486d5533d96e09c_source VPWR sky130_fd_pr__pfet_01v8_hvt w=2.6 l=0.15 nf=1 m=1
Vregister_cf_f486d5533d96e09c Y register_cf_node_f486d5533d96e09c 0
Vregister_cf_f486d5533d96e09c_source VPWR register_cf_node_f486d5533d96e09c_source 0
.ends cell_nand2

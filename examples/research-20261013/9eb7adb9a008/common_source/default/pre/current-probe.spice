.subckt common_source IN OUT VPWR VGND
XMN1 register_cf_node_93d25bbc8eacc7ed IN register_cf_node_93d25bbc8eacc7ed_source VGND sky130_fd_pr__nfet_01v8 w=0.65 l=0.15 nf=1 m=1
Vregister_cf_93d25bbc8eacc7ed OUT register_cf_node_93d25bbc8eacc7ed 0
Vregister_cf_93d25bbc8eacc7ed_source VGND register_cf_node_93d25bbc8eacc7ed_source 0
RRD register_cf_node_e15fad05f7a2876b OUT 10000
Vregister_cf_e15fad05f7a2876b VPWR register_cf_node_e15fad05f7a2876b 0
.ends common_source

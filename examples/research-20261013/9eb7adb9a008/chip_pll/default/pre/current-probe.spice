.subckt NAND2 A0 A1 Y VPWR VGND
XMN0 register_cf_node_377cff7a8fc053f0 A0 register_cf_node_377cff7a8fc053f0_source VGND sky130_fd_pr__nfet_01v8 w=0.65 l=0.15 nf=1 m=1
Vregister_cf_377cff7a8fc053f0 Y register_cf_node_377cff7a8fc053f0 0
Vregister_cf_377cff7a8fc053f0_source N1 register_cf_node_377cff7a8fc053f0_source 0
XMN1 register_cf_node_12c0ec391985518a A1 register_cf_node_12c0ec391985518a_source VGND sky130_fd_pr__nfet_01v8 w=0.65 l=0.15 nf=1 m=1
Vregister_cf_12c0ec391985518a N1 register_cf_node_12c0ec391985518a 0
Vregister_cf_12c0ec391985518a_source VGND register_cf_node_12c0ec391985518a_source 0
XMP0 register_cf_node_1c0f6f4ae9f406c8 A0 register_cf_node_1c0f6f4ae9f406c8_source VPWR sky130_fd_pr__pfet_01v8_hvt w=0.65 l=0.15 nf=1 m=1
Vregister_cf_1c0f6f4ae9f406c8 Y register_cf_node_1c0f6f4ae9f406c8 0
Vregister_cf_1c0f6f4ae9f406c8_source VPWR register_cf_node_1c0f6f4ae9f406c8_source 0
XMP1 register_cf_node_092f3ee2a80b5958 A1 register_cf_node_092f3ee2a80b5958_source VPWR sky130_fd_pr__pfet_01v8_hvt w=0.65 l=0.15 nf=1 m=1
Vregister_cf_092f3ee2a80b5958 Y register_cf_node_092f3ee2a80b5958 0
Vregister_cf_092f3ee2a80b5958_source VPWR register_cf_node_092f3ee2a80b5958_source 0
.ends NAND2
.subckt XOR2 A B Y VPWR VGND
XN1 A B N1 VPWR VGND NAND2
XN2 A N1 N2 VPWR VGND NAND2
XN3 B N1 N3 VPWR VGND NAND2
XN4 N2 N3 Y VPWR VGND NAND2
.ends XOR2
.subckt RING_VCO CTRL OUT VPWR VGND
CC_STAGE0 register_cf_node_3867cc6f76c40144 VGND 5e-13
Vregister_cf_3867cc6f76c40144 Q0 register_cf_node_3867cc6f76c40144 0
CC_STAGE1 register_cf_node_5a84de89dae31852 VGND 5e-13
Vregister_cf_5a84de89dae31852 Q1 register_cf_node_5a84de89dae31852 0
CC_STAGE2 register_cf_node_227b8b9b1329e08e VGND 5e-13
Vregister_cf_227b8b9b1329e08e OUT register_cf_node_227b8b9b1329e08e 0
XN_BIAS register_cf_node_bd942ff9c2bcdf87 CTRL register_cf_node_bd942ff9c2bcdf87_source VGND sky130_fd_pr__nfet_01v8 w=5 l=0.5 nf=1 m=1
Vregister_cf_bd942ff9c2bcdf87 PBIAS register_cf_node_bd942ff9c2bcdf87 0
Vregister_cf_bd942ff9c2bcdf87_source VGND register_cf_node_bd942ff9c2bcdf87_source 0
XN_INV0 register_cf_node_33531960e1bd1e76 OUT register_cf_node_33531960e1bd1e76_source VGND sky130_fd_pr__nfet_01v8 w=4 l=0.15 nf=1 m=1
Vregister_cf_33531960e1bd1e76 Q0 register_cf_node_33531960e1bd1e76 0
Vregister_cf_33531960e1bd1e76_source N0 register_cf_node_33531960e1bd1e76_source 0
XN_INV1 register_cf_node_fd2a22b5393e7cb3 Q0 register_cf_node_fd2a22b5393e7cb3_source VGND sky130_fd_pr__nfet_01v8 w=4 l=0.15 nf=1 m=1
Vregister_cf_fd2a22b5393e7cb3 Q1 register_cf_node_fd2a22b5393e7cb3 0
Vregister_cf_fd2a22b5393e7cb3_source N1 register_cf_node_fd2a22b5393e7cb3_source 0
XN_INV2 register_cf_node_471fd7a674828182 Q1 register_cf_node_471fd7a674828182_source VGND sky130_fd_pr__nfet_01v8 w=4 l=0.15 nf=1 m=1
Vregister_cf_471fd7a674828182 OUT register_cf_node_471fd7a674828182 0
Vregister_cf_471fd7a674828182_source N2 register_cf_node_471fd7a674828182_source 0
XN_LIMIT0 register_cf_node_ffa878ddc9944e75 CTRL register_cf_node_ffa878ddc9944e75_source VGND sky130_fd_pr__nfet_01v8 w=5 l=0.5 nf=1 m=1
Vregister_cf_ffa878ddc9944e75 N0 register_cf_node_ffa878ddc9944e75 0
Vregister_cf_ffa878ddc9944e75_source VGND register_cf_node_ffa878ddc9944e75_source 0
XN_LIMIT1 register_cf_node_b9a0d36ba731cb04 CTRL register_cf_node_b9a0d36ba731cb04_source VGND sky130_fd_pr__nfet_01v8 w=5 l=0.5 nf=1 m=1
Vregister_cf_b9a0d36ba731cb04 N1 register_cf_node_b9a0d36ba731cb04 0
Vregister_cf_b9a0d36ba731cb04_source VGND register_cf_node_b9a0d36ba731cb04_source 0
XN_LIMIT2 register_cf_node_e270ea1b4cc1b8cf CTRL register_cf_node_e270ea1b4cc1b8cf_source VGND sky130_fd_pr__nfet_01v8 w=5 l=0.5 nf=1 m=1
Vregister_cf_e270ea1b4cc1b8cf N2 register_cf_node_e270ea1b4cc1b8cf 0
Vregister_cf_e270ea1b4cc1b8cf_source VGND register_cf_node_e270ea1b4cc1b8cf_source 0
XP_BIAS register_cf_node_3b2e3853737c9d43 PBIAS register_cf_node_3b2e3853737c9d43_source VPWR sky130_fd_pr__pfet_01v8_hvt w=10 l=0.5 nf=1 m=1
Vregister_cf_3b2e3853737c9d43 PBIAS register_cf_node_3b2e3853737c9d43 0
Vregister_cf_3b2e3853737c9d43_source VPWR register_cf_node_3b2e3853737c9d43_source 0
XP_INV0 register_cf_node_39cbcce4e5591b8b OUT register_cf_node_39cbcce4e5591b8b_source VPWR sky130_fd_pr__pfet_01v8_hvt w=8 l=0.15 nf=1 m=1
Vregister_cf_39cbcce4e5591b8b Q0 register_cf_node_39cbcce4e5591b8b 0
Vregister_cf_39cbcce4e5591b8b_source P0 register_cf_node_39cbcce4e5591b8b_source 0
XP_INV1 register_cf_node_e154dcb4d988e5be Q0 register_cf_node_e154dcb4d988e5be_source VPWR sky130_fd_pr__pfet_01v8_hvt w=8 l=0.15 nf=1 m=1
Vregister_cf_e154dcb4d988e5be Q1 register_cf_node_e154dcb4d988e5be 0
Vregister_cf_e154dcb4d988e5be_source P1 register_cf_node_e154dcb4d988e5be_source 0
XP_INV2 register_cf_node_5d2140eee831956c Q1 register_cf_node_5d2140eee831956c_source VPWR sky130_fd_pr__pfet_01v8_hvt w=8 l=0.15 nf=1 m=1
Vregister_cf_5d2140eee831956c OUT register_cf_node_5d2140eee831956c 0
Vregister_cf_5d2140eee831956c_source P2 register_cf_node_5d2140eee831956c_source 0
XP_LIMIT0 register_cf_node_ce582c4bc1041629 PBIAS register_cf_node_ce582c4bc1041629_source VPWR sky130_fd_pr__pfet_01v8_hvt w=10 l=0.5 nf=1 m=1
Vregister_cf_ce582c4bc1041629 P0 register_cf_node_ce582c4bc1041629 0
Vregister_cf_ce582c4bc1041629_source VPWR register_cf_node_ce582c4bc1041629_source 0
XP_LIMIT1 register_cf_node_745d62d3ac19bbd9 PBIAS register_cf_node_745d62d3ac19bbd9_source VPWR sky130_fd_pr__pfet_01v8_hvt w=10 l=0.5 nf=1 m=1
Vregister_cf_745d62d3ac19bbd9 P1 register_cf_node_745d62d3ac19bbd9 0
Vregister_cf_745d62d3ac19bbd9_source VPWR register_cf_node_745d62d3ac19bbd9_source 0
XP_LIMIT2 register_cf_node_3ea8acbf3ce3dd23 PBIAS register_cf_node_3ea8acbf3ce3dd23_source VPWR sky130_fd_pr__pfet_01v8_hvt w=10 l=0.5 nf=1 m=1
Vregister_cf_3ea8acbf3ce3dd23 P2 register_cf_node_3ea8acbf3ce3dd23 0
Vregister_cf_3ea8acbf3ce3dd23_source VPWR register_cf_node_3ea8acbf3ce3dd23_source 0
.ends RING_VCO
.subckt chip_pll REF CTRL OUT VPWR VGND
CC_FILTER register_cf_node_4fcb2be9b20c435a VGND 1e-11
Vregister_cf_4fcb2be9b20c435a CTRL register_cf_node_4fcb2be9b20c435a 0
XOSCILLATOR TUNE OUT VPWR VGND RING_VCO
XPHASE_DETECTOR REF OUT PD VPWR VGND XOR2
RR_BIAS_BOTTOM register_cf_node_e67a5633d425e43b VGND 100000
Vregister_cf_e67a5633d425e43b TUNE register_cf_node_e67a5633d425e43b 0
RR_BIAS_TOP register_cf_node_240b9376c2a3871b TUNE 100000
Vregister_cf_240b9376c2a3871b VPWR register_cf_node_240b9376c2a3871b 0
RR_FILTER register_cf_node_26e5afaf70deff77 CTRL 20000
Vregister_cf_26e5afaf70deff77 PD register_cf_node_26e5afaf70deff77 0
RR_TUNE register_cf_node_092bb5fb2878d2b0 TUNE 1000000
Vregister_cf_092bb5fb2878d2b0 CTRL register_cf_node_092bb5fb2878d2b0 0
.ends chip_pll

.subckt NAND2 A0 A1 Y VPWR VGND
XMN0 Y A0 N1 VGND sky130_fd_pr__nfet_01v8 w=0.65 l=0.15 nf=1 m=1
XMN1 N1 A1 VGND VGND sky130_fd_pr__nfet_01v8 w=0.65 l=0.15 nf=1 m=1
XMP0 Y A0 VPWR VPWR sky130_fd_pr__pfet_01v8_hvt w=0.65 l=0.15 nf=1 m=1
XMP1 Y A1 VPWR VPWR sky130_fd_pr__pfet_01v8_hvt w=0.65 l=0.15 nf=1 m=1
.ends NAND2
.subckt XOR2 A B Y VPWR VGND
XN1 A B N1 VPWR VGND NAND2
XN2 A N1 N2 VPWR VGND NAND2
XN3 B N1 N3 VPWR VGND NAND2
XN4 N2 N3 Y VPWR VGND NAND2
.ends XOR2
.subckt RING_VCO CTRL OUT VPWR VGND
CC_STAGE0 Q0 VGND 5e-13
CC_STAGE1 Q1 VGND 5e-13
CC_STAGE2 OUT VGND 5e-13
XN_BIAS PBIAS CTRL VGND VGND sky130_fd_pr__nfet_01v8 w=5 l=0.5 nf=1 m=1
XN_INV0 Q0 OUT N0 VGND sky130_fd_pr__nfet_01v8 w=4 l=0.15 nf=1 m=1
XN_INV1 Q1 Q0 N1 VGND sky130_fd_pr__nfet_01v8 w=4 l=0.15 nf=1 m=1
XN_INV2 OUT Q1 N2 VGND sky130_fd_pr__nfet_01v8 w=4 l=0.15 nf=1 m=1
XN_LIMIT0 N0 CTRL VGND VGND sky130_fd_pr__nfet_01v8 w=5 l=0.5 nf=1 m=1
XN_LIMIT1 N1 CTRL VGND VGND sky130_fd_pr__nfet_01v8 w=5 l=0.5 nf=1 m=1
XN_LIMIT2 N2 CTRL VGND VGND sky130_fd_pr__nfet_01v8 w=5 l=0.5 nf=1 m=1
XP_BIAS PBIAS PBIAS VPWR VPWR sky130_fd_pr__pfet_01v8_hvt w=10 l=0.5 nf=1 m=1
XP_INV0 Q0 OUT P0 VPWR sky130_fd_pr__pfet_01v8_hvt w=8 l=0.15 nf=1 m=1
XP_INV1 Q1 Q0 P1 VPWR sky130_fd_pr__pfet_01v8_hvt w=8 l=0.15 nf=1 m=1
XP_INV2 OUT Q1 P2 VPWR sky130_fd_pr__pfet_01v8_hvt w=8 l=0.15 nf=1 m=1
XP_LIMIT0 P0 PBIAS VPWR VPWR sky130_fd_pr__pfet_01v8_hvt w=10 l=0.5 nf=1 m=1
XP_LIMIT1 P1 PBIAS VPWR VPWR sky130_fd_pr__pfet_01v8_hvt w=10 l=0.5 nf=1 m=1
XP_LIMIT2 P2 PBIAS VPWR VPWR sky130_fd_pr__pfet_01v8_hvt w=10 l=0.5 nf=1 m=1
.ends RING_VCO
.subckt chip_pll REF CTRL OUT VPWR VGND
CC_FILTER CTRL VGND 1e-11
XOSCILLATOR TUNE OUT VPWR VGND RING_VCO
XPHASE_DETECTOR REF OUT PD VPWR VGND XOR2
RR_BIAS_BOTTOM TUNE VGND 100000
RR_BIAS_TOP VPWR TUNE 100000
RR_FILTER PD CTRL 20000
RR_TUNE CTRL TUNE 1000000
.ends chip_pll

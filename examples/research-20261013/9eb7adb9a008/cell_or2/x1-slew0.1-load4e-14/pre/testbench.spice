Resistor public CMOS cell actual input truth matrix
.include "/workspace/.runtime/eda/runs/576c9fa544cb4016ad4551180cadd1e1/supported-tt.spice"
.option scale=1e-6
.include "/workspace/.runtime/eda/runs/576c9fa544cb4016ad4551180cadd1e1/current-probe.spice"
.temp 27.0
VGND VGND 0 0
VDD VPWR VGND 1.8
VA A VGND PWL(0 0 5e-08 0 5.01e-08 1.8 1e-07 1.8 1.001e-07 0 1.5e-07 0 1.501e-07 1.8 2e-07 1.8 2.001e-07 0 2.5e-07 0 2.501e-07 1.8 3e-07 1.8 3.001e-07 0 3.5e-07 0 3.501e-07 0 4e-07 0 4.001e-07 1.8 4.5e-07 1.8 4.501e-07 0 5e-07 0 5.001e-07 0 5.5e-07 0 5.501e-07 0 6e-07 0)
VB B VGND PWL(0 0 5e-08 0 5.01e-08 0 1e-07 0 1.001e-07 1.8 1.5e-07 1.8 1.501e-07 1.8 2e-07 1.8 2.001e-07 0 2.5e-07 0 2.501e-07 0 3e-07 0 3.001e-07 0 3.5e-07 0 3.501e-07 1.8 4e-07 1.8 4.001e-07 0 4.5e-07 0 4.501e-07 0 5e-07 0 5.001e-07 1.8 5.5e-07 1.8 5.501e-07 0 6e-07 0)
CLOAD Y VGND 4e-14
XU A B Y VPWR VGND cell_or2
.control
save v(A) v(B) v(Y) i(VDD) i(v.xu.xbuf.vregister_cf_37eac2f2e7d80b63) i(v.xu.xbuf.vregister_cf_684eb771bbecb33a) i(v.xu.xcore.vregister_cf_40f4e68d977a2d21) i(v.xu.xcore.vregister_cf_ceed8e7771b3bb8b) i(v.xu.xcore.vregister_cf_b7a54d16593fd7b2) i(v.xu.xcore.vregister_cf_513ed0843ecfc45c) i(VGND) i(VA) i(VB) v(VGND) v(XU.N) v(VPWR) v(XU.XCORE.N)
set numdgt=17
set wr_singlescale
set wr_vecnames
tran 1e-11 6e-07 0 1e-11
let mos_wave_0 = v(A)
let mos_wave_1 = v(B)
let mos_wave_2 = v(Y)
let mos_wave_3 = -i(VDD)
wrdata waveform.dat mos_wave_0 mos_wave_1 mos_wave_2 mos_wave_3
write waveform.raw all
let register_flow_0 = i(v.xu.xbuf.vregister_cf_37eac2f2e7d80b63)
let register_flow_1 = i(v.xu.xbuf.vregister_cf_684eb771bbecb33a)
let register_flow_2 = i(v.xu.xcore.vregister_cf_40f4e68d977a2d21)
let register_flow_3 = i(v.xu.xcore.vregister_cf_ceed8e7771b3bb8b)
let register_flow_4 = i(v.xu.xcore.vregister_cf_b7a54d16593fd7b2)
let register_flow_5 = i(v.xu.xcore.vregister_cf_513ed0843ecfc45c)
let register_flow_6 = i(VGND)
let register_flow_7 = i(VDD)
let register_flow_8 = i(VA)
let register_flow_9 = i(VB)
wrdata current-flow.dat register_flow_0 register_flow_1 register_flow_2 register_flow_3 register_flow_4 register_flow_5 register_flow_6 register_flow_7 register_flow_8 register_flow_9
let register_voltage_0 = v(Y)
let register_voltage_1 = v(VGND)
let register_voltage_2 = v(XU.N)
let register_voltage_3 = v(VPWR)
let register_voltage_4 = v(A)
let register_voltage_5 = v(B)
let register_voltage_6 = v(XU.XCORE.N)
let register_voltage_7 = 0*register_flow_0
wrdata node-voltages.dat register_voltage_0 register_voltage_1 register_voltage_2 register_voltage_3 register_voltage_4 register_voltage_5 register_voltage_6 register_voltage_7
quit
.endc
.end

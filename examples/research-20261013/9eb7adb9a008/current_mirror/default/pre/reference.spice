.subckt current_mirror REF OUT VGND
XMN1 REF REF VGND VGND sky130_fd_pr__nfet_01v8 w=0.65 l=0.15 nf=1 m=1
XMN2 OUT REF VGND VGND sky130_fd_pr__nfet_01v8 w=0.65 l=0.15 nf=1 m=1
.ends current_mirror

.subckt chip_ldo VREF BIAS OUT VPWR VGND
XC_COMP_P0 GATE COMP sky130_fd_pr__cap_mim_m3_1 w=28.68 l=28.68
XC_COMP_P1 GATE COMP sky130_fd_pr__cap_mim_m3_1 w=28.68 l=28.68
XC_COMP_P10 GATE COMP sky130_fd_pr__cap_mim_m3_1 w=28.68 l=28.68
XC_COMP_P11 GATE COMP sky130_fd_pr__cap_mim_m3_1 w=28.68 l=28.68
XC_COMP_P2 GATE COMP sky130_fd_pr__cap_mim_m3_1 w=28.68 l=28.68
XC_COMP_P3 GATE COMP sky130_fd_pr__cap_mim_m3_1 w=28.68 l=28.68
XC_COMP_P4 GATE COMP sky130_fd_pr__cap_mim_m3_1 w=28.68 l=28.68
XC_COMP_P5 GATE COMP sky130_fd_pr__cap_mim_m3_1 w=28.68 l=28.68
XC_COMP_P6 GATE COMP sky130_fd_pr__cap_mim_m3_1 w=28.68 l=28.68
XC_COMP_P7 GATE COMP sky130_fd_pr__cap_mim_m3_1 w=28.68 l=28.68
XC_COMP_P8 GATE COMP sky130_fd_pr__cap_mim_m3_1 w=28.68 l=28.68
XC_COMP_P9 GATE COMP sky130_fd_pr__cap_mim_m3_1 w=28.68 l=28.68
XERROR_AMP_N_INN ERROR_AMP__MIR FB ERROR_AMP__TAIL VGND sky130_fd_pr__nfet_01v8 w=10 l=1 nf=1 m=1
XERROR_AMP_N_INP GATE VREF ERROR_AMP__TAIL VGND sky130_fd_pr__nfet_01v8 w=10 l=1 nf=1 m=1
XERROR_AMP_N_TAIL ERROR_AMP__TAIL BIAS VGND VGND sky130_fd_pr__nfet_01v8 w=2 l=1 nf=1 m=1
XERROR_AMP_P_DIODE ERROR_AMP__MIR ERROR_AMP__MIR VPWR VPWR sky130_fd_pr__pfet_01v8_hvt w=20 l=1 nf=1 m=1
XERROR_AMP_P_MIRROR GATE ERROR_AMP__MIR VPWR VPWR sky130_fd_pr__pfet_01v8_hvt w=20 l=1 nf=1 m=1
XPASS0 OUT GATE VPWR VPWR sky130_fd_pr__pfet_01v8_hvt w=20 l=0.15 nf=1 m=1
XPASS1 OUT GATE VPWR VPWR sky130_fd_pr__pfet_01v8_hvt w=20 l=0.15 nf=1 m=1
XPASS2 OUT GATE VPWR VPWR sky130_fd_pr__pfet_01v8_hvt w=20 l=0.15 nf=1 m=1
XPASS3 OUT GATE VPWR VPWR sky130_fd_pr__pfet_01v8_hvt w=20 l=0.15 nf=1 m=1
XPASS4 OUT GATE VPWR VPWR sky130_fd_pr__pfet_01v8_hvt w=20 l=0.15 nf=1 m=1
XR_FB_BOTTOM_P0 FB R_FB_BOTTOM_R0_N0 VGND sky130_fd_pr__res_xhigh_po_1p41 l=28.035
XR_FB_BOTTOM_P1 R_FB_BOTTOM_R0_N0 R_FB_BOTTOM_R0_N1 VGND sky130_fd_pr__res_xhigh_po_1p41 l=28.035
XR_FB_BOTTOM_P2 R_FB_BOTTOM_R0_N1 R_FB_BOTTOM_R0_N2 VGND sky130_fd_pr__res_xhigh_po_1p41 l=28.035
XR_FB_BOTTOM_P3 R_FB_BOTTOM_R0_N2 R_FB_BOTTOM_R0_N3 VGND sky130_fd_pr__res_xhigh_po_1p41 l=28.035
XR_FB_BOTTOM_P4 R_FB_BOTTOM_R0_N3 VGND VGND sky130_fd_pr__res_xhigh_po_1p41 l=28.035
XR_FB_TOP_P0 OUT R_FB_TOP_R0_N0 VGND sky130_fd_pr__res_xhigh_po_1p41 l=28.035
XR_FB_TOP_P1 R_FB_TOP_R0_N0 R_FB_TOP_R0_N1 VGND sky130_fd_pr__res_xhigh_po_1p41 l=28.035
XR_FB_TOP_P2 R_FB_TOP_R0_N1 R_FB_TOP_R0_N2 VGND sky130_fd_pr__res_xhigh_po_1p41 l=28.035
XR_FB_TOP_P3 R_FB_TOP_R0_N2 R_FB_TOP_R0_N3 VGND sky130_fd_pr__res_xhigh_po_1p41 l=28.035
XR_FB_TOP_P4 R_FB_TOP_R0_N3 FB VGND sky130_fd_pr__res_xhigh_po_1p41 l=28.035
XR_ZERO_P0 COMP OUT VGND sky130_fd_pr__res_xhigh_po_1p41 l=0.54
.ends chip_ldo

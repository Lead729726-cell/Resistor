.subckt cell_inv A Y VPWR VGND
XMN Y A VGND VGND sky130_fd_pr__nfet_01v8 w=2.6 l=0.15 nf=1 m=1
XMP Y A VPWR VPWR sky130_fd_pr__pfet_01v8_hvt w=2.6 l=0.15 nf=1 m=1
.ends cell_inv

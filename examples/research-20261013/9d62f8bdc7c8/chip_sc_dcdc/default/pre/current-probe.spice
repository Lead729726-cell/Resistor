.subckt chip_sc_dcdc PHI1 PHI1B PHI2 PHI2B OUT VPWR VGND
XN_BOTTOM_CHARGE register_cf_node_3c1ae243e0461cec PHI1 register_cf_node_3c1ae243e0461cec_source VGND sky130_fd_pr__nfet_01v8 w=20 l=0.15 nf=1 m=1
Vregister_cf_3c1ae243e0461cec OUT register_cf_node_3c1ae243e0461cec 0
Vregister_cf_3c1ae243e0461cec_source FLYBOTTOM register_cf_node_3c1ae243e0461cec_source 0
XN_BOTTOM_TRANSFER register_cf_node_4b2cc0664d4f8ee5 PHI2 register_cf_node_4b2cc0664d4f8ee5_source VGND sky130_fd_pr__nfet_01v8 w=20 l=0.15 nf=1 m=1
Vregister_cf_4b2cc0664d4f8ee5 FLYBOTTOM register_cf_node_4b2cc0664d4f8ee5 0
Vregister_cf_4b2cc0664d4f8ee5_source VGND register_cf_node_4b2cc0664d4f8ee5_source 0
XN_TOP_CHARGE register_cf_node_26022b929921ff94 PHI1 register_cf_node_26022b929921ff94_source VGND sky130_fd_pr__nfet_01v8 w=20 l=0.15 nf=1 m=1
Vregister_cf_26022b929921ff94 VPWR register_cf_node_26022b929921ff94 0
Vregister_cf_26022b929921ff94_source FLYTOP register_cf_node_26022b929921ff94_source 0
XN_TOP_TRANSFER register_cf_node_81887fac5d22173f PHI2 register_cf_node_81887fac5d22173f_source VGND sky130_fd_pr__nfet_01v8 w=20 l=0.15 nf=1 m=1
Vregister_cf_81887fac5d22173f FLYTOP register_cf_node_81887fac5d22173f 0
Vregister_cf_81887fac5d22173f_source OUT register_cf_node_81887fac5d22173f_source 0
XP_BOTTOM_CHARGE register_cf_node_b74705dc0e0122c5 PHI1B register_cf_node_b74705dc0e0122c5_source VPWR sky130_fd_pr__pfet_01v8_hvt w=20 l=0.15 nf=1 m=1
Vregister_cf_b74705dc0e0122c5 OUT register_cf_node_b74705dc0e0122c5 0
Vregister_cf_b74705dc0e0122c5_source FLYBOTTOM register_cf_node_b74705dc0e0122c5_source 0
XP_BOTTOM_TRANSFER register_cf_node_a491c787bfff7a6c PHI2B register_cf_node_a491c787bfff7a6c_source VPWR sky130_fd_pr__pfet_01v8_hvt w=20 l=0.15 nf=1 m=1
Vregister_cf_a491c787bfff7a6c FLYBOTTOM register_cf_node_a491c787bfff7a6c 0
Vregister_cf_a491c787bfff7a6c_source VGND register_cf_node_a491c787bfff7a6c_source 0
XP_TOP_CHARGE register_cf_node_16333635d80f45c8 PHI1B register_cf_node_16333635d80f45c8_source VPWR sky130_fd_pr__pfet_01v8_hvt w=20 l=0.15 nf=1 m=1
Vregister_cf_16333635d80f45c8 VPWR register_cf_node_16333635d80f45c8 0
Vregister_cf_16333635d80f45c8_source FLYTOP register_cf_node_16333635d80f45c8_source 0
XP_TOP_TRANSFER register_cf_node_2c801747b661ae05 PHI2B register_cf_node_2c801747b661ae05_source VPWR sky130_fd_pr__pfet_01v8_hvt w=20 l=0.15 nf=1 m=1
Vregister_cf_2c801747b661ae05 FLYTOP register_cf_node_2c801747b661ae05 0
Vregister_cf_2c801747b661ae05_source OUT register_cf_node_2c801747b661ae05_source 0
.ends chip_sc_dcdc

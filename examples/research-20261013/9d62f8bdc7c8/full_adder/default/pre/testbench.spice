Register actual transistor digital full_adder
.options klu noinit method=gear maxord=2
.include "/workspace/.runtime/eda/runs/bf200e1eb68848b383c09fd8f250379e/supported-tt.spice"
.option scale=1e-6
.include "/workspace/.runtime/eda/runs/bf200e1eb68848b383c09fd8f250379e/current-probe.spice"
.temp 27.0
VGND VGND 0 0
VDD VPWR VGND 1.8
VA A VGND PWL(0 0 4e-07 0 4.001e-07 1.8 8e-07 1.8)
VB B VGND PWL(0 0 2e-07 0 2.001e-07 1.8 4e-07 1.8 4.001e-07 0 6e-07 0 6.001e-07 1.8 8e-07 1.8)
VCIN CIN VGND PWL(0 0 1e-07 0 1.001e-07 1.8 2e-07 1.8 2.001e-07 0 3e-07 0 3.001e-07 1.8 4e-07 1.8 4.001e-07 0 5e-07 0 5.001e-07 1.8 6e-07 1.8 6.001e-07 0 7e-07 0 7.001e-07 1.8 8e-07 1.8)
CLOAD_SUM SUM VGND 5e-15
CLOAD_COUT COUT VGND 5e-15
XU A B CIN SUM COUT VPWR VGND full_adder
.control
save v(A) v(B) v(CIN) v(SUM) v(COUT) i(VDD) i(v.xu.xn1.vregister_cf_377cff7a8fc053f0) i(v.xu.xn1.vregister_cf_12c0ec391985518a) i(v.xu.xn1.vregister_cf_1c0f6f4ae9f406c8) i(v.xu.xn1.vregister_cf_092f3ee2a80b5958) i(v.xu.xn2.vregister_cf_377cff7a8fc053f0) i(v.xu.xn2.vregister_cf_12c0ec391985518a) i(v.xu.xn2.vregister_cf_1c0f6f4ae9f406c8) i(v.xu.xn2.vregister_cf_092f3ee2a80b5958) i(v.xu.xn3.vregister_cf_377cff7a8fc053f0) i(v.xu.xn3.vregister_cf_12c0ec391985518a) i(v.xu.xn3.vregister_cf_1c0f6f4ae9f406c8) i(v.xu.xn3.vregister_cf_092f3ee2a80b5958) i(v.xu.xn4.vregister_cf_377cff7a8fc053f0) i(v.xu.xn4.vregister_cf_12c0ec391985518a) i(v.xu.xn4.vregister_cf_1c0f6f4ae9f406c8) i(v.xu.xn4.vregister_cf_092f3ee2a80b5958) i(v.xu.xn5.vregister_cf_377cff7a8fc053f0) i(v.xu.xn5.vregister_cf_12c0ec391985518a) i(v.xu.xn5.vregister_cf_1c0f6f4ae9f406c8) i(v.xu.xn5.vregister_cf_092f3ee2a80b5958) i(v.xu.xn6.vregister_cf_377cff7a8fc053f0) i(v.xu.xn6.vregister_cf_12c0ec391985518a) i(v.xu.xn6.vregister_cf_1c0f6f4ae9f406c8) i(v.xu.xn6.vregister_cf_092f3ee2a80b5958) i(v.xu.xn7.vregister_cf_377cff7a8fc053f0) i(v.xu.xn7.vregister_cf_12c0ec391985518a) i(v.xu.xn7.vregister_cf_1c0f6f4ae9f406c8) i(v.xu.xn7.vregister_cf_092f3ee2a80b5958) i(v.xu.xn8.vregister_cf_377cff7a8fc053f0) i(v.xu.xn8.vregister_cf_12c0ec391985518a) i(v.xu.xn8.vregister_cf_1c0f6f4ae9f406c8) i(v.xu.xn8.vregister_cf_092f3ee2a80b5958) i(v.xu.xn9.vregister_cf_377cff7a8fc053f0) i(v.xu.xn9.vregister_cf_12c0ec391985518a) i(v.xu.xn9.vregister_cf_1c0f6f4ae9f406c8) i(v.xu.xn9.vregister_cf_092f3ee2a80b5958) i(VGND) i(VA) i(VB) i(VCIN) v(XU.N1) v(XU.XN1.N1) v(VGND) v(VPWR) v(XU.N2) v(XU.XN2.N1) v(XU.N3) v(XU.XN3.N1) v(XU.P) v(XU.XN4.N1) v(XU.N5) v(XU.XN5.N1) v(XU.N6) v(XU.XN6.N1) v(XU.N7) v(XU.XN7.N1) v(XU.XN8.N1) v(XU.XN9.N1)
set num_threads=1
set noaskquit
set wr_singlescale
set wr_vecnames
tran 1e-09 8e-07
let mos_wave_0 = v(A)
let mos_wave_1 = v(B)
let mos_wave_2 = v(CIN)
let mos_wave_3 = v(SUM)
let mos_wave_4 = v(COUT)
let mos_wave_5 = -i(VDD)
wrdata waveform.dat mos_wave_0 mos_wave_1 mos_wave_2 mos_wave_3 mos_wave_4 mos_wave_5
write waveform.raw all
let register_flow_0 = i(v.xu.xn1.vregister_cf_377cff7a8fc053f0)
let register_flow_1 = i(v.xu.xn1.vregister_cf_12c0ec391985518a)
let register_flow_2 = i(v.xu.xn1.vregister_cf_1c0f6f4ae9f406c8)
let register_flow_3 = i(v.xu.xn1.vregister_cf_092f3ee2a80b5958)
let register_flow_4 = i(v.xu.xn2.vregister_cf_377cff7a8fc053f0)
let register_flow_5 = i(v.xu.xn2.vregister_cf_12c0ec391985518a)
let register_flow_6 = i(v.xu.xn2.vregister_cf_1c0f6f4ae9f406c8)
let register_flow_7 = i(v.xu.xn2.vregister_cf_092f3ee2a80b5958)
let register_flow_8 = i(v.xu.xn3.vregister_cf_377cff7a8fc053f0)
let register_flow_9 = i(v.xu.xn3.vregister_cf_12c0ec391985518a)
let register_flow_10 = i(v.xu.xn3.vregister_cf_1c0f6f4ae9f406c8)
let register_flow_11 = i(v.xu.xn3.vregister_cf_092f3ee2a80b5958)
let register_flow_12 = i(v.xu.xn4.vregister_cf_377cff7a8fc053f0)
let register_flow_13 = i(v.xu.xn4.vregister_cf_12c0ec391985518a)
let register_flow_14 = i(v.xu.xn4.vregister_cf_1c0f6f4ae9f406c8)
let register_flow_15 = i(v.xu.xn4.vregister_cf_092f3ee2a80b5958)
let register_flow_16 = i(v.xu.xn5.vregister_cf_377cff7a8fc053f0)
let register_flow_17 = i(v.xu.xn5.vregister_cf_12c0ec391985518a)
let register_flow_18 = i(v.xu.xn5.vregister_cf_1c0f6f4ae9f406c8)
let register_flow_19 = i(v.xu.xn5.vregister_cf_092f3ee2a80b5958)
let register_flow_20 = i(v.xu.xn6.vregister_cf_377cff7a8fc053f0)
let register_flow_21 = i(v.xu.xn6.vregister_cf_12c0ec391985518a)
let register_flow_22 = i(v.xu.xn6.vregister_cf_1c0f6f4ae9f406c8)
let register_flow_23 = i(v.xu.xn6.vregister_cf_092f3ee2a80b5958)
let register_flow_24 = i(v.xu.xn7.vregister_cf_377cff7a8fc053f0)
let register_flow_25 = i(v.xu.xn7.vregister_cf_12c0ec391985518a)
let register_flow_26 = i(v.xu.xn7.vregister_cf_1c0f6f4ae9f406c8)
let register_flow_27 = i(v.xu.xn7.vregister_cf_092f3ee2a80b5958)
let register_flow_28 = i(v.xu.xn8.vregister_cf_377cff7a8fc053f0)
let register_flow_29 = i(v.xu.xn8.vregister_cf_12c0ec391985518a)
let register_flow_30 = i(v.xu.xn8.vregister_cf_1c0f6f4ae9f406c8)
let register_flow_31 = i(v.xu.xn8.vregister_cf_092f3ee2a80b5958)
let register_flow_32 = i(v.xu.xn9.vregister_cf_377cff7a8fc053f0)
let register_flow_33 = i(v.xu.xn9.vregister_cf_12c0ec391985518a)
let register_flow_34 = i(v.xu.xn9.vregister_cf_1c0f6f4ae9f406c8)
let register_flow_35 = i(v.xu.xn9.vregister_cf_092f3ee2a80b5958)
let register_flow_36 = i(VGND)
let register_flow_37 = i(VDD)
let register_flow_38 = i(VA)
let register_flow_39 = i(VB)
let register_flow_40 = i(VCIN)
wrdata current-flow.dat register_flow_0 register_flow_1 register_flow_2 register_flow_3 register_flow_4 register_flow_5 register_flow_6 register_flow_7 register_flow_8 register_flow_9 register_flow_10 register_flow_11 register_flow_12 register_flow_13 register_flow_14 register_flow_15 register_flow_16 register_flow_17 register_flow_18 register_flow_19 register_flow_20 register_flow_21 register_flow_22 register_flow_23 register_flow_24 register_flow_25 register_flow_26 register_flow_27 register_flow_28 register_flow_29 register_flow_30 register_flow_31 register_flow_32 register_flow_33 register_flow_34 register_flow_35 register_flow_36 register_flow_37 register_flow_38 register_flow_39 register_flow_40
let register_voltage_0 = v(XU.N1)
let register_voltage_1 = v(XU.XN1.N1)
let register_voltage_2 = v(A)
let register_voltage_3 = v(VGND)
let register_voltage_4 = v(B)
let register_voltage_5 = v(VPWR)
let register_voltage_6 = v(XU.N2)
let register_voltage_7 = v(XU.XN2.N1)
let register_voltage_8 = v(XU.N3)
let register_voltage_9 = v(XU.XN3.N1)
let register_voltage_10 = v(XU.P)
let register_voltage_11 = v(XU.XN4.N1)
let register_voltage_12 = v(XU.N5)
let register_voltage_13 = v(XU.XN5.N1)
let register_voltage_14 = v(CIN)
let register_voltage_15 = v(XU.N6)
let register_voltage_16 = v(XU.XN6.N1)
let register_voltage_17 = v(XU.N7)
let register_voltage_18 = v(XU.XN7.N1)
let register_voltage_19 = v(SUM)
let register_voltage_20 = v(XU.XN8.N1)
let register_voltage_21 = v(COUT)
let register_voltage_22 = v(XU.XN9.N1)
let register_voltage_23 = 0*register_flow_0
wrdata node-voltages.dat register_voltage_0 register_voltage_1 register_voltage_2 register_voltage_3 register_voltage_4 register_voltage_5 register_voltage_6 register_voltage_7 register_voltage_8 register_voltage_9 register_voltage_10 register_voltage_11 register_voltage_12 register_voltage_13 register_voltage_14 register_voltage_15 register_voltage_16 register_voltage_17 register_voltage_18 register_voltage_19 register_voltage_20 register_voltage_21 register_voltage_22 register_voltage_23
quit
.endc
.end

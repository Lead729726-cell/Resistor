* NGSPICE file created from cell_or2.ext - technology: sky130A

.subckt cell_or2 Y VPWR VGND B A
X0 VPWR.t4 A.t0 CORE__N.t1 VPWR.t3 sky130_fd_pr__pfet_01v8_hvt ad=0.1885 pd=1.88 as=0.1885 ps=1.88 w=0.65 l=0.15
X1 VGND.t3 B.t0 N.t0 VGND.t2 sky130_fd_pr__nfet_01v8 ad=0.1885 pd=1.88 as=0.1885 ps=1.88 w=0.65 l=0.15
X2 VGND.t5 A.t1 N.t2 VGND.t4 sky130_fd_pr__nfet_01v8 ad=0.1885 pd=1.88 as=0.1885 ps=1.88 w=0.65 l=0.15
X3 VGND.t1 N.t3 Y.t0 VGND.t0 sky130_fd_pr__nfet_01v8 ad=0.1885 pd=1.88 as=0.1885 ps=1.88 w=0.65 l=0.15
X4 VPWR.t2 N.t4 Y.t1 VPWR.t1 sky130_fd_pr__pfet_01v8_hvt ad=0.1885 pd=1.88 as=0.1885 ps=1.88 w=0.65 l=0.15
X5 CORE__N.t0 B.t1 N.t1 VPWR.t0 sky130_fd_pr__pfet_01v8_hvt ad=0.1885 pd=1.88 as=0.1885 ps=1.88 w=0.65 l=0.15
C0 B CORE__N 0.51851f
C1 A Y 0.00389f
C2 B Y 2.40757f
C3 VPWR N 0.57116f
C4 A N 0.44761f
C5 CORE__N Y 0.0013f
C6 B N 0.70125f
C7 A VPWR 0.42241f
C8 CORE__N N 0.33255f
C9 B VPWR 0.32365f
C10 A B 2.2972f
C11 VPWR CORE__N 0.42356f
C12 Y N 3.96028f
C13 A CORE__N 1.73842f
C14 VPWR Y 0.27336f
R0 A A.t0 330.341
R1 A A.t1 315.88
R2 A.n0 A 30.9089
R3 A.n0 A 29.7837
R4 A A.n0 5.31204
R5 CORE__N.t1 CORE__N.n1 700.484
R6 CORE__N.n2 CORE__N.t1 700.484
R7 CORE__N.t0 CORE__N.n0 700.484
R8 CORE__N.n5 CORE__N.t0 700.484
R9 CORE__N.n4 CORE__N.n3 20.8153
R10 CORE__N CORE__N.n1 12.8005
R11 CORE__N.n2 CORE__N 12.8005
R12 CORE__N CORE__N.n0 12.8005
R13 CORE__N CORE__N.n5 12.8005
R14 CORE__N.n3 CORE__N.n1 10.1513
R15 CORE__N.n3 CORE__N.n2 10.1513
R16 CORE__N.n4 CORE__N.n0 10.1513
R17 CORE__N.n5 CORE__N.n4 10.1513
R18 VPWR.n53 VPWR.n41 832.942
R19 VPWR.n64 VPWR.n42 832.942
R20 VPWR.n66 VPWR.n39 832.942
R21 VPWR.n48 VPWR.n38 832.942
R22 VPWR.n20 VPWR.n8 832.942
R23 VPWR.n31 VPWR.n9 832.942
R24 VPWR.n33 VPWR.n6 832.942
R25 VPWR.n15 VPWR.n5 832.942
R26 VPWR.n90 VPWR.n78 832.942
R27 VPWR.n101 VPWR.n79 832.942
R28 VPWR.n103 VPWR.n76 832.942
R29 VPWR.n85 VPWR.n75 832.942
R30 VPWR.t4 VPWR.n69 700.484
R31 VPWR.n70 VPWR.t4 700.484
R32 VPWR.t2 VPWR.n0 700.484
R33 VPWR.n1 VPWR.t2 700.484
R34 VPWR.n64 VPWR.n41 240
R35 VPWR.n60 VPWR.n58 240
R36 VPWR.n66 VPWR.n38 240
R37 VPWR.n45 VPWR.n44 240
R38 VPWR.n31 VPWR.n8 240
R39 VPWR.n27 VPWR.n25 240
R40 VPWR.n33 VPWR.n5 240
R41 VPWR.n12 VPWR.n11 240
R42 VPWR.n101 VPWR.n78 240
R43 VPWR.n97 VPWR.n95 240
R44 VPWR.n103 VPWR.n75 240
R45 VPWR.n82 VPWR.n81 240
R46 VPWR.n51 VPWR.n50 207.394
R47 VPWR.n65 VPWR.n40 207.394
R48 VPWR.n18 VPWR.n17 207.394
R49 VPWR.n32 VPWR.n7 207.394
R50 VPWR.n88 VPWR.n87 207.394
R51 VPWR.n102 VPWR.n77 207.394
R52 VPWR.n48 VPWR.n47 185
R53 VPWR.n46 VPWR.n45 185
R54 VPWR.n44 VPWR.n43 185
R55 VPWR.n54 VPWR.n53 185
R56 VPWR.n55 VPWR.n41 185
R57 VPWR.n50 VPWR.n41 185
R58 VPWR.n64 VPWR.n63 185
R59 VPWR.n65 VPWR.n64 185
R60 VPWR.n62 VPWR.n42 185
R61 VPWR.n61 VPWR.n60 185
R62 VPWR.n58 VPWR.n56 185
R63 VPWR.n39 VPWR.n37 185
R64 VPWR.n67 VPWR.n66 185
R65 VPWR.n66 VPWR.n65 185
R66 VPWR.n38 VPWR.n36 185
R67 VPWR.n50 VPWR.n38 185
R68 VPWR.n15 VPWR.n14 185
R69 VPWR.n13 VPWR.n12 185
R70 VPWR.n11 VPWR.n10 185
R71 VPWR.n21 VPWR.n20 185
R72 VPWR.n22 VPWR.n8 185
R73 VPWR.n17 VPWR.n8 185
R74 VPWR.n31 VPWR.n30 185
R75 VPWR.n32 VPWR.n31 185
R76 VPWR.n29 VPWR.n9 185
R77 VPWR.n28 VPWR.n27 185
R78 VPWR.n25 VPWR.n23 185
R79 VPWR.n6 VPWR.n4 185
R80 VPWR.n34 VPWR.n33 185
R81 VPWR.n33 VPWR.n32 185
R82 VPWR.n5 VPWR.n3 185
R83 VPWR.n17 VPWR.n5 185
R84 VPWR.n85 VPWR.n84 185
R85 VPWR.n83 VPWR.n82 185
R86 VPWR.n81 VPWR.n80 185
R87 VPWR.n91 VPWR.n90 185
R88 VPWR.n92 VPWR.n78 185
R89 VPWR.n87 VPWR.n78 185
R90 VPWR.n101 VPWR.n100 185
R91 VPWR.n102 VPWR.n101 185
R92 VPWR.n99 VPWR.n79 185
R93 VPWR.n98 VPWR.n97 185
R94 VPWR.n95 VPWR.n93 185
R95 VPWR.n76 VPWR.n74 185
R96 VPWR.n104 VPWR.n103 185
R97 VPWR.n103 VPWR.n102 185
R98 VPWR.n75 VPWR.n73 185
R99 VPWR.n87 VPWR.n75 185
R100 VPWR.n55 VPWR.n54 88.8476
R101 VPWR.n47 VPWR.n36 88.8476
R102 VPWR.n63 VPWR.n62 88.8476
R103 VPWR.n67 VPWR.n37 88.8476
R104 VPWR.n22 VPWR.n21 88.8476
R105 VPWR.n14 VPWR.n3 88.8476
R106 VPWR.n30 VPWR.n29 88.8476
R107 VPWR.n34 VPWR.n4 88.8476
R108 VPWR.n92 VPWR.n91 88.8476
R109 VPWR.n84 VPWR.n73 88.8476
R110 VPWR.n100 VPWR.n99 88.8476
R111 VPWR.n104 VPWR.n74 88.8476
R112 VPWR.n59 VPWR.n42 72.7879
R113 VPWR.n57 VPWR.n39 72.7879
R114 VPWR.n53 VPWR.n52 72.7879
R115 VPWR.n49 VPWR.n45 72.7879
R116 VPWR.n49 VPWR.n48 72.7879
R117 VPWR.n52 VPWR.n44 72.7879
R118 VPWR.n60 VPWR.n59 72.7879
R119 VPWR.n58 VPWR.n57 72.7879
R120 VPWR.n26 VPWR.n9 72.7879
R121 VPWR.n24 VPWR.n6 72.7879
R122 VPWR.n20 VPWR.n19 72.7879
R123 VPWR.n16 VPWR.n12 72.7879
R124 VPWR.n16 VPWR.n15 72.7879
R125 VPWR.n19 VPWR.n11 72.7879
R126 VPWR.n27 VPWR.n26 72.7879
R127 VPWR.n25 VPWR.n24 72.7879
R128 VPWR.n96 VPWR.n79 72.7879
R129 VPWR.n94 VPWR.n76 72.7879
R130 VPWR.n90 VPWR.n89 72.7879
R131 VPWR.n86 VPWR.n82 72.7879
R132 VPWR.n86 VPWR.n85 72.7879
R133 VPWR.n89 VPWR.n81 72.7879
R134 VPWR.n97 VPWR.n96 72.7879
R135 VPWR.n95 VPWR.n94 72.7879
R136 VPWR.n50 VPWR.t0 56.8667
R137 VPWR.n65 VPWR.t0 56.8667
R138 VPWR.n17 VPWR.t1 56.8667
R139 VPWR.n32 VPWR.t1 56.8667
R140 VPWR.n87 VPWR.t3 56.8667
R141 VPWR.n102 VPWR.t3 56.8667
R142 VPWR.n51 VPWR.n49 56.1076
R143 VPWR.n52 VPWR.n51 56.1076
R144 VPWR.n59 VPWR.n40 56.1076
R145 VPWR.n57 VPWR.n40 56.1076
R146 VPWR.n18 VPWR.n16 56.1076
R147 VPWR.n19 VPWR.n18 56.1076
R148 VPWR.n26 VPWR.n7 56.1076
R149 VPWR.n24 VPWR.n7 56.1076
R150 VPWR.n88 VPWR.n86 56.1076
R151 VPWR.n89 VPWR.n88 56.1076
R152 VPWR.n96 VPWR.n77 56.1076
R153 VPWR.n94 VPWR.n77 56.1076
R154 VPWR.n54 VPWR.n43 25.6005
R155 VPWR.n46 VPWR.n43 25.6005
R156 VPWR.n47 VPWR.n46 25.6005
R157 VPWR.n63 VPWR.n55 25.6005
R158 VPWR.n62 VPWR.n61 25.6005
R159 VPWR.n61 VPWR.n56 25.6005
R160 VPWR.n56 VPWR.n37 25.6005
R161 VPWR.n21 VPWR.n10 25.6005
R162 VPWR.n13 VPWR.n10 25.6005
R163 VPWR.n14 VPWR.n13 25.6005
R164 VPWR.n30 VPWR.n22 25.6005
R165 VPWR.n29 VPWR.n28 25.6005
R166 VPWR.n28 VPWR.n23 25.6005
R167 VPWR.n23 VPWR.n4 25.6005
R168 VPWR.n91 VPWR.n80 25.6005
R169 VPWR.n83 VPWR.n80 25.6005
R170 VPWR.n84 VPWR.n83 25.6005
R171 VPWR.n100 VPWR.n92 25.6005
R172 VPWR.n99 VPWR.n98 25.6005
R173 VPWR.n98 VPWR.n93 25.6005
R174 VPWR.n93 VPWR.n74 25.6005
R175 VPWR.n68 VPWR 18.865
R176 VPWR.n35 VPWR 18.865
R177 VPWR.n105 VPWR 18.865
R178 VPWR VPWR.n69 12.8005
R179 VPWR.n70 VPWR 12.8005
R180 VPWR VPWR.n0 12.8005
R181 VPWR.n1 VPWR 12.8005
R182 VPWR VPWR.n36 12.8005
R183 VPWR VPWR.n67 12.8005
R184 VPWR VPWR.n3 12.8005
R185 VPWR VPWR.n34 12.8005
R186 VPWR VPWR.n73 12.8005
R187 VPWR VPWR.n104 12.8005
R188 VPWR.n35 VPWR.n2 10.6503
R189 VPWR.n72 VPWR.n71 10.5563
R190 VPWR.n71 VPWR.n69 10.1513
R191 VPWR.n71 VPWR.n70 10.1513
R192 VPWR.n2 VPWR.n0 10.1513
R193 VPWR.n2 VPWR.n1 10.1513
R194 VPWR VPWR.n105 4.46447
R195 VPWR.n68 VPWR.n35 1.65412
R196 VPWR.n72 VPWR.n68 0.46345
R197 VPWR.n105 VPWR.n72 0.0945
R198 B B.t1 330.341
R199 B B.t0 315.88
R200 B.n0 B 31.317
R201 B.n0 B 30.2004
R202 B B.n0 5.72799
R203 N.t1 N.n2 700.484
R204 N.n3 N.t1 700.484
R205 N N.t4 330.341
R206 N N.t3 315.88
R207 N.t2 N.n5 255.345
R208 N.n6 N.t2 255.345
R209 N.t0 N.n0 255.345
R210 N.n11 N.t0 255.345
R211 N.n1 N 31.602
R212 N.n1 N 31.0337
R213 N N.n2 12.8005
R214 N.n3 N 12.8005
R215 N N.n5 12.8005
R216 N.n6 N 12.8005
R217 N N.n0 12.8005
R218 N N.n11 12.8005
R219 N.n8 N.n4 12.2547
R220 N.n8 N.n7 11.7021
R221 N.n10 N.n9 11.7021
R222 N.n4 N.n2 10.1513
R223 N.n4 N.n3 10.1513
R224 N.n7 N.n5 10.1513
R225 N.n7 N.n6 10.1513
R226 N.n10 N.n0 10.1513
R227 N.n11 N.n10 10.1513
R228 N.n9 N.n1 0.789708
R229 N.n9 N.n8 0.548833
R230 VGND.n61 VGND.n60 3632.52
R231 VGND.n86 VGND.n84 1515.12
R232 VGND.n94 VGND.n9 1315.26
R233 VGND.n105 VGND.n10 1315.26
R234 VGND.n89 VGND.n6 1315.26
R235 VGND.n107 VGND.n7 1315.26
R236 VGND.n72 VGND.n62 1315.26
R237 VGND.n82 VGND.n15 1315.26
R238 VGND.n74 VGND.n18 1315.26
R239 VGND.n76 VGND.n75 1315.26
R240 VGND.n48 VGND.n38 1315.26
R241 VGND.n58 VGND.n23 1315.26
R242 VGND.n52 VGND.n51 1315.26
R243 VGND.n50 VGND.n26 1315.26
R244 VGND.n82 VGND.n81 585
R245 VGND.n80 VGND.n14 585
R246 VGND.n79 VGND.n78 585
R247 VGND.n77 VGND.n76 585
R248 VGND.n75 VGND.n17 585
R249 VGND.n75 VGND.n12 585
R250 VGND.n74 VGND.n19 585
R251 VGND.n74 VGND.n73 585
R252 VGND.n63 VGND.n18 585
R253 VGND.n67 VGND.n64 585
R254 VGND.n69 VGND.n68 585
R255 VGND.n70 VGND.n62 585
R256 VGND.n72 VGND.n71 585
R257 VGND.n73 VGND.n72 585
R258 VGND.n16 VGND.n15 585
R259 VGND.n15 VGND.n12 585
R260 VGND.n103 VGND.n10 585
R261 VGND.n102 VGND.n101 585
R262 VGND.n99 VGND.n97 585
R263 VGND.n7 VGND.n5 585
R264 VGND.n108 VGND.n107 585
R265 VGND.n107 VGND.n106 585
R266 VGND.n6 VGND.n4 585
R267 VGND.n85 VGND.n6 585
R268 VGND.n89 VGND.n88 585
R269 VGND.n91 VGND.n87 585
R270 VGND.n92 VGND.n11 585
R271 VGND.n95 VGND.n94 585
R272 VGND.n96 VGND.n9 585
R273 VGND.n85 VGND.n9 585
R274 VGND.n105 VGND.n104 585
R275 VGND.n106 VGND.n105 585
R276 VGND.n39 VGND.n26 585
R277 VGND.n42 VGND.n40 585
R278 VGND.n45 VGND.n44 585
R279 VGND.n46 VGND.n38 585
R280 VGND.n48 VGND.n47 585
R281 VGND.n49 VGND.n48 585
R282 VGND.n24 VGND.n23 585
R283 VGND.n23 VGND.n20 585
R284 VGND.n58 VGND.n57 585
R285 VGND.n56 VGND.n22 585
R286 VGND.n55 VGND.n54 585
R287 VGND.n53 VGND.n52 585
R288 VGND.n51 VGND.n25 585
R289 VGND.n51 VGND.n20 585
R290 VGND.n50 VGND.n36 585
R291 VGND.n50 VGND.n49 585
R292 VGND.n105 VGND.n9 394
R293 VGND.n92 VGND.n91 394
R294 VGND.n107 VGND.n6 394
R295 VGND.n101 VGND.n99 394
R296 VGND.n72 VGND.n15 394
R297 VGND.n68 VGND.n67 394
R298 VGND.n75 VGND.n74 394
R299 VGND.n78 VGND.n14 394
R300 VGND.n48 VGND.n23 394
R301 VGND.n54 VGND.n22 394
R302 VGND.n51 VGND.n50 394
R303 VGND.n44 VGND.n42 394
R304 VGND.t5 VGND.n0 255.345
R305 VGND.n1 VGND.t5 255.345
R306 VGND.t3 VGND.n31 255.345
R307 VGND.n32 VGND.t3 255.345
R308 VGND.t1 VGND.n27 255.345
R309 VGND.n28 VGND.t1 255.345
R310 VGND.n84 VGND.n83 218.815
R311 VGND.n84 VGND.n13 218.815
R312 VGND.n66 VGND.n61 218.815
R313 VGND.n65 VGND.n61 218.815
R314 VGND.n100 VGND.n8 218.815
R315 VGND.n98 VGND.n8 218.815
R316 VGND.n90 VGND.n86 218.815
R317 VGND.n93 VGND.n86 218.815
R318 VGND.n41 VGND.n37 218.815
R319 VGND.n43 VGND.n37 218.815
R320 VGND.n60 VGND.n59 218.815
R321 VGND.n60 VGND.n21 218.815
R322 VGND.n73 VGND.n61 173.316
R323 VGND.n84 VGND.n12 173.316
R324 VGND.n86 VGND.n85 173.316
R325 VGND.n106 VGND.n8 173.316
R326 VGND.n49 VGND.n37 173.316
R327 VGND.n60 VGND.n20 173.316
R328 VGND.n93 VGND.n92 147.374
R329 VGND.n90 VGND.n89 147.374
R330 VGND.n100 VGND.n10 147.374
R331 VGND.n98 VGND.n7 147.374
R332 VGND.n68 VGND.n65 147.374
R333 VGND.n66 VGND.n18 147.374
R334 VGND.n83 VGND.n82 147.374
R335 VGND.n76 VGND.n13 147.374
R336 VGND.n83 VGND.n14 147.374
R337 VGND.n78 VGND.n13 147.374
R338 VGND.n67 VGND.n66 147.374
R339 VGND.n65 VGND.n62 147.374
R340 VGND.n101 VGND.n100 147.374
R341 VGND.n99 VGND.n98 147.374
R342 VGND.n91 VGND.n90 147.374
R343 VGND.n94 VGND.n93 147.374
R344 VGND.n59 VGND.n58 147.374
R345 VGND.n52 VGND.n21 147.374
R346 VGND.n43 VGND.n38 147.374
R347 VGND.n42 VGND.n41 147.374
R348 VGND.n41 VGND.n26 147.374
R349 VGND.n44 VGND.n43 147.374
R350 VGND.n59 VGND.n22 147.374
R351 VGND.n54 VGND.n21 147.374
R352 VGND.n96 VGND.n95 85.4593
R353 VGND.n104 VGND.n103 85.4593
R354 VGND.n88 VGND.n4 85.4593
R355 VGND.n108 VGND.n5 85.4593
R356 VGND.n71 VGND.n70 85.4593
R357 VGND.n81 VGND.n16 85.4593
R358 VGND.n63 VGND.n19 85.4593
R359 VGND.n77 VGND.n17 85.4593
R360 VGND.n47 VGND.n46 85.4593
R361 VGND.n39 VGND.n36 85.4593
R362 VGND.n57 VGND.n24 85.4593
R363 VGND.n53 VGND.n25 85.4593
R364 VGND.n73 VGND.t2 47.5227
R365 VGND.t2 VGND.n12 47.5227
R366 VGND.n85 VGND.t4 47.5227
R367 VGND.n106 VGND.t4 47.5227
R368 VGND.n49 VGND.t0 47.5227
R369 VGND.t0 VGND.n20 47.5227
R370 VGND.n104 VGND.n96 25.6005
R371 VGND.n95 VGND.n11 25.6005
R372 VGND.n87 VGND.n11 25.6005
R373 VGND.n88 VGND.n87 25.6005
R374 VGND.n103 VGND.n102 25.6005
R375 VGND.n102 VGND.n97 25.6005
R376 VGND.n97 VGND.n5 25.6005
R377 VGND.n71 VGND.n16 25.6005
R378 VGND.n70 VGND.n69 25.6005
R379 VGND.n69 VGND.n64 25.6005
R380 VGND.n64 VGND.n63 25.6005
R381 VGND.n81 VGND.n80 25.6005
R382 VGND.n80 VGND.n79 25.6005
R383 VGND.n79 VGND.n77 25.6005
R384 VGND.n46 VGND.n45 25.6005
R385 VGND.n45 VGND.n40 25.6005
R386 VGND.n40 VGND.n39 25.6005
R387 VGND.n47 VGND.n24 25.6005
R388 VGND.n57 VGND.n56 25.6005
R389 VGND.n56 VGND.n55 25.6005
R390 VGND.n55 VGND.n53 25.6005
R391 VGND.n109 VGND 18.3598
R392 VGND.n30 VGND 18.3598
R393 VGND VGND.n35 18.3598
R394 VGND VGND.n31 12.8005
R395 VGND.n32 VGND 12.8005
R396 VGND VGND.n27 12.8005
R397 VGND.n28 VGND 12.8005
R398 VGND VGND.n4 12.8005
R399 VGND VGND.n108 12.8005
R400 VGND VGND.n19 12.8005
R401 VGND VGND.n17 12.8005
R402 VGND.n36 VGND 12.8005
R403 VGND VGND.n25 12.8005
R404 VGND VGND.n0 12.8005
R405 VGND.n1 VGND 12.8005
R406 VGND.n33 VGND.n31 10.1513
R407 VGND.n33 VGND.n32 10.1513
R408 VGND.n29 VGND.n27 10.1513
R409 VGND.n29 VGND.n28 10.1513
R410 VGND.n2 VGND.n0 10.1513
R411 VGND.n2 VGND.n1 10.1513
R412 VGND.n35 VGND.n29 10.1294
R413 VGND.n34 VGND.n33 10.0354
R414 VGND.n3 VGND.n2 10.0354
R415 VGND VGND.n109 5.71507
R416 VGND.n35 VGND.n34 1.01178
R417 VGND.n30 VGND.n3 0.454833
R418 VGND.n34 VGND.n30 0.0945
R419 VGND.n109 VGND.n3 0.0945
R420 Y.t1 Y.n3 700.484
R421 Y.n4 Y.t1 700.484
R422 Y.t0 Y.n0 255.345
R423 Y.n1 Y.t0 255.345
R424 Y Y.n0 12.8005
R425 Y.n1 Y 12.8005
R426 Y Y.n3 12.8005
R427 Y.n4 Y 12.8005
R428 Y.n6 Y.n2 11.8381
R429 Y.n6 Y.n5 11.2854
R430 Y.n2 Y.n0 10.1513
R431 Y.n2 Y.n1 10.1513
R432 Y.n5 Y.n3 10.1513
R433 Y.n5 Y.n4 10.1513
R434 Y Y.n6 6.44004
C15 Y VGND 3.33081f
C16 B VGND 3.11182f
C17 A VGND 2.66978f
C18 VPWR VGND 9.83427f
C19 N VGND 7.18409f $ **FLOATING
C20 CORE__N VGND 1.80084f $ **FLOATING
C21 Y.n0 VGND 0.01221f $ **FLOATING
C22 Y.t0 VGND 0.02968f $ **FLOATING
C23 Y.n1 VGND 0.01221f $ **FLOATING
C24 Y.n2 VGND 0.34796f $ **FLOATING
C25 Y.n3 VGND 0.01068f $ **FLOATING
C26 Y.t1 VGND 0.03273f $ **FLOATING
C27 Y.n4 VGND 0.01068f $ **FLOATING
C28 Y.n5 VGND 0.31125f $ **FLOATING
C29 Y.n6 VGND 4.69324f $ **FLOATING
C30 N.n0 VGND 0.00519f $ **FLOATING
C31 N.t3 VGND 0.01877f $ **FLOATING
C32 N.t4 VGND 0.0195f $ **FLOATING
C33 N.n1 VGND 1.10274f $ **FLOATING
C34 N.n2 VGND 0.00454f $ **FLOATING
C35 N.t1 VGND 0.01391f $ **FLOATING
C36 N.n3 VGND 0.00454f $ **FLOATING
C37 N.n4 VGND 0.19741f $ **FLOATING
C38 N.n5 VGND 0.00519f $ **FLOATING
C39 N.t2 VGND 0.01262f $ **FLOATING
C40 N.n6 VGND 0.00519f $ **FLOATING
C41 N.n7 VGND 0.14839f $ **FLOATING
C42 N.n8 VGND 1.55378f $ **FLOATING
C43 N.n9 VGND 0.5919f $ **FLOATING
C44 N.n10 VGND 0.14839f $ **FLOATING
C45 N.t0 VGND 0.01262f $ **FLOATING
C46 N.n11 VGND 0.00519f $ **FLOATING
C47 B.t0 VGND 0.0387f $ **FLOATING
C48 B.t1 VGND 0.04022f $ **FLOATING
C49 B.n0 VGND 3.95028f $ **FLOATING
C50 A.t1 VGND 0.02279f $ **FLOATING
C51 A.t0 VGND 0.02369f $ **FLOATING
C52 A.n0 VGND 1.94724f $ **FLOATING
.ends

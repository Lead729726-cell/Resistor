.subckt current_mirror REF OUT VGND
XMN1 register_cf_node_608b00de935f2f3c REF register_cf_node_608b00de935f2f3c_source VGND sky130_fd_pr__nfet_01v8 w=0.65 l=0.15 nf=1 m=1
Vregister_cf_608b00de935f2f3c REF register_cf_node_608b00de935f2f3c 0
Vregister_cf_608b00de935f2f3c_source VGND register_cf_node_608b00de935f2f3c_source 0
XMN2 register_cf_node_28153a61bb2a3581 REF register_cf_node_28153a61bb2a3581_source VGND sky130_fd_pr__nfet_01v8 w=0.65 l=0.15 nf=1 m=1
Vregister_cf_28153a61bb2a3581 OUT register_cf_node_28153a61bb2a3581 0
Vregister_cf_28153a61bb2a3581_source VGND register_cf_node_28153a61bb2a3581_source 0
.ends current_mirror

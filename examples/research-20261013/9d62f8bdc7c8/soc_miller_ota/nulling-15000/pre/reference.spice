.subckt soc_miller_ota INP INN BIAS OUT VPWR VGND
XC_MILLER_P0 PRE COMP sky130_fd_pr__cap_mim_m3_1 w=28.68 l=28.68
XC_MILLER_P1 PRE COMP sky130_fd_pr__cap_mim_m3_1 w=28.68 l=28.68
XC_MILLER_P2 PRE COMP sky130_fd_pr__cap_mim_m3_1 w=28.68 l=28.68
XFIRST_N_INN0 FIRST__MIR INN FIRST__TAIL VGND sky130_fd_pr__nfet_01v8 w=5 l=1 nf=1 m=1
XFIRST_N_INN1 FIRST__MIR INN FIRST__TAIL VGND sky130_fd_pr__nfet_01v8 w=5 l=1 nf=1 m=1
XFIRST_N_INP0 PRE INP FIRST__TAIL VGND sky130_fd_pr__nfet_01v8 w=5 l=1 nf=1 m=1
XFIRST_N_INP1 PRE INP FIRST__TAIL VGND sky130_fd_pr__nfet_01v8 w=5 l=1 nf=1 m=1
XFIRST_N_TAIL FIRST__TAIL BIAS VGND VGND sky130_fd_pr__nfet_01v8 w=2 l=1 nf=1 m=1
XFIRST_P_DIODE FIRST__MIR FIRST__MIR VPWR VPWR sky130_fd_pr__pfet_01v8_hvt w=20 l=1 nf=1 m=1
XFIRST_P_MIRROR PRE FIRST__MIR VPWR VPWR sky130_fd_pr__pfet_01v8_hvt w=20 l=1 nf=1 m=1
XN_SECOND OUT BIAS VGND VGND sky130_fd_pr__nfet_01v8 w=2 l=1 nf=1 m=1
XP_SECOND OUT PRE VPWR VPWR sky130_fd_pr__pfet_01v8_hvt w=40 l=1 nf=1 m=1
XR_ZERO_P0 COMP OUT VGND sky130_fd_pr__res_xhigh_po_1p41 l=10.41
.ends soc_miller_ota

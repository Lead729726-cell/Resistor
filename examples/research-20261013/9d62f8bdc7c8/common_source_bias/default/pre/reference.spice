.subckt common_source_bias IN OUT VPWR VGND
CCIN IN GATE 1e-12
XMN1 OUT GATE VGND VGND sky130_fd_pr__nfet_01v8 w=0.65 l=0.15 nf=1 m=1
RRB1 VPWR GATE 100000
RRB2 GATE VGND 60000
RRD VPWR OUT 10000
.ends common_source_bias

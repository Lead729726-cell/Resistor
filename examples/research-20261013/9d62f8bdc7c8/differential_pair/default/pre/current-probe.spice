.subckt differential_pair INP INN OUTP OUTN BIAS VGND
XMN1 register_cf_node_6ca64884186f2241 INP register_cf_node_6ca64884186f2241_source VGND sky130_fd_pr__nfet_01v8 w=0.65 l=0.15 nf=1 m=1
Vregister_cf_6ca64884186f2241 OUTP register_cf_node_6ca64884186f2241 0
Vregister_cf_6ca64884186f2241_source TAIL register_cf_node_6ca64884186f2241_source 0
XMN2 register_cf_node_f741058f08906de2 INN register_cf_node_f741058f08906de2_source VGND sky130_fd_pr__nfet_01v8 w=0.65 l=0.15 nf=1 m=1
Vregister_cf_f741058f08906de2 OUTN register_cf_node_f741058f08906de2 0
Vregister_cf_f741058f08906de2_source TAIL register_cf_node_f741058f08906de2_source 0
XMN3 register_cf_node_78ccf72aa40b6097 BIAS register_cf_node_78ccf72aa40b6097_source VGND sky130_fd_pr__nfet_01v8 w=0.65 l=0.15 nf=1 m=1
Vregister_cf_78ccf72aa40b6097 TAIL register_cf_node_78ccf72aa40b6097 0
Vregister_cf_78ccf72aa40b6097_source VGND register_cf_node_78ccf72aa40b6097_source 0
.ends differential_pair

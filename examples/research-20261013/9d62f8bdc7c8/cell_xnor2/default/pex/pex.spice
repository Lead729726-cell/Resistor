* NGSPICE file created from cell_xnor2.ext - technology: sky130A

.subckt cell_xnor2 Y VPWR VGND B A
X0 VPWR.t1 N.t3 Y.t1 VPWR.t0 sky130_fd_pr__pfet_01v8_hvt ad=0.1885 pd=1.88 as=0.1885 ps=1.88 w=0.65 l=0.15
X1 VGND.t4 N.t4 Y.t0 VGND.t3 sky130_fd_pr__nfet_01v8 ad=0.1885 pd=1.88 as=0.1885 ps=1.88 w=0.65 l=0.15
X2 CORE__N3__N1.t1 B.t0 CORE__N3.t2 VGND.t10 sky130_fd_pr__nfet_01v8 ad=0.1885 pd=1.88 as=0.1885 ps=1.88 w=0.65 l=0.15
X3 VGND.t1 CORE__N1.t3 CORE__N3__N1.t0 VGND.t0 sky130_fd_pr__nfet_01v8 ad=0.1885 pd=1.88 as=0.1885 ps=1.88 w=0.65 l=0.15
X4 CORE__N2__N1.t1 A.t0 CORE__N2.t2 VGND.t2 sky130_fd_pr__nfet_01v8 ad=0.1885 pd=1.88 as=0.1885 ps=1.88 w=0.65 l=0.15
X5 CORE__N4__N1.t1 CORE__N2.t3 N.t1 VGND.t13 sky130_fd_pr__nfet_01v8 ad=0.1885 pd=1.88 as=0.1885 ps=1.88 w=0.65 l=0.15
X6 CORE__N1__N1.t1 A.t1 CORE__N1.t0 VGND.t7 sky130_fd_pr__nfet_01v8 ad=0.1885 pd=1.88 as=0.1885 ps=1.88 w=0.65 l=0.15
X7 VGND.t9 CORE__N3.t3 CORE__N4__N1.t0 VGND.t8 sky130_fd_pr__nfet_01v8 ad=0.1885 pd=1.88 as=0.1885 ps=1.88 w=0.65 l=0.15
X8 VGND.t6 CORE__N1.t4 CORE__N2__N1.t0 VGND.t5 sky130_fd_pr__nfet_01v8 ad=0.1885 pd=1.88 as=0.1885 ps=1.88 w=0.65 l=0.15
X9 VPWR.t3 CORE__N1.t5 CORE__N3.t0 VPWR.t2 sky130_fd_pr__pfet_01v8_hvt ad=0.1885 pd=1.88 as=0.1885 ps=1.88 w=0.65 l=0.15
X10 VPWR.t13 A.t2 CORE__N1.t2 VPWR.t12 sky130_fd_pr__pfet_01v8_hvt ad=0.1885 pd=1.88 as=0.1885 ps=1.88 w=0.65 l=0.15
X11 VPWR.t17 CORE__N2.t4 N.t2 VPWR.t16 sky130_fd_pr__pfet_01v8_hvt ad=0.1885 pd=1.88 as=0.1885 ps=1.88 w=0.65 l=0.15
X12 VPWR.t15 B.t1 CORE__N1.t1 VPWR.t14 sky130_fd_pr__pfet_01v8_hvt ad=0.1885 pd=1.88 as=0.1885 ps=1.88 w=0.65 l=0.15
X13 VPWR.t9 B.t2 CORE__N3.t1 VPWR.t8 sky130_fd_pr__pfet_01v8_hvt ad=0.1885 pd=1.88 as=0.1885 ps=1.88 w=0.65 l=0.15
X14 VPWR.t11 A.t3 CORE__N2.t1 VPWR.t10 sky130_fd_pr__pfet_01v8_hvt ad=0.1885 pd=1.88 as=0.1885 ps=1.88 w=0.65 l=0.15
X15 VPWR.t7 CORE__N3.t4 N.t0 VPWR.t6 sky130_fd_pr__pfet_01v8_hvt ad=0.1885 pd=1.88 as=0.1885 ps=1.88 w=0.65 l=0.15
X16 VPWR.t5 CORE__N1.t6 CORE__N2.t0 VPWR.t4 sky130_fd_pr__pfet_01v8_hvt ad=0.1885 pd=1.88 as=0.1885 ps=1.88 w=0.65 l=0.15
X17 VGND.t12 B.t3 CORE__N1__N1.t0 VGND.t11 sky130_fd_pr__nfet_01v8 ad=0.1885 pd=1.88 as=0.1885 ps=1.88 w=0.65 l=0.15
C0 CORE__N1 CORE__N4__N1 0.00603f
C1 CORE__N3 B 0.58667f
C2 CORE__N2__N1 VPWR 0.02371f
C3 A VPWR 0.85687f
C4 CORE__N3__N1 CORE__N4__N1 0.00116f
C5 CORE__N1__N1 CORE__N4__N1 0
C6 CORE__N2 CORE__N4__N1 9.0801f
C7 CORE__N1 Y 0.00145f
C8 B VPWR 0.84794f
C9 CORE__N3__N1 Y 0
C10 B N 0
C11 CORE__N2 Y 0.00203f
C12 CORE__N3 VPWR 0.94648f
C13 CORE__N3 N 0.66324f
C14 CORE__N2__N1 CORE__N4__N1 0
C15 CORE__N1 CORE__N3__N1 7.51144f
C16 CORE__N1 CORE__N1__N1 0.53709f
C17 CORE__N2 CORE__N1 7.59209f
C18 A CORE__N4__N1 0
C19 CORE__N1__N1 CORE__N3__N1 0
C20 CORE__N2__N1 Y 0
C21 CORE__N2 CORE__N3__N1 0.2848f
C22 N VPWR 0.94487f
C23 CORE__N2 CORE__N1__N1 0.00336f
C24 B CORE__N4__N1 0
C25 CORE__N3 CORE__N4__N1 9.44747f
C26 CORE__N1 CORE__N2__N1 0.60805f
C27 CORE__N1 A 0.58173f
C28 B Y 0
C29 CORE__N2__N1 CORE__N3__N1 0.00269f
C30 CORE__N1__N1 CORE__N2__N1 0.00298f
C31 CORE__N3 Y 8.76957f
C32 CORE__N2 CORE__N2__N1 0.58352f
C33 CORE__N3__N1 A 0.00178f
C34 CORE__N1__N1 A 3.46777f
C35 CORE__N2 A 0.4858f
C36 CORE__N4__N1 VPWR 0.01242f
C37 CORE__N1 B 0.83778f
C38 N CORE__N4__N1 0.71275f
C39 CORE__N1 CORE__N3 0.60853f
C40 B CORE__N3__N1 6.74209f
C41 CORE__N1__N1 B 0.25806f
C42 CORE__N2 B 0.37916f
C43 Y VPWR 0.26802f
C44 Y N 10.546f
C45 CORE__N3 CORE__N3__N1 0.63388f
C46 CORE__N2 CORE__N3 0.36914f
C47 CORE__N2__N1 A 4.5904f
C48 CORE__N1 VPWR 1.36734f
C49 CORE__N1 N 0.12793f
C50 CORE__N2__N1 B 4.89549f
C51 CORE__N3__N1 VPWR 0.01463f
C52 CORE__N1__N1 VPWR 0.05039f
C53 CORE__N2 VPWR 0.94651f
C54 CORE__N3__N1 N 0.00336f
C55 B A 0.3658f
C56 CORE__N2 N 0.73925f
C57 CORE__N3 CORE__N2__N1 0.00336f
C58 Y CORE__N4__N1 0.00577f
C59 CORE__N3 A 0
R0 N.t2 N.n2 700.484
R1 N.n3 N.t2 700.484
R2 N.t0 N.n0 700.484
R3 N.n11 N.t0 700.484
R4 N N.t3 330.341
R5 N N.t4 315.88
R6 N.t1 N.n5 255.345
R7 N.n6 N.t1 255.345
R8 N.n1 N 34.102
R9 N.n1 N 33.5337
R10 N.n8 N.n4 14.7547
R11 N.n8 N.n7 14.2021
R12 N.n10 N.n9 14.2021
R13 N N.n2 12.8005
R14 N.n3 N 12.8005
R15 N N.n5 12.8005
R16 N.n6 N 12.8005
R17 N N.n0 12.8005
R18 N N.n11 12.8005
R19 N.n4 N.n2 10.1513
R20 N.n4 N.n3 10.1513
R21 N.n7 N.n5 10.1513
R22 N.n7 N.n6 10.1513
R23 N.n10 N.n0 10.1513
R24 N.n11 N.n10 10.1513
R25 N.n9 N.n1 1.34235
R26 N.n9 N.n8 0.553142
R27 Y.t1 Y.n3 700.484
R28 Y.n4 Y.t1 700.484
R29 Y.t0 Y.n0 255.345
R30 Y.n1 Y.t0 255.345
R31 Y.n6 Y.n2 14.3381
R32 Y.n6 Y.n5 13.7854
R33 Y Y.n6 13.0717
R34 Y Y.n0 12.8005
R35 Y.n1 Y 12.8005
R36 Y Y.n3 12.8005
R37 Y.n4 Y 12.8005
R38 Y.n2 Y.n0 10.1513
R39 Y.n2 Y.n1 10.1513
R40 Y.n5 Y.n3 10.1513
R41 Y.n5 Y.n4 10.1513
R42 VPWR.n279 VPWR.n267 832.942
R43 VPWR.n290 VPWR.n268 832.942
R44 VPWR.n292 VPWR.n265 832.942
R45 VPWR.n274 VPWR.n264 832.942
R46 VPWR.n242 VPWR.n230 832.942
R47 VPWR.n253 VPWR.n231 832.942
R48 VPWR.n255 VPWR.n228 832.942
R49 VPWR.n237 VPWR.n227 832.942
R50 VPWR.n205 VPWR.n193 832.942
R51 VPWR.n216 VPWR.n194 832.942
R52 VPWR.n218 VPWR.n191 832.942
R53 VPWR.n200 VPWR.n190 832.942
R54 VPWR.n168 VPWR.n156 832.942
R55 VPWR.n179 VPWR.n157 832.942
R56 VPWR.n181 VPWR.n154 832.942
R57 VPWR.n163 VPWR.n153 832.942
R58 VPWR.n131 VPWR.n119 832.942
R59 VPWR.n142 VPWR.n120 832.942
R60 VPWR.n144 VPWR.n117 832.942
R61 VPWR.n126 VPWR.n116 832.942
R62 VPWR.n94 VPWR.n82 832.942
R63 VPWR.n105 VPWR.n83 832.942
R64 VPWR.n107 VPWR.n80 832.942
R65 VPWR.n89 VPWR.n79 832.942
R66 VPWR.n57 VPWR.n45 832.942
R67 VPWR.n68 VPWR.n46 832.942
R68 VPWR.n70 VPWR.n43 832.942
R69 VPWR.n52 VPWR.n42 832.942
R70 VPWR.n20 VPWR.n8 832.942
R71 VPWR.n31 VPWR.n9 832.942
R72 VPWR.n33 VPWR.n6 832.942
R73 VPWR.n15 VPWR.n5 832.942
R74 VPWR.n316 VPWR.n304 832.942
R75 VPWR.n327 VPWR.n305 832.942
R76 VPWR.n329 VPWR.n302 832.942
R77 VPWR.n311 VPWR.n301 832.942
R78 VPWR.t13 VPWR.n295 700.484
R79 VPWR.n296 VPWR.t13 700.484
R80 VPWR.t15 VPWR.n258 700.484
R81 VPWR.n259 VPWR.t15 700.484
R82 VPWR.t11 VPWR.n221 700.484
R83 VPWR.n222 VPWR.t11 700.484
R84 VPWR.t5 VPWR.n184 700.484
R85 VPWR.n185 VPWR.t5 700.484
R86 VPWR.t9 VPWR.n147 700.484
R87 VPWR.n148 VPWR.t9 700.484
R88 VPWR.t3 VPWR.n110 700.484
R89 VPWR.n111 VPWR.t3 700.484
R90 VPWR.t17 VPWR.n73 700.484
R91 VPWR.n74 VPWR.t17 700.484
R92 VPWR.t7 VPWR.n36 700.484
R93 VPWR.n37 VPWR.t7 700.484
R94 VPWR.t1 VPWR.n0 700.484
R95 VPWR.n1 VPWR.t1 700.484
R96 VPWR.n290 VPWR.n267 240
R97 VPWR.n286 VPWR.n284 240
R98 VPWR.n292 VPWR.n264 240
R99 VPWR.n271 VPWR.n270 240
R100 VPWR.n253 VPWR.n230 240
R101 VPWR.n249 VPWR.n247 240
R102 VPWR.n255 VPWR.n227 240
R103 VPWR.n234 VPWR.n233 240
R104 VPWR.n216 VPWR.n193 240
R105 VPWR.n212 VPWR.n210 240
R106 VPWR.n218 VPWR.n190 240
R107 VPWR.n197 VPWR.n196 240
R108 VPWR.n179 VPWR.n156 240
R109 VPWR.n175 VPWR.n173 240
R110 VPWR.n181 VPWR.n153 240
R111 VPWR.n160 VPWR.n159 240
R112 VPWR.n142 VPWR.n119 240
R113 VPWR.n138 VPWR.n136 240
R114 VPWR.n144 VPWR.n116 240
R115 VPWR.n123 VPWR.n122 240
R116 VPWR.n105 VPWR.n82 240
R117 VPWR.n101 VPWR.n99 240
R118 VPWR.n107 VPWR.n79 240
R119 VPWR.n86 VPWR.n85 240
R120 VPWR.n68 VPWR.n45 240
R121 VPWR.n64 VPWR.n62 240
R122 VPWR.n70 VPWR.n42 240
R123 VPWR.n49 VPWR.n48 240
R124 VPWR.n31 VPWR.n8 240
R125 VPWR.n27 VPWR.n25 240
R126 VPWR.n33 VPWR.n5 240
R127 VPWR.n12 VPWR.n11 240
R128 VPWR.n327 VPWR.n304 240
R129 VPWR.n323 VPWR.n321 240
R130 VPWR.n329 VPWR.n301 240
R131 VPWR.n308 VPWR.n307 240
R132 VPWR.n277 VPWR.n276 207.394
R133 VPWR.n291 VPWR.n266 207.394
R134 VPWR.n240 VPWR.n239 207.394
R135 VPWR.n254 VPWR.n229 207.394
R136 VPWR.n203 VPWR.n202 207.394
R137 VPWR.n217 VPWR.n192 207.394
R138 VPWR.n166 VPWR.n165 207.394
R139 VPWR.n180 VPWR.n155 207.394
R140 VPWR.n129 VPWR.n128 207.394
R141 VPWR.n143 VPWR.n118 207.394
R142 VPWR.n92 VPWR.n91 207.394
R143 VPWR.n106 VPWR.n81 207.394
R144 VPWR.n55 VPWR.n54 207.394
R145 VPWR.n69 VPWR.n44 207.394
R146 VPWR.n18 VPWR.n17 207.394
R147 VPWR.n32 VPWR.n7 207.394
R148 VPWR.n314 VPWR.n313 207.394
R149 VPWR.n328 VPWR.n303 207.394
R150 VPWR.n274 VPWR.n273 185
R151 VPWR.n272 VPWR.n271 185
R152 VPWR.n270 VPWR.n269 185
R153 VPWR.n280 VPWR.n279 185
R154 VPWR.n281 VPWR.n267 185
R155 VPWR.n276 VPWR.n267 185
R156 VPWR.n290 VPWR.n289 185
R157 VPWR.n291 VPWR.n290 185
R158 VPWR.n288 VPWR.n268 185
R159 VPWR.n287 VPWR.n286 185
R160 VPWR.n284 VPWR.n282 185
R161 VPWR.n265 VPWR.n263 185
R162 VPWR.n293 VPWR.n292 185
R163 VPWR.n292 VPWR.n291 185
R164 VPWR.n264 VPWR.n262 185
R165 VPWR.n276 VPWR.n264 185
R166 VPWR.n237 VPWR.n236 185
R167 VPWR.n235 VPWR.n234 185
R168 VPWR.n233 VPWR.n232 185
R169 VPWR.n243 VPWR.n242 185
R170 VPWR.n244 VPWR.n230 185
R171 VPWR.n239 VPWR.n230 185
R172 VPWR.n253 VPWR.n252 185
R173 VPWR.n254 VPWR.n253 185
R174 VPWR.n251 VPWR.n231 185
R175 VPWR.n250 VPWR.n249 185
R176 VPWR.n247 VPWR.n245 185
R177 VPWR.n228 VPWR.n226 185
R178 VPWR.n256 VPWR.n255 185
R179 VPWR.n255 VPWR.n254 185
R180 VPWR.n227 VPWR.n225 185
R181 VPWR.n239 VPWR.n227 185
R182 VPWR.n200 VPWR.n199 185
R183 VPWR.n198 VPWR.n197 185
R184 VPWR.n196 VPWR.n195 185
R185 VPWR.n206 VPWR.n205 185
R186 VPWR.n207 VPWR.n193 185
R187 VPWR.n202 VPWR.n193 185
R188 VPWR.n216 VPWR.n215 185
R189 VPWR.n217 VPWR.n216 185
R190 VPWR.n214 VPWR.n194 185
R191 VPWR.n213 VPWR.n212 185
R192 VPWR.n210 VPWR.n208 185
R193 VPWR.n191 VPWR.n189 185
R194 VPWR.n219 VPWR.n218 185
R195 VPWR.n218 VPWR.n217 185
R196 VPWR.n190 VPWR.n188 185
R197 VPWR.n202 VPWR.n190 185
R198 VPWR.n163 VPWR.n162 185
R199 VPWR.n161 VPWR.n160 185
R200 VPWR.n159 VPWR.n158 185
R201 VPWR.n169 VPWR.n168 185
R202 VPWR.n170 VPWR.n156 185
R203 VPWR.n165 VPWR.n156 185
R204 VPWR.n179 VPWR.n178 185
R205 VPWR.n180 VPWR.n179 185
R206 VPWR.n177 VPWR.n157 185
R207 VPWR.n176 VPWR.n175 185
R208 VPWR.n173 VPWR.n171 185
R209 VPWR.n154 VPWR.n152 185
R210 VPWR.n182 VPWR.n181 185
R211 VPWR.n181 VPWR.n180 185
R212 VPWR.n153 VPWR.n151 185
R213 VPWR.n165 VPWR.n153 185
R214 VPWR.n126 VPWR.n125 185
R215 VPWR.n124 VPWR.n123 185
R216 VPWR.n122 VPWR.n121 185
R217 VPWR.n132 VPWR.n131 185
R218 VPWR.n133 VPWR.n119 185
R219 VPWR.n128 VPWR.n119 185
R220 VPWR.n142 VPWR.n141 185
R221 VPWR.n143 VPWR.n142 185
R222 VPWR.n140 VPWR.n120 185
R223 VPWR.n139 VPWR.n138 185
R224 VPWR.n136 VPWR.n134 185
R225 VPWR.n117 VPWR.n115 185
R226 VPWR.n145 VPWR.n144 185
R227 VPWR.n144 VPWR.n143 185
R228 VPWR.n116 VPWR.n114 185
R229 VPWR.n128 VPWR.n116 185
R230 VPWR.n89 VPWR.n88 185
R231 VPWR.n87 VPWR.n86 185
R232 VPWR.n85 VPWR.n84 185
R233 VPWR.n95 VPWR.n94 185
R234 VPWR.n96 VPWR.n82 185
R235 VPWR.n91 VPWR.n82 185
R236 VPWR.n105 VPWR.n104 185
R237 VPWR.n106 VPWR.n105 185
R238 VPWR.n103 VPWR.n83 185
R239 VPWR.n102 VPWR.n101 185
R240 VPWR.n99 VPWR.n97 185
R241 VPWR.n80 VPWR.n78 185
R242 VPWR.n108 VPWR.n107 185
R243 VPWR.n107 VPWR.n106 185
R244 VPWR.n79 VPWR.n77 185
R245 VPWR.n91 VPWR.n79 185
R246 VPWR.n52 VPWR.n51 185
R247 VPWR.n50 VPWR.n49 185
R248 VPWR.n48 VPWR.n47 185
R249 VPWR.n58 VPWR.n57 185
R250 VPWR.n59 VPWR.n45 185
R251 VPWR.n54 VPWR.n45 185
R252 VPWR.n68 VPWR.n67 185
R253 VPWR.n69 VPWR.n68 185
R254 VPWR.n66 VPWR.n46 185
R255 VPWR.n65 VPWR.n64 185
R256 VPWR.n62 VPWR.n60 185
R257 VPWR.n43 VPWR.n41 185
R258 VPWR.n71 VPWR.n70 185
R259 VPWR.n70 VPWR.n69 185
R260 VPWR.n42 VPWR.n40 185
R261 VPWR.n54 VPWR.n42 185
R262 VPWR.n15 VPWR.n14 185
R263 VPWR.n13 VPWR.n12 185
R264 VPWR.n11 VPWR.n10 185
R265 VPWR.n21 VPWR.n20 185
R266 VPWR.n22 VPWR.n8 185
R267 VPWR.n17 VPWR.n8 185
R268 VPWR.n31 VPWR.n30 185
R269 VPWR.n32 VPWR.n31 185
R270 VPWR.n29 VPWR.n9 185
R271 VPWR.n28 VPWR.n27 185
R272 VPWR.n25 VPWR.n23 185
R273 VPWR.n6 VPWR.n4 185
R274 VPWR.n34 VPWR.n33 185
R275 VPWR.n33 VPWR.n32 185
R276 VPWR.n5 VPWR.n3 185
R277 VPWR.n17 VPWR.n5 185
R278 VPWR.n311 VPWR.n310 185
R279 VPWR.n309 VPWR.n308 185
R280 VPWR.n307 VPWR.n306 185
R281 VPWR.n317 VPWR.n316 185
R282 VPWR.n318 VPWR.n304 185
R283 VPWR.n313 VPWR.n304 185
R284 VPWR.n327 VPWR.n326 185
R285 VPWR.n328 VPWR.n327 185
R286 VPWR.n325 VPWR.n305 185
R287 VPWR.n324 VPWR.n323 185
R288 VPWR.n321 VPWR.n319 185
R289 VPWR.n302 VPWR.n300 185
R290 VPWR.n330 VPWR.n329 185
R291 VPWR.n329 VPWR.n328 185
R292 VPWR.n301 VPWR.n299 185
R293 VPWR.n313 VPWR.n301 185
R294 VPWR.n281 VPWR.n280 88.8476
R295 VPWR.n273 VPWR.n262 88.8476
R296 VPWR.n289 VPWR.n288 88.8476
R297 VPWR.n293 VPWR.n263 88.8476
R298 VPWR.n244 VPWR.n243 88.8476
R299 VPWR.n236 VPWR.n225 88.8476
R300 VPWR.n252 VPWR.n251 88.8476
R301 VPWR.n256 VPWR.n226 88.8476
R302 VPWR.n207 VPWR.n206 88.8476
R303 VPWR.n199 VPWR.n188 88.8476
R304 VPWR.n215 VPWR.n214 88.8476
R305 VPWR.n219 VPWR.n189 88.8476
R306 VPWR.n170 VPWR.n169 88.8476
R307 VPWR.n162 VPWR.n151 88.8476
R308 VPWR.n178 VPWR.n177 88.8476
R309 VPWR.n182 VPWR.n152 88.8476
R310 VPWR.n133 VPWR.n132 88.8476
R311 VPWR.n125 VPWR.n114 88.8476
R312 VPWR.n141 VPWR.n140 88.8476
R313 VPWR.n145 VPWR.n115 88.8476
R314 VPWR.n96 VPWR.n95 88.8476
R315 VPWR.n88 VPWR.n77 88.8476
R316 VPWR.n104 VPWR.n103 88.8476
R317 VPWR.n108 VPWR.n78 88.8476
R318 VPWR.n59 VPWR.n58 88.8476
R319 VPWR.n51 VPWR.n40 88.8476
R320 VPWR.n67 VPWR.n66 88.8476
R321 VPWR.n71 VPWR.n41 88.8476
R322 VPWR.n22 VPWR.n21 88.8476
R323 VPWR.n14 VPWR.n3 88.8476
R324 VPWR.n30 VPWR.n29 88.8476
R325 VPWR.n34 VPWR.n4 88.8476
R326 VPWR.n318 VPWR.n317 88.8476
R327 VPWR.n310 VPWR.n299 88.8476
R328 VPWR.n326 VPWR.n325 88.8476
R329 VPWR.n330 VPWR.n300 88.8476
R330 VPWR.n285 VPWR.n268 72.7879
R331 VPWR.n283 VPWR.n265 72.7879
R332 VPWR.n279 VPWR.n278 72.7879
R333 VPWR.n275 VPWR.n271 72.7879
R334 VPWR.n275 VPWR.n274 72.7879
R335 VPWR.n278 VPWR.n270 72.7879
R336 VPWR.n286 VPWR.n285 72.7879
R337 VPWR.n284 VPWR.n283 72.7879
R338 VPWR.n248 VPWR.n231 72.7879
R339 VPWR.n246 VPWR.n228 72.7879
R340 VPWR.n242 VPWR.n241 72.7879
R341 VPWR.n238 VPWR.n234 72.7879
R342 VPWR.n238 VPWR.n237 72.7879
R343 VPWR.n241 VPWR.n233 72.7879
R344 VPWR.n249 VPWR.n248 72.7879
R345 VPWR.n247 VPWR.n246 72.7879
R346 VPWR.n211 VPWR.n194 72.7879
R347 VPWR.n209 VPWR.n191 72.7879
R348 VPWR.n205 VPWR.n204 72.7879
R349 VPWR.n201 VPWR.n197 72.7879
R350 VPWR.n201 VPWR.n200 72.7879
R351 VPWR.n204 VPWR.n196 72.7879
R352 VPWR.n212 VPWR.n211 72.7879
R353 VPWR.n210 VPWR.n209 72.7879
R354 VPWR.n174 VPWR.n157 72.7879
R355 VPWR.n172 VPWR.n154 72.7879
R356 VPWR.n168 VPWR.n167 72.7879
R357 VPWR.n164 VPWR.n160 72.7879
R358 VPWR.n164 VPWR.n163 72.7879
R359 VPWR.n167 VPWR.n159 72.7879
R360 VPWR.n175 VPWR.n174 72.7879
R361 VPWR.n173 VPWR.n172 72.7879
R362 VPWR.n137 VPWR.n120 72.7879
R363 VPWR.n135 VPWR.n117 72.7879
R364 VPWR.n131 VPWR.n130 72.7879
R365 VPWR.n127 VPWR.n123 72.7879
R366 VPWR.n127 VPWR.n126 72.7879
R367 VPWR.n130 VPWR.n122 72.7879
R368 VPWR.n138 VPWR.n137 72.7879
R369 VPWR.n136 VPWR.n135 72.7879
R370 VPWR.n100 VPWR.n83 72.7879
R371 VPWR.n98 VPWR.n80 72.7879
R372 VPWR.n94 VPWR.n93 72.7879
R373 VPWR.n90 VPWR.n86 72.7879
R374 VPWR.n90 VPWR.n89 72.7879
R375 VPWR.n93 VPWR.n85 72.7879
R376 VPWR.n101 VPWR.n100 72.7879
R377 VPWR.n99 VPWR.n98 72.7879
R378 VPWR.n63 VPWR.n46 72.7879
R379 VPWR.n61 VPWR.n43 72.7879
R380 VPWR.n57 VPWR.n56 72.7879
R381 VPWR.n53 VPWR.n49 72.7879
R382 VPWR.n53 VPWR.n52 72.7879
R383 VPWR.n56 VPWR.n48 72.7879
R384 VPWR.n64 VPWR.n63 72.7879
R385 VPWR.n62 VPWR.n61 72.7879
R386 VPWR.n26 VPWR.n9 72.7879
R387 VPWR.n24 VPWR.n6 72.7879
R388 VPWR.n20 VPWR.n19 72.7879
R389 VPWR.n16 VPWR.n12 72.7879
R390 VPWR.n16 VPWR.n15 72.7879
R391 VPWR.n19 VPWR.n11 72.7879
R392 VPWR.n27 VPWR.n26 72.7879
R393 VPWR.n25 VPWR.n24 72.7879
R394 VPWR.n322 VPWR.n305 72.7879
R395 VPWR.n320 VPWR.n302 72.7879
R396 VPWR.n316 VPWR.n315 72.7879
R397 VPWR.n312 VPWR.n308 72.7879
R398 VPWR.n312 VPWR.n311 72.7879
R399 VPWR.n315 VPWR.n307 72.7879
R400 VPWR.n323 VPWR.n322 72.7879
R401 VPWR.n321 VPWR.n320 72.7879
R402 VPWR.n276 VPWR.t14 56.8667
R403 VPWR.n291 VPWR.t14 56.8667
R404 VPWR.n239 VPWR.t10 56.8667
R405 VPWR.n254 VPWR.t10 56.8667
R406 VPWR.n202 VPWR.t4 56.8667
R407 VPWR.n217 VPWR.t4 56.8667
R408 VPWR.n165 VPWR.t8 56.8667
R409 VPWR.n180 VPWR.t8 56.8667
R410 VPWR.n128 VPWR.t2 56.8667
R411 VPWR.n143 VPWR.t2 56.8667
R412 VPWR.n91 VPWR.t16 56.8667
R413 VPWR.n106 VPWR.t16 56.8667
R414 VPWR.n54 VPWR.t6 56.8667
R415 VPWR.n69 VPWR.t6 56.8667
R416 VPWR.n17 VPWR.t0 56.8667
R417 VPWR.n32 VPWR.t0 56.8667
R418 VPWR.n313 VPWR.t12 56.8667
R419 VPWR.n328 VPWR.t12 56.8667
R420 VPWR.n277 VPWR.n275 56.1076
R421 VPWR.n278 VPWR.n277 56.1076
R422 VPWR.n285 VPWR.n266 56.1076
R423 VPWR.n283 VPWR.n266 56.1076
R424 VPWR.n240 VPWR.n238 56.1076
R425 VPWR.n241 VPWR.n240 56.1076
R426 VPWR.n248 VPWR.n229 56.1076
R427 VPWR.n246 VPWR.n229 56.1076
R428 VPWR.n203 VPWR.n201 56.1076
R429 VPWR.n204 VPWR.n203 56.1076
R430 VPWR.n211 VPWR.n192 56.1076
R431 VPWR.n209 VPWR.n192 56.1076
R432 VPWR.n166 VPWR.n164 56.1076
R433 VPWR.n167 VPWR.n166 56.1076
R434 VPWR.n174 VPWR.n155 56.1076
R435 VPWR.n172 VPWR.n155 56.1076
R436 VPWR.n129 VPWR.n127 56.1076
R437 VPWR.n130 VPWR.n129 56.1076
R438 VPWR.n137 VPWR.n118 56.1076
R439 VPWR.n135 VPWR.n118 56.1076
R440 VPWR.n92 VPWR.n90 56.1076
R441 VPWR.n93 VPWR.n92 56.1076
R442 VPWR.n100 VPWR.n81 56.1076
R443 VPWR.n98 VPWR.n81 56.1076
R444 VPWR.n55 VPWR.n53 56.1076
R445 VPWR.n56 VPWR.n55 56.1076
R446 VPWR.n63 VPWR.n44 56.1076
R447 VPWR.n61 VPWR.n44 56.1076
R448 VPWR.n18 VPWR.n16 56.1076
R449 VPWR.n19 VPWR.n18 56.1076
R450 VPWR.n26 VPWR.n7 56.1076
R451 VPWR.n24 VPWR.n7 56.1076
R452 VPWR.n314 VPWR.n312 56.1076
R453 VPWR.n315 VPWR.n314 56.1076
R454 VPWR.n322 VPWR.n303 56.1076
R455 VPWR.n320 VPWR.n303 56.1076
R456 VPWR.n280 VPWR.n269 25.6005
R457 VPWR.n272 VPWR.n269 25.6005
R458 VPWR.n273 VPWR.n272 25.6005
R459 VPWR.n289 VPWR.n281 25.6005
R460 VPWR.n288 VPWR.n287 25.6005
R461 VPWR.n287 VPWR.n282 25.6005
R462 VPWR.n282 VPWR.n263 25.6005
R463 VPWR.n243 VPWR.n232 25.6005
R464 VPWR.n235 VPWR.n232 25.6005
R465 VPWR.n236 VPWR.n235 25.6005
R466 VPWR.n252 VPWR.n244 25.6005
R467 VPWR.n251 VPWR.n250 25.6005
R468 VPWR.n250 VPWR.n245 25.6005
R469 VPWR.n245 VPWR.n226 25.6005
R470 VPWR.n206 VPWR.n195 25.6005
R471 VPWR.n198 VPWR.n195 25.6005
R472 VPWR.n199 VPWR.n198 25.6005
R473 VPWR.n215 VPWR.n207 25.6005
R474 VPWR.n214 VPWR.n213 25.6005
R475 VPWR.n213 VPWR.n208 25.6005
R476 VPWR.n208 VPWR.n189 25.6005
R477 VPWR.n169 VPWR.n158 25.6005
R478 VPWR.n161 VPWR.n158 25.6005
R479 VPWR.n162 VPWR.n161 25.6005
R480 VPWR.n178 VPWR.n170 25.6005
R481 VPWR.n177 VPWR.n176 25.6005
R482 VPWR.n176 VPWR.n171 25.6005
R483 VPWR.n171 VPWR.n152 25.6005
R484 VPWR.n132 VPWR.n121 25.6005
R485 VPWR.n124 VPWR.n121 25.6005
R486 VPWR.n125 VPWR.n124 25.6005
R487 VPWR.n141 VPWR.n133 25.6005
R488 VPWR.n140 VPWR.n139 25.6005
R489 VPWR.n139 VPWR.n134 25.6005
R490 VPWR.n134 VPWR.n115 25.6005
R491 VPWR.n95 VPWR.n84 25.6005
R492 VPWR.n87 VPWR.n84 25.6005
R493 VPWR.n88 VPWR.n87 25.6005
R494 VPWR.n104 VPWR.n96 25.6005
R495 VPWR.n103 VPWR.n102 25.6005
R496 VPWR.n102 VPWR.n97 25.6005
R497 VPWR.n97 VPWR.n78 25.6005
R498 VPWR.n58 VPWR.n47 25.6005
R499 VPWR.n50 VPWR.n47 25.6005
R500 VPWR.n51 VPWR.n50 25.6005
R501 VPWR.n67 VPWR.n59 25.6005
R502 VPWR.n66 VPWR.n65 25.6005
R503 VPWR.n65 VPWR.n60 25.6005
R504 VPWR.n60 VPWR.n41 25.6005
R505 VPWR.n21 VPWR.n10 25.6005
R506 VPWR.n13 VPWR.n10 25.6005
R507 VPWR.n14 VPWR.n13 25.6005
R508 VPWR.n30 VPWR.n22 25.6005
R509 VPWR.n29 VPWR.n28 25.6005
R510 VPWR.n28 VPWR.n23 25.6005
R511 VPWR.n23 VPWR.n4 25.6005
R512 VPWR.n317 VPWR.n306 25.6005
R513 VPWR.n309 VPWR.n306 25.6005
R514 VPWR.n310 VPWR.n309 25.6005
R515 VPWR.n326 VPWR.n318 25.6005
R516 VPWR.n325 VPWR.n324 25.6005
R517 VPWR.n324 VPWR.n319 25.6005
R518 VPWR.n319 VPWR.n300 25.6005
R519 VPWR.n294 VPWR 18.865
R520 VPWR.n257 VPWR 18.865
R521 VPWR.n220 VPWR 18.865
R522 VPWR.n183 VPWR 18.865
R523 VPWR.n146 VPWR 18.865
R524 VPWR.n109 VPWR 18.865
R525 VPWR.n72 VPWR 18.865
R526 VPWR.n35 VPWR 18.865
R527 VPWR.n331 VPWR 18.865
R528 VPWR VPWR.n295 12.8005
R529 VPWR.n296 VPWR 12.8005
R530 VPWR VPWR.n258 12.8005
R531 VPWR.n259 VPWR 12.8005
R532 VPWR VPWR.n262 12.8005
R533 VPWR VPWR.n293 12.8005
R534 VPWR VPWR.n221 12.8005
R535 VPWR.n222 VPWR 12.8005
R536 VPWR VPWR.n225 12.8005
R537 VPWR VPWR.n256 12.8005
R538 VPWR VPWR.n184 12.8005
R539 VPWR.n185 VPWR 12.8005
R540 VPWR VPWR.n188 12.8005
R541 VPWR VPWR.n219 12.8005
R542 VPWR VPWR.n147 12.8005
R543 VPWR.n148 VPWR 12.8005
R544 VPWR VPWR.n151 12.8005
R545 VPWR VPWR.n182 12.8005
R546 VPWR VPWR.n110 12.8005
R547 VPWR.n111 VPWR 12.8005
R548 VPWR VPWR.n114 12.8005
R549 VPWR VPWR.n145 12.8005
R550 VPWR VPWR.n73 12.8005
R551 VPWR.n74 VPWR 12.8005
R552 VPWR VPWR.n77 12.8005
R553 VPWR VPWR.n108 12.8005
R554 VPWR VPWR.n36 12.8005
R555 VPWR.n37 VPWR 12.8005
R556 VPWR VPWR.n40 12.8005
R557 VPWR VPWR.n71 12.8005
R558 VPWR VPWR.n0 12.8005
R559 VPWR.n1 VPWR 12.8005
R560 VPWR VPWR.n3 12.8005
R561 VPWR VPWR.n34 12.8005
R562 VPWR VPWR.n299 12.8005
R563 VPWR VPWR.n330 12.8005
R564 VPWR.n35 VPWR.n2 10.6503
R565 VPWR.n298 VPWR.n297 10.5563
R566 VPWR.n261 VPWR.n260 10.5563
R567 VPWR.n224 VPWR.n223 10.5563
R568 VPWR.n187 VPWR.n186 10.5563
R569 VPWR.n150 VPWR.n149 10.5563
R570 VPWR.n113 VPWR.n112 10.5563
R571 VPWR.n76 VPWR.n75 10.5563
R572 VPWR.n39 VPWR.n38 10.5563
R573 VPWR.n297 VPWR.n295 10.1513
R574 VPWR.n297 VPWR.n296 10.1513
R575 VPWR.n260 VPWR.n258 10.1513
R576 VPWR.n260 VPWR.n259 10.1513
R577 VPWR.n223 VPWR.n221 10.1513
R578 VPWR.n223 VPWR.n222 10.1513
R579 VPWR.n186 VPWR.n184 10.1513
R580 VPWR.n186 VPWR.n185 10.1513
R581 VPWR.n149 VPWR.n147 10.1513
R582 VPWR.n149 VPWR.n148 10.1513
R583 VPWR.n112 VPWR.n110 10.1513
R584 VPWR.n112 VPWR.n111 10.1513
R585 VPWR.n75 VPWR.n73 10.1513
R586 VPWR.n75 VPWR.n74 10.1513
R587 VPWR.n38 VPWR.n36 10.1513
R588 VPWR.n38 VPWR.n37 10.1513
R589 VPWR.n2 VPWR.n0 10.1513
R590 VPWR.n2 VPWR.n1 10.1513
R591 VPWR VPWR.n331 4.46447
R592 VPWR.n39 VPWR.n35 1.01178
R593 VPWR.n76 VPWR.n72 1.01178
R594 VPWR.n113 VPWR.n109 1.01178
R595 VPWR.n150 VPWR.n146 1.01178
R596 VPWR.n187 VPWR.n183 1.01178
R597 VPWR.n224 VPWR.n220 1.01178
R598 VPWR.n261 VPWR.n257 1.01178
R599 VPWR.n298 VPWR.n294 1.01178
R600 VPWR.n72 VPWR.n39 0.0945
R601 VPWR.n109 VPWR.n76 0.0945
R602 VPWR.n146 VPWR.n113 0.0945
R603 VPWR.n183 VPWR.n150 0.0945
R604 VPWR.n220 VPWR.n187 0.0945
R605 VPWR.n257 VPWR.n224 0.0945
R606 VPWR.n294 VPWR.n261 0.0945
R607 VPWR.n331 VPWR.n298 0.0945
R608 VGND.n312 VGND.n311 6809.77
R609 VGND.n304 VGND.n52 4272.39
R610 VGND.n280 VGND.n279 4057.78
R611 VGND.n279 VGND.n278 4057.78
R612 VGND.n278 VGND.n277 4057.78
R613 VGND.n277 VGND.n276 4057.78
R614 VGND.n276 VGND.n275 4057.78
R615 VGND.n275 VGND.n14 4057.78
R616 VGND.n312 VGND.n14 4057.78
R617 VGND.n280 VGND.n52 3499.87
R618 VGND.n311 VGND.n310 1934.17
R619 VGND.n310 VGND.n309 1934.17
R620 VGND.n309 VGND.n308 1934.17
R621 VGND.n308 VGND.n307 1934.17
R622 VGND.n307 VGND.n306 1934.17
R623 VGND.n306 VGND.n305 1934.17
R624 VGND.n305 VGND.n304 1934.17
R625 VGND.n289 VGND.n61 1315.26
R626 VGND.n286 VGND.n283 1315.26
R627 VGND.n59 VGND.n54 1315.26
R628 VGND.n301 VGND.n55 1315.26
R629 VGND.n314 VGND.n10 1315.26
R630 VGND.n316 VGND.n12 1315.26
R631 VGND.n327 VGND.n8 1315.26
R632 VGND.n330 VGND.n329 1315.26
R633 VGND.n32 VGND.n23 1315.26
R634 VGND.n29 VGND.n26 1315.26
R635 VGND.n21 VGND.n16 1315.26
R636 VGND.n44 VGND.n17 1315.26
R637 VGND.n272 VGND.n68 1315.26
R638 VGND.n268 VGND.n67 1315.26
R639 VGND.n261 VGND.n74 1315.26
R640 VGND.n259 VGND.n77 1315.26
R641 VGND.n233 VGND.n229 1315.26
R642 VGND.n235 VGND.n231 1315.26
R643 VGND.n246 VGND.n227 1315.26
R644 VGND.n249 VGND.n248 1315.26
R645 VGND.n198 VGND.n194 1315.26
R646 VGND.n200 VGND.n196 1315.26
R647 VGND.n211 VGND.n192 1315.26
R648 VGND.n214 VGND.n213 1315.26
R649 VGND.n167 VGND.n163 1315.26
R650 VGND.n169 VGND.n165 1315.26
R651 VGND.n180 VGND.n161 1315.26
R652 VGND.n183 VGND.n182 1315.26
R653 VGND.n132 VGND.n128 1315.26
R654 VGND.n134 VGND.n130 1315.26
R655 VGND.n145 VGND.n126 1315.26
R656 VGND.n148 VGND.n147 1315.26
R657 VGND.n99 VGND.n87 1315.26
R658 VGND.n110 VGND.n88 1315.26
R659 VGND.n112 VGND.n85 1315.26
R660 VGND.n94 VGND.n84 1315.26
R661 VGND.n311 VGND.n6 993.668
R662 VGND.n310 VGND.n46 993.668
R663 VGND.n309 VGND.n47 993.668
R664 VGND.n308 VGND.n48 993.668
R665 VGND.n307 VGND.n49 993.668
R666 VGND.n306 VGND.n50 993.668
R667 VGND.n305 VGND.n51 993.668
R668 VGND.n304 VGND.n303 993.668
R669 VGND.n86 VGND.n52 662.304
R670 VGND.n318 VGND.n12 585
R671 VGND.n12 VGND.n11 585
R672 VGND.n321 VGND.n320 585
R673 VGND.n322 VGND.n321 585
R674 VGND.n319 VGND.n4 585
R675 VGND.n5 VGND.n4 585
R676 VGND.n329 VGND.n2 585
R677 VGND.n329 VGND.n328 585
R678 VGND.n331 VGND.n330 585
R679 VGND.n8 VGND.n1 585
R680 VGND.n327 VGND.n326 585
R681 VGND.n328 VGND.n327 585
R682 VGND.n325 VGND.n7 585
R683 VGND.n7 VGND.n5 585
R684 VGND.n324 VGND.n323 585
R685 VGND.n323 VGND.n322 585
R686 VGND.n10 VGND.n9 585
R687 VGND.n11 VGND.n10 585
R688 VGND.n314 VGND.n13 585
R689 VGND.n317 VGND.n316 585
R690 VGND.n29 VGND.n28 585
R691 VGND.n31 VGND.n29 585
R692 VGND.n19 VGND.n18 585
R693 VGND.n30 VGND.n19 585
R694 VGND.n41 VGND.n40 585
R695 VGND.n40 VGND.n39 585
R696 VGND.n42 VGND.n17 585
R697 VGND.n17 VGND.n15 585
R698 VGND.n44 VGND.n43 585
R699 VGND.n35 VGND.n16 585
R700 VGND.n36 VGND.n21 585
R701 VGND.n21 VGND.n15 585
R702 VGND.n38 VGND.n37 585
R703 VGND.n39 VGND.n38 585
R704 VGND.n34 VGND.n20 585
R705 VGND.n30 VGND.n20 585
R706 VGND.n33 VGND.n32 585
R707 VGND.n32 VGND.n31 585
R708 VGND.n23 VGND.n22 585
R709 VGND.n27 VGND.n26 585
R710 VGND.n269 VGND.n268 585
R711 VGND.n268 VGND.n66 585
R712 VGND.n267 VGND.n70 585
R713 VGND.n267 VGND.n266 585
R714 VGND.n78 VGND.n71 585
R715 VGND.n75 VGND.n71 585
R716 VGND.n259 VGND.n258 585
R717 VGND.n260 VGND.n259 585
R718 VGND.n257 VGND.n77 585
R719 VGND.n74 VGND.n73 585
R720 VGND.n262 VGND.n261 585
R721 VGND.n261 VGND.n260 585
R722 VGND.n263 VGND.n72 585
R723 VGND.n75 VGND.n72 585
R724 VGND.n265 VGND.n264 585
R725 VGND.n266 VGND.n265 585
R726 VGND.n69 VGND.n68 585
R727 VGND.n68 VGND.n66 585
R728 VGND.n272 VGND.n271 585
R729 VGND.n270 VGND.n67 585
R730 VGND.n237 VGND.n231 585
R731 VGND.n231 VGND.n230 585
R732 VGND.n240 VGND.n239 585
R733 VGND.n241 VGND.n240 585
R734 VGND.n238 VGND.n224 585
R735 VGND.n225 VGND.n224 585
R736 VGND.n248 VGND.n222 585
R737 VGND.n248 VGND.n247 585
R738 VGND.n250 VGND.n249 585
R739 VGND.n227 VGND.n221 585
R740 VGND.n246 VGND.n245 585
R741 VGND.n247 VGND.n246 585
R742 VGND.n244 VGND.n226 585
R743 VGND.n226 VGND.n225 585
R744 VGND.n243 VGND.n242 585
R745 VGND.n242 VGND.n241 585
R746 VGND.n229 VGND.n228 585
R747 VGND.n230 VGND.n229 585
R748 VGND.n233 VGND.n232 585
R749 VGND.n236 VGND.n235 585
R750 VGND.n202 VGND.n196 585
R751 VGND.n196 VGND.n195 585
R752 VGND.n205 VGND.n204 585
R753 VGND.n206 VGND.n205 585
R754 VGND.n203 VGND.n189 585
R755 VGND.n190 VGND.n189 585
R756 VGND.n213 VGND.n187 585
R757 VGND.n213 VGND.n212 585
R758 VGND.n215 VGND.n214 585
R759 VGND.n192 VGND.n186 585
R760 VGND.n211 VGND.n210 585
R761 VGND.n212 VGND.n211 585
R762 VGND.n209 VGND.n191 585
R763 VGND.n191 VGND.n190 585
R764 VGND.n208 VGND.n207 585
R765 VGND.n207 VGND.n206 585
R766 VGND.n194 VGND.n193 585
R767 VGND.n195 VGND.n194 585
R768 VGND.n198 VGND.n197 585
R769 VGND.n201 VGND.n200 585
R770 VGND.n171 VGND.n165 585
R771 VGND.n165 VGND.n164 585
R772 VGND.n174 VGND.n173 585
R773 VGND.n175 VGND.n174 585
R774 VGND.n172 VGND.n158 585
R775 VGND.n159 VGND.n158 585
R776 VGND.n182 VGND.n156 585
R777 VGND.n182 VGND.n181 585
R778 VGND.n184 VGND.n183 585
R779 VGND.n161 VGND.n155 585
R780 VGND.n180 VGND.n179 585
R781 VGND.n181 VGND.n180 585
R782 VGND.n178 VGND.n160 585
R783 VGND.n160 VGND.n159 585
R784 VGND.n177 VGND.n176 585
R785 VGND.n176 VGND.n175 585
R786 VGND.n163 VGND.n162 585
R787 VGND.n164 VGND.n163 585
R788 VGND.n167 VGND.n166 585
R789 VGND.n170 VGND.n169 585
R790 VGND.n136 VGND.n130 585
R791 VGND.n130 VGND.n129 585
R792 VGND.n139 VGND.n138 585
R793 VGND.n140 VGND.n139 585
R794 VGND.n137 VGND.n123 585
R795 VGND.n124 VGND.n123 585
R796 VGND.n147 VGND.n121 585
R797 VGND.n147 VGND.n146 585
R798 VGND.n149 VGND.n148 585
R799 VGND.n126 VGND.n120 585
R800 VGND.n145 VGND.n144 585
R801 VGND.n146 VGND.n145 585
R802 VGND.n143 VGND.n125 585
R803 VGND.n125 VGND.n124 585
R804 VGND.n142 VGND.n141 585
R805 VGND.n141 VGND.n140 585
R806 VGND.n128 VGND.n127 585
R807 VGND.n129 VGND.n128 585
R808 VGND.n132 VGND.n131 585
R809 VGND.n135 VGND.n134 585
R810 VGND.n286 VGND.n285 585
R811 VGND.n288 VGND.n286 585
R812 VGND.n57 VGND.n56 585
R813 VGND.n287 VGND.n57 585
R814 VGND.n298 VGND.n297 585
R815 VGND.n297 VGND.n296 585
R816 VGND.n299 VGND.n55 585
R817 VGND.n55 VGND.n53 585
R818 VGND.n301 VGND.n300 585
R819 VGND.n292 VGND.n54 585
R820 VGND.n293 VGND.n59 585
R821 VGND.n59 VGND.n53 585
R822 VGND.n295 VGND.n294 585
R823 VGND.n296 VGND.n295 585
R824 VGND.n291 VGND.n58 585
R825 VGND.n287 VGND.n58 585
R826 VGND.n290 VGND.n289 585
R827 VGND.n289 VGND.n288 585
R828 VGND.n61 VGND.n60 585
R829 VGND.n284 VGND.n283 585
R830 VGND.n94 VGND.n93 585
R831 VGND.n92 VGND.n91 585
R832 VGND.n90 VGND.n89 585
R833 VGND.n100 VGND.n99 585
R834 VGND.n101 VGND.n87 585
R835 VGND.n96 VGND.n87 585
R836 VGND.n110 VGND.n109 585
R837 VGND.n111 VGND.n110 585
R838 VGND.n108 VGND.n88 585
R839 VGND.n107 VGND.n106 585
R840 VGND.n104 VGND.n102 585
R841 VGND.n85 VGND.n83 585
R842 VGND.n113 VGND.n112 585
R843 VGND.n112 VGND.n111 585
R844 VGND.n84 VGND.n82 585
R845 VGND.n96 VGND.n84 585
R846 VGND.n289 VGND.n58 394
R847 VGND.n295 VGND.n58 394
R848 VGND.n295 VGND.n59 394
R849 VGND.n286 VGND.n57 394
R850 VGND.n297 VGND.n57 394
R851 VGND.n297 VGND.n55 394
R852 VGND.n323 VGND.n10 394
R853 VGND.n323 VGND.n7 394
R854 VGND.n327 VGND.n7 394
R855 VGND.n321 VGND.n12 394
R856 VGND.n321 VGND.n4 394
R857 VGND.n329 VGND.n4 394
R858 VGND.n32 VGND.n20 394
R859 VGND.n38 VGND.n20 394
R860 VGND.n38 VGND.n21 394
R861 VGND.n29 VGND.n19 394
R862 VGND.n40 VGND.n19 394
R863 VGND.n40 VGND.n17 394
R864 VGND.n265 VGND.n68 394
R865 VGND.n265 VGND.n72 394
R866 VGND.n261 VGND.n72 394
R867 VGND.n268 VGND.n267 394
R868 VGND.n267 VGND.n71 394
R869 VGND.n259 VGND.n71 394
R870 VGND.n242 VGND.n229 394
R871 VGND.n242 VGND.n226 394
R872 VGND.n246 VGND.n226 394
R873 VGND.n240 VGND.n231 394
R874 VGND.n240 VGND.n224 394
R875 VGND.n248 VGND.n224 394
R876 VGND.n207 VGND.n194 394
R877 VGND.n207 VGND.n191 394
R878 VGND.n211 VGND.n191 394
R879 VGND.n205 VGND.n196 394
R880 VGND.n205 VGND.n189 394
R881 VGND.n213 VGND.n189 394
R882 VGND.n176 VGND.n163 394
R883 VGND.n176 VGND.n160 394
R884 VGND.n180 VGND.n160 394
R885 VGND.n174 VGND.n165 394
R886 VGND.n174 VGND.n158 394
R887 VGND.n182 VGND.n158 394
R888 VGND.n141 VGND.n128 394
R889 VGND.n141 VGND.n125 394
R890 VGND.n145 VGND.n125 394
R891 VGND.n139 VGND.n130 394
R892 VGND.n139 VGND.n123 394
R893 VGND.n147 VGND.n123 394
R894 VGND.n110 VGND.n87 394
R895 VGND.n106 VGND.n104 394
R896 VGND.n112 VGND.n84 394
R897 VGND.n91 VGND.n90 394
R898 VGND.n97 VGND.n96 357.068
R899 VGND.n111 VGND.n86 357.068
R900 VGND.t12 VGND.n252 255.345
R901 VGND.n253 VGND.t12 255.345
R902 VGND.t6 VGND.n217 255.345
R903 VGND.n218 VGND.t6 255.345
R904 VGND.t1 VGND.n151 255.345
R905 VGND.n152 VGND.t1 255.345
R906 VGND.t9 VGND.n115 255.345
R907 VGND.n116 VGND.t9 255.345
R908 VGND.t4 VGND.n79 255.345
R909 VGND.n80 VGND.t4 255.345
R910 VGND.n313 VGND.n11 220
R911 VGND.n328 VGND.n6 220
R912 VGND.n31 VGND.n24 220
R913 VGND.n46 VGND.n15 220
R914 VGND.n274 VGND.n66 220
R915 VGND.n260 VGND.n47 220
R916 VGND.n230 VGND.n65 220
R917 VGND.n247 VGND.n48 220
R918 VGND.n195 VGND.n64 220
R919 VGND.n212 VGND.n49 220
R920 VGND.n164 VGND.n63 220
R921 VGND.n181 VGND.n50 220
R922 VGND.n129 VGND.n62 220
R923 VGND.n146 VGND.n51 220
R924 VGND.n288 VGND.n281 220
R925 VGND.n303 VGND.n53 220
R926 VGND.n6 VGND.n3 218.815
R927 VGND.n315 VGND.n313 218.815
R928 VGND.n46 VGND.n45 218.815
R929 VGND.n25 VGND.n24 218.815
R930 VGND.n76 VGND.n47 218.815
R931 VGND.n274 VGND.n273 218.815
R932 VGND.n223 VGND.n48 218.815
R933 VGND.n234 VGND.n65 218.815
R934 VGND.n188 VGND.n49 218.815
R935 VGND.n199 VGND.n64 218.815
R936 VGND.n157 VGND.n50 218.815
R937 VGND.n168 VGND.n63 218.815
R938 VGND.n122 VGND.n51 218.815
R939 VGND.n133 VGND.n62 218.815
R940 VGND.n303 VGND.n302 218.815
R941 VGND.n282 VGND.n281 218.815
R942 VGND.n97 VGND.n95 218.815
R943 VGND.n98 VGND.n97 218.815
R944 VGND.n105 VGND.n86 218.815
R945 VGND.n103 VGND.n86 218.815
R946 VGND.n282 VGND.n61 147.374
R947 VGND.n302 VGND.n301 147.374
R948 VGND.n315 VGND.n314 147.374
R949 VGND.n330 VGND.n3 147.374
R950 VGND.n8 VGND.n3 147.374
R951 VGND.n316 VGND.n315 147.374
R952 VGND.n25 VGND.n23 147.374
R953 VGND.n45 VGND.n44 147.374
R954 VGND.n45 VGND.n16 147.374
R955 VGND.n26 VGND.n25 147.374
R956 VGND.n273 VGND.n272 147.374
R957 VGND.n77 VGND.n76 147.374
R958 VGND.n76 VGND.n74 147.374
R959 VGND.n273 VGND.n67 147.374
R960 VGND.n234 VGND.n233 147.374
R961 VGND.n249 VGND.n223 147.374
R962 VGND.n227 VGND.n223 147.374
R963 VGND.n235 VGND.n234 147.374
R964 VGND.n199 VGND.n198 147.374
R965 VGND.n214 VGND.n188 147.374
R966 VGND.n192 VGND.n188 147.374
R967 VGND.n200 VGND.n199 147.374
R968 VGND.n168 VGND.n167 147.374
R969 VGND.n183 VGND.n157 147.374
R970 VGND.n161 VGND.n157 147.374
R971 VGND.n169 VGND.n168 147.374
R972 VGND.n133 VGND.n132 147.374
R973 VGND.n148 VGND.n122 147.374
R974 VGND.n126 VGND.n122 147.374
R975 VGND.n134 VGND.n133 147.374
R976 VGND.n302 VGND.n54 147.374
R977 VGND.n283 VGND.n282 147.374
R978 VGND.n105 VGND.n88 147.374
R979 VGND.n103 VGND.n85 147.374
R980 VGND.n99 VGND.n98 147.374
R981 VGND.n95 VGND.n91 147.374
R982 VGND.n95 VGND.n94 147.374
R983 VGND.n98 VGND.n90 147.374
R984 VGND.n106 VGND.n105 147.374
R985 VGND.n104 VGND.n103 147.374
R986 VGND.n322 VGND.n11 124.668
R987 VGND.n328 VGND.n5 124.668
R988 VGND.n31 VGND.n30 124.668
R989 VGND.n39 VGND.n15 124.668
R990 VGND.n266 VGND.n66 124.668
R991 VGND.n260 VGND.n75 124.668
R992 VGND.n241 VGND.n230 124.668
R993 VGND.n247 VGND.n225 124.668
R994 VGND.n206 VGND.n195 124.668
R995 VGND.n212 VGND.n190 124.668
R996 VGND.n175 VGND.n164 124.668
R997 VGND.n181 VGND.n159 124.668
R998 VGND.n140 VGND.n129 124.668
R999 VGND.n146 VGND.n124 124.668
R1000 VGND.n288 VGND.n287 124.668
R1001 VGND.n296 VGND.n53 124.668
R1002 VGND.n313 VGND.n312 113.668
R1003 VGND.n24 VGND.n14 113.668
R1004 VGND.n275 VGND.n274 113.668
R1005 VGND.n276 VGND.n65 113.668
R1006 VGND.n277 VGND.n64 113.668
R1007 VGND.n278 VGND.n63 113.668
R1008 VGND.n279 VGND.n62 113.668
R1009 VGND.n281 VGND.n280 113.668
R1010 VGND.n96 VGND.t3 97.9063
R1011 VGND.n111 VGND.t3 97.9063
R1012 VGND.n290 VGND.n60 85.4593
R1013 VGND.n285 VGND.n284 85.4593
R1014 VGND.n293 VGND.n292 85.4593
R1015 VGND.n300 VGND.n299 85.4593
R1016 VGND.n13 VGND.n9 85.4593
R1017 VGND.n318 VGND.n317 85.4593
R1018 VGND.n326 VGND.n1 85.4593
R1019 VGND.n331 VGND.n2 85.4593
R1020 VGND.n33 VGND.n22 85.4593
R1021 VGND.n28 VGND.n27 85.4593
R1022 VGND.n36 VGND.n35 85.4593
R1023 VGND.n43 VGND.n42 85.4593
R1024 VGND.n271 VGND.n69 85.4593
R1025 VGND.n270 VGND.n269 85.4593
R1026 VGND.n262 VGND.n73 85.4593
R1027 VGND.n258 VGND.n257 85.4593
R1028 VGND.n232 VGND.n228 85.4593
R1029 VGND.n237 VGND.n236 85.4593
R1030 VGND.n245 VGND.n221 85.4593
R1031 VGND.n250 VGND.n222 85.4593
R1032 VGND.n197 VGND.n193 85.4593
R1033 VGND.n202 VGND.n201 85.4593
R1034 VGND.n210 VGND.n186 85.4593
R1035 VGND.n215 VGND.n187 85.4593
R1036 VGND.n166 VGND.n162 85.4593
R1037 VGND.n171 VGND.n170 85.4593
R1038 VGND.n179 VGND.n155 85.4593
R1039 VGND.n184 VGND.n156 85.4593
R1040 VGND.n131 VGND.n127 85.4593
R1041 VGND.n136 VGND.n135 85.4593
R1042 VGND.n144 VGND.n120 85.4593
R1043 VGND.n149 VGND.n121 85.4593
R1044 VGND.n101 VGND.n100 85.4593
R1045 VGND.n93 VGND.n82 85.4593
R1046 VGND.n109 VGND.n108 85.4593
R1047 VGND.n113 VGND.n83 85.4593
R1048 VGND.n322 VGND.t7 62.3338
R1049 VGND.t7 VGND.n5 62.3338
R1050 VGND.n30 VGND.t11 62.3338
R1051 VGND.n39 VGND.t11 62.3338
R1052 VGND.n266 VGND.t2 62.3338
R1053 VGND.n75 VGND.t2 62.3338
R1054 VGND.n241 VGND.t5 62.3338
R1055 VGND.t5 VGND.n225 62.3338
R1056 VGND.n206 VGND.t10 62.3338
R1057 VGND.t10 VGND.n190 62.3338
R1058 VGND.n175 VGND.t0 62.3338
R1059 VGND.t0 VGND.n159 62.3338
R1060 VGND.n140 VGND.t13 62.3338
R1061 VGND.t13 VGND.n124 62.3338
R1062 VGND.n287 VGND.t8 62.3338
R1063 VGND.n296 VGND.t8 62.3338
R1064 VGND.n284 VGND.n60 25.6005
R1065 VGND.n291 VGND.n290 25.6005
R1066 VGND.n294 VGND.n291 25.6005
R1067 VGND.n294 VGND.n293 25.6005
R1068 VGND.n285 VGND.n56 25.6005
R1069 VGND.n298 VGND.n56 25.6005
R1070 VGND.n299 VGND.n298 25.6005
R1071 VGND.n317 VGND.n13 25.6005
R1072 VGND.n324 VGND.n9 25.6005
R1073 VGND.n325 VGND.n324 25.6005
R1074 VGND.n326 VGND.n325 25.6005
R1075 VGND.n320 VGND.n318 25.6005
R1076 VGND.n320 VGND.n319 25.6005
R1077 VGND.n319 VGND.n2 25.6005
R1078 VGND.n27 VGND.n22 25.6005
R1079 VGND.n34 VGND.n33 25.6005
R1080 VGND.n37 VGND.n34 25.6005
R1081 VGND.n37 VGND.n36 25.6005
R1082 VGND.n28 VGND.n18 25.6005
R1083 VGND.n41 VGND.n18 25.6005
R1084 VGND.n42 VGND.n41 25.6005
R1085 VGND.n271 VGND.n270 25.6005
R1086 VGND.n264 VGND.n69 25.6005
R1087 VGND.n264 VGND.n263 25.6005
R1088 VGND.n263 VGND.n262 25.6005
R1089 VGND.n269 VGND.n70 25.6005
R1090 VGND.n78 VGND.n70 25.6005
R1091 VGND.n258 VGND.n78 25.6005
R1092 VGND.n236 VGND.n232 25.6005
R1093 VGND.n243 VGND.n228 25.6005
R1094 VGND.n244 VGND.n243 25.6005
R1095 VGND.n245 VGND.n244 25.6005
R1096 VGND.n239 VGND.n237 25.6005
R1097 VGND.n239 VGND.n238 25.6005
R1098 VGND.n238 VGND.n222 25.6005
R1099 VGND.n201 VGND.n197 25.6005
R1100 VGND.n208 VGND.n193 25.6005
R1101 VGND.n209 VGND.n208 25.6005
R1102 VGND.n210 VGND.n209 25.6005
R1103 VGND.n204 VGND.n202 25.6005
R1104 VGND.n204 VGND.n203 25.6005
R1105 VGND.n203 VGND.n187 25.6005
R1106 VGND.n170 VGND.n166 25.6005
R1107 VGND.n177 VGND.n162 25.6005
R1108 VGND.n178 VGND.n177 25.6005
R1109 VGND.n179 VGND.n178 25.6005
R1110 VGND.n173 VGND.n171 25.6005
R1111 VGND.n173 VGND.n172 25.6005
R1112 VGND.n172 VGND.n156 25.6005
R1113 VGND.n135 VGND.n131 25.6005
R1114 VGND.n142 VGND.n127 25.6005
R1115 VGND.n143 VGND.n142 25.6005
R1116 VGND.n144 VGND.n143 25.6005
R1117 VGND.n138 VGND.n136 25.6005
R1118 VGND.n138 VGND.n137 25.6005
R1119 VGND.n137 VGND.n121 25.6005
R1120 VGND.n100 VGND.n89 25.6005
R1121 VGND.n92 VGND.n89 25.6005
R1122 VGND.n93 VGND.n92 25.6005
R1123 VGND.n109 VGND.n101 25.6005
R1124 VGND.n108 VGND.n107 25.6005
R1125 VGND.n107 VGND.n102 25.6005
R1126 VGND.n102 VGND.n83 25.6005
R1127 VGND.n119 VGND 18.3598
R1128 VGND.n332 VGND 18.3598
R1129 VGND VGND.n0 18.3598
R1130 VGND VGND.n256 18.3598
R1131 VGND.n251 VGND 18.3598
R1132 VGND.n216 VGND 18.3598
R1133 VGND.n185 VGND 18.3598
R1134 VGND.n150 VGND 18.3598
R1135 VGND.n114 VGND 18.3598
R1136 VGND VGND.n217 12.8005
R1137 VGND.n218 VGND 12.8005
R1138 VGND VGND.n151 12.8005
R1139 VGND.n152 VGND 12.8005
R1140 VGND VGND.n115 12.8005
R1141 VGND.n116 VGND 12.8005
R1142 VGND VGND.n79 12.8005
R1143 VGND.n80 VGND 12.8005
R1144 VGND.n292 VGND 12.8005
R1145 VGND.n300 VGND 12.8005
R1146 VGND VGND.n1 12.8005
R1147 VGND VGND.n331 12.8005
R1148 VGND.n35 VGND 12.8005
R1149 VGND.n43 VGND 12.8005
R1150 VGND VGND.n73 12.8005
R1151 VGND.n257 VGND 12.8005
R1152 VGND VGND.n221 12.8005
R1153 VGND VGND.n250 12.8005
R1154 VGND VGND.n186 12.8005
R1155 VGND VGND.n215 12.8005
R1156 VGND VGND.n155 12.8005
R1157 VGND VGND.n184 12.8005
R1158 VGND VGND.n120 12.8005
R1159 VGND VGND.n149 12.8005
R1160 VGND VGND.n82 12.8005
R1161 VGND VGND.n113 12.8005
R1162 VGND VGND.n252 12.8005
R1163 VGND.n253 VGND 12.8005
R1164 VGND.n219 VGND.n217 10.1513
R1165 VGND.n219 VGND.n218 10.1513
R1166 VGND.n153 VGND.n151 10.1513
R1167 VGND.n153 VGND.n152 10.1513
R1168 VGND.n117 VGND.n115 10.1513
R1169 VGND.n117 VGND.n116 10.1513
R1170 VGND.n81 VGND.n79 10.1513
R1171 VGND.n81 VGND.n80 10.1513
R1172 VGND.n254 VGND.n252 10.1513
R1173 VGND.n254 VGND.n253 10.1513
R1174 VGND.n114 VGND.n81 10.1294
R1175 VGND.n220 VGND.n219 10.0354
R1176 VGND.n154 VGND.n153 10.0354
R1177 VGND.n118 VGND.n117 10.0354
R1178 VGND.n255 VGND.n254 10.0354
R1179 VGND VGND.n332 5.15812
R1180 VGND.n150 VGND.n119 1.10578
R1181 VGND.n216 VGND.n185 1.10578
R1182 VGND.n256 VGND.n251 1.10578
R1183 VGND.n332 VGND.n0 1.10578
R1184 VGND.n118 VGND.n114 1.01178
R1185 VGND.n154 VGND.n150 1.01178
R1186 VGND.n220 VGND.n216 1.01178
R1187 VGND.n256 VGND.n255 1.01178
R1188 VGND.n119 VGND.n118 0.0945
R1189 VGND.n185 VGND.n154 0.0945
R1190 VGND.n251 VGND.n220 0.0945
R1191 VGND.n255 VGND.n0 0.0945
R1192 B B.t1 330.341
R1193 B B.t2 330.341
R1194 B B.t3 315.88
R1195 B B.t0 315.88
R1196 B.n0 B 31.1853
R1197 B.n1 B 30.6327
R1198 B.n0 B 30.6171
R1199 B.n2 B 30.6171
R1200 B B.n2 7.12233
R1201 B.n1 B.n0 2.76371
R1202 B.n2 B.n1 0.553142
R1203 CORE__N3.t1 CORE__N3.n2 700.484
R1204 CORE__N3.n3 CORE__N3.t1 700.484
R1205 CORE__N3.t0 CORE__N3.n0 700.484
R1206 CORE__N3.n11 CORE__N3.t0 700.484
R1207 CORE__N3 CORE__N3.t4 330.341
R1208 CORE__N3 CORE__N3.t3 315.88
R1209 CORE__N3.t2 CORE__N3.n5 255.345
R1210 CORE__N3.n6 CORE__N3.t2 255.345
R1211 CORE__N3.n1 CORE__N3 33.2687
R1212 CORE__N3.n1 CORE__N3 32.7004
R1213 CORE__N3.n8 CORE__N3.n4 13.9214
R1214 CORE__N3.n8 CORE__N3.n7 13.3688
R1215 CORE__N3.n10 CORE__N3.n9 13.3688
R1216 CORE__N3 CORE__N3.n2 12.8005
R1217 CORE__N3.n3 CORE__N3 12.8005
R1218 CORE__N3 CORE__N3.n5 12.8005
R1219 CORE__N3.n6 CORE__N3 12.8005
R1220 CORE__N3 CORE__N3.n0 12.8005
R1221 CORE__N3 CORE__N3.n11 12.8005
R1222 CORE__N3.n4 CORE__N3.n2 10.1513
R1223 CORE__N3.n4 CORE__N3.n3 10.1513
R1224 CORE__N3.n7 CORE__N3.n5 10.1513
R1225 CORE__N3.n7 CORE__N3.n6 10.1513
R1226 CORE__N3.n10 CORE__N3.n0 10.1513
R1227 CORE__N3.n11 CORE__N3.n10 10.1513
R1228 CORE__N3.n9 CORE__N3.n1 2.44763
R1229 CORE__N3.n9 CORE__N3.n8 0.553142
R1230 CORE__N3__N1.t1 CORE__N3__N1.n1 255.345
R1231 CORE__N3__N1.n2 CORE__N3__N1.t1 255.345
R1232 CORE__N3__N1.t0 CORE__N3__N1.n0 255.345
R1233 CORE__N3__N1.n5 CORE__N3__N1.t0 255.345
R1234 CORE__N3__N1.n4 CORE__N3__N1.n3 24.321
R1235 CORE__N3__N1 CORE__N3__N1.n1 12.8005
R1236 CORE__N3__N1.n2 CORE__N3__N1 12.8005
R1237 CORE__N3__N1 CORE__N3__N1.n0 12.8005
R1238 CORE__N3__N1 CORE__N3__N1.n5 12.8005
R1239 CORE__N3__N1.n3 CORE__N3__N1.n1 10.1513
R1240 CORE__N3__N1.n3 CORE__N3__N1.n2 10.1513
R1241 CORE__N3__N1.n4 CORE__N3__N1.n0 10.1513
R1242 CORE__N3__N1.n5 CORE__N3__N1.n4 10.1513
R1243 CORE__N1.t2 CORE__N1.n8 700.484
R1244 CORE__N1.n9 CORE__N1.t2 700.484
R1245 CORE__N1.t1 CORE__N1.n4 700.484
R1246 CORE__N1.n5 CORE__N1.t1 700.484
R1247 CORE__N1 CORE__N1.t6 330.341
R1248 CORE__N1 CORE__N1.t5 330.341
R1249 CORE__N1 CORE__N1.t4 315.88
R1250 CORE__N1 CORE__N1.t3 315.88
R1251 CORE__N1.t0 CORE__N1.n0 255.345
R1252 CORE__N1.n13 CORE__N1.t0 255.345
R1253 CORE__N1.n1 CORE__N1 32.0187
R1254 CORE__N1.n2 CORE__N1 31.466
R1255 CORE__N1.n3 CORE__N1 31.4504
R1256 CORE__N1.n1 CORE__N1 31.4504
R1257 CORE__N1 CORE__N1.n8 12.8005
R1258 CORE__N1.n9 CORE__N1 12.8005
R1259 CORE__N1 CORE__N1.n4 12.8005
R1260 CORE__N1.n5 CORE__N1 12.8005
R1261 CORE__N1 CORE__N1.n0 12.8005
R1262 CORE__N1 CORE__N1.n13 12.8005
R1263 CORE__N1.n11 CORE__N1.n10 12.6714
R1264 CORE__N1.n7 CORE__N1.n6 12.1188
R1265 CORE__N1.n12 CORE__N1.n11 12.1188
R1266 CORE__N1.n10 CORE__N1.n8 10.1513
R1267 CORE__N1.n10 CORE__N1.n9 10.1513
R1268 CORE__N1.n6 CORE__N1.n4 10.1513
R1269 CORE__N1.n6 CORE__N1.n5 10.1513
R1270 CORE__N1.n12 CORE__N1.n0 10.1513
R1271 CORE__N1.n13 CORE__N1.n12 10.1513
R1272 CORE__N1.n7 CORE__N1.n3 2.44763
R1273 CORE__N1.n2 CORE__N1.n1 1.65843
R1274 CORE__N1.n3 CORE__N1.n2 0.553142
R1275 CORE__N1.n11 CORE__N1.n7 0.553142
R1276 A A.t2 330.341
R1277 A A.t3 330.341
R1278 A A.t1 315.88
R1279 A A.t0 315.88
R1280 A.n0 A 30.352
R1281 A.n1 A 29.7994
R1282 A.n0 A 29.7837
R1283 A.n2 A 29.7837
R1284 A A.n2 6.15804
R1285 A.n1 A.n0 1.65843
R1286 A.n2 A.n1 0.553142
R1287 CORE__N2.t1 CORE__N2.n2 700.484
R1288 CORE__N2.n3 CORE__N2.t1 700.484
R1289 CORE__N2.t0 CORE__N2.n0 700.484
R1290 CORE__N2.n11 CORE__N2.t0 700.484
R1291 CORE__N2 CORE__N2.t4 330.341
R1292 CORE__N2 CORE__N2.t3 315.88
R1293 CORE__N2.t2 CORE__N2.n5 255.345
R1294 CORE__N2.n6 CORE__N2.t2 255.345
R1295 CORE__N2.n1 CORE__N2 32.4353
R1296 CORE__N2.n1 CORE__N2 31.8671
R1297 CORE__N2.n8 CORE__N2.n4 13.0881
R1298 CORE__N2 CORE__N2.n2 12.8005
R1299 CORE__N2.n3 CORE__N2 12.8005
R1300 CORE__N2 CORE__N2.n5 12.8005
R1301 CORE__N2.n6 CORE__N2 12.8005
R1302 CORE__N2 CORE__N2.n0 12.8005
R1303 CORE__N2 CORE__N2.n11 12.8005
R1304 CORE__N2.n8 CORE__N2.n7 12.5354
R1305 CORE__N2.n10 CORE__N2.n9 12.5354
R1306 CORE__N2.n4 CORE__N2.n2 10.1513
R1307 CORE__N2.n4 CORE__N2.n3 10.1513
R1308 CORE__N2.n7 CORE__N2.n5 10.1513
R1309 CORE__N2.n7 CORE__N2.n6 10.1513
R1310 CORE__N2.n10 CORE__N2.n0 10.1513
R1311 CORE__N2.n11 CORE__N2.n10 10.1513
R1312 CORE__N2.n9 CORE__N2.n1 3.55292
R1313 CORE__N2.n9 CORE__N2.n8 0.553142
R1314 CORE__N2__N1.t1 CORE__N2__N1.n1 255.345
R1315 CORE__N2__N1.n2 CORE__N2__N1.t1 255.345
R1316 CORE__N2__N1.t0 CORE__N2__N1.n0 255.345
R1317 CORE__N2__N1.n5 CORE__N2__N1.t0 255.345
R1318 CORE__N2__N1.n4 CORE__N2__N1.n3 22.6543
R1319 CORE__N2__N1 CORE__N2__N1.n1 12.8005
R1320 CORE__N2__N1.n2 CORE__N2__N1 12.8005
R1321 CORE__N2__N1 CORE__N2__N1.n0 12.8005
R1322 CORE__N2__N1 CORE__N2__N1.n5 12.8005
R1323 CORE__N2__N1.n3 CORE__N2__N1.n1 10.1513
R1324 CORE__N2__N1.n3 CORE__N2__N1.n2 10.1513
R1325 CORE__N2__N1.n4 CORE__N2__N1.n0 10.1513
R1326 CORE__N2__N1.n5 CORE__N2__N1.n4 10.1513
R1327 CORE__N4__N1.t1 CORE__N4__N1.n1 255.345
R1328 CORE__N4__N1.n2 CORE__N4__N1.t1 255.345
R1329 CORE__N4__N1.t0 CORE__N4__N1.n0 255.345
R1330 CORE__N4__N1.n5 CORE__N4__N1.t0 255.345
R1331 CORE__N4__N1.n4 CORE__N4__N1.n3 26.821
R1332 CORE__N4__N1 CORE__N4__N1.n1 12.8005
R1333 CORE__N4__N1.n2 CORE__N4__N1 12.8005
R1334 CORE__N4__N1 CORE__N4__N1.n0 12.8005
R1335 CORE__N4__N1 CORE__N4__N1.n5 12.8005
R1336 CORE__N4__N1.n3 CORE__N4__N1.n1 10.1513
R1337 CORE__N4__N1.n3 CORE__N4__N1.n2 10.1513
R1338 CORE__N4__N1.n4 CORE__N4__N1.n0 10.1513
R1339 CORE__N4__N1.n5 CORE__N4__N1.n4 10.1513
R1340 CORE__N1__N1.t1 CORE__N1__N1.n1 255.345
R1341 CORE__N1__N1.n2 CORE__N1__N1.t1 255.345
R1342 CORE__N1__N1.t0 CORE__N1__N1.n0 255.345
R1343 CORE__N1__N1.n5 CORE__N1__N1.t0 255.345
R1344 CORE__N1__N1.n4 CORE__N1__N1.n3 20.9877
R1345 CORE__N1__N1 CORE__N1__N1.n1 12.8005
R1346 CORE__N1__N1.n2 CORE__N1__N1 12.8005
R1347 CORE__N1__N1 CORE__N1__N1.n0 12.8005
R1348 CORE__N1__N1 CORE__N1__N1.n5 12.8005
R1349 CORE__N1__N1.n3 CORE__N1__N1.n1 10.1513
R1350 CORE__N1__N1.n3 CORE__N1__N1.n2 10.1513
R1351 CORE__N1__N1.n4 CORE__N1__N1.n0 10.1513
R1352 CORE__N1__N1.n5 CORE__N1__N1.n4 10.1513
C60 Y VGND 9.99444f
C61 B VGND 6.39834f
C62 A VGND 5.03763f
C63 VPWR VGND 31.1792f
C64 CORE__N4__N1 VGND 3.79278f $ **FLOATING
C65 N VGND 13.20425f $ **FLOATING
C66 CORE__N3__N1 VGND 3.10569f $ **FLOATING
C67 CORE__N3 VGND 7.56587f $ **FLOATING
C68 CORE__N2__N1 VGND 2.55873f $ **FLOATING
C69 CORE__N2 VGND 6.74003f $ **FLOATING
C70 CORE__N1__N1 VGND 2.97727f $ **FLOATING
C71 CORE__N1 VGND 8.416f $ **FLOATING
C72 CORE__N1__N1.n0 VGND 0.00867f $ **FLOATING
C73 CORE__N1__N1.n1 VGND 0.00867f $ **FLOATING
C74 CORE__N1__N1.t1 VGND 0.02109f $ **FLOATING
C75 CORE__N1__N1.n2 VGND 0.00867f $ **FLOATING
C76 CORE__N1__N1.n3 VGND 1.74743f $ **FLOATING
C77 CORE__N1__N1.n4 VGND 1.66758f $ **FLOATING
C78 CORE__N1__N1.t0 VGND 0.02109f $ **FLOATING
C79 CORE__N1__N1.n5 VGND 0.00867f $ **FLOATING
C80 CORE__N4__N1.n0 VGND 0.01439f $ **FLOATING
C81 CORE__N4__N1.n1 VGND 0.01439f $ **FLOATING
C82 CORE__N4__N1.t1 VGND 0.035f $ **FLOATING
C83 CORE__N4__N1.n2 VGND 0.01439f $ **FLOATING
C84 CORE__N4__N1.n3 VGND 9.42424f $ **FLOATING
C85 CORE__N4__N1.n4 VGND 8.93471f $ **FLOATING
C86 CORE__N4__N1.t0 VGND 0.035f $ **FLOATING
C87 CORE__N4__N1.n5 VGND 0.01439f $ **FLOATING
C88 CORE__N2__N1.n0 VGND 0.01376f $ **FLOATING
C89 CORE__N2__N1.n1 VGND 0.01376f $ **FLOATING
C90 CORE__N2__N1.t1 VGND 0.03347f $ **FLOATING
C91 CORE__N2__N1.n2 VGND 0.01376f $ **FLOATING
C92 CORE__N2__N1.n3 VGND 4.81333f $ **FLOATING
C93 CORE__N2__N1.n4 VGND 4.55178f $ **FLOATING
C94 CORE__N2__N1.t0 VGND 0.03347f $ **FLOATING
C95 CORE__N2__N1.n5 VGND 0.01376f $ **FLOATING
C96 CORE__N2.n0 VGND 0.01024f $ **FLOATING
C97 CORE__N2.t3 VGND 0.04229f $ **FLOATING
C98 CORE__N2.t4 VGND 0.04395f $ **FLOATING
C99 CORE__N2.n1 VGND 4.74728f $ **FLOATING
C100 CORE__N2.n2 VGND 0.01024f $ **FLOATING
C101 CORE__N2.t1 VGND 0.03135f $ **FLOATING
C102 CORE__N2.n3 VGND 0.01024f $ **FLOATING
C103 CORE__N2.n4 VGND 0.63563f $ **FLOATING
C104 CORE__N2.n5 VGND 0.01169f $ **FLOATING
C105 CORE__N2.t2 VGND 0.02843f $ **FLOATING
C106 CORE__N2.n6 VGND 0.01169f $ **FLOATING
C107 CORE__N2.n7 VGND 0.4079f $ **FLOATING
C108 CORE__N2.n8 VGND 6.42088f $ **FLOATING
C109 CORE__N2.n9 VGND 3.43115f $ **FLOATING
C110 CORE__N2.n10 VGND 0.4079f $ **FLOATING
C111 CORE__N2.t0 VGND 0.03135f $ **FLOATING
C112 CORE__N2.n11 VGND 0.01024f $ **FLOATING
C113 A.t0 VGND 0.04174f $ **FLOATING
C114 A.t3 VGND 0.04338f $ **FLOATING
C115 A.n0 VGND 2.68321f $ **FLOATING
C116 A.t1 VGND 0.04174f $ **FLOATING
C117 A.n1 VGND 1.92647f $ **FLOATING
C118 A.t2 VGND 0.04338f $ **FLOATING
C119 A.n2 VGND 2.40039f $ **FLOATING
C120 CORE__N1.n0 VGND 0.01069f $ **FLOATING
C121 CORE__N1.t3 VGND 0.03866f $ **FLOATING
C122 CORE__N1.t5 VGND 0.04017f $ **FLOATING
C123 CORE__N1.n1 VGND 2.96625f $ **FLOATING
C124 CORE__N1.t4 VGND 0.03866f $ **FLOATING
C125 CORE__N1.n2 VGND 2.02647f $ **FLOATING
C126 CORE__N1.t6 VGND 0.04017f $ **FLOATING
C127 CORE__N1.n3 VGND 2.54742f $ **FLOATING
C128 CORE__N1.n4 VGND 0.00936f $ **FLOATING
C129 CORE__N1.t1 VGND 0.02866f $ **FLOATING
C130 CORE__N1.n5 VGND 0.00936f $ **FLOATING
C131 CORE__N1.n6 VGND 0.33916f $ **FLOATING
C132 CORE__N1.n7 VGND 2.36266f $ **FLOATING
C133 CORE__N1.n8 VGND 0.00936f $ **FLOATING
C134 CORE__N1.t2 VGND 0.02866f $ **FLOATING
C135 CORE__N1.n9 VGND 0.00936f $ **FLOATING
C136 CORE__N1.n10 VGND 0.43179f $ **FLOATING
C137 CORE__N1.n11 VGND 3.1381f $ **FLOATING
C138 CORE__N1.n12 VGND 0.33916f $ **FLOATING
C139 CORE__N1.t0 VGND 0.02599f $ **FLOATING
C140 CORE__N1.n13 VGND 0.01069f $ **FLOATING
C141 CORE__N3__N1.n0 VGND 0.01454f $ **FLOATING
C142 CORE__N3__N1.n1 VGND 0.01454f $ **FLOATING
C143 CORE__N3__N1.t1 VGND 0.03535f $ **FLOATING
C144 CORE__N3__N1.n2 VGND 0.01454f $ **FLOATING
C145 CORE__N3__N1.n3 VGND 7.22833f $ **FLOATING
C146 CORE__N3__N1.n4 VGND 6.82921f $ **FLOATING
C147 CORE__N3__N1.t0 VGND 0.03535f $ **FLOATING
C148 CORE__N3__N1.n5 VGND 0.01454f $ **FLOATING
C149 CORE__N3.n0 VGND 0.00984f $ **FLOATING
C150 CORE__N3.t3 VGND 0.04064f $ **FLOATING
C151 CORE__N3.t4 VGND 0.04223f $ **FLOATING
C152 CORE__N3.n1 VGND 4.03509f $ **FLOATING
C153 CORE__N3.n2 VGND 0.00984f $ **FLOATING
C154 CORE__N3.t1 VGND 0.03012f $ **FLOATING
C155 CORE__N3.n3 VGND 0.00984f $ **FLOATING
C156 CORE__N3.n4 VGND 0.7881f $ **FLOATING
C157 CORE__N3.n5 VGND 0.01124f $ **FLOATING
C158 CORE__N3.t2 VGND 0.02732f $ **FLOATING
C159 CORE__N3.n6 VGND 0.01124f $ **FLOATING
C160 CORE__N3.n7 VGND 0.46358f $ **FLOATING
C161 CORE__N3.n8 VGND 9.14215f $ **FLOATING
C162 CORE__N3.n9 VGND 2.61255f $ **FLOATING
C163 CORE__N3.n10 VGND 0.46358f $ **FLOATING
C164 CORE__N3.t0 VGND 0.03012f $ **FLOATING
C165 CORE__N3.n11 VGND 0.00984f $ **FLOATING
C166 B.t0 VGND 0.04096f $ **FLOATING
C167 B.t2 VGND 0.04257f $ **FLOATING
C168 B.n0 VGND 3.66708f $ **FLOATING
C169 B.t3 VGND 0.04096f $ **FLOATING
C170 B.n1 VGND 2.7966f $ **FLOATING
C171 B.t1 VGND 0.04257f $ **FLOATING
C172 B.n2 VGND 3.61573f $ **FLOATING
C173 Y.n0 VGND 0.01349f $ **FLOATING
C174 Y.t0 VGND 0.0328f $ **FLOATING
C175 Y.n1 VGND 0.01349f $ **FLOATING
C176 Y.n2 VGND 0.6453f $ **FLOATING
C177 Y.n3 VGND 0.01181f $ **FLOATING
C178 Y.t1 VGND 0.03616f $ **FLOATING
C179 Y.n4 VGND 0.01181f $ **FLOATING
C180 Y.n5 VGND 0.59985f $ **FLOATING
C181 Y.n6 VGND 12.2927f $ **FLOATING
C182 N.n0 VGND 0.0051f $ **FLOATING
C183 N.t4 VGND 0.02106f $ **FLOATING
C184 N.t3 VGND 0.02188f $ **FLOATING
C185 N.n1 VGND 1.81557f $ **FLOATING
C186 N.n2 VGND 0.0051f $ **FLOATING
C187 N.t2 VGND 0.01561f $ **FLOATING
C188 N.n3 VGND 0.0051f $ **FLOATING
C189 N.n4 VGND 0.49274f $ **FLOATING
C190 N.n5 VGND 0.00582f $ **FLOATING
C191 N.t1 VGND 0.01416f $ **FLOATING
C192 N.n6 VGND 0.00582f $ **FLOATING
C193 N.n7 VGND 0.27773f $ **FLOATING
C194 N.n8 VGND 6.23863f $ **FLOATING
C195 N.n9 VGND 0.9985f $ **FLOATING
C196 N.n10 VGND 0.27773f $ **FLOATING
C197 N.t0 VGND 0.01561f $ **FLOATING
C198 N.n11 VGND 0.0051f $ **FLOATING
.ends

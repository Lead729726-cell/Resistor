.subckt rc_lowpass IN OUT VGND
CC1 register_cf_node_14b59466c5db7da9 VGND 1e-12
Vregister_cf_14b59466c5db7da9 OUT register_cf_node_14b59466c5db7da9 0
RR1 register_cf_node_7c48c48dcebfc52e OUT 10000
Vregister_cf_7c48c48dcebfc52e IN register_cf_node_7c48c48dcebfc52e 0
.ends rc_lowpass

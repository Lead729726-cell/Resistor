.subckt rc_lowpass IN OUT VGND
CC1 OUT VGND 1e-12
RR1 IN OUT 10000
.ends rc_lowpass

* NGSPICE file created from cell_xor2.ext - technology: sky130A

.subckt cell_xor2 Y VPWR VGND B A
X0 register_cf_node_683eb4d351eb8286 A.t0 register_cf_node_683eb4d351eb8286_source VGND.t1 sky130_fd_pr__nfet_01v8 ad=0.1885 pd=1.88 as=0.1885 ps=1.88 w=0.65 l=0.15
Vregister_cf_683eb4d351eb8286 N1__N1.t0 register_cf_node_683eb4d351eb8286 0
Vregister_cf_683eb4d351eb8286_source N1.t1 register_cf_node_683eb4d351eb8286_source 0
X1 register_cf_node_01dead019619b2b8 A.t1 register_cf_node_01dead019619b2b8_source VGND.t0 sky130_fd_pr__nfet_01v8 ad=0.1885 pd=1.88 as=0.1885 ps=1.88 w=0.65 l=0.15
Vregister_cf_01dead019619b2b8 N2__N1.t0 register_cf_node_01dead019619b2b8 0
Vregister_cf_01dead019619b2b8_source N2.t1 register_cf_node_01dead019619b2b8_source 0
X2 register_cf_node_4ea80be5325e2b83 N3.t3 register_cf_node_4ea80be5325e2b83_source VGND.t2 sky130_fd_pr__nfet_01v8 ad=0.1885 pd=1.88 as=0.1885 ps=1.88 w=0.65 l=0.15
Vregister_cf_4ea80be5325e2b83 VGND.t3 register_cf_node_4ea80be5325e2b83 0
Vregister_cf_4ea80be5325e2b83_source N4__N1.t1 register_cf_node_4ea80be5325e2b83_source 0
X3 register_cf_node_5a8cab2fb1531f55 N1.t3 register_cf_node_5a8cab2fb1531f55_source VGND.t8 sky130_fd_pr__nfet_01v8 ad=0.1885 pd=1.88 as=0.1885 ps=1.88 w=0.65 l=0.15
Vregister_cf_5a8cab2fb1531f55 VGND.t9 register_cf_node_5a8cab2fb1531f55 0
Vregister_cf_5a8cab2fb1531f55_source N2__N1.t1 register_cf_node_5a8cab2fb1531f55_source 0
X4 register_cf_node_7d87aa2c74760312 B.t0 register_cf_node_7d87aa2c74760312_source VGND.t5 sky130_fd_pr__nfet_01v8 ad=0.1885 pd=1.88 as=0.1885 ps=1.88 w=0.65 l=0.15
Vregister_cf_7d87aa2c74760312 N3__N1.t0 register_cf_node_7d87aa2c74760312 0
Vregister_cf_7d87aa2c74760312_source N3.t0 register_cf_node_7d87aa2c74760312_source 0
X5 register_cf_node_8b48dd30c91e4b3f N2.t3 register_cf_node_8b48dd30c91e4b3f_source VPWR.t8 sky130_fd_pr__pfet_01v8_hvt ad=0.1885 pd=1.88 as=0.1885 ps=1.88 w=0.65 l=0.15
Vregister_cf_8b48dd30c91e4b3f VPWR.t9 register_cf_node_8b48dd30c91e4b3f 0
Vregister_cf_8b48dd30c91e4b3f_source Y.t1 register_cf_node_8b48dd30c91e4b3f_source 0
X6 register_cf_node_a5c0e43ae4e6aebc N1.t4 register_cf_node_a5c0e43ae4e6aebc_source VPWR.t14 sky130_fd_pr__pfet_01v8_hvt ad=0.1885 pd=1.88 as=0.1885 ps=1.88 w=0.65 l=0.15
Vregister_cf_a5c0e43ae4e6aebc VPWR.t15 register_cf_node_a5c0e43ae4e6aebc 0
Vregister_cf_a5c0e43ae4e6aebc_source N2.t2 register_cf_node_a5c0e43ae4e6aebc_source 0
X7 register_cf_node_5b6050caedbba198 N1.t5 register_cf_node_5b6050caedbba198_source VPWR.t12 sky130_fd_pr__pfet_01v8_hvt ad=0.1885 pd=1.88 as=0.1885 ps=1.88 w=0.65 l=0.15
Vregister_cf_5b6050caedbba198 VPWR.t13 register_cf_node_5b6050caedbba198 0
Vregister_cf_5b6050caedbba198_source N3.t2 register_cf_node_5b6050caedbba198_source 0
X8 register_cf_node_10694f1af9a19748 B.t1 register_cf_node_10694f1af9a19748_source VPWR.t2 sky130_fd_pr__pfet_01v8_hvt ad=0.1885 pd=1.88 as=0.1885 ps=1.88 w=0.65 l=0.15
Vregister_cf_10694f1af9a19748 VPWR.t3 register_cf_node_10694f1af9a19748 0
Vregister_cf_10694f1af9a19748_source N3.t1 register_cf_node_10694f1af9a19748_source 0
X9 register_cf_node_c1972b280ed7cad0 A.t2 register_cf_node_c1972b280ed7cad0_source VPWR.t6 sky130_fd_pr__pfet_01v8_hvt ad=0.1885 pd=1.88 as=0.1885 ps=1.88 w=0.65 l=0.15
Vregister_cf_c1972b280ed7cad0 VPWR.t7 register_cf_node_c1972b280ed7cad0 0
Vregister_cf_c1972b280ed7cad0_source N1.t0 register_cf_node_c1972b280ed7cad0_source 0
X10 register_cf_node_5cebfddc1237d460 A.t3 register_cf_node_5cebfddc1237d460_source VPWR.t4 sky130_fd_pr__pfet_01v8_hvt ad=0.1885 pd=1.88 as=0.1885 ps=1.88 w=0.65 l=0.15
Vregister_cf_5cebfddc1237d460 VPWR.t5 register_cf_node_5cebfddc1237d460 0
Vregister_cf_5cebfddc1237d460_source N2.t0 register_cf_node_5cebfddc1237d460_source 0
X11 register_cf_node_a53c911ea079998e B.t2 register_cf_node_a53c911ea079998e_source VPWR.t0 sky130_fd_pr__pfet_01v8_hvt ad=0.1885 pd=1.88 as=0.1885 ps=1.88 w=0.65 l=0.15
Vregister_cf_a53c911ea079998e VPWR.t1 register_cf_node_a53c911ea079998e 0
Vregister_cf_a53c911ea079998e_source N1.t2 register_cf_node_a53c911ea079998e_source 0
X12 register_cf_node_099b6d51416137cb N3.t4 register_cf_node_099b6d51416137cb_source VPWR.t10 sky130_fd_pr__pfet_01v8_hvt ad=0.1885 pd=1.88 as=0.1885 ps=1.88 w=0.65 l=0.15
Vregister_cf_099b6d51416137cb VPWR.t11 register_cf_node_099b6d51416137cb 0
Vregister_cf_099b6d51416137cb_source Y.t2 register_cf_node_099b6d51416137cb_source 0
X13 register_cf_node_d002c0cfdff274bb B.t3 register_cf_node_d002c0cfdff274bb_source VGND.t10 sky130_fd_pr__nfet_01v8 ad=0.1885 pd=1.88 as=0.1885 ps=1.88 w=0.65 l=0.15
Vregister_cf_d002c0cfdff274bb VGND.t11 register_cf_node_d002c0cfdff274bb 0
Vregister_cf_d002c0cfdff274bb_source N1__N1.t1 register_cf_node_d002c0cfdff274bb_source 0
X14 register_cf_node_add0247286d98b0f N2.t4 register_cf_node_add0247286d98b0f_source VGND.t4 sky130_fd_pr__nfet_01v8 ad=0.1885 pd=1.88 as=0.1885 ps=1.88 w=0.65 l=0.15
Vregister_cf_add0247286d98b0f N4__N1.t0 register_cf_node_add0247286d98b0f 0
Vregister_cf_add0247286d98b0f_source Y.t0 register_cf_node_add0247286d98b0f_source 0
X15 register_cf_node_1458ae15465185b8 N1.t6 register_cf_node_1458ae15465185b8_source VGND.t6 sky130_fd_pr__nfet_01v8 ad=0.1885 pd=1.88 as=0.1885 ps=1.88 w=0.65 l=0.15
Vregister_cf_1458ae15465185b8 VGND.t7 register_cf_node_1458ae15465185b8 0
Vregister_cf_1458ae15465185b8_source N3__N1.t1 register_cf_node_1458ae15465185b8_source 0
C0 N2 N3 0.34136f
C1 N2 N1 7.51809f
C2 VPWR A 0.85687f
C3 N2__N1 A 4.5164f
C4 Y A 0
C5 B VPWR 0.84794f
C6 N3__N1 VPWR 0.01463f
C7 N2 N4__N1 1.34746f
C8 N2__N1 B 4.82149f
C9 N3__N1 N2__N1 0.00269f
C10 N1 N3 0.60736f
C11 B Y 0
C12 N3__N1 Y 0.00424f
C13 N1__N1 VPWR 0.05039f
C14 N2__N1 N1__N1 0.00298f
C15 N4__N1 N3 9.41903f
C16 N1 N4__N1 0.00261f
C17 N1__N1 Y 0
C18 N2 VPWR 0.94651f
C19 N2 N2__N1 0.58352f
C20 N2 Y 8.29126f
C21 VPWR N3 0.94487f
C22 N1 VPWR 1.36734f
C23 B A 0.3658f
C24 N3__N1 A 0.00178f
C25 N2__N1 N3 0.00312f
C26 N2__N1 N1 0.60805f
C27 N1 Y 0.13305f
C28 Y N3 0.52799f
C29 N1__N1 A 3.39377f
C30 VPWR N4__N1 0.01193f
C31 N3__N1 B 6.66809f
C32 N2__N1 N4__N1 0
C33 Y N4__N1 8.35963f
C34 B N1__N1 0.25806f
C35 N3__N1 N1__N1 0
C36 N2 A 0.4858f
C37 N2 B 0.37916f
C38 N3__N1 N2 0.2848f
C39 N2__N1 VPWR 0.02371f
C40 N1 A 0.58173f
C41 VPWR Y 0.52563f
C42 N2 N1__N1 0.00336f
C43 N2__N1 Y 0
C44 N1 B 0.83778f
C45 B N3 0.58648f
C46 N3__N1 N3 0.63364f
C47 N3__N1 N1 7.43744f
C48 N4__N1 A 0
C49 N1 N1__N1 0.53709f
C50 B N4__N1 0
C51 N3__N1 N4__N1 0
C52 Y VGND 7.9926f
C53 B VGND 6.34708f
C54 A VGND 4.97613f
C55 VPWR VGND 27.6943f
C56 N4__N1 VGND 3.82313f $ **FLOATING
C57 N3__N1 VGND 3.08764f $ **FLOATING
C58 N3 VGND 12.40478f $ **FLOATING
C59 N2__N1 VGND 2.54044f $ **FLOATING
C60 N2 VGND 6.73972f $ **FLOATING
C61 N1__N1 VGND 2.91594f $ **FLOATING
C62 N1 VGND 8.39277f $ **FLOATING
C63 Y.n0 VGND 0.01139f $ **FLOATING
C64 Y.t2 VGND 0.0349f $ **FLOATING
C65 Y.n1 VGND 0.01139f $ **FLOATING
C66 Y.n2 VGND 0.53801f $ **FLOATING
C67 Y.n3 VGND 0.01302f $ **FLOATING
C68 Y.t0 VGND 0.03165f $ **FLOATING
C69 Y.n4 VGND 0.01302f $ **FLOATING
C70 Y.n5 VGND 0.49547f $ **FLOATING
C71 Y.n6 VGND 2.44463f $ **FLOATING
C72 Y.n7 VGND 0.01139f $ **FLOATING
C73 Y.t1 VGND 0.0349f $ **FLOATING
C74 Y.n8 VGND 0.01139f $ **FLOATING
C75 Y.n9 VGND 0.49547f $ **FLOATING
C76 Y.n10 VGND 8.70634f $ **FLOATING
C77 N3__N1.n0 VGND 0.01455f $ **FLOATING
C78 N3__N1.n1 VGND 0.01455f $ **FLOATING
C79 N3__N1.t1 VGND 0.03538f $ **FLOATING
C80 N3__N1.n2 VGND 0.01455f $ **FLOATING
C81 N3__N1.n3 VGND 6.7811f $ **FLOATING
C82 N3__N1.n4 VGND 7.17632f $ **FLOATING
C83 N3__N1.t0 VGND 0.03538f $ **FLOATING
C84 N3__N1.n5 VGND 0.01455f $ **FLOATING
C85 B.t0 VGND 0.04092f $ **FLOATING
C86 B.t1 VGND 0.04252f $ **FLOATING
C87 B.n0 VGND 3.66327f $ **FLOATING
C88 B.t3 VGND 0.04092f $ **FLOATING
C89 B.n1 VGND 2.7937f $ **FLOATING
C90 B.t2 VGND 0.04252f $ **FLOATING
C91 B.n2 VGND 3.5557f $ **FLOATING
C92 N4__N1.n0 VGND 0.01378f $ **FLOATING
C93 N4__N1.n1 VGND 0.01378f $ **FLOATING
C94 N4__N1.t1 VGND 0.03352f $ **FLOATING
C95 N4__N1.n2 VGND 0.01378f $ **FLOATING
C96 N4__N1.n3 VGND 8.60694f $ **FLOATING
C97 N4__N1.n4 VGND 9.058f $ **FLOATING
C98 N4__N1.t0 VGND 0.03352f $ **FLOATING
C99 N4__N1.n5 VGND 0.01378f $ **FLOATING
C100 N3.n0 VGND 0.00571f $ **FLOATING
C101 N3.t3 VGND 0.02064f $ **FLOATING
C102 N3.t4 VGND 0.02145f $ **FLOATING
C103 N3.n1 VGND 2.11063f $ **FLOATING
C104 N3.n2 VGND 0.005f $ **FLOATING
C105 N3.t2 VGND 0.0153f $ **FLOATING
C106 N3.n3 VGND 0.005f $ **FLOATING
C107 N3.n4 VGND 0.25382f $ **FLOATING
C108 N3.n5 VGND 1.34863f $ **FLOATING
C109 N3.n6 VGND 0.005f $ **FLOATING
C110 N3.t1 VGND 0.0153f $ **FLOATING
C111 N3.n7 VGND 0.005f $ **FLOATING
C112 N3.n8 VGND 0.41299f $ **FLOATING
C113 N3.n9 VGND 4.64823f $ **FLOATING
C114 N3.n10 VGND 0.25382f $ **FLOATING
C115 N3.t0 VGND 0.01388f $ **FLOATING
C116 N3.n11 VGND 0.00571f $ **FLOATING
C117 N2__N1.n0 VGND 0.01363f $ **FLOATING
C118 N2__N1.n1 VGND 0.01363f $ **FLOATING
C119 N2__N1.t1 VGND 0.03314f $ **FLOATING
C120 N2__N1.n2 VGND 0.01363f $ **FLOATING
C121 N2__N1.n3 VGND 4.45589f $ **FLOATING
C122 N2__N1.n4 VGND 4.71056f $ **FLOATING
C123 N2__N1.t0 VGND 0.03314f $ **FLOATING
C124 N2__N1.n5 VGND 0.01363f $ **FLOATING
C125 N2.n0 VGND 0.00974f $ **FLOATING
C126 N2.t4 VGND 0.04023f $ **FLOATING
C127 N2.t3 VGND 0.04181f $ **FLOATING
C128 N2.n1 VGND 4.51602f $ **FLOATING
C129 N2.n2 VGND 0.00974f $ **FLOATING
C130 N2.t2 VGND 0.02982f $ **FLOATING
C131 N2.n3 VGND 0.00974f $ **FLOATING
C132 N2.n4 VGND 0.38803f $ **FLOATING
C133 N2.n5 VGND 3.264f $ **FLOATING
C134 N2.n6 VGND 0.01112f $ **FLOATING
C135 N2.t1 VGND 0.02705f $ **FLOATING
C136 N2.n7 VGND 0.01112f $ **FLOATING
C137 N2.n8 VGND 0.38803f $ **FLOATING
C138 N2.n9 VGND 6.02527f $ **FLOATING
C139 N2.n10 VGND 0.60101f $ **FLOATING
C140 N2.t0 VGND 0.02982f $ **FLOATING
C141 N2.n11 VGND 0.00974f $ **FLOATING
C142 N1__N1.n0 VGND 0.00859f $ **FLOATING
C143 N1__N1.n1 VGND 0.00859f $ **FLOATING
C144 N1__N1.t1 VGND 0.02089f $ **FLOATING
C145 N1__N1.n2 VGND 0.00859f $ **FLOATING
C146 N1__N1.n3 VGND 1.61982f $ **FLOATING
C147 N1__N1.n4 VGND 1.69599f $ **FLOATING
C148 N1__N1.t0 VGND 0.02089f $ **FLOATING
C149 N1__N1.n5 VGND 0.00859f $ **FLOATING
C150 N1.n0 VGND 0.00928f $ **FLOATING
C151 N1.t6 VGND 0.03836f $ **FLOATING
C152 N1.t5 VGND 0.03986f $ **FLOATING
C153 N1.n1 VGND 2.94316f $ **FLOATING
C154 N1.t3 VGND 0.03836f $ **FLOATING
C155 N1.n2 VGND 2.01069f $ **FLOATING
C156 N1.t4 VGND 0.03986f $ **FLOATING
C157 N1.n3 VGND 2.52758f $ **FLOATING
C158 N1.n4 VGND 0.00928f $ **FLOATING
C159 N1.t2 VGND 0.02843f $ **FLOATING
C160 N1.n5 VGND 0.00928f $ **FLOATING
C161 N1.n6 VGND 0.33651f $ **FLOATING
C162 N1.n7 VGND 2.34427f $ **FLOATING
C163 N1.n8 VGND 0.01061f $ **FLOATING
C164 N1.t1 VGND 0.02579f $ **FLOATING
C165 N1.n9 VGND 0.01061f $ **FLOATING
C166 N1.n10 VGND 0.33651f $ **FLOATING
C167 N1.n11 VGND 3.03483f $ **FLOATING
C168 N1.n12 VGND 0.42483f $ **FLOATING
C169 N1.t0 VGND 0.02843f $ **FLOATING
C170 N1.n13 VGND 0.00928f $ **FLOATING
C171 A.t1 VGND 0.04117f $ **FLOATING
C172 A.t3 VGND 0.04278f $ **FLOATING
C173 A.n0 VGND 2.64627f $ **FLOATING
C174 A.t0 VGND 0.04117f $ **FLOATING
C175 A.n1 VGND 1.89994f $ **FLOATING
C176 A.t2 VGND 0.04278f $ **FLOATING
C177 A.n2 VGND 2.30953f $ **FLOATING
rmesh_equiv_0 a a.n0 15.03258234958602
rmesh_equiv_1 a a.n1 29.799399999999999
rmesh_equiv_10 b b.n1 30.632700000000003
rmesh_equiv_100 n2__n1.n4 n2__n1.n5 10.151300000000001
rmesh_equiv_101 n2__n1.n5 n2__n1.t0 255.34500000000003
rmesh_equiv_102 n3 n3.n0 12.8005
rmesh_equiv_103 n3 n3.n1 16.699391767810738
rmesh_equiv_104 n3 n3.n11 12.8005
rmesh_equiv_105 n3 n3.n2 12.8005
rmesh_equiv_106 n3 n3.n3 12.8005
rmesh_equiv_107 n3 n3.n6 12.8005
rmesh_equiv_108 n3 n3.n7 12.8005
rmesh_equiv_109 n3 n3.t3 315.88
rmesh_equiv_11 b b.n2 5.6850267083758554
rmesh_equiv_110 n3 n3.t4 330.34100000000001
rmesh_equiv_111 n3.n0 n3.n10 10.151300000000001
rmesh_equiv_112 n3.n0 n3.t0 255.34500000000003
rmesh_equiv_113 n3.n1 n3.n5 2.4476300000000002
rmesh_equiv_114 n3.n10 n3.n11 10.151300000000001
rmesh_equiv_115 n3.n10 n3.n9 13.785399999999999
rmesh_equiv_116 n3.n11 n3.t0 255.34500000000003
rmesh_equiv_117 n3.n2 n3.n4 10.151300000000001
rmesh_equiv_118 n3.n2 n3.t2 700.48400000000004
rmesh_equiv_119 n3.n3 n3.n4 10.151300000000001
rmesh_equiv_12 b b.t0 315.88
rmesh_equiv_120 n3.n3 n3.t2 700.48400000000004
rmesh_equiv_121 n3.n4 n3.n5 13.785399999999999
rmesh_equiv_122 n3.n5 n3.n9 0.55314200000000002
rmesh_equiv_123 n3.n6 n3.n8 10.151300000000001
rmesh_equiv_124 n3.n6 n3.t1 700.48400000000004
rmesh_equiv_125 n3.n7 n3.n8 10.151300000000001
rmesh_equiv_126 n3.n7 n3.t1 700.48400000000004
rmesh_equiv_127 n3.n8 n3.n9 14.338100000000001
rmesh_equiv_128 n3__n1 n3__n1.n0 12.8005
rmesh_equiv_129 n3__n1 n3__n1.n1 12.8005
rmesh_equiv_13 b b.t1 330.34100000000001
rmesh_equiv_130 n3__n1 n3__n1.n2 12.8005
rmesh_equiv_131 n3__n1 n3__n1.n5 12.8005
rmesh_equiv_132 n3__n1.n0 n3__n1.n4 10.151300000000001
rmesh_equiv_133 n3__n1.n0 n3__n1.t0 255.34500000000003
rmesh_equiv_134 n3__n1.n1 n3__n1.n3 10.151300000000001
rmesh_equiv_135 n3__n1.n1 n3__n1.t1 255.34500000000003
rmesh_equiv_136 n3__n1.n2 n3__n1.n3 10.151300000000001
rmesh_equiv_137 n3__n1.n2 n3__n1.t1 255.34500000000003
rmesh_equiv_138 n3__n1.n3 n3__n1.n4 24.321000000000002
rmesh_equiv_139 n3__n1.n4 n3__n1.n5 10.151300000000001
rmesh_equiv_14 b b.t2 330.34100000000001
rmesh_equiv_140 n3__n1.n5 n3__n1.t0 255.34500000000003
rmesh_equiv_141 n4__n1 n4__n1.n0 12.8005
rmesh_equiv_142 n4__n1 n4__n1.n1 12.8005
rmesh_equiv_143 n4__n1 n4__n1.n2 12.8005
rmesh_equiv_144 n4__n1 n4__n1.n5 12.8005
rmesh_equiv_145 n4__n1.n0 n4__n1.n4 10.151300000000001
rmesh_equiv_146 n4__n1.n0 n4__n1.t0 255.34500000000003
rmesh_equiv_147 n4__n1.n1 n4__n1.n3 10.151300000000001
rmesh_equiv_148 n4__n1.n1 n4__n1.t1 255.34500000000003
rmesh_equiv_149 n4__n1.n2 n4__n1.n3 10.151300000000001
rmesh_equiv_15 b b.t3 315.88
rmesh_equiv_150 n4__n1.n2 n4__n1.t1 255.34500000000003
rmesh_equiv_151 n4__n1.n3 n4__n1.n4 27.654300000000003
rmesh_equiv_152 n4__n1.n4 n4__n1.n5 10.151300000000001
rmesh_equiv_153 n4__n1.n5 n4__n1.t0 255.34500000000003
rmesh_equiv_154 vgnd vgnd.n238 769.66301137813343
rmesh_equiv_155 vgnd vgnd.n269 1314.2515627304822
rmesh_equiv_156 vgnd vgnd.t0 242.60312076847495
rmesh_equiv_157 vgnd vgnd.t1 205.78606282415677
rmesh_equiv_158 vgnd vgnd.t10 208.29762869899392
rmesh_equiv_159 vgnd vgnd.t11 132.56347877170109
rmesh_equiv_16 b.n0 b.n1 2.7637100000000001
rmesh_equiv_160 vgnd vgnd.t2 239.83564373830484
rmesh_equiv_161 vgnd vgnd.t3 132.74687061266857
rmesh_equiv_162 vgnd vgnd.t4 205.04690757166594
rmesh_equiv_163 vgnd vgnd.t5 208.22298003681121
rmesh_equiv_164 vgnd vgnd.t6 206.17764099205058
rmesh_equiv_165 vgnd vgnd.t7 132.70613283749017
rmesh_equiv_166 vgnd vgnd.t8 216.6513320636526
rmesh_equiv_167 vgnd vgnd.t9 132.65140208246996
rmesh_equiv_168 vgnd.n238 vgnd.n269 144675.98378032033
rmesh_equiv_169 vgnd.n238 vgnd.t0 576.64701162796655
rmesh_equiv_17 b.n1 b.n2 0.55314200000000002
rmesh_equiv_170 vgnd.n238 vgnd.t1 107560.09003146591
rmesh_equiv_171 vgnd.n238 vgnd.t10 8307.730487907289
rmesh_equiv_172 vgnd.n238 vgnd.t2 398940581.22390479
rmesh_equiv_173 vgnd.n238 vgnd.t4 24236291.555569783
rmesh_equiv_174 vgnd.n238 vgnd.t5 122710.46547245566
rmesh_equiv_175 vgnd.n238 vgnd.t6 1769054.7288071152
rmesh_equiv_176 vgnd.n238 vgnd.t8 8433.7749134785336
rmesh_equiv_177 vgnd.n269 vgnd.t0 8080.1391862197333
rmesh_equiv_178 vgnd.n269 vgnd.t1 61723.440645288363
rmesh_equiv_179 vgnd.n269 vgnd.t10 25529.494820447017
rmesh_equiv_18 n1 n1.n0 12.8005
rmesh_equiv_180 vgnd.n269 vgnd.t2 403684.62453010364
rmesh_equiv_181 vgnd.n269 vgnd.t4 73159.009150171056
rmesh_equiv_182 vgnd.n269 vgnd.t5 7854.5567321743192
rmesh_equiv_183 vgnd.n269 vgnd.t6 25579.321319619972
rmesh_equiv_184 vgnd.n269 vgnd.t8 2398.3044589291285
rmesh_equiv_185 vgnd.t0 vgnd.t1 78349.422781188259
rmesh_equiv_186 vgnd.t0 vgnd.t10 32406.184136302607
rmesh_equiv_187 vgnd.t1 vgnd.t10 8895.2190325082156
rmesh_equiv_188 vgnd.t11 vgnd.t3 344050.60929888918
rmesh_equiv_189 vgnd.t11 vgnd.t7 268433.30229806103
rmesh_equiv_19 n1 n1.n1 15.866002865646433
rmesh_equiv_190 vgnd.t11 vgnd.t9 170719.7058812358
rmesh_equiv_191 vgnd.t2 vgnd.t4 14130.069846522096
rmesh_equiv_192 vgnd.t2 vgnd.t5 448196.00458546024
rmesh_equiv_193 vgnd.t2 vgnd.t6 95771.273179854572
rmesh_equiv_194 vgnd.t2 vgnd.t8 52380870.209296435
rmesh_equiv_195 vgnd.t3 vgnd.t7 111523.37570328217
rmesh_equiv_196 vgnd.t3 vgnd.t9 198138.93735500451
rmesh_equiv_197 vgnd.t4 vgnd.t5 65055.611446360017
rmesh_equiv_198 vgnd.t4 vgnd.t6 9779.8075882375197
rmesh_equiv_199 vgnd.t4 vgnd.t8 3182223.3737972449
rmesh_equiv_2 a a.n2 5.0057544689858355
rmesh_equiv_20 n1 n1.n13 12.8005
rmesh_equiv_200 vgnd.t5 vgnd.t6 10653.89425241051
rmesh_equiv_201 vgnd.t5 vgnd.t8 16111.875471569356
rmesh_equiv_202 vgnd.t6 vgnd.t8 232276.76126229874
rmesh_equiv_203 vgnd.t7 vgnd.t9 154590.8881731611
rmesh_equiv_204 vpwr vpwr.n150 1.7724987105796428
rmesh_equiv_205 vpwr vpwr.t0 117.18187411979875
rmesh_equiv_206 vpwr vpwr.t1 419.40136273717212
rmesh_equiv_207 vpwr vpwr.t10 117.18187411979875
rmesh_equiv_208 vpwr vpwr.t11 407.85629939876543
rmesh_equiv_209 vpwr vpwr.t12 117.18187411979875
rmesh_equiv_21 n1 n1.n2 31.465999999999998
rmesh_equiv_210 vpwr vpwr.t13 428.57020446085915
rmesh_equiv_211 vpwr vpwr.t14 117.18187411979875
rmesh_equiv_212 vpwr vpwr.t15 500.04319233285042
rmesh_equiv_213 vpwr vpwr.t2 117.18187411979875
rmesh_equiv_214 vpwr vpwr.t3 454.5388272132746
rmesh_equiv_215 vpwr vpwr.t4 117.18187411979875
rmesh_equiv_216 vpwr vpwr.t5 449.59676129676092
rmesh_equiv_217 vpwr vpwr.t6 117.18187411979875
rmesh_equiv_218 vpwr vpwr.t7 400.3612153872827
rmesh_equiv_219 vpwr vpwr.t8 117.18187411979875
rmesh_equiv_22 n1 n1.n3 31.450400000000002
rmesh_equiv_220 vpwr vpwr.t9 414.19392887357168
rmesh_equiv_221 vpwr.n150 vpwr.t1 2312.4722452162646
rmesh_equiv_222 vpwr.n150 vpwr.t11 2755.5151901339868
rmesh_equiv_223 vpwr.n150 vpwr.t13 2072.7390516975156
rmesh_equiv_224 vpwr.n150 vpwr.t15 1221.3038835025977
rmesh_equiv_225 vpwr.n150 vpwr.t3 1621.0163833047866
rmesh_equiv_226 vpwr.n150 vpwr.t5 1685.8134953956599
rmesh_equiv_227 vpwr.n150 vpwr.t7 3135.0308793874242
rmesh_equiv_228 vpwr.n150 vpwr.t9 2495.2258083079932
rmesh_equiv_229 vpwr.t1 vpwr.t5 2541265.7488911371
rmesh_equiv_23 n1 n1.n4 12.8005
rmesh_equiv_230 vpwr.t1 vpwr.t7 1633304.2239710954
rmesh_equiv_231 vpwr.t11 vpwr.t13 1435582.2230822039
rmesh_equiv_232 vpwr.t11 vpwr.t3 3028142.8837568033
rmesh_equiv_233 vpwr.t11 vpwr.t9 877887.93880665232
rmesh_equiv_234 vpwr.t13 vpwr.t3 2277813.6124074352
rmesh_equiv_235 vpwr.t13 vpwr.t9 1299975.3461016845
rmesh_equiv_236 vpwr.t3 vpwr.t9 2742100.7519202833
rmesh_equiv_237 vpwr.t5 vpwr.t7 3445207.4449690296
rmesh_equiv_238 y y.n0 12.8005
rmesh_equiv_239 y y.n1 12.8005
rmesh_equiv_24 n1 n1.n5 12.8005
rmesh_equiv_240 y y.n10 10.8612
rmesh_equiv_241 y y.n3 12.8005
rmesh_equiv_242 y y.n4 12.8005
rmesh_equiv_243 y y.n7 12.8005
rmesh_equiv_244 y y.n8 12.8005
rmesh_equiv_245 y.n0 y.n2 10.151300000000001
rmesh_equiv_246 y.n0 y.t2 700.48400000000004
rmesh_equiv_247 y.n1 y.n2 10.151300000000001
rmesh_equiv_248 y.n1 y.t2 700.48400000000004
rmesh_equiv_249 y.n10 y.n6 0.55314200000000002
rmesh_equiv_25 n1 n1.n8 12.8005
rmesh_equiv_250 y.n10 y.n9 12.952100000000002
rmesh_equiv_251 y.n2 y.n6 13.5047
rmesh_equiv_252 y.n3 y.n5 10.151300000000001
rmesh_equiv_253 y.n3 y.t0 255.34500000000003
rmesh_equiv_254 y.n4 y.n5 10.151300000000001
rmesh_equiv_255 y.n4 y.t0 255.34500000000003
rmesh_equiv_256 y.n5 y.n6 12.952100000000002
rmesh_equiv_257 y.n7 y.n9 10.151300000000001
rmesh_equiv_258 y.n7 y.t1 700.48400000000004
rmesh_equiv_259 y.n8 y.n9 10.151300000000001
rmesh_equiv_26 n1 n1.n9 12.8005
rmesh_equiv_260 y.n8 y.t1 700.48400000000004
rmesh_equiv_27 n1 n1.t3 315.88
rmesh_equiv_28 n1 n1.t4 330.34100000000001
rmesh_equiv_29 n1 n1.t5 330.34100000000001
rmesh_equiv_3 a a.t0 315.88
rmesh_equiv_30 n1 n1.t6 315.88
rmesh_equiv_31 n1.n0 n1.n12 10.151300000000001
rmesh_equiv_32 n1.n0 n1.t0 700.48400000000004
rmesh_equiv_33 n1.n1 n1.n2 1.6584300000000001
rmesh_equiv_34 n1.n10 n1.n11 12.1188
rmesh_equiv_35 n1.n10 n1.n8 10.151300000000001
rmesh_equiv_36 n1.n10 n1.n9 10.151300000000001
rmesh_equiv_37 n1.n11 n1.n12 12.671400000000002
rmesh_equiv_38 n1.n11 n1.n7 0.55314200000000002
rmesh_equiv_39 n1.n12 n1.n13 10.151300000000001
rmesh_equiv_4 a a.t1 315.88
rmesh_equiv_40 n1.n13 n1.t0 700.48400000000004
rmesh_equiv_41 n1.n2 n1.n3 0.55314200000000002
rmesh_equiv_42 n1.n3 n1.n7 2.4476300000000002
rmesh_equiv_43 n1.n4 n1.n6 10.151300000000001
rmesh_equiv_44 n1.n4 n1.t2 700.48400000000004
rmesh_equiv_45 n1.n5 n1.n6 10.151300000000001
rmesh_equiv_46 n1.n5 n1.t2 700.48400000000004
rmesh_equiv_47 n1.n6 n1.n7 12.1188
rmesh_equiv_48 n1.n8 n1.t1 255.34500000000003
rmesh_equiv_49 n1.n9 n1.t1 255.34500000000003
rmesh_equiv_5 a a.t2 330.34100000000001
rmesh_equiv_50 n1__n1 n1__n1.n0 12.8005
rmesh_equiv_51 n1__n1 n1__n1.n1 12.8005
rmesh_equiv_52 n1__n1 n1__n1.n2 12.8005
rmesh_equiv_53 n1__n1 n1__n1.n5 12.8005
rmesh_equiv_54 n1__n1.n0 n1__n1.n4 10.151300000000001
rmesh_equiv_55 n1__n1.n0 n1__n1.t0 255.34500000000003
rmesh_equiv_56 n1__n1.n1 n1__n1.n3 10.151300000000001
rmesh_equiv_57 n1__n1.n1 n1__n1.t1 255.34500000000003
rmesh_equiv_58 n1__n1.n2 n1__n1.n3 10.151300000000001
rmesh_equiv_59 n1__n1.n2 n1__n1.t1 255.34500000000003
rmesh_equiv_6 a a.t3 330.34100000000001
rmesh_equiv_60 n1__n1.n3 n1__n1.n4 20.9877
rmesh_equiv_61 n1__n1.n4 n1__n1.n5 10.151300000000001
rmesh_equiv_62 n1__n1.n5 n1__n1.t0 255.34500000000003
rmesh_equiv_63 n2 n2.n0 12.8005
rmesh_equiv_64 n2 n2.n1 16.074344793195898
rmesh_equiv_65 n2 n2.n11 12.8005
rmesh_equiv_66 n2 n2.n2 12.8005
rmesh_equiv_67 n2 n2.n3 12.8005
rmesh_equiv_68 n2 n2.n6 12.8005
rmesh_equiv_69 n2 n2.n7 12.8005
rmesh_equiv_7 a.n0 a.n1 1.6584300000000001
rmesh_equiv_70 n2 n2.t3 330.34100000000001
rmesh_equiv_71 n2 n2.t4 315.88
rmesh_equiv_72 n2.n0 n2.n10 10.151300000000001
rmesh_equiv_73 n2.n0 n2.t0 700.48400000000004
rmesh_equiv_74 n2.n1 n2.n5 3.5529199999999999
rmesh_equiv_75 n2.n10 n2.n11 10.151300000000001
rmesh_equiv_76 n2.n10 n2.n9 13.088100000000001
rmesh_equiv_77 n2.n11 n2.t0 700.48400000000004
rmesh_equiv_78 n2.n2 n2.n4 10.151300000000001
rmesh_equiv_79 n2.n2 n2.t2 700.48400000000004
rmesh_equiv_8 a.n1 a.n2 0.55314200000000002
rmesh_equiv_80 n2.n3 n2.n4 10.151300000000001
rmesh_equiv_81 n2.n3 n2.t2 700.48400000000004
rmesh_equiv_82 n2.n4 n2.n5 12.535399999999999
rmesh_equiv_83 n2.n5 n2.n9 0.55314200000000002
rmesh_equiv_84 n2.n6 n2.n8 10.151300000000001
rmesh_equiv_85 n2.n6 n2.t1 255.34500000000003
rmesh_equiv_86 n2.n7 n2.n8 10.151300000000001
rmesh_equiv_87 n2.n7 n2.t1 255.34500000000003
rmesh_equiv_88 n2.n8 n2.n9 12.535399999999999
rmesh_equiv_89 n2__n1 n2__n1.n0 12.8005
rmesh_equiv_9 b b.n0 15.449294018193466
rmesh_equiv_90 n2__n1 n2__n1.n1 12.8005
rmesh_equiv_91 n2__n1 n2__n1.n2 12.8005
rmesh_equiv_92 n2__n1 n2__n1.n5 12.8005
rmesh_equiv_93 n2__n1.n0 n2__n1.n4 10.151300000000001
rmesh_equiv_94 n2__n1.n0 n2__n1.t0 255.34500000000003
rmesh_equiv_95 n2__n1.n1 n2__n1.n3 10.151300000000001
rmesh_equiv_96 n2__n1.n1 n2__n1.t1 255.34500000000003
rmesh_equiv_97 n2__n1.n2 n2__n1.n3 10.151300000000001
rmesh_equiv_98 n2__n1.n2 n2__n1.t1 255.34500000000003
rmesh_equiv_99 n2__n1.n3 n2__n1.n4 22.654299999999999
.ends

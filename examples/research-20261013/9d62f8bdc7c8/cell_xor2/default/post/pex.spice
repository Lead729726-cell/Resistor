* NGSPICE file created from cell_xor2.ext - technology: sky130A

.subckt cell_xor2 Y VPWR VGND B A
X0 N1__N1.t0 A.t0 N1.t1 VGND.t1 sky130_fd_pr__nfet_01v8 ad=0.1885 pd=1.88 as=0.1885 ps=1.88 w=0.65 l=0.15
X1 N2__N1.t0 A.t1 N2.t1 VGND.t0 sky130_fd_pr__nfet_01v8 ad=0.1885 pd=1.88 as=0.1885 ps=1.88 w=0.65 l=0.15
X2 VGND.t3 N3.t3 N4__N1.t1 VGND.t2 sky130_fd_pr__nfet_01v8 ad=0.1885 pd=1.88 as=0.1885 ps=1.88 w=0.65 l=0.15
X3 VGND.t9 N1.t3 N2__N1.t1 VGND.t8 sky130_fd_pr__nfet_01v8 ad=0.1885 pd=1.88 as=0.1885 ps=1.88 w=0.65 l=0.15
X4 N3__N1.t0 B.t0 N3.t0 VGND.t5 sky130_fd_pr__nfet_01v8 ad=0.1885 pd=1.88 as=0.1885 ps=1.88 w=0.65 l=0.15
X5 VPWR.t9 N2.t3 Y.t1 VPWR.t8 sky130_fd_pr__pfet_01v8_hvt ad=0.1885 pd=1.88 as=0.1885 ps=1.88 w=0.65 l=0.15
X6 VPWR.t15 N1.t4 N2.t2 VPWR.t14 sky130_fd_pr__pfet_01v8_hvt ad=0.1885 pd=1.88 as=0.1885 ps=1.88 w=0.65 l=0.15
X7 VPWR.t13 N1.t5 N3.t2 VPWR.t12 sky130_fd_pr__pfet_01v8_hvt ad=0.1885 pd=1.88 as=0.1885 ps=1.88 w=0.65 l=0.15
X8 VPWR.t3 B.t1 N3.t1 VPWR.t2 sky130_fd_pr__pfet_01v8_hvt ad=0.1885 pd=1.88 as=0.1885 ps=1.88 w=0.65 l=0.15
X9 VPWR.t7 A.t2 N1.t0 VPWR.t6 sky130_fd_pr__pfet_01v8_hvt ad=0.1885 pd=1.88 as=0.1885 ps=1.88 w=0.65 l=0.15
X10 VPWR.t5 A.t3 N2.t0 VPWR.t4 sky130_fd_pr__pfet_01v8_hvt ad=0.1885 pd=1.88 as=0.1885 ps=1.88 w=0.65 l=0.15
X11 VPWR.t1 B.t2 N1.t2 VPWR.t0 sky130_fd_pr__pfet_01v8_hvt ad=0.1885 pd=1.88 as=0.1885 ps=1.88 w=0.65 l=0.15
X12 VPWR.t11 N3.t4 Y.t2 VPWR.t10 sky130_fd_pr__pfet_01v8_hvt ad=0.1885 pd=1.88 as=0.1885 ps=1.88 w=0.65 l=0.15
X13 VGND.t11 B.t3 N1__N1.t1 VGND.t10 sky130_fd_pr__nfet_01v8 ad=0.1885 pd=1.88 as=0.1885 ps=1.88 w=0.65 l=0.15
X14 N4__N1.t0 N2.t4 Y.t0 VGND.t4 sky130_fd_pr__nfet_01v8 ad=0.1885 pd=1.88 as=0.1885 ps=1.88 w=0.65 l=0.15
X15 VGND.t7 N1.t6 N3__N1.t1 VGND.t6 sky130_fd_pr__nfet_01v8 ad=0.1885 pd=1.88 as=0.1885 ps=1.88 w=0.65 l=0.15
C0 N2 N3 0.34136f
C1 N2 N1 7.51809f
C2 VPWR A 0.85687f
C3 N2__N1 A 4.5164f
C4 Y A 0
C5 B VPWR 0.84794f
C6 N3__N1 VPWR 0.01463f
C7 N2 N4__N1 1.34746f
C8 N2__N1 B 4.82149f
C9 N3__N1 N2__N1 0.00269f
C10 N1 N3 0.60736f
C11 B Y 0
C12 N3__N1 Y 0.00424f
C13 N1__N1 VPWR 0.05039f
C14 N2__N1 N1__N1 0.00298f
C15 N4__N1 N3 9.41903f
C16 N1 N4__N1 0.00261f
C17 N1__N1 Y 0
C18 N2 VPWR 0.94651f
C19 N2 N2__N1 0.58352f
C20 N2 Y 8.29126f
C21 VPWR N3 0.94487f
C22 N1 VPWR 1.36734f
C23 B A 0.3658f
C24 N3__N1 A 0.00178f
C25 N2__N1 N3 0.00312f
C26 N2__N1 N1 0.60805f
C27 N1 Y 0.13305f
C28 Y N3 0.52799f
C29 N1__N1 A 3.39377f
C30 VPWR N4__N1 0.01193f
C31 N3__N1 B 6.66809f
C32 N2__N1 N4__N1 0
C33 Y N4__N1 8.35963f
C34 B N1__N1 0.25806f
C35 N3__N1 N1__N1 0
C36 N2 A 0.4858f
C37 N2 B 0.37916f
C38 N3__N1 N2 0.2848f
C39 N2__N1 VPWR 0.02371f
C40 N1 A 0.58173f
C41 VPWR Y 0.52563f
C42 N2 N1__N1 0.00336f
C43 N2__N1 Y 0
C44 N1 B 0.83778f
C45 B N3 0.58648f
C46 N3__N1 N3 0.63364f
C47 N3__N1 N1 7.43744f
C48 N4__N1 A 0
C49 N1 N1__N1 0.53709f
C50 B N4__N1 0
C51 N3__N1 N4__N1 0
R0 A A.t2 330.341
R1 A A.t3 330.341
R2 A A.t0 315.88
R3 A A.t1 315.88
R4 A.n0 A 30.352
R5 A.n1 A 29.7994
R6 A.n0 A 29.7837
R7 A.n2 A 29.7837
R8 A A.n2 6.01704
R9 A.n1 A.n0 1.65843
R10 A.n2 A.n1 0.553142
R11 N1.t2 N1.n4 700.484
R12 N1.n5 N1.t2 700.484
R13 N1.t0 N1.n0 700.484
R14 N1.n13 N1.t0 700.484
R15 N1 N1.t4 330.341
R16 N1 N1.t5 330.341
R17 N1 N1.t3 315.88
R18 N1 N1.t6 315.88
R19 N1.t1 N1.n8 255.345
R20 N1.n9 N1.t1 255.345
R21 N1.n1 N1 32.0187
R22 N1.n2 N1 31.466
R23 N1.n3 N1 31.4504
R24 N1.n1 N1 31.4504
R25 N1 N1.n8 12.8005
R26 N1.n9 N1 12.8005
R27 N1 N1.n4 12.8005
R28 N1.n5 N1 12.8005
R29 N1 N1.n0 12.8005
R30 N1 N1.n13 12.8005
R31 N1.n12 N1.n11 12.6714
R32 N1.n11 N1.n10 12.1188
R33 N1.n7 N1.n6 12.1188
R34 N1.n10 N1.n8 10.1513
R35 N1.n10 N1.n9 10.1513
R36 N1.n6 N1.n4 10.1513
R37 N1.n6 N1.n5 10.1513
R38 N1.n12 N1.n0 10.1513
R39 N1.n13 N1.n12 10.1513
R40 N1.n7 N1.n3 2.44763
R41 N1.n2 N1.n1 1.65843
R42 N1.n3 N1.n2 0.553142
R43 N1.n11 N1.n7 0.553142
R44 N1__N1.t1 N1__N1.n1 255.345
R45 N1__N1.n2 N1__N1.t1 255.345
R46 N1__N1.t0 N1__N1.n0 255.345
R47 N1__N1.n5 N1__N1.t0 255.345
R48 N1__N1.n4 N1__N1.n3 20.9877
R49 N1__N1 N1__N1.n1 12.8005
R50 N1__N1.n2 N1__N1 12.8005
R51 N1__N1 N1__N1.n0 12.8005
R52 N1__N1 N1__N1.n5 12.8005
R53 N1__N1.n3 N1__N1.n1 10.1513
R54 N1__N1.n3 N1__N1.n2 10.1513
R55 N1__N1.n4 N1__N1.n0 10.1513
R56 N1__N1.n5 N1__N1.n4 10.1513
R57 VGND.n273 VGND.n272 7027.79
R58 VGND.n242 VGND.n241 4403.12
R59 VGND.n241 VGND.n240 4403.12
R60 VGND.n240 VGND.n239 4403.12
R61 VGND.n239 VGND.n238 4403.12
R62 VGND.n238 VGND.n14 4403.12
R63 VGND.n273 VGND.n14 4403.12
R64 VGND.n266 VGND.n51 4272.39
R65 VGND.n242 VGND.n51 3797.73
R66 VGND.n272 VGND.n271 1934.17
R67 VGND.n271 VGND.n270 1934.17
R68 VGND.n270 VGND.n269 1934.17
R69 VGND.n269 VGND.n268 1934.17
R70 VGND.n268 VGND.n267 1934.17
R71 VGND.n267 VGND.n266 1934.17
R72 VGND.n251 VGND.n60 1315.26
R73 VGND.n248 VGND.n245 1315.26
R74 VGND.n58 VGND.n53 1315.26
R75 VGND.n263 VGND.n54 1315.26
R76 VGND.n275 VGND.n10 1315.26
R77 VGND.n277 VGND.n12 1315.26
R78 VGND.n288 VGND.n8 1315.26
R79 VGND.n291 VGND.n290 1315.26
R80 VGND.n32 VGND.n23 1315.26
R81 VGND.n29 VGND.n26 1315.26
R82 VGND.n21 VGND.n16 1315.26
R83 VGND.n44 VGND.n17 1315.26
R84 VGND.n235 VGND.n66 1315.26
R85 VGND.n231 VGND.n65 1315.26
R86 VGND.n224 VGND.n72 1315.26
R87 VGND.n222 VGND.n75 1315.26
R88 VGND.n196 VGND.n192 1315.26
R89 VGND.n198 VGND.n194 1315.26
R90 VGND.n209 VGND.n190 1315.26
R91 VGND.n212 VGND.n211 1315.26
R92 VGND.n161 VGND.n157 1315.26
R93 VGND.n163 VGND.n159 1315.26
R94 VGND.n174 VGND.n155 1315.26
R95 VGND.n177 VGND.n176 1315.26
R96 VGND.n130 VGND.n126 1315.26
R97 VGND.n132 VGND.n128 1315.26
R98 VGND.n143 VGND.n124 1315.26
R99 VGND.n146 VGND.n145 1315.26
R100 VGND.n97 VGND.n85 1315.26
R101 VGND.n108 VGND.n86 1315.26
R102 VGND.n110 VGND.n83 1315.26
R103 VGND.n92 VGND.n82 1315.26
R104 VGND.n272 VGND.n6 993.668
R105 VGND.n271 VGND.n46 993.668
R106 VGND.n270 VGND.n47 993.668
R107 VGND.n269 VGND.n48 993.668
R108 VGND.n268 VGND.n49 993.668
R109 VGND.n267 VGND.n50 993.668
R110 VGND.n266 VGND.n265 993.668
R111 VGND.n84 VGND.n51 662.304
R112 VGND.n279 VGND.n12 585
R113 VGND.n12 VGND.n11 585
R114 VGND.n282 VGND.n281 585
R115 VGND.n283 VGND.n282 585
R116 VGND.n280 VGND.n4 585
R117 VGND.n5 VGND.n4 585
R118 VGND.n290 VGND.n2 585
R119 VGND.n290 VGND.n289 585
R120 VGND.n292 VGND.n291 585
R121 VGND.n8 VGND.n1 585
R122 VGND.n288 VGND.n287 585
R123 VGND.n289 VGND.n288 585
R124 VGND.n286 VGND.n7 585
R125 VGND.n7 VGND.n5 585
R126 VGND.n285 VGND.n284 585
R127 VGND.n284 VGND.n283 585
R128 VGND.n10 VGND.n9 585
R129 VGND.n11 VGND.n10 585
R130 VGND.n275 VGND.n13 585
R131 VGND.n278 VGND.n277 585
R132 VGND.n29 VGND.n28 585
R133 VGND.n31 VGND.n29 585
R134 VGND.n19 VGND.n18 585
R135 VGND.n30 VGND.n19 585
R136 VGND.n41 VGND.n40 585
R137 VGND.n40 VGND.n39 585
R138 VGND.n42 VGND.n17 585
R139 VGND.n17 VGND.n15 585
R140 VGND.n44 VGND.n43 585
R141 VGND.n35 VGND.n16 585
R142 VGND.n36 VGND.n21 585
R143 VGND.n21 VGND.n15 585
R144 VGND.n38 VGND.n37 585
R145 VGND.n39 VGND.n38 585
R146 VGND.n34 VGND.n20 585
R147 VGND.n30 VGND.n20 585
R148 VGND.n33 VGND.n32 585
R149 VGND.n32 VGND.n31 585
R150 VGND.n23 VGND.n22 585
R151 VGND.n27 VGND.n26 585
R152 VGND.n232 VGND.n231 585
R153 VGND.n231 VGND.n64 585
R154 VGND.n230 VGND.n68 585
R155 VGND.n230 VGND.n229 585
R156 VGND.n76 VGND.n69 585
R157 VGND.n73 VGND.n69 585
R158 VGND.n222 VGND.n221 585
R159 VGND.n223 VGND.n222 585
R160 VGND.n220 VGND.n75 585
R161 VGND.n72 VGND.n71 585
R162 VGND.n225 VGND.n224 585
R163 VGND.n224 VGND.n223 585
R164 VGND.n226 VGND.n70 585
R165 VGND.n73 VGND.n70 585
R166 VGND.n228 VGND.n227 585
R167 VGND.n229 VGND.n228 585
R168 VGND.n67 VGND.n66 585
R169 VGND.n66 VGND.n64 585
R170 VGND.n235 VGND.n234 585
R171 VGND.n233 VGND.n65 585
R172 VGND.n200 VGND.n194 585
R173 VGND.n194 VGND.n193 585
R174 VGND.n203 VGND.n202 585
R175 VGND.n204 VGND.n203 585
R176 VGND.n201 VGND.n187 585
R177 VGND.n188 VGND.n187 585
R178 VGND.n211 VGND.n185 585
R179 VGND.n211 VGND.n210 585
R180 VGND.n213 VGND.n212 585
R181 VGND.n190 VGND.n184 585
R182 VGND.n209 VGND.n208 585
R183 VGND.n210 VGND.n209 585
R184 VGND.n207 VGND.n189 585
R185 VGND.n189 VGND.n188 585
R186 VGND.n206 VGND.n205 585
R187 VGND.n205 VGND.n204 585
R188 VGND.n192 VGND.n191 585
R189 VGND.n193 VGND.n192 585
R190 VGND.n196 VGND.n195 585
R191 VGND.n199 VGND.n198 585
R192 VGND.n165 VGND.n159 585
R193 VGND.n159 VGND.n158 585
R194 VGND.n168 VGND.n167 585
R195 VGND.n169 VGND.n168 585
R196 VGND.n166 VGND.n152 585
R197 VGND.n153 VGND.n152 585
R198 VGND.n176 VGND.n150 585
R199 VGND.n176 VGND.n175 585
R200 VGND.n178 VGND.n177 585
R201 VGND.n155 VGND.n149 585
R202 VGND.n174 VGND.n173 585
R203 VGND.n175 VGND.n174 585
R204 VGND.n172 VGND.n154 585
R205 VGND.n154 VGND.n153 585
R206 VGND.n171 VGND.n170 585
R207 VGND.n170 VGND.n169 585
R208 VGND.n157 VGND.n156 585
R209 VGND.n158 VGND.n157 585
R210 VGND.n161 VGND.n160 585
R211 VGND.n164 VGND.n163 585
R212 VGND.n134 VGND.n128 585
R213 VGND.n128 VGND.n127 585
R214 VGND.n137 VGND.n136 585
R215 VGND.n138 VGND.n137 585
R216 VGND.n135 VGND.n121 585
R217 VGND.n122 VGND.n121 585
R218 VGND.n145 VGND.n119 585
R219 VGND.n145 VGND.n144 585
R220 VGND.n147 VGND.n146 585
R221 VGND.n124 VGND.n118 585
R222 VGND.n143 VGND.n142 585
R223 VGND.n144 VGND.n143 585
R224 VGND.n141 VGND.n123 585
R225 VGND.n123 VGND.n122 585
R226 VGND.n140 VGND.n139 585
R227 VGND.n139 VGND.n138 585
R228 VGND.n126 VGND.n125 585
R229 VGND.n127 VGND.n126 585
R230 VGND.n130 VGND.n129 585
R231 VGND.n133 VGND.n132 585
R232 VGND.n248 VGND.n247 585
R233 VGND.n250 VGND.n248 585
R234 VGND.n56 VGND.n55 585
R235 VGND.n249 VGND.n56 585
R236 VGND.n260 VGND.n259 585
R237 VGND.n259 VGND.n258 585
R238 VGND.n261 VGND.n54 585
R239 VGND.n54 VGND.n52 585
R240 VGND.n263 VGND.n262 585
R241 VGND.n254 VGND.n53 585
R242 VGND.n255 VGND.n58 585
R243 VGND.n58 VGND.n52 585
R244 VGND.n257 VGND.n256 585
R245 VGND.n258 VGND.n257 585
R246 VGND.n253 VGND.n57 585
R247 VGND.n249 VGND.n57 585
R248 VGND.n252 VGND.n251 585
R249 VGND.n251 VGND.n250 585
R250 VGND.n60 VGND.n59 585
R251 VGND.n246 VGND.n245 585
R252 VGND.n92 VGND.n91 585
R253 VGND.n90 VGND.n89 585
R254 VGND.n88 VGND.n87 585
R255 VGND.n98 VGND.n97 585
R256 VGND.n99 VGND.n85 585
R257 VGND.n94 VGND.n85 585
R258 VGND.n108 VGND.n107 585
R259 VGND.n109 VGND.n108 585
R260 VGND.n106 VGND.n86 585
R261 VGND.n105 VGND.n104 585
R262 VGND.n102 VGND.n100 585
R263 VGND.n83 VGND.n81 585
R264 VGND.n111 VGND.n110 585
R265 VGND.n110 VGND.n109 585
R266 VGND.n82 VGND.n80 585
R267 VGND.n94 VGND.n82 585
R268 VGND.n251 VGND.n57 394
R269 VGND.n257 VGND.n57 394
R270 VGND.n257 VGND.n58 394
R271 VGND.n248 VGND.n56 394
R272 VGND.n259 VGND.n56 394
R273 VGND.n259 VGND.n54 394
R274 VGND.n284 VGND.n10 394
R275 VGND.n284 VGND.n7 394
R276 VGND.n288 VGND.n7 394
R277 VGND.n282 VGND.n12 394
R278 VGND.n282 VGND.n4 394
R279 VGND.n290 VGND.n4 394
R280 VGND.n32 VGND.n20 394
R281 VGND.n38 VGND.n20 394
R282 VGND.n38 VGND.n21 394
R283 VGND.n29 VGND.n19 394
R284 VGND.n40 VGND.n19 394
R285 VGND.n40 VGND.n17 394
R286 VGND.n228 VGND.n66 394
R287 VGND.n228 VGND.n70 394
R288 VGND.n224 VGND.n70 394
R289 VGND.n231 VGND.n230 394
R290 VGND.n230 VGND.n69 394
R291 VGND.n222 VGND.n69 394
R292 VGND.n205 VGND.n192 394
R293 VGND.n205 VGND.n189 394
R294 VGND.n209 VGND.n189 394
R295 VGND.n203 VGND.n194 394
R296 VGND.n203 VGND.n187 394
R297 VGND.n211 VGND.n187 394
R298 VGND.n170 VGND.n157 394
R299 VGND.n170 VGND.n154 394
R300 VGND.n174 VGND.n154 394
R301 VGND.n168 VGND.n159 394
R302 VGND.n168 VGND.n152 394
R303 VGND.n176 VGND.n152 394
R304 VGND.n139 VGND.n126 394
R305 VGND.n139 VGND.n123 394
R306 VGND.n143 VGND.n123 394
R307 VGND.n137 VGND.n128 394
R308 VGND.n137 VGND.n121 394
R309 VGND.n145 VGND.n121 394
R310 VGND.n108 VGND.n85 394
R311 VGND.n104 VGND.n102 394
R312 VGND.n110 VGND.n82 394
R313 VGND.n89 VGND.n88 394
R314 VGND.n95 VGND.n94 357.068
R315 VGND.n109 VGND.n84 357.068
R316 VGND.t11 VGND.n215 255.345
R317 VGND.n216 VGND.t11 255.345
R318 VGND.t9 VGND.n180 255.345
R319 VGND.n181 VGND.t9 255.345
R320 VGND.t7 VGND.n114 255.345
R321 VGND.n115 VGND.t7 255.345
R322 VGND.t3 VGND.n77 255.345
R323 VGND.n78 VGND.t3 255.345
R324 VGND.n274 VGND.n11 220
R325 VGND.n289 VGND.n6 220
R326 VGND.n31 VGND.n24 220
R327 VGND.n46 VGND.n15 220
R328 VGND.n237 VGND.n64 220
R329 VGND.n223 VGND.n47 220
R330 VGND.n193 VGND.n63 220
R331 VGND.n210 VGND.n48 220
R332 VGND.n158 VGND.n62 220
R333 VGND.n175 VGND.n49 220
R334 VGND.n127 VGND.n61 220
R335 VGND.n144 VGND.n50 220
R336 VGND.n250 VGND.n243 220
R337 VGND.n265 VGND.n52 220
R338 VGND.n6 VGND.n3 218.815
R339 VGND.n276 VGND.n274 218.815
R340 VGND.n46 VGND.n45 218.815
R341 VGND.n25 VGND.n24 218.815
R342 VGND.n74 VGND.n47 218.815
R343 VGND.n237 VGND.n236 218.815
R344 VGND.n186 VGND.n48 218.815
R345 VGND.n197 VGND.n63 218.815
R346 VGND.n151 VGND.n49 218.815
R347 VGND.n162 VGND.n62 218.815
R348 VGND.n120 VGND.n50 218.815
R349 VGND.n131 VGND.n61 218.815
R350 VGND.n265 VGND.n264 218.815
R351 VGND.n244 VGND.n243 218.815
R352 VGND.n95 VGND.n93 218.815
R353 VGND.n96 VGND.n95 218.815
R354 VGND.n103 VGND.n84 218.815
R355 VGND.n101 VGND.n84 218.815
R356 VGND.n244 VGND.n60 147.374
R357 VGND.n264 VGND.n263 147.374
R358 VGND.n276 VGND.n275 147.374
R359 VGND.n291 VGND.n3 147.374
R360 VGND.n8 VGND.n3 147.374
R361 VGND.n277 VGND.n276 147.374
R362 VGND.n25 VGND.n23 147.374
R363 VGND.n45 VGND.n44 147.374
R364 VGND.n45 VGND.n16 147.374
R365 VGND.n26 VGND.n25 147.374
R366 VGND.n236 VGND.n235 147.374
R367 VGND.n75 VGND.n74 147.374
R368 VGND.n74 VGND.n72 147.374
R369 VGND.n236 VGND.n65 147.374
R370 VGND.n197 VGND.n196 147.374
R371 VGND.n212 VGND.n186 147.374
R372 VGND.n190 VGND.n186 147.374
R373 VGND.n198 VGND.n197 147.374
R374 VGND.n162 VGND.n161 147.374
R375 VGND.n177 VGND.n151 147.374
R376 VGND.n155 VGND.n151 147.374
R377 VGND.n163 VGND.n162 147.374
R378 VGND.n131 VGND.n130 147.374
R379 VGND.n146 VGND.n120 147.374
R380 VGND.n124 VGND.n120 147.374
R381 VGND.n132 VGND.n131 147.374
R382 VGND.n264 VGND.n53 147.374
R383 VGND.n245 VGND.n244 147.374
R384 VGND.n103 VGND.n86 147.374
R385 VGND.n101 VGND.n83 147.374
R386 VGND.n97 VGND.n96 147.374
R387 VGND.n93 VGND.n89 147.374
R388 VGND.n93 VGND.n92 147.374
R389 VGND.n96 VGND.n88 147.374
R390 VGND.n104 VGND.n103 147.374
R391 VGND.n102 VGND.n101 147.374
R392 VGND.n283 VGND.n11 124.668
R393 VGND.n289 VGND.n5 124.668
R394 VGND.n31 VGND.n30 124.668
R395 VGND.n39 VGND.n15 124.668
R396 VGND.n229 VGND.n64 124.668
R397 VGND.n223 VGND.n73 124.668
R398 VGND.n204 VGND.n193 124.668
R399 VGND.n210 VGND.n188 124.668
R400 VGND.n169 VGND.n158 124.668
R401 VGND.n175 VGND.n153 124.668
R402 VGND.n138 VGND.n127 124.668
R403 VGND.n144 VGND.n122 124.668
R404 VGND.n250 VGND.n249 124.668
R405 VGND.n258 VGND.n52 124.668
R406 VGND.n274 VGND.n273 113.668
R407 VGND.n24 VGND.n14 113.668
R408 VGND.n238 VGND.n237 113.668
R409 VGND.n239 VGND.n63 113.668
R410 VGND.n240 VGND.n62 113.668
R411 VGND.n241 VGND.n61 113.668
R412 VGND.n243 VGND.n242 113.668
R413 VGND.n94 VGND.t2 97.9063
R414 VGND.n109 VGND.t2 97.9063
R415 VGND.n252 VGND.n59 85.4593
R416 VGND.n247 VGND.n246 85.4593
R417 VGND.n255 VGND.n254 85.4593
R418 VGND.n262 VGND.n261 85.4593
R419 VGND.n13 VGND.n9 85.4593
R420 VGND.n279 VGND.n278 85.4593
R421 VGND.n287 VGND.n1 85.4593
R422 VGND.n292 VGND.n2 85.4593
R423 VGND.n33 VGND.n22 85.4593
R424 VGND.n28 VGND.n27 85.4593
R425 VGND.n36 VGND.n35 85.4593
R426 VGND.n43 VGND.n42 85.4593
R427 VGND.n234 VGND.n67 85.4593
R428 VGND.n233 VGND.n232 85.4593
R429 VGND.n225 VGND.n71 85.4593
R430 VGND.n221 VGND.n220 85.4593
R431 VGND.n195 VGND.n191 85.4593
R432 VGND.n200 VGND.n199 85.4593
R433 VGND.n208 VGND.n184 85.4593
R434 VGND.n213 VGND.n185 85.4593
R435 VGND.n160 VGND.n156 85.4593
R436 VGND.n165 VGND.n164 85.4593
R437 VGND.n173 VGND.n149 85.4593
R438 VGND.n178 VGND.n150 85.4593
R439 VGND.n129 VGND.n125 85.4593
R440 VGND.n134 VGND.n133 85.4593
R441 VGND.n142 VGND.n118 85.4593
R442 VGND.n147 VGND.n119 85.4593
R443 VGND.n99 VGND.n98 85.4593
R444 VGND.n91 VGND.n80 85.4593
R445 VGND.n107 VGND.n106 85.4593
R446 VGND.n111 VGND.n81 85.4593
R447 VGND.n283 VGND.t1 62.3338
R448 VGND.t1 VGND.n5 62.3338
R449 VGND.n30 VGND.t10 62.3338
R450 VGND.n39 VGND.t10 62.3338
R451 VGND.n229 VGND.t0 62.3338
R452 VGND.n73 VGND.t0 62.3338
R453 VGND.n204 VGND.t8 62.3338
R454 VGND.t8 VGND.n188 62.3338
R455 VGND.n169 VGND.t5 62.3338
R456 VGND.t5 VGND.n153 62.3338
R457 VGND.n138 VGND.t6 62.3338
R458 VGND.t6 VGND.n122 62.3338
R459 VGND.n249 VGND.t4 62.3338
R460 VGND.n258 VGND.t4 62.3338
R461 VGND.n246 VGND.n59 25.6005
R462 VGND.n253 VGND.n252 25.6005
R463 VGND.n256 VGND.n253 25.6005
R464 VGND.n256 VGND.n255 25.6005
R465 VGND.n247 VGND.n55 25.6005
R466 VGND.n260 VGND.n55 25.6005
R467 VGND.n261 VGND.n260 25.6005
R468 VGND.n278 VGND.n13 25.6005
R469 VGND.n285 VGND.n9 25.6005
R470 VGND.n286 VGND.n285 25.6005
R471 VGND.n287 VGND.n286 25.6005
R472 VGND.n281 VGND.n279 25.6005
R473 VGND.n281 VGND.n280 25.6005
R474 VGND.n280 VGND.n2 25.6005
R475 VGND.n27 VGND.n22 25.6005
R476 VGND.n34 VGND.n33 25.6005
R477 VGND.n37 VGND.n34 25.6005
R478 VGND.n37 VGND.n36 25.6005
R479 VGND.n28 VGND.n18 25.6005
R480 VGND.n41 VGND.n18 25.6005
R481 VGND.n42 VGND.n41 25.6005
R482 VGND.n234 VGND.n233 25.6005
R483 VGND.n227 VGND.n67 25.6005
R484 VGND.n227 VGND.n226 25.6005
R485 VGND.n226 VGND.n225 25.6005
R486 VGND.n232 VGND.n68 25.6005
R487 VGND.n76 VGND.n68 25.6005
R488 VGND.n221 VGND.n76 25.6005
R489 VGND.n199 VGND.n195 25.6005
R490 VGND.n206 VGND.n191 25.6005
R491 VGND.n207 VGND.n206 25.6005
R492 VGND.n208 VGND.n207 25.6005
R493 VGND.n202 VGND.n200 25.6005
R494 VGND.n202 VGND.n201 25.6005
R495 VGND.n201 VGND.n185 25.6005
R496 VGND.n164 VGND.n160 25.6005
R497 VGND.n171 VGND.n156 25.6005
R498 VGND.n172 VGND.n171 25.6005
R499 VGND.n173 VGND.n172 25.6005
R500 VGND.n167 VGND.n165 25.6005
R501 VGND.n167 VGND.n166 25.6005
R502 VGND.n166 VGND.n150 25.6005
R503 VGND.n133 VGND.n129 25.6005
R504 VGND.n140 VGND.n125 25.6005
R505 VGND.n141 VGND.n140 25.6005
R506 VGND.n142 VGND.n141 25.6005
R507 VGND.n136 VGND.n134 25.6005
R508 VGND.n136 VGND.n135 25.6005
R509 VGND.n135 VGND.n119 25.6005
R510 VGND.n98 VGND.n87 25.6005
R511 VGND.n90 VGND.n87 25.6005
R512 VGND.n91 VGND.n90 25.6005
R513 VGND.n107 VGND.n99 25.6005
R514 VGND.n106 VGND.n105 25.6005
R515 VGND.n105 VGND.n100 25.6005
R516 VGND.n100 VGND.n81 25.6005
R517 VGND.n113 VGND 18.3598
R518 VGND.n293 VGND 18.3598
R519 VGND VGND.n0 18.3598
R520 VGND VGND.n219 18.3598
R521 VGND.n214 VGND 18.3598
R522 VGND.n179 VGND 18.3598
R523 VGND.n148 VGND 18.3598
R524 VGND.n112 VGND 18.3598
R525 VGND VGND.n180 12.8005
R526 VGND.n181 VGND 12.8005
R527 VGND VGND.n114 12.8005
R528 VGND.n115 VGND 12.8005
R529 VGND VGND.n77 12.8005
R530 VGND.n78 VGND 12.8005
R531 VGND.n254 VGND 12.8005
R532 VGND.n262 VGND 12.8005
R533 VGND VGND.n1 12.8005
R534 VGND VGND.n292 12.8005
R535 VGND.n35 VGND 12.8005
R536 VGND.n43 VGND 12.8005
R537 VGND VGND.n71 12.8005
R538 VGND.n220 VGND 12.8005
R539 VGND VGND.n184 12.8005
R540 VGND VGND.n213 12.8005
R541 VGND VGND.n149 12.8005
R542 VGND VGND.n178 12.8005
R543 VGND VGND.n118 12.8005
R544 VGND VGND.n147 12.8005
R545 VGND VGND.n80 12.8005
R546 VGND VGND.n111 12.8005
R547 VGND VGND.n215 12.8005
R548 VGND.n216 VGND 12.8005
R549 VGND.n182 VGND.n180 10.1513
R550 VGND.n182 VGND.n181 10.1513
R551 VGND.n116 VGND.n114 10.1513
R552 VGND.n116 VGND.n115 10.1513
R553 VGND.n79 VGND.n77 10.1513
R554 VGND.n79 VGND.n78 10.1513
R555 VGND.n217 VGND.n215 10.1513
R556 VGND.n217 VGND.n216 10.1513
R557 VGND.n112 VGND.n79 10.1294
R558 VGND.n183 VGND.n182 10.0354
R559 VGND.n117 VGND.n116 10.0354
R560 VGND.n218 VGND.n217 10.0354
R561 VGND VGND.n293 5.15812
R562 VGND.n113 VGND.n112 1.10578
R563 VGND.n179 VGND.n148 1.10578
R564 VGND.n219 VGND.n214 1.10578
R565 VGND.n293 VGND.n0 1.10578
R566 VGND.n117 VGND.n113 1.01178
R567 VGND.n183 VGND.n179 1.01178
R568 VGND.n219 VGND.n218 1.01178
R569 VGND.n148 VGND.n117 0.0945
R570 VGND.n214 VGND.n183 0.0945
R571 VGND.n218 VGND.n0 0.0945
R572 N2.t2 N2.n2 700.484
R573 N2.n3 N2.t2 700.484
R574 N2.t0 N2.n0 700.484
R575 N2.n11 N2.t0 700.484
R576 N2 N2.t3 330.341
R577 N2 N2.t4 315.88
R578 N2.t1 N2.n6 255.345
R579 N2.n7 N2.t1 255.345
R580 N2.n1 N2 32.4353
R581 N2.n1 N2 31.8671
R582 N2.n10 N2.n9 13.0881
R583 N2 N2.n6 12.8005
R584 N2.n7 N2 12.8005
R585 N2 N2.n2 12.8005
R586 N2.n3 N2 12.8005
R587 N2 N2.n0 12.8005
R588 N2 N2.n11 12.8005
R589 N2.n9 N2.n8 12.5354
R590 N2.n5 N2.n4 12.5354
R591 N2.n8 N2.n6 10.1513
R592 N2.n8 N2.n7 10.1513
R593 N2.n4 N2.n2 10.1513
R594 N2.n4 N2.n3 10.1513
R595 N2.n10 N2.n0 10.1513
R596 N2.n11 N2.n10 10.1513
R597 N2.n5 N2.n1 3.55292
R598 N2.n9 N2.n5 0.553142
R599 N2__N1.t1 N2__N1.n1 255.345
R600 N2__N1.n2 N2__N1.t1 255.345
R601 N2__N1.t0 N2__N1.n0 255.345
R602 N2__N1.n5 N2__N1.t0 255.345
R603 N2__N1.n4 N2__N1.n3 22.6543
R604 N2__N1 N2__N1.n1 12.8005
R605 N2__N1.n2 N2__N1 12.8005
R606 N2__N1 N2__N1.n0 12.8005
R607 N2__N1 N2__N1.n5 12.8005
R608 N2__N1.n3 N2__N1.n1 10.1513
R609 N2__N1.n3 N2__N1.n2 10.1513
R610 N2__N1.n4 N2__N1.n0 10.1513
R611 N2__N1.n5 N2__N1.n4 10.1513
R612 N3.t1 N3.n6 700.484
R613 N3.n7 N3.t1 700.484
R614 N3.t2 N3.n2 700.484
R615 N3.n3 N3.t2 700.484
R616 N3 N3.t4 330.341
R617 N3 N3.t3 315.88
R618 N3.t0 N3.n0 255.345
R619 N3.n11 N3.t0 255.345
R620 N3.n1 N3 33.6853
R621 N3.n1 N3 33.1171
R622 N3.n9 N3.n8 14.3381
R623 N3.n5 N3.n4 13.7854
R624 N3.n10 N3.n9 13.7854
R625 N3 N3.n6 12.8005
R626 N3.n7 N3 12.8005
R627 N3 N3.n2 12.8005
R628 N3.n3 N3 12.8005
R629 N3 N3.n0 12.8005
R630 N3 N3.n11 12.8005
R631 N3.n8 N3.n6 10.1513
R632 N3.n8 N3.n7 10.1513
R633 N3.n4 N3.n2 10.1513
R634 N3.n4 N3.n3 10.1513
R635 N3.n10 N3.n0 10.1513
R636 N3.n11 N3.n10 10.1513
R637 N3.n5 N3.n1 2.44763
R638 N3.n9 N3.n5 0.553142
R639 N4__N1.t1 N4__N1.n1 255.345
R640 N4__N1.n2 N4__N1.t1 255.345
R641 N4__N1.t0 N4__N1.n0 255.345
R642 N4__N1.n5 N4__N1.t0 255.345
R643 N4__N1.n4 N4__N1.n3 27.6543
R644 N4__N1 N4__N1.n1 12.8005
R645 N4__N1.n2 N4__N1 12.8005
R646 N4__N1 N4__N1.n0 12.8005
R647 N4__N1 N4__N1.n5 12.8005
R648 N4__N1.n3 N4__N1.n1 10.1513
R649 N4__N1.n3 N4__N1.n2 10.1513
R650 N4__N1.n4 N4__N1.n0 10.1513
R651 N4__N1.n5 N4__N1.n4 10.1513
R652 B B.t2 330.341
R653 B B.t1 330.341
R654 B B.t3 315.88
R655 B B.t0 315.88
R656 B.n0 B 31.1853
R657 B.n1 B 30.6327
R658 B.n0 B 30.6171
R659 B.n2 B 30.6171
R660 B B.n2 6.98133
R661 B.n1 B.n0 2.76371
R662 B.n2 B.n1 0.553142
R663 N3__N1.t1 N3__N1.n1 255.345
R664 N3__N1.n2 N3__N1.t1 255.345
R665 N3__N1.t0 N3__N1.n0 255.345
R666 N3__N1.n5 N3__N1.t0 255.345
R667 N3__N1.n4 N3__N1.n3 24.321
R668 N3__N1 N3__N1.n1 12.8005
R669 N3__N1.n2 N3__N1 12.8005
R670 N3__N1 N3__N1.n0 12.8005
R671 N3__N1 N3__N1.n5 12.8005
R672 N3__N1.n3 N3__N1.n1 10.1513
R673 N3__N1.n3 N3__N1.n2 10.1513
R674 N3__N1.n4 N3__N1.n0 10.1513
R675 N3__N1.n5 N3__N1.n4 10.1513
R676 Y.t1 Y.n7 700.484
R677 Y.n8 Y.t1 700.484
R678 Y.t2 Y.n0 700.484
R679 Y.n1 Y.t2 700.484
R680 Y.t0 Y.n3 255.345
R681 Y.n4 Y.t0 255.345
R682 Y.n6 Y.n2 13.5047
R683 Y.n6 Y.n5 12.9521
R684 Y.n10 Y.n9 12.9521
R685 Y Y.n3 12.8005
R686 Y.n4 Y 12.8005
R687 Y Y.n0 12.8005
R688 Y.n1 Y 12.8005
R689 Y Y.n7 12.8005
R690 Y.n8 Y 12.8005
R691 Y Y.n10 10.8612
R692 Y.n5 Y.n3 10.1513
R693 Y.n5 Y.n4 10.1513
R694 Y.n2 Y.n0 10.1513
R695 Y.n2 Y.n1 10.1513
R696 Y.n9 Y.n7 10.1513
R697 Y.n9 Y.n8 10.1513
R698 Y.n10 Y.n6 0.553142
R699 VPWR.n242 VPWR.n230 832.942
R700 VPWR.n253 VPWR.n231 832.942
R701 VPWR.n255 VPWR.n228 832.942
R702 VPWR.n237 VPWR.n227 832.942
R703 VPWR.n205 VPWR.n193 832.942
R704 VPWR.n216 VPWR.n194 832.942
R705 VPWR.n218 VPWR.n191 832.942
R706 VPWR.n200 VPWR.n190 832.942
R707 VPWR.n168 VPWR.n156 832.942
R708 VPWR.n179 VPWR.n157 832.942
R709 VPWR.n181 VPWR.n154 832.942
R710 VPWR.n163 VPWR.n153 832.942
R711 VPWR.n131 VPWR.n119 832.942
R712 VPWR.n142 VPWR.n120 832.942
R713 VPWR.n144 VPWR.n117 832.942
R714 VPWR.n126 VPWR.n116 832.942
R715 VPWR.n94 VPWR.n82 832.942
R716 VPWR.n105 VPWR.n83 832.942
R717 VPWR.n107 VPWR.n80 832.942
R718 VPWR.n89 VPWR.n79 832.942
R719 VPWR.n57 VPWR.n45 832.942
R720 VPWR.n68 VPWR.n46 832.942
R721 VPWR.n70 VPWR.n43 832.942
R722 VPWR.n52 VPWR.n42 832.942
R723 VPWR.n20 VPWR.n8 832.942
R724 VPWR.n31 VPWR.n9 832.942
R725 VPWR.n33 VPWR.n6 832.942
R726 VPWR.n15 VPWR.n5 832.942
R727 VPWR.n279 VPWR.n267 832.942
R728 VPWR.n290 VPWR.n268 832.942
R729 VPWR.n292 VPWR.n265 832.942
R730 VPWR.n274 VPWR.n264 832.942
R731 VPWR.t7 VPWR.n258 700.484
R732 VPWR.n259 VPWR.t7 700.484
R733 VPWR.t1 VPWR.n221 700.484
R734 VPWR.n222 VPWR.t1 700.484
R735 VPWR.t5 VPWR.n184 700.484
R736 VPWR.n185 VPWR.t5 700.484
R737 VPWR.t15 VPWR.n147 700.484
R738 VPWR.n148 VPWR.t15 700.484
R739 VPWR.t3 VPWR.n110 700.484
R740 VPWR.n111 VPWR.t3 700.484
R741 VPWR.t13 VPWR.n73 700.484
R742 VPWR.n74 VPWR.t13 700.484
R743 VPWR.t9 VPWR.n36 700.484
R744 VPWR.n37 VPWR.t9 700.484
R745 VPWR.t11 VPWR.n0 700.484
R746 VPWR.n1 VPWR.t11 700.484
R747 VPWR.n253 VPWR.n230 240
R748 VPWR.n249 VPWR.n247 240
R749 VPWR.n255 VPWR.n227 240
R750 VPWR.n234 VPWR.n233 240
R751 VPWR.n216 VPWR.n193 240
R752 VPWR.n212 VPWR.n210 240
R753 VPWR.n218 VPWR.n190 240
R754 VPWR.n197 VPWR.n196 240
R755 VPWR.n179 VPWR.n156 240
R756 VPWR.n175 VPWR.n173 240
R757 VPWR.n181 VPWR.n153 240
R758 VPWR.n160 VPWR.n159 240
R759 VPWR.n142 VPWR.n119 240
R760 VPWR.n138 VPWR.n136 240
R761 VPWR.n144 VPWR.n116 240
R762 VPWR.n123 VPWR.n122 240
R763 VPWR.n105 VPWR.n82 240
R764 VPWR.n101 VPWR.n99 240
R765 VPWR.n107 VPWR.n79 240
R766 VPWR.n86 VPWR.n85 240
R767 VPWR.n68 VPWR.n45 240
R768 VPWR.n64 VPWR.n62 240
R769 VPWR.n70 VPWR.n42 240
R770 VPWR.n49 VPWR.n48 240
R771 VPWR.n31 VPWR.n8 240
R772 VPWR.n27 VPWR.n25 240
R773 VPWR.n33 VPWR.n5 240
R774 VPWR.n12 VPWR.n11 240
R775 VPWR.n290 VPWR.n267 240
R776 VPWR.n286 VPWR.n284 240
R777 VPWR.n292 VPWR.n264 240
R778 VPWR.n271 VPWR.n270 240
R779 VPWR.n240 VPWR.n239 207.394
R780 VPWR.n254 VPWR.n229 207.394
R781 VPWR.n203 VPWR.n202 207.394
R782 VPWR.n217 VPWR.n192 207.394
R783 VPWR.n166 VPWR.n165 207.394
R784 VPWR.n180 VPWR.n155 207.394
R785 VPWR.n129 VPWR.n128 207.394
R786 VPWR.n143 VPWR.n118 207.394
R787 VPWR.n92 VPWR.n91 207.394
R788 VPWR.n106 VPWR.n81 207.394
R789 VPWR.n55 VPWR.n54 207.394
R790 VPWR.n69 VPWR.n44 207.394
R791 VPWR.n18 VPWR.n17 207.394
R792 VPWR.n32 VPWR.n7 207.394
R793 VPWR.n277 VPWR.n276 207.394
R794 VPWR.n291 VPWR.n266 207.394
R795 VPWR.n237 VPWR.n236 185
R796 VPWR.n235 VPWR.n234 185
R797 VPWR.n233 VPWR.n232 185
R798 VPWR.n243 VPWR.n242 185
R799 VPWR.n244 VPWR.n230 185
R800 VPWR.n239 VPWR.n230 185
R801 VPWR.n253 VPWR.n252 185
R802 VPWR.n254 VPWR.n253 185
R803 VPWR.n251 VPWR.n231 185
R804 VPWR.n250 VPWR.n249 185
R805 VPWR.n247 VPWR.n245 185
R806 VPWR.n228 VPWR.n226 185
R807 VPWR.n256 VPWR.n255 185
R808 VPWR.n255 VPWR.n254 185
R809 VPWR.n227 VPWR.n225 185
R810 VPWR.n239 VPWR.n227 185
R811 VPWR.n200 VPWR.n199 185
R812 VPWR.n198 VPWR.n197 185
R813 VPWR.n196 VPWR.n195 185
R814 VPWR.n206 VPWR.n205 185
R815 VPWR.n207 VPWR.n193 185
R816 VPWR.n202 VPWR.n193 185
R817 VPWR.n216 VPWR.n215 185
R818 VPWR.n217 VPWR.n216 185
R819 VPWR.n214 VPWR.n194 185
R820 VPWR.n213 VPWR.n212 185
R821 VPWR.n210 VPWR.n208 185
R822 VPWR.n191 VPWR.n189 185
R823 VPWR.n219 VPWR.n218 185
R824 VPWR.n218 VPWR.n217 185
R825 VPWR.n190 VPWR.n188 185
R826 VPWR.n202 VPWR.n190 185
R827 VPWR.n163 VPWR.n162 185
R828 VPWR.n161 VPWR.n160 185
R829 VPWR.n159 VPWR.n158 185
R830 VPWR.n169 VPWR.n168 185
R831 VPWR.n170 VPWR.n156 185
R832 VPWR.n165 VPWR.n156 185
R833 VPWR.n179 VPWR.n178 185
R834 VPWR.n180 VPWR.n179 185
R835 VPWR.n177 VPWR.n157 185
R836 VPWR.n176 VPWR.n175 185
R837 VPWR.n173 VPWR.n171 185
R838 VPWR.n154 VPWR.n152 185
R839 VPWR.n182 VPWR.n181 185
R840 VPWR.n181 VPWR.n180 185
R841 VPWR.n153 VPWR.n151 185
R842 VPWR.n165 VPWR.n153 185
R843 VPWR.n126 VPWR.n125 185
R844 VPWR.n124 VPWR.n123 185
R845 VPWR.n122 VPWR.n121 185
R846 VPWR.n132 VPWR.n131 185
R847 VPWR.n133 VPWR.n119 185
R848 VPWR.n128 VPWR.n119 185
R849 VPWR.n142 VPWR.n141 185
R850 VPWR.n143 VPWR.n142 185
R851 VPWR.n140 VPWR.n120 185
R852 VPWR.n139 VPWR.n138 185
R853 VPWR.n136 VPWR.n134 185
R854 VPWR.n117 VPWR.n115 185
R855 VPWR.n145 VPWR.n144 185
R856 VPWR.n144 VPWR.n143 185
R857 VPWR.n116 VPWR.n114 185
R858 VPWR.n128 VPWR.n116 185
R859 VPWR.n89 VPWR.n88 185
R860 VPWR.n87 VPWR.n86 185
R861 VPWR.n85 VPWR.n84 185
R862 VPWR.n95 VPWR.n94 185
R863 VPWR.n96 VPWR.n82 185
R864 VPWR.n91 VPWR.n82 185
R865 VPWR.n105 VPWR.n104 185
R866 VPWR.n106 VPWR.n105 185
R867 VPWR.n103 VPWR.n83 185
R868 VPWR.n102 VPWR.n101 185
R869 VPWR.n99 VPWR.n97 185
R870 VPWR.n80 VPWR.n78 185
R871 VPWR.n108 VPWR.n107 185
R872 VPWR.n107 VPWR.n106 185
R873 VPWR.n79 VPWR.n77 185
R874 VPWR.n91 VPWR.n79 185
R875 VPWR.n52 VPWR.n51 185
R876 VPWR.n50 VPWR.n49 185
R877 VPWR.n48 VPWR.n47 185
R878 VPWR.n58 VPWR.n57 185
R879 VPWR.n59 VPWR.n45 185
R880 VPWR.n54 VPWR.n45 185
R881 VPWR.n68 VPWR.n67 185
R882 VPWR.n69 VPWR.n68 185
R883 VPWR.n66 VPWR.n46 185
R884 VPWR.n65 VPWR.n64 185
R885 VPWR.n62 VPWR.n60 185
R886 VPWR.n43 VPWR.n41 185
R887 VPWR.n71 VPWR.n70 185
R888 VPWR.n70 VPWR.n69 185
R889 VPWR.n42 VPWR.n40 185
R890 VPWR.n54 VPWR.n42 185
R891 VPWR.n15 VPWR.n14 185
R892 VPWR.n13 VPWR.n12 185
R893 VPWR.n11 VPWR.n10 185
R894 VPWR.n21 VPWR.n20 185
R895 VPWR.n22 VPWR.n8 185
R896 VPWR.n17 VPWR.n8 185
R897 VPWR.n31 VPWR.n30 185
R898 VPWR.n32 VPWR.n31 185
R899 VPWR.n29 VPWR.n9 185
R900 VPWR.n28 VPWR.n27 185
R901 VPWR.n25 VPWR.n23 185
R902 VPWR.n6 VPWR.n4 185
R903 VPWR.n34 VPWR.n33 185
R904 VPWR.n33 VPWR.n32 185
R905 VPWR.n5 VPWR.n3 185
R906 VPWR.n17 VPWR.n5 185
R907 VPWR.n274 VPWR.n273 185
R908 VPWR.n272 VPWR.n271 185
R909 VPWR.n270 VPWR.n269 185
R910 VPWR.n280 VPWR.n279 185
R911 VPWR.n281 VPWR.n267 185
R912 VPWR.n276 VPWR.n267 185
R913 VPWR.n290 VPWR.n289 185
R914 VPWR.n291 VPWR.n290 185
R915 VPWR.n288 VPWR.n268 185
R916 VPWR.n287 VPWR.n286 185
R917 VPWR.n284 VPWR.n282 185
R918 VPWR.n265 VPWR.n263 185
R919 VPWR.n293 VPWR.n292 185
R920 VPWR.n292 VPWR.n291 185
R921 VPWR.n264 VPWR.n262 185
R922 VPWR.n276 VPWR.n264 185
R923 VPWR.n244 VPWR.n243 88.8476
R924 VPWR.n236 VPWR.n225 88.8476
R925 VPWR.n252 VPWR.n251 88.8476
R926 VPWR.n256 VPWR.n226 88.8476
R927 VPWR.n207 VPWR.n206 88.8476
R928 VPWR.n199 VPWR.n188 88.8476
R929 VPWR.n215 VPWR.n214 88.8476
R930 VPWR.n219 VPWR.n189 88.8476
R931 VPWR.n170 VPWR.n169 88.8476
R932 VPWR.n162 VPWR.n151 88.8476
R933 VPWR.n178 VPWR.n177 88.8476
R934 VPWR.n182 VPWR.n152 88.8476
R935 VPWR.n133 VPWR.n132 88.8476
R936 VPWR.n125 VPWR.n114 88.8476
R937 VPWR.n141 VPWR.n140 88.8476
R938 VPWR.n145 VPWR.n115 88.8476
R939 VPWR.n96 VPWR.n95 88.8476
R940 VPWR.n88 VPWR.n77 88.8476
R941 VPWR.n104 VPWR.n103 88.8476
R942 VPWR.n108 VPWR.n78 88.8476
R943 VPWR.n59 VPWR.n58 88.8476
R944 VPWR.n51 VPWR.n40 88.8476
R945 VPWR.n67 VPWR.n66 88.8476
R946 VPWR.n71 VPWR.n41 88.8476
R947 VPWR.n22 VPWR.n21 88.8476
R948 VPWR.n14 VPWR.n3 88.8476
R949 VPWR.n30 VPWR.n29 88.8476
R950 VPWR.n34 VPWR.n4 88.8476
R951 VPWR.n281 VPWR.n280 88.8476
R952 VPWR.n273 VPWR.n262 88.8476
R953 VPWR.n289 VPWR.n288 88.8476
R954 VPWR.n293 VPWR.n263 88.8476
R955 VPWR.n248 VPWR.n231 72.7879
R956 VPWR.n246 VPWR.n228 72.7879
R957 VPWR.n242 VPWR.n241 72.7879
R958 VPWR.n238 VPWR.n234 72.7879
R959 VPWR.n238 VPWR.n237 72.7879
R960 VPWR.n241 VPWR.n233 72.7879
R961 VPWR.n249 VPWR.n248 72.7879
R962 VPWR.n247 VPWR.n246 72.7879
R963 VPWR.n211 VPWR.n194 72.7879
R964 VPWR.n209 VPWR.n191 72.7879
R965 VPWR.n205 VPWR.n204 72.7879
R966 VPWR.n201 VPWR.n197 72.7879
R967 VPWR.n201 VPWR.n200 72.7879
R968 VPWR.n204 VPWR.n196 72.7879
R969 VPWR.n212 VPWR.n211 72.7879
R970 VPWR.n210 VPWR.n209 72.7879
R971 VPWR.n174 VPWR.n157 72.7879
R972 VPWR.n172 VPWR.n154 72.7879
R973 VPWR.n168 VPWR.n167 72.7879
R974 VPWR.n164 VPWR.n160 72.7879
R975 VPWR.n164 VPWR.n163 72.7879
R976 VPWR.n167 VPWR.n159 72.7879
R977 VPWR.n175 VPWR.n174 72.7879
R978 VPWR.n173 VPWR.n172 72.7879
R979 VPWR.n137 VPWR.n120 72.7879
R980 VPWR.n135 VPWR.n117 72.7879
R981 VPWR.n131 VPWR.n130 72.7879
R982 VPWR.n127 VPWR.n123 72.7879
R983 VPWR.n127 VPWR.n126 72.7879
R984 VPWR.n130 VPWR.n122 72.7879
R985 VPWR.n138 VPWR.n137 72.7879
R986 VPWR.n136 VPWR.n135 72.7879
R987 VPWR.n100 VPWR.n83 72.7879
R988 VPWR.n98 VPWR.n80 72.7879
R989 VPWR.n94 VPWR.n93 72.7879
R990 VPWR.n90 VPWR.n86 72.7879
R991 VPWR.n90 VPWR.n89 72.7879
R992 VPWR.n93 VPWR.n85 72.7879
R993 VPWR.n101 VPWR.n100 72.7879
R994 VPWR.n99 VPWR.n98 72.7879
R995 VPWR.n63 VPWR.n46 72.7879
R996 VPWR.n61 VPWR.n43 72.7879
R997 VPWR.n57 VPWR.n56 72.7879
R998 VPWR.n53 VPWR.n49 72.7879
R999 VPWR.n53 VPWR.n52 72.7879
R1000 VPWR.n56 VPWR.n48 72.7879
R1001 VPWR.n64 VPWR.n63 72.7879
R1002 VPWR.n62 VPWR.n61 72.7879
R1003 VPWR.n26 VPWR.n9 72.7879
R1004 VPWR.n24 VPWR.n6 72.7879
R1005 VPWR.n20 VPWR.n19 72.7879
R1006 VPWR.n16 VPWR.n12 72.7879
R1007 VPWR.n16 VPWR.n15 72.7879
R1008 VPWR.n19 VPWR.n11 72.7879
R1009 VPWR.n27 VPWR.n26 72.7879
R1010 VPWR.n25 VPWR.n24 72.7879
R1011 VPWR.n285 VPWR.n268 72.7879
R1012 VPWR.n283 VPWR.n265 72.7879
R1013 VPWR.n279 VPWR.n278 72.7879
R1014 VPWR.n275 VPWR.n271 72.7879
R1015 VPWR.n275 VPWR.n274 72.7879
R1016 VPWR.n278 VPWR.n270 72.7879
R1017 VPWR.n286 VPWR.n285 72.7879
R1018 VPWR.n284 VPWR.n283 72.7879
R1019 VPWR.n239 VPWR.t0 56.8667
R1020 VPWR.n254 VPWR.t0 56.8667
R1021 VPWR.n202 VPWR.t4 56.8667
R1022 VPWR.n217 VPWR.t4 56.8667
R1023 VPWR.n165 VPWR.t14 56.8667
R1024 VPWR.n180 VPWR.t14 56.8667
R1025 VPWR.n128 VPWR.t2 56.8667
R1026 VPWR.n143 VPWR.t2 56.8667
R1027 VPWR.n91 VPWR.t12 56.8667
R1028 VPWR.n106 VPWR.t12 56.8667
R1029 VPWR.n54 VPWR.t8 56.8667
R1030 VPWR.n69 VPWR.t8 56.8667
R1031 VPWR.n17 VPWR.t10 56.8667
R1032 VPWR.n32 VPWR.t10 56.8667
R1033 VPWR.n276 VPWR.t6 56.8667
R1034 VPWR.n291 VPWR.t6 56.8667
R1035 VPWR.n240 VPWR.n238 56.1076
R1036 VPWR.n241 VPWR.n240 56.1076
R1037 VPWR.n248 VPWR.n229 56.1076
R1038 VPWR.n246 VPWR.n229 56.1076
R1039 VPWR.n203 VPWR.n201 56.1076
R1040 VPWR.n204 VPWR.n203 56.1076
R1041 VPWR.n211 VPWR.n192 56.1076
R1042 VPWR.n209 VPWR.n192 56.1076
R1043 VPWR.n166 VPWR.n164 56.1076
R1044 VPWR.n167 VPWR.n166 56.1076
R1045 VPWR.n174 VPWR.n155 56.1076
R1046 VPWR.n172 VPWR.n155 56.1076
R1047 VPWR.n129 VPWR.n127 56.1076
R1048 VPWR.n130 VPWR.n129 56.1076
R1049 VPWR.n137 VPWR.n118 56.1076
R1050 VPWR.n135 VPWR.n118 56.1076
R1051 VPWR.n92 VPWR.n90 56.1076
R1052 VPWR.n93 VPWR.n92 56.1076
R1053 VPWR.n100 VPWR.n81 56.1076
R1054 VPWR.n98 VPWR.n81 56.1076
R1055 VPWR.n55 VPWR.n53 56.1076
R1056 VPWR.n56 VPWR.n55 56.1076
R1057 VPWR.n63 VPWR.n44 56.1076
R1058 VPWR.n61 VPWR.n44 56.1076
R1059 VPWR.n18 VPWR.n16 56.1076
R1060 VPWR.n19 VPWR.n18 56.1076
R1061 VPWR.n26 VPWR.n7 56.1076
R1062 VPWR.n24 VPWR.n7 56.1076
R1063 VPWR.n277 VPWR.n275 56.1076
R1064 VPWR.n278 VPWR.n277 56.1076
R1065 VPWR.n285 VPWR.n266 56.1076
R1066 VPWR.n283 VPWR.n266 56.1076
R1067 VPWR.n243 VPWR.n232 25.6005
R1068 VPWR.n235 VPWR.n232 25.6005
R1069 VPWR.n236 VPWR.n235 25.6005
R1070 VPWR.n252 VPWR.n244 25.6005
R1071 VPWR.n251 VPWR.n250 25.6005
R1072 VPWR.n250 VPWR.n245 25.6005
R1073 VPWR.n245 VPWR.n226 25.6005
R1074 VPWR.n206 VPWR.n195 25.6005
R1075 VPWR.n198 VPWR.n195 25.6005
R1076 VPWR.n199 VPWR.n198 25.6005
R1077 VPWR.n215 VPWR.n207 25.6005
R1078 VPWR.n214 VPWR.n213 25.6005
R1079 VPWR.n213 VPWR.n208 25.6005
R1080 VPWR.n208 VPWR.n189 25.6005
R1081 VPWR.n169 VPWR.n158 25.6005
R1082 VPWR.n161 VPWR.n158 25.6005
R1083 VPWR.n162 VPWR.n161 25.6005
R1084 VPWR.n178 VPWR.n170 25.6005
R1085 VPWR.n177 VPWR.n176 25.6005
R1086 VPWR.n176 VPWR.n171 25.6005
R1087 VPWR.n171 VPWR.n152 25.6005
R1088 VPWR.n132 VPWR.n121 25.6005
R1089 VPWR.n124 VPWR.n121 25.6005
R1090 VPWR.n125 VPWR.n124 25.6005
R1091 VPWR.n141 VPWR.n133 25.6005
R1092 VPWR.n140 VPWR.n139 25.6005
R1093 VPWR.n139 VPWR.n134 25.6005
R1094 VPWR.n134 VPWR.n115 25.6005
R1095 VPWR.n95 VPWR.n84 25.6005
R1096 VPWR.n87 VPWR.n84 25.6005
R1097 VPWR.n88 VPWR.n87 25.6005
R1098 VPWR.n104 VPWR.n96 25.6005
R1099 VPWR.n103 VPWR.n102 25.6005
R1100 VPWR.n102 VPWR.n97 25.6005
R1101 VPWR.n97 VPWR.n78 25.6005
R1102 VPWR.n58 VPWR.n47 25.6005
R1103 VPWR.n50 VPWR.n47 25.6005
R1104 VPWR.n51 VPWR.n50 25.6005
R1105 VPWR.n67 VPWR.n59 25.6005
R1106 VPWR.n66 VPWR.n65 25.6005
R1107 VPWR.n65 VPWR.n60 25.6005
R1108 VPWR.n60 VPWR.n41 25.6005
R1109 VPWR.n21 VPWR.n10 25.6005
R1110 VPWR.n13 VPWR.n10 25.6005
R1111 VPWR.n14 VPWR.n13 25.6005
R1112 VPWR.n30 VPWR.n22 25.6005
R1113 VPWR.n29 VPWR.n28 25.6005
R1114 VPWR.n28 VPWR.n23 25.6005
R1115 VPWR.n23 VPWR.n4 25.6005
R1116 VPWR.n280 VPWR.n269 25.6005
R1117 VPWR.n272 VPWR.n269 25.6005
R1118 VPWR.n273 VPWR.n272 25.6005
R1119 VPWR.n289 VPWR.n281 25.6005
R1120 VPWR.n288 VPWR.n287 25.6005
R1121 VPWR.n287 VPWR.n282 25.6005
R1122 VPWR.n282 VPWR.n263 25.6005
R1123 VPWR.n257 VPWR 18.865
R1124 VPWR.n220 VPWR 18.865
R1125 VPWR.n183 VPWR 18.865
R1126 VPWR.n146 VPWR 18.865
R1127 VPWR.n109 VPWR 18.865
R1128 VPWR.n72 VPWR 18.865
R1129 VPWR.n35 VPWR 18.865
R1130 VPWR.n294 VPWR 18.865
R1131 VPWR VPWR.n258 12.8005
R1132 VPWR.n259 VPWR 12.8005
R1133 VPWR VPWR.n221 12.8005
R1134 VPWR.n222 VPWR 12.8005
R1135 VPWR VPWR.n225 12.8005
R1136 VPWR VPWR.n256 12.8005
R1137 VPWR VPWR.n184 12.8005
R1138 VPWR.n185 VPWR 12.8005
R1139 VPWR VPWR.n188 12.8005
R1140 VPWR VPWR.n219 12.8005
R1141 VPWR VPWR.n147 12.8005
R1142 VPWR.n148 VPWR 12.8005
R1143 VPWR VPWR.n151 12.8005
R1144 VPWR VPWR.n182 12.8005
R1145 VPWR VPWR.n110 12.8005
R1146 VPWR.n111 VPWR 12.8005
R1147 VPWR VPWR.n114 12.8005
R1148 VPWR VPWR.n145 12.8005
R1149 VPWR VPWR.n73 12.8005
R1150 VPWR.n74 VPWR 12.8005
R1151 VPWR VPWR.n77 12.8005
R1152 VPWR VPWR.n108 12.8005
R1153 VPWR VPWR.n36 12.8005
R1154 VPWR.n37 VPWR 12.8005
R1155 VPWR VPWR.n40 12.8005
R1156 VPWR VPWR.n71 12.8005
R1157 VPWR VPWR.n0 12.8005
R1158 VPWR.n1 VPWR 12.8005
R1159 VPWR VPWR.n3 12.8005
R1160 VPWR VPWR.n34 12.8005
R1161 VPWR VPWR.n262 12.8005
R1162 VPWR VPWR.n293 12.8005
R1163 VPWR.n35 VPWR.n2 10.6503
R1164 VPWR.n261 VPWR.n260 10.5563
R1165 VPWR.n224 VPWR.n223 10.5563
R1166 VPWR.n187 VPWR.n186 10.5563
R1167 VPWR.n150 VPWR.n149 10.5563
R1168 VPWR.n113 VPWR.n112 10.5563
R1169 VPWR.n76 VPWR.n75 10.5563
R1170 VPWR.n39 VPWR.n38 10.5563
R1171 VPWR.n260 VPWR.n258 10.1513
R1172 VPWR.n260 VPWR.n259 10.1513
R1173 VPWR.n223 VPWR.n221 10.1513
R1174 VPWR.n223 VPWR.n222 10.1513
R1175 VPWR.n186 VPWR.n184 10.1513
R1176 VPWR.n186 VPWR.n185 10.1513
R1177 VPWR.n149 VPWR.n147 10.1513
R1178 VPWR.n149 VPWR.n148 10.1513
R1179 VPWR.n112 VPWR.n110 10.1513
R1180 VPWR.n112 VPWR.n111 10.1513
R1181 VPWR.n75 VPWR.n73 10.1513
R1182 VPWR.n75 VPWR.n74 10.1513
R1183 VPWR.n38 VPWR.n36 10.1513
R1184 VPWR.n38 VPWR.n37 10.1513
R1185 VPWR.n2 VPWR.n0 10.1513
R1186 VPWR.n2 VPWR.n1 10.1513
R1187 VPWR VPWR.n294 4.46447
R1188 VPWR.n39 VPWR.n35 1.01178
R1189 VPWR.n76 VPWR.n72 1.01178
R1190 VPWR.n113 VPWR.n109 1.01178
R1191 VPWR.n150 VPWR.n146 1.01178
R1192 VPWR.n187 VPWR.n183 1.01178
R1193 VPWR.n224 VPWR.n220 1.01178
R1194 VPWR.n261 VPWR.n257 1.01178
R1195 VPWR.n72 VPWR.n39 0.0945
R1196 VPWR.n109 VPWR.n76 0.0945
R1197 VPWR.n146 VPWR.n113 0.0945
R1198 VPWR.n183 VPWR.n150 0.0945
R1199 VPWR.n220 VPWR.n187 0.0945
R1200 VPWR.n257 VPWR.n224 0.0945
R1201 VPWR.n294 VPWR.n261 0.0945
C52 Y VGND 7.9926f
C53 B VGND 6.34708f
C54 A VGND 4.97613f
C55 VPWR VGND 27.6943f
C56 N4__N1 VGND 3.82313f $ **FLOATING
C57 N3__N1 VGND 3.08764f $ **FLOATING
C58 N3 VGND 12.40478f $ **FLOATING
C59 N2__N1 VGND 2.54044f $ **FLOATING
C60 N2 VGND 6.73972f $ **FLOATING
C61 N1__N1 VGND 2.91594f $ **FLOATING
C62 N1 VGND 8.39277f $ **FLOATING
C63 Y.n0 VGND 0.01139f $ **FLOATING
C64 Y.t2 VGND 0.0349f $ **FLOATING
C65 Y.n1 VGND 0.01139f $ **FLOATING
C66 Y.n2 VGND 0.53801f $ **FLOATING
C67 Y.n3 VGND 0.01302f $ **FLOATING
C68 Y.t0 VGND 0.03165f $ **FLOATING
C69 Y.n4 VGND 0.01302f $ **FLOATING
C70 Y.n5 VGND 0.49547f $ **FLOATING
C71 Y.n6 VGND 2.44463f $ **FLOATING
C72 Y.n7 VGND 0.01139f $ **FLOATING
C73 Y.t1 VGND 0.0349f $ **FLOATING
C74 Y.n8 VGND 0.01139f $ **FLOATING
C75 Y.n9 VGND 0.49547f $ **FLOATING
C76 Y.n10 VGND 8.70634f $ **FLOATING
C77 N3__N1.n0 VGND 0.01455f $ **FLOATING
C78 N3__N1.n1 VGND 0.01455f $ **FLOATING
C79 N3__N1.t1 VGND 0.03538f $ **FLOATING
C80 N3__N1.n2 VGND 0.01455f $ **FLOATING
C81 N3__N1.n3 VGND 6.7811f $ **FLOATING
C82 N3__N1.n4 VGND 7.17632f $ **FLOATING
C83 N3__N1.t0 VGND 0.03538f $ **FLOATING
C84 N3__N1.n5 VGND 0.01455f $ **FLOATING
C85 B.t0 VGND 0.04092f $ **FLOATING
C86 B.t1 VGND 0.04252f $ **FLOATING
C87 B.n0 VGND 3.66327f $ **FLOATING
C88 B.t3 VGND 0.04092f $ **FLOATING
C89 B.n1 VGND 2.7937f $ **FLOATING
C90 B.t2 VGND 0.04252f $ **FLOATING
C91 B.n2 VGND 3.5557f $ **FLOATING
C92 N4__N1.n0 VGND 0.01378f $ **FLOATING
C93 N4__N1.n1 VGND 0.01378f $ **FLOATING
C94 N4__N1.t1 VGND 0.03352f $ **FLOATING
C95 N4__N1.n2 VGND 0.01378f $ **FLOATING
C96 N4__N1.n3 VGND 8.60694f $ **FLOATING
C97 N4__N1.n4 VGND 9.058f $ **FLOATING
C98 N4__N1.t0 VGND 0.03352f $ **FLOATING
C99 N4__N1.n5 VGND 0.01378f $ **FLOATING
C100 N3.n0 VGND 0.00571f $ **FLOATING
C101 N3.t3 VGND 0.02064f $ **FLOATING
C102 N3.t4 VGND 0.02145f $ **FLOATING
C103 N3.n1 VGND 2.11063f $ **FLOATING
C104 N3.n2 VGND 0.005f $ **FLOATING
C105 N3.t2 VGND 0.0153f $ **FLOATING
C106 N3.n3 VGND 0.005f $ **FLOATING
C107 N3.n4 VGND 0.25382f $ **FLOATING
C108 N3.n5 VGND 1.34863f $ **FLOATING
C109 N3.n6 VGND 0.005f $ **FLOATING
C110 N3.t1 VGND 0.0153f $ **FLOATING
C111 N3.n7 VGND 0.005f $ **FLOATING
C112 N3.n8 VGND 0.41299f $ **FLOATING
C113 N3.n9 VGND 4.64823f $ **FLOATING
C114 N3.n10 VGND 0.25382f $ **FLOATING
C115 N3.t0 VGND 0.01388f $ **FLOATING
C116 N3.n11 VGND 0.00571f $ **FLOATING
C117 N2__N1.n0 VGND 0.01363f $ **FLOATING
C118 N2__N1.n1 VGND 0.01363f $ **FLOATING
C119 N2__N1.t1 VGND 0.03314f $ **FLOATING
C120 N2__N1.n2 VGND 0.01363f $ **FLOATING
C121 N2__N1.n3 VGND 4.45589f $ **FLOATING
C122 N2__N1.n4 VGND 4.71056f $ **FLOATING
C123 N2__N1.t0 VGND 0.03314f $ **FLOATING
C124 N2__N1.n5 VGND 0.01363f $ **FLOATING
C125 N2.n0 VGND 0.00974f $ **FLOATING
C126 N2.t4 VGND 0.04023f $ **FLOATING
C127 N2.t3 VGND 0.04181f $ **FLOATING
C128 N2.n1 VGND 4.51602f $ **FLOATING
C129 N2.n2 VGND 0.00974f $ **FLOATING
C130 N2.t2 VGND 0.02982f $ **FLOATING
C131 N2.n3 VGND 0.00974f $ **FLOATING
C132 N2.n4 VGND 0.38803f $ **FLOATING
C133 N2.n5 VGND 3.264f $ **FLOATING
C134 N2.n6 VGND 0.01112f $ **FLOATING
C135 N2.t1 VGND 0.02705f $ **FLOATING
C136 N2.n7 VGND 0.01112f $ **FLOATING
C137 N2.n8 VGND 0.38803f $ **FLOATING
C138 N2.n9 VGND 6.02527f $ **FLOATING
C139 N2.n10 VGND 0.60101f $ **FLOATING
C140 N2.t0 VGND 0.02982f $ **FLOATING
C141 N2.n11 VGND 0.00974f $ **FLOATING
C142 N1__N1.n0 VGND 0.00859f $ **FLOATING
C143 N1__N1.n1 VGND 0.00859f $ **FLOATING
C144 N1__N1.t1 VGND 0.02089f $ **FLOATING
C145 N1__N1.n2 VGND 0.00859f $ **FLOATING
C146 N1__N1.n3 VGND 1.61982f $ **FLOATING
C147 N1__N1.n4 VGND 1.69599f $ **FLOATING
C148 N1__N1.t0 VGND 0.02089f $ **FLOATING
C149 N1__N1.n5 VGND 0.00859f $ **FLOATING
C150 N1.n0 VGND 0.00928f $ **FLOATING
C151 N1.t6 VGND 0.03836f $ **FLOATING
C152 N1.t5 VGND 0.03986f $ **FLOATING
C153 N1.n1 VGND 2.94316f $ **FLOATING
C154 N1.t3 VGND 0.03836f $ **FLOATING
C155 N1.n2 VGND 2.01069f $ **FLOATING
C156 N1.t4 VGND 0.03986f $ **FLOATING
C157 N1.n3 VGND 2.52758f $ **FLOATING
C158 N1.n4 VGND 0.00928f $ **FLOATING
C159 N1.t2 VGND 0.02843f $ **FLOATING
C160 N1.n5 VGND 0.00928f $ **FLOATING
C161 N1.n6 VGND 0.33651f $ **FLOATING
C162 N1.n7 VGND 2.34427f $ **FLOATING
C163 N1.n8 VGND 0.01061f $ **FLOATING
C164 N1.t1 VGND 0.02579f $ **FLOATING
C165 N1.n9 VGND 0.01061f $ **FLOATING
C166 N1.n10 VGND 0.33651f $ **FLOATING
C167 N1.n11 VGND 3.03483f $ **FLOATING
C168 N1.n12 VGND 0.42483f $ **FLOATING
C169 N1.t0 VGND 0.02843f $ **FLOATING
C170 N1.n13 VGND 0.00928f $ **FLOATING
C171 A.t1 VGND 0.04117f $ **FLOATING
C172 A.t3 VGND 0.04278f $ **FLOATING
C173 A.n0 VGND 2.64627f $ **FLOATING
C174 A.t0 VGND 0.04117f $ **FLOATING
C175 A.n1 VGND 1.89994f $ **FLOATING
C176 A.t2 VGND 0.04278f $ **FLOATING
C177 A.n2 VGND 2.30953f $ **FLOATING
.ends

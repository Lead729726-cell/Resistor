* NGSPICE file created from cell_nand2.ext - technology: sky130A

.subckt cell_nand2 Y VPWR VGND A1 A0
X0 N1.t1 A0.t0 Y.t1 VGND.t2 sky130_fd_pr__nfet_01v8 ad=0.1885 pd=1.88 as=0.1885 ps=1.88 w=0.65 l=0.15
X1 VGND.t1 A1.t0 N1.t0 VGND.t0 sky130_fd_pr__nfet_01v8 ad=0.1885 pd=1.88 as=0.1885 ps=1.88 w=0.65 l=0.15
X2 VPWR.t1 A1.t1 Y.t0 VPWR.t0 sky130_fd_pr__pfet_01v8_hvt ad=0.1885 pd=1.88 as=0.1885 ps=1.88 w=0.65 l=0.15
X3 VPWR.t3 A0.t1 Y.t2 VPWR.t2 sky130_fd_pr__pfet_01v8_hvt ad=0.1885 pd=1.88 as=0.1885 ps=1.88 w=0.65 l=0.15
C0 A0 Y 1.71746f
C1 N1 A1 2.6595f
C2 VPWR A0 0.43986f
C3 N1 Y 1.94216f
C4 N1 VPWR 0.02126f
C5 A1 Y 0.12228f
C6 N1 A0 0.7039f
C7 VPWR A1 0.42007f
C8 VPWR Y 0.52747f
C9 A1 A0 0.0325f
R0 A0 A0.t1 330.341
R1 A0 A0.t0 315.88
R2 A0.n0 A0 29.9353
R3 A0.n0 A0 29.3671
R4 A0 A0.n0 5.17104
R5 Y.t2 Y.n7 700.484
R6 Y.n8 Y.t2 700.484
R7 Y.t0 Y.n0 700.484
R8 Y.n1 Y.t0 700.484
R9 Y.t1 Y.n3 255.345
R10 Y.n4 Y.t1 255.345
R11 Y Y.n3 12.8005
R12 Y.n4 Y 12.8005
R13 Y Y.n0 12.8005
R14 Y.n1 Y 12.8005
R15 Y Y.n7 12.8005
R16 Y.n8 Y 12.8005
R17 Y.n6 Y.n2 11.0047
R18 Y.n6 Y.n5 10.4521
R19 Y.n10 Y.n9 10.4521
R20 Y.n5 Y.n3 10.1513
R21 Y.n5 Y.n4 10.1513
R22 Y.n2 Y.n0 10.1513
R23 Y.n2 Y.n1 10.1513
R24 Y.n9 Y.n7 10.1513
R25 Y.n9 Y.n8 10.1513
R26 Y Y.n10 4.22948
R27 Y.n10 Y.n6 0.553142
R28 N1.t1 N1.n1 255.345
R29 N1.n2 N1.t1 255.345
R30 N1.t0 N1.n0 255.345
R31 N1.n5 N1.t0 255.345
R32 N1.n4 N1.n3 22.6543
R33 N1 N1.n1 12.8005
R34 N1.n2 N1 12.8005
R35 N1 N1.n0 12.8005
R36 N1 N1.n5 12.8005
R37 N1.n3 N1.n1 10.1513
R38 N1.n3 N1.n2 10.1513
R39 N1.n4 N1.n0 10.1513
R40 N1.n5 N1.n4 10.1513
R41 VGND.n50 VGND.n43 3946.74
R42 VGND.n31 VGND.n21 1315.26
R43 VGND.n41 VGND.n17 1315.26
R44 VGND.n33 VGND.n19 1315.26
R45 VGND.n35 VGND.n34 1315.26
R46 VGND.n52 VGND.n10 1315.26
R47 VGND.n63 VGND.n11 1315.26
R48 VGND.n65 VGND.n8 1315.26
R49 VGND.n47 VGND.n7 1315.26
R50 VGND.n41 VGND.n40 585
R51 VGND.n39 VGND.n16 585
R52 VGND.n38 VGND.n37 585
R53 VGND.n36 VGND.n35 585
R54 VGND.n34 VGND.n1 585
R55 VGND.n34 VGND.n14 585
R56 VGND.n33 VGND.n0 585
R57 VGND.n33 VGND.n32 585
R58 VGND.n22 VGND.n19 585
R59 VGND.n26 VGND.n23 585
R60 VGND.n28 VGND.n27 585
R61 VGND.n29 VGND.n21 585
R62 VGND.n31 VGND.n30 585
R63 VGND.n32 VGND.n31 585
R64 VGND.n18 VGND.n17 585
R65 VGND.n17 VGND.n14 585
R66 VGND.n47 VGND.n46 585
R67 VGND.n45 VGND.n44 585
R68 VGND.n13 VGND.n12 585
R69 VGND.n53 VGND.n52 585
R70 VGND.n54 VGND.n10 585
R71 VGND.n49 VGND.n10 585
R72 VGND.n63 VGND.n62 585
R73 VGND.n64 VGND.n63 585
R74 VGND.n61 VGND.n11 585
R75 VGND.n60 VGND.n59 585
R76 VGND.n57 VGND.n55 585
R77 VGND.n8 VGND.n6 585
R78 VGND.n66 VGND.n65 585
R79 VGND.n65 VGND.n64 585
R80 VGND.n7 VGND.n5 585
R81 VGND.n49 VGND.n7 585
R82 VGND.n31 VGND.n17 394
R83 VGND.n27 VGND.n26 394
R84 VGND.n34 VGND.n33 394
R85 VGND.n37 VGND.n16 394
R86 VGND.n63 VGND.n10 394
R87 VGND.n59 VGND.n57 394
R88 VGND.n65 VGND.n7 394
R89 VGND.n44 VGND.n13 394
R90 VGND.t1 VGND.n2 255.345
R91 VGND.n3 VGND.t1 255.345
R92 VGND.n43 VGND.n42 218.815
R93 VGND.n43 VGND.n15 218.815
R94 VGND.n25 VGND.n20 218.815
R95 VGND.n24 VGND.n20 218.815
R96 VGND.n50 VGND.n48 218.815
R97 VGND.n51 VGND.n50 218.815
R98 VGND.n58 VGND.n9 218.815
R99 VGND.n56 VGND.n9 218.815
R100 VGND.n32 VGND.n20 187.62
R101 VGND.n43 VGND.n14 187.62
R102 VGND.n50 VGND.n49 187.62
R103 VGND.n64 VGND.n9 187.62
R104 VGND.n27 VGND.n24 147.374
R105 VGND.n25 VGND.n19 147.374
R106 VGND.n42 VGND.n41 147.374
R107 VGND.n35 VGND.n15 147.374
R108 VGND.n42 VGND.n16 147.374
R109 VGND.n37 VGND.n15 147.374
R110 VGND.n26 VGND.n25 147.374
R111 VGND.n24 VGND.n21 147.374
R112 VGND.n58 VGND.n11 147.374
R113 VGND.n56 VGND.n8 147.374
R114 VGND.n52 VGND.n51 147.374
R115 VGND.n48 VGND.n44 147.374
R116 VGND.n48 VGND.n47 147.374
R117 VGND.n51 VGND.n13 147.374
R118 VGND.n59 VGND.n58 147.374
R119 VGND.n57 VGND.n56 147.374
R120 VGND.n30 VGND.n29 85.4593
R121 VGND.n40 VGND.n18 85.4593
R122 VGND.n22 VGND.n0 85.4593
R123 VGND.n36 VGND.n1 85.4593
R124 VGND.n54 VGND.n53 85.4593
R125 VGND.n46 VGND.n5 85.4593
R126 VGND.n62 VGND.n61 85.4593
R127 VGND.n66 VGND.n6 85.4593
R128 VGND.n32 VGND.t0 51.4448
R129 VGND.t0 VGND.n14 51.4448
R130 VGND.n49 VGND.t2 51.4448
R131 VGND.n64 VGND.t2 51.4448
R132 VGND.n30 VGND.n18 25.6005
R133 VGND.n29 VGND.n28 25.6005
R134 VGND.n28 VGND.n23 25.6005
R135 VGND.n23 VGND.n22 25.6005
R136 VGND.n40 VGND.n39 25.6005
R137 VGND.n39 VGND.n38 25.6005
R138 VGND.n38 VGND.n36 25.6005
R139 VGND.n53 VGND.n12 25.6005
R140 VGND.n45 VGND.n12 25.6005
R141 VGND.n46 VGND.n45 25.6005
R142 VGND.n62 VGND.n54 25.6005
R143 VGND.n61 VGND.n60 25.6005
R144 VGND.n60 VGND.n55 25.6005
R145 VGND.n55 VGND.n6 25.6005
R146 VGND VGND.n68 18.3598
R147 VGND.n67 VGND 18.3598
R148 VGND VGND.n2 12.8005
R149 VGND.n3 VGND 12.8005
R150 VGND VGND.n0 12.8005
R151 VGND VGND.n1 12.8005
R152 VGND VGND.n5 12.8005
R153 VGND VGND.n66 12.8005
R154 VGND.n4 VGND.n2 10.1513
R155 VGND.n4 VGND.n3 10.1513
R156 VGND.n68 VGND.n4 10.1294
R157 VGND.n67 VGND 5.15812
R158 VGND.n68 VGND.n67 1.10578
R159 A1 A1.t1 330.341
R160 A1 A1.t0 315.88
R161 A1.n0 A1 31.1853
R162 A1.n0 A1 30.6171
R163 A1 A1.n0 6.13533
R164 VPWR.n20 VPWR.n8 832.942
R165 VPWR.n31 VPWR.n9 832.942
R166 VPWR.n33 VPWR.n6 832.942
R167 VPWR.n15 VPWR.n5 832.942
R168 VPWR.n57 VPWR.n45 832.942
R169 VPWR.n68 VPWR.n46 832.942
R170 VPWR.n70 VPWR.n43 832.942
R171 VPWR.n52 VPWR.n42 832.942
R172 VPWR.t3 VPWR.n36 700.484
R173 VPWR.n37 VPWR.t3 700.484
R174 VPWR.t1 VPWR.n0 700.484
R175 VPWR.n1 VPWR.t1 700.484
R176 VPWR.n31 VPWR.n8 240
R177 VPWR.n27 VPWR.n25 240
R178 VPWR.n33 VPWR.n5 240
R179 VPWR.n12 VPWR.n11 240
R180 VPWR.n68 VPWR.n45 240
R181 VPWR.n64 VPWR.n62 240
R182 VPWR.n70 VPWR.n42 240
R183 VPWR.n49 VPWR.n48 240
R184 VPWR.n18 VPWR.n17 207.394
R185 VPWR.n32 VPWR.n7 207.394
R186 VPWR.n55 VPWR.n54 207.394
R187 VPWR.n69 VPWR.n44 207.394
R188 VPWR.n15 VPWR.n14 185
R189 VPWR.n13 VPWR.n12 185
R190 VPWR.n11 VPWR.n10 185
R191 VPWR.n21 VPWR.n20 185
R192 VPWR.n22 VPWR.n8 185
R193 VPWR.n17 VPWR.n8 185
R194 VPWR.n31 VPWR.n30 185
R195 VPWR.n32 VPWR.n31 185
R196 VPWR.n29 VPWR.n9 185
R197 VPWR.n28 VPWR.n27 185
R198 VPWR.n25 VPWR.n23 185
R199 VPWR.n6 VPWR.n4 185
R200 VPWR.n34 VPWR.n33 185
R201 VPWR.n33 VPWR.n32 185
R202 VPWR.n5 VPWR.n3 185
R203 VPWR.n17 VPWR.n5 185
R204 VPWR.n52 VPWR.n51 185
R205 VPWR.n50 VPWR.n49 185
R206 VPWR.n48 VPWR.n47 185
R207 VPWR.n58 VPWR.n57 185
R208 VPWR.n59 VPWR.n45 185
R209 VPWR.n54 VPWR.n45 185
R210 VPWR.n68 VPWR.n67 185
R211 VPWR.n69 VPWR.n68 185
R212 VPWR.n66 VPWR.n46 185
R213 VPWR.n65 VPWR.n64 185
R214 VPWR.n62 VPWR.n60 185
R215 VPWR.n43 VPWR.n41 185
R216 VPWR.n71 VPWR.n70 185
R217 VPWR.n70 VPWR.n69 185
R218 VPWR.n42 VPWR.n40 185
R219 VPWR.n54 VPWR.n42 185
R220 VPWR.n22 VPWR.n21 88.8476
R221 VPWR.n14 VPWR.n3 88.8476
R222 VPWR.n30 VPWR.n29 88.8476
R223 VPWR.n34 VPWR.n4 88.8476
R224 VPWR.n59 VPWR.n58 88.8476
R225 VPWR.n51 VPWR.n40 88.8476
R226 VPWR.n67 VPWR.n66 88.8476
R227 VPWR.n71 VPWR.n41 88.8476
R228 VPWR.n26 VPWR.n9 72.7879
R229 VPWR.n24 VPWR.n6 72.7879
R230 VPWR.n20 VPWR.n19 72.7879
R231 VPWR.n16 VPWR.n12 72.7879
R232 VPWR.n16 VPWR.n15 72.7879
R233 VPWR.n19 VPWR.n11 72.7879
R234 VPWR.n27 VPWR.n26 72.7879
R235 VPWR.n25 VPWR.n24 72.7879
R236 VPWR.n63 VPWR.n46 72.7879
R237 VPWR.n61 VPWR.n43 72.7879
R238 VPWR.n57 VPWR.n56 72.7879
R239 VPWR.n53 VPWR.n49 72.7879
R240 VPWR.n53 VPWR.n52 72.7879
R241 VPWR.n56 VPWR.n48 72.7879
R242 VPWR.n64 VPWR.n63 72.7879
R243 VPWR.n62 VPWR.n61 72.7879
R244 VPWR.n17 VPWR.t0 56.8667
R245 VPWR.n32 VPWR.t0 56.8667
R246 VPWR.n54 VPWR.t2 56.8667
R247 VPWR.n69 VPWR.t2 56.8667
R248 VPWR.n18 VPWR.n16 56.1076
R249 VPWR.n19 VPWR.n18 56.1076
R250 VPWR.n26 VPWR.n7 56.1076
R251 VPWR.n24 VPWR.n7 56.1076
R252 VPWR.n55 VPWR.n53 56.1076
R253 VPWR.n56 VPWR.n55 56.1076
R254 VPWR.n63 VPWR.n44 56.1076
R255 VPWR.n61 VPWR.n44 56.1076
R256 VPWR.n21 VPWR.n10 25.6005
R257 VPWR.n13 VPWR.n10 25.6005
R258 VPWR.n14 VPWR.n13 25.6005
R259 VPWR.n30 VPWR.n22 25.6005
R260 VPWR.n29 VPWR.n28 25.6005
R261 VPWR.n28 VPWR.n23 25.6005
R262 VPWR.n23 VPWR.n4 25.6005
R263 VPWR.n58 VPWR.n47 25.6005
R264 VPWR.n50 VPWR.n47 25.6005
R265 VPWR.n51 VPWR.n50 25.6005
R266 VPWR.n67 VPWR.n59 25.6005
R267 VPWR.n66 VPWR.n65 25.6005
R268 VPWR.n65 VPWR.n60 25.6005
R269 VPWR.n60 VPWR.n41 25.6005
R270 VPWR.n35 VPWR 18.865
R271 VPWR.n72 VPWR 18.865
R272 VPWR VPWR.n36 12.8005
R273 VPWR.n37 VPWR 12.8005
R274 VPWR VPWR.n0 12.8005
R275 VPWR.n1 VPWR 12.8005
R276 VPWR VPWR.n3 12.8005
R277 VPWR VPWR.n34 12.8005
R278 VPWR VPWR.n40 12.8005
R279 VPWR VPWR.n71 12.8005
R280 VPWR.n35 VPWR.n2 10.6503
R281 VPWR.n39 VPWR.n38 10.5563
R282 VPWR.n38 VPWR.n36 10.1513
R283 VPWR.n38 VPWR.n37 10.1513
R284 VPWR.n2 VPWR.n0 10.1513
R285 VPWR.n2 VPWR.n1 10.1513
R286 VPWR VPWR.n72 4.46447
R287 VPWR.n39 VPWR.n35 1.01178
R288 VPWR.n72 VPWR.n39 0.0945
C10 A1 VGND 4.38811f
C11 Y VGND 1.962f
C12 A0 VGND 2.46062f
C13 VPWR VGND 6.78517f
C14 N1 VGND 2.04611f $ **FLOATING
C15 A1.t0 VGND 0.02192f $ **FLOATING
C16 A1.t1 VGND 0.02278f $ **FLOATING
C17 A1.n0 VGND 2.1849f $ **FLOATING
C18 N1.n0 VGND 0.00702f $ **FLOATING
C19 N1.n1 VGND 0.00702f $ **FLOATING
C20 N1.t1 VGND 0.01706f $ **FLOATING
C21 N1.n2 VGND 0.00702f $ **FLOATING
C22 N1.n3 VGND 1.33892f $ **FLOATING
C23 N1.n4 VGND 1.29234f $ **FLOATING
C24 N1.t0 VGND 0.01706f $ **FLOATING
C25 N1.n5 VGND 0.00702f $ **FLOATING
.ends

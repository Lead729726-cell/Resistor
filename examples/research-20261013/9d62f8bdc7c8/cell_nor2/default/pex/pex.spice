* NGSPICE file created from cell_nor2.ext - technology: sky130A

.subckt cell_nor2 Y VPWR B VGND A
X0 VGND.t3 A.t0 Y.t2 VGND.t2 sky130_fd_pr__nfet_01v8 ad=0.1885 pd=1.88 as=0.1885 ps=1.88 w=0.65 l=0.15
X1 VGND.t1 B.t0 Y.t1 VGND.t0 sky130_fd_pr__nfet_01v8 ad=0.1885 pd=1.88 as=0.1885 ps=1.88 w=0.65 l=0.15
X2 N.t0 B.t1 Y.t0 VPWR.t0 sky130_fd_pr__pfet_01v8_hvt ad=0.1885 pd=1.88 as=0.1885 ps=1.88 w=0.65 l=0.15
X3 VPWR.t2 A.t1 N.t1 VPWR.t1 sky130_fd_pr__pfet_01v8_hvt ad=0.1885 pd=1.88 as=0.1885 ps=1.88 w=0.65 l=0.15
C0 A B 0.27151f
C1 N Y 0.33489f
C2 VPWR A 0.42211f
C3 N B 0.51683f
C4 N VPWR 0.42312f
C5 Y B 2.48873f
C6 N A 1.66442f
C7 VPWR Y 0.15171f
C8 VPWR B 0.32156f
C9 Y A 2.25481f
R0 A A.t1 330.341
R1 A A.t0 315.88
R2 A.n0 A 30.9089
R3 A.n0 A 29.7837
R4 A A.n0 5.17104
R5 Y.t0 Y.n7 700.484
R6 Y.n8 Y.t0 700.484
R7 Y.t2 Y.n3 255.345
R8 Y.n4 Y.t2 255.345
R9 Y.t1 Y.n0 255.345
R10 Y.n1 Y.t1 255.345
R11 Y Y.n3 12.8005
R12 Y.n4 Y 12.8005
R13 Y Y.n0 12.8005
R14 Y.n1 Y 12.8005
R15 Y Y.n7 12.8005
R16 Y.n8 Y 12.8005
R17 Y.n6 Y.n2 11.4171
R18 Y.n6 Y.n5 10.8688
R19 Y.n10 Y.n9 10.8688
R20 Y.n5 Y.n3 10.1513
R21 Y.n5 Y.n4 10.1513
R22 Y.n2 Y.n0 10.1513
R23 Y.n2 Y.n1 10.1513
R24 Y.n9 Y.n7 10.1513
R25 Y.n9 Y.n8 10.1513
R26 Y Y.n10 4.78642
R27 Y.n10 Y.n6 0.553142
R28 VGND.n49 VGND.n47 1640.17
R29 VGND.n57 VGND.n9 1315.26
R30 VGND.n68 VGND.n10 1315.26
R31 VGND.n52 VGND.n6 1315.26
R32 VGND.n70 VGND.n7 1315.26
R33 VGND.n35 VGND.n25 1315.26
R34 VGND.n45 VGND.n15 1315.26
R35 VGND.n39 VGND.n38 1315.26
R36 VGND.n37 VGND.n18 1315.26
R37 VGND.n66 VGND.n10 585
R38 VGND.n65 VGND.n64 585
R39 VGND.n62 VGND.n60 585
R40 VGND.n7 VGND.n5 585
R41 VGND.n71 VGND.n70 585
R42 VGND.n70 VGND.n69 585
R43 VGND.n6 VGND.n4 585
R44 VGND.n48 VGND.n6 585
R45 VGND.n52 VGND.n51 585
R46 VGND.n54 VGND.n50 585
R47 VGND.n55 VGND.n11 585
R48 VGND.n58 VGND.n57 585
R49 VGND.n59 VGND.n9 585
R50 VGND.n48 VGND.n9 585
R51 VGND.n68 VGND.n67 585
R52 VGND.n69 VGND.n68 585
R53 VGND.n26 VGND.n18 585
R54 VGND.n29 VGND.n27 585
R55 VGND.n32 VGND.n31 585
R56 VGND.n33 VGND.n25 585
R57 VGND.n35 VGND.n34 585
R58 VGND.n36 VGND.n35 585
R59 VGND.n16 VGND.n15 585
R60 VGND.n15 VGND.n12 585
R61 VGND.n45 VGND.n44 585
R62 VGND.n43 VGND.n14 585
R63 VGND.n42 VGND.n41 585
R64 VGND.n40 VGND.n39 585
R65 VGND.n38 VGND.n17 585
R66 VGND.n38 VGND.n12 585
R67 VGND.n37 VGND.n23 585
R68 VGND.n37 VGND.n36 585
R69 VGND.n68 VGND.n9 394
R70 VGND.n55 VGND.n54 394
R71 VGND.n70 VGND.n6 394
R72 VGND.n64 VGND.n62 394
R73 VGND.n35 VGND.n15 394
R74 VGND.n41 VGND.n14 394
R75 VGND.n38 VGND.n37 394
R76 VGND.n31 VGND.n29 394
R77 VGND.t3 VGND.n0 255.345
R78 VGND.n1 VGND.t3 255.345
R79 VGND.t1 VGND.n19 255.345
R80 VGND.n20 VGND.t1 255.345
R81 VGND.n63 VGND.n8 218.815
R82 VGND.n61 VGND.n8 218.815
R83 VGND.n53 VGND.n49 218.815
R84 VGND.n56 VGND.n49 218.815
R85 VGND.n28 VGND.n24 218.815
R86 VGND.n30 VGND.n24 218.815
R87 VGND.n47 VGND.n46 218.815
R88 VGND.n47 VGND.n13 218.815
R89 VGND.n36 VGND.n24 187.62
R90 VGND.n47 VGND.n12 187.62
R91 VGND.n49 VGND.n48 187.62
R92 VGND.n69 VGND.n8 187.62
R93 VGND.n56 VGND.n55 147.374
R94 VGND.n53 VGND.n52 147.374
R95 VGND.n63 VGND.n10 147.374
R96 VGND.n61 VGND.n7 147.374
R97 VGND.n64 VGND.n63 147.374
R98 VGND.n62 VGND.n61 147.374
R99 VGND.n54 VGND.n53 147.374
R100 VGND.n57 VGND.n56 147.374
R101 VGND.n46 VGND.n45 147.374
R102 VGND.n39 VGND.n13 147.374
R103 VGND.n30 VGND.n25 147.374
R104 VGND.n29 VGND.n28 147.374
R105 VGND.n28 VGND.n18 147.374
R106 VGND.n31 VGND.n30 147.374
R107 VGND.n46 VGND.n14 147.374
R108 VGND.n41 VGND.n13 147.374
R109 VGND.n59 VGND.n58 85.4593
R110 VGND.n67 VGND.n66 85.4593
R111 VGND.n51 VGND.n4 85.4593
R112 VGND.n71 VGND.n5 85.4593
R113 VGND.n34 VGND.n33 85.4593
R114 VGND.n26 VGND.n23 85.4593
R115 VGND.n44 VGND.n16 85.4593
R116 VGND.n40 VGND.n17 85.4593
R117 VGND.n36 VGND.t0 51.4448
R118 VGND.t0 VGND.n12 51.4448
R119 VGND.n48 VGND.t2 51.4448
R120 VGND.n69 VGND.t2 51.4448
R121 VGND.n67 VGND.n59 25.6005
R122 VGND.n58 VGND.n11 25.6005
R123 VGND.n50 VGND.n11 25.6005
R124 VGND.n51 VGND.n50 25.6005
R125 VGND.n66 VGND.n65 25.6005
R126 VGND.n65 VGND.n60 25.6005
R127 VGND.n60 VGND.n5 25.6005
R128 VGND.n33 VGND.n32 25.6005
R129 VGND.n32 VGND.n27 25.6005
R130 VGND.n27 VGND.n26 25.6005
R131 VGND.n34 VGND.n16 25.6005
R132 VGND.n44 VGND.n43 25.6005
R133 VGND.n43 VGND.n42 25.6005
R134 VGND.n42 VGND.n40 25.6005
R135 VGND.n72 VGND 18.3598
R136 VGND VGND.n22 18.3598
R137 VGND VGND.n19 12.8005
R138 VGND.n20 VGND 12.8005
R139 VGND VGND.n4 12.8005
R140 VGND VGND.n71 12.8005
R141 VGND.n23 VGND 12.8005
R142 VGND VGND.n17 12.8005
R143 VGND VGND.n0 12.8005
R144 VGND.n1 VGND 12.8005
R145 VGND.n21 VGND.n19 10.1513
R146 VGND.n21 VGND.n20 10.1513
R147 VGND.n2 VGND.n0 10.1513
R148 VGND.n2 VGND.n1 10.1513
R149 VGND.n22 VGND.n21 10.1294
R150 VGND.n3 VGND.n2 10.0354
R151 VGND VGND.n72 5.71507
R152 VGND.n22 VGND.n3 0.454833
R153 VGND.n72 VGND.n3 0.0945
R154 B B.t1 330.341
R155 B B.t0 315.88
R156 B.n0 B 31.7337
R157 B.n0 B 30.6171
R158 B B.n0 5.58699
R159 N.t1 N.n1 700.484
R160 N.n2 N.t1 700.484
R161 N.t0 N.n0 700.484
R162 N.n5 N.t0 700.484
R163 N.n4 N.n3 20.8153
R164 N N.n1 12.8005
R165 N.n2 N 12.8005
R166 N N.n0 12.8005
R167 N N.n5 12.8005
R168 N.n3 N.n1 10.1513
R169 N.n3 N.n2 10.1513
R170 N.n4 N.n0 10.1513
R171 N.n5 N.n4 10.1513
R172 VPWR.n17 VPWR.n5 832.942
R173 VPWR.n28 VPWR.n6 832.942
R174 VPWR.n30 VPWR.n3 832.942
R175 VPWR.n12 VPWR.n2 832.942
R176 VPWR.n53 VPWR.n41 832.942
R177 VPWR.n64 VPWR.n42 832.942
R178 VPWR.n66 VPWR.n39 832.942
R179 VPWR.n48 VPWR.n38 832.942
R180 VPWR.t2 VPWR.n32 700.484
R181 VPWR.n33 VPWR.t2 700.484
R182 VPWR.n28 VPWR.n5 240
R183 VPWR.n24 VPWR.n22 240
R184 VPWR.n30 VPWR.n2 240
R185 VPWR.n9 VPWR.n8 240
R186 VPWR.n64 VPWR.n41 240
R187 VPWR.n60 VPWR.n58 240
R188 VPWR.n66 VPWR.n38 240
R189 VPWR.n45 VPWR.n44 240
R190 VPWR.n15 VPWR.n14 207.394
R191 VPWR.n29 VPWR.n4 207.394
R192 VPWR.n51 VPWR.n50 207.394
R193 VPWR.n65 VPWR.n40 207.394
R194 VPWR.n12 VPWR.n11 185
R195 VPWR.n10 VPWR.n9 185
R196 VPWR.n8 VPWR.n7 185
R197 VPWR.n18 VPWR.n17 185
R198 VPWR.n19 VPWR.n5 185
R199 VPWR.n14 VPWR.n5 185
R200 VPWR.n28 VPWR.n27 185
R201 VPWR.n29 VPWR.n28 185
R202 VPWR.n26 VPWR.n6 185
R203 VPWR.n25 VPWR.n24 185
R204 VPWR.n22 VPWR.n20 185
R205 VPWR.n3 VPWR.n1 185
R206 VPWR.n31 VPWR.n30 185
R207 VPWR.n30 VPWR.n29 185
R208 VPWR.n2 VPWR.n0 185
R209 VPWR.n14 VPWR.n2 185
R210 VPWR.n48 VPWR.n47 185
R211 VPWR.n46 VPWR.n45 185
R212 VPWR.n44 VPWR.n43 185
R213 VPWR.n54 VPWR.n53 185
R214 VPWR.n55 VPWR.n41 185
R215 VPWR.n50 VPWR.n41 185
R216 VPWR.n64 VPWR.n63 185
R217 VPWR.n65 VPWR.n64 185
R218 VPWR.n62 VPWR.n42 185
R219 VPWR.n61 VPWR.n60 185
R220 VPWR.n58 VPWR.n56 185
R221 VPWR.n39 VPWR.n37 185
R222 VPWR.n67 VPWR.n66 185
R223 VPWR.n66 VPWR.n65 185
R224 VPWR.n38 VPWR.n36 185
R225 VPWR.n50 VPWR.n38 185
R226 VPWR.n19 VPWR.n18 88.8476
R227 VPWR.n11 VPWR.n0 88.8476
R228 VPWR.n27 VPWR.n26 88.8476
R229 VPWR.n31 VPWR.n1 88.8476
R230 VPWR.n55 VPWR.n54 88.8476
R231 VPWR.n47 VPWR.n36 88.8476
R232 VPWR.n63 VPWR.n62 88.8476
R233 VPWR.n67 VPWR.n37 88.8476
R234 VPWR.n23 VPWR.n6 72.7879
R235 VPWR.n21 VPWR.n3 72.7879
R236 VPWR.n17 VPWR.n16 72.7879
R237 VPWR.n13 VPWR.n9 72.7879
R238 VPWR.n13 VPWR.n12 72.7879
R239 VPWR.n16 VPWR.n8 72.7879
R240 VPWR.n24 VPWR.n23 72.7879
R241 VPWR.n22 VPWR.n21 72.7879
R242 VPWR.n59 VPWR.n42 72.7879
R243 VPWR.n57 VPWR.n39 72.7879
R244 VPWR.n53 VPWR.n52 72.7879
R245 VPWR.n49 VPWR.n45 72.7879
R246 VPWR.n49 VPWR.n48 72.7879
R247 VPWR.n52 VPWR.n44 72.7879
R248 VPWR.n60 VPWR.n59 72.7879
R249 VPWR.n58 VPWR.n57 72.7879
R250 VPWR.n14 VPWR.t0 56.8667
R251 VPWR.n29 VPWR.t0 56.8667
R252 VPWR.n50 VPWR.t1 56.8667
R253 VPWR.n65 VPWR.t1 56.8667
R254 VPWR.n15 VPWR.n13 56.1076
R255 VPWR.n16 VPWR.n15 56.1076
R256 VPWR.n23 VPWR.n4 56.1076
R257 VPWR.n21 VPWR.n4 56.1076
R258 VPWR.n51 VPWR.n49 56.1076
R259 VPWR.n52 VPWR.n51 56.1076
R260 VPWR.n59 VPWR.n40 56.1076
R261 VPWR.n57 VPWR.n40 56.1076
R262 VPWR.n18 VPWR.n7 25.6005
R263 VPWR.n10 VPWR.n7 25.6005
R264 VPWR.n11 VPWR.n10 25.6005
R265 VPWR.n27 VPWR.n19 25.6005
R266 VPWR.n26 VPWR.n25 25.6005
R267 VPWR.n25 VPWR.n20 25.6005
R268 VPWR.n20 VPWR.n1 25.6005
R269 VPWR.n54 VPWR.n43 25.6005
R270 VPWR.n46 VPWR.n43 25.6005
R271 VPWR.n47 VPWR.n46 25.6005
R272 VPWR.n63 VPWR.n55 25.6005
R273 VPWR.n62 VPWR.n61 25.6005
R274 VPWR.n61 VPWR.n56 25.6005
R275 VPWR.n56 VPWR.n37 25.6005
R276 VPWR.n35 VPWR 19.328
R277 VPWR.n68 VPWR 18.865
R278 VPWR VPWR.n32 12.8005
R279 VPWR.n33 VPWR 12.8005
R280 VPWR VPWR.n0 12.8005
R281 VPWR VPWR.n31 12.8005
R282 VPWR VPWR.n36 12.8005
R283 VPWR VPWR.n67 12.8005
R284 VPWR.n35 VPWR.n34 10.5563
R285 VPWR.n34 VPWR.n32 10.1513
R286 VPWR.n34 VPWR.n33 10.1513
R287 VPWR VPWR.n68 4.46447
R288 VPWR.n68 VPWR.n35 0.0945
C10 Y VGND 2.79746f
C11 B VGND 4.24661f
C12 A VGND 2.67636f
C13 VPWR VGND 5.43412f
C14 N VGND 1.73972f $ **FLOATING
C15 B.t0 VGND 0.0203f $ **FLOATING
C16 B.t1 VGND 0.02109f $ **FLOATING
C17 B.n0 VGND 2.10484f $ **FLOATING
C18 Y.n0 VGND 0.01132f $ **FLOATING
C19 Y.t1 VGND 0.02754f $ **FLOATING
C20 Y.n1 VGND 0.01132f $ **FLOATING
C21 Y.n2 VGND 0.28673f $ **FLOATING
C22 Y.n3 VGND 0.01132f $ **FLOATING
C23 Y.t2 VGND 0.02754f $ **FLOATING
C24 Y.n4 VGND 0.01132f $ **FLOATING
C25 Y.n5 VGND 0.25397f $ **FLOATING
C26 Y.n6 VGND 1.68669f $ **FLOATING
C27 Y.n7 VGND 0.00991f $ **FLOATING
C28 Y.t0 VGND 0.03036f $ **FLOATING
C29 Y.n8 VGND 0.00991f $ **FLOATING
C30 Y.n9 VGND 0.25397f $ **FLOATING
C31 Y.n10 VGND 1.9134f $ **FLOATING
C32 A.t0 VGND 0.02329f $ **FLOATING
C33 A.t1 VGND 0.0242f $ **FLOATING
C34 A.n0 VGND 1.95424f $ **FLOATING
.ends

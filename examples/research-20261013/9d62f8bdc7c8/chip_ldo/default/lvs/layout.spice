* NGSPICE file created from chip_ldo.ext - technology: sky130A

.subckt chip_ldo VREF VPWR VGND OUT BIAS
X0 R_FB_BOTTOM_R0_N0 R_FB_BOTTOM_R0_N1 VGND sky130_fd_pr__res_xhigh_po_1p41 l=28.04
X1 VPWR GATE OUT VPWR sky130_fd_pr__pfet_01v8_hvt ad=5.8 pd=40.58 as=5.8 ps=40.58 w=20 l=0.15
X2 COMP OUT VGND sky130_fd_pr__res_xhigh_po_1p41 l=0.54
X3 R_FB_TOP_R0_N3 FB VGND sky130_fd_pr__res_xhigh_po_1p41 l=28.04
X4 GATE COMP sky130_fd_pr__cap_mim_m3_1 l=28.68 w=28.68
X5 FB R_FB_BOTTOM_R0_N0 VGND sky130_fd_pr__res_xhigh_po_1p41 l=28.04
X6 R_FB_TOP_R0_N1 R_FB_TOP_R0_N2 VGND sky130_fd_pr__res_xhigh_po_1p41 l=28.04
X7 GATE COMP sky130_fd_pr__cap_mim_m3_1 l=28.68 w=28.68
X8 R_FB_BOTTOM_R0_N3 VGND VGND sky130_fd_pr__res_xhigh_po_1p41 l=28.04
X9 GATE COMP sky130_fd_pr__cap_mim_m3_1 l=28.68 w=28.68
X10 VPWR ERROR_AMP__MIR ERROR_AMP__MIR VPWR sky130_fd_pr__pfet_01v8_hvt ad=5.8 pd=40.58 as=5.8 ps=40.58 w=20 l=1
X11 VGND BIAS ERROR_AMP__TAIL VGND sky130_fd_pr__nfet_01v8 ad=0.58 pd=4.58 as=0.58 ps=4.58 w=2 l=1
X12 R_FB_TOP_R0_N2 R_FB_TOP_R0_N3 VGND sky130_fd_pr__res_xhigh_po_1p41 l=28.04
X13 GATE COMP sky130_fd_pr__cap_mim_m3_1 l=28.68 w=28.68
X14 GATE COMP sky130_fd_pr__cap_mim_m3_1 l=28.68 w=28.68
X15 GATE COMP sky130_fd_pr__cap_mim_m3_1 l=28.68 w=28.68
X16 ERROR_AMP__TAIL FB ERROR_AMP__MIR VGND sky130_fd_pr__nfet_01v8 ad=2.9 pd=20.58 as=2.9 ps=20.58 w=10 l=1
X17 R_FB_BOTTOM_R0_N1 R_FB_BOTTOM_R0_N2 VGND sky130_fd_pr__res_xhigh_po_1p41 l=28.04
X18 GATE COMP sky130_fd_pr__cap_mim_m3_1 l=28.68 w=28.68
X19 ERROR_AMP__TAIL VREF GATE VGND sky130_fd_pr__nfet_01v8 ad=2.9 pd=20.58 as=2.9 ps=20.58 w=10 l=1
X20 VPWR ERROR_AMP__MIR GATE VPWR sky130_fd_pr__pfet_01v8_hvt ad=5.8 pd=40.58 as=5.8 ps=40.58 w=20 l=1
X21 R_FB_TOP_R0_N0 R_FB_TOP_R0_N1 VGND sky130_fd_pr__res_xhigh_po_1p41 l=28.04
X22 GATE COMP sky130_fd_pr__cap_mim_m3_1 l=28.68 w=28.68
X23 VPWR GATE OUT VPWR sky130_fd_pr__pfet_01v8_hvt ad=5.8 pd=40.58 as=5.8 ps=40.58 w=20 l=0.15
X24 GATE COMP sky130_fd_pr__cap_mim_m3_1 l=28.68 w=28.68
X25 OUT R_FB_TOP_R0_N0 VGND sky130_fd_pr__res_xhigh_po_1p41 l=28.04
X26 VPWR GATE OUT VPWR sky130_fd_pr__pfet_01v8_hvt ad=5.8 pd=40.58 as=5.8 ps=40.58 w=20 l=0.15
X27 VPWR GATE OUT VPWR sky130_fd_pr__pfet_01v8_hvt ad=5.8 pd=40.58 as=5.8 ps=40.58 w=20 l=0.15
X28 R_FB_BOTTOM_R0_N2 R_FB_BOTTOM_R0_N3 VGND sky130_fd_pr__res_xhigh_po_1p41 l=28.04
X29 GATE COMP sky130_fd_pr__cap_mim_m3_1 l=28.68 w=28.68
X30 GATE COMP sky130_fd_pr__cap_mim_m3_1 l=28.68 w=28.68
X31 VPWR GATE OUT VPWR sky130_fd_pr__pfet_01v8_hvt ad=5.8 pd=40.58 as=5.8 ps=40.58 w=20 l=0.15
X32 GATE COMP sky130_fd_pr__cap_mim_m3_1 l=28.68 w=28.68
.ends

* NGSPICE file created from soc_miller_ota.ext - technology: sky130A

.subckt soc_miller_ota VPWR INP OUT INN VGND BIAS
X0 PRE COMP sky130_fd_pr__cap_mim_m3_1 l=28.68 w=28.68
X1 FIRST__TAIL INN FIRST__MIR VGND sky130_fd_pr__nfet_01v8 ad=1.45 pd=10.58 as=1.45 ps=10.58 w=5 l=1
X2 PRE COMP sky130_fd_pr__cap_mim_m3_1 l=28.68 w=28.68
X3 FIRST__TAIL INP PRE VGND sky130_fd_pr__nfet_01v8 ad=1.45 pd=10.58 as=1.45 ps=10.58 w=5 l=1
X4 COMP OUT VGND sky130_fd_pr__res_xhigh_po_1p41 l=3.36
X5 FIRST__TAIL INP PRE VGND sky130_fd_pr__nfet_01v8 ad=1.45 pd=10.58 as=1.45 ps=10.58 w=5 l=1
X6 VPWR PRE OUT VPWR sky130_fd_pr__pfet_01v8_hvt ad=11.6 pd=80.58 as=11.6 ps=80.58 w=40 l=1
X7 PRE COMP sky130_fd_pr__cap_mim_m3_1 l=28.68 w=28.68
X8 VPWR FIRST__MIR FIRST__MIR VPWR sky130_fd_pr__pfet_01v8_hvt ad=5.8 pd=40.58 as=5.8 ps=40.58 w=20 l=1
X9 FIRST__TAIL INN FIRST__MIR VGND sky130_fd_pr__nfet_01v8 ad=1.45 pd=10.58 as=1.45 ps=10.58 w=5 l=1
X10 VGND BIAS FIRST__TAIL VGND sky130_fd_pr__nfet_01v8 ad=0.58 pd=4.58 as=0.58 ps=4.58 w=2 l=1
X11 VPWR FIRST__MIR PRE VPWR sky130_fd_pr__pfet_01v8_hvt ad=5.8 pd=40.58 as=5.8 ps=40.58 w=20 l=1
X12 VGND BIAS OUT VGND sky130_fd_pr__nfet_01v8 ad=0.58 pd=4.58 as=0.58 ps=4.58 w=2 l=1
.ends

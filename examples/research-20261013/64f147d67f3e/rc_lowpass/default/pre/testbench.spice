Register actual native rc_lowpass
.include "/workspace/.runtime/eda/runs/850f0ed902244c87b80f1c74d40dbce9/supported-tt.spice"
.option scale=1e-6
.include "/workspace/.runtime/eda/runs/850f0ed902244c87b80f1c74d40dbce9/current-probe.spice"
.temp 27.0
VGND VGND 0 0
VIN IN VGND 0 AC 1 PULSE(0 1.8 1e-09 1e-12 1e-12 1 2)
XU IN OUT VGND rc_lowpass
.control
save v(IN) v(OUT) i(v.xu.vregister_cf_14b59466c5db7da9) i(v.xu.vregister_cf_7c48c48dcebfc52e) i(VGND) i(VIN) v(VGND)
set num_threads=1
set noaskquit
set wr_singlescale
set wr_vecnames
tran 1e-10 2e-07
let mos_wave_0 = v(IN)
let mos_wave_1 = v(OUT)
wrdata waveform.dat mos_wave_0 mos_wave_1
write waveform.raw all
let register_flow_0 = i(v.xu.vregister_cf_14b59466c5db7da9)
let register_flow_1 = i(v.xu.vregister_cf_7c48c48dcebfc52e)
let register_flow_2 = i(VGND)
let register_flow_3 = i(VIN)
wrdata current-flow.dat register_flow_0 register_flow_1 register_flow_2 register_flow_3
let register_voltage_0 = v(OUT)
let register_voltage_1 = v(VGND)
let register_voltage_2 = v(IN)
let register_voltage_3 = 0*register_flow_0
wrdata node-voltages.dat register_voltage_0 register_voltage_1 register_voltage_2 register_voltage_3
quit
.endc
.end

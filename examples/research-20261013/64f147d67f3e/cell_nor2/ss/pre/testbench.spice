Resistor public CMOS cell actual input truth matrix
.include "/workspace/.runtime/eda/runs/6dc3c27a86a44b88a05be45a373f9a77/supported-ss.spice"
.option scale=1e-6
.include "/workspace/.runtime/eda/runs/6dc3c27a86a44b88a05be45a373f9a77/current-probe.spice"
.temp 125.0
VGND VGND 0 0
VDD VPWR VGND 1.6
VA A VGND PWL(0 0 5e-08 0 5.1e-08 1.6 1e-07 1.6 1.01e-07 0 1.5e-07 0 1.51e-07 1.6 2e-07 1.6 2.01e-07 0 2.5e-07 0 2.51e-07 1.6 3e-07 1.6 3.01e-07 0 3.5e-07 0 3.51e-07 0 4e-07 0 4.01e-07 1.6 4.5e-07 1.6 4.51e-07 0 5e-07 0 5.01e-07 0 5.5e-07 0 5.51e-07 0 6e-07 0)
VB B VGND PWL(0 0 5e-08 0 5.1e-08 0 1e-07 0 1.01e-07 1.6 1.5e-07 1.6 1.51e-07 1.6 2e-07 1.6 2.01e-07 0 2.5e-07 0 2.51e-07 0 3e-07 0 3.01e-07 0 3.5e-07 0 3.51e-07 1.6 4e-07 1.6 4.01e-07 0 4.5e-07 0 4.51e-07 0 5e-07 0 5.01e-07 1.6 5.5e-07 1.6 5.51e-07 0 6e-07 0)
CLOAD Y VGND 4e-14
XU A B Y VPWR VGND cell_nor2
.control
save v(A) v(B) v(Y) i(VDD) i(v.xu.vregister_cf_cfe2518dd12054ff) i(v.xu.vregister_cf_8dcb0ec41fb007ec) i(v.xu.vregister_cf_1e43f7262c1fb23a) i(v.xu.vregister_cf_09bb3b0f2177dc48) i(VGND) i(VA) i(VB) v(VGND) v(XU.N) v(VPWR)
set numdgt=17
set wr_singlescale
set wr_vecnames
tran 1e-10 6e-07 0 1e-10
let mos_wave_0 = v(A)
let mos_wave_1 = v(B)
let mos_wave_2 = v(Y)
let mos_wave_3 = -i(VDD)
wrdata waveform.dat mos_wave_0 mos_wave_1 mos_wave_2 mos_wave_3
write waveform.raw all
let register_flow_0 = i(v.xu.vregister_cf_cfe2518dd12054ff)
let register_flow_1 = i(v.xu.vregister_cf_8dcb0ec41fb007ec)
let register_flow_2 = i(v.xu.vregister_cf_1e43f7262c1fb23a)
let register_flow_3 = i(v.xu.vregister_cf_09bb3b0f2177dc48)
let register_flow_4 = i(VGND)
let register_flow_5 = i(VDD)
let register_flow_6 = i(VA)
let register_flow_7 = i(VB)
wrdata current-flow.dat register_flow_0 register_flow_1 register_flow_2 register_flow_3 register_flow_4 register_flow_5 register_flow_6 register_flow_7
let register_voltage_0 = v(Y)
let register_voltage_1 = v(VGND)
let register_voltage_2 = v(A)
let register_voltage_3 = v(B)
let register_voltage_4 = v(XU.N)
let register_voltage_5 = v(VPWR)
let register_voltage_6 = 0*register_flow_0
wrdata node-voltages.dat register_voltage_0 register_voltage_1 register_voltage_2 register_voltage_3 register_voltage_4 register_voltage_5 register_voltage_6
quit
.endc
.end

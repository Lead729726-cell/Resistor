Resistor public CMOS cell actual input truth matrix
.include "/workspace/.runtime/eda/runs/6edfc7b961d345b5a75f1dbed1f845af/supported-tt.spice"
.option scale=1e-6
.include "/workspace/.runtime/eda/runs/6edfc7b961d345b5a75f1dbed1f845af/current-probe.spice"
.temp 27.0
VGND VGND 0 0
VDD VPWR VGND 1.8
VA A VGND PWL(0 0 5e-08 0 5.01e-08 1.8 1e-07 1.8 1.001e-07 0 1.5e-07 0 1.501e-07 1.8 2e-07 1.8 2.001e-07 0 2.5e-07 0 2.501e-07 1.8 3e-07 1.8 3.001e-07 0 3.5e-07 0 3.501e-07 0 4e-07 0 4.001e-07 1.8 4.5e-07 1.8 4.501e-07 0 5e-07 0 5.001e-07 0 5.5e-07 0 5.501e-07 0 6e-07 0)
VB B VGND PWL(0 0 5e-08 0 5.01e-08 0 1e-07 0 1.001e-07 1.8 1.5e-07 1.8 1.501e-07 1.8 2e-07 1.8 2.001e-07 0 2.5e-07 0 2.501e-07 0 3e-07 0 3.001e-07 0 3.5e-07 0 3.501e-07 1.8 4e-07 1.8 4.001e-07 0 4.5e-07 0 4.501e-07 0 5e-07 0 5.001e-07 1.8 5.5e-07 1.8 5.501e-07 0 6e-07 0)
CLOAD Y VGND 5e-15
XU Y VPWR VGND B A cell_nor2
.control
save v(A) v(B) v(Y) i(VDD) i(v.xu.vregister_cf_e04c4332effa44b9) i(v.xu.vregister_cf_3a52c45e6ae8d7e3) i(v.xu.vregister_cf_0944a8cd6e6c28dc) i(v.xu.vregister_cf_da7cac648640c3f6) i(VGND) i(VA) i(VB) v(XU.VGND.t3) v(XU.Y.t2) v(XU.A.t0) v(XU.VGND.t2) v(XU.VGND.t1) v(XU.Y.t1) v(XU.B.t0) v(XU.VGND.t0) v(XU.N.t0) v(XU.Y.t0) v(XU.B.t1) v(XU.VPWR.t0) v(XU.VPWR.t2) v(XU.N.t1) v(XU.A.t1) v(XU.VPWR.t1) v(VGND) v(VPWR)
set numdgt=17
set wr_singlescale
set wr_vecnames
tran 1e-11 6e-07 0 1e-11
let mos_wave_0 = v(A)
let mos_wave_1 = v(B)
let mos_wave_2 = v(Y)
let mos_wave_3 = -i(VDD)
wrdata waveform.dat mos_wave_0 mos_wave_1 mos_wave_2 mos_wave_3
write waveform.raw all
let register_flow_0 = i(v.xu.vregister_cf_e04c4332effa44b9)
let register_flow_1 = i(v.xu.vregister_cf_3a52c45e6ae8d7e3)
let register_flow_2 = i(v.xu.vregister_cf_0944a8cd6e6c28dc)
let register_flow_3 = i(v.xu.vregister_cf_da7cac648640c3f6)
let register_flow_4 = i(VGND)
let register_flow_5 = i(VDD)
let register_flow_6 = i(VA)
let register_flow_7 = i(VB)
wrdata current-flow.dat register_flow_0 register_flow_1 register_flow_2 register_flow_3 register_flow_4 register_flow_5 register_flow_6 register_flow_7
let register_voltage_0 = v(XU.VGND.t3)
let register_voltage_1 = v(XU.Y.t2)
let register_voltage_2 = v(XU.A.t0)
let register_voltage_3 = v(XU.VGND.t2)
let register_voltage_4 = v(XU.VGND.t1)
let register_voltage_5 = v(XU.Y.t1)
let register_voltage_6 = v(XU.B.t0)
let register_voltage_7 = v(XU.VGND.t0)
let register_voltage_8 = v(XU.N.t0)
let register_voltage_9 = v(XU.Y.t0)
let register_voltage_10 = v(XU.B.t1)
let register_voltage_11 = v(XU.VPWR.t0)
let register_voltage_12 = v(XU.VPWR.t2)
let register_voltage_13 = v(XU.N.t1)
let register_voltage_14 = v(XU.A.t1)
let register_voltage_15 = v(XU.VPWR.t1)
let register_voltage_16 = v(VGND)
let register_voltage_17 = 0*register_flow_0
let register_voltage_18 = v(VPWR)
let register_voltage_19 = v(A)
let register_voltage_20 = v(B)
wrdata node-voltages.dat register_voltage_0 register_voltage_1 register_voltage_2 register_voltage_3 register_voltage_4 register_voltage_5 register_voltage_6 register_voltage_7 register_voltage_8 register_voltage_9 register_voltage_10 register_voltage_11 register_voltage_12 register_voltage_13 register_voltage_14 register_voltage_15 register_voltage_16 register_voltage_17 register_voltage_18 register_voltage_19 register_voltage_20
quit
.endc
.end

.subckt cell_nor2 A B Y VPWR VGND
XMN0 register_cf_node_cfe2518dd12054ff A register_cf_node_cfe2518dd12054ff_source VGND sky130_fd_pr__nfet_01v8 w=2.6 l=0.15 nf=1 m=1
Vregister_cf_cfe2518dd12054ff Y register_cf_node_cfe2518dd12054ff 0
Vregister_cf_cfe2518dd12054ff_source VGND register_cf_node_cfe2518dd12054ff_source 0
XMN1 register_cf_node_8dcb0ec41fb007ec B register_cf_node_8dcb0ec41fb007ec_source VGND sky130_fd_pr__nfet_01v8 w=2.6 l=0.15 nf=1 m=1
Vregister_cf_8dcb0ec41fb007ec Y register_cf_node_8dcb0ec41fb007ec 0
Vregister_cf_8dcb0ec41fb007ec_source VGND register_cf_node_8dcb0ec41fb007ec_source 0
XMP0 register_cf_node_1e43f7262c1fb23a A register_cf_node_1e43f7262c1fb23a_source VPWR sky130_fd_pr__pfet_01v8_hvt w=2.6 l=0.15 nf=1 m=1
Vregister_cf_1e43f7262c1fb23a N register_cf_node_1e43f7262c1fb23a 0
Vregister_cf_1e43f7262c1fb23a_source VPWR register_cf_node_1e43f7262c1fb23a_source 0
XMP1 register_cf_node_09bb3b0f2177dc48 B register_cf_node_09bb3b0f2177dc48_source VPWR sky130_fd_pr__pfet_01v8_hvt w=2.6 l=0.15 nf=1 m=1
Vregister_cf_09bb3b0f2177dc48 Y register_cf_node_09bb3b0f2177dc48 0
Vregister_cf_09bb3b0f2177dc48_source N register_cf_node_09bb3b0f2177dc48_source 0
.ends cell_nor2

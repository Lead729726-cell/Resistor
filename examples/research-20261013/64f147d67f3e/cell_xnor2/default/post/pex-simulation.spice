* NGSPICE file created from cell_xnor2.ext - technology: sky130A

.subckt cell_xnor2 Y VPWR VGND B A
X0 VPWR.t3 N.t3 Y.t1 VPWR.t2 sky130_fd_pr__pfet_01v8_hvt ad=0.1885 pd=1.88 as=0.1885 ps=1.88 w=0.65 l=0.15
X1 VGND.t2 N.t4 Y.t0 VGND.t1 sky130_fd_pr__nfet_01v8 ad=0.1885 pd=1.88 as=0.1885 ps=1.88 w=0.65 l=0.15
X2 CORE__N3__N1.t1 B.t0 CORE__N3.t2 VGND.t8 sky130_fd_pr__nfet_01v8 ad=0.1885 pd=1.88 as=0.1885 ps=1.88 w=0.65 l=0.15
X3 VGND.t4 CORE__N1.t3 CORE__N3__N1.t0 VGND.t3 sky130_fd_pr__nfet_01v8 ad=0.1885 pd=1.88 as=0.1885 ps=1.88 w=0.65 l=0.15
X4 CORE__N2__N1.t1 A.t0 CORE__N2.t2 VGND.t5 sky130_fd_pr__nfet_01v8 ad=0.1885 pd=1.88 as=0.1885 ps=1.88 w=0.65 l=0.15
X5 CORE__N4__N1.t1 CORE__N2.t3 N.t1 VGND.t11 sky130_fd_pr__nfet_01v8 ad=0.1885 pd=1.88 as=0.1885 ps=1.88 w=0.65 l=0.15
X6 CORE__N1__N1.t1 A.t1 CORE__N1.t0 VGND.t0 sky130_fd_pr__nfet_01v8 ad=0.1885 pd=1.88 as=0.1885 ps=1.88 w=0.65 l=0.15
X7 VGND.t10 CORE__N3.t3 CORE__N4__N1.t0 VGND.t9 sky130_fd_pr__nfet_01v8 ad=0.1885 pd=1.88 as=0.1885 ps=1.88 w=0.65 l=0.15
X8 VGND.t7 CORE__N1.t4 CORE__N2__N1.t0 VGND.t6 sky130_fd_pr__nfet_01v8 ad=0.1885 pd=1.88 as=0.1885 ps=1.88 w=0.65 l=0.15
X9 VPWR.t1 CORE__N1.t5 CORE__N3.t0 VPWR.t0 sky130_fd_pr__pfet_01v8_hvt ad=0.1885 pd=1.88 as=0.1885 ps=1.88 w=0.65 l=0.15
X10 VPWR.t17 A.t2 CORE__N1.t2 VPWR.t16 sky130_fd_pr__pfet_01v8_hvt ad=0.1885 pd=1.88 as=0.1885 ps=1.88 w=0.65 l=0.15
X11 VPWR.t13 CORE__N2.t4 N.t2 VPWR.t12 sky130_fd_pr__pfet_01v8_hvt ad=0.1885 pd=1.88 as=0.1885 ps=1.88 w=0.65 l=0.15
X12 VPWR.t15 B.t1 CORE__N1.t1 VPWR.t14 sky130_fd_pr__pfet_01v8_hvt ad=0.1885 pd=1.88 as=0.1885 ps=1.88 w=0.65 l=0.15
X13 VPWR.t9 B.t2 CORE__N3.t1 VPWR.t8 sky130_fd_pr__pfet_01v8_hvt ad=0.1885 pd=1.88 as=0.1885 ps=1.88 w=0.65 l=0.15
X14 VPWR.t11 A.t3 CORE__N2.t1 VPWR.t10 sky130_fd_pr__pfet_01v8_hvt ad=0.1885 pd=1.88 as=0.1885 ps=1.88 w=0.65 l=0.15
X15 VPWR.t5 CORE__N3.t4 N.t0 VPWR.t4 sky130_fd_pr__pfet_01v8_hvt ad=0.1885 pd=1.88 as=0.1885 ps=1.88 w=0.65 l=0.15
X16 VPWR.t7 CORE__N1.t6 CORE__N2.t0 VPWR.t6 sky130_fd_pr__pfet_01v8_hvt ad=0.1885 pd=1.88 as=0.1885 ps=1.88 w=0.65 l=0.15
X17 VGND.t13 B.t3 CORE__N1__N1.t0 VGND.t12 sky130_fd_pr__nfet_01v8 ad=0.1885 pd=1.88 as=0.1885 ps=1.88 w=0.65 l=0.15
C0 CORE__N3__N1 Y 0
C1 B N 0
C2 CORE__N2 Y 0.00203f
C3 CORE__N3 VPWR 0.94648f
C4 CORE__N3 N 0.66324f
C5 CORE__N2__N1 CORE__N4__N1 0
C6 CORE__N1 CORE__N3__N1 7.51144f
C7 CORE__N1 CORE__N1__N1 0.53709f
C8 CORE__N2 CORE__N1 7.59209f
C9 A CORE__N4__N1 0
C10 CORE__N1__N1 CORE__N3__N1 0
C11 CORE__N2__N1 Y 0
C12 CORE__N2 CORE__N3__N1 0.2848f
C13 N VPWR 0.94487f
C14 CORE__N2 CORE__N1__N1 0.00336f
C15 B CORE__N4__N1 0
C16 CORE__N3 CORE__N4__N1 9.44747f
C17 CORE__N1 CORE__N2__N1 0.60805f
C18 CORE__N1 A 0.58173f
C19 B Y 0
C20 CORE__N2__N1 CORE__N3__N1 0.00269f
C21 CORE__N1__N1 CORE__N2__N1 0.00298f
C22 CORE__N3 Y 8.76957f
C23 CORE__N2 CORE__N2__N1 0.58352f
C24 CORE__N3__N1 A 0.00178f
C25 CORE__N1__N1 A 3.46777f
C26 CORE__N4__N1 VPWR 0.01242f
C27 CORE__N2 A 0.4858f
C28 CORE__N1 B 0.83778f
C29 N CORE__N4__N1 0.71275f
C30 CORE__N1 CORE__N3 0.60853f
C31 B CORE__N3__N1 6.74209f
C32 CORE__N1__N1 B 0.25806f
C33 CORE__N2 B 0.37916f
C34 Y VPWR 0.26802f
C35 Y N 10.546f
C36 CORE__N3 CORE__N3__N1 0.63388f
C37 CORE__N2 CORE__N3 0.36914f
C38 CORE__N2__N1 A 4.5904f
C39 CORE__N1 VPWR 1.36734f
C40 CORE__N1 N 0.12793f
C41 CORE__N2__N1 B 4.89549f
C42 CORE__N3__N1 VPWR 0.01463f
C43 CORE__N1__N1 VPWR 0.05039f
C44 CORE__N2 VPWR 0.94651f
C45 CORE__N3__N1 N 0.00336f
C46 B A 0.3658f
C47 CORE__N2 N 0.73925f
C48 CORE__N3 CORE__N2__N1 0.00336f
C49 Y CORE__N4__N1 0.00577f
C50 CORE__N3 A 0
C51 CORE__N1 CORE__N4__N1 0.00603f
C52 CORE__N3 B 0.58667f
C53 CORE__N2__N1 VPWR 0.02371f
C54 A VPWR 0.85687f
C55 CORE__N3__N1 CORE__N4__N1 0.00116f
C56 CORE__N1__N1 CORE__N4__N1 0
C57 CORE__N2 CORE__N4__N1 9.0801f
C58 CORE__N1 Y 0.00145f
C59 B VPWR 0.84794f
C60 Y VGND 9.99444f
C61 B VGND 6.39834f
C62 A VGND 5.03763f
C63 VPWR VGND 31.1792f
C64 CORE__N4__N1 VGND 3.79278f $ **FLOATING
C65 N VGND 13.20425f $ **FLOATING
C66 CORE__N3__N1 VGND 3.10569f $ **FLOATING
C67 CORE__N3 VGND 7.56587f $ **FLOATING
C68 CORE__N2__N1 VGND 2.55873f $ **FLOATING
C69 CORE__N2 VGND 6.74003f $ **FLOATING
C70 CORE__N1__N1 VGND 2.97727f $ **FLOATING
C71 CORE__N1 VGND 8.416f $ **FLOATING
C72 CORE__N1__N1.n0 VGND 0.00867f $ **FLOATING
C73 CORE__N1__N1.n1 VGND 0.00867f $ **FLOATING
C74 CORE__N1__N1.t1 VGND 0.02109f $ **FLOATING
C75 CORE__N1__N1.n2 VGND 0.00867f $ **FLOATING
C76 CORE__N1__N1.n3 VGND 1.74743f $ **FLOATING
C77 CORE__N1__N1.n4 VGND 1.66758f $ **FLOATING
C78 CORE__N1__N1.t0 VGND 0.02109f $ **FLOATING
C79 CORE__N1__N1.n5 VGND 0.00867f $ **FLOATING
C80 CORE__N4__N1.n0 VGND 0.01439f $ **FLOATING
C81 CORE__N4__N1.n1 VGND 0.01439f $ **FLOATING
C82 CORE__N4__N1.t1 VGND 0.035f $ **FLOATING
C83 CORE__N4__N1.n2 VGND 0.01439f $ **FLOATING
C84 CORE__N4__N1.n3 VGND 9.42424f $ **FLOATING
C85 CORE__N4__N1.n4 VGND 8.93471f $ **FLOATING
C86 CORE__N4__N1.t0 VGND 0.035f $ **FLOATING
C87 CORE__N4__N1.n5 VGND 0.01439f $ **FLOATING
C88 CORE__N2__N1.n0 VGND 0.01376f $ **FLOATING
C89 CORE__N2__N1.n1 VGND 0.01376f $ **FLOATING
C90 CORE__N2__N1.t1 VGND 0.03347f $ **FLOATING
C91 CORE__N2__N1.n2 VGND 0.01376f $ **FLOATING
C92 CORE__N2__N1.n3 VGND 4.81333f $ **FLOATING
C93 CORE__N2__N1.n4 VGND 4.55178f $ **FLOATING
C94 CORE__N2__N1.t0 VGND 0.03347f $ **FLOATING
C95 CORE__N2__N1.n5 VGND 0.01376f $ **FLOATING
C96 CORE__N2.n0 VGND 0.01024f $ **FLOATING
C97 CORE__N2.t3 VGND 0.04229f $ **FLOATING
C98 CORE__N2.t4 VGND 0.04395f $ **FLOATING
C99 CORE__N2.n1 VGND 4.74728f $ **FLOATING
C100 CORE__N2.n2 VGND 0.01024f $ **FLOATING
C101 CORE__N2.t1 VGND 0.03135f $ **FLOATING
C102 CORE__N2.n3 VGND 0.01024f $ **FLOATING
C103 CORE__N2.n4 VGND 0.63563f $ **FLOATING
C104 CORE__N2.n5 VGND 0.01169f $ **FLOATING
C105 CORE__N2.t2 VGND 0.02843f $ **FLOATING
C106 CORE__N2.n6 VGND 0.01169f $ **FLOATING
C107 CORE__N2.n7 VGND 0.4079f $ **FLOATING
C108 CORE__N2.n8 VGND 6.42088f $ **FLOATING
C109 CORE__N2.n9 VGND 3.43115f $ **FLOATING
C110 CORE__N2.n10 VGND 0.4079f $ **FLOATING
C111 CORE__N2.t0 VGND 0.03135f $ **FLOATING
C112 CORE__N2.n11 VGND 0.01024f $ **FLOATING
C113 A.t0 VGND 0.04174f $ **FLOATING
C114 A.t3 VGND 0.04338f $ **FLOATING
C115 A.n0 VGND 2.68321f $ **FLOATING
C116 A.t1 VGND 0.04174f $ **FLOATING
C117 A.n1 VGND 1.92647f $ **FLOATING
C118 A.t2 VGND 0.04338f $ **FLOATING
C119 A.n2 VGND 2.40039f $ **FLOATING
C120 CORE__N1.n0 VGND 0.01069f $ **FLOATING
C121 CORE__N1.t3 VGND 0.03866f $ **FLOATING
C122 CORE__N1.t5 VGND 0.04017f $ **FLOATING
C123 CORE__N1.n1 VGND 2.96625f $ **FLOATING
C124 CORE__N1.t4 VGND 0.03866f $ **FLOATING
C125 CORE__N1.n2 VGND 2.02647f $ **FLOATING
C126 CORE__N1.t6 VGND 0.04017f $ **FLOATING
C127 CORE__N1.n3 VGND 2.54742f $ **FLOATING
C128 CORE__N1.n4 VGND 0.00936f $ **FLOATING
C129 CORE__N1.t1 VGND 0.02866f $ **FLOATING
C130 CORE__N1.n5 VGND 0.00936f $ **FLOATING
C131 CORE__N1.n6 VGND 0.33916f $ **FLOATING
C132 CORE__N1.n7 VGND 2.36266f $ **FLOATING
C133 CORE__N1.n8 VGND 0.00936f $ **FLOATING
C134 CORE__N1.t2 VGND 0.02866f $ **FLOATING
C135 CORE__N1.n9 VGND 0.00936f $ **FLOATING
C136 CORE__N1.n10 VGND 0.43179f $ **FLOATING
C137 CORE__N1.n11 VGND 3.1381f $ **FLOATING
C138 CORE__N1.n12 VGND 0.33916f $ **FLOATING
C139 CORE__N1.t0 VGND 0.02599f $ **FLOATING
C140 CORE__N1.n13 VGND 0.01069f $ **FLOATING
C141 CORE__N3__N1.n0 VGND 0.01454f $ **FLOATING
C142 CORE__N3__N1.n1 VGND 0.01454f $ **FLOATING
C143 CORE__N3__N1.t1 VGND 0.03535f $ **FLOATING
C144 CORE__N3__N1.n2 VGND 0.01454f $ **FLOATING
C145 CORE__N3__N1.n3 VGND 7.22833f $ **FLOATING
C146 CORE__N3__N1.n4 VGND 6.82921f $ **FLOATING
C147 CORE__N3__N1.t0 VGND 0.03535f $ **FLOATING
C148 CORE__N3__N1.n5 VGND 0.01454f $ **FLOATING
C149 CORE__N3.n0 VGND 0.00984f $ **FLOATING
C150 CORE__N3.t3 VGND 0.04064f $ **FLOATING
C151 CORE__N3.t4 VGND 0.04223f $ **FLOATING
C152 CORE__N3.n1 VGND 4.03509f $ **FLOATING
C153 CORE__N3.n2 VGND 0.00984f $ **FLOATING
C154 CORE__N3.t1 VGND 0.03012f $ **FLOATING
C155 CORE__N3.n3 VGND 0.00984f $ **FLOATING
C156 CORE__N3.n4 VGND 0.7881f $ **FLOATING
C157 CORE__N3.n5 VGND 0.01124f $ **FLOATING
C158 CORE__N3.t2 VGND 0.02732f $ **FLOATING
C159 CORE__N3.n6 VGND 0.01124f $ **FLOATING
C160 CORE__N3.n7 VGND 0.46358f $ **FLOATING
C161 CORE__N3.n8 VGND 9.14215f $ **FLOATING
C162 CORE__N3.n9 VGND 2.61255f $ **FLOATING
C163 CORE__N3.n10 VGND 0.46358f $ **FLOATING
C164 CORE__N3.t0 VGND 0.03012f $ **FLOATING
C165 CORE__N3.n11 VGND 0.00984f $ **FLOATING
C166 B.t0 VGND 0.04096f $ **FLOATING
C167 B.t2 VGND 0.04257f $ **FLOATING
C168 B.n0 VGND 3.66708f $ **FLOATING
C169 B.t3 VGND 0.04096f $ **FLOATING
C170 B.n1 VGND 2.7966f $ **FLOATING
C171 B.t1 VGND 0.04257f $ **FLOATING
C172 B.n2 VGND 3.61573f $ **FLOATING
C173 Y.n0 VGND 0.01349f $ **FLOATING
C174 Y.t0 VGND 0.0328f $ **FLOATING
C175 Y.n1 VGND 0.01349f $ **FLOATING
C176 Y.n2 VGND 0.6453f $ **FLOATING
C177 Y.n3 VGND 0.01181f $ **FLOATING
C178 Y.t1 VGND 0.03616f $ **FLOATING
C179 Y.n4 VGND 0.01181f $ **FLOATING
C180 Y.n5 VGND 0.59985f $ **FLOATING
C181 Y.n6 VGND 12.2927f $ **FLOATING
C182 N.n0 VGND 0.0051f $ **FLOATING
C183 N.t4 VGND 0.02106f $ **FLOATING
C184 N.t3 VGND 0.02188f $ **FLOATING
C185 N.n1 VGND 1.81557f $ **FLOATING
C186 N.n2 VGND 0.0051f $ **FLOATING
C187 N.t2 VGND 0.01561f $ **FLOATING
C188 N.n3 VGND 0.0051f $ **FLOATING
C189 N.n4 VGND 0.49274f $ **FLOATING
C190 N.n5 VGND 0.00582f $ **FLOATING
C191 N.t1 VGND 0.01416f $ **FLOATING
C192 N.n6 VGND 0.00582f $ **FLOATING
C193 N.n7 VGND 0.27773f $ **FLOATING
C194 N.n8 VGND 6.23863f $ **FLOATING
C195 N.n9 VGND 0.9985f $ **FLOATING
C196 N.n10 VGND 0.27773f $ **FLOATING
C197 N.t0 VGND 0.01561f $ **FLOATING
C198 N.n11 VGND 0.0051f $ **FLOATING
rmesh_equiv_0 a a.n0 15.03258234958602
rmesh_equiv_1 a a.n1 29.799399999999999
rmesh_equiv_10 b b.n1 30.632700000000003
rmesh_equiv_100 core__n2__n1.n4 core__n2__n1.n5 10.151300000000001
rmesh_equiv_101 core__n2__n1.n5 core__n2__n1.t0 255.34500000000003
rmesh_equiv_102 core__n3 core__n3.n0 12.8005
rmesh_equiv_103 core__n3 core__n3.n1 16.491051075124567
rmesh_equiv_104 core__n3 core__n3.n11 12.8005
rmesh_equiv_105 core__n3 core__n3.n2 12.8005
rmesh_equiv_106 core__n3 core__n3.n3 12.8005
rmesh_equiv_107 core__n3 core__n3.n5 12.8005
rmesh_equiv_108 core__n3 core__n3.n6 12.8005
rmesh_equiv_109 core__n3 core__n3.t3 315.88
rmesh_equiv_11 b b.n2 5.7781765607747646
rmesh_equiv_110 core__n3 core__n3.t4 330.34100000000001
rmesh_equiv_111 core__n3.n0 core__n3.n10 10.151300000000001
rmesh_equiv_112 core__n3.n0 core__n3.t0 700.48400000000004
rmesh_equiv_113 core__n3.n1 core__n3.n9 2.4476300000000002
rmesh_equiv_114 core__n3.n10 core__n3.n11 10.151300000000001
rmesh_equiv_115 core__n3.n10 core__n3.n9 13.3688
rmesh_equiv_116 core__n3.n11 core__n3.t0 700.48400000000004
rmesh_equiv_117 core__n3.n2 core__n3.n4 10.151300000000001
rmesh_equiv_118 core__n3.n2 core__n3.t1 700.48400000000004
rmesh_equiv_119 core__n3.n3 core__n3.n4 10.151300000000001
rmesh_equiv_12 b b.t0 315.88
rmesh_equiv_120 core__n3.n3 core__n3.t1 700.48400000000004
rmesh_equiv_121 core__n3.n4 core__n3.n8 13.9214
rmesh_equiv_122 core__n3.n5 core__n3.n7 10.151300000000001
rmesh_equiv_123 core__n3.n5 core__n3.t2 255.34500000000003
rmesh_equiv_124 core__n3.n6 core__n3.n7 10.151300000000001
rmesh_equiv_125 core__n3.n6 core__n3.t2 255.34500000000003
rmesh_equiv_126 core__n3.n7 core__n3.n8 13.3688
rmesh_equiv_127 core__n3.n8 core__n3.n9 0.55314200000000002
rmesh_equiv_128 core__n3__n1 core__n3__n1.n0 12.8005
rmesh_equiv_129 core__n3__n1 core__n3__n1.n1 12.8005
rmesh_equiv_13 b b.t1 330.34100000000001
rmesh_equiv_130 core__n3__n1 core__n3__n1.n2 12.8005
rmesh_equiv_131 core__n3__n1 core__n3__n1.n5 12.8005
rmesh_equiv_132 core__n3__n1.n0 core__n3__n1.n4 10.151300000000001
rmesh_equiv_133 core__n3__n1.n0 core__n3__n1.t0 255.34500000000003
rmesh_equiv_134 core__n3__n1.n1 core__n3__n1.n3 10.151300000000001
rmesh_equiv_135 core__n3__n1.n1 core__n3__n1.t1 255.34500000000003
rmesh_equiv_136 core__n3__n1.n2 core__n3__n1.n3 10.151300000000001
rmesh_equiv_137 core__n3__n1.n2 core__n3__n1.t1 255.34500000000003
rmesh_equiv_138 core__n3__n1.n3 core__n3__n1.n4 24.321000000000002
rmesh_equiv_139 core__n3__n1.n4 core__n3__n1.n5 10.151300000000001
rmesh_equiv_14 b b.t2 330.34100000000001
rmesh_equiv_140 core__n3__n1.n5 core__n3__n1.t0 255.34500000000003
rmesh_equiv_141 core__n4__n1 core__n4__n1.n0 12.8005
rmesh_equiv_142 core__n4__n1 core__n4__n1.n1 12.8005
rmesh_equiv_143 core__n4__n1 core__n4__n1.n2 12.8005
rmesh_equiv_144 core__n4__n1 core__n4__n1.n5 12.8005
rmesh_equiv_145 core__n4__n1.n0 core__n4__n1.n4 10.151300000000001
rmesh_equiv_146 core__n4__n1.n0 core__n4__n1.t0 255.34500000000003
rmesh_equiv_147 core__n4__n1.n1 core__n4__n1.n3 10.151300000000001
rmesh_equiv_148 core__n4__n1.n1 core__n4__n1.t1 255.34500000000003
rmesh_equiv_149 core__n4__n1.n2 core__n4__n1.n3 10.151300000000001
rmesh_equiv_15 b b.t3 315.88
rmesh_equiv_150 core__n4__n1.n2 core__n4__n1.t1 255.34500000000003
rmesh_equiv_151 core__n4__n1.n3 core__n4__n1.n4 26.821000000000002
rmesh_equiv_152 core__n4__n1.n4 core__n4__n1.n5 10.151300000000001
rmesh_equiv_153 core__n4__n1.n5 core__n4__n1.t0 255.34500000000003
rmesh_equiv_154 n n.n0 12.8005
rmesh_equiv_155 n n.n1 16.907731233653234
rmesh_equiv_156 n n.n11 12.8005
rmesh_equiv_157 n n.n2 12.8005
rmesh_equiv_158 n n.n3 12.8005
rmesh_equiv_159 n n.n5 12.8005
rmesh_equiv_16 b.n0 b.n1 2.7637100000000001
rmesh_equiv_160 n n.n6 12.8005
rmesh_equiv_161 n n.t3 330.34100000000001
rmesh_equiv_162 n n.t4 315.88
rmesh_equiv_163 n.n0 n.n10 10.151300000000001
rmesh_equiv_164 n.n0 n.t0 700.48400000000004
rmesh_equiv_165 n.n1 n.n9 1.3423499999999999
rmesh_equiv_166 n.n10 n.n11 10.151300000000001
rmesh_equiv_167 n.n10 n.n9 14.2021
rmesh_equiv_168 n.n11 n.t0 700.48400000000004
rmesh_equiv_169 n.n2 n.n4 10.151300000000001
rmesh_equiv_17 b.n1 b.n2 0.55314200000000002
rmesh_equiv_170 n.n2 n.t2 700.48400000000004
rmesh_equiv_171 n.n3 n.n4 10.151300000000001
rmesh_equiv_172 n.n3 n.t2 700.48400000000004
rmesh_equiv_173 n.n4 n.n8 14.7547
rmesh_equiv_174 n.n5 n.n7 10.151300000000001
rmesh_equiv_175 n.n5 n.t1 255.34500000000003
rmesh_equiv_176 n.n6 n.n7 10.151300000000001
rmesh_equiv_177 n.n6 n.t1 255.34500000000003
rmesh_equiv_178 n.n7 n.n8 14.2021
rmesh_equiv_179 n.n8 n.n9 0.55314200000000002
rmesh_equiv_18 core__n1 core__n1.n0 12.8005
rmesh_equiv_180 vgnd vgnd.n277 768.14652784690713
rmesh_equiv_181 vgnd vgnd.n279 826.7903876730652
rmesh_equiv_182 vgnd vgnd.n289 2590.3111679180265
rmesh_equiv_183 vgnd vgnd.n295 994.95037025735576
rmesh_equiv_184 vgnd vgnd.n301 621.27217228762765
rmesh_equiv_185 vgnd vgnd.n305 1782.4857566483943
rmesh_equiv_186 vgnd vgnd.n309 1597.1416278191823
rmesh_equiv_187 vgnd vgnd.n48 422.81723734024416
rmesh_equiv_188 vgnd vgnd.n52 1626.3993929339324
rmesh_equiv_189 vgnd vgnd.n53 2316.5706116610354
rmesh_equiv_19 core__n1 core__n1.n1 15.866002865646433
rmesh_equiv_190 vgnd vgnd.n54 600.2813385672996
rmesh_equiv_191 vgnd vgnd.n56 161.67858873254423
rmesh_equiv_192 vgnd vgnd.n57 6125.6406921336529
rmesh_equiv_193 vgnd vgnd.n58 1928.2830296281973
rmesh_equiv_194 vgnd vgnd.n60 378.40372511531109
rmesh_equiv_195 vgnd vgnd.t0 206.40917760259012
rmesh_equiv_196 vgnd vgnd.t1 256.9267355354894
rmesh_equiv_197 vgnd vgnd.t10 132.81363209846495
rmesh_equiv_198 vgnd vgnd.t11 251.00528645723827
rmesh_equiv_199 vgnd vgnd.t12 208.18571024322867
rmesh_equiv_2 a a.n2 5.102958731213346
rmesh_equiv_20 core__n1 core__n1.n13 12.8005
rmesh_equiv_200 vgnd vgnd.t13 132.57552655213755
rmesh_equiv_201 vgnd vgnd.t2 132.84038113436327
rmesh_equiv_202 vgnd vgnd.t3 213.1537452235828
rmesh_equiv_203 vgnd vgnd.t4 132.74338745471042
rmesh_equiv_204 vgnd vgnd.t5 214.7315411858068
rmesh_equiv_205 vgnd vgnd.t6 272.69351213247973
rmesh_equiv_206 vgnd vgnd.t7 132.67235114355285
rmesh_equiv_207 vgnd vgnd.t8 242.94916727308964
rmesh_equiv_208 vgnd vgnd.t9 15580.997162510759
rmesh_equiv_209 vgnd.n277 vgnd.n279 55429.127690427471
rmesh_equiv_21 core__n1 core__n1.n2 31.465999999999998
rmesh_equiv_210 vgnd.n277 vgnd.n305 489676.59945580846
rmesh_equiv_211 vgnd.n277 vgnd.n309 614590.26170956157
rmesh_equiv_212 vgnd.n277 vgnd.n48 95886.724239230272
rmesh_equiv_213 vgnd.n277 vgnd.t0 18339949.435584668
rmesh_equiv_214 vgnd.n277 vgnd.t12 1447029.6675646035
rmesh_equiv_215 vgnd.n277 vgnd.t3 7798.1493070067781
rmesh_equiv_216 vgnd.n277 vgnd.t5 106837.09940059675
rmesh_equiv_217 vgnd.n277 vgnd.t6 8052.3301323136284
rmesh_equiv_218 vgnd.n277 vgnd.t8 576.54758802900528
rmesh_equiv_219 vgnd.n279 vgnd.n289 25424.47536501964
rmesh_equiv_22 core__n1 core__n1.n3 31.450400000000002
rmesh_equiv_220 vgnd.n279 vgnd.n305 54019.397023496582
rmesh_equiv_221 vgnd.n279 vgnd.n309 32870823.574716803
rmesh_equiv_222 vgnd.n279 vgnd.n48 16887184.435619261
rmesh_equiv_223 vgnd.n279 vgnd.n52 52351.722246414043
rmesh_equiv_224 vgnd.n279 vgnd.n56 73586.8254127603
rmesh_equiv_225 vgnd.n279 vgnd.n57 43921.222683118554
rmesh_equiv_226 vgnd.n279 vgnd.n58 133268.15361089818
rmesh_equiv_227 vgnd.n279 vgnd.n60 17467.716940696435
rmesh_equiv_228 vgnd.n279 vgnd.t11 578.1293457997732
rmesh_equiv_229 vgnd.n279 vgnd.t3 7879.3728086167612
rmesh_equiv_23 core__n1 core__n1.n4 12.8005
rmesh_equiv_230 vgnd.n279 vgnd.t8 10572670.073652659
rmesh_equiv_231 vgnd.n279 vgnd.t9 14200.188775300867
rmesh_equiv_232 vgnd.n289 vgnd.n295 9052.652059481843
rmesh_equiv_233 vgnd.n289 vgnd.n52 21928.82773234904
rmesh_equiv_234 vgnd.n289 vgnd.n53 59468.57677168971
rmesh_equiv_235 vgnd.n289 vgnd.n54 62788.235402814411
rmesh_equiv_236 vgnd.n289 vgnd.n56 8079.1684726292569
rmesh_equiv_237 vgnd.n289 vgnd.n57 3903.0803097675803
rmesh_equiv_238 vgnd.n289 vgnd.n58 364.78424384053636
rmesh_equiv_239 vgnd.n289 vgnd.n60 677.01638238461283
rmesh_equiv_24 core__n1 core__n1.n5 12.8005
rmesh_equiv_240 vgnd.n289 vgnd.t9 1126.1608642523199
rmesh_equiv_241 vgnd.n295 vgnd.n301 224562.50879138653
rmesh_equiv_242 vgnd.n295 vgnd.n53 829.7302680483989
rmesh_equiv_243 vgnd.n295 vgnd.n54 3044.4939442040081
rmesh_equiv_244 vgnd.n295 vgnd.n56 39633.662354635635
rmesh_equiv_245 vgnd.n295 vgnd.n57 27137.121261474756
rmesh_equiv_246 vgnd.n295 vgnd.n58 372.23688971362191
rmesh_equiv_247 vgnd.n295 vgnd.n60 1322.4500993963704
rmesh_equiv_248 vgnd.n295 vgnd.t9 987.8245771118967
rmesh_equiv_249 vgnd.n301 vgnd.n305 16586.847388396847
rmesh_equiv_25 core__n1 core__n1.n8 12.8005
rmesh_equiv_250 vgnd.n301 vgnd.n52 36638.70337856176
rmesh_equiv_251 vgnd.n301 vgnd.n53 852.06904071346696
rmesh_equiv_252 vgnd.n301 vgnd.n54 346.48502047419839
rmesh_equiv_253 vgnd.n301 vgnd.n56 3092.7374712977139
rmesh_equiv_254 vgnd.n301 vgnd.n57 9407.2191031056736
rmesh_equiv_255 vgnd.n301 vgnd.t9 23927.922240171847
rmesh_equiv_256 vgnd.n305 vgnd.n309 84266.126772206131
rmesh_equiv_257 vgnd.n305 vgnd.n48 43291.206903987004
rmesh_equiv_258 vgnd.n305 vgnd.n52 13589.7908002695
rmesh_equiv_259 vgnd.n305 vgnd.n53 6237.7461101929321
rmesh_equiv_26 core__n1 core__n1.n9 12.8005
rmesh_equiv_260 vgnd.n305 vgnd.n54 16586.847388396847
rmesh_equiv_261 vgnd.n305 vgnd.t11 2455.1629247560222
rmesh_equiv_262 vgnd.n305 vgnd.t3 7920.6143062648898
rmesh_equiv_263 vgnd.n305 vgnd.t8 27103.609215084914
rmesh_equiv_264 vgnd.n309 vgnd.n48 3621.7553617403769
rmesh_equiv_265 vgnd.n309 vgnd.t0 18717.809161921545
rmesh_equiv_266 vgnd.n309 vgnd.t12 7715.1356481137891
rmesh_equiv_267 vgnd.n309 vgnd.t3 104575.77783675611
rmesh_equiv_268 vgnd.n309 vgnd.t5 2398.2387159817463
rmesh_equiv_269 vgnd.n309 vgnd.t6 1448491.8318446709
rmesh_equiv_27 core__n1 core__n1.t3 315.88
rmesh_equiv_270 vgnd.n309 vgnd.t8 29723.044534726239
rmesh_equiv_271 vgnd.n48 vgnd.t0 44568043.186155252
rmesh_equiv_272 vgnd.n48 vgnd.t12 3516437.214954142
rmesh_equiv_273 vgnd.n48 vgnd.t3 53725.165839349072
rmesh_equiv_274 vgnd.n48 vgnd.t5 259625.6045684983
rmesh_equiv_275 vgnd.n48 vgnd.t6 428.83884030001377
rmesh_equiv_276 vgnd.n48 vgnd.t8 15270.032218849617
rmesh_equiv_277 vgnd.n52 vgnd.n53 13778.563468426861
rmesh_equiv_278 vgnd.n52 vgnd.n54 36638.70337856176
rmesh_equiv_279 vgnd.n52 vgnd.n56 63469.267101064484
rmesh_equiv_28 core__n1 core__n1.t4 315.88
rmesh_equiv_280 vgnd.n52 vgnd.n57 37882.430696579446
rmesh_equiv_281 vgnd.n52 vgnd.n58 114944.92377067613
rmesh_equiv_282 vgnd.n52 vgnd.n60 15066.055451314569
rmesh_equiv_283 vgnd.n52 vgnd.t1 1802.4136072744463
rmesh_equiv_284 vgnd.n52 vgnd.t9 12247.784426216363
rmesh_equiv_285 vgnd.n53 vgnd.n54 886.4323615002213
rmesh_equiv_286 vgnd.n53 vgnd.n56 1848.1592508257279
rmesh_equiv_287 vgnd.n53 vgnd.n57 2475.9597917442879
rmesh_equiv_288 vgnd.n53 vgnd.n58 44269.680340049323
rmesh_equiv_289 vgnd.n53 vgnd.n60 8687.4238340254069
rmesh_equiv_29 core__n1 core__n1.t5 330.34100000000001
rmesh_equiv_290 vgnd.n53 vgnd.t9 206.56443782996493
rmesh_equiv_291 vgnd.n54 vgnd.n58 46740.905219067063
rmesh_equiv_292 vgnd.n54 vgnd.n60 9172.3737534354495
rmesh_equiv_293 vgnd.n56 vgnd.n57 343.79650895798369
rmesh_equiv_294 vgnd.n56 vgnd.n58 41955.272085723474
rmesh_equiv_295 vgnd.n56 vgnd.n60 140.26132899278875
rmesh_equiv_296 vgnd.n56 vgnd.t9 2171.636952669061
rmesh_equiv_297 vgnd.n57 vgnd.n58 5975.4796322397651
rmesh_equiv_298 vgnd.n57 vgnd.n60 2748.8825287757913
rmesh_equiv_299 vgnd.n57 vgnd.t9 521.80830652085251
rmesh_equiv_3 a a.t0 315.88
rmesh_equiv_30 core__n1 core__n1.t6 330.34100000000001
rmesh_equiv_300 vgnd.n58 vgnd.n60 1261.8065993570997
rmesh_equiv_301 vgnd.n58 vgnd.t9 814.42630648780994
rmesh_equiv_302 vgnd.n60 vgnd.t9 2187.7156841848296
rmesh_equiv_303 vgnd.t0 vgnd.t12 8837.5671346810905
rmesh_equiv_304 vgnd.t0 vgnd.t5 191127.75438581308
rmesh_equiv_305 vgnd.t0 vgnd.t6 2676480.4996815477
rmesh_equiv_306 vgnd.t10 vgnd.t13 444268.66989480116
rmesh_equiv_307 vgnd.t10 vgnd.t2 89115.012202616257
rmesh_equiv_308 vgnd.t10 vgnd.t4 144008.87673717982
rmesh_equiv_309 vgnd.t10 vgnd.t7 255854.57422226228
rmesh_equiv_31 core__n1.n0 core__n1.n12 10.151300000000001
rmesh_equiv_310 vgnd.t12 vgnd.t5 15080.059618629777
rmesh_equiv_311 vgnd.t12 vgnd.t6 211175.42888001245
rmesh_equiv_312 vgnd.t13 vgnd.t2 492026.64846622257
rmesh_equiv_313 vgnd.t13 vgnd.t4 297706.93316557398
rmesh_equiv_314 vgnd.t13 vgnd.t7 176948.11186131171
rmesh_equiv_315 vgnd.t2 vgnd.t4 159489.53813726743
rmesh_equiv_316 vgnd.t2 vgnd.t7 283358.42065824958
rmesh_equiv_317 vgnd.t3 vgnd.t8 33636.066168237041
rmesh_equiv_318 vgnd.t4 vgnd.t7 171449.58848016386
rmesh_equiv_319 vgnd.t5 vgnd.t6 15591.504992561095
rmesh_equiv_32 core__n1.n0 core__n1.t0 255.34500000000003
rmesh_equiv_320 vpwr vpwr.n76 2.0057214639569798
rmesh_equiv_321 vpwr vpwr.t0 117.18187411979875
rmesh_equiv_322 vpwr vpwr.t1 448.98074248368647
rmesh_equiv_323 vpwr vpwr.t10 117.18187411979875
rmesh_equiv_324 vpwr vpwr.t11 385.71880791551115
rmesh_equiv_325 vpwr vpwr.t12 117.18187411979875
rmesh_equiv_326 vpwr vpwr.t13 500.04319233285042
rmesh_equiv_327 vpwr vpwr.t14 117.18187411979875
rmesh_equiv_328 vpwr vpwr.t15 376.94895021372906
rmesh_equiv_329 vpwr vpwr.t16 117.18187411979875
rmesh_equiv_33 core__n1.n1 core__n1.n2 1.6584300000000001
rmesh_equiv_330 vpwr vpwr.t17 370.94503576334074
rmesh_equiv_331 vpwr vpwr.t2 117.18187411979875
rmesh_equiv_332 vpwr vpwr.t3 454.34497435172432
rmesh_equiv_333 vpwr vpwr.t4 117.18187411979875
rmesh_equiv_334 vpwr vpwr.t5 467.8833246889215
rmesh_equiv_335 vpwr vpwr.t6 117.18187411979875
rmesh_equiv_336 vpwr vpwr.t7 398.68102716348898
rmesh_equiv_337 vpwr vpwr.t8 117.18187411979875
rmesh_equiv_338 vpwr vpwr.t9 418.27213859724401
rmesh_equiv_339 vpwr.n76 vpwr.t1 1695.7893602292056
rmesh_equiv_34 core__n1.n10 core__n1.n11 12.671400000000002
rmesh_equiv_340 vpwr.n76 vpwr.t11 4497.1054705992283
rmesh_equiv_341 vpwr.n76 vpwr.t13 1221.3038835025977
rmesh_equiv_342 vpwr.n76 vpwr.t15 6168.7912767184253
rmesh_equiv_343 vpwr.n76 vpwr.t17 8363.0630296275849
rmesh_equiv_344 vpwr.n76 vpwr.t3 1623.6107483018338
rmesh_equiv_345 vpwr.n76 vpwr.t5 1470.2424636650235
rmesh_equiv_346 vpwr.n76 vpwr.t7 3257.9715317052714
rmesh_equiv_347 vpwr.n76 vpwr.t9 2352.5152249565849
rmesh_equiv_348 vpwr.t1 vpwr.t11 4942044.2235474214
rmesh_equiv_349 vpwr.t1 vpwr.t15 6779124.8158815755
rmesh_equiv_35 core__n1.n10 core__n1.n8 10.151300000000001
rmesh_equiv_350 vpwr.t1 vpwr.t17 9190495.4435562305
rmesh_equiv_351 vpwr.t1 vpwr.t7 3580311.7125026104
rmesh_equiv_352 vpwr.t1 vpwr.t9 2585270.537752117
rmesh_equiv_353 vpwr.t11 vpwr.t15 1312122.7502161504
rmesh_equiv_354 vpwr.t11 vpwr.t17 1778851.7669710154
rmesh_equiv_355 vpwr.t11 vpwr.t7 1432746.4665467902
rmesh_equiv_356 vpwr.t11 vpwr.t9 2342924.7249419307
rmesh_equiv_357 vpwr.t15 vpwr.t17 1233844.4419960629
rmesh_equiv_358 vpwr.t15 vpwr.t7 1965333.9158632862
rmesh_equiv_359 vpwr.t15 vpwr.t9 3213848.0406384305
rmesh_equiv_36 core__n1.n10 core__n1.n9 10.151300000000001
rmesh_equiv_360 vpwr.t17 vpwr.t7 2664413.6063836687
rmesh_equiv_361 vpwr.t17 vpwr.t9 4357030.8227063613
rmesh_equiv_362 vpwr.t3 vpwr.t5 1784249.0402755467
rmesh_equiv_363 vpwr.t7 vpwr.t9 1697354.4660432679
rmesh_equiv_364 y y.n0 12.8005
rmesh_equiv_365 y y.n1 12.8005
rmesh_equiv_366 y y.n3 12.8005
rmesh_equiv_367 y y.n4 12.8005
rmesh_equiv_368 y y.n6 13.071700000000002
rmesh_equiv_369 y.n0 y.n2 10.151300000000001
rmesh_equiv_37 core__n1.n11 core__n1.n12 12.1188
rmesh_equiv_370 y.n0 y.t0 255.34500000000003
rmesh_equiv_371 y.n1 y.n2 10.151300000000001
rmesh_equiv_372 y.n1 y.t0 255.34500000000003
rmesh_equiv_373 y.n2 y.n6 14.338100000000001
rmesh_equiv_374 y.n3 y.n5 10.151300000000001
rmesh_equiv_375 y.n3 y.t1 700.48400000000004
rmesh_equiv_376 y.n4 y.n5 10.151300000000001
rmesh_equiv_377 y.n4 y.t1 700.48400000000004
rmesh_equiv_378 y.n5 y.n6 13.785399999999999
rmesh_equiv_38 core__n1.n11 core__n1.n7 0.55314200000000002
rmesh_equiv_39 core__n1.n12 core__n1.n13 10.151300000000001
rmesh_equiv_4 a a.t1 315.88
rmesh_equiv_40 core__n1.n13 core__n1.t0 255.34500000000003
rmesh_equiv_41 core__n1.n2 core__n1.n3 0.55314200000000002
rmesh_equiv_42 core__n1.n3 core__n1.n7 2.4476300000000002
rmesh_equiv_43 core__n1.n4 core__n1.n6 10.151300000000001
rmesh_equiv_44 core__n1.n4 core__n1.t1 700.48400000000004
rmesh_equiv_45 core__n1.n5 core__n1.n6 10.151300000000001
rmesh_equiv_46 core__n1.n5 core__n1.t1 700.48400000000004
rmesh_equiv_47 core__n1.n6 core__n1.n7 12.1188
rmesh_equiv_48 core__n1.n8 core__n1.t2 700.48400000000004
rmesh_equiv_49 core__n1.n9 core__n1.t2 700.48400000000004
rmesh_equiv_5 a a.t2 330.34100000000001
rmesh_equiv_50 core__n1__n1 core__n1__n1.n0 12.8005
rmesh_equiv_51 core__n1__n1 core__n1__n1.n1 12.8005
rmesh_equiv_52 core__n1__n1 core__n1__n1.n2 12.8005
rmesh_equiv_53 core__n1__n1 core__n1__n1.n5 12.8005
rmesh_equiv_54 core__n1__n1.n0 core__n1__n1.n4 10.151300000000001
rmesh_equiv_55 core__n1__n1.n0 core__n1__n1.t0 255.34500000000003
rmesh_equiv_56 core__n1__n1.n1 core__n1__n1.n3 10.151300000000001
rmesh_equiv_57 core__n1__n1.n1 core__n1__n1.t1 255.34500000000003
rmesh_equiv_58 core__n1__n1.n2 core__n1__n1.n3 10.151300000000001
rmesh_equiv_59 core__n1__n1.n2 core__n1__n1.t1 255.34500000000003
rmesh_equiv_6 a a.t3 330.34100000000001
rmesh_equiv_60 core__n1__n1.n3 core__n1__n1.n4 20.9877
rmesh_equiv_61 core__n1__n1.n4 core__n1__n1.n5 10.151300000000001
rmesh_equiv_62 core__n1__n1.n5 core__n1__n1.t0 255.34500000000003
rmesh_equiv_63 core__n2 core__n2.n0 12.8005
rmesh_equiv_64 core__n2 core__n2.n1 16.074344793195898
rmesh_equiv_65 core__n2 core__n2.n11 12.8005
rmesh_equiv_66 core__n2 core__n2.n2 12.8005
rmesh_equiv_67 core__n2 core__n2.n3 12.8005
rmesh_equiv_68 core__n2 core__n2.n5 12.8005
rmesh_equiv_69 core__n2 core__n2.n6 12.8005
rmesh_equiv_7 a.n0 a.n1 1.6584300000000001
rmesh_equiv_70 core__n2 core__n2.t3 315.88
rmesh_equiv_71 core__n2 core__n2.t4 330.34100000000001
rmesh_equiv_72 core__n2.n0 core__n2.n10 10.151300000000001
rmesh_equiv_73 core__n2.n0 core__n2.t0 700.48400000000004
rmesh_equiv_74 core__n2.n1 core__n2.n9 3.5529199999999999
rmesh_equiv_75 core__n2.n10 core__n2.n11 10.151300000000001
rmesh_equiv_76 core__n2.n10 core__n2.n9 12.535399999999999
rmesh_equiv_77 core__n2.n11 core__n2.t0 700.48400000000004
rmesh_equiv_78 core__n2.n2 core__n2.n4 10.151300000000001
rmesh_equiv_79 core__n2.n2 core__n2.t1 700.48400000000004
rmesh_equiv_8 a.n1 a.n2 0.55314200000000002
rmesh_equiv_80 core__n2.n3 core__n2.n4 10.151300000000001
rmesh_equiv_81 core__n2.n3 core__n2.t1 700.48400000000004
rmesh_equiv_82 core__n2.n4 core__n2.n8 13.088100000000001
rmesh_equiv_83 core__n2.n5 core__n2.n7 10.151300000000001
rmesh_equiv_84 core__n2.n5 core__n2.t2 255.34500000000003
rmesh_equiv_85 core__n2.n6 core__n2.n7 10.151300000000001
rmesh_equiv_86 core__n2.n6 core__n2.t2 255.34500000000003
rmesh_equiv_87 core__n2.n7 core__n2.n8 12.535399999999999
rmesh_equiv_88 core__n2.n8 core__n2.n9 0.55314200000000002
rmesh_equiv_89 core__n2__n1 core__n2__n1.n0 12.8005
rmesh_equiv_9 b b.n0 15.449294018193466
rmesh_equiv_90 core__n2__n1 core__n2__n1.n1 12.8005
rmesh_equiv_91 core__n2__n1 core__n2__n1.n2 12.8005
rmesh_equiv_92 core__n2__n1 core__n2__n1.n5 12.8005
rmesh_equiv_93 core__n2__n1.n0 core__n2__n1.n4 10.151300000000001
rmesh_equiv_94 core__n2__n1.n0 core__n2__n1.t0 255.34500000000003
rmesh_equiv_95 core__n2__n1.n1 core__n2__n1.n3 10.151300000000001
rmesh_equiv_96 core__n2__n1.n1 core__n2__n1.t1 255.34500000000003
rmesh_equiv_97 core__n2__n1.n2 core__n2__n1.n3 10.151300000000001
rmesh_equiv_98 core__n2__n1.n2 core__n2__n1.t1 255.34500000000003
rmesh_equiv_99 core__n2__n1.n3 core__n2__n1.n4 22.654299999999999
.ends

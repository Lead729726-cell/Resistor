.subckt NAND2 A0 A1 Y VPWR VGND
XMN0 register_cf_node_377cff7a8fc053f0 A0 register_cf_node_377cff7a8fc053f0_source VGND sky130_fd_pr__nfet_01v8 w=0.65 l=0.15 nf=1 m=1
Vregister_cf_377cff7a8fc053f0 Y register_cf_node_377cff7a8fc053f0 0
Vregister_cf_377cff7a8fc053f0_source N1 register_cf_node_377cff7a8fc053f0_source 0
XMN1 register_cf_node_12c0ec391985518a A1 register_cf_node_12c0ec391985518a_source VGND sky130_fd_pr__nfet_01v8 w=0.65 l=0.15 nf=1 m=1
Vregister_cf_12c0ec391985518a N1 register_cf_node_12c0ec391985518a 0
Vregister_cf_12c0ec391985518a_source VGND register_cf_node_12c0ec391985518a_source 0
XMP0 register_cf_node_1c0f6f4ae9f406c8 A0 register_cf_node_1c0f6f4ae9f406c8_source VPWR sky130_fd_pr__pfet_01v8_hvt w=0.65 l=0.15 nf=1 m=1
Vregister_cf_1c0f6f4ae9f406c8 Y register_cf_node_1c0f6f4ae9f406c8 0
Vregister_cf_1c0f6f4ae9f406c8_source VPWR register_cf_node_1c0f6f4ae9f406c8_source 0
XMP1 register_cf_node_092f3ee2a80b5958 A1 register_cf_node_092f3ee2a80b5958_source VPWR sky130_fd_pr__pfet_01v8_hvt w=0.65 l=0.15 nf=1 m=1
Vregister_cf_092f3ee2a80b5958 Y register_cf_node_092f3ee2a80b5958 0
Vregister_cf_092f3ee2a80b5958_source VPWR register_cf_node_092f3ee2a80b5958_source 0
.ends NAND2
.subckt FA A B CIN SUM COUT VPWR VGND
XN1 A B N1 VPWR VGND NAND2
XN2 A N1 N2 VPWR VGND NAND2
XN3 B N1 N3 VPWR VGND NAND2
XN4 N2 N3 P VPWR VGND NAND2
XN5 P CIN N5 VPWR VGND NAND2
XN6 P N5 N6 VPWR VGND NAND2
XN7 CIN N5 N7 VPWR VGND NAND2
XN8 N6 N7 SUM VPWR VGND NAND2
XN9 N1 N5 COUT VPWR VGND NAND2
.ends FA
.subckt adder16 A0 A1 A2 A3 A4 A5 A6 A7 A8 A9 A10 A11 A12 A13 A14 A15 B0 B1 B2 B3 B4 B5 B6 B7 B8 B9 B10 B11 B12 B13 B14 B15 CIN S0 S1 S2 S3 S4 S5 S6 S7 S8 S9 S10 S11 S12 S13 S14 S15 COUT VPWR VGND
XBIT0 A0 B0 CIN S0 C1 VPWR VGND FA
XBIT1 A1 B1 C1 S1 C2 VPWR VGND FA
XBIT10 A10 B10 C10 S10 C11 VPWR VGND FA
XBIT11 A11 B11 C11 S11 C12 VPWR VGND FA
XBIT12 A12 B12 C12 S12 C13 VPWR VGND FA
XBIT13 A13 B13 C13 S13 C14 VPWR VGND FA
XBIT14 A14 B14 C14 S14 C15 VPWR VGND FA
XBIT15 A15 B15 C15 S15 COUT VPWR VGND FA
XBIT2 A2 B2 C2 S2 C3 VPWR VGND FA
XBIT3 A3 B3 C3 S3 C4 VPWR VGND FA
XBIT4 A4 B4 C4 S4 C5 VPWR VGND FA
XBIT5 A5 B5 C5 S5 C6 VPWR VGND FA
XBIT6 A6 B6 C6 S6 C7 VPWR VGND FA
XBIT7 A7 B7 C7 S7 C8 VPWR VGND FA
XBIT8 A8 B8 C8 S8 C9 VPWR VGND FA
XBIT9 A9 B9 C9 S9 C10 VPWR VGND FA
.ends adder16

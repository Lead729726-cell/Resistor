Register actual transistor digital adder4
.options klu noinit method=gear maxord=2
.include "/workspace/.runtime/eda/runs/59935ac1ae3147828e512550d408ce57/supported-tt.spice"
.option scale=1e-6
.include "/workspace/.runtime/eda/runs/59935ac1ae3147828e512550d408ce57/current-probe.spice"
.temp 27.0
VGND VGND 0 0
VDD VPWR VGND 1.8
VA0 A0 VGND PWL(0 0 3.2e-06 0 3.2001e-06 1.8 6.4e-06 1.8 6.4001e-06 0 9.6e-06 0 9.6001e-06 1.8 1.28e-05 1.8 1.28001e-05 0 1.6e-05 0 1.60001e-05 1.8 1.92e-05 1.8 1.92001e-05 0 2.24e-05 0 2.24001e-05 1.8 2.56e-05 1.8 2.56001e-05 0 2.88e-05 0 2.88001e-05 1.8 3.2e-05 1.8 3.20001e-05 0 3.52e-05 0 3.52001e-05 1.8 3.84e-05 1.8 3.84001e-05 0 4.16e-05 0 4.16001e-05 1.8 4.48e-05 1.8 4.48001e-05 0 4.8e-05 0 4.80001e-05 1.8 5.12e-05 1.8)
VA1 A1 VGND PWL(0 0 6.4e-06 0 6.4001e-06 1.8 1.28e-05 1.8 1.28001e-05 0 1.92e-05 0 1.92001e-05 1.8 2.56e-05 1.8 2.56001e-05 0 3.2e-05 0 3.20001e-05 1.8 3.84e-05 1.8 3.84001e-05 0 4.48e-05 0 4.48001e-05 1.8 5.12e-05 1.8)
VA2 A2 VGND PWL(0 0 1.28e-05 0 1.28001e-05 1.8 2.56e-05 1.8 2.56001e-05 0 3.84e-05 0 3.84001e-05 1.8 5.12e-05 1.8)
VA3 A3 VGND PWL(0 0 2.56e-05 0 2.56001e-05 1.8 5.12e-05 1.8)
VB0 B0 VGND PWL(0 0 2e-07 0 2.001e-07 1.8 4e-07 1.8 4.001e-07 0 6e-07 0 6.001e-07 1.8 8e-07 1.8 8.001e-07 0 1e-06 0 1.0001e-06 1.8 1.2e-06 1.8 1.2001e-06 0 1.4e-06 0 1.4001e-06 1.8 1.6e-06 1.8 1.6001e-06 0 1.8e-06 0 1.8001e-06 1.8 2e-06 1.8 2.0001e-06 0 2.2e-06 0 2.2001e-06 1.8 2.4e-06 1.8 2.4001e-06 0 2.6e-06 0 2.6001e-06 1.8 2.8e-06 1.8 2.8001e-06 0 3e-06 0 3.0001e-06 1.8 3.2e-06 1.8 3.2001e-06 0 3.4e-06 0 3.4001e-06 1.8 3.6e-06 1.8 3.6001e-06 0 3.8e-06 0 3.8001e-06 1.8 4e-06 1.8 4.0001e-06 0 4.2e-06 0 4.2001e-06 1.8 4.4e-06 1.8 4.4001e-06 0 4.6e-06 0 4.6001e-06 1.8 4.8e-06 1.8 4.8001e-06 0 5e-06 0 5.0001e-06 1.8 5.2e-06 1.8 5.2001e-06 0 5.4e-06 0 5.4001e-06 1.8 5.6e-06 1.8 5.6001e-06 0 5.8e-06 0 5.8001e-06 1.8 6e-06 1.8 6.0001e-06 0 6.2e-06 0 6.2001e-06 1.8 6.4e-06 1.8 6.4001e-06 0 6.6e-06 0 6.6001e-06 1.8 6.8e-06 1.8 6.8001e-06 0 7e-06 0 7.0001e-06 1.8 7.2e-06 1.8 7.2001e-06 0 7.4e-06 0 7.4001e-06 1.8 7.6e-06 1.8 7.6001e-06 0 7.8e-06 0 7.8001e-06 1.8 8e-06 1.8 8.0001e-06 0 8.2e-06 0 8.2001e-06 1.8 8.4e-06 1.8 8.4001e-06 0 8.6e-06 0 8.6001e-06 1.8 8.8e-06 1.8 8.8001e-06 0 9e-06 0 9.0001e-06 1.8 9.2e-06 1.8 9.2001e-06 0 9.4e-06 0 9.4001e-06 1.8 9.6e-06 1.8 9.6001e-06 0 9.8e-06 0 9.8001e-06 1.8 1e-05 1.8 1.00001e-05 0 1.02e-05 0 1.02001e-05 1.8 1.04e-05 1.8 1.04001e-05 0 1.06e-05 0 1.06001e-05 1.8 1.08e-05 1.8 1.08001e-05 0 1.1e-05 0 1.10001e-05 1.8 1.12e-05 1.8 1.12001e-05 0 1.14e-05 0 1.14001e-05 1.8 1.16e-05 1.8 1.16001e-05 0 1.18e-05 0 1.18001e-05 1.8 1.2e-05 1.8 1.20001e-05 0 1.22e-05 0 1.22001e-05 1.8 1.24e-05 1.8 1.24001e-05 0 1.26e-05 0 1.26001e-05 1.8 1.28e-05 1.8 1.28001e-05 0 1.3e-05 0 1.30001e-05 1.8 1.32e-05 1.8 1.32001e-05 0 1.34e-05 0 1.34001e-05 1.8 1.36e-05 1.8 1.36001e-05 0 1.38e-05 0 1.38001e-05 1.8 1.4e-05 1.8 1.40001e-05 0 1.42e-05 0 1.42001e-05 1.8 1.44e-05 1.8 1.44001e-05 0 1.46e-05 0 1.46001e-05 1.8 1.48e-05 1.8 1.48001e-05 0 1.5e-05 0 1.50001e-05 1.8 1.52e-05 1.8 1.52001e-05 0 1.54e-05 0 1.54001e-05 1.8 1.56e-05 1.8 1.56001e-05 0 1.58e-05 0 1.58001e-05 1.8 1.6e-05 1.8 1.60001e-05 0 1.62e-05 0 1.62001e-05 1.8 1.64e-05 1.8 1.64001e-05 0 1.66e-05 0 1.66001e-05 1.8 1.68e-05 1.8 1.68001e-05 0 1.7e-05 0 1.70001e-05 1.8 1.72e-05 1.8 1.72001e-05 0 1.74e-05 0 1.74001e-05 1.8 1.76e-05 1.8 1.76001e-05 0 1.78e-05 0 1.78001e-05 1.8 1.8e-05 1.8 1.80001e-05 0 1.82e-05 0 1.82001e-05 1.8 1.84e-05 1.8 1.84001e-05 0 1.86e-05 0 1.86001e-05 1.8 1.88e-05 1.8 1.88001e-05 0 1.9e-05 0 1.90001e-05 1.8 1.92e-05 1.8 1.92001e-05 0 1.94e-05 0 1.94001e-05 1.8 1.96e-05 1.8 1.96001e-05 0 1.98e-05 0 1.98001e-05 1.8 2e-05 1.8 2.00001e-05 0 2.02e-05 0 2.02001e-05 1.8 2.04e-05 1.8 2.04001e-05 0 2.06e-05 0 2.06001e-05 1.8 2.08e-05 1.8 2.08001e-05 0 2.1e-05 0 2.10001e-05 1.8 2.12e-05 1.8 2.12001e-05 0 2.14e-05 0 2.14001e-05 1.8 2.16e-05 1.8 2.16001e-05 0 2.18e-05 0 2.18001e-05 1.8 2.2e-05 1.8 2.20001e-05 0 2.22e-05 0 2.22001e-05 1.8 2.24e-05 1.8 2.24001e-05 0 2.26e-05 0 2.26001e-05 1.8 2.28e-05 1.8 2.28001e-05 0 2.3e-05 0 2.30001e-05 1.8 2.32e-05 1.8 2.32001e-05 0 2.34e-05 0 2.34001e-05 1.8 2.36e-05 1.8 2.36001e-05 0 2.38e-05 0 2.38001e-05 1.8 2.4e-05 1.8 2.40001e-05 0 2.42e-05 0 2.42001e-05 1.8 2.44e-05 1.8 2.44001e-05 0 2.46e-05 0 2.46001e-05 1.8 2.48e-05 1.8 2.48001e-05 0 2.5e-05 0 2.50001e-05 1.8 2.52e-05 1.8 2.52001e-05 0 2.54e-05 0 2.54001e-05 1.8 2.56e-05 1.8 2.56001e-05 0 2.58e-05 0 2.58001e-05 1.8 2.6e-05 1.8 2.60001e-05 0 2.62e-05 0 2.62001e-05 1.8 2.64e-05 1.8 2.64001e-05 0 2.66e-05 0 2.66001e-05 1.8 2.68e-05 1.8 2.68001e-05 0 2.7e-05 0 2.70001e-05 1.8 2.72e-05 1.8 2.72001e-05 0 2.74e-05 0 2.74001e-05 1.8 2.76e-05 1.8 2.76001e-05 0 2.78e-05 0 2.78001e-05 1.8 2.8e-05 1.8 2.80001e-05 0 2.82e-05 0 2.82001e-05 1.8 2.84e-05 1.8 2.84001e-05 0 2.86e-05 0 2.86001e-05 1.8 2.88e-05 1.8 2.88001e-05 0 2.9e-05 0 2.90001e-05 1.8 2.92e-05 1.8 2.92001e-05 0 2.94e-05 0 2.94001e-05 1.8 2.96e-05 1.8 2.96001e-05 0 2.98e-05 0 2.98001e-05 1.8 3e-05 1.8 3.00001e-05 0 3.02e-05 0 3.02001e-05 1.8 3.04e-05 1.8 3.04001e-05 0 3.06e-05 0 3.06001e-05 1.8 3.08e-05 1.8 3.08001e-05 0 3.1e-05 0 3.10001e-05 1.8 3.12e-05 1.8 3.12001e-05 0 3.14e-05 0 3.14001e-05 1.8 3.16e-05 1.8 3.16001e-05 0 3.18e-05 0 3.18001e-05 1.8 3.2e-05 1.8 3.20001e-05 0 3.22e-05 0 3.22001e-05 1.8 3.24e-05 1.8 3.24001e-05 0 3.26e-05 0 3.26001e-05 1.8 3.28e-05 1.8 3.28001e-05 0 3.3e-05 0 3.30001e-05 1.8 3.32e-05 1.8 3.32001e-05 0 3.34e-05 0 3.34001e-05 1.8 3.36e-05 1.8 3.36001e-05 0 3.38e-05 0 3.38001e-05 1.8 3.4e-05 1.8 3.40001e-05 0 3.42e-05 0 3.42001e-05 1.8 3.44e-05 1.8 3.44001e-05 0 3.46e-05 0 3.46001e-05 1.8 3.48e-05 1.8 3.48001e-05 0 3.5e-05 0 3.50001e-05 1.8 3.52e-05 1.8 3.52001e-05 0 3.54e-05 0 3.54001e-05 1.8 3.56e-05 1.8 3.56001e-05 0 3.58e-05 0 3.58001e-05 1.8 3.6e-05 1.8 3.60001e-05 0 3.62e-05 0 3.62001e-05 1.8 3.64e-05 1.8 3.64001e-05 0 3.66e-05 0 3.66001e-05 1.8 3.68e-05 1.8 3.68001e-05 0 3.7e-05 0 3.70001e-05 1.8 3.72e-05 1.8 3.72001e-05 0 3.74e-05 0 3.74001e-05 1.8 3.76e-05 1.8 3.76001e-05 0 3.78e-05 0 3.78001e-05 1.8 3.8e-05 1.8 3.80001e-05 0 3.82e-05 0 3.82001e-05 1.8 3.84e-05 1.8 3.84001e-05 0 3.86e-05 0 3.86001e-05 1.8 3.88e-05 1.8 3.88001e-05 0 3.9e-05 0 3.90001e-05 1.8 3.92e-05 1.8 3.92001e-05 0 3.94e-05 0 3.94001e-05 1.8 3.96e-05 1.8 3.96001e-05 0 3.98e-05 0 3.98001e-05 1.8 4e-05 1.8 4.00001e-05 0 4.02e-05 0 4.02001e-05 1.8 4.04e-05 1.8 4.04001e-05 0 4.06e-05 0 4.06001e-05 1.8 4.08e-05 1.8 4.08001e-05 0 4.1e-05 0 4.10001e-05 1.8 4.12e-05 1.8 4.12001e-05 0 4.14e-05 0 4.14001e-05 1.8 4.16e-05 1.8 4.16001e-05 0 4.18e-05 0 4.18001e-05 1.8 4.2e-05 1.8 4.20001e-05 0 4.22e-05 0 4.22001e-05 1.8 4.24e-05 1.8 4.24001e-05 0 4.26e-05 0 4.26001e-05 1.8 4.28e-05 1.8 4.28001e-05 0 4.3e-05 0 4.30001e-05 1.8 4.32e-05 1.8 4.32001e-05 0 4.34e-05 0 4.34001e-05 1.8 4.36e-05 1.8 4.36001e-05 0 4.38e-05 0 4.38001e-05 1.8 4.4e-05 1.8 4.40001e-05 0 4.42e-05 0 4.42001e-05 1.8 4.44e-05 1.8 4.44001e-05 0 4.46e-05 0 4.46001e-05 1.8 4.48e-05 1.8 4.48001e-05 0 4.5e-05 0 4.50001e-05 1.8 4.52e-05 1.8 4.52001e-05 0 4.54e-05 0 4.54001e-05 1.8 4.56e-05 1.8 4.56001e-05 0 4.58e-05 0 4.58001e-05 1.8 4.6e-05 1.8 4.60001e-05 0 4.62e-05 0 4.62001e-05 1.8 4.64e-05 1.8 4.64001e-05 0 4.66e-05 0 4.66001e-05 1.8 4.68e-05 1.8 4.68001e-05 0 4.7e-05 0 4.70001e-05 1.8 4.72e-05 1.8 4.72001e-05 0 4.74e-05 0 4.74001e-05 1.8 4.76e-05 1.8 4.76001e-05 0 4.78e-05 0 4.78001e-05 1.8 4.8e-05 1.8 4.80001e-05 0 4.82e-05 0 4.82001e-05 1.8 4.84e-05 1.8 4.84001e-05 0 4.86e-05 0 4.86001e-05 1.8 4.88e-05 1.8 4.88001e-05 0 4.9e-05 0 4.90001e-05 1.8 4.92e-05 1.8 4.92001e-05 0 4.94e-05 0 4.94001e-05 1.8 4.96e-05 1.8 4.96001e-05 0 4.98e-05 0 4.98001e-05 1.8 5e-05 1.8 5.00001e-05 0 5.02e-05 0 5.02001e-05 1.8 5.04e-05 1.8 5.04001e-05 0 5.06e-05 0 5.06001e-05 1.8 5.08e-05 1.8 5.08001e-05 0 5.1e-05 0 5.10001e-05 1.8 5.12e-05 1.8)
VB1 B1 VGND PWL(0 0 4e-07 0 4.001e-07 1.8 8e-07 1.8 8.001e-07 0 1.2e-06 0 1.2001e-06 1.8 1.6e-06 1.8 1.6001e-06 0 2e-06 0 2.0001e-06 1.8 2.4e-06 1.8 2.4001e-06 0 2.8e-06 0 2.8001e-06 1.8 3.2e-06 1.8 3.2001e-06 0 3.6e-06 0 3.6001e-06 1.8 4e-06 1.8 4.0001e-06 0 4.4e-06 0 4.4001e-06 1.8 4.8e-06 1.8 4.8001e-06 0 5.2e-06 0 5.2001e-06 1.8 5.6e-06 1.8 5.6001e-06 0 6e-06 0 6.0001e-06 1.8 6.4e-06 1.8 6.4001e-06 0 6.8e-06 0 6.8001e-06 1.8 7.2e-06 1.8 7.2001e-06 0 7.6e-06 0 7.6001e-06 1.8 8e-06 1.8 8.0001e-06 0 8.4e-06 0 8.4001e-06 1.8 8.8e-06 1.8 8.8001e-06 0 9.2e-06 0 9.2001e-06 1.8 9.6e-06 1.8 9.6001e-06 0 1e-05 0 1.00001e-05 1.8 1.04e-05 1.8 1.04001e-05 0 1.08e-05 0 1.08001e-05 1.8 1.12e-05 1.8 1.12001e-05 0 1.16e-05 0 1.16001e-05 1.8 1.2e-05 1.8 1.20001e-05 0 1.24e-05 0 1.24001e-05 1.8 1.28e-05 1.8 1.28001e-05 0 1.32e-05 0 1.32001e-05 1.8 1.36e-05 1.8 1.36001e-05 0 1.4e-05 0 1.40001e-05 1.8 1.44e-05 1.8 1.44001e-05 0 1.48e-05 0 1.48001e-05 1.8 1.52e-05 1.8 1.52001e-05 0 1.56e-05 0 1.56001e-05 1.8 1.6e-05 1.8 1.60001e-05 0 1.64e-05 0 1.64001e-05 1.8 1.68e-05 1.8 1.68001e-05 0 1.72e-05 0 1.72001e-05 1.8 1.76e-05 1.8 1.76001e-05 0 1.8e-05 0 1.80001e-05 1.8 1.84e-05 1.8 1.84001e-05 0 1.88e-05 0 1.88001e-05 1.8 1.92e-05 1.8 1.92001e-05 0 1.96e-05 0 1.96001e-05 1.8 2e-05 1.8 2.00001e-05 0 2.04e-05 0 2.04001e-05 1.8 2.08e-05 1.8 2.08001e-05 0 2.12e-05 0 2.12001e-05 1.8 2.16e-05 1.8 2.16001e-05 0 2.2e-05 0 2.20001e-05 1.8 2.24e-05 1.8 2.24001e-05 0 2.28e-05 0 2.28001e-05 1.8 2.32e-05 1.8 2.32001e-05 0 2.36e-05 0 2.36001e-05 1.8 2.4e-05 1.8 2.40001e-05 0 2.44e-05 0 2.44001e-05 1.8 2.48e-05 1.8 2.48001e-05 0 2.52e-05 0 2.52001e-05 1.8 2.56e-05 1.8 2.56001e-05 0 2.6e-05 0 2.60001e-05 1.8 2.64e-05 1.8 2.64001e-05 0 2.68e-05 0 2.68001e-05 1.8 2.72e-05 1.8 2.72001e-05 0 2.76e-05 0 2.76001e-05 1.8 2.8e-05 1.8 2.80001e-05 0 2.84e-05 0 2.84001e-05 1.8 2.88e-05 1.8 2.88001e-05 0 2.92e-05 0 2.92001e-05 1.8 2.96e-05 1.8 2.96001e-05 0 3e-05 0 3.00001e-05 1.8 3.04e-05 1.8 3.04001e-05 0 3.08e-05 0 3.08001e-05 1.8 3.12e-05 1.8 3.12001e-05 0 3.16e-05 0 3.16001e-05 1.8 3.2e-05 1.8 3.20001e-05 0 3.24e-05 0 3.24001e-05 1.8 3.28e-05 1.8 3.28001e-05 0 3.32e-05 0 3.32001e-05 1.8 3.36e-05 1.8 3.36001e-05 0 3.4e-05 0 3.40001e-05 1.8 3.44e-05 1.8 3.44001e-05 0 3.48e-05 0 3.48001e-05 1.8 3.52e-05 1.8 3.52001e-05 0 3.56e-05 0 3.56001e-05 1.8 3.6e-05 1.8 3.60001e-05 0 3.64e-05 0 3.64001e-05 1.8 3.68e-05 1.8 3.68001e-05 0 3.72e-05 0 3.72001e-05 1.8 3.76e-05 1.8 3.76001e-05 0 3.8e-05 0 3.80001e-05 1.8 3.84e-05 1.8 3.84001e-05 0 3.88e-05 0 3.88001e-05 1.8 3.92e-05 1.8 3.92001e-05 0 3.96e-05 0 3.96001e-05 1.8 4e-05 1.8 4.00001e-05 0 4.04e-05 0 4.04001e-05 1.8 4.08e-05 1.8 4.08001e-05 0 4.12e-05 0 4.12001e-05 1.8 4.16e-05 1.8 4.16001e-05 0 4.2e-05 0 4.20001e-05 1.8 4.24e-05 1.8 4.24001e-05 0 4.28e-05 0 4.28001e-05 1.8 4.32e-05 1.8 4.32001e-05 0 4.36e-05 0 4.36001e-05 1.8 4.4e-05 1.8 4.40001e-05 0 4.44e-05 0 4.44001e-05 1.8 4.48e-05 1.8 4.48001e-05 0 4.52e-05 0 4.52001e-05 1.8 4.56e-05 1.8 4.56001e-05 0 4.6e-05 0 4.60001e-05 1.8 4.64e-05 1.8 4.64001e-05 0 4.68e-05 0 4.68001e-05 1.8 4.72e-05 1.8 4.72001e-05 0 4.76e-05 0 4.76001e-05 1.8 4.8e-05 1.8 4.80001e-05 0 4.84e-05 0 4.84001e-05 1.8 4.88e-05 1.8 4.88001e-05 0 4.92e-05 0 4.92001e-05 1.8 4.96e-05 1.8 4.96001e-05 0 5e-05 0 5.00001e-05 1.8 5.04e-05 1.8 5.04001e-05 0 5.08e-05 0 5.08001e-05 1.8 5.12e-05 1.8)
VB2 B2 VGND PWL(0 0 8e-07 0 8.001e-07 1.8 1.6e-06 1.8 1.6001e-06 0 2.4e-06 0 2.4001e-06 1.8 3.2e-06 1.8 3.2001e-06 0 4e-06 0 4.0001e-06 1.8 4.8e-06 1.8 4.8001e-06 0 5.6e-06 0 5.6001e-06 1.8 6.4e-06 1.8 6.4001e-06 0 7.2e-06 0 7.2001e-06 1.8 8e-06 1.8 8.0001e-06 0 8.8e-06 0 8.8001e-06 1.8 9.6e-06 1.8 9.6001e-06 0 1.04e-05 0 1.04001e-05 1.8 1.12e-05 1.8 1.12001e-05 0 1.2e-05 0 1.20001e-05 1.8 1.28e-05 1.8 1.28001e-05 0 1.36e-05 0 1.36001e-05 1.8 1.44e-05 1.8 1.44001e-05 0 1.52e-05 0 1.52001e-05 1.8 1.6e-05 1.8 1.60001e-05 0 1.68e-05 0 1.68001e-05 1.8 1.76e-05 1.8 1.76001e-05 0 1.84e-05 0 1.84001e-05 1.8 1.92e-05 1.8 1.92001e-05 0 2e-05 0 2.00001e-05 1.8 2.08e-05 1.8 2.08001e-05 0 2.16e-05 0 2.16001e-05 1.8 2.24e-05 1.8 2.24001e-05 0 2.32e-05 0 2.32001e-05 1.8 2.4e-05 1.8 2.40001e-05 0 2.48e-05 0 2.48001e-05 1.8 2.56e-05 1.8 2.56001e-05 0 2.64e-05 0 2.64001e-05 1.8 2.72e-05 1.8 2.72001e-05 0 2.8e-05 0 2.80001e-05 1.8 2.88e-05 1.8 2.88001e-05 0 2.96e-05 0 2.96001e-05 1.8 3.04e-05 1.8 3.04001e-05 0 3.12e-05 0 3.12001e-05 1.8 3.2e-05 1.8 3.20001e-05 0 3.28e-05 0 3.28001e-05 1.8 3.36e-05 1.8 3.36001e-05 0 3.44e-05 0 3.44001e-05 1.8 3.52e-05 1.8 3.52001e-05 0 3.6e-05 0 3.60001e-05 1.8 3.68e-05 1.8 3.68001e-05 0 3.76e-05 0 3.76001e-05 1.8 3.84e-05 1.8 3.84001e-05 0 3.92e-05 0 3.92001e-05 1.8 4e-05 1.8 4.00001e-05 0 4.08e-05 0 4.08001e-05 1.8 4.16e-05 1.8 4.16001e-05 0 4.24e-05 0 4.24001e-05 1.8 4.32e-05 1.8 4.32001e-05 0 4.4e-05 0 4.40001e-05 1.8 4.48e-05 1.8 4.48001e-05 0 4.56e-05 0 4.56001e-05 1.8 4.64e-05 1.8 4.64001e-05 0 4.72e-05 0 4.72001e-05 1.8 4.8e-05 1.8 4.80001e-05 0 4.88e-05 0 4.88001e-05 1.8 4.96e-05 1.8 4.96001e-05 0 5.04e-05 0 5.04001e-05 1.8 5.12e-05 1.8)
VB3 B3 VGND PWL(0 0 1.6e-06 0 1.6001e-06 1.8 3.2e-06 1.8 3.2001e-06 0 4.8e-06 0 4.8001e-06 1.8 6.4e-06 1.8 6.4001e-06 0 8e-06 0 8.0001e-06 1.8 9.6e-06 1.8 9.6001e-06 0 1.12e-05 0 1.12001e-05 1.8 1.28e-05 1.8 1.28001e-05 0 1.44e-05 0 1.44001e-05 1.8 1.6e-05 1.8 1.60001e-05 0 1.76e-05 0 1.76001e-05 1.8 1.92e-05 1.8 1.92001e-05 0 2.08e-05 0 2.08001e-05 1.8 2.24e-05 1.8 2.24001e-05 0 2.4e-05 0 2.40001e-05 1.8 2.56e-05 1.8 2.56001e-05 0 2.72e-05 0 2.72001e-05 1.8 2.88e-05 1.8 2.88001e-05 0 3.04e-05 0 3.04001e-05 1.8 3.2e-05 1.8 3.20001e-05 0 3.36e-05 0 3.36001e-05 1.8 3.52e-05 1.8 3.52001e-05 0 3.68e-05 0 3.68001e-05 1.8 3.84e-05 1.8 3.84001e-05 0 4e-05 0 4.00001e-05 1.8 4.16e-05 1.8 4.16001e-05 0 4.32e-05 0 4.32001e-05 1.8 4.48e-05 1.8 4.48001e-05 0 4.64e-05 0 4.64001e-05 1.8 4.8e-05 1.8 4.80001e-05 0 4.96e-05 0 4.96001e-05 1.8 5.12e-05 1.8)
VCIN CIN VGND PWL(0 0 1e-07 0 1.001e-07 1.8 2e-07 1.8 2.001e-07 0 3e-07 0 3.001e-07 1.8 4e-07 1.8 4.001e-07 0 5e-07 0 5.001e-07 1.8 6e-07 1.8 6.001e-07 0 7e-07 0 7.001e-07 1.8 8e-07 1.8 8.001e-07 0 9e-07 0 9.001e-07 1.8 1e-06 1.8 1.0001e-06 0 1.1e-06 0 1.1001e-06 1.8 1.2e-06 1.8 1.2001e-06 0 1.3e-06 0 1.3001e-06 1.8 1.4e-06 1.8 1.4001e-06 0 1.5e-06 0 1.5001e-06 1.8 1.6e-06 1.8 1.6001e-06 0 1.7e-06 0 1.7001e-06 1.8 1.8e-06 1.8 1.8001e-06 0 1.9e-06 0 1.9001e-06 1.8 2e-06 1.8 2.0001e-06 0 2.1e-06 0 2.1001e-06 1.8 2.2e-06 1.8 2.2001e-06 0 2.3e-06 0 2.3001e-06 1.8 2.4e-06 1.8 2.4001e-06 0 2.5e-06 0 2.5001e-06 1.8 2.6e-06 1.8 2.6001e-06 0 2.7e-06 0 2.7001e-06 1.8 2.8e-06 1.8 2.8001e-06 0 2.9e-06 0 2.9001e-06 1.8 3e-06 1.8 3.0001e-06 0 3.1e-06 0 3.1001e-06 1.8 3.2e-06 1.8 3.2001e-06 0 3.3e-06 0 3.3001e-06 1.8 3.4e-06 1.8 3.4001e-06 0 3.5e-06 0 3.5001e-06 1.8 3.6e-06 1.8 3.6001e-06 0 3.7e-06 0 3.7001e-06 1.8 3.8e-06 1.8 3.8001e-06 0 3.9e-06 0 3.9001e-06 1.8 4e-06 1.8 4.0001e-06 0 4.1e-06 0 4.1001e-06 1.8 4.2e-06 1.8 4.2001e-06 0 4.3e-06 0 4.3001e-06 1.8 4.4e-06 1.8 4.4001e-06 0 4.5e-06 0 4.5001e-06 1.8 4.6e-06 1.8 4.6001e-06 0 4.7e-06 0 4.7001e-06 1.8 4.8e-06 1.8 4.8001e-06 0 4.9e-06 0 4.9001e-06 1.8 5e-06 1.8 5.0001e-06 0 5.1e-06 0 5.1001e-06 1.8 5.2e-06 1.8 5.2001e-06 0 5.3e-06 0 5.3001e-06 1.8 5.4e-06 1.8 5.4001e-06 0 5.5e-06 0 5.5001e-06 1.8 5.6e-06 1.8 5.6001e-06 0 5.7e-06 0 5.7001e-06 1.8 5.8e-06 1.8 5.8001e-06 0 5.9e-06 0 5.9001e-06 1.8 6e-06 1.8 6.0001e-06 0 6.1e-06 0 6.1001e-06 1.8 6.2e-06 1.8 6.2001e-06 0 6.3e-06 0 6.3001e-06 1.8 6.4e-06 1.8 6.4001e-06 0 6.5e-06 0 6.5001e-06 1.8 6.6e-06 1.8 6.6001e-06 0 6.7e-06 0 6.7001e-06 1.8 6.8e-06 1.8 6.8001e-06 0 6.9e-06 0 6.9001e-06 1.8 7e-06 1.8 7.0001e-06 0 7.1e-06 0 7.1001e-06 1.8 7.2e-06 1.8 7.2001e-06 0 7.3e-06 0 7.3001e-06 1.8 7.4e-06 1.8 7.4001e-06 0 7.5e-06 0 7.5001e-06 1.8 7.6e-06 1.8 7.6001e-06 0 7.7e-06 0 7.7001e-06 1.8 7.8e-06 1.8 7.8001e-06 0 7.9e-06 0 7.9001e-06 1.8 8e-06 1.8 8.0001e-06 0 8.1e-06 0 8.1001e-06 1.8 8.2e-06 1.8 8.2001e-06 0 8.3e-06 0 8.3001e-06 1.8 8.4e-06 1.8 8.4001e-06 0 8.5e-06 0 8.5001e-06 1.8 8.6e-06 1.8 8.6001e-06 0 8.7e-06 0 8.7001e-06 1.8 8.8e-06 1.8 8.8001e-06 0 8.9e-06 0 8.9001e-06 1.8 9e-06 1.8 9.0001e-06 0 9.1e-06 0 9.1001e-06 1.8 9.2e-06 1.8 9.2001e-06 0 9.3e-06 0 9.3001e-06 1.8 9.4e-06 1.8 9.4001e-06 0 9.5e-06 0 9.5001e-06 1.8 9.6e-06 1.8 9.6001e-06 0 9.7e-06 0 9.7001e-06 1.8 9.8e-06 1.8 9.8001e-06 0 9.9e-06 0 9.9001e-06 1.8 1e-05 1.8 1.00001e-05 0 1.01e-05 0 1.01001e-05 1.8 1.02e-05 1.8 1.02001e-05 0 1.03e-05 0 1.03001e-05 1.8 1.04e-05 1.8 1.04001e-05 0 1.05e-05 0 1.05001e-05 1.8 1.06e-05 1.8 1.06001e-05 0 1.07e-05 0 1.07001e-05 1.8 1.08e-05 1.8 1.08001e-05 0 1.09e-05 0 1.09001e-05 1.8 1.1e-05 1.8 1.10001e-05 0 1.11e-05 0 1.11001e-05 1.8 1.12e-05 1.8 1.12001e-05 0 1.13e-05 0 1.13001e-05 1.8 1.14e-05 1.8 1.14001e-05 0 1.15e-05 0 1.15001e-05 1.8 1.16e-05 1.8 1.16001e-05 0 1.17e-05 0 1.17001e-05 1.8 1.18e-05 1.8 1.18001e-05 0 1.19e-05 0 1.19001e-05 1.8 1.2e-05 1.8 1.20001e-05 0 1.21e-05 0 1.21001e-05 1.8 1.22e-05 1.8 1.22001e-05 0 1.23e-05 0 1.23001e-05 1.8 1.24e-05 1.8 1.24001e-05 0 1.25e-05 0 1.25001e-05 1.8 1.26e-05 1.8 1.26001e-05 0 1.27e-05 0 1.27001e-05 1.8 1.28e-05 1.8 1.28001e-05 0 1.29e-05 0 1.29001e-05 1.8 1.3e-05 1.8 1.30001e-05 0 1.31e-05 0 1.31001e-05 1.8 1.32e-05 1.8 1.32001e-05 0 1.33e-05 0 1.33001e-05 1.8 1.34e-05 1.8 1.34001e-05 0 1.35e-05 0 1.35001e-05 1.8 1.36e-05 1.8 1.36001e-05 0 1.37e-05 0 1.37001e-05 1.8 1.38e-05 1.8 1.38001e-05 0 1.39e-05 0 1.39001e-05 1.8 1.4e-05 1.8 1.40001e-05 0 1.41e-05 0 1.41001e-05 1.8 1.42e-05 1.8 1.42001e-05 0 1.43e-05 0 1.43001e-05 1.8 1.44e-05 1.8 1.44001e-05 0 1.45e-05 0 1.45001e-05 1.8 1.46e-05 1.8 1.46001e-05 0 1.47e-05 0 1.47001e-05 1.8 1.48e-05 1.8 1.48001e-05 0 1.49e-05 0 1.49001e-05 1.8 1.5e-05 1.8 1.50001e-05 0 1.51e-05 0 1.51001e-05 1.8 1.52e-05 1.8 1.52001e-05 0 1.53e-05 0 1.53001e-05 1.8 1.54e-05 1.8 1.54001e-05 0 1.55e-05 0 1.55001e-05 1.8 1.56e-05 1.8 1.56001e-05 0 1.57e-05 0 1.57001e-05 1.8 1.58e-05 1.8 1.58001e-05 0 1.59e-05 0 1.59001e-05 1.8 1.6e-05 1.8 1.60001e-05 0 1.61e-05 0 1.61001e-05 1.8 1.62e-05 1.8 1.62001e-05 0 1.63e-05 0 1.63001e-05 1.8 1.64e-05 1.8 1.64001e-05 0 1.65e-05 0 1.65001e-05 1.8 1.66e-05 1.8 1.66001e-05 0 1.67e-05 0 1.67001e-05 1.8 1.68e-05 1.8 1.68001e-05 0 1.69e-05 0 1.69001e-05 1.8 1.7e-05 1.8 1.70001e-05 0 1.71e-05 0 1.71001e-05 1.8 1.72e-05 1.8 1.72001e-05 0 1.73e-05 0 1.73001e-05 1.8 1.74e-05 1.8 1.74001e-05 0 1.75e-05 0 1.75001e-05 1.8 1.76e-05 1.8 1.76001e-05 0 1.77e-05 0 1.77001e-05 1.8 1.78e-05 1.8 1.78001e-05 0 1.79e-05 0 1.79001e-05 1.8 1.8e-05 1.8 1.80001e-05 0 1.81e-05 0 1.81001e-05 1.8 1.82e-05 1.8 1.82001e-05 0 1.83e-05 0 1.83001e-05 1.8 1.84e-05 1.8 1.84001e-05 0 1.85e-05 0 1.85001e-05 1.8 1.86e-05 1.8 1.86001e-05 0 1.87e-05 0 1.87001e-05 1.8 1.88e-05 1.8 1.88001e-05 0 1.89e-05 0 1.89001e-05 1.8 1.9e-05 1.8 1.90001e-05 0 1.91e-05 0 1.91001e-05 1.8 1.92e-05 1.8 1.92001e-05 0 1.93e-05 0 1.93001e-05 1.8 1.94e-05 1.8 1.94001e-05 0 1.95e-05 0 1.95001e-05 1.8 1.96e-05 1.8 1.96001e-05 0 1.97e-05 0 1.97001e-05 1.8 1.98e-05 1.8 1.98001e-05 0 1.99e-05 0 1.99001e-05 1.8 2e-05 1.8 2.00001e-05 0 2.01e-05 0 2.01001e-05 1.8 2.02e-05 1.8 2.02001e-05 0 2.03e-05 0 2.03001e-05 1.8 2.04e-05 1.8 2.04001e-05 0 2.05e-05 0 2.05001e-05 1.8 2.06e-05 1.8 2.06001e-05 0 2.07e-05 0 2.07001e-05 1.8 2.08e-05 1.8 2.08001e-05 0 2.09e-05 0 2.09001e-05 1.8 2.1e-05 1.8 2.10001e-05 0 2.11e-05 0 2.11001e-05 1.8 2.12e-05 1.8 2.12001e-05 0 2.13e-05 0 2.13001e-05 1.8 2.14e-05 1.8 2.14001e-05 0 2.15e-05 0 2.15001e-05 1.8 2.16e-05 1.8 2.16001e-05 0 2.17e-05 0 2.17001e-05 1.8 2.18e-05 1.8 2.18001e-05 0 2.19e-05 0 2.19001e-05 1.8 2.2e-05 1.8 2.20001e-05 0 2.21e-05 0 2.21001e-05 1.8 2.22e-05 1.8 2.22001e-05 0 2.23e-05 0 2.23001e-05 1.8 2.24e-05 1.8 2.24001e-05 0 2.25e-05 0 2.25001e-05 1.8 2.26e-05 1.8 2.26001e-05 0 2.27e-05 0 2.27001e-05 1.8 2.28e-05 1.8 2.28001e-05 0 2.29e-05 0 2.29001e-05 1.8 2.3e-05 1.8 2.30001e-05 0 2.31e-05 0 2.31001e-05 1.8 2.32e-05 1.8 2.32001e-05 0 2.33e-05 0 2.33001e-05 1.8 2.34e-05 1.8 2.34001e-05 0 2.35e-05 0 2.35001e-05 1.8 2.36e-05 1.8 2.36001e-05 0 2.37e-05 0 2.37001e-05 1.8 2.38e-05 1.8 2.38001e-05 0 2.39e-05 0 2.39001e-05 1.8 2.4e-05 1.8 2.40001e-05 0 2.41e-05 0 2.41001e-05 1.8 2.42e-05 1.8 2.42001e-05 0 2.43e-05 0 2.43001e-05 1.8 2.44e-05 1.8 2.44001e-05 0 2.45e-05 0 2.45001e-05 1.8 2.46e-05 1.8 2.46001e-05 0 2.47e-05 0 2.47001e-05 1.8 2.48e-05 1.8 2.48001e-05 0 2.49e-05 0 2.49001e-05 1.8 2.5e-05 1.8 2.50001e-05 0 2.51e-05 0 2.51001e-05 1.8 2.52e-05 1.8 2.52001e-05 0 2.53e-05 0 2.53001e-05 1.8 2.54e-05 1.8 2.54001e-05 0 2.55e-05 0 2.55001e-05 1.8 2.56e-05 1.8 2.56001e-05 0 2.57e-05 0 2.57001e-05 1.8 2.58e-05 1.8 2.58001e-05 0 2.59e-05 0 2.59001e-05 1.8 2.6e-05 1.8 2.60001e-05 0 2.61e-05 0 2.61001e-05 1.8 2.62e-05 1.8 2.62001e-05 0 2.63e-05 0 2.63001e-05 1.8 2.64e-05 1.8 2.64001e-05 0 2.65e-05 0 2.65001e-05 1.8 2.66e-05 1.8 2.66001e-05 0 2.67e-05 0 2.67001e-05 1.8 2.68e-05 1.8 2.68001e-05 0 2.69e-05 0 2.69001e-05 1.8 2.7e-05 1.8 2.70001e-05 0 2.71e-05 0 2.71001e-05 1.8 2.72e-05 1.8 2.72001e-05 0 2.73e-05 0 2.73001e-05 1.8 2.74e-05 1.8 2.74001e-05 0 2.75e-05 0 2.75001e-05 1.8 2.76e-05 1.8 2.76001e-05 0 2.77e-05 0 2.77001e-05 1.8 2.78e-05 1.8 2.78001e-05 0 2.79e-05 0 2.79001e-05 1.8 2.8e-05 1.8 2.80001e-05 0 2.81e-05 0 2.81001e-05 1.8 2.82e-05 1.8 2.82001e-05 0 2.83e-05 0 2.83001e-05 1.8 2.84e-05 1.8 2.84001e-05 0 2.85e-05 0 2.85001e-05 1.8 2.86e-05 1.8 2.86001e-05 0 2.87e-05 0 2.87001e-05 1.8 2.88e-05 1.8 2.88001e-05 0 2.89e-05 0 2.89001e-05 1.8 2.9e-05 1.8 2.90001e-05 0 2.91e-05 0 2.91001e-05 1.8 2.92e-05 1.8 2.92001e-05 0 2.93e-05 0 2.93001e-05 1.8 2.94e-05 1.8 2.94001e-05 0 2.95e-05 0 2.95001e-05 1.8 2.96e-05 1.8 2.96001e-05 0 2.97e-05 0 2.97001e-05 1.8 2.98e-05 1.8 2.98001e-05 0 2.99e-05 0 2.99001e-05 1.8 3e-05 1.8 3.00001e-05 0 3.01e-05 0 3.01001e-05 1.8 3.02e-05 1.8 3.02001e-05 0 3.03e-05 0 3.03001e-05 1.8 3.04e-05 1.8 3.04001e-05 0 3.05e-05 0 3.05001e-05 1.8 3.06e-05 1.8 3.06001e-05 0 3.07e-05 0 3.07001e-05 1.8 3.08e-05 1.8 3.08001e-05 0 3.09e-05 0 3.09001e-05 1.8 3.1e-05 1.8 3.10001e-05 0 3.11e-05 0 3.11001e-05 1.8 3.12e-05 1.8 3.12001e-05 0 3.13e-05 0 3.13001e-05 1.8 3.14e-05 1.8 3.14001e-05 0 3.15e-05 0 3.15001e-05 1.8 3.16e-05 1.8 3.16001e-05 0 3.17e-05 0 3.17001e-05 1.8 3.18e-05 1.8 3.18001e-05 0 3.19e-05 0 3.19001e-05 1.8 3.2e-05 1.8 3.20001e-05 0 3.21e-05 0 3.21001e-05 1.8 3.22e-05 1.8 3.22001e-05 0 3.23e-05 0 3.23001e-05 1.8 3.24e-05 1.8 3.24001e-05 0 3.25e-05 0 3.25001e-05 1.8 3.26e-05 1.8 3.26001e-05 0 3.27e-05 0 3.27001e-05 1.8 3.28e-05 1.8 3.28001e-05 0 3.29e-05 0 3.29001e-05 1.8 3.3e-05 1.8 3.30001e-05 0 3.31e-05 0 3.31001e-05 1.8 3.32e-05 1.8 3.32001e-05 0 3.33e-05 0 3.33001e-05 1.8 3.34e-05 1.8 3.34001e-05 0 3.35e-05 0 3.35001e-05 1.8 3.36e-05 1.8 3.36001e-05 0 3.37e-05 0 3.37001e-05 1.8 3.38e-05 1.8 3.38001e-05 0 3.39e-05 0 3.39001e-05 1.8 3.4e-05 1.8 3.40001e-05 0 3.41e-05 0 3.41001e-05 1.8 3.42e-05 1.8 3.42001e-05 0 3.43e-05 0 3.43001e-05 1.8 3.44e-05 1.8 3.44001e-05 0 3.45e-05 0 3.45001e-05 1.8 3.46e-05 1.8 3.46001e-05 0 3.47e-05 0 3.47001e-05 1.8 3.48e-05 1.8 3.48001e-05 0 3.49e-05 0 3.49001e-05 1.8 3.5e-05 1.8 3.50001e-05 0 3.51e-05 0 3.51001e-05 1.8 3.52e-05 1.8 3.52001e-05 0 3.53e-05 0 3.53001e-05 1.8 3.54e-05 1.8 3.54001e-05 0 3.55e-05 0 3.55001e-05 1.8 3.56e-05 1.8 3.56001e-05 0 3.57e-05 0 3.57001e-05 1.8 3.58e-05 1.8 3.58001e-05 0 3.59e-05 0 3.59001e-05 1.8 3.6e-05 1.8 3.60001e-05 0 3.61e-05 0 3.61001e-05 1.8 3.62e-05 1.8 3.62001e-05 0 3.63e-05 0 3.63001e-05 1.8 3.64e-05 1.8 3.64001e-05 0 3.65e-05 0 3.65001e-05 1.8 3.66e-05 1.8 3.66001e-05 0 3.67e-05 0 3.67001e-05 1.8 3.68e-05 1.8 3.68001e-05 0 3.69e-05 0 3.69001e-05 1.8 3.7e-05 1.8 3.70001e-05 0 3.71e-05 0 3.71001e-05 1.8 3.72e-05 1.8 3.72001e-05 0 3.73e-05 0 3.73001e-05 1.8 3.74e-05 1.8 3.74001e-05 0 3.75e-05 0 3.75001e-05 1.8 3.76e-05 1.8 3.76001e-05 0 3.77e-05 0 3.77001e-05 1.8 3.78e-05 1.8 3.78001e-05 0 3.79e-05 0 3.79001e-05 1.8 3.8e-05 1.8 3.80001e-05 0 3.81e-05 0 3.81001e-05 1.8 3.82e-05 1.8 3.82001e-05 0 3.83e-05 0 3.83001e-05 1.8 3.84e-05 1.8 3.84001e-05 0 3.85e-05 0 3.85001e-05 1.8 3.86e-05 1.8 3.86001e-05 0 3.87e-05 0 3.87001e-05 1.8 3.88e-05 1.8 3.88001e-05 0 3.89e-05 0 3.89001e-05 1.8 3.9e-05 1.8 3.90001e-05 0 3.91e-05 0 3.91001e-05 1.8 3.92e-05 1.8 3.92001e-05 0 3.93e-05 0 3.93001e-05 1.8 3.94e-05 1.8 3.94001e-05 0 3.95e-05 0 3.95001e-05 1.8 3.96e-05 1.8 3.96001e-05 0 3.97e-05 0 3.97001e-05 1.8 3.98e-05 1.8 3.98001e-05 0 3.99e-05 0 3.99001e-05 1.8 4e-05 1.8 4.00001e-05 0 4.01e-05 0 4.01001e-05 1.8 4.02e-05 1.8 4.02001e-05 0 4.03e-05 0 4.03001e-05 1.8 4.04e-05 1.8 4.04001e-05 0 4.05e-05 0 4.05001e-05 1.8 4.06e-05 1.8 4.06001e-05 0 4.07e-05 0 4.07001e-05 1.8 4.08e-05 1.8 4.08001e-05 0 4.09e-05 0 4.09001e-05 1.8 4.1e-05 1.8 4.10001e-05 0 4.11e-05 0 4.11001e-05 1.8 4.12e-05 1.8 4.12001e-05 0 4.13e-05 0 4.13001e-05 1.8 4.14e-05 1.8 4.14001e-05 0 4.15e-05 0 4.15001e-05 1.8 4.16e-05 1.8 4.16001e-05 0 4.17e-05 0 4.17001e-05 1.8 4.18e-05 1.8 4.18001e-05 0 4.19e-05 0 4.19001e-05 1.8 4.2e-05 1.8 4.20001e-05 0 4.21e-05 0 4.21001e-05 1.8 4.22e-05 1.8 4.22001e-05 0 4.23e-05 0 4.23001e-05 1.8 4.24e-05 1.8 4.24001e-05 0 4.25e-05 0 4.25001e-05 1.8 4.26e-05 1.8 4.26001e-05 0 4.27e-05 0 4.27001e-05 1.8 4.28e-05 1.8 4.28001e-05 0 4.29e-05 0 4.29001e-05 1.8 4.3e-05 1.8 4.30001e-05 0 4.31e-05 0 4.31001e-05 1.8 4.32e-05 1.8 4.32001e-05 0 4.33e-05 0 4.33001e-05 1.8 4.34e-05 1.8 4.34001e-05 0 4.35e-05 0 4.35001e-05 1.8 4.36e-05 1.8 4.36001e-05 0 4.37e-05 0 4.37001e-05 1.8 4.38e-05 1.8 4.38001e-05 0 4.39e-05 0 4.39001e-05 1.8 4.4e-05 1.8 4.40001e-05 0 4.41e-05 0 4.41001e-05 1.8 4.42e-05 1.8 4.42001e-05 0 4.43e-05 0 4.43001e-05 1.8 4.44e-05 1.8 4.44001e-05 0 4.45e-05 0 4.45001e-05 1.8 4.46e-05 1.8 4.46001e-05 0 4.47e-05 0 4.47001e-05 1.8 4.48e-05 1.8 4.48001e-05 0 4.49e-05 0 4.49001e-05 1.8 4.5e-05 1.8 4.50001e-05 0 4.51e-05 0 4.51001e-05 1.8 4.52e-05 1.8 4.52001e-05 0 4.53e-05 0 4.53001e-05 1.8 4.54e-05 1.8 4.54001e-05 0 4.55e-05 0 4.55001e-05 1.8 4.56e-05 1.8 4.56001e-05 0 4.57e-05 0 4.57001e-05 1.8 4.58e-05 1.8 4.58001e-05 0 4.59e-05 0 4.59001e-05 1.8 4.6e-05 1.8 4.60001e-05 0 4.61e-05 0 4.61001e-05 1.8 4.62e-05 1.8 4.62001e-05 0 4.63e-05 0 4.63001e-05 1.8 4.64e-05 1.8 4.64001e-05 0 4.65e-05 0 4.65001e-05 1.8 4.66e-05 1.8 4.66001e-05 0 4.67e-05 0 4.67001e-05 1.8 4.68e-05 1.8 4.68001e-05 0 4.69e-05 0 4.69001e-05 1.8 4.7e-05 1.8 4.70001e-05 0 4.71e-05 0 4.71001e-05 1.8 4.72e-05 1.8 4.72001e-05 0 4.73e-05 0 4.73001e-05 1.8 4.74e-05 1.8 4.74001e-05 0 4.75e-05 0 4.75001e-05 1.8 4.76e-05 1.8 4.76001e-05 0 4.77e-05 0 4.77001e-05 1.8 4.78e-05 1.8 4.78001e-05 0 4.79e-05 0 4.79001e-05 1.8 4.8e-05 1.8 4.80001e-05 0 4.81e-05 0 4.81001e-05 1.8 4.82e-05 1.8 4.82001e-05 0 4.83e-05 0 4.83001e-05 1.8 4.84e-05 1.8 4.84001e-05 0 4.85e-05 0 4.85001e-05 1.8 4.86e-05 1.8 4.86001e-05 0 4.87e-05 0 4.87001e-05 1.8 4.88e-05 1.8 4.88001e-05 0 4.89e-05 0 4.89001e-05 1.8 4.9e-05 1.8 4.90001e-05 0 4.91e-05 0 4.91001e-05 1.8 4.92e-05 1.8 4.92001e-05 0 4.93e-05 0 4.93001e-05 1.8 4.94e-05 1.8 4.94001e-05 0 4.95e-05 0 4.95001e-05 1.8 4.96e-05 1.8 4.96001e-05 0 4.97e-05 0 4.97001e-05 1.8 4.98e-05 1.8 4.98001e-05 0 4.99e-05 0 4.99001e-05 1.8 5e-05 1.8 5.00001e-05 0 5.01e-05 0 5.01001e-05 1.8 5.02e-05 1.8 5.02001e-05 0 5.03e-05 0 5.03001e-05 1.8 5.04e-05 1.8 5.04001e-05 0 5.05e-05 0 5.05001e-05 1.8 5.06e-05 1.8 5.06001e-05 0 5.07e-05 0 5.07001e-05 1.8 5.08e-05 1.8 5.08001e-05 0 5.09e-05 0 5.09001e-05 1.8 5.1e-05 1.8 5.10001e-05 0 5.11e-05 0 5.11001e-05 1.8 5.12e-05 1.8)
CLOAD_S0 S0 VGND 5e-15
CLOAD_S1 S1 VGND 5e-15
CLOAD_S2 S2 VGND 5e-15
CLOAD_S3 S3 VGND 5e-15
CLOAD_COUT COUT VGND 5e-15
XU A0 A1 A2 A3 B0 B1 B2 B3 CIN S0 S1 S2 S3 COUT VPWR VGND adder4
.control
save v(A0) v(A1) v(A2) v(A3) v(B0) v(B1) v(B2) v(B3) v(CIN) v(S0) v(S1) v(S2) v(S3) v(COUT) i(VDD) i(v.xu.xbit0.xn1.vregister_cf_377cff7a8fc053f0) i(v.xu.xbit0.xn1.vregister_cf_12c0ec391985518a) i(v.xu.xbit0.xn1.vregister_cf_1c0f6f4ae9f406c8) i(v.xu.xbit0.xn1.vregister_cf_092f3ee2a80b5958) i(v.xu.xbit0.xn2.vregister_cf_377cff7a8fc053f0) i(v.xu.xbit0.xn2.vregister_cf_12c0ec391985518a) i(v.xu.xbit0.xn2.vregister_cf_1c0f6f4ae9f406c8) i(v.xu.xbit0.xn2.vregister_cf_092f3ee2a80b5958) i(v.xu.xbit0.xn3.vregister_cf_377cff7a8fc053f0) i(v.xu.xbit0.xn3.vregister_cf_12c0ec391985518a) i(v.xu.xbit0.xn3.vregister_cf_1c0f6f4ae9f406c8) i(v.xu.xbit0.xn3.vregister_cf_092f3ee2a80b5958) i(v.xu.xbit0.xn4.vregister_cf_377cff7a8fc053f0) i(v.xu.xbit0.xn4.vregister_cf_12c0ec391985518a) i(v.xu.xbit0.xn4.vregister_cf_1c0f6f4ae9f406c8) i(v.xu.xbit0.xn4.vregister_cf_092f3ee2a80b5958) i(v.xu.xbit0.xn5.vregister_cf_377cff7a8fc053f0) i(v.xu.xbit0.xn5.vregister_cf_12c0ec391985518a) i(v.xu.xbit0.xn5.vregister_cf_1c0f6f4ae9f406c8) i(v.xu.xbit0.xn5.vregister_cf_092f3ee2a80b5958) i(v.xu.xbit0.xn6.vregister_cf_377cff7a8fc053f0) i(v.xu.xbit0.xn6.vregister_cf_12c0ec391985518a) i(v.xu.xbit0.xn6.vregister_cf_1c0f6f4ae9f406c8) i(v.xu.xbit0.xn6.vregister_cf_092f3ee2a80b5958) i(v.xu.xbit0.xn7.vregister_cf_377cff7a8fc053f0) i(v.xu.xbit0.xn7.vregister_cf_12c0ec391985518a) i(v.xu.xbit0.xn7.vregister_cf_1c0f6f4ae9f406c8) i(v.xu.xbit0.xn7.vregister_cf_092f3ee2a80b5958) i(v.xu.xbit0.xn8.vregister_cf_377cff7a8fc053f0) i(v.xu.xbit0.xn8.vregister_cf_12c0ec391985518a) i(v.xu.xbit0.xn8.vregister_cf_1c0f6f4ae9f406c8) i(v.xu.xbit0.xn8.vregister_cf_092f3ee2a80b5958) i(v.xu.xbit0.xn9.vregister_cf_377cff7a8fc053f0) i(v.xu.xbit0.xn9.vregister_cf_12c0ec391985518a) i(v.xu.xbit0.xn9.vregister_cf_1c0f6f4ae9f406c8) i(v.xu.xbit0.xn9.vregister_cf_092f3ee2a80b5958) i(v.xu.xbit1.xn1.vregister_cf_377cff7a8fc053f0) i(v.xu.xbit1.xn1.vregister_cf_12c0ec391985518a) i(v.xu.xbit1.xn1.vregister_cf_1c0f6f4ae9f406c8) i(v.xu.xbit1.xn1.vregister_cf_092f3ee2a80b5958) i(v.xu.xbit1.xn2.vregister_cf_377cff7a8fc053f0) i(v.xu.xbit1.xn2.vregister_cf_12c0ec391985518a) i(v.xu.xbit1.xn2.vregister_cf_1c0f6f4ae9f406c8) i(v.xu.xbit1.xn2.vregister_cf_092f3ee2a80b5958) i(v.xu.xbit1.xn3.vregister_cf_377cff7a8fc053f0) i(v.xu.xbit1.xn3.vregister_cf_12c0ec391985518a) i(v.xu.xbit1.xn3.vregister_cf_1c0f6f4ae9f406c8) i(v.xu.xbit1.xn3.vregister_cf_092f3ee2a80b5958) i(v.xu.xbit1.xn4.vregister_cf_377cff7a8fc053f0) i(v.xu.xbit1.xn4.vregister_cf_12c0ec391985518a) i(v.xu.xbit1.xn4.vregister_cf_1c0f6f4ae9f406c8) i(v.xu.xbit1.xn4.vregister_cf_092f3ee2a80b5958) i(v.xu.xbit1.xn5.vregister_cf_377cff7a8fc053f0) i(v.xu.xbit1.xn5.vregister_cf_12c0ec391985518a) i(v.xu.xbit1.xn5.vregister_cf_1c0f6f4ae9f406c8) i(v.xu.xbit1.xn5.vregister_cf_092f3ee2a80b5958) i(VGND) i(VA0) i(VA1) i(VA2) i(VA3) i(VB0) i(VB1) v(XU.XBIT0.N1) v(XU.XBIT0.XN1.N1) v(VGND) v(VPWR) v(XU.XBIT0.N2) v(XU.XBIT0.XN2.N1) v(XU.XBIT0.N3) v(XU.XBIT0.XN3.N1) v(XU.XBIT0.P) v(XU.XBIT0.XN4.N1) v(XU.XBIT0.N5) v(XU.XBIT0.XN5.N1) v(XU.XBIT0.N6) v(XU.XBIT0.XN6.N1) v(XU.XBIT0.N7) v(XU.XBIT0.XN7.N1) v(XU.XBIT0.XN8.N1) v(XU.C1) v(XU.XBIT0.XN9.N1) v(XU.XBIT1.N1) v(XU.XBIT1.XN1.N1) v(XU.XBIT1.N2) v(XU.XBIT1.XN2.N1) v(XU.XBIT1.N3) v(XU.XBIT1.XN3.N1) v(XU.XBIT1.P) v(XU.XBIT1.XN4.N1) v(XU.XBIT1.N5) v(XU.XBIT1.XN5.N1)
set num_threads=1
set noaskquit
set wr_singlescale
set wr_vecnames
tran 1e-09 5.12e-05
let mos_wave_0 = v(A0)
let mos_wave_1 = v(A1)
let mos_wave_2 = v(A2)
let mos_wave_3 = v(A3)
let mos_wave_4 = v(B0)
let mos_wave_5 = v(B1)
let mos_wave_6 = v(B2)
let mos_wave_7 = v(B3)
let mos_wave_8 = v(CIN)
let mos_wave_9 = v(S0)
let mos_wave_10 = v(S1)
let mos_wave_11 = v(S2)
let mos_wave_12 = v(S3)
let mos_wave_13 = v(COUT)
let mos_wave_14 = -i(VDD)
wrdata waveform.dat mos_wave_0 mos_wave_1 mos_wave_2 mos_wave_3 mos_wave_4 mos_wave_5 mos_wave_6 mos_wave_7 mos_wave_8 mos_wave_9 mos_wave_10 mos_wave_11 mos_wave_12 mos_wave_13 mos_wave_14
write waveform.raw all
let register_flow_0 = i(v.xu.xbit0.xn1.vregister_cf_377cff7a8fc053f0)
let register_flow_1 = i(v.xu.xbit0.xn1.vregister_cf_12c0ec391985518a)
let register_flow_2 = i(v.xu.xbit0.xn1.vregister_cf_1c0f6f4ae9f406c8)
let register_flow_3 = i(v.xu.xbit0.xn1.vregister_cf_092f3ee2a80b5958)
let register_flow_4 = i(v.xu.xbit0.xn2.vregister_cf_377cff7a8fc053f0)
let register_flow_5 = i(v.xu.xbit0.xn2.vregister_cf_12c0ec391985518a)
let register_flow_6 = i(v.xu.xbit0.xn2.vregister_cf_1c0f6f4ae9f406c8)
let register_flow_7 = i(v.xu.xbit0.xn2.vregister_cf_092f3ee2a80b5958)
let register_flow_8 = i(v.xu.xbit0.xn3.vregister_cf_377cff7a8fc053f0)
let register_flow_9 = i(v.xu.xbit0.xn3.vregister_cf_12c0ec391985518a)
let register_flow_10 = i(v.xu.xbit0.xn3.vregister_cf_1c0f6f4ae9f406c8)
let register_flow_11 = i(v.xu.xbit0.xn3.vregister_cf_092f3ee2a80b5958)
let register_flow_12 = i(v.xu.xbit0.xn4.vregister_cf_377cff7a8fc053f0)
let register_flow_13 = i(v.xu.xbit0.xn4.vregister_cf_12c0ec391985518a)
let register_flow_14 = i(v.xu.xbit0.xn4.vregister_cf_1c0f6f4ae9f406c8)
let register_flow_15 = i(v.xu.xbit0.xn4.vregister_cf_092f3ee2a80b5958)
let register_flow_16 = i(v.xu.xbit0.xn5.vregister_cf_377cff7a8fc053f0)
let register_flow_17 = i(v.xu.xbit0.xn5.vregister_cf_12c0ec391985518a)
let register_flow_18 = i(v.xu.xbit0.xn5.vregister_cf_1c0f6f4ae9f406c8)
let register_flow_19 = i(v.xu.xbit0.xn5.vregister_cf_092f3ee2a80b5958)
let register_flow_20 = i(v.xu.xbit0.xn6.vregister_cf_377cff7a8fc053f0)
let register_flow_21 = i(v.xu.xbit0.xn6.vregister_cf_12c0ec391985518a)
let register_flow_22 = i(v.xu.xbit0.xn6.vregister_cf_1c0f6f4ae9f406c8)
let register_flow_23 = i(v.xu.xbit0.xn6.vregister_cf_092f3ee2a80b5958)
let register_flow_24 = i(v.xu.xbit0.xn7.vregister_cf_377cff7a8fc053f0)
let register_flow_25 = i(v.xu.xbit0.xn7.vregister_cf_12c0ec391985518a)
let register_flow_26 = i(v.xu.xbit0.xn7.vregister_cf_1c0f6f4ae9f406c8)
let register_flow_27 = i(v.xu.xbit0.xn7.vregister_cf_092f3ee2a80b5958)
let register_flow_28 = i(v.xu.xbit0.xn8.vregister_cf_377cff7a8fc053f0)
let register_flow_29 = i(v.xu.xbit0.xn8.vregister_cf_12c0ec391985518a)
let register_flow_30 = i(v.xu.xbit0.xn8.vregister_cf_1c0f6f4ae9f406c8)
let register_flow_31 = i(v.xu.xbit0.xn8.vregister_cf_092f3ee2a80b5958)
let register_flow_32 = i(v.xu.xbit0.xn9.vregister_cf_377cff7a8fc053f0)
let register_flow_33 = i(v.xu.xbit0.xn9.vregister_cf_12c0ec391985518a)
let register_flow_34 = i(v.xu.xbit0.xn9.vregister_cf_1c0f6f4ae9f406c8)
let register_flow_35 = i(v.xu.xbit0.xn9.vregister_cf_092f3ee2a80b5958)
let register_flow_36 = i(v.xu.xbit1.xn1.vregister_cf_377cff7a8fc053f0)
let register_flow_37 = i(v.xu.xbit1.xn1.vregister_cf_12c0ec391985518a)
let register_flow_38 = i(v.xu.xbit1.xn1.vregister_cf_1c0f6f4ae9f406c8)
let register_flow_39 = i(v.xu.xbit1.xn1.vregister_cf_092f3ee2a80b5958)
let register_flow_40 = i(v.xu.xbit1.xn2.vregister_cf_377cff7a8fc053f0)
let register_flow_41 = i(v.xu.xbit1.xn2.vregister_cf_12c0ec391985518a)
let register_flow_42 = i(v.xu.xbit1.xn2.vregister_cf_1c0f6f4ae9f406c8)
let register_flow_43 = i(v.xu.xbit1.xn2.vregister_cf_092f3ee2a80b5958)
let register_flow_44 = i(v.xu.xbit1.xn3.vregister_cf_377cff7a8fc053f0)
let register_flow_45 = i(v.xu.xbit1.xn3.vregister_cf_12c0ec391985518a)
let register_flow_46 = i(v.xu.xbit1.xn3.vregister_cf_1c0f6f4ae9f406c8)
let register_flow_47 = i(v.xu.xbit1.xn3.vregister_cf_092f3ee2a80b5958)
let register_flow_48 = i(v.xu.xbit1.xn4.vregister_cf_377cff7a8fc053f0)
let register_flow_49 = i(v.xu.xbit1.xn4.vregister_cf_12c0ec391985518a)
let register_flow_50 = i(v.xu.xbit1.xn4.vregister_cf_1c0f6f4ae9f406c8)
let register_flow_51 = i(v.xu.xbit1.xn4.vregister_cf_092f3ee2a80b5958)
let register_flow_52 = i(v.xu.xbit1.xn5.vregister_cf_377cff7a8fc053f0)
let register_flow_53 = i(v.xu.xbit1.xn5.vregister_cf_12c0ec391985518a)
let register_flow_54 = i(v.xu.xbit1.xn5.vregister_cf_1c0f6f4ae9f406c8)
let register_flow_55 = i(v.xu.xbit1.xn5.vregister_cf_092f3ee2a80b5958)
let register_flow_56 = i(VGND)
let register_flow_57 = i(VDD)
let register_flow_58 = i(VA0)
let register_flow_59 = i(VA1)
let register_flow_60 = i(VA2)
let register_flow_61 = i(VA3)
let register_flow_62 = i(VB0)
let register_flow_63 = i(VB1)
wrdata current-flow.dat register_flow_0 register_flow_1 register_flow_2 register_flow_3 register_flow_4 register_flow_5 register_flow_6 register_flow_7 register_flow_8 register_flow_9 register_flow_10 register_flow_11 register_flow_12 register_flow_13 register_flow_14 register_flow_15 register_flow_16 register_flow_17 register_flow_18 register_flow_19 register_flow_20 register_flow_21 register_flow_22 register_flow_23 register_flow_24 register_flow_25 register_flow_26 register_flow_27 register_flow_28 register_flow_29 register_flow_30 register_flow_31 register_flow_32 register_flow_33 register_flow_34 register_flow_35 register_flow_36 register_flow_37 register_flow_38 register_flow_39 register_flow_40 register_flow_41 register_flow_42 register_flow_43 register_flow_44 register_flow_45 register_flow_46 register_flow_47 register_flow_48 register_flow_49 register_flow_50 register_flow_51 register_flow_52 register_flow_53 register_flow_54 register_flow_55 register_flow_56 register_flow_57 register_flow_58 register_flow_59 register_flow_60 register_flow_61 register_flow_62 register_flow_63
let register_voltage_0 = v(XU.XBIT0.N1)
let register_voltage_1 = v(XU.XBIT0.XN1.N1)
let register_voltage_2 = v(A0)
let register_voltage_3 = v(VGND)
let register_voltage_4 = v(B0)
let register_voltage_5 = v(VPWR)
let register_voltage_6 = v(XU.XBIT0.N2)
let register_voltage_7 = v(XU.XBIT0.XN2.N1)
let register_voltage_8 = v(XU.XBIT0.N3)
let register_voltage_9 = v(XU.XBIT0.XN3.N1)
let register_voltage_10 = v(XU.XBIT0.P)
let register_voltage_11 = v(XU.XBIT0.XN4.N1)
let register_voltage_12 = v(XU.XBIT0.N5)
let register_voltage_13 = v(XU.XBIT0.XN5.N1)
let register_voltage_14 = v(CIN)
let register_voltage_15 = v(XU.XBIT0.N6)
let register_voltage_16 = v(XU.XBIT0.XN6.N1)
let register_voltage_17 = v(XU.XBIT0.N7)
let register_voltage_18 = v(XU.XBIT0.XN7.N1)
let register_voltage_19 = v(S0)
let register_voltage_20 = v(XU.XBIT0.XN8.N1)
let register_voltage_21 = v(XU.C1)
let register_voltage_22 = v(XU.XBIT0.XN9.N1)
let register_voltage_23 = v(XU.XBIT1.N1)
let register_voltage_24 = v(XU.XBIT1.XN1.N1)
let register_voltage_25 = v(A1)
let register_voltage_26 = v(B1)
let register_voltage_27 = v(XU.XBIT1.N2)
let register_voltage_28 = v(XU.XBIT1.XN2.N1)
let register_voltage_29 = v(XU.XBIT1.N3)
let register_voltage_30 = v(XU.XBIT1.XN3.N1)
let register_voltage_31 = v(XU.XBIT1.P)
let register_voltage_32 = v(XU.XBIT1.XN4.N1)
let register_voltage_33 = v(XU.XBIT1.N5)
let register_voltage_34 = v(XU.XBIT1.XN5.N1)
let register_voltage_35 = 0*register_flow_0
let register_voltage_36 = v(A2)
let register_voltage_37 = v(A3)
wrdata node-voltages.dat register_voltage_0 register_voltage_1 register_voltage_2 register_voltage_3 register_voltage_4 register_voltage_5 register_voltage_6 register_voltage_7 register_voltage_8 register_voltage_9 register_voltage_10 register_voltage_11 register_voltage_12 register_voltage_13 register_voltage_14 register_voltage_15 register_voltage_16 register_voltage_17 register_voltage_18 register_voltage_19 register_voltage_20 register_voltage_21 register_voltage_22 register_voltage_23 register_voltage_24 register_voltage_25 register_voltage_26 register_voltage_27 register_voltage_28 register_voltage_29 register_voltage_30 register_voltage_31 register_voltage_32 register_voltage_33 register_voltage_34 register_voltage_35 register_voltage_36 register_voltage_37
quit
.endc
.end

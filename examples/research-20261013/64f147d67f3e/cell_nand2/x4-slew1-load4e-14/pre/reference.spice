.subckt cell_nand2 A0 A1 Y VPWR VGND
XMN0 Y A0 N1 VGND sky130_fd_pr__nfet_01v8 w=2.6 l=0.15 nf=1 m=1
XMN1 N1 A1 VGND VGND sky130_fd_pr__nfet_01v8 w=2.6 l=0.15 nf=1 m=1
XMP0 Y A0 VPWR VPWR sky130_fd_pr__pfet_01v8_hvt w=2.6 l=0.15 nf=1 m=1
XMP1 Y A1 VPWR VPWR sky130_fd_pr__pfet_01v8_hvt w=2.6 l=0.15 nf=1 m=1
.ends cell_nand2

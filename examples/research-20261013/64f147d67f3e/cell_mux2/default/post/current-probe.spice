* NGSPICE file created from cell_mux2.ext - technology: sky130A

.subckt cell_mux2 VPWR VGND S Y B A
X0 register_cf_node_2dfe7ac807dfa274 SB.t2 register_cf_node_2dfe7ac807dfa274_source VPWR.t3 sky130_fd_pr__pfet_01v8_hvt ad=0.1885 pd=1.88 as=0.1885 ps=1.88 w=0.65 l=0.15
Vregister_cf_2dfe7ac807dfa274 B.t1 register_cf_node_2dfe7ac807dfa274 0
Vregister_cf_2dfe7ac807dfa274_source Y.t3 register_cf_node_2dfe7ac807dfa274_source 0
X1 register_cf_node_ceeb90d1efecaa54 S.t0 register_cf_node_ceeb90d1efecaa54_source VPWR.t0 sky130_fd_pr__pfet_01v8_hvt ad=0.1885 pd=1.88 as=0.1885 ps=1.88 w=0.65 l=0.15
Vregister_cf_ceeb90d1efecaa54 VPWR.t1 register_cf_node_ceeb90d1efecaa54 0
Vregister_cf_ceeb90d1efecaa54_source SB.t1 register_cf_node_ceeb90d1efecaa54_source 0
X2 register_cf_node_7d0d73f1b050b403 S.t1 register_cf_node_7d0d73f1b050b403_source VPWR.t2 sky130_fd_pr__pfet_01v8_hvt ad=0.1885 pd=1.88 as=0.1885 ps=1.88 w=0.65 l=0.15
Vregister_cf_7d0d73f1b050b403 A.t0 register_cf_node_7d0d73f1b050b403 0
Vregister_cf_7d0d73f1b050b403_source Y.t1 register_cf_node_7d0d73f1b050b403_source 0
X3 register_cf_node_37e64c969cc4a523 S.t2 register_cf_node_37e64c969cc4a523_source VGND.t2 sky130_fd_pr__nfet_01v8 ad=0.1885 pd=1.88 as=0.1885 ps=1.88 w=0.65 l=0.15
Vregister_cf_37e64c969cc4a523 B.t0 register_cf_node_37e64c969cc4a523 0
Vregister_cf_37e64c969cc4a523_source Y.t0 register_cf_node_37e64c969cc4a523_source 0
X4 register_cf_node_ed60a013e612093b S.t3 register_cf_node_ed60a013e612093b_source VGND.t0 sky130_fd_pr__nfet_01v8 ad=0.1885 pd=1.88 as=0.1885 ps=1.88 w=0.65 l=0.15
Vregister_cf_ed60a013e612093b VGND.t1 register_cf_node_ed60a013e612093b 0
Vregister_cf_ed60a013e612093b_source SB.t0 register_cf_node_ed60a013e612093b_source 0
X5 register_cf_node_7bef044a22354119 SB.t3 register_cf_node_7bef044a22354119_source VGND.t3 sky130_fd_pr__nfet_01v8 ad=0.1885 pd=1.88 as=0.1885 ps=1.88 w=0.65 l=0.15
Vregister_cf_7bef044a22354119 A.t1 register_cf_node_7bef044a22354119 0
Vregister_cf_7bef044a22354119_source Y.t2 register_cf_node_7bef044a22354119_source 0
C0 A Y 0.65913f
C1 S SB 0.59591f
C2 S Y 3.4163f
C3 VPWR B 0.13687f
C4 A B 0.0263f
C5 S B 0.85053f
C6 Y SB 0.47962f
C7 B SB 4.66001f
C8 A VPWR 0.16738f
C9 B Y 3.79436f
C10 VPWR S 0.74422f
C11 A S 3.29812f
C12 VPWR SB 0.59148f
C13 A SB 0.79994f
C14 VPWR Y 0.28278f
C15 B VGND 3.29926f
C16 A VGND 3.02041f
C17 Y VGND 3.29159f
C18 S VGND 4.18849f
C19 VPWR VGND 10.0234f
C20 SB VGND 6.23936f $ **FLOATING
C21 A.n0 VGND 0.00697f $ **FLOATING
C22 A.t0 VGND 0.02134f $ **FLOATING
C23 A.n1 VGND 0.00697f $ **FLOATING
C24 A.n2 VGND 0.15225f $ **FLOATING
C25 A.n3 VGND 0.00796f $ **FLOATING
C26 A.t1 VGND 0.01935f $ **FLOATING
C27 A.n4 VGND 0.00796f $ **FLOATING
C28 A.n5 VGND 0.13043f $ **FLOATING
C29 A.n6 VGND 2.49289f $ **FLOATING
C30 S.t2 VGND 0.04247f $ **FLOATING
C31 S.t1 VGND 0.04414f $ **FLOATING
C32 S.n0 VGND 2.32446f $ **FLOATING
C33 S.t3 VGND 0.04247f $ **FLOATING
C34 S.n1 VGND 1.55449f $ **FLOATING
C35 S.t0 VGND 0.04414f $ **FLOATING
C36 S.n2 VGND 1.94325f $ **FLOATING
C37 B.n0 VGND 0.0127f $ **FLOATING
C38 B.t1 VGND 0.03889f $ **FLOATING
C39 B.n1 VGND 0.0127f $ **FLOATING
C40 B.n2 VGND 0.41352f $ **FLOATING
C41 B.n3 VGND 0.01451f $ **FLOATING
C42 B.t0 VGND 0.03527f $ **FLOATING
C43 B.n4 VGND 0.01451f $ **FLOATING
C44 B.n5 VGND 0.36989f $ **FLOATING
C45 B.n6 VGND 6.19126f $ **FLOATING
C46 Y.n0 VGND 0.01031f $ **FLOATING
C47 Y.t3 VGND 0.03159f $ **FLOATING
C48 Y.n1 VGND 0.01031f $ **FLOATING
C49 Y.n2 VGND 0.29874f $ **FLOATING
C50 Y.n3 VGND 0.01178f $ **FLOATING
C51 Y.t0 VGND 0.02865f $ **FLOATING
C52 Y.n4 VGND 0.01178f $ **FLOATING
C53 Y.n5 VGND 0.26425f $ **FLOATING
C54 Y.n6 VGND 1.76082f $ **FLOATING
C55 Y.n7 VGND 0.01031f $ **FLOATING
C56 Y.t1 VGND 0.03159f $ **FLOATING
C57 Y.n8 VGND 0.01031f $ **FLOATING
C58 Y.n9 VGND 0.26425f $ **FLOATING
C59 Y.n10 VGND 1.08241f $ **FLOATING
C60 Y.n11 VGND 0.01178f $ **FLOATING
C61 Y.t2 VGND 0.02865f $ **FLOATING
C62 Y.n12 VGND 0.01178f $ **FLOATING
C63 Y.n13 VGND 0.26425f $ **FLOATING
C64 Y.n14 VGND 2.61141f $ **FLOATING
C65 SB.n0 VGND 0.00666f $ **FLOATING
C66 SB.t2 VGND 0.02503f $ **FLOATING
C67 SB.t3 VGND 0.02408f $ **FLOATING
C68 SB.n1 VGND 2.28483f $ **FLOATING
C69 SB.n2 VGND 0.00583f $ **FLOATING
C70 SB.t1 VGND 0.01785f $ **FLOATING
C71 SB.n3 VGND 0.00583f $ **FLOATING
C72 SB.n4 VGND 0.23262f $ **FLOATING
C73 SB.n5 VGND 1.65266f $ **FLOATING
C74 SB.n6 VGND 0.19045f $ **FLOATING
C75 SB.t0 VGND 0.01619f $ **FLOATING
C76 SB.n7 VGND 0.00666f $ **FLOATING
rmesh_equiv_0 a a.n0 12.8005
rmesh_equiv_1 a a.n1 12.8005
rmesh_equiv_10 a.n3 a.n5 10.151300000000001
rmesh_equiv_11 a.n3 a.t1 255.34500000000003
rmesh_equiv_12 a.n4 a.n5 10.151300000000001
rmesh_equiv_13 a.n4 a.t1 255.34500000000003
rmesh_equiv_14 a.n5 a.n6 10.035399999999999
rmesh_equiv_15 b b.n0 12.8005
rmesh_equiv_16 b b.n1 12.8005
rmesh_equiv_17 b b.n3 12.8005
rmesh_equiv_18 b b.n4 12.8005
rmesh_equiv_19 b b.n6 7.3287300000000011
rmesh_equiv_2 a a.n3 12.8005
rmesh_equiv_20 b.n0 b.n2 10.151300000000001
rmesh_equiv_21 b.n0 b.t1 700.48400000000004
rmesh_equiv_22 b.n1 b.n2 10.151300000000001
rmesh_equiv_23 b.n1 b.t1 700.48400000000004
rmesh_equiv_24 b.n2 b.n6 11.838100000000003
rmesh_equiv_25 b.n3 b.n5 10.151300000000001
rmesh_equiv_26 b.n3 b.t0 255.34500000000003
rmesh_equiv_27 b.n4 b.n5 10.151300000000001
rmesh_equiv_28 b.n4 b.t0 255.34500000000003
rmesh_equiv_29 b.n5 b.n6 11.285399999999999
rmesh_equiv_3 a a.n4 12.8005
rmesh_equiv_30 s s.n0 15.03258234958602
rmesh_equiv_31 s s.n1 29.799399999999999
rmesh_equiv_32 s s.n2 4.303278026089699
rmesh_equiv_33 s s.t0 330.34100000000001
rmesh_equiv_34 s s.t1 330.34100000000001
rmesh_equiv_35 s s.t2 315.88
rmesh_equiv_36 s s.t3 315.88
rmesh_equiv_37 s.n0 s.n1 1.1014699999999999
rmesh_equiv_38 s.n1 s.n2 0.55314200000000002
rmesh_equiv_39 sb sb.n0 12.8005
rmesh_equiv_4 a a.n6 6.3644499999999997
rmesh_equiv_40 sb sb.n1 15.924696467114625
rmesh_equiv_41 sb sb.n2 12.8005
rmesh_equiv_42 sb sb.n3 12.8005
rmesh_equiv_43 sb sb.n7 12.8005
rmesh_equiv_44 sb sb.t2 330.34100000000001
rmesh_equiv_45 sb sb.t3 315.88
rmesh_equiv_46 sb.n0 sb.n6 10.151300000000001
rmesh_equiv_47 sb.n0 sb.t0 255.34500000000003
rmesh_equiv_48 sb.n1 sb.n5 0.78539999999999988
rmesh_equiv_49 sb.n2 sb.n4 10.151300000000001
rmesh_equiv_5 a.n0 a.n2 10.151300000000001
rmesh_equiv_50 sb.n2 sb.t1 700.48400000000004
rmesh_equiv_51 sb.n3 sb.n4 10.151300000000001
rmesh_equiv_52 sb.n3 sb.t1 700.48400000000004
rmesh_equiv_53 sb.n4 sb.n5 12.254699999999998
rmesh_equiv_54 sb.n5 sb.n6 11.7021
rmesh_equiv_55 sb.n6 sb.n7 10.151300000000001
rmesh_equiv_56 sb.n7 sb.t0 255.34500000000003
rmesh_equiv_57 vgnd vgnd.t0 193.39787368183516
rmesh_equiv_58 vgnd vgnd.t1 132.3954069544867
rmesh_equiv_59 vgnd vgnd.t2 193.39787368183519
rmesh_equiv_6 a.n0 a.t0 700.48400000000004
rmesh_equiv_60 vgnd vgnd.t3 193.39787368183514
rmesh_equiv_61 vgnd.t0 vgnd.t2 2843772.4046686324
rmesh_equiv_62 vgnd.t0 vgnd.t3 4283.8248738558632
rmesh_equiv_63 vgnd.t2 vgnd.t3 9394.5053944664141
rmesh_equiv_64 vpwr vpwr.t0 117.18187411979875
rmesh_equiv_65 vpwr vpwr.t1 354.99182419285825
rmesh_equiv_66 vpwr vpwr.t2 117.18187411979875
rmesh_equiv_67 vpwr vpwr.t3 117.18187411979874
rmesh_equiv_68 y y.n0 12.8005
rmesh_equiv_69 y y.n1 12.8005
rmesh_equiv_7 a.n1 a.n2 10.151300000000001
rmesh_equiv_70 y y.n11 12.8005
rmesh_equiv_71 y y.n12 12.8005
rmesh_equiv_72 y y.n14 5.3304499999999999
rmesh_equiv_73 y y.n3 12.8005
rmesh_equiv_74 y y.n4 12.8005
rmesh_equiv_75 y y.n7 12.8005
rmesh_equiv_76 y y.n8 12.8005
rmesh_equiv_77 y.n0 y.n2 10.151300000000001
rmesh_equiv_78 y.n0 y.t3 700.48400000000004
rmesh_equiv_79 y.n1 y.n2 10.151300000000001
rmesh_equiv_8 a.n1 a.t0 700.48400000000004
rmesh_equiv_80 y.n1 y.t3 700.48400000000004
rmesh_equiv_81 y.n10 y.n14 0.55314200000000002
rmesh_equiv_82 y.n10 y.n6 0.55314200000000002
rmesh_equiv_83 y.n10 y.n9 10.8688
rmesh_equiv_84 y.n11 y.n13 10.151300000000001
rmesh_equiv_85 y.n11 y.t2 255.34500000000003
rmesh_equiv_86 y.n12 y.n13 10.151300000000001
rmesh_equiv_87 y.n12 y.t2 255.34500000000003
rmesh_equiv_88 y.n13 y.n14 10.8688
rmesh_equiv_89 y.n2 y.n6 11.4214
rmesh_equiv_9 a.n2 a.n6 10.588100000000001
rmesh_equiv_90 y.n3 y.n5 10.151300000000001
rmesh_equiv_91 y.n3 y.t0 255.34500000000003
rmesh_equiv_92 y.n4 y.n5 10.151300000000001
rmesh_equiv_93 y.n4 y.t0 255.34500000000003
rmesh_equiv_94 y.n5 y.n6 10.8688
rmesh_equiv_95 y.n7 y.n9 10.151300000000001
rmesh_equiv_96 y.n7 y.t1 700.48400000000004
rmesh_equiv_97 y.n8 y.n9 10.151300000000001
rmesh_equiv_98 y.n8 y.t1 700.48400000000004
.ends

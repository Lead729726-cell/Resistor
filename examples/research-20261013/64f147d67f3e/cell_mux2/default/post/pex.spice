* NGSPICE file created from cell_mux2.ext - technology: sky130A

.subckt cell_mux2 VPWR VGND S Y B A
X0 B.t1 SB.t2 Y.t3 VPWR.t3 sky130_fd_pr__pfet_01v8_hvt ad=0.1885 pd=1.88 as=0.1885 ps=1.88 w=0.65 l=0.15
X1 VPWR.t1 S.t0 SB.t1 VPWR.t0 sky130_fd_pr__pfet_01v8_hvt ad=0.1885 pd=1.88 as=0.1885 ps=1.88 w=0.65 l=0.15
X2 A.t0 S.t1 Y.t1 VPWR.t2 sky130_fd_pr__pfet_01v8_hvt ad=0.1885 pd=1.88 as=0.1885 ps=1.88 w=0.65 l=0.15
X3 B.t0 S.t2 Y.t0 VGND.t2 sky130_fd_pr__nfet_01v8 ad=0.1885 pd=1.88 as=0.1885 ps=1.88 w=0.65 l=0.15
X4 VGND.t1 S.t3 SB.t0 VGND.t0 sky130_fd_pr__nfet_01v8 ad=0.1885 pd=1.88 as=0.1885 ps=1.88 w=0.65 l=0.15
X5 A.t1 SB.t3 Y.t2 VGND.t3 sky130_fd_pr__nfet_01v8 ad=0.1885 pd=1.88 as=0.1885 ps=1.88 w=0.65 l=0.15
C0 A Y 0.65913f
C1 S SB 0.59591f
C2 S Y 3.4163f
C3 VPWR B 0.13687f
C4 A B 0.0263f
C5 S B 0.85053f
C6 Y SB 0.47962f
C7 B SB 4.66001f
C8 A VPWR 0.16738f
C9 B Y 3.79436f
C10 VPWR S 0.74422f
C11 A S 3.29812f
C12 VPWR SB 0.59148f
C13 A SB 0.79994f
C14 VPWR Y 0.28278f
R0 SB.t1 SB.n2 700.484
R1 SB.n3 SB.t1 700.484
R2 SB SB.t2 330.341
R3 SB SB.t3 315.88
R4 SB.t0 SB.n0 255.345
R5 SB.n7 SB.t0 255.345
R6 SB.n1 SB 32.6917
R7 SB.n1 SB 31.0494
R8 SB SB.n2 12.8005
R9 SB.n3 SB 12.8005
R10 SB SB.n0 12.8005
R11 SB SB.n7 12.8005
R12 SB.n5 SB.n4 12.2547
R13 SB.n6 SB.n5 11.7021
R14 SB.n4 SB.n2 10.1513
R15 SB.n4 SB.n3 10.1513
R16 SB.n6 SB.n0 10.1513
R17 SB.n7 SB.n6 10.1513
R18 SB.n5 SB.n1 0.7854
R19 Y.t1 Y.n7 700.484
R20 Y.n8 Y.t1 700.484
R21 Y.t3 Y.n0 700.484
R22 Y.n1 Y.t3 700.484
R23 Y.t2 Y.n11 255.345
R24 Y.n12 Y.t2 255.345
R25 Y.t0 Y.n3 255.345
R26 Y.n4 Y.t0 255.345
R27 Y Y.n7 12.8005
R28 Y.n8 Y 12.8005
R29 Y Y.n3 12.8005
R30 Y.n4 Y 12.8005
R31 Y Y.n0 12.8005
R32 Y.n1 Y 12.8005
R33 Y Y.n11 12.8005
R34 Y.n12 Y 12.8005
R35 Y.n6 Y.n2 11.4214
R36 Y.n10 Y.n9 10.8688
R37 Y.n6 Y.n5 10.8688
R38 Y.n14 Y.n13 10.8688
R39 Y.n9 Y.n7 10.1513
R40 Y.n9 Y.n8 10.1513
R41 Y.n5 Y.n3 10.1513
R42 Y.n5 Y.n4 10.1513
R43 Y.n2 Y.n0 10.1513
R44 Y.n2 Y.n1 10.1513
R45 Y.n13 Y.n11 10.1513
R46 Y.n13 Y.n12 10.1513
R47 Y Y.n14 5.33045
R48 Y.n10 Y.n6 0.553142
R49 Y.n14 Y.n10 0.553142
R50 B.t1 B.n0 700.484
R51 B.n1 B.t1 700.484
R52 B.t0 B.n3 255.345
R53 B.n4 B.t0 255.345
R54 B B.n0 12.8005
R55 B.n1 B 12.8005
R56 B B.n3 12.8005
R57 B.n4 B 12.8005
R58 B.n6 B.n2 11.8381
R59 B.n6 B.n5 11.2854
R60 B.n2 B.n0 10.1513
R61 B.n2 B.n1 10.1513
R62 B.n5 B.n3 10.1513
R63 B.n5 B.n4 10.1513
R64 B B.n6 7.32873
R65 VPWR.n49 VPWR.n37 832.942
R66 VPWR.n60 VPWR.n38 832.942
R67 VPWR.n62 VPWR.n35 832.942
R68 VPWR.n44 VPWR.n34 832.942
R69 VPWR.n17 VPWR.n5 832.942
R70 VPWR.n28 VPWR.n6 832.942
R71 VPWR.n30 VPWR.n3 832.942
R72 VPWR.n12 VPWR.n2 832.942
R73 VPWR.n86 VPWR.n74 832.942
R74 VPWR.n97 VPWR.n75 832.942
R75 VPWR.n99 VPWR.n72 832.942
R76 VPWR.n81 VPWR.n71 832.942
R77 VPWR.t1 VPWR.n65 700.484
R78 VPWR.n66 VPWR.t1 700.484
R79 VPWR.n60 VPWR.n37 240
R80 VPWR.n56 VPWR.n54 240
R81 VPWR.n62 VPWR.n34 240
R82 VPWR.n41 VPWR.n40 240
R83 VPWR.n28 VPWR.n5 240
R84 VPWR.n24 VPWR.n22 240
R85 VPWR.n30 VPWR.n2 240
R86 VPWR.n9 VPWR.n8 240
R87 VPWR.n97 VPWR.n74 240
R88 VPWR.n93 VPWR.n91 240
R89 VPWR.n99 VPWR.n71 240
R90 VPWR.n78 VPWR.n77 240
R91 VPWR.n47 VPWR.n46 207.394
R92 VPWR.n61 VPWR.n36 207.394
R93 VPWR.n15 VPWR.n14 207.394
R94 VPWR.n29 VPWR.n4 207.394
R95 VPWR.n84 VPWR.n83 207.394
R96 VPWR.n98 VPWR.n73 207.394
R97 VPWR.n44 VPWR.n43 185
R98 VPWR.n42 VPWR.n41 185
R99 VPWR.n40 VPWR.n39 185
R100 VPWR.n50 VPWR.n49 185
R101 VPWR.n51 VPWR.n37 185
R102 VPWR.n46 VPWR.n37 185
R103 VPWR.n60 VPWR.n59 185
R104 VPWR.n61 VPWR.n60 185
R105 VPWR.n58 VPWR.n38 185
R106 VPWR.n57 VPWR.n56 185
R107 VPWR.n54 VPWR.n52 185
R108 VPWR.n35 VPWR.n33 185
R109 VPWR.n63 VPWR.n62 185
R110 VPWR.n62 VPWR.n61 185
R111 VPWR.n34 VPWR.n32 185
R112 VPWR.n46 VPWR.n34 185
R113 VPWR.n12 VPWR.n11 185
R114 VPWR.n10 VPWR.n9 185
R115 VPWR.n8 VPWR.n7 185
R116 VPWR.n18 VPWR.n17 185
R117 VPWR.n19 VPWR.n5 185
R118 VPWR.n14 VPWR.n5 185
R119 VPWR.n28 VPWR.n27 185
R120 VPWR.n29 VPWR.n28 185
R121 VPWR.n26 VPWR.n6 185
R122 VPWR.n25 VPWR.n24 185
R123 VPWR.n22 VPWR.n20 185
R124 VPWR.n3 VPWR.n1 185
R125 VPWR.n31 VPWR.n30 185
R126 VPWR.n30 VPWR.n29 185
R127 VPWR.n2 VPWR.n0 185
R128 VPWR.n14 VPWR.n2 185
R129 VPWR.n81 VPWR.n80 185
R130 VPWR.n79 VPWR.n78 185
R131 VPWR.n77 VPWR.n76 185
R132 VPWR.n87 VPWR.n86 185
R133 VPWR.n88 VPWR.n74 185
R134 VPWR.n83 VPWR.n74 185
R135 VPWR.n97 VPWR.n96 185
R136 VPWR.n98 VPWR.n97 185
R137 VPWR.n95 VPWR.n75 185
R138 VPWR.n94 VPWR.n93 185
R139 VPWR.n91 VPWR.n89 185
R140 VPWR.n72 VPWR.n70 185
R141 VPWR.n100 VPWR.n99 185
R142 VPWR.n99 VPWR.n98 185
R143 VPWR.n71 VPWR.n69 185
R144 VPWR.n83 VPWR.n71 185
R145 VPWR.n51 VPWR.n50 88.8476
R146 VPWR.n43 VPWR.n32 88.8476
R147 VPWR.n59 VPWR.n58 88.8476
R148 VPWR.n63 VPWR.n33 88.8476
R149 VPWR.n19 VPWR.n18 88.8476
R150 VPWR.n11 VPWR.n0 88.8476
R151 VPWR.n27 VPWR.n26 88.8476
R152 VPWR.n31 VPWR.n1 88.8476
R153 VPWR.n88 VPWR.n87 88.8476
R154 VPWR.n80 VPWR.n69 88.8476
R155 VPWR.n96 VPWR.n95 88.8476
R156 VPWR.n100 VPWR.n70 88.8476
R157 VPWR.n55 VPWR.n38 72.7879
R158 VPWR.n53 VPWR.n35 72.7879
R159 VPWR.n49 VPWR.n48 72.7879
R160 VPWR.n45 VPWR.n41 72.7879
R161 VPWR.n45 VPWR.n44 72.7879
R162 VPWR.n48 VPWR.n40 72.7879
R163 VPWR.n56 VPWR.n55 72.7879
R164 VPWR.n54 VPWR.n53 72.7879
R165 VPWR.n23 VPWR.n6 72.7879
R166 VPWR.n21 VPWR.n3 72.7879
R167 VPWR.n17 VPWR.n16 72.7879
R168 VPWR.n13 VPWR.n9 72.7879
R169 VPWR.n13 VPWR.n12 72.7879
R170 VPWR.n16 VPWR.n8 72.7879
R171 VPWR.n24 VPWR.n23 72.7879
R172 VPWR.n22 VPWR.n21 72.7879
R173 VPWR.n92 VPWR.n75 72.7879
R174 VPWR.n90 VPWR.n72 72.7879
R175 VPWR.n86 VPWR.n85 72.7879
R176 VPWR.n82 VPWR.n78 72.7879
R177 VPWR.n82 VPWR.n81 72.7879
R178 VPWR.n85 VPWR.n77 72.7879
R179 VPWR.n93 VPWR.n92 72.7879
R180 VPWR.n91 VPWR.n90 72.7879
R181 VPWR.n46 VPWR.t2 56.8667
R182 VPWR.n61 VPWR.t2 56.8667
R183 VPWR.n14 VPWR.t3 56.8667
R184 VPWR.n29 VPWR.t3 56.8667
R185 VPWR.n83 VPWR.t0 56.8667
R186 VPWR.n98 VPWR.t0 56.8667
R187 VPWR.n47 VPWR.n45 56.1076
R188 VPWR.n48 VPWR.n47 56.1076
R189 VPWR.n55 VPWR.n36 56.1076
R190 VPWR.n53 VPWR.n36 56.1076
R191 VPWR.n15 VPWR.n13 56.1076
R192 VPWR.n16 VPWR.n15 56.1076
R193 VPWR.n23 VPWR.n4 56.1076
R194 VPWR.n21 VPWR.n4 56.1076
R195 VPWR.n84 VPWR.n82 56.1076
R196 VPWR.n85 VPWR.n84 56.1076
R197 VPWR.n92 VPWR.n73 56.1076
R198 VPWR.n90 VPWR.n73 56.1076
R199 VPWR.n50 VPWR.n39 25.6005
R200 VPWR.n42 VPWR.n39 25.6005
R201 VPWR.n43 VPWR.n42 25.6005
R202 VPWR.n59 VPWR.n51 25.6005
R203 VPWR.n58 VPWR.n57 25.6005
R204 VPWR.n57 VPWR.n52 25.6005
R205 VPWR.n52 VPWR.n33 25.6005
R206 VPWR.n18 VPWR.n7 25.6005
R207 VPWR.n10 VPWR.n7 25.6005
R208 VPWR.n11 VPWR.n10 25.6005
R209 VPWR.n27 VPWR.n19 25.6005
R210 VPWR.n26 VPWR.n25 25.6005
R211 VPWR.n25 VPWR.n20 25.6005
R212 VPWR.n20 VPWR.n1 25.6005
R213 VPWR.n87 VPWR.n76 25.6005
R214 VPWR.n79 VPWR.n76 25.6005
R215 VPWR.n80 VPWR.n79 25.6005
R216 VPWR.n96 VPWR.n88 25.6005
R217 VPWR.n95 VPWR.n94 25.6005
R218 VPWR.n94 VPWR.n89 25.6005
R219 VPWR.n89 VPWR.n70 25.6005
R220 VPWR.n64 VPWR 19.9703
R221 VPWR.n64 VPWR 18.865
R222 VPWR.n101 VPWR 18.865
R223 VPWR VPWR.n65 12.8005
R224 VPWR.n66 VPWR 12.8005
R225 VPWR VPWR.n32 12.8005
R226 VPWR VPWR.n63 12.8005
R227 VPWR VPWR.n0 12.8005
R228 VPWR VPWR.n31 12.8005
R229 VPWR VPWR.n69 12.8005
R230 VPWR VPWR.n100 12.8005
R231 VPWR.n68 VPWR.n67 10.5563
R232 VPWR.n67 VPWR.n65 10.1513
R233 VPWR.n67 VPWR.n66 10.1513
R234 VPWR VPWR.n101 4.46447
R235 VPWR.n68 VPWR.n64 1.56012
R236 VPWR.n101 VPWR.n68 0.0945
R237 S S.t0 330.341
R238 S S.t1 330.341
R239 S S.t3 315.88
R240 S S.t2 315.88
R241 S.n0 S 30.352
R242 S.n1 S 29.7994
R243 S.n0 S 29.7837
R244 S.n2 S 29.7837
R245 S S.n2 5.03004
R246 S.n1 S.n0 1.10147
R247 S.n2 S.n1 0.553142
R248 A.t0 A.n0 700.484
R249 A.n1 A.t0 700.484
R250 A.t1 A.n3 255.345
R251 A.n4 A.t1 255.345
R252 A A.n0 12.8005
R253 A.n1 A 12.8005
R254 A A.n3 12.8005
R255 A.n4 A 12.8005
R256 A.n6 A.n2 10.5881
R257 A.n2 A.n0 10.1513
R258 A.n2 A.n1 10.1513
R259 A.n5 A.n3 10.1513
R260 A.n5 A.n4 10.1513
R261 A.n6 A.n5 10.0354
R262 A A.n6 6.36445
R263 VGND.n53 VGND.n52 3632.52
R264 VGND.n78 VGND.n76 1515.12
R265 VGND.n86 VGND.n9 1315.26
R266 VGND.n97 VGND.n10 1315.26
R267 VGND.n81 VGND.n6 1315.26
R268 VGND.n99 VGND.n7 1315.26
R269 VGND.n64 VGND.n54 1315.26
R270 VGND.n74 VGND.n15 1315.26
R271 VGND.n66 VGND.n18 1315.26
R272 VGND.n68 VGND.n67 1315.26
R273 VGND.n40 VGND.n30 1315.26
R274 VGND.n50 VGND.n23 1315.26
R275 VGND.n44 VGND.n43 1315.26
R276 VGND.n42 VGND.n26 1315.26
R277 VGND.n74 VGND.n73 585
R278 VGND.n72 VGND.n14 585
R279 VGND.n71 VGND.n70 585
R280 VGND.n69 VGND.n68 585
R281 VGND.n67 VGND.n17 585
R282 VGND.n67 VGND.n12 585
R283 VGND.n66 VGND.n19 585
R284 VGND.n66 VGND.n65 585
R285 VGND.n55 VGND.n18 585
R286 VGND.n59 VGND.n56 585
R287 VGND.n61 VGND.n60 585
R288 VGND.n62 VGND.n54 585
R289 VGND.n64 VGND.n63 585
R290 VGND.n65 VGND.n64 585
R291 VGND.n16 VGND.n15 585
R292 VGND.n15 VGND.n12 585
R293 VGND.n95 VGND.n10 585
R294 VGND.n94 VGND.n93 585
R295 VGND.n91 VGND.n89 585
R296 VGND.n7 VGND.n5 585
R297 VGND.n100 VGND.n99 585
R298 VGND.n99 VGND.n98 585
R299 VGND.n6 VGND.n4 585
R300 VGND.n77 VGND.n6 585
R301 VGND.n81 VGND.n80 585
R302 VGND.n83 VGND.n79 585
R303 VGND.n84 VGND.n11 585
R304 VGND.n87 VGND.n86 585
R305 VGND.n88 VGND.n9 585
R306 VGND.n77 VGND.n9 585
R307 VGND.n97 VGND.n96 585
R308 VGND.n98 VGND.n97 585
R309 VGND.n31 VGND.n26 585
R310 VGND.n34 VGND.n32 585
R311 VGND.n37 VGND.n36 585
R312 VGND.n38 VGND.n30 585
R313 VGND.n40 VGND.n39 585
R314 VGND.n41 VGND.n40 585
R315 VGND.n24 VGND.n23 585
R316 VGND.n23 VGND.n20 585
R317 VGND.n50 VGND.n49 585
R318 VGND.n48 VGND.n22 585
R319 VGND.n47 VGND.n46 585
R320 VGND.n45 VGND.n44 585
R321 VGND.n43 VGND.n25 585
R322 VGND.n43 VGND.n20 585
R323 VGND.n42 VGND.n28 585
R324 VGND.n42 VGND.n41 585
R325 VGND.n97 VGND.n9 394
R326 VGND.n84 VGND.n83 394
R327 VGND.n99 VGND.n6 394
R328 VGND.n93 VGND.n91 394
R329 VGND.n64 VGND.n15 394
R330 VGND.n60 VGND.n59 394
R331 VGND.n67 VGND.n66 394
R332 VGND.n70 VGND.n14 394
R333 VGND.n40 VGND.n23 394
R334 VGND.n46 VGND.n22 394
R335 VGND.n43 VGND.n42 394
R336 VGND.n36 VGND.n34 394
R337 VGND.t1 VGND.n0 255.345
R338 VGND.n1 VGND.t1 255.345
R339 VGND.n76 VGND.n75 218.815
R340 VGND.n76 VGND.n13 218.815
R341 VGND.n58 VGND.n53 218.815
R342 VGND.n57 VGND.n53 218.815
R343 VGND.n92 VGND.n8 218.815
R344 VGND.n90 VGND.n8 218.815
R345 VGND.n82 VGND.n78 218.815
R346 VGND.n85 VGND.n78 218.815
R347 VGND.n33 VGND.n29 218.815
R348 VGND.n35 VGND.n29 218.815
R349 VGND.n52 VGND.n51 218.815
R350 VGND.n52 VGND.n21 218.815
R351 VGND.n65 VGND.n53 173.316
R352 VGND.n76 VGND.n12 173.316
R353 VGND.n78 VGND.n77 173.316
R354 VGND.n98 VGND.n8 173.316
R355 VGND.n41 VGND.n29 173.316
R356 VGND.n52 VGND.n20 173.316
R357 VGND.n85 VGND.n84 147.374
R358 VGND.n82 VGND.n81 147.374
R359 VGND.n92 VGND.n10 147.374
R360 VGND.n90 VGND.n7 147.374
R361 VGND.n60 VGND.n57 147.374
R362 VGND.n58 VGND.n18 147.374
R363 VGND.n75 VGND.n74 147.374
R364 VGND.n68 VGND.n13 147.374
R365 VGND.n75 VGND.n14 147.374
R366 VGND.n70 VGND.n13 147.374
R367 VGND.n59 VGND.n58 147.374
R368 VGND.n57 VGND.n54 147.374
R369 VGND.n93 VGND.n92 147.374
R370 VGND.n91 VGND.n90 147.374
R371 VGND.n83 VGND.n82 147.374
R372 VGND.n86 VGND.n85 147.374
R373 VGND.n51 VGND.n50 147.374
R374 VGND.n44 VGND.n21 147.374
R375 VGND.n35 VGND.n30 147.374
R376 VGND.n34 VGND.n33 147.374
R377 VGND.n33 VGND.n26 147.374
R378 VGND.n36 VGND.n35 147.374
R379 VGND.n51 VGND.n22 147.374
R380 VGND.n46 VGND.n21 147.374
R381 VGND.n88 VGND.n87 85.4593
R382 VGND.n96 VGND.n95 85.4593
R383 VGND.n80 VGND.n4 85.4593
R384 VGND.n100 VGND.n5 85.4593
R385 VGND.n63 VGND.n62 85.4593
R386 VGND.n73 VGND.n16 85.4593
R387 VGND.n55 VGND.n19 85.4593
R388 VGND.n69 VGND.n17 85.4593
R389 VGND.n39 VGND.n38 85.4593
R390 VGND.n31 VGND.n28 85.4593
R391 VGND.n49 VGND.n24 85.4593
R392 VGND.n45 VGND.n25 85.4593
R393 VGND.n65 VGND.t3 47.5227
R394 VGND.t3 VGND.n12 47.5227
R395 VGND.n77 VGND.t0 47.5227
R396 VGND.n98 VGND.t0 47.5227
R397 VGND.n41 VGND.t2 47.5227
R398 VGND.t2 VGND.n20 47.5227
R399 VGND.n96 VGND.n88 25.6005
R400 VGND.n87 VGND.n11 25.6005
R401 VGND.n79 VGND.n11 25.6005
R402 VGND.n80 VGND.n79 25.6005
R403 VGND.n95 VGND.n94 25.6005
R404 VGND.n94 VGND.n89 25.6005
R405 VGND.n89 VGND.n5 25.6005
R406 VGND.n63 VGND.n16 25.6005
R407 VGND.n62 VGND.n61 25.6005
R408 VGND.n61 VGND.n56 25.6005
R409 VGND.n56 VGND.n55 25.6005
R410 VGND.n73 VGND.n72 25.6005
R411 VGND.n72 VGND.n71 25.6005
R412 VGND.n71 VGND.n69 25.6005
R413 VGND.n38 VGND.n37 25.6005
R414 VGND.n37 VGND.n32 25.6005
R415 VGND.n32 VGND.n31 25.6005
R416 VGND.n39 VGND.n24 25.6005
R417 VGND.n49 VGND.n48 25.6005
R418 VGND.n48 VGND.n47 25.6005
R419 VGND.n47 VGND.n45 25.6005
R420 VGND VGND.n27 19.4651
R421 VGND.n101 VGND 18.3598
R422 VGND.n27 VGND 18.3598
R423 VGND VGND.n4 12.8005
R424 VGND VGND.n100 12.8005
R425 VGND VGND.n19 12.8005
R426 VGND VGND.n17 12.8005
R427 VGND.n28 VGND 12.8005
R428 VGND VGND.n25 12.8005
R429 VGND VGND.n0 12.8005
R430 VGND.n1 VGND 12.8005
R431 VGND.n2 VGND.n0 10.1513
R432 VGND.n2 VGND.n1 10.1513
R433 VGND.n3 VGND.n2 10.0354
R434 VGND VGND.n101 5.15812
R435 VGND.n27 VGND.n3 0.454833
R436 VGND.n101 VGND.n3 0.0945
C15 B VGND 3.29926f
C16 A VGND 3.02041f
C17 Y VGND 3.29159f
C18 S VGND 4.18849f
C19 VPWR VGND 10.0234f
C20 SB VGND 6.23936f $ **FLOATING
C21 A.n0 VGND 0.00697f $ **FLOATING
C22 A.t0 VGND 0.02134f $ **FLOATING
C23 A.n1 VGND 0.00697f $ **FLOATING
C24 A.n2 VGND 0.15225f $ **FLOATING
C25 A.n3 VGND 0.00796f $ **FLOATING
C26 A.t1 VGND 0.01935f $ **FLOATING
C27 A.n4 VGND 0.00796f $ **FLOATING
C28 A.n5 VGND 0.13043f $ **FLOATING
C29 A.n6 VGND 2.49289f $ **FLOATING
C30 S.t2 VGND 0.04247f $ **FLOATING
C31 S.t1 VGND 0.04414f $ **FLOATING
C32 S.n0 VGND 2.32446f $ **FLOATING
C33 S.t3 VGND 0.04247f $ **FLOATING
C34 S.n1 VGND 1.55449f $ **FLOATING
C35 S.t0 VGND 0.04414f $ **FLOATING
C36 S.n2 VGND 1.94325f $ **FLOATING
C37 B.n0 VGND 0.0127f $ **FLOATING
C38 B.t1 VGND 0.03889f $ **FLOATING
C39 B.n1 VGND 0.0127f $ **FLOATING
C40 B.n2 VGND 0.41352f $ **FLOATING
C41 B.n3 VGND 0.01451f $ **FLOATING
C42 B.t0 VGND 0.03527f $ **FLOATING
C43 B.n4 VGND 0.01451f $ **FLOATING
C44 B.n5 VGND 0.36989f $ **FLOATING
C45 B.n6 VGND 6.19126f $ **FLOATING
C46 Y.n0 VGND 0.01031f $ **FLOATING
C47 Y.t3 VGND 0.03159f $ **FLOATING
C48 Y.n1 VGND 0.01031f $ **FLOATING
C49 Y.n2 VGND 0.29874f $ **FLOATING
C50 Y.n3 VGND 0.01178f $ **FLOATING
C51 Y.t0 VGND 0.02865f $ **FLOATING
C52 Y.n4 VGND 0.01178f $ **FLOATING
C53 Y.n5 VGND 0.26425f $ **FLOATING
C54 Y.n6 VGND 1.76082f $ **FLOATING
C55 Y.n7 VGND 0.01031f $ **FLOATING
C56 Y.t1 VGND 0.03159f $ **FLOATING
C57 Y.n8 VGND 0.01031f $ **FLOATING
C58 Y.n9 VGND 0.26425f $ **FLOATING
C59 Y.n10 VGND 1.08241f $ **FLOATING
C60 Y.n11 VGND 0.01178f $ **FLOATING
C61 Y.t2 VGND 0.02865f $ **FLOATING
C62 Y.n12 VGND 0.01178f $ **FLOATING
C63 Y.n13 VGND 0.26425f $ **FLOATING
C64 Y.n14 VGND 2.61141f $ **FLOATING
C65 SB.n0 VGND 0.00666f $ **FLOATING
C66 SB.t2 VGND 0.02503f $ **FLOATING
C67 SB.t3 VGND 0.02408f $ **FLOATING
C68 SB.n1 VGND 2.28483f $ **FLOATING
C69 SB.n2 VGND 0.00583f $ **FLOATING
C70 SB.t1 VGND 0.01785f $ **FLOATING
C71 SB.n3 VGND 0.00583f $ **FLOATING
C72 SB.n4 VGND 0.23262f $ **FLOATING
C73 SB.n5 VGND 1.65266f $ **FLOATING
C74 SB.n6 VGND 0.19045f $ **FLOATING
C75 SB.t0 VGND 0.01619f $ **FLOATING
C76 SB.n7 VGND 0.00666f $ **FLOATING
.ends

Resistor public CMOS cell actual input truth matrix
.include "/workspace/.runtime/eda/runs/5e53788b172a4642ab402c321d411a7f/supported-tt.spice"
.option scale=1e-6
.include "/workspace/.runtime/eda/runs/5e53788b172a4642ab402c321d411a7f/current-probe.spice"
.temp 27.0
VGND VGND 0 0
VDD VPWR VGND 1.8
VA A VGND PWL(0 0 5e-08 0 5.01e-08 1.8 1e-07 1.8 1.001e-07 0 1.5e-07 0 1.501e-07 1.8 2e-07 1.8 2.001e-07 0 2.5e-07 0 2.501e-07 1.8 3e-07 1.8 3.001e-07 0 3.5e-07 0 3.501e-07 1.8 4e-07 1.8 4.001e-07 0 4.5e-07 0 4.501e-07 1.8 5e-07 1.8 5.001e-07 1.8 5.5e-07 1.8 5.501e-07 0 6e-07 0 6.001e-07 1.8 6.5e-07 1.8 6.501e-07 1.8 7e-07 1.8 7.001e-07 0 7.5e-07 0 7.501e-07 1.8 8e-07 1.8 8.001e-07 0 8.5e-07 0 8.501e-07 0 9e-07 0 9.001e-07 1.8 9.5e-07 1.8 9.501e-07 0 1e-06 0 1.0001e-06 0 1.05e-06 0 1.0501e-06 0 1.1e-06 0 1.1001e-06 1.8 1.15e-06 1.8 1.1501e-06 1.8 1.2e-06 1.8 1.2001e-06 1.8 1.25e-06 1.8 1.2501e-06 1.8 1.3e-06 1.8 1.3001e-06 0 1.35e-06 0 1.3501e-06 0 1.4e-06 0 1.4001e-06 0 1.45e-06 0 1.4501e-06 0 1.5e-06 0 1.5001e-06 1.8 1.55e-06 1.8 1.5501e-06 1.8 1.6e-06 1.8)
VB B VGND PWL(0 0 5e-08 0 5.01e-08 0 1e-07 0 1.001e-07 1.8 1.5e-07 1.8 1.501e-07 1.8 2e-07 1.8 2.001e-07 0 2.5e-07 0 2.501e-07 0 3e-07 0 3.001e-07 1.8 3.5e-07 1.8 3.501e-07 1.8 4e-07 1.8 4.001e-07 0 4.5e-07 0 4.501e-07 0 5e-07 0 5.001e-07 0 5.5e-07 0 5.501e-07 0 6e-07 0 6.001e-07 0 6.5e-07 0 6.501e-07 0 7e-07 0 7.001e-07 1.8 7.5e-07 1.8 7.501e-07 1.8 8e-07 1.8 8.001e-07 1.8 8.5e-07 1.8 8.501e-07 1.8 9e-07 1.8 9.001e-07 1.8 9.5e-07 1.8 9.501e-07 1.8 1e-06 1.8 1.0001e-06 0 1.05e-06 0 1.0501e-06 1.8 1.1e-06 1.8 1.1001e-06 0 1.15e-06 0 1.1501e-06 1.8 1.2e-06 1.8 1.2001e-06 0 1.25e-06 0 1.2501e-06 0 1.3e-06 0 1.3001e-06 1.8 1.35e-06 1.8 1.3501e-06 0 1.4e-06 0 1.4001e-06 1.8 1.45e-06 1.8 1.4501e-06 1.8 1.5e-06 1.8 1.5001e-06 1.8 1.55e-06 1.8 1.5501e-06 0 1.6e-06 0)
VS S VGND PWL(0 0 5e-08 0 5.01e-08 0 1e-07 0 1.001e-07 0 1.5e-07 0 1.501e-07 0 2e-07 0 2.001e-07 1.8 2.5e-07 1.8 2.501e-07 1.8 3e-07 1.8 3.001e-07 1.8 3.5e-07 1.8 3.501e-07 1.8 4e-07 1.8 4.001e-07 0 4.5e-07 0 4.501e-07 0 5e-07 0 5.001e-07 0 5.5e-07 0 5.501e-07 0 6e-07 0 6.001e-07 0 6.5e-07 0 6.501e-07 1.8 7e-07 1.8 7.001e-07 0 7.5e-07 0 7.501e-07 0 8e-07 0 8.001e-07 0 8.5e-07 0 8.501e-07 1.8 9e-07 1.8 9.001e-07 0 9.5e-07 0 9.501e-07 0 1e-06 0 1.0001e-06 1.8 1.05e-06 1.8 1.0501e-06 1.8 1.1e-06 1.8 1.1001e-06 1.8 1.15e-06 1.8 1.1501e-06 1.8 1.2e-06 1.8 1.2001e-06 1.8 1.25e-06 1.8 1.2501e-06 0 1.3e-06 0 1.3001e-06 1.8 1.35e-06 1.8 1.3501e-06 1.8 1.4e-06 1.8 1.4001e-06 1.8 1.45e-06 1.8 1.4501e-06 0 1.5e-06 0 1.5001e-06 1.8 1.55e-06 1.8 1.5501e-06 1.8 1.6e-06 1.8)
CLOAD Y VGND 5e-15
XU VPWR VGND S Y B A cell_mux2
.control
save v(A) v(B) v(S) v(Y) i(VDD) i(v.xu.vregister_cf_2dfe7ac807dfa274) i(v.xu.vregister_cf_ceeb90d1efecaa54) i(v.xu.vregister_cf_7d0d73f1b050b403) i(v.xu.vregister_cf_37e64c969cc4a523) i(v.xu.vregister_cf_ed60a013e612093b) i(v.xu.vregister_cf_7bef044a22354119) i(VGND) i(VA) i(VB) i(VS) v(XU.B.t1) v(XU.Y.t3) v(XU.SB.t2) v(XU.VPWR.t3) v(XU.VPWR.t1) v(XU.SB.t1) v(XU.S.t0) v(XU.VPWR.t0) v(XU.A.t0) v(XU.Y.t1) v(XU.S.t1) v(XU.VPWR.t2) v(XU.B.t0) v(XU.Y.t0) v(XU.S.t2) v(XU.VGND.t2) v(XU.VGND.t1) v(XU.SB.t0) v(XU.S.t3) v(XU.VGND.t0) v(XU.A.t1) v(XU.Y.t2) v(XU.SB.t3) v(XU.VGND.t3) v(VGND) v(VPWR)
set numdgt=17
set wr_singlescale
set wr_vecnames
tran 1e-11 1.6e-06 0 1e-11
let mos_wave_0 = v(A)
let mos_wave_1 = v(B)
let mos_wave_2 = v(S)
let mos_wave_3 = v(Y)
let mos_wave_4 = -i(VDD)
wrdata waveform.dat mos_wave_0 mos_wave_1 mos_wave_2 mos_wave_3 mos_wave_4
write waveform.raw all
let register_flow_0 = i(v.xu.vregister_cf_2dfe7ac807dfa274)
let register_flow_1 = i(v.xu.vregister_cf_ceeb90d1efecaa54)
let register_flow_2 = i(v.xu.vregister_cf_7d0d73f1b050b403)
let register_flow_3 = i(v.xu.vregister_cf_37e64c969cc4a523)
let register_flow_4 = i(v.xu.vregister_cf_ed60a013e612093b)
let register_flow_5 = i(v.xu.vregister_cf_7bef044a22354119)
let register_flow_6 = i(VGND)
let register_flow_7 = i(VDD)
let register_flow_8 = i(VA)
let register_flow_9 = i(VB)
let register_flow_10 = i(VS)
wrdata current-flow.dat register_flow_0 register_flow_1 register_flow_2 register_flow_3 register_flow_4 register_flow_5 register_flow_6 register_flow_7 register_flow_8 register_flow_9 register_flow_10
let register_voltage_0 = v(XU.B.t1)
let register_voltage_1 = v(XU.Y.t3)
let register_voltage_2 = v(XU.SB.t2)
let register_voltage_3 = v(XU.VPWR.t3)
let register_voltage_4 = v(XU.VPWR.t1)
let register_voltage_5 = v(XU.SB.t1)
let register_voltage_6 = v(XU.S.t0)
let register_voltage_7 = v(XU.VPWR.t0)
let register_voltage_8 = v(XU.A.t0)
let register_voltage_9 = v(XU.Y.t1)
let register_voltage_10 = v(XU.S.t1)
let register_voltage_11 = v(XU.VPWR.t2)
let register_voltage_12 = v(XU.B.t0)
let register_voltage_13 = v(XU.Y.t0)
let register_voltage_14 = v(XU.S.t2)
let register_voltage_15 = v(XU.VGND.t2)
let register_voltage_16 = v(XU.VGND.t1)
let register_voltage_17 = v(XU.SB.t0)
let register_voltage_18 = v(XU.S.t3)
let register_voltage_19 = v(XU.VGND.t0)
let register_voltage_20 = v(XU.A.t1)
let register_voltage_21 = v(XU.Y.t2)
let register_voltage_22 = v(XU.SB.t3)
let register_voltage_23 = v(XU.VGND.t3)
let register_voltage_24 = v(VGND)
let register_voltage_25 = 0*register_flow_0
let register_voltage_26 = v(VPWR)
let register_voltage_27 = v(A)
let register_voltage_28 = v(B)
let register_voltage_29 = v(S)
wrdata node-voltages.dat register_voltage_0 register_voltage_1 register_voltage_2 register_voltage_3 register_voltage_4 register_voltage_5 register_voltage_6 register_voltage_7 register_voltage_8 register_voltage_9 register_voltage_10 register_voltage_11 register_voltage_12 register_voltage_13 register_voltage_14 register_voltage_15 register_voltage_16 register_voltage_17 register_voltage_18 register_voltage_19 register_voltage_20 register_voltage_21 register_voltage_22 register_voltage_23 register_voltage_24 register_voltage_25 register_voltage_26 register_voltage_27 register_voltage_28 register_voltage_29
quit
.endc
.end

.subckt differential_pair INP INN OUTP OUTN BIAS VGND
XMN1 OUTP INP TAIL VGND sky130_fd_pr__nfet_01v8 w=0.65 l=0.15 nf=1 m=1
XMN2 OUTN INN TAIL VGND sky130_fd_pr__nfet_01v8 w=0.65 l=0.15 nf=1 m=1
XMN3 TAIL BIAS VGND VGND sky130_fd_pr__nfet_01v8 w=0.65 l=0.15 nf=1 m=1
.ends differential_pair

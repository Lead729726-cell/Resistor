.subckt common_source IN OUT VPWR VGND
XMN1 OUT IN VGND VGND sky130_fd_pr__nfet_01v8 w=0.65 l=0.15 nf=1 m=1
RRD VPWR OUT 10000
.ends common_source

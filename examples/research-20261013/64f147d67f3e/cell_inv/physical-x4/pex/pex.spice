* NGSPICE file created from cell_inv.ext - technology: sky130A

.subckt cell_inv Y VPWR VGND A
X0 VPWR.t1 A.t0 Y.t0 VPWR.t0 sky130_fd_pr__pfet_01v8_hvt ad=0.754 pd=5.78 as=0.754 ps=5.78 w=2.6 l=0.15
X1 VGND.t1 A.t1 Y.t1 VGND.t0 sky130_fd_pr__nfet_01v8 ad=0.754 pd=5.78 as=0.754 ps=5.78 w=2.6 l=0.15
C0 Y A 1.45399f
C1 A VPWR 0.42183f
C2 Y VPWR 0.77971f
R0 A A.t0 643.64
R1 A A.t1 629.181
R2 A.n0 A 30.352
R3 A.n0 A 29.7837
R4 A A.n0 4.88904
R5 Y.n6 Y.n5 198.054
R6 Y.n5 Y.n4 140.863
R7 Y.n1 Y.n0 64.7149
R8 Y.n2 Y.n1 41.2879
R9 Y Y.n4 21.987
R10 Y.n2 Y 20.2436
R11 Y.n7 Y.n4 11.4451
R12 Y.n5 Y.t0 10.987
R13 Y.n8 Y.n3 10.9266
R14 Y.n3 Y.n2 10.883
R15 Y.n8 Y.n7 10.374
R16 Y.n1 Y.t1 6.69281
R17 Y.n6 Y 6.45887
R18 Y Y.n0 6.44918
R19 Y Y.n8 4.22948
R20 Y.n3 Y.n0 0.875595
R21 Y.n7 Y.n6 0.871844
R22 VPWR.n36 VPWR.n9 801.178
R23 VPWR.n61 VPWR.n10 801.178
R24 VPWR.n63 VPWR.n7 801.178
R25 VPWR.n31 VPWR.n6 801.178
R26 VPWR.n61 VPWR.n9 240
R27 VPWR.n57 VPWR.n55 240
R28 VPWR.n55 VPWR.n54 240
R29 VPWR.n51 VPWR.n50 240
R30 VPWR.n48 VPWR.n42 240
R31 VPWR.n44 VPWR.n7 240
R32 VPWR.n63 VPWR.n6 240
R33 VPWR.n17 VPWR.n12 240
R34 VPWR.n21 VPWR.n20 240
R35 VPWR.n25 VPWR.n24 240
R36 VPWR.n27 VPWR.n16 240
R37 VPWR.n1 VPWR.n0 198.054
R38 VPWR.n31 VPWR.n30 185
R39 VPWR.n29 VPWR.n16 185
R40 VPWR.n28 VPWR.n27 185
R41 VPWR.n26 VPWR.n25 185
R42 VPWR.n24 VPWR.n23 185
R43 VPWR.n22 VPWR.n21 185
R44 VPWR.n20 VPWR.n19 185
R45 VPWR.n18 VPWR.n17 185
R46 VPWR.n12 VPWR.n11 185
R47 VPWR.n37 VPWR.n36 185
R48 VPWR.n38 VPWR.n9 185
R49 VPWR.n33 VPWR.n9 185
R50 VPWR.n61 VPWR.n60 185
R51 VPWR.n62 VPWR.n61 185
R52 VPWR.n59 VPWR.n10 185
R53 VPWR.n58 VPWR.n57 185
R54 VPWR.n55 VPWR.n39 185
R55 VPWR.n55 VPWR.n8 185
R56 VPWR.n54 VPWR.n53 185
R57 VPWR.n52 VPWR.n51 185
R58 VPWR.n50 VPWR.n41 185
R59 VPWR.n48 VPWR.n47 185
R60 VPWR.n46 VPWR.n42 185
R61 VPWR.n45 VPWR.n44 185
R62 VPWR.n7 VPWR.n5 185
R63 VPWR.n8 VPWR.n7 185
R64 VPWR.n64 VPWR.n63 185
R65 VPWR.n63 VPWR.n62 185
R66 VPWR.n6 VPWR.n4 185
R67 VPWR.n33 VPWR.n6 185
R68 VPWR.n2 VPWR.n1 140.863
R69 VPWR.n34 VPWR.n33 122.966
R70 VPWR.n62 VPWR.n8 122.966
R71 VPWR.n38 VPWR.n37 85.4593
R72 VPWR.n30 VPWR.n4 85.4593
R73 VPWR.n60 VPWR.n59 85.4593
R74 VPWR.n64 VPWR.n5 85.4593
R75 VPWR.n56 VPWR.n10 72.7879
R76 VPWR.n54 VPWR.n40 72.7879
R77 VPWR.n50 VPWR.n49 72.7879
R78 VPWR.n43 VPWR.n42 72.7879
R79 VPWR.n36 VPWR.n35 72.7879
R80 VPWR.n17 VPWR.n13 72.7879
R81 VPWR.n21 VPWR.n14 72.7879
R82 VPWR.n25 VPWR.n15 72.7879
R83 VPWR.n32 VPWR.n16 72.7879
R84 VPWR.n32 VPWR.n31 72.7879
R85 VPWR.n27 VPWR.n15 72.7879
R86 VPWR.n24 VPWR.n14 72.7879
R87 VPWR.n20 VPWR.n13 72.7879
R88 VPWR.n35 VPWR.n12 72.7879
R89 VPWR.n57 VPWR.n56 72.7879
R90 VPWR.n51 VPWR.n40 72.7879
R91 VPWR.n49 VPWR.n48 72.7879
R92 VPWR.n44 VPWR.n43 72.7879
R93 VPWR.n34 VPWR.n32 56.1076
R94 VPWR.n34 VPWR.n15 56.1076
R95 VPWR.n34 VPWR.n14 56.1076
R96 VPWR.n34 VPWR.n13 56.1076
R97 VPWR.n35 VPWR.n34 56.1076
R98 VPWR.n56 VPWR.n8 56.1076
R99 VPWR.n40 VPWR.n8 56.1076
R100 VPWR.n49 VPWR.n8 56.1076
R101 VPWR.n43 VPWR.n8 56.1076
R102 VPWR.n33 VPWR.t0 33.7166
R103 VPWR.n62 VPWR.t0 33.7166
R104 VPWR.n37 VPWR.n11 25.6005
R105 VPWR.n18 VPWR.n11 25.6005
R106 VPWR.n19 VPWR.n18 25.6005
R107 VPWR.n22 VPWR.n19 25.6005
R108 VPWR.n23 VPWR.n22 25.6005
R109 VPWR.n26 VPWR.n23 25.6005
R110 VPWR.n28 VPWR.n26 25.6005
R111 VPWR.n29 VPWR.n28 25.6005
R112 VPWR.n30 VPWR.n29 25.6005
R113 VPWR.n60 VPWR.n38 25.6005
R114 VPWR.n59 VPWR.n58 25.6005
R115 VPWR.n58 VPWR.n39 25.6005
R116 VPWR.n53 VPWR.n39 25.6005
R117 VPWR.n53 VPWR.n52 25.6005
R118 VPWR.n52 VPWR.n41 25.6005
R119 VPWR.n47 VPWR.n41 25.6005
R120 VPWR.n47 VPWR.n46 25.6005
R121 VPWR.n46 VPWR.n45 25.6005
R122 VPWR.n45 VPWR.n5 25.6005
R123 VPWR.n2 VPWR 21.987
R124 VPWR.n65 VPWR 18.865
R125 VPWR VPWR.n4 12.8005
R126 VPWR VPWR.n64 12.8005
R127 VPWR.n3 VPWR.n2 11.4451
R128 VPWR.n65 VPWR.n3 10.9888
R129 VPWR.n1 VPWR.t1 10.987
R130 VPWR VPWR.n0 6.45887
R131 VPWR VPWR.n65 4.46447
R132 VPWR.n3 VPWR.n0 0.871844
R133 VGND.n36 VGND.n9 1263.12
R134 VGND.n61 VGND.n10 1263.12
R135 VGND.n63 VGND.n7 1263.12
R136 VGND.n31 VGND.n6 1263.12
R137 VGND.n31 VGND.n30 585
R138 VGND.n29 VGND.n16 585
R139 VGND.n28 VGND.n27 585
R140 VGND.n26 VGND.n25 585
R141 VGND.n24 VGND.n23 585
R142 VGND.n22 VGND.n21 585
R143 VGND.n20 VGND.n19 585
R144 VGND.n18 VGND.n17 585
R145 VGND.n12 VGND.n11 585
R146 VGND.n37 VGND.n36 585
R147 VGND.n38 VGND.n9 585
R148 VGND.n33 VGND.n9 585
R149 VGND.n61 VGND.n60 585
R150 VGND.n62 VGND.n61 585
R151 VGND.n59 VGND.n10 585
R152 VGND.n58 VGND.n57 585
R153 VGND.n55 VGND.n39 585
R154 VGND.n55 VGND.n8 585
R155 VGND.n54 VGND.n53 585
R156 VGND.n52 VGND.n51 585
R157 VGND.n50 VGND.n41 585
R158 VGND.n48 VGND.n47 585
R159 VGND.n46 VGND.n42 585
R160 VGND.n45 VGND.n44 585
R161 VGND.n7 VGND.n5 585
R162 VGND.n8 VGND.n7 585
R163 VGND.n64 VGND.n63 585
R164 VGND.n63 VGND.n62 585
R165 VGND.n6 VGND.n4 585
R166 VGND.n33 VGND.n6 585
R167 VGND.n61 VGND.n9 394
R168 VGND.n57 VGND.n55 394
R169 VGND.n55 VGND.n54 394
R170 VGND.n51 VGND.n50 394
R171 VGND.n48 VGND.n42 394
R172 VGND.n44 VGND.n7 394
R173 VGND.n63 VGND.n6 394
R174 VGND.n17 VGND.n12 394
R175 VGND.n21 VGND.n20 394
R176 VGND.n25 VGND.n24 394
R177 VGND.n27 VGND.n16 394
R178 VGND.n34 VGND.n32 218.815
R179 VGND.n34 VGND.n15 218.815
R180 VGND.n34 VGND.n14 218.815
R181 VGND.n34 VGND.n13 218.815
R182 VGND.n35 VGND.n34 218.815
R183 VGND.n56 VGND.n8 218.815
R184 VGND.n40 VGND.n8 218.815
R185 VGND.n49 VGND.n8 218.815
R186 VGND.n43 VGND.n8 218.815
R187 VGND.n34 VGND.n33 193.613
R188 VGND.n62 VGND.n8 193.613
R189 VGND.n56 VGND.n10 147.374
R190 VGND.n54 VGND.n40 147.374
R191 VGND.n50 VGND.n49 147.374
R192 VGND.n43 VGND.n42 147.374
R193 VGND.n36 VGND.n35 147.374
R194 VGND.n17 VGND.n13 147.374
R195 VGND.n21 VGND.n14 147.374
R196 VGND.n25 VGND.n15 147.374
R197 VGND.n32 VGND.n16 147.374
R198 VGND.n32 VGND.n31 147.374
R199 VGND.n27 VGND.n15 147.374
R200 VGND.n24 VGND.n14 147.374
R201 VGND.n20 VGND.n13 147.374
R202 VGND.n35 VGND.n12 147.374
R203 VGND.n57 VGND.n56 147.374
R204 VGND.n51 VGND.n40 147.374
R205 VGND.n49 VGND.n48 147.374
R206 VGND.n44 VGND.n43 147.374
R207 VGND.n38 VGND.n37 82.0711
R208 VGND.n30 VGND.n4 82.0711
R209 VGND.n60 VGND.n59 82.0711
R210 VGND.n64 VGND.n5 82.0711
R211 VGND.n1 VGND.n0 64.7149
R212 VGND.n33 VGND.t0 53.0878
R213 VGND.n62 VGND.t0 53.0878
R214 VGND.n2 VGND.n1 41.2879
R215 VGND.n37 VGND.n11 25.6005
R216 VGND.n18 VGND.n11 25.6005
R217 VGND.n19 VGND.n18 25.6005
R218 VGND.n22 VGND.n19 25.6005
R219 VGND.n23 VGND.n22 25.6005
R220 VGND.n26 VGND.n23 25.6005
R221 VGND.n28 VGND.n26 25.6005
R222 VGND.n29 VGND.n28 25.6005
R223 VGND.n30 VGND.n29 25.6005
R224 VGND.n60 VGND.n38 25.6005
R225 VGND.n59 VGND.n58 25.6005
R226 VGND.n58 VGND.n39 25.6005
R227 VGND.n53 VGND.n39 25.6005
R228 VGND.n53 VGND.n52 25.6005
R229 VGND.n52 VGND.n41 25.6005
R230 VGND.n47 VGND.n41 25.6005
R231 VGND.n47 VGND.n46 25.6005
R232 VGND.n46 VGND.n45 25.6005
R233 VGND.n45 VGND.n5 25.6005
R234 VGND.n2 VGND 20.2436
R235 VGND.n65 VGND 18.3598
R236 VGND VGND.n4 12.8005
R237 VGND VGND.n64 12.8005
R238 VGND.n3 VGND.n2 10.883
R239 VGND.n65 VGND.n3 10.468
R240 VGND.n1 VGND.t1 6.69281
R241 VGND VGND.n0 6.44918
R242 VGND VGND.n65 5.15812
R243 VGND.n3 VGND.n0 0.875595
C3 Y VGND 2.51391f
C4 A VGND 2.9817f
C5 VPWR VGND 4.02416f
.ends

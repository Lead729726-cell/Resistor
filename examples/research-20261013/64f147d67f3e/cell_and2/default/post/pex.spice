* NGSPICE file created from cell_and2.ext - technology: sky130A

.subckt cell_and2 Y VPWR VGND B A
X0 VPWR.t5 A.t0 N.t1 VPWR.t4 sky130_fd_pr__pfet_01v8_hvt ad=0.1885 pd=1.88 as=0.1885 ps=1.88 w=0.65 l=0.15
X1 VPWR.t1 B.t0 N.t0 VPWR.t0 sky130_fd_pr__pfet_01v8_hvt ad=0.1885 pd=1.88 as=0.1885 ps=1.88 w=0.65 l=0.15
X2 VGND.t3 B.t1 N1__N1.t0 VGND.t2 sky130_fd_pr__nfet_01v8 ad=0.1885 pd=1.88 as=0.1885 ps=1.88 w=0.65 l=0.15
X3 N1__N1.t1 A.t1 N.t2 VGND.t4 sky130_fd_pr__nfet_01v8 ad=0.1885 pd=1.88 as=0.1885 ps=1.88 w=0.65 l=0.15
X4 VGND.t1 N.t3 Y.t1 VGND.t0 sky130_fd_pr__nfet_01v8 ad=0.1885 pd=1.88 as=0.1885 ps=1.88 w=0.65 l=0.15
X5 VPWR.t3 N.t4 Y.t0 VPWR.t2 sky130_fd_pr__pfet_01v8_hvt ad=0.1885 pd=1.88 as=0.1885 ps=1.88 w=0.65 l=0.15
C0 A Y 0.00236f
C1 B Y 2.40762f
C2 VPWR N1__N1 0.02656f
C3 A N1__N1 2.0926f
C4 N Y 3.94724f
C5 B N1__N1 2.61478f
C6 A VPWR 0.43986f
C7 N N1__N1 0.55834f
C8 B VPWR 0.42216f
C9 A B 0.08432f
C10 VPWR N 0.94533f
C11 Y N1__N1 0.00592f
C12 A N 0.43522f
C13 VPWR Y 0.2734f
C14 B N 0.5757f
R0 A A.t0 330.341
R1 A A.t1 315.88
R2 A.n0 A 29.9353
R3 A.n0 A 29.3671
R4 A A.n0 5.31204
R5 N.t1 N.n2 700.484
R6 N.n3 N.t1 700.484
R7 N.t0 N.n0 700.484
R8 N.n11 N.t0 700.484
R9 N N.t4 330.341
R10 N N.t3 315.88
R11 N.t2 N.n5 255.345
R12 N.n6 N.t2 255.345
R13 N.n1 N 31.602
R14 N.n1 N 31.0337
R15 N N.n2 12.8005
R16 N.n3 N 12.8005
R17 N N.n5 12.8005
R18 N.n6 N 12.8005
R19 N N.n0 12.8005
R20 N N.n11 12.8005
R21 N.n8 N.n4 12.2547
R22 N.n8 N.n7 11.7021
R23 N.n10 N.n9 11.7021
R24 N.n4 N.n2 10.1513
R25 N.n4 N.n3 10.1513
R26 N.n7 N.n5 10.1513
R27 N.n7 N.n6 10.1513
R28 N.n10 N.n0 10.1513
R29 N.n11 N.n10 10.1513
R30 N.n9 N.n1 1.34235
R31 N.n9 N.n8 0.553142
R32 VPWR.n57 VPWR.n45 832.942
R33 VPWR.n68 VPWR.n46 832.942
R34 VPWR.n70 VPWR.n43 832.942
R35 VPWR.n52 VPWR.n42 832.942
R36 VPWR.n20 VPWR.n8 832.942
R37 VPWR.n31 VPWR.n9 832.942
R38 VPWR.n33 VPWR.n6 832.942
R39 VPWR.n15 VPWR.n5 832.942
R40 VPWR.n94 VPWR.n82 832.942
R41 VPWR.n105 VPWR.n83 832.942
R42 VPWR.n107 VPWR.n80 832.942
R43 VPWR.n89 VPWR.n79 832.942
R44 VPWR.t5 VPWR.n73 700.484
R45 VPWR.n74 VPWR.t5 700.484
R46 VPWR.t1 VPWR.n36 700.484
R47 VPWR.n37 VPWR.t1 700.484
R48 VPWR.t3 VPWR.n0 700.484
R49 VPWR.n1 VPWR.t3 700.484
R50 VPWR.n68 VPWR.n45 240
R51 VPWR.n64 VPWR.n62 240
R52 VPWR.n70 VPWR.n42 240
R53 VPWR.n49 VPWR.n48 240
R54 VPWR.n31 VPWR.n8 240
R55 VPWR.n27 VPWR.n25 240
R56 VPWR.n33 VPWR.n5 240
R57 VPWR.n12 VPWR.n11 240
R58 VPWR.n105 VPWR.n82 240
R59 VPWR.n101 VPWR.n99 240
R60 VPWR.n107 VPWR.n79 240
R61 VPWR.n86 VPWR.n85 240
R62 VPWR.n55 VPWR.n54 207.394
R63 VPWR.n69 VPWR.n44 207.394
R64 VPWR.n18 VPWR.n17 207.394
R65 VPWR.n32 VPWR.n7 207.394
R66 VPWR.n92 VPWR.n91 207.394
R67 VPWR.n106 VPWR.n81 207.394
R68 VPWR.n52 VPWR.n51 185
R69 VPWR.n50 VPWR.n49 185
R70 VPWR.n48 VPWR.n47 185
R71 VPWR.n58 VPWR.n57 185
R72 VPWR.n59 VPWR.n45 185
R73 VPWR.n54 VPWR.n45 185
R74 VPWR.n68 VPWR.n67 185
R75 VPWR.n69 VPWR.n68 185
R76 VPWR.n66 VPWR.n46 185
R77 VPWR.n65 VPWR.n64 185
R78 VPWR.n62 VPWR.n60 185
R79 VPWR.n43 VPWR.n41 185
R80 VPWR.n71 VPWR.n70 185
R81 VPWR.n70 VPWR.n69 185
R82 VPWR.n42 VPWR.n40 185
R83 VPWR.n54 VPWR.n42 185
R84 VPWR.n15 VPWR.n14 185
R85 VPWR.n13 VPWR.n12 185
R86 VPWR.n11 VPWR.n10 185
R87 VPWR.n21 VPWR.n20 185
R88 VPWR.n22 VPWR.n8 185
R89 VPWR.n17 VPWR.n8 185
R90 VPWR.n31 VPWR.n30 185
R91 VPWR.n32 VPWR.n31 185
R92 VPWR.n29 VPWR.n9 185
R93 VPWR.n28 VPWR.n27 185
R94 VPWR.n25 VPWR.n23 185
R95 VPWR.n6 VPWR.n4 185
R96 VPWR.n34 VPWR.n33 185
R97 VPWR.n33 VPWR.n32 185
R98 VPWR.n5 VPWR.n3 185
R99 VPWR.n17 VPWR.n5 185
R100 VPWR.n89 VPWR.n88 185
R101 VPWR.n87 VPWR.n86 185
R102 VPWR.n85 VPWR.n84 185
R103 VPWR.n95 VPWR.n94 185
R104 VPWR.n96 VPWR.n82 185
R105 VPWR.n91 VPWR.n82 185
R106 VPWR.n105 VPWR.n104 185
R107 VPWR.n106 VPWR.n105 185
R108 VPWR.n103 VPWR.n83 185
R109 VPWR.n102 VPWR.n101 185
R110 VPWR.n99 VPWR.n97 185
R111 VPWR.n80 VPWR.n78 185
R112 VPWR.n108 VPWR.n107 185
R113 VPWR.n107 VPWR.n106 185
R114 VPWR.n79 VPWR.n77 185
R115 VPWR.n91 VPWR.n79 185
R116 VPWR.n59 VPWR.n58 88.8476
R117 VPWR.n51 VPWR.n40 88.8476
R118 VPWR.n67 VPWR.n66 88.8476
R119 VPWR.n71 VPWR.n41 88.8476
R120 VPWR.n22 VPWR.n21 88.8476
R121 VPWR.n14 VPWR.n3 88.8476
R122 VPWR.n30 VPWR.n29 88.8476
R123 VPWR.n34 VPWR.n4 88.8476
R124 VPWR.n96 VPWR.n95 88.8476
R125 VPWR.n88 VPWR.n77 88.8476
R126 VPWR.n104 VPWR.n103 88.8476
R127 VPWR.n108 VPWR.n78 88.8476
R128 VPWR.n63 VPWR.n46 72.7879
R129 VPWR.n61 VPWR.n43 72.7879
R130 VPWR.n57 VPWR.n56 72.7879
R131 VPWR.n53 VPWR.n49 72.7879
R132 VPWR.n53 VPWR.n52 72.7879
R133 VPWR.n56 VPWR.n48 72.7879
R134 VPWR.n64 VPWR.n63 72.7879
R135 VPWR.n62 VPWR.n61 72.7879
R136 VPWR.n26 VPWR.n9 72.7879
R137 VPWR.n24 VPWR.n6 72.7879
R138 VPWR.n20 VPWR.n19 72.7879
R139 VPWR.n16 VPWR.n12 72.7879
R140 VPWR.n16 VPWR.n15 72.7879
R141 VPWR.n19 VPWR.n11 72.7879
R142 VPWR.n27 VPWR.n26 72.7879
R143 VPWR.n25 VPWR.n24 72.7879
R144 VPWR.n100 VPWR.n83 72.7879
R145 VPWR.n98 VPWR.n80 72.7879
R146 VPWR.n94 VPWR.n93 72.7879
R147 VPWR.n90 VPWR.n86 72.7879
R148 VPWR.n90 VPWR.n89 72.7879
R149 VPWR.n93 VPWR.n85 72.7879
R150 VPWR.n101 VPWR.n100 72.7879
R151 VPWR.n99 VPWR.n98 72.7879
R152 VPWR.n54 VPWR.t0 56.8667
R153 VPWR.n69 VPWR.t0 56.8667
R154 VPWR.n17 VPWR.t2 56.8667
R155 VPWR.n32 VPWR.t2 56.8667
R156 VPWR.n91 VPWR.t4 56.8667
R157 VPWR.n106 VPWR.t4 56.8667
R158 VPWR.n55 VPWR.n53 56.1076
R159 VPWR.n56 VPWR.n55 56.1076
R160 VPWR.n63 VPWR.n44 56.1076
R161 VPWR.n61 VPWR.n44 56.1076
R162 VPWR.n18 VPWR.n16 56.1076
R163 VPWR.n19 VPWR.n18 56.1076
R164 VPWR.n26 VPWR.n7 56.1076
R165 VPWR.n24 VPWR.n7 56.1076
R166 VPWR.n92 VPWR.n90 56.1076
R167 VPWR.n93 VPWR.n92 56.1076
R168 VPWR.n100 VPWR.n81 56.1076
R169 VPWR.n98 VPWR.n81 56.1076
R170 VPWR.n58 VPWR.n47 25.6005
R171 VPWR.n50 VPWR.n47 25.6005
R172 VPWR.n51 VPWR.n50 25.6005
R173 VPWR.n67 VPWR.n59 25.6005
R174 VPWR.n66 VPWR.n65 25.6005
R175 VPWR.n65 VPWR.n60 25.6005
R176 VPWR.n60 VPWR.n41 25.6005
R177 VPWR.n21 VPWR.n10 25.6005
R178 VPWR.n13 VPWR.n10 25.6005
R179 VPWR.n14 VPWR.n13 25.6005
R180 VPWR.n30 VPWR.n22 25.6005
R181 VPWR.n29 VPWR.n28 25.6005
R182 VPWR.n28 VPWR.n23 25.6005
R183 VPWR.n23 VPWR.n4 25.6005
R184 VPWR.n95 VPWR.n84 25.6005
R185 VPWR.n87 VPWR.n84 25.6005
R186 VPWR.n88 VPWR.n87 25.6005
R187 VPWR.n104 VPWR.n96 25.6005
R188 VPWR.n103 VPWR.n102 25.6005
R189 VPWR.n102 VPWR.n97 25.6005
R190 VPWR.n97 VPWR.n78 25.6005
R191 VPWR.n72 VPWR 18.865
R192 VPWR.n35 VPWR 18.865
R193 VPWR.n109 VPWR 18.865
R194 VPWR VPWR.n73 12.8005
R195 VPWR.n74 VPWR 12.8005
R196 VPWR VPWR.n36 12.8005
R197 VPWR.n37 VPWR 12.8005
R198 VPWR VPWR.n40 12.8005
R199 VPWR VPWR.n71 12.8005
R200 VPWR VPWR.n0 12.8005
R201 VPWR.n1 VPWR 12.8005
R202 VPWR VPWR.n3 12.8005
R203 VPWR VPWR.n34 12.8005
R204 VPWR VPWR.n77 12.8005
R205 VPWR VPWR.n108 12.8005
R206 VPWR.n35 VPWR.n2 10.6503
R207 VPWR.n76 VPWR.n75 10.5563
R208 VPWR.n39 VPWR.n38 10.5563
R209 VPWR.n75 VPWR.n73 10.1513
R210 VPWR.n75 VPWR.n74 10.1513
R211 VPWR.n38 VPWR.n36 10.1513
R212 VPWR.n38 VPWR.n37 10.1513
R213 VPWR.n2 VPWR.n0 10.1513
R214 VPWR.n2 VPWR.n1 10.1513
R215 VPWR VPWR.n109 4.46447
R216 VPWR.n39 VPWR.n35 1.01178
R217 VPWR.n76 VPWR.n72 1.01178
R218 VPWR.n72 VPWR.n39 0.0945
R219 VPWR.n109 VPWR.n76 0.0945
R220 B B.t0 330.341
R221 B B.t1 315.88
R222 B.n0 B 30.7687
R223 B.n0 B 30.2004
R224 B B.n0 6.27633
R225 N1__N1.t1 N1__N1.n1 255.345
R226 N1__N1.n2 N1__N1.t1 255.345
R227 N1__N1.t0 N1__N1.n0 255.345
R228 N1__N1.n5 N1__N1.t0 255.345
R229 N1__N1.n4 N1__N1.n3 21.821
R230 N1__N1 N1__N1.n1 12.8005
R231 N1__N1.n2 N1__N1 12.8005
R232 N1__N1 N1__N1.n0 12.8005
R233 N1__N1 N1__N1.n5 12.8005
R234 N1__N1.n3 N1__N1.n1 10.1513
R235 N1__N1.n3 N1__N1.n2 10.1513
R236 N1__N1.n4 N1__N1.n0 10.1513
R237 N1__N1.n5 N1__N1.n4 10.1513
R238 VGND.n82 VGND.n80 3632.52
R239 VGND.n57 VGND.n56 3632.52
R240 VGND.n68 VGND.n58 1315.26
R241 VGND.n78 VGND.n12 1315.26
R242 VGND.n70 VGND.n15 1315.26
R243 VGND.n72 VGND.n71 1315.26
R244 VGND.n90 VGND.n6 1315.26
R245 VGND.n101 VGND.n7 1315.26
R246 VGND.n85 VGND.n3 1315.26
R247 VGND.n103 VGND.n4 1315.26
R248 VGND.n44 VGND.n34 1315.26
R249 VGND.n54 VGND.n20 1315.26
R250 VGND.n48 VGND.n47 1315.26
R251 VGND.n46 VGND.n23 1315.26
R252 VGND.n99 VGND.n7 585
R253 VGND.n98 VGND.n97 585
R254 VGND.n95 VGND.n93 585
R255 VGND.n4 VGND.n2 585
R256 VGND.n104 VGND.n103 585
R257 VGND.n103 VGND.n102 585
R258 VGND.n3 VGND.n1 585
R259 VGND.n81 VGND.n3 585
R260 VGND.n85 VGND.n84 585
R261 VGND.n87 VGND.n83 585
R262 VGND.n88 VGND.n8 585
R263 VGND.n91 VGND.n90 585
R264 VGND.n92 VGND.n6 585
R265 VGND.n81 VGND.n6 585
R266 VGND.n101 VGND.n100 585
R267 VGND.n102 VGND.n101 585
R268 VGND.n78 VGND.n77 585
R269 VGND.n76 VGND.n11 585
R270 VGND.n75 VGND.n74 585
R271 VGND.n73 VGND.n72 585
R272 VGND.n71 VGND.n14 585
R273 VGND.n71 VGND.n9 585
R274 VGND.n70 VGND.n16 585
R275 VGND.n70 VGND.n69 585
R276 VGND.n59 VGND.n15 585
R277 VGND.n63 VGND.n60 585
R278 VGND.n65 VGND.n64 585
R279 VGND.n66 VGND.n58 585
R280 VGND.n68 VGND.n67 585
R281 VGND.n69 VGND.n68 585
R282 VGND.n13 VGND.n12 585
R283 VGND.n12 VGND.n9 585
R284 VGND.n35 VGND.n23 585
R285 VGND.n38 VGND.n36 585
R286 VGND.n41 VGND.n40 585
R287 VGND.n42 VGND.n34 585
R288 VGND.n44 VGND.n43 585
R289 VGND.n45 VGND.n44 585
R290 VGND.n21 VGND.n20 585
R291 VGND.n20 VGND.n17 585
R292 VGND.n54 VGND.n53 585
R293 VGND.n52 VGND.n19 585
R294 VGND.n51 VGND.n50 585
R295 VGND.n49 VGND.n48 585
R296 VGND.n47 VGND.n22 585
R297 VGND.n47 VGND.n17 585
R298 VGND.n46 VGND.n32 585
R299 VGND.n46 VGND.n45 585
R300 VGND.n68 VGND.n12 394
R301 VGND.n64 VGND.n63 394
R302 VGND.n71 VGND.n70 394
R303 VGND.n74 VGND.n11 394
R304 VGND.n101 VGND.n6 394
R305 VGND.n88 VGND.n87 394
R306 VGND.n103 VGND.n3 394
R307 VGND.n97 VGND.n95 394
R308 VGND.n44 VGND.n20 394
R309 VGND.n50 VGND.n19 394
R310 VGND.n47 VGND.n46 394
R311 VGND.n40 VGND.n38 394
R312 VGND.t3 VGND.n27 255.345
R313 VGND.n28 VGND.t3 255.345
R314 VGND.t1 VGND.n24 255.345
R315 VGND.n25 VGND.t1 255.345
R316 VGND.n96 VGND.n5 218.815
R317 VGND.n94 VGND.n5 218.815
R318 VGND.n86 VGND.n82 218.815
R319 VGND.n89 VGND.n82 218.815
R320 VGND.n80 VGND.n79 218.815
R321 VGND.n80 VGND.n10 218.815
R322 VGND.n62 VGND.n57 218.815
R323 VGND.n61 VGND.n57 218.815
R324 VGND.n37 VGND.n33 218.815
R325 VGND.n39 VGND.n33 218.815
R326 VGND.n56 VGND.n55 218.815
R327 VGND.n56 VGND.n18 218.815
R328 VGND.n82 VGND.n81 173.316
R329 VGND.n102 VGND.n5 173.316
R330 VGND.n69 VGND.n57 173.316
R331 VGND.n80 VGND.n9 173.316
R332 VGND.n45 VGND.n33 173.316
R333 VGND.n56 VGND.n17 173.316
R334 VGND.n64 VGND.n61 147.374
R335 VGND.n62 VGND.n15 147.374
R336 VGND.n79 VGND.n78 147.374
R337 VGND.n72 VGND.n10 147.374
R338 VGND.n89 VGND.n88 147.374
R339 VGND.n86 VGND.n85 147.374
R340 VGND.n96 VGND.n7 147.374
R341 VGND.n94 VGND.n4 147.374
R342 VGND.n97 VGND.n96 147.374
R343 VGND.n95 VGND.n94 147.374
R344 VGND.n87 VGND.n86 147.374
R345 VGND.n90 VGND.n89 147.374
R346 VGND.n79 VGND.n11 147.374
R347 VGND.n74 VGND.n10 147.374
R348 VGND.n63 VGND.n62 147.374
R349 VGND.n61 VGND.n58 147.374
R350 VGND.n55 VGND.n54 147.374
R351 VGND.n48 VGND.n18 147.374
R352 VGND.n39 VGND.n34 147.374
R353 VGND.n38 VGND.n37 147.374
R354 VGND.n37 VGND.n23 147.374
R355 VGND.n40 VGND.n39 147.374
R356 VGND.n55 VGND.n19 147.374
R357 VGND.n50 VGND.n18 147.374
R358 VGND.n67 VGND.n66 85.4593
R359 VGND.n77 VGND.n13 85.4593
R360 VGND.n59 VGND.n16 85.4593
R361 VGND.n73 VGND.n14 85.4593
R362 VGND.n92 VGND.n91 85.4593
R363 VGND.n100 VGND.n99 85.4593
R364 VGND.n84 VGND.n1 85.4593
R365 VGND.n104 VGND.n2 85.4593
R366 VGND.n43 VGND.n42 85.4593
R367 VGND.n35 VGND.n32 85.4593
R368 VGND.n53 VGND.n21 85.4593
R369 VGND.n49 VGND.n22 85.4593
R370 VGND.n81 VGND.t4 47.5227
R371 VGND.n102 VGND.t4 47.5227
R372 VGND.n69 VGND.t2 47.5227
R373 VGND.t2 VGND.n9 47.5227
R374 VGND.n45 VGND.t0 47.5227
R375 VGND.t0 VGND.n17 47.5227
R376 VGND.n67 VGND.n13 25.6005
R377 VGND.n66 VGND.n65 25.6005
R378 VGND.n65 VGND.n60 25.6005
R379 VGND.n60 VGND.n59 25.6005
R380 VGND.n77 VGND.n76 25.6005
R381 VGND.n76 VGND.n75 25.6005
R382 VGND.n75 VGND.n73 25.6005
R383 VGND.n100 VGND.n92 25.6005
R384 VGND.n91 VGND.n8 25.6005
R385 VGND.n83 VGND.n8 25.6005
R386 VGND.n84 VGND.n83 25.6005
R387 VGND.n99 VGND.n98 25.6005
R388 VGND.n98 VGND.n93 25.6005
R389 VGND.n93 VGND.n2 25.6005
R390 VGND.n42 VGND.n41 25.6005
R391 VGND.n41 VGND.n36 25.6005
R392 VGND.n36 VGND.n35 25.6005
R393 VGND.n43 VGND.n21 25.6005
R394 VGND.n53 VGND.n52 25.6005
R395 VGND.n52 VGND.n51 25.6005
R396 VGND.n51 VGND.n49 25.6005
R397 VGND VGND.n0 18.3598
R398 VGND.n105 VGND 18.3598
R399 VGND VGND.n31 18.3598
R400 VGND VGND.n24 12.8005
R401 VGND.n25 VGND 12.8005
R402 VGND.n16 VGND 12.8005
R403 VGND VGND.n14 12.8005
R404 VGND VGND.n1 12.8005
R405 VGND VGND.n104 12.8005
R406 VGND.n32 VGND 12.8005
R407 VGND VGND.n22 12.8005
R408 VGND VGND.n27 12.8005
R409 VGND.n28 VGND 12.8005
R410 VGND.n26 VGND.n24 10.1513
R411 VGND.n26 VGND.n25 10.1513
R412 VGND.n29 VGND.n27 10.1513
R413 VGND.n29 VGND.n28 10.1513
R414 VGND.n31 VGND.n26 10.1294
R415 VGND.n30 VGND.n29 10.0354
R416 VGND VGND.n105 5.15812
R417 VGND.n105 VGND.n0 1.10578
R418 VGND.n31 VGND.n30 1.01178
R419 VGND.n30 VGND.n0 0.0945
R420 Y.t0 Y.n3 700.484
R421 Y.n4 Y.t0 700.484
R422 Y.t1 Y.n0 255.345
R423 Y.n1 Y.t1 255.345
R424 Y Y.n0 12.8005
R425 Y.n1 Y 12.8005
R426 Y Y.n3 12.8005
R427 Y.n4 Y 12.8005
R428 Y.n6 Y.n2 11.8381
R429 Y.n6 Y.n5 11.2854
R430 Y.n2 Y.n0 10.1513
R431 Y.n2 Y.n1 10.1513
R432 Y.n5 Y.n3 10.1513
R433 Y.n5 Y.n4 10.1513
R434 Y Y.n6 6.44004
C15 Y VGND 3.32835f
C16 B VGND 3.23854f
C17 A VGND 2.82485f
C18 VPWR VGND 10.2701f
C19 N1__N1 VGND 2.00033f $ **FLOATING
C20 N VGND 7.0136f $ **FLOATING
C21 Y.n0 VGND 0.01202f $ **FLOATING
C22 Y.t1 VGND 0.02922f $ **FLOATING
C23 Y.n1 VGND 0.01202f $ **FLOATING
C24 Y.n2 VGND 0.34253f $ **FLOATING
C25 Y.n3 VGND 0.01052f $ **FLOATING
C26 Y.t0 VGND 0.03221f $ **FLOATING
C27 Y.n4 VGND 0.01052f $ **FLOATING
C28 Y.n5 VGND 0.30639f $ **FLOATING
C29 Y.n6 VGND 4.61991f $ **FLOATING
C30 N1__N1.n0 VGND 0.01267f $ **FLOATING
C31 N1__N1.n1 VGND 0.01267f $ **FLOATING
C32 N1__N1.t1 VGND 0.03081f $ **FLOATING
C33 N1__N1.n2 VGND 0.01267f $ **FLOATING
C34 N1__N1.n3 VGND 2.33159f $ **FLOATING
C35 N1__N1.n4 VGND 2.24423f $ **FLOATING
C36 N1__N1.t0 VGND 0.03081f $ **FLOATING
C37 N1__N1.n5 VGND 0.01267f $ **FLOATING
C38 B.t1 VGND 0.04117f $ **FLOATING
C39 B.t0 VGND 0.04279f $ **FLOATING
C40 B.n0 VGND 4.03483f $ **FLOATING
C41 N.n0 VGND 0.00438f $ **FLOATING
C42 N.t3 VGND 0.01811f $ **FLOATING
C43 N.t4 VGND 0.01882f $ **FLOATING
C44 N.n1 VGND 1.23609f $ **FLOATING
C45 N.n2 VGND 0.00438f $ **FLOATING
C46 N.t1 VGND 0.01343f $ **FLOATING
C47 N.n3 VGND 0.00438f $ **FLOATING
C48 N.n4 VGND 0.17671f $ **FLOATING
C49 N.n5 VGND 0.00501f $ **FLOATING
C50 N.t2 VGND 0.01218f $ **FLOATING
C51 N.n6 VGND 0.00501f $ **FLOATING
C52 N.n7 VGND 0.14323f $ **FLOATING
C53 N.n8 VGND 1.20795f $ **FLOATING
C54 N.n9 VGND 0.74433f $ **FLOATING
C55 N.n10 VGND 0.14323f $ **FLOATING
C56 N.t0 VGND 0.01343f $ **FLOATING
C57 N.n11 VGND 0.00438f $ **FLOATING
C58 A.t1 VGND 0.02694f $ **FLOATING
C59 A.t0 VGND 0.028f $ **FLOATING
C60 A.n0 VGND 1.7192f $ **FLOATING
.ends

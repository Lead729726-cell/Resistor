.subckt NAND2 A0 A1 Y VPWR VGND
XMN0 Y A0 N1 VGND sky130_fd_pr__nfet_01v8 w=0.65 l=0.15 nf=1 m=1
XMN1 N1 A1 VGND VGND sky130_fd_pr__nfet_01v8 w=0.65 l=0.15 nf=1 m=1
XMP0 Y A0 VPWR VPWR sky130_fd_pr__pfet_01v8_hvt w=0.65 l=0.15 nf=1 m=1
XMP1 Y A1 VPWR VPWR sky130_fd_pr__pfet_01v8_hvt w=0.65 l=0.15 nf=1 m=1
.ends NAND2
.subckt full_adder A B CIN SUM COUT VPWR VGND
XN1 A B N1 VPWR VGND NAND2
XN2 A N1 N2 VPWR VGND NAND2
XN3 B N1 N3 VPWR VGND NAND2
XN4 N2 N3 P VPWR VGND NAND2
XN5 P CIN N5 VPWR VGND NAND2
XN6 P N5 N6 VPWR VGND NAND2
XN7 CIN N5 N7 VPWR VGND NAND2
XN8 N6 N7 SUM VPWR VGND NAND2
XN9 N1 N5 COUT VPWR VGND NAND2
.ends full_adder

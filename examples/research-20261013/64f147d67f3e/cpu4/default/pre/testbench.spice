Register actual transistor digital cpu4
.options noinit method=gear maxord=2
.include "/workspace/.runtime/eda/runs/8e5da3deff5c4db288d941396bcbef54/supported-tt.spice"
.option scale=1e-6
.include "/workspace/.runtime/eda/runs/8e5da3deff5c4db288d941396bcbef54/current-probe.spice"
.temp 27.0
VGND VGND 0 0
VDD VPWR VGND 1.8
VCLK CLK VGND PULSE(0 1.8 1e-07 1e-10 1e-10 1.96e-07 4e-07)
VRST RESET VGND PWL(0 1.8 7.2e-07 1.8 7.201e-07 0)
CLOAD_ACC0 ACC0 VGND 5e-15
CLOAD_ACC1 ACC1 VGND 5e-15
CLOAD_ACC2 ACC2 VGND 5e-15
CLOAD_ACC3 ACC3 VGND 5e-15
CLOAD_PC0 PC0 VGND 5e-15
CLOAD_PC1 PC1 VGND 5e-15
CLOAD_PC2 PC2 VGND 5e-15
CLOAD_PC3 PC3 VGND 5e-15
CLOAD_CARRY CARRY VGND 5e-15
CLOAD_ZERO ZERO VGND 5e-15
XU CLK RESET ACC0 ACC1 ACC2 ACC3 PC0 PC1 PC2 PC3 CARRY ZERO VPWR VGND cpu4
.control
save v(CLK) v(RESET) v(ACC0) v(ACC1) v(ACC2) v(ACC3) v(PC0) v(PC1) v(PC2) v(PC3) v(CARRY) v(ZERO) v(xu.OP0) v(xu.OP1) v(xu.IMM0) v(xu.IMM1) v(xu.IMM2) v(xu.IMM3) i(VDD) i(v.xu.xacc_reg0.vregister_cf_1532470e8825cafa) i(v.xu.xacc_reg0.vregister_cf_ad50516e93123ce0) i(v.xu.xacc_reg0.vregister_cf_eeaa3872c2dd9f8d) i(v.xu.xacc_reg0.vregister_cf_ef8ed4eded6c09f4) i(v.xu.xacc_reg0.vregister_cf_8b0bc9693bb836e6) i(v.xu.xacc_reg0.vregister_cf_d0d00b0b897b56d6) i(v.xu.xacc_reg0.vregister_cf_016ad729cc31b397) i(v.xu.xacc_reg0.vregister_cf_f781dc7a86153e61) i(v.xu.xacc_reg0.xiclk.vregister_cf_37eac2f2e7d80b63) i(v.xu.xacc_reg0.xiclk.vregister_cf_684eb771bbecb33a) i(v.xu.xacc_reg0.xm1.vregister_cf_37eac2f2e7d80b63) i(v.xu.xacc_reg0.xm1.vregister_cf_684eb771bbecb33a) i(v.xu.xacc_reg0.xm2.vregister_cf_37eac2f2e7d80b63) i(v.xu.xacc_reg0.xm2.vregister_cf_684eb771bbecb33a) i(v.xu.xacc_reg0.xs1.vregister_cf_37eac2f2e7d80b63) i(v.xu.xacc_reg0.xs1.vregister_cf_684eb771bbecb33a) i(v.xu.xacc_reg0.xs2.vregister_cf_37eac2f2e7d80b63) i(v.xu.xacc_reg0.xs2.vregister_cf_684eb771bbecb33a) i(v.xu.xacc_reg1.vregister_cf_1532470e8825cafa) i(v.xu.xacc_reg1.vregister_cf_ad50516e93123ce0) i(v.xu.xacc_reg1.vregister_cf_eeaa3872c2dd9f8d) i(v.xu.xacc_reg1.vregister_cf_ef8ed4eded6c09f4) i(v.xu.xacc_reg1.vregister_cf_8b0bc9693bb836e6) i(v.xu.xacc_reg1.vregister_cf_d0d00b0b897b56d6) i(v.xu.xacc_reg1.vregister_cf_016ad729cc31b397) i(v.xu.xacc_reg1.vregister_cf_f781dc7a86153e61) i(v.xu.xacc_reg1.xiclk.vregister_cf_37eac2f2e7d80b63) i(v.xu.xacc_reg1.xiclk.vregister_cf_684eb771bbecb33a) i(v.xu.xacc_reg1.xm1.vregister_cf_37eac2f2e7d80b63) i(v.xu.xacc_reg1.xm1.vregister_cf_684eb771bbecb33a) i(v.xu.xacc_reg1.xm2.vregister_cf_37eac2f2e7d80b63) i(v.xu.xacc_reg1.xm2.vregister_cf_684eb771bbecb33a) i(v.xu.xacc_reg1.xs1.vregister_cf_37eac2f2e7d80b63) i(v.xu.xacc_reg1.xs1.vregister_cf_684eb771bbecb33a) i(v.xu.xacc_reg1.xs2.vregister_cf_37eac2f2e7d80b63) i(v.xu.xacc_reg1.xs2.vregister_cf_684eb771bbecb33a) i(v.xu.xacc_reg2.vregister_cf_1532470e8825cafa) i(v.xu.xacc_reg2.vregister_cf_ad50516e93123ce0) i(v.xu.xacc_reg2.vregister_cf_eeaa3872c2dd9f8d) i(v.xu.xacc_reg2.vregister_cf_ef8ed4eded6c09f4) i(v.xu.xacc_reg2.vregister_cf_8b0bc9693bb836e6) i(v.xu.xacc_reg2.vregister_cf_d0d00b0b897b56d6) i(v.xu.xacc_reg2.vregister_cf_016ad729cc31b397) i(v.xu.xacc_reg2.vregister_cf_f781dc7a86153e61) i(v.xu.xacc_reg2.xiclk.vregister_cf_37eac2f2e7d80b63) i(v.xu.xacc_reg2.xiclk.vregister_cf_684eb771bbecb33a) i(v.xu.xacc_reg2.xm1.vregister_cf_37eac2f2e7d80b63) i(v.xu.xacc_reg2.xm1.vregister_cf_684eb771bbecb33a) i(v.xu.xacc_reg2.xm2.vregister_cf_37eac2f2e7d80b63) i(v.xu.xacc_reg2.xm2.vregister_cf_684eb771bbecb33a) i(v.xu.xacc_reg2.xs1.vregister_cf_37eac2f2e7d80b63) i(v.xu.xacc_reg2.xs1.vregister_cf_684eb771bbecb33a) i(v.xu.xacc_reg2.xs2.vregister_cf_37eac2f2e7d80b63) i(v.xu.xacc_reg2.xs2.vregister_cf_684eb771bbecb33a) i(v.xu.xacc_reg3.vregister_cf_1532470e8825cafa) i(v.xu.xacc_reg3.vregister_cf_ad50516e93123ce0) i(VGND) i(VCLK) i(VRST) v(XU.XACC_REG0.M) v(XU.NEXT_ACC0) v(XU.XACC_REG0.CLKB) v(VGND) v(XU.XACC_REG0.MF) v(XU.XACC_REG0.T) v(VPWR) v(XU.XACC_REG0.MB) v(XU.XACC_REG0.TB) v(XU.XACC_REG1.M) v(XU.NEXT_ACC1) v(XU.XACC_REG1.CLKB) v(XU.XACC_REG1.MF) v(XU.XACC_REG1.T) v(XU.XACC_REG1.MB) v(XU.XACC_REG1.TB) v(XU.XACC_REG2.M) v(XU.NEXT_ACC2) v(XU.XACC_REG2.CLKB) v(XU.XACC_REG2.MF) v(XU.XACC_REG2.T) v(XU.XACC_REG2.MB) v(XU.XACC_REG2.TB) v(XU.XACC_REG3.M) v(XU.NEXT_ACC3) v(XU.XACC_REG3.CLKB) v(XU.XACC_REG3.MF)
set num_threads=1
set noaskquit
set wr_singlescale
set wr_vecnames
tran 4e-09 7.6e-06
let mos_wave_0 = v(CLK)
let mos_wave_1 = v(RESET)
let mos_wave_2 = v(ACC0)
let mos_wave_3 = v(ACC1)
let mos_wave_4 = v(ACC2)
let mos_wave_5 = v(ACC3)
let mos_wave_6 = v(PC0)
let mos_wave_7 = v(PC1)
let mos_wave_8 = v(PC2)
let mos_wave_9 = v(PC3)
let mos_wave_10 = v(CARRY)
let mos_wave_11 = v(ZERO)
let mos_wave_12 = v(xu.OP0)
let mos_wave_13 = v(xu.OP1)
let mos_wave_14 = v(xu.IMM0)
let mos_wave_15 = v(xu.IMM1)
let mos_wave_16 = v(xu.IMM2)
let mos_wave_17 = v(xu.IMM3)
let mos_wave_18 = -i(VDD)
wrdata waveform.dat mos_wave_0 mos_wave_1 mos_wave_2 mos_wave_3 mos_wave_4 mos_wave_5 mos_wave_6 mos_wave_7 mos_wave_8 mos_wave_9 mos_wave_10 mos_wave_11 mos_wave_12 mos_wave_13 mos_wave_14 mos_wave_15 mos_wave_16 mos_wave_17 mos_wave_18
write waveform.raw all
let register_flow_0 = i(v.xu.xacc_reg0.vregister_cf_1532470e8825cafa)
let register_flow_1 = i(v.xu.xacc_reg0.vregister_cf_ad50516e93123ce0)
let register_flow_2 = i(v.xu.xacc_reg0.vregister_cf_eeaa3872c2dd9f8d)
let register_flow_3 = i(v.xu.xacc_reg0.vregister_cf_ef8ed4eded6c09f4)
let register_flow_4 = i(v.xu.xacc_reg0.vregister_cf_8b0bc9693bb836e6)
let register_flow_5 = i(v.xu.xacc_reg0.vregister_cf_d0d00b0b897b56d6)
let register_flow_6 = i(v.xu.xacc_reg0.vregister_cf_016ad729cc31b397)
let register_flow_7 = i(v.xu.xacc_reg0.vregister_cf_f781dc7a86153e61)
let register_flow_8 = i(v.xu.xacc_reg0.xiclk.vregister_cf_37eac2f2e7d80b63)
let register_flow_9 = i(v.xu.xacc_reg0.xiclk.vregister_cf_684eb771bbecb33a)
let register_flow_10 = i(v.xu.xacc_reg0.xm1.vregister_cf_37eac2f2e7d80b63)
let register_flow_11 = i(v.xu.xacc_reg0.xm1.vregister_cf_684eb771bbecb33a)
let register_flow_12 = i(v.xu.xacc_reg0.xm2.vregister_cf_37eac2f2e7d80b63)
let register_flow_13 = i(v.xu.xacc_reg0.xm2.vregister_cf_684eb771bbecb33a)
let register_flow_14 = i(v.xu.xacc_reg0.xs1.vregister_cf_37eac2f2e7d80b63)
let register_flow_15 = i(v.xu.xacc_reg0.xs1.vregister_cf_684eb771bbecb33a)
let register_flow_16 = i(v.xu.xacc_reg0.xs2.vregister_cf_37eac2f2e7d80b63)
let register_flow_17 = i(v.xu.xacc_reg0.xs2.vregister_cf_684eb771bbecb33a)
let register_flow_18 = i(v.xu.xacc_reg1.vregister_cf_1532470e8825cafa)
let register_flow_19 = i(v.xu.xacc_reg1.vregister_cf_ad50516e93123ce0)
let register_flow_20 = i(v.xu.xacc_reg1.vregister_cf_eeaa3872c2dd9f8d)
let register_flow_21 = i(v.xu.xacc_reg1.vregister_cf_ef8ed4eded6c09f4)
let register_flow_22 = i(v.xu.xacc_reg1.vregister_cf_8b0bc9693bb836e6)
let register_flow_23 = i(v.xu.xacc_reg1.vregister_cf_d0d00b0b897b56d6)
let register_flow_24 = i(v.xu.xacc_reg1.vregister_cf_016ad729cc31b397)
let register_flow_25 = i(v.xu.xacc_reg1.vregister_cf_f781dc7a86153e61)
let register_flow_26 = i(v.xu.xacc_reg1.xiclk.vregister_cf_37eac2f2e7d80b63)
let register_flow_27 = i(v.xu.xacc_reg1.xiclk.vregister_cf_684eb771bbecb33a)
let register_flow_28 = i(v.xu.xacc_reg1.xm1.vregister_cf_37eac2f2e7d80b63)
let register_flow_29 = i(v.xu.xacc_reg1.xm1.vregister_cf_684eb771bbecb33a)
let register_flow_30 = i(v.xu.xacc_reg1.xm2.vregister_cf_37eac2f2e7d80b63)
let register_flow_31 = i(v.xu.xacc_reg1.xm2.vregister_cf_684eb771bbecb33a)
let register_flow_32 = i(v.xu.xacc_reg1.xs1.vregister_cf_37eac2f2e7d80b63)
let register_flow_33 = i(v.xu.xacc_reg1.xs1.vregister_cf_684eb771bbecb33a)
let register_flow_34 = i(v.xu.xacc_reg1.xs2.vregister_cf_37eac2f2e7d80b63)
let register_flow_35 = i(v.xu.xacc_reg1.xs2.vregister_cf_684eb771bbecb33a)
let register_flow_36 = i(v.xu.xacc_reg2.vregister_cf_1532470e8825cafa)
let register_flow_37 = i(v.xu.xacc_reg2.vregister_cf_ad50516e93123ce0)
let register_flow_38 = i(v.xu.xacc_reg2.vregister_cf_eeaa3872c2dd9f8d)
let register_flow_39 = i(v.xu.xacc_reg2.vregister_cf_ef8ed4eded6c09f4)
let register_flow_40 = i(v.xu.xacc_reg2.vregister_cf_8b0bc9693bb836e6)
let register_flow_41 = i(v.xu.xacc_reg2.vregister_cf_d0d00b0b897b56d6)
let register_flow_42 = i(v.xu.xacc_reg2.vregister_cf_016ad729cc31b397)
let register_flow_43 = i(v.xu.xacc_reg2.vregister_cf_f781dc7a86153e61)
let register_flow_44 = i(v.xu.xacc_reg2.xiclk.vregister_cf_37eac2f2e7d80b63)
let register_flow_45 = i(v.xu.xacc_reg2.xiclk.vregister_cf_684eb771bbecb33a)
let register_flow_46 = i(v.xu.xacc_reg2.xm1.vregister_cf_37eac2f2e7d80b63)
let register_flow_47 = i(v.xu.xacc_reg2.xm1.vregister_cf_684eb771bbecb33a)
let register_flow_48 = i(v.xu.xacc_reg2.xm2.vregister_cf_37eac2f2e7d80b63)
let register_flow_49 = i(v.xu.xacc_reg2.xm2.vregister_cf_684eb771bbecb33a)
let register_flow_50 = i(v.xu.xacc_reg2.xs1.vregister_cf_37eac2f2e7d80b63)
let register_flow_51 = i(v.xu.xacc_reg2.xs1.vregister_cf_684eb771bbecb33a)
let register_flow_52 = i(v.xu.xacc_reg2.xs2.vregister_cf_37eac2f2e7d80b63)
let register_flow_53 = i(v.xu.xacc_reg2.xs2.vregister_cf_684eb771bbecb33a)
let register_flow_54 = i(v.xu.xacc_reg3.vregister_cf_1532470e8825cafa)
let register_flow_55 = i(v.xu.xacc_reg3.vregister_cf_ad50516e93123ce0)
let register_flow_56 = i(VGND)
let register_flow_57 = i(VDD)
let register_flow_58 = i(VCLK)
let register_flow_59 = i(VRST)
wrdata current-flow.dat register_flow_0 register_flow_1 register_flow_2 register_flow_3 register_flow_4 register_flow_5 register_flow_6 register_flow_7 register_flow_8 register_flow_9 register_flow_10 register_flow_11 register_flow_12 register_flow_13 register_flow_14 register_flow_15 register_flow_16 register_flow_17 register_flow_18 register_flow_19 register_flow_20 register_flow_21 register_flow_22 register_flow_23 register_flow_24 register_flow_25 register_flow_26 register_flow_27 register_flow_28 register_flow_29 register_flow_30 register_flow_31 register_flow_32 register_flow_33 register_flow_34 register_flow_35 register_flow_36 register_flow_37 register_flow_38 register_flow_39 register_flow_40 register_flow_41 register_flow_42 register_flow_43 register_flow_44 register_flow_45 register_flow_46 register_flow_47 register_flow_48 register_flow_49 register_flow_50 register_flow_51 register_flow_52 register_flow_53 register_flow_54 register_flow_55 register_flow_56 register_flow_57 register_flow_58 register_flow_59
let register_voltage_0 = v(XU.XACC_REG0.M)
let register_voltage_1 = v(XU.NEXT_ACC0)
let register_voltage_2 = v(XU.XACC_REG0.CLKB)
let register_voltage_3 = v(VGND)
let register_voltage_4 = v(XU.XACC_REG0.MF)
let register_voltage_5 = v(CLK)
let register_voltage_6 = v(XU.XACC_REG0.T)
let register_voltage_7 = v(ACC0)
let register_voltage_8 = v(VPWR)
let register_voltage_9 = v(XU.XACC_REG0.MB)
let register_voltage_10 = v(XU.XACC_REG0.TB)
let register_voltage_11 = v(XU.XACC_REG1.M)
let register_voltage_12 = v(XU.NEXT_ACC1)
let register_voltage_13 = v(XU.XACC_REG1.CLKB)
let register_voltage_14 = v(XU.XACC_REG1.MF)
let register_voltage_15 = v(XU.XACC_REG1.T)
let register_voltage_16 = v(ACC1)
let register_voltage_17 = v(XU.XACC_REG1.MB)
let register_voltage_18 = v(XU.XACC_REG1.TB)
let register_voltage_19 = v(XU.XACC_REG2.M)
let register_voltage_20 = v(XU.NEXT_ACC2)
let register_voltage_21 = v(XU.XACC_REG2.CLKB)
let register_voltage_22 = v(XU.XACC_REG2.MF)
let register_voltage_23 = v(XU.XACC_REG2.T)
let register_voltage_24 = v(ACC2)
let register_voltage_25 = v(XU.XACC_REG2.MB)
let register_voltage_26 = v(XU.XACC_REG2.TB)
let register_voltage_27 = v(XU.XACC_REG3.M)
let register_voltage_28 = v(XU.NEXT_ACC3)
let register_voltage_29 = v(XU.XACC_REG3.CLKB)
let register_voltage_30 = v(XU.XACC_REG3.MF)
let register_voltage_31 = 0*register_flow_0
let register_voltage_32 = v(RESET)
wrdata node-voltages.dat register_voltage_0 register_voltage_1 register_voltage_2 register_voltage_3 register_voltage_4 register_voltage_5 register_voltage_6 register_voltage_7 register_voltage_8 register_voltage_9 register_voltage_10 register_voltage_11 register_voltage_12 register_voltage_13 register_voltage_14 register_voltage_15 register_voltage_16 register_voltage_17 register_voltage_18 register_voltage_19 register_voltage_20 register_voltage_21 register_voltage_22 register_voltage_23 register_voltage_24 register_voltage_25 register_voltage_26 register_voltage_27 register_voltage_28 register_voltage_29 register_voltage_30 register_voltage_31 register_voltage_32
quit
.endc
.end

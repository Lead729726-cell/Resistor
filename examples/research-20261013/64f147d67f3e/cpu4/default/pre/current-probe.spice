.subckt INV A Y VPWR VGND
XMN register_cf_node_37eac2f2e7d80b63 A register_cf_node_37eac2f2e7d80b63_source VGND sky130_fd_pr__nfet_01v8 w=0.65 l=0.15 nf=1 m=1
Vregister_cf_37eac2f2e7d80b63 Y register_cf_node_37eac2f2e7d80b63 0
Vregister_cf_37eac2f2e7d80b63_source VGND register_cf_node_37eac2f2e7d80b63_source 0
XMP register_cf_node_684eb771bbecb33a A register_cf_node_684eb771bbecb33a_source VPWR sky130_fd_pr__pfet_01v8_hvt w=0.65 l=0.15 nf=1 m=1
Vregister_cf_684eb771bbecb33a Y register_cf_node_684eb771bbecb33a 0
Vregister_cf_684eb771bbecb33a_source VPWR register_cf_node_684eb771bbecb33a_source 0
.ends INV
.subckt NAND4 A0 A1 A2 A3 Y VPWR VGND
XMN0 register_cf_node_90cb44b421387dd3 A0 register_cf_node_90cb44b421387dd3_source VGND sky130_fd_pr__nfet_01v8 w=0.65 l=0.15 nf=1 m=1
Vregister_cf_90cb44b421387dd3 Y register_cf_node_90cb44b421387dd3 0
Vregister_cf_90cb44b421387dd3_source N1 register_cf_node_90cb44b421387dd3_source 0
XMN1 register_cf_node_45e45b58e79ebf1a A1 register_cf_node_45e45b58e79ebf1a_source VGND sky130_fd_pr__nfet_01v8 w=0.65 l=0.15 nf=1 m=1
Vregister_cf_45e45b58e79ebf1a N1 register_cf_node_45e45b58e79ebf1a 0
Vregister_cf_45e45b58e79ebf1a_source N2 register_cf_node_45e45b58e79ebf1a_source 0
XMN2 register_cf_node_5b729d7bbf34e727 A2 register_cf_node_5b729d7bbf34e727_source VGND sky130_fd_pr__nfet_01v8 w=0.65 l=0.15 nf=1 m=1
Vregister_cf_5b729d7bbf34e727 N2 register_cf_node_5b729d7bbf34e727 0
Vregister_cf_5b729d7bbf34e727_source N3 register_cf_node_5b729d7bbf34e727_source 0
XMN3 register_cf_node_815e7f5c6bab2250 A3 register_cf_node_815e7f5c6bab2250_source VGND sky130_fd_pr__nfet_01v8 w=0.65 l=0.15 nf=1 m=1
Vregister_cf_815e7f5c6bab2250 N3 register_cf_node_815e7f5c6bab2250 0
Vregister_cf_815e7f5c6bab2250_source VGND register_cf_node_815e7f5c6bab2250_source 0
XMP0 register_cf_node_cbe681943b7bc649 A0 register_cf_node_cbe681943b7bc649_source VPWR sky130_fd_pr__pfet_01v8_hvt w=0.65 l=0.15 nf=1 m=1
Vregister_cf_cbe681943b7bc649 Y register_cf_node_cbe681943b7bc649 0
Vregister_cf_cbe681943b7bc649_source VPWR register_cf_node_cbe681943b7bc649_source 0
XMP1 register_cf_node_cc38d00de872a56d A1 register_cf_node_cc38d00de872a56d_source VPWR sky130_fd_pr__pfet_01v8_hvt w=0.65 l=0.15 nf=1 m=1
Vregister_cf_cc38d00de872a56d Y register_cf_node_cc38d00de872a56d 0
Vregister_cf_cc38d00de872a56d_source VPWR register_cf_node_cc38d00de872a56d_source 0
XMP2 register_cf_node_39a1a5d177e73051 A2 register_cf_node_39a1a5d177e73051_source VPWR sky130_fd_pr__pfet_01v8_hvt w=0.65 l=0.15 nf=1 m=1
Vregister_cf_39a1a5d177e73051 Y register_cf_node_39a1a5d177e73051 0
Vregister_cf_39a1a5d177e73051_source VPWR register_cf_node_39a1a5d177e73051_source 0
XMP3 register_cf_node_81c0565e7142dd60 A3 register_cf_node_81c0565e7142dd60_source VPWR sky130_fd_pr__pfet_01v8_hvt w=0.65 l=0.15 nf=1 m=1
Vregister_cf_81c0565e7142dd60 Y register_cf_node_81c0565e7142dd60 0
Vregister_cf_81c0565e7142dd60_source VPWR register_cf_node_81c0565e7142dd60_source 0
.ends NAND4
.subckt NAND10 A0 A1 A2 A3 A4 A5 A6 A7 A8 A9 Y VPWR VGND
XMN0 register_cf_node_35a4a9aff4aa45c0 A0 register_cf_node_35a4a9aff4aa45c0_source VGND sky130_fd_pr__nfet_01v8 w=0.65 l=0.15 nf=1 m=1
Vregister_cf_35a4a9aff4aa45c0 Y register_cf_node_35a4a9aff4aa45c0 0
Vregister_cf_35a4a9aff4aa45c0_source N1 register_cf_node_35a4a9aff4aa45c0_source 0
XMN1 register_cf_node_de8672fa5838ed0b A1 register_cf_node_de8672fa5838ed0b_source VGND sky130_fd_pr__nfet_01v8 w=0.65 l=0.15 nf=1 m=1
Vregister_cf_de8672fa5838ed0b N1 register_cf_node_de8672fa5838ed0b 0
Vregister_cf_de8672fa5838ed0b_source N2 register_cf_node_de8672fa5838ed0b_source 0
XMN2 register_cf_node_690c84bc3669b8ca A2 register_cf_node_690c84bc3669b8ca_source VGND sky130_fd_pr__nfet_01v8 w=0.65 l=0.15 nf=1 m=1
Vregister_cf_690c84bc3669b8ca N2 register_cf_node_690c84bc3669b8ca 0
Vregister_cf_690c84bc3669b8ca_source N3 register_cf_node_690c84bc3669b8ca_source 0
XMN3 register_cf_node_a4e794d258ac0efc A3 register_cf_node_a4e794d258ac0efc_source VGND sky130_fd_pr__nfet_01v8 w=0.65 l=0.15 nf=1 m=1
Vregister_cf_a4e794d258ac0efc N3 register_cf_node_a4e794d258ac0efc 0
Vregister_cf_a4e794d258ac0efc_source N4 register_cf_node_a4e794d258ac0efc_source 0
XMN4 register_cf_node_be0d0a5b8016b4a9 A4 register_cf_node_be0d0a5b8016b4a9_source VGND sky130_fd_pr__nfet_01v8 w=0.65 l=0.15 nf=1 m=1
Vregister_cf_be0d0a5b8016b4a9 N4 register_cf_node_be0d0a5b8016b4a9 0
Vregister_cf_be0d0a5b8016b4a9_source N5 register_cf_node_be0d0a5b8016b4a9_source 0
XMN5 register_cf_node_fb69a47b45938659 A5 register_cf_node_fb69a47b45938659_source VGND sky130_fd_pr__nfet_01v8 w=0.65 l=0.15 nf=1 m=1
Vregister_cf_fb69a47b45938659 N5 register_cf_node_fb69a47b45938659 0
Vregister_cf_fb69a47b45938659_source N6 register_cf_node_fb69a47b45938659_source 0
XMN6 register_cf_node_10da40ffbc5475ba A6 register_cf_node_10da40ffbc5475ba_source VGND sky130_fd_pr__nfet_01v8 w=0.65 l=0.15 nf=1 m=1
Vregister_cf_10da40ffbc5475ba N6 register_cf_node_10da40ffbc5475ba 0
Vregister_cf_10da40ffbc5475ba_source N7 register_cf_node_10da40ffbc5475ba_source 0
XMN7 register_cf_node_5bc3599bf87cb7b2 A7 register_cf_node_5bc3599bf87cb7b2_source VGND sky130_fd_pr__nfet_01v8 w=0.65 l=0.15 nf=1 m=1
Vregister_cf_5bc3599bf87cb7b2 N7 register_cf_node_5bc3599bf87cb7b2 0
Vregister_cf_5bc3599bf87cb7b2_source N8 register_cf_node_5bc3599bf87cb7b2_source 0
XMN8 register_cf_node_a37f4779902a7e8b A8 register_cf_node_a37f4779902a7e8b_source VGND sky130_fd_pr__nfet_01v8 w=0.65 l=0.15 nf=1 m=1
Vregister_cf_a37f4779902a7e8b N8 register_cf_node_a37f4779902a7e8b 0
Vregister_cf_a37f4779902a7e8b_source N9 register_cf_node_a37f4779902a7e8b_source 0
XMN9 register_cf_node_630971c15a3c9b80 A9 register_cf_node_630971c15a3c9b80_source VGND sky130_fd_pr__nfet_01v8 w=0.65 l=0.15 nf=1 m=1
Vregister_cf_630971c15a3c9b80 N9 register_cf_node_630971c15a3c9b80 0
Vregister_cf_630971c15a3c9b80_source VGND register_cf_node_630971c15a3c9b80_source 0
XMP0 register_cf_node_9101bb9377202571 A0 register_cf_node_9101bb9377202571_source VPWR sky130_fd_pr__pfet_01v8_hvt w=0.65 l=0.15 nf=1 m=1
Vregister_cf_9101bb9377202571 Y register_cf_node_9101bb9377202571 0
Vregister_cf_9101bb9377202571_source VPWR register_cf_node_9101bb9377202571_source 0
XMP1 register_cf_node_e41ebb412bee370a A1 register_cf_node_e41ebb412bee370a_source VPWR sky130_fd_pr__pfet_01v8_hvt w=0.65 l=0.15 nf=1 m=1
Vregister_cf_e41ebb412bee370a Y register_cf_node_e41ebb412bee370a 0
Vregister_cf_e41ebb412bee370a_source VPWR register_cf_node_e41ebb412bee370a_source 0
XMP2 register_cf_node_a237e6f492ebdf09 A2 register_cf_node_a237e6f492ebdf09_source VPWR sky130_fd_pr__pfet_01v8_hvt w=0.65 l=0.15 nf=1 m=1
Vregister_cf_a237e6f492ebdf09 Y register_cf_node_a237e6f492ebdf09 0
Vregister_cf_a237e6f492ebdf09_source VPWR register_cf_node_a237e6f492ebdf09_source 0
XMP3 register_cf_node_a50892d1c930768b A3 register_cf_node_a50892d1c930768b_source VPWR sky130_fd_pr__pfet_01v8_hvt w=0.65 l=0.15 nf=1 m=1
Vregister_cf_a50892d1c930768b Y register_cf_node_a50892d1c930768b 0
Vregister_cf_a50892d1c930768b_source VPWR register_cf_node_a50892d1c930768b_source 0
XMP4 register_cf_node_e53b43f6df1d9407 A4 register_cf_node_e53b43f6df1d9407_source VPWR sky130_fd_pr__pfet_01v8_hvt w=0.65 l=0.15 nf=1 m=1
Vregister_cf_e53b43f6df1d9407 Y register_cf_node_e53b43f6df1d9407 0
Vregister_cf_e53b43f6df1d9407_source VPWR register_cf_node_e53b43f6df1d9407_source 0
XMP5 register_cf_node_4aceeb41dba0b58b A5 register_cf_node_4aceeb41dba0b58b_source VPWR sky130_fd_pr__pfet_01v8_hvt w=0.65 l=0.15 nf=1 m=1
Vregister_cf_4aceeb41dba0b58b Y register_cf_node_4aceeb41dba0b58b 0
Vregister_cf_4aceeb41dba0b58b_source VPWR register_cf_node_4aceeb41dba0b58b_source 0
XMP6 register_cf_node_8e153dfecdcb66be A6 register_cf_node_8e153dfecdcb66be_source VPWR sky130_fd_pr__pfet_01v8_hvt w=0.65 l=0.15 nf=1 m=1
Vregister_cf_8e153dfecdcb66be Y register_cf_node_8e153dfecdcb66be 0
Vregister_cf_8e153dfecdcb66be_source VPWR register_cf_node_8e153dfecdcb66be_source 0
XMP7 register_cf_node_f0c12047c5900d53 A7 register_cf_node_f0c12047c5900d53_source VPWR sky130_fd_pr__pfet_01v8_hvt w=0.65 l=0.15 nf=1 m=1
Vregister_cf_f0c12047c5900d53 Y register_cf_node_f0c12047c5900d53 0
Vregister_cf_f0c12047c5900d53_source VPWR register_cf_node_f0c12047c5900d53_source 0
XMP8 register_cf_node_559fa8e40669fbec A8 register_cf_node_559fa8e40669fbec_source VPWR sky130_fd_pr__pfet_01v8_hvt w=0.65 l=0.15 nf=1 m=1
Vregister_cf_559fa8e40669fbec Y register_cf_node_559fa8e40669fbec 0
Vregister_cf_559fa8e40669fbec_source VPWR register_cf_node_559fa8e40669fbec_source 0
XMP9 register_cf_node_fe835841f8f9e812 A9 register_cf_node_fe835841f8f9e812_source VPWR sky130_fd_pr__pfet_01v8_hvt w=0.65 l=0.15 nf=1 m=1
Vregister_cf_fe835841f8f9e812 Y register_cf_node_fe835841f8f9e812 0
Vregister_cf_fe835841f8f9e812_source VPWR register_cf_node_fe835841f8f9e812_source 0
.ends NAND10
.subckt NAND9 A0 A1 A2 A3 A4 A5 A6 A7 A8 Y VPWR VGND
XMN0 register_cf_node_33debdd5ef2fcca3 A0 register_cf_node_33debdd5ef2fcca3_source VGND sky130_fd_pr__nfet_01v8 w=0.65 l=0.15 nf=1 m=1
Vregister_cf_33debdd5ef2fcca3 Y register_cf_node_33debdd5ef2fcca3 0
Vregister_cf_33debdd5ef2fcca3_source N1 register_cf_node_33debdd5ef2fcca3_source 0
XMN1 register_cf_node_9459c900a21de0c0 A1 register_cf_node_9459c900a21de0c0_source VGND sky130_fd_pr__nfet_01v8 w=0.65 l=0.15 nf=1 m=1
Vregister_cf_9459c900a21de0c0 N1 register_cf_node_9459c900a21de0c0 0
Vregister_cf_9459c900a21de0c0_source N2 register_cf_node_9459c900a21de0c0_source 0
XMN2 register_cf_node_bdfb120681c474cf A2 register_cf_node_bdfb120681c474cf_source VGND sky130_fd_pr__nfet_01v8 w=0.65 l=0.15 nf=1 m=1
Vregister_cf_bdfb120681c474cf N2 register_cf_node_bdfb120681c474cf 0
Vregister_cf_bdfb120681c474cf_source N3 register_cf_node_bdfb120681c474cf_source 0
XMN3 register_cf_node_c384b1586139244b A3 register_cf_node_c384b1586139244b_source VGND sky130_fd_pr__nfet_01v8 w=0.65 l=0.15 nf=1 m=1
Vregister_cf_c384b1586139244b N3 register_cf_node_c384b1586139244b 0
Vregister_cf_c384b1586139244b_source N4 register_cf_node_c384b1586139244b_source 0
XMN4 register_cf_node_ab907d60592d9385 A4 register_cf_node_ab907d60592d9385_source VGND sky130_fd_pr__nfet_01v8 w=0.65 l=0.15 nf=1 m=1
Vregister_cf_ab907d60592d9385 N4 register_cf_node_ab907d60592d9385 0
Vregister_cf_ab907d60592d9385_source N5 register_cf_node_ab907d60592d9385_source 0
XMN5 register_cf_node_f6b869ff8a2dbbe7 A5 register_cf_node_f6b869ff8a2dbbe7_source VGND sky130_fd_pr__nfet_01v8 w=0.65 l=0.15 nf=1 m=1
Vregister_cf_f6b869ff8a2dbbe7 N5 register_cf_node_f6b869ff8a2dbbe7 0
Vregister_cf_f6b869ff8a2dbbe7_source N6 register_cf_node_f6b869ff8a2dbbe7_source 0
XMN6 register_cf_node_88c2353ee92a73b0 A6 register_cf_node_88c2353ee92a73b0_source VGND sky130_fd_pr__nfet_01v8 w=0.65 l=0.15 nf=1 m=1
Vregister_cf_88c2353ee92a73b0 N6 register_cf_node_88c2353ee92a73b0 0
Vregister_cf_88c2353ee92a73b0_source N7 register_cf_node_88c2353ee92a73b0_source 0
XMN7 register_cf_node_b450cc4801a8a5af A7 register_cf_node_b450cc4801a8a5af_source VGND sky130_fd_pr__nfet_01v8 w=0.65 l=0.15 nf=1 m=1
Vregister_cf_b450cc4801a8a5af N7 register_cf_node_b450cc4801a8a5af 0
Vregister_cf_b450cc4801a8a5af_source N8 register_cf_node_b450cc4801a8a5af_source 0
XMN8 register_cf_node_83e9802d06d75465 A8 register_cf_node_83e9802d06d75465_source VGND sky130_fd_pr__nfet_01v8 w=0.65 l=0.15 nf=1 m=1
Vregister_cf_83e9802d06d75465 N8 register_cf_node_83e9802d06d75465 0
Vregister_cf_83e9802d06d75465_source VGND register_cf_node_83e9802d06d75465_source 0
XMP0 register_cf_node_36a305bd038d5fe1 A0 register_cf_node_36a305bd038d5fe1_source VPWR sky130_fd_pr__pfet_01v8_hvt w=0.65 l=0.15 nf=1 m=1
Vregister_cf_36a305bd038d5fe1 Y register_cf_node_36a305bd038d5fe1 0
Vregister_cf_36a305bd038d5fe1_source VPWR register_cf_node_36a305bd038d5fe1_source 0
XMP1 register_cf_node_02c573e02ca09763 A1 register_cf_node_02c573e02ca09763_source VPWR sky130_fd_pr__pfet_01v8_hvt w=0.65 l=0.15 nf=1 m=1
Vregister_cf_02c573e02ca09763 Y register_cf_node_02c573e02ca09763 0
Vregister_cf_02c573e02ca09763_source VPWR register_cf_node_02c573e02ca09763_source 0
XMP2 register_cf_node_0e625c9b94d3a95a A2 register_cf_node_0e625c9b94d3a95a_source VPWR sky130_fd_pr__pfet_01v8_hvt w=0.65 l=0.15 nf=1 m=1
Vregister_cf_0e625c9b94d3a95a Y register_cf_node_0e625c9b94d3a95a 0
Vregister_cf_0e625c9b94d3a95a_source VPWR register_cf_node_0e625c9b94d3a95a_source 0
XMP3 register_cf_node_df7e27076cef8206 A3 register_cf_node_df7e27076cef8206_source VPWR sky130_fd_pr__pfet_01v8_hvt w=0.65 l=0.15 nf=1 m=1
Vregister_cf_df7e27076cef8206 Y register_cf_node_df7e27076cef8206 0
Vregister_cf_df7e27076cef8206_source VPWR register_cf_node_df7e27076cef8206_source 0
XMP4 register_cf_node_ffddefae2857b420 A4 register_cf_node_ffddefae2857b420_source VPWR sky130_fd_pr__pfet_01v8_hvt w=0.65 l=0.15 nf=1 m=1
Vregister_cf_ffddefae2857b420 Y register_cf_node_ffddefae2857b420 0
Vregister_cf_ffddefae2857b420_source VPWR register_cf_node_ffddefae2857b420_source 0
XMP5 register_cf_node_547b008f772c3389 A5 register_cf_node_547b008f772c3389_source VPWR sky130_fd_pr__pfet_01v8_hvt w=0.65 l=0.15 nf=1 m=1
Vregister_cf_547b008f772c3389 Y register_cf_node_547b008f772c3389 0
Vregister_cf_547b008f772c3389_source VPWR register_cf_node_547b008f772c3389_source 0
XMP6 register_cf_node_5e42345fd7cabe29 A6 register_cf_node_5e42345fd7cabe29_source VPWR sky130_fd_pr__pfet_01v8_hvt w=0.65 l=0.15 nf=1 m=1
Vregister_cf_5e42345fd7cabe29 Y register_cf_node_5e42345fd7cabe29 0
Vregister_cf_5e42345fd7cabe29_source VPWR register_cf_node_5e42345fd7cabe29_source 0
XMP7 register_cf_node_caf81f42f0bd0740 A7 register_cf_node_caf81f42f0bd0740_source VPWR sky130_fd_pr__pfet_01v8_hvt w=0.65 l=0.15 nf=1 m=1
Vregister_cf_caf81f42f0bd0740 Y register_cf_node_caf81f42f0bd0740 0
Vregister_cf_caf81f42f0bd0740_source VPWR register_cf_node_caf81f42f0bd0740_source 0
XMP8 register_cf_node_979a7944d288d396 A8 register_cf_node_979a7944d288d396_source VPWR sky130_fd_pr__pfet_01v8_hvt w=0.65 l=0.15 nf=1 m=1
Vregister_cf_979a7944d288d396 Y register_cf_node_979a7944d288d396 0
Vregister_cf_979a7944d288d396_source VPWR register_cf_node_979a7944d288d396_source 0
.ends NAND9
.subckt NAND7 A0 A1 A2 A3 A4 A5 A6 Y VPWR VGND
XMN0 register_cf_node_df84bb48a852d218 A0 register_cf_node_df84bb48a852d218_source VGND sky130_fd_pr__nfet_01v8 w=0.65 l=0.15 nf=1 m=1
Vregister_cf_df84bb48a852d218 Y register_cf_node_df84bb48a852d218 0
Vregister_cf_df84bb48a852d218_source N1 register_cf_node_df84bb48a852d218_source 0
XMN1 register_cf_node_27164b25c2265b9d A1 register_cf_node_27164b25c2265b9d_source VGND sky130_fd_pr__nfet_01v8 w=0.65 l=0.15 nf=1 m=1
Vregister_cf_27164b25c2265b9d N1 register_cf_node_27164b25c2265b9d 0
Vregister_cf_27164b25c2265b9d_source N2 register_cf_node_27164b25c2265b9d_source 0
XMN2 register_cf_node_f31c0fd5cff17876 A2 register_cf_node_f31c0fd5cff17876_source VGND sky130_fd_pr__nfet_01v8 w=0.65 l=0.15 nf=1 m=1
Vregister_cf_f31c0fd5cff17876 N2 register_cf_node_f31c0fd5cff17876 0
Vregister_cf_f31c0fd5cff17876_source N3 register_cf_node_f31c0fd5cff17876_source 0
XMN3 register_cf_node_fc4e0ef7613461ad A3 register_cf_node_fc4e0ef7613461ad_source VGND sky130_fd_pr__nfet_01v8 w=0.65 l=0.15 nf=1 m=1
Vregister_cf_fc4e0ef7613461ad N3 register_cf_node_fc4e0ef7613461ad 0
Vregister_cf_fc4e0ef7613461ad_source N4 register_cf_node_fc4e0ef7613461ad_source 0
XMN4 register_cf_node_811d5ad4513313ff A4 register_cf_node_811d5ad4513313ff_source VGND sky130_fd_pr__nfet_01v8 w=0.65 l=0.15 nf=1 m=1
Vregister_cf_811d5ad4513313ff N4 register_cf_node_811d5ad4513313ff 0
Vregister_cf_811d5ad4513313ff_source N5 register_cf_node_811d5ad4513313ff_source 0
XMN5 register_cf_node_a73f523e203d5544 A5 register_cf_node_a73f523e203d5544_source VGND sky130_fd_pr__nfet_01v8 w=0.65 l=0.15 nf=1 m=1
Vregister_cf_a73f523e203d5544 N5 register_cf_node_a73f523e203d5544 0
Vregister_cf_a73f523e203d5544_source N6 register_cf_node_a73f523e203d5544_source 0
XMN6 register_cf_node_3d0da63b90a732b1 A6 register_cf_node_3d0da63b90a732b1_source VGND sky130_fd_pr__nfet_01v8 w=0.65 l=0.15 nf=1 m=1
Vregister_cf_3d0da63b90a732b1 N6 register_cf_node_3d0da63b90a732b1 0
Vregister_cf_3d0da63b90a732b1_source VGND register_cf_node_3d0da63b90a732b1_source 0
XMP0 register_cf_node_07124f010ca851de A0 register_cf_node_07124f010ca851de_source VPWR sky130_fd_pr__pfet_01v8_hvt w=0.65 l=0.15 nf=1 m=1
Vregister_cf_07124f010ca851de Y register_cf_node_07124f010ca851de 0
Vregister_cf_07124f010ca851de_source VPWR register_cf_node_07124f010ca851de_source 0
XMP1 register_cf_node_73b425f0c8e05323 A1 register_cf_node_73b425f0c8e05323_source VPWR sky130_fd_pr__pfet_01v8_hvt w=0.65 l=0.15 nf=1 m=1
Vregister_cf_73b425f0c8e05323 Y register_cf_node_73b425f0c8e05323 0
Vregister_cf_73b425f0c8e05323_source VPWR register_cf_node_73b425f0c8e05323_source 0
XMP2 register_cf_node_d120079099931bcb A2 register_cf_node_d120079099931bcb_source VPWR sky130_fd_pr__pfet_01v8_hvt w=0.65 l=0.15 nf=1 m=1
Vregister_cf_d120079099931bcb Y register_cf_node_d120079099931bcb 0
Vregister_cf_d120079099931bcb_source VPWR register_cf_node_d120079099931bcb_source 0
XMP3 register_cf_node_eafecdf32c72963c A3 register_cf_node_eafecdf32c72963c_source VPWR sky130_fd_pr__pfet_01v8_hvt w=0.65 l=0.15 nf=1 m=1
Vregister_cf_eafecdf32c72963c Y register_cf_node_eafecdf32c72963c 0
Vregister_cf_eafecdf32c72963c_source VPWR register_cf_node_eafecdf32c72963c_source 0
XMP4 register_cf_node_37af88b8fa0b1240 A4 register_cf_node_37af88b8fa0b1240_source VPWR sky130_fd_pr__pfet_01v8_hvt w=0.65 l=0.15 nf=1 m=1
Vregister_cf_37af88b8fa0b1240 Y register_cf_node_37af88b8fa0b1240 0
Vregister_cf_37af88b8fa0b1240_source VPWR register_cf_node_37af88b8fa0b1240_source 0
XMP5 register_cf_node_f6829f518f1c0514 A5 register_cf_node_f6829f518f1c0514_source VPWR sky130_fd_pr__pfet_01v8_hvt w=0.65 l=0.15 nf=1 m=1
Vregister_cf_f6829f518f1c0514 Y register_cf_node_f6829f518f1c0514 0
Vregister_cf_f6829f518f1c0514_source VPWR register_cf_node_f6829f518f1c0514_source 0
XMP6 register_cf_node_8ba95f5f73ce9fd7 A6 register_cf_node_8ba95f5f73ce9fd7_source VPWR sky130_fd_pr__pfet_01v8_hvt w=0.65 l=0.15 nf=1 m=1
Vregister_cf_8ba95f5f73ce9fd7 Y register_cf_node_8ba95f5f73ce9fd7 0
Vregister_cf_8ba95f5f73ce9fd7_source VPWR register_cf_node_8ba95f5f73ce9fd7_source 0
.ends NAND7
.subckt NAND6 A0 A1 A2 A3 A4 A5 Y VPWR VGND
XMN0 register_cf_node_d8062e7d5cb32f1e A0 register_cf_node_d8062e7d5cb32f1e_source VGND sky130_fd_pr__nfet_01v8 w=0.65 l=0.15 nf=1 m=1
Vregister_cf_d8062e7d5cb32f1e Y register_cf_node_d8062e7d5cb32f1e 0
Vregister_cf_d8062e7d5cb32f1e_source N1 register_cf_node_d8062e7d5cb32f1e_source 0
XMN1 register_cf_node_a7b18f5ebc0d8228 A1 register_cf_node_a7b18f5ebc0d8228_source VGND sky130_fd_pr__nfet_01v8 w=0.65 l=0.15 nf=1 m=1
Vregister_cf_a7b18f5ebc0d8228 N1 register_cf_node_a7b18f5ebc0d8228 0
Vregister_cf_a7b18f5ebc0d8228_source N2 register_cf_node_a7b18f5ebc0d8228_source 0
XMN2 register_cf_node_4d27903b8dd40e29 A2 register_cf_node_4d27903b8dd40e29_source VGND sky130_fd_pr__nfet_01v8 w=0.65 l=0.15 nf=1 m=1
Vregister_cf_4d27903b8dd40e29 N2 register_cf_node_4d27903b8dd40e29 0
Vregister_cf_4d27903b8dd40e29_source N3 register_cf_node_4d27903b8dd40e29_source 0
XMN3 register_cf_node_6d9520c299c265ec A3 register_cf_node_6d9520c299c265ec_source VGND sky130_fd_pr__nfet_01v8 w=0.65 l=0.15 nf=1 m=1
Vregister_cf_6d9520c299c265ec N3 register_cf_node_6d9520c299c265ec 0
Vregister_cf_6d9520c299c265ec_source N4 register_cf_node_6d9520c299c265ec_source 0
XMN4 register_cf_node_e707184af5150eac A4 register_cf_node_e707184af5150eac_source VGND sky130_fd_pr__nfet_01v8 w=0.65 l=0.15 nf=1 m=1
Vregister_cf_e707184af5150eac N4 register_cf_node_e707184af5150eac 0
Vregister_cf_e707184af5150eac_source N5 register_cf_node_e707184af5150eac_source 0
XMN5 register_cf_node_46f5f255ac2cf75f A5 register_cf_node_46f5f255ac2cf75f_source VGND sky130_fd_pr__nfet_01v8 w=0.65 l=0.15 nf=1 m=1
Vregister_cf_46f5f255ac2cf75f N5 register_cf_node_46f5f255ac2cf75f 0
Vregister_cf_46f5f255ac2cf75f_source VGND register_cf_node_46f5f255ac2cf75f_source 0
XMP0 register_cf_node_3c7fb5cc2df085c1 A0 register_cf_node_3c7fb5cc2df085c1_source VPWR sky130_fd_pr__pfet_01v8_hvt w=0.65 l=0.15 nf=1 m=1
Vregister_cf_3c7fb5cc2df085c1 Y register_cf_node_3c7fb5cc2df085c1 0
Vregister_cf_3c7fb5cc2df085c1_source VPWR register_cf_node_3c7fb5cc2df085c1_source 0
XMP1 register_cf_node_f5eee84c593727e8 A1 register_cf_node_f5eee84c593727e8_source VPWR sky130_fd_pr__pfet_01v8_hvt w=0.65 l=0.15 nf=1 m=1
Vregister_cf_f5eee84c593727e8 Y register_cf_node_f5eee84c593727e8 0
Vregister_cf_f5eee84c593727e8_source VPWR register_cf_node_f5eee84c593727e8_source 0
XMP2 register_cf_node_c4f405e1a785c16a A2 register_cf_node_c4f405e1a785c16a_source VPWR sky130_fd_pr__pfet_01v8_hvt w=0.65 l=0.15 nf=1 m=1
Vregister_cf_c4f405e1a785c16a Y register_cf_node_c4f405e1a785c16a 0
Vregister_cf_c4f405e1a785c16a_source VPWR register_cf_node_c4f405e1a785c16a_source 0
XMP3 register_cf_node_8678b026e027287d A3 register_cf_node_8678b026e027287d_source VPWR sky130_fd_pr__pfet_01v8_hvt w=0.65 l=0.15 nf=1 m=1
Vregister_cf_8678b026e027287d Y register_cf_node_8678b026e027287d 0
Vregister_cf_8678b026e027287d_source VPWR register_cf_node_8678b026e027287d_source 0
XMP4 register_cf_node_a8926642eb94c3de A4 register_cf_node_a8926642eb94c3de_source VPWR sky130_fd_pr__pfet_01v8_hvt w=0.65 l=0.15 nf=1 m=1
Vregister_cf_a8926642eb94c3de Y register_cf_node_a8926642eb94c3de 0
Vregister_cf_a8926642eb94c3de_source VPWR register_cf_node_a8926642eb94c3de_source 0
XMP5 register_cf_node_be09c43d893a2923 A5 register_cf_node_be09c43d893a2923_source VPWR sky130_fd_pr__pfet_01v8_hvt w=0.65 l=0.15 nf=1 m=1
Vregister_cf_be09c43d893a2923 Y register_cf_node_be09c43d893a2923 0
Vregister_cf_be09c43d893a2923_source VPWR register_cf_node_be09c43d893a2923_source 0
.ends NAND6
.subckt ROM16 P0 P1 P2 P3 I0 I1 I2 I3 O0 O1 VPWR VGND
XDEC0 PB0 PB1 PB2 PB3 D0 VPWR VGND NAND4
XDEC1 P0 PB1 PB2 PB3 D1 VPWR VGND NAND4
XDEC10 PB0 P1 PB2 P3 D10 VPWR VGND NAND4
XDEC11 P0 P1 PB2 P3 D11 VPWR VGND NAND4
XDEC12 PB0 PB1 P2 P3 D12 VPWR VGND NAND4
XDEC13 P0 PB1 P2 P3 D13 VPWR VGND NAND4
XDEC14 PB0 P1 P2 P3 D14 VPWR VGND NAND4
XDEC15 P0 P1 P2 P3 D15 VPWR VGND NAND4
XDEC2 PB0 P1 PB2 PB3 D2 VPWR VGND NAND4
XDEC3 P0 P1 PB2 PB3 D3 VPWR VGND NAND4
XDEC4 PB0 PB1 P2 PB3 D4 VPWR VGND NAND4
XDEC5 P0 PB1 P2 PB3 D5 VPWR VGND NAND4
XDEC6 PB0 P1 P2 PB3 D6 VPWR VGND NAND4
XDEC7 P0 P1 P2 PB3 D7 VPWR VGND NAND4
XDEC8 PB0 PB1 PB2 P3 D8 VPWR VGND NAND4
XDEC9 P0 PB1 PB2 P3 D9 VPWR VGND NAND4
XIP0 P0 PB0 VPWR VGND INV
XIP1 P1 PB1 VPWR VGND INV
XIP2 P2 PB2 VPWR VGND INV
XIP3 P3 PB3 VPWR VGND INV
XROM0 D0 D1 D2 D4 D5 D6 D7 D9 D11 D13 I0 VPWR VGND NAND10
XROM1 D0 D3 D4 D5 D7 D8 D9 D11 D14 I1 VPWR VGND NAND9
XROM2 D1 D4 D5 D7 D8 D9 D11 D13 D15 I2 VPWR VGND NAND9
XROM3 D2 D3 D5 D7 D9 D12 D14 I3 VPWR VGND NAND7
XROM4 D1 D2 D3 D6 D7 D9 D11 D12 D13 O0 VPWR VGND NAND9
XROM5 D3 D4 D8 D9 D13 D14 O1 VPWR VGND NAND6
.ends ROM16
.subckt NAND2 A0 A1 Y VPWR VGND
XMN0 register_cf_node_377cff7a8fc053f0 A0 register_cf_node_377cff7a8fc053f0_source VGND sky130_fd_pr__nfet_01v8 w=0.65 l=0.15 nf=1 m=1
Vregister_cf_377cff7a8fc053f0 Y register_cf_node_377cff7a8fc053f0 0
Vregister_cf_377cff7a8fc053f0_source N1 register_cf_node_377cff7a8fc053f0_source 0
XMN1 register_cf_node_12c0ec391985518a A1 register_cf_node_12c0ec391985518a_source VGND sky130_fd_pr__nfet_01v8 w=0.65 l=0.15 nf=1 m=1
Vregister_cf_12c0ec391985518a N1 register_cf_node_12c0ec391985518a 0
Vregister_cf_12c0ec391985518a_source VGND register_cf_node_12c0ec391985518a_source 0
XMP0 register_cf_node_1c0f6f4ae9f406c8 A0 register_cf_node_1c0f6f4ae9f406c8_source VPWR sky130_fd_pr__pfet_01v8_hvt w=0.65 l=0.15 nf=1 m=1
Vregister_cf_1c0f6f4ae9f406c8 Y register_cf_node_1c0f6f4ae9f406c8 0
Vregister_cf_1c0f6f4ae9f406c8_source VPWR register_cf_node_1c0f6f4ae9f406c8_source 0
XMP1 register_cf_node_092f3ee2a80b5958 A1 register_cf_node_092f3ee2a80b5958_source VPWR sky130_fd_pr__pfet_01v8_hvt w=0.65 l=0.15 nf=1 m=1
Vregister_cf_092f3ee2a80b5958 Y register_cf_node_092f3ee2a80b5958 0
Vregister_cf_092f3ee2a80b5958_source VPWR register_cf_node_092f3ee2a80b5958_source 0
.ends NAND2
.subckt FA A B CIN SUM COUT VPWR VGND
XN1 A B N1 VPWR VGND NAND2
XN2 A N1 N2 VPWR VGND NAND2
XN3 B N1 N3 VPWR VGND NAND2
XN4 N2 N3 P VPWR VGND NAND2
XN5 P CIN N5 VPWR VGND NAND2
XN6 P N5 N6 VPWR VGND NAND2
XN7 CIN N5 N7 VPWR VGND NAND2
XN8 N6 N7 SUM VPWR VGND NAND2
XN9 N1 N5 COUT VPWR VGND NAND2
.ends FA
.subckt ADD4 A0 A1 A2 A3 B0 B1 B2 B3 CIN S0 S1 S2 S3 COUT VPWR VGND
XBIT0 A0 B0 CIN S0 C1 VPWR VGND FA
XBIT1 A1 B1 C1 S1 C2 VPWR VGND FA
XBIT2 A2 B2 C2 S2 C3 VPWR VGND FA
XBIT3 A3 B3 C3 S3 COUT VPWR VGND FA
.ends ADD4
.subckt AND2 A B Y VPWR VGND
XI1 N Y VPWR VGND INV
XN1 A B N VPWR VGND NAND2
.ends AND2
.subckt XOR2 A B Y VPWR VGND
XN1 A B N1 VPWR VGND NAND2
XN2 A N1 N2 VPWR VGND NAND2
XN3 B N1 N3 VPWR VGND NAND2
XN4 N2 N3 Y VPWR VGND NAND2
.ends XOR2
.subckt MUX2 A B S Y VPWR VGND
XIS S SB VPWR VGND INV
XMNA register_cf_node_bbc0a6d3f4fd8c5e SB register_cf_node_bbc0a6d3f4fd8c5e_source VGND sky130_fd_pr__nfet_01v8 w=0.65 l=0.15 nf=1 m=1
Vregister_cf_bbc0a6d3f4fd8c5e Y register_cf_node_bbc0a6d3f4fd8c5e 0
Vregister_cf_bbc0a6d3f4fd8c5e_source A register_cf_node_bbc0a6d3f4fd8c5e_source 0
XMNB register_cf_node_83cccc875ed4527b S register_cf_node_83cccc875ed4527b_source VGND sky130_fd_pr__nfet_01v8 w=0.65 l=0.15 nf=1 m=1
Vregister_cf_83cccc875ed4527b Y register_cf_node_83cccc875ed4527b 0
Vregister_cf_83cccc875ed4527b_source B register_cf_node_83cccc875ed4527b_source 0
XMPA register_cf_node_7370e7e8c7f6aa5a S register_cf_node_7370e7e8c7f6aa5a_source VPWR sky130_fd_pr__pfet_01v8_hvt w=0.65 l=0.15 nf=1 m=1
Vregister_cf_7370e7e8c7f6aa5a Y register_cf_node_7370e7e8c7f6aa5a 0
Vregister_cf_7370e7e8c7f6aa5a_source A register_cf_node_7370e7e8c7f6aa5a_source 0
XMPB register_cf_node_00d7986dfe60e3f6 SB register_cf_node_00d7986dfe60e3f6_source VPWR sky130_fd_pr__pfet_01v8_hvt w=0.65 l=0.15 nf=1 m=1
Vregister_cf_00d7986dfe60e3f6 Y register_cf_node_00d7986dfe60e3f6 0
Vregister_cf_00d7986dfe60e3f6_source B register_cf_node_00d7986dfe60e3f6_source 0
.ends MUX2
.subckt DFF D CLK Q VPWR VGND
XICLK CLK CLKB VPWR VGND INV
XM1 M MB VPWR VGND INV
XM2 MB MF VPWR VGND INV
XMNIN register_cf_node_1532470e8825cafa CLKB register_cf_node_1532470e8825cafa_source VGND sky130_fd_pr__nfet_01v8 w=0.65 l=0.15 nf=1 m=1
Vregister_cf_1532470e8825cafa M register_cf_node_1532470e8825cafa 0
Vregister_cf_1532470e8825cafa_source D register_cf_node_1532470e8825cafa_source 0
XMNMF register_cf_node_ad50516e93123ce0 CLK register_cf_node_ad50516e93123ce0_source VGND sky130_fd_pr__nfet_01v8 w=0.65 l=0.15 nf=1 m=1
Vregister_cf_ad50516e93123ce0 M register_cf_node_ad50516e93123ce0 0
Vregister_cf_ad50516e93123ce0_source MF register_cf_node_ad50516e93123ce0_source 0
XMNOUT register_cf_node_eeaa3872c2dd9f8d CLK register_cf_node_eeaa3872c2dd9f8d_source VGND sky130_fd_pr__nfet_01v8 w=0.65 l=0.15 nf=1 m=1
Vregister_cf_eeaa3872c2dd9f8d T register_cf_node_eeaa3872c2dd9f8d 0
Vregister_cf_eeaa3872c2dd9f8d_source MF register_cf_node_eeaa3872c2dd9f8d_source 0
XMNSF register_cf_node_ef8ed4eded6c09f4 CLKB register_cf_node_ef8ed4eded6c09f4_source VGND sky130_fd_pr__nfet_01v8 w=0.65 l=0.15 nf=1 m=1
Vregister_cf_ef8ed4eded6c09f4 T register_cf_node_ef8ed4eded6c09f4 0
Vregister_cf_ef8ed4eded6c09f4_source Q register_cf_node_ef8ed4eded6c09f4_source 0
XMPIN register_cf_node_8b0bc9693bb836e6 CLK register_cf_node_8b0bc9693bb836e6_source VPWR sky130_fd_pr__pfet_01v8_hvt w=0.65 l=0.15 nf=1 m=1
Vregister_cf_8b0bc9693bb836e6 M register_cf_node_8b0bc9693bb836e6 0
Vregister_cf_8b0bc9693bb836e6_source D register_cf_node_8b0bc9693bb836e6_source 0
XMPMF register_cf_node_d0d00b0b897b56d6 CLKB register_cf_node_d0d00b0b897b56d6_source VPWR sky130_fd_pr__pfet_01v8_hvt w=0.65 l=0.15 nf=1 m=1
Vregister_cf_d0d00b0b897b56d6 M register_cf_node_d0d00b0b897b56d6 0
Vregister_cf_d0d00b0b897b56d6_source MF register_cf_node_d0d00b0b897b56d6_source 0
XMPOUT register_cf_node_016ad729cc31b397 CLKB register_cf_node_016ad729cc31b397_source VPWR sky130_fd_pr__pfet_01v8_hvt w=0.65 l=0.15 nf=1 m=1
Vregister_cf_016ad729cc31b397 T register_cf_node_016ad729cc31b397 0
Vregister_cf_016ad729cc31b397_source MF register_cf_node_016ad729cc31b397_source 0
XMPSF register_cf_node_f781dc7a86153e61 CLK register_cf_node_f781dc7a86153e61_source VPWR sky130_fd_pr__pfet_01v8_hvt w=0.65 l=0.15 nf=1 m=1
Vregister_cf_f781dc7a86153e61 T register_cf_node_f781dc7a86153e61 0
Vregister_cf_f781dc7a86153e61_source Q register_cf_node_f781dc7a86153e61_source 0
XS1 T TB VPWR VGND INV
XS2 TB Q VPWR VGND INV
.ends DFF
.subckt NAND3 A0 A1 A2 Y VPWR VGND
XMN0 register_cf_node_63a77504f7413c32 A0 register_cf_node_63a77504f7413c32_source VGND sky130_fd_pr__nfet_01v8 w=0.65 l=0.15 nf=1 m=1
Vregister_cf_63a77504f7413c32 Y register_cf_node_63a77504f7413c32 0
Vregister_cf_63a77504f7413c32_source N1 register_cf_node_63a77504f7413c32_source 0
XMN1 register_cf_node_31e2239a5e7439d8 A1 register_cf_node_31e2239a5e7439d8_source VGND sky130_fd_pr__nfet_01v8 w=0.65 l=0.15 nf=1 m=1
Vregister_cf_31e2239a5e7439d8 N1 register_cf_node_31e2239a5e7439d8 0
Vregister_cf_31e2239a5e7439d8_source N2 register_cf_node_31e2239a5e7439d8_source 0
XMN2 register_cf_node_06e64f28b4b38281 A2 register_cf_node_06e64f28b4b38281_source VGND sky130_fd_pr__nfet_01v8 w=0.65 l=0.15 nf=1 m=1
Vregister_cf_06e64f28b4b38281 N2 register_cf_node_06e64f28b4b38281 0
Vregister_cf_06e64f28b4b38281_source VGND register_cf_node_06e64f28b4b38281_source 0
XMP0 register_cf_node_fe27d89251933aef A0 register_cf_node_fe27d89251933aef_source VPWR sky130_fd_pr__pfet_01v8_hvt w=0.65 l=0.15 nf=1 m=1
Vregister_cf_fe27d89251933aef Y register_cf_node_fe27d89251933aef 0
Vregister_cf_fe27d89251933aef_source VPWR register_cf_node_fe27d89251933aef_source 0
XMP1 register_cf_node_f96b4a01ac36553f A1 register_cf_node_f96b4a01ac36553f_source VPWR sky130_fd_pr__pfet_01v8_hvt w=0.65 l=0.15 nf=1 m=1
Vregister_cf_f96b4a01ac36553f Y register_cf_node_f96b4a01ac36553f 0
Vregister_cf_f96b4a01ac36553f_source VPWR register_cf_node_f96b4a01ac36553f_source 0
XMP2 register_cf_node_de453345a41ed12e A2 register_cf_node_de453345a41ed12e_source VPWR sky130_fd_pr__pfet_01v8_hvt w=0.65 l=0.15 nf=1 m=1
Vregister_cf_de453345a41ed12e Y register_cf_node_de453345a41ed12e 0
Vregister_cf_de453345a41ed12e_source VPWR register_cf_node_de453345a41ed12e_source 0
.ends NAND3
.subckt cpu4 CLK RESET ACC0 ACC1 ACC2 ACC3 PC0 PC1 PC2 PC3 CARRY ZERO VPWR VGND
XACC_REG0 NEXT_ACC0 CLK ACC0 VPWR VGND DFF
XACC_REG1 NEXT_ACC1 CLK ACC1 VPWR VGND DFF
XACC_REG2 NEXT_ACC2 CLK ACC2 VPWR VGND DFF
XACC_REG3 NEXT_ACC3 CLK ACC3 VPWR VGND DFF
XADD_ENABLE OP0 OP1B IS_ADD VPWR VGND AND2
XALU_ADD ACC0 ACC1 ACC2 ACC3 IMM0 IMM1 IMM2 IMM3 VGND ADD0 ADD1 ADD2 ADD3 ADD_CARRY VPWR VGND ADD4
XALU_AND0 ACC0 IMM0 AND0 VPWR VGND AND2
XALU_AND1 ACC1 IMM1 AND1 VPWR VGND AND2
XALU_AND2 ACC2 IMM2 AND2 VPWR VGND AND2
XALU_AND3 ACC3 IMM3 AND3 VPWR VGND AND2
XALU_XOR0 ACC0 IMM0 XOR0 VPWR VGND XOR2
XALU_XOR1 ACC1 IMM1 XOR1 VPWR VGND XOR2
XALU_XOR2 ACC2 IMM2 XOR2 VPWR VGND XOR2
XALU_XOR3 ACC3 IMM3 XOR3 VPWR VGND XOR2
XCARRY_REG CD CLK CARRY VPWR VGND DFF
XCARRY_RESET CV RESETB CD VPWR VGND AND2
XCARRY_VALUE ADD_CARRY IS_ADD CV VPWR VGND AND2
XHIGH0 AND0 XOR0 OP0 H0 VPWR VGND MUX2
XHIGH1 AND1 XOR1 OP0 H1 VPWR VGND MUX2
XHIGH2 AND2 XOR2 OP0 H2 VPWR VGND MUX2
XHIGH3 AND3 XOR3 OP0 H3 VPWR VGND MUX2
XIOP1 OP1 OP1B VPWR VGND INV
XIR RESET RESETB VPWR VGND INV
XLOW0 IMM0 ADD0 OP0 L0 VPWR VGND MUX2
XLOW1 IMM1 ADD1 OP0 L1 VPWR VGND MUX2
XLOW2 IMM2 ADD2 OP0 L2 VPWR VGND MUX2
XLOW3 IMM3 ADD3 OP0 L3 VPWR VGND MUX2
XPCC2 PC0 PC1 PC_CB2 VPWR VGND NAND2
XPCC3 PC0 PC1 PC2 PC_CB3 VPWR VGND NAND3
XPCCI2 PC_CB2 PC_C2 VPWR VGND INV
XPCCI3 PC_CB3 PC_C3 VPWR VGND INV
XPC_PLUS0 PC0 PC_NEXT0 VPWR VGND INV
XPC_PLUS1 PC1 PC0 PC_NEXT1 VPWR VGND XOR2
XPC_PLUS2 PC2 PC_C2 PC_NEXT2 VPWR VGND XOR2
XPC_PLUS3 PC3 PC_C3 PC_NEXT3 VPWR VGND XOR2
XPC_REG0 PC_D0 CLK PC0 VPWR VGND DFF
XPC_REG1 PC_D1 CLK PC1 VPWR VGND DFF
XPC_REG2 PC_D2 CLK PC2 VPWR VGND DFF
XPC_REG3 PC_D3 CLK PC3 VPWR VGND DFF
XRESET_ACC0 RES0 RESETB NEXT_ACC0 VPWR VGND AND2
XRESET_ACC1 RES1 RESETB NEXT_ACC1 VPWR VGND AND2
XRESET_ACC2 RES2 RESETB NEXT_ACC2 VPWR VGND AND2
XRESET_ACC3 RES3 RESETB NEXT_ACC3 VPWR VGND AND2
XRESET_PC0 PC_NEXT0 RESETB PC_D0 VPWR VGND AND2
XRESET_PC1 PC_NEXT1 RESETB PC_D1 VPWR VGND AND2
XRESET_PC2 PC_NEXT2 RESETB PC_D2 VPWR VGND AND2
XRESET_PC3 PC_NEXT3 RESETB PC_D3 VPWR VGND AND2
XRESULT0 L0 H0 OP1 RES0 VPWR VGND MUX2
XRESULT1 L1 H1 OP1 RES1 VPWR VGND MUX2
XRESULT2 L2 H2 OP1 RES2 VPWR VGND MUX2
XRESULT3 L3 H3 OP1 RES3 VPWR VGND MUX2
XROM PC0 PC1 PC2 PC3 IMM0 IMM1 IMM2 IMM3 OP0 OP1 VPWR VGND ROM16
XZI ZERO_B ZERO VPWR VGND INV
XZI0 ACC0 ACC_B0 VPWR VGND INV
XZI1 ACC1 ACC_B1 VPWR VGND INV
XZI2 ACC2 ACC_B2 VPWR VGND INV
XZI3 ACC3 ACC_B3 VPWR VGND INV
XZN ACC_B0 ACC_B1 ACC_B2 ACC_B3 ZERO_B VPWR VGND NAND4
.ends cpu4

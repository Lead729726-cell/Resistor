Register actual native common_source_bias
.include "/workspace/.runtime/eda/runs/d40911e0731e4befba4037d3abd96a3d/supported-tt.spice"
.option scale=1e-6
.include "/workspace/.runtime/eda/runs/d40911e0731e4befba4037d3abd96a3d/current-probe.spice"
.temp 27.0
VGND VGND 0 0
VDD VPWR VGND 1.8
VIN IN VGND 0 AC 1 PULSE(0 0.01 10e-9 1e-12 1e-12 20e-9 40e-9)
XU IN OUT VPWR VGND common_source_bias
.control
save v(IN) v(OUT) i(VDD) v(xu.GATE) i(v.xu.vregister_cf_4fd70e60ff15b77d) i(v.xu.vregister_cf_ec959fe42841a287) i(v.xu.vregister_cf_3bb4d08f2366a390) i(v.xu.vregister_cf_79ef0548dcece81a) i(v.xu.vregister_cf_7f32bd107c40da34) i(VGND) i(VIN) v(XU.GATE) v(VGND) v(VPWR)
set num_threads=1
set noaskquit
set wr_singlescale
set wr_vecnames
op
let mos_sample_index=0
setscale mos_sample_index
let mos_wave_0 = v(IN)
let mos_wave_1 = v(OUT)
let mos_wave_2 = -i(VDD)
let mos_wave_3 = v(xu.GATE)
wrdata waveform.dat mos_wave_0 mos_wave_1 mos_wave_2 mos_wave_3
write waveform.raw all
let register_flow_0 = i(v.xu.vregister_cf_4fd70e60ff15b77d)
let register_flow_1 = i(v.xu.vregister_cf_ec959fe42841a287)
let register_flow_2 = i(v.xu.vregister_cf_3bb4d08f2366a390)
let register_flow_3 = i(v.xu.vregister_cf_79ef0548dcece81a)
let register_flow_4 = i(v.xu.vregister_cf_7f32bd107c40da34)
let register_flow_5 = i(VGND)
let register_flow_6 = i(VDD)
let register_flow_7 = i(VIN)
wrdata current-flow.dat register_flow_0 register_flow_1 register_flow_2 register_flow_3 register_flow_4 register_flow_5 register_flow_6 register_flow_7
let register_voltage_0 = v(IN)
let register_voltage_1 = v(XU.GATE)
let register_voltage_2 = v(OUT)
let register_voltage_3 = v(VGND)
let register_voltage_4 = v(VPWR)
let register_voltage_5 = 0*register_flow_0
wrdata node-voltages.dat register_voltage_0 register_voltage_1 register_voltage_2 register_voltage_3 register_voltage_4 register_voltage_5
quit
.endc
.end

.subckt IVR_BIAS BIAS ENB VPWR VGND
XN_DISABLE BIAS ENB VGND VGND sky130_fd_pr__nfet_01v8 w=2 l=0.15 nf=1 m=1
XN_REFERENCE BIAS BIAS VGND VGND sky130_fd_pr__nfet_01v8 w=2 l=1 nf=1 m=1
RR_BIAS VPWR BIAS 100000
.ends IVR_BIAS
.subckt IVR_ERROR_AMP INP INN BIAS OUT VPWR VGND
XN_INN MIR INN TAIL VGND sky130_fd_pr__nfet_01v8 w=10 l=1 nf=1 m=1
XN_INP OUT INP TAIL VGND sky130_fd_pr__nfet_01v8 w=10 l=1 nf=1 m=1
XN_TAIL TAIL BIAS VGND VGND sky130_fd_pr__nfet_01v8 w=2 l=1 nf=1 m=1
XP_DIODE MIR MIR VPWR VPWR sky130_fd_pr__pfet_01v8_hvt w=20 l=1 nf=1 m=1
XP_MIRROR OUT MIR VPWR VPWR sky130_fd_pr__pfet_01v8_hvt w=20 l=1 nf=1 m=1
.ends IVR_ERROR_AMP
.subckt IVR_PASS_BANK OUT GATE VPWR VGND
XP_PASS0 OUT GATE VPWR VPWR sky130_fd_pr__pfet_01v8_hvt w=20 l=0.15 nf=1 m=1
XP_PASS1 OUT GATE VPWR VPWR sky130_fd_pr__pfet_01v8_hvt w=20 l=0.15 nf=1 m=1
XP_PASS2 OUT GATE VPWR VPWR sky130_fd_pr__pfet_01v8_hvt w=20 l=0.15 nf=1 m=1
XP_PASS3 OUT GATE VPWR VPWR sky130_fd_pr__pfet_01v8_hvt w=20 l=0.15 nf=1 m=1
XP_PASS4 OUT GATE VPWR VPWR sky130_fd_pr__pfet_01v8_hvt w=20 l=0.15 nf=1 m=1
XP_PASS5 OUT GATE VPWR VPWR sky130_fd_pr__pfet_01v8_hvt w=20 l=0.15 nf=1 m=1
XP_PASS6 OUT GATE VPWR VPWR sky130_fd_pr__pfet_01v8_hvt w=20 l=0.15 nf=1 m=1
XP_PASS7 OUT GATE VPWR VPWR sky130_fd_pr__pfet_01v8_hvt w=20 l=0.15 nf=1 m=1
.ends IVR_PASS_BANK
.subckt IVR_FEEDBACK OUT FB VGND
RR_BOTTOM FB VGND 200000
RR_TOP OUT FB 200000
.ends IVR_FEEDBACK
.subckt IVR_COMPENSATION EA_OUT GATE OUT
CC_COMP GATE ZERO 1e-11
RR_GATE EA_OUT GATE 1000
RR_ZERO ZERO OUT 1000
.ends IVR_COMPENSATION
.subckt IVR_ENABLE EN ENB GATE OUT VPWR VGND
XN_DISCHARGE OUT ENB VGND VGND sky130_fd_pr__nfet_01v8 w=2 l=1 nf=1 m=1
XN_INV ENB EN VGND VGND sky130_fd_pr__nfet_01v8 w=0.5 l=0.15 nf=1 m=1
XP_GATE_OFF GATE EN VPWR VPWR sky130_fd_pr__pfet_01v8_hvt w=20 l=0.15 nf=1 m=1
XP_INV ENB EN VPWR VPWR sky130_fd_pr__pfet_01v8_hvt w=1 l=0.15 nf=1 m=1
.ends IVR_ENABLE
.subckt IVR_DECOUPLING OUT VGND
CC_DECAP CAP VGND 1e-09
RR_ESR OUT CAP 0.5
.ends IVR_DECOUPLING
.subckt soc_ivr_ldo VREF EN OUT FB GATE BIAS VPWR VGND
XBIAS_SOURCE BIAS ENB VPWR VGND IVR_BIAS
XCOMPENSATION EA_OUT GATE OUT IVR_COMPENSATION
XDECOUPLING OUT VGND IVR_DECOUPLING
XENABLE EN ENB GATE OUT VPWR VGND IVR_ENABLE
XERROR_AMP VREF FB BIAS EA_OUT VPWR VGND IVR_ERROR_AMP
XFEEDBACK OUT FB VGND IVR_FEEDBACK
XPASS_BANK OUT GATE VPWR VGND IVR_PASS_BANK
.ends soc_ivr_ldo

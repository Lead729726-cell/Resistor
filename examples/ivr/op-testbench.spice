Resistor actual SKY130 integrated linear IVR
.include "D:/Coldbrew/Resistor/.runtime/ivr/native-xLgP2f/.runtime/eda/runs/eccb9fdb18d54754bf15d7041c2ad6f5/supported-tt.spice"
.include "D:/Coldbrew/Resistor/.runtime/ivr/native-xLgP2f/.runtime/eda/runs/eccb9fdb18d54754bf15d7041c2ad6f5/current-probe.spice"
.options method=gear maxord=2
.temp 27.0
VGND VGND 0 0
RLOAD OUT VGND 60000
RSTEP OUT LOADSTEP 6666.66666666667
SLOAD LOADSTEP VGND LOADCTL VGND LOADSW
.model LOADSW SW(Ron=0.1 Roff=1e12 Vt=0.9 Vh=0.01)
VDD VPWR VGND DC 1.8
VREF VREF VGND 0.6
VEN EN VGND 1.8
VLOAD LOADCTL VGND 0
XU VREF EN OUT FB GATE BIAS VPWR VGND soc_ivr_ldo
.control
save v(VPWR) v(OUT) v(VREF) v(EN) v(FB) v(GATE) v(BIAS) i(VDD) v(LOADSTEP) i(v.xu.xbias_source.vregister_cf_d37d12aa8cf06331) i(v.xu.xbias_source.vregister_cf_dd4ede4dbf4bae16) i(v.xu.xbias_source.vregister_cf_de07c8350dd0f476) i(v.xu.xcompensation.vregister_cf_6cdd9e1f389fce08) i(v.xu.xcompensation.vregister_cf_df25474645d3940e) i(v.xu.xcompensation.vregister_cf_f44bbfd662c3f8ae) i(v.xu.xdecoupling.vregister_cf_1d8faa75b4dcbb23) i(v.xu.xdecoupling.vregister_cf_064b9505254ecced) i(v.xu.xenable.vregister_cf_c33c2ff7fe49e0d5) i(v.xu.xenable.vregister_cf_aed81ceac9cbe1a6) i(v.xu.xenable.vregister_cf_cb376e86ae90d043) i(v.xu.xenable.vregister_cf_bbb44029696b84a4) i(v.xu.xerror_amp.vregister_cf_f2e07793da078661) i(v.xu.xerror_amp.vregister_cf_f6460027b7ffd0cb) i(v.xu.xerror_amp.vregister_cf_c2ebf366e6639bec) i(v.xu.xerror_amp.vregister_cf_d67cc245ee41645f) i(v.xu.xerror_amp.vregister_cf_e4e51937b39b4691) i(v.xu.xfeedback.vregister_cf_bc5172b93ca5807b) i(v.xu.xfeedback.vregister_cf_3a422fb5728ac531) i(v.xu.xpass_bank.vregister_cf_c4529c8a644aa122) i(v.xu.xpass_bank.vregister_cf_c660b9f0af5d49c1) i(v.xu.xpass_bank.vregister_cf_51ed9378459231fb) i(v.xu.xpass_bank.vregister_cf_2d0a7a0607cba687) i(v.xu.xpass_bank.vregister_cf_366d33dfcfdbad65) i(v.xu.xpass_bank.vregister_cf_1b67208cb208e966) i(v.xu.xpass_bank.vregister_cf_fde30e2d2f4a090a) i(v.xu.xpass_bank.vregister_cf_3d469519e4ead358) i(VGND) i(VREF) i(VEN) i(VLOAD) v(VGND) v(XU.ENB) v(XU.XCOMPENSATION.ZERO) v(XU.EA_OUT) v(XU.XDECOUPLING.CAP) v(XU.XERROR_AMP.MIR) v(XU.XERROR_AMP.TAIL) v(LOADCTL)
set num_threads=1
set numdgt=17
set wr_singlescale
set wr_vecnames
set noaskquit
op
let mos_sample_index=0
setscale mos_sample_index
let mos_wave_0 = v(VPWR)
let mos_wave_1 = v(OUT)
let mos_wave_2 = v(VREF)
let mos_wave_3 = v(EN)
let mos_wave_4 = v(FB)
let mos_wave_5 = v(GATE)
let mos_wave_6 = v(BIAS)
let mos_wave_7 = -i(VDD)
let mos_wave_8 = v(OUT)/60000+(v(OUT)-v(LOADSTEP))/6666.66666666667
wrdata waveform.dat mos_wave_0 mos_wave_1 mos_wave_2 mos_wave_3 mos_wave_4 mos_wave_5 mos_wave_6 mos_wave_7 mos_wave_8
write waveform.raw all
let register_flow_0 = i(v.xu.xbias_source.vregister_cf_d37d12aa8cf06331)
let register_flow_1 = i(v.xu.xbias_source.vregister_cf_dd4ede4dbf4bae16)
let register_flow_2 = i(v.xu.xbias_source.vregister_cf_de07c8350dd0f476)
let register_flow_3 = i(v.xu.xcompensation.vregister_cf_6cdd9e1f389fce08)
let register_flow_4 = i(v.xu.xcompensation.vregister_cf_df25474645d3940e)
let register_flow_5 = i(v.xu.xcompensation.vregister_cf_f44bbfd662c3f8ae)
let register_flow_6 = i(v.xu.xdecoupling.vregister_cf_1d8faa75b4dcbb23)
let register_flow_7 = i(v.xu.xdecoupling.vregister_cf_064b9505254ecced)
let register_flow_8 = i(v.xu.xenable.vregister_cf_c33c2ff7fe49e0d5)
let register_flow_9 = i(v.xu.xenable.vregister_cf_aed81ceac9cbe1a6)
let register_flow_10 = i(v.xu.xenable.vregister_cf_cb376e86ae90d043)
let register_flow_11 = i(v.xu.xenable.vregister_cf_bbb44029696b84a4)
let register_flow_12 = i(v.xu.xerror_amp.vregister_cf_f2e07793da078661)
let register_flow_13 = i(v.xu.xerror_amp.vregister_cf_f6460027b7ffd0cb)
let register_flow_14 = i(v.xu.xerror_amp.vregister_cf_c2ebf366e6639bec)
let register_flow_15 = i(v.xu.xerror_amp.vregister_cf_d67cc245ee41645f)
let register_flow_16 = i(v.xu.xerror_amp.vregister_cf_e4e51937b39b4691)
let register_flow_17 = i(v.xu.xfeedback.vregister_cf_bc5172b93ca5807b)
let register_flow_18 = i(v.xu.xfeedback.vregister_cf_3a422fb5728ac531)
let register_flow_19 = i(v.xu.xpass_bank.vregister_cf_c4529c8a644aa122)
let register_flow_20 = i(v.xu.xpass_bank.vregister_cf_c660b9f0af5d49c1)
let register_flow_21 = i(v.xu.xpass_bank.vregister_cf_51ed9378459231fb)
let register_flow_22 = i(v.xu.xpass_bank.vregister_cf_2d0a7a0607cba687)
let register_flow_23 = i(v.xu.xpass_bank.vregister_cf_366d33dfcfdbad65)
let register_flow_24 = i(v.xu.xpass_bank.vregister_cf_1b67208cb208e966)
let register_flow_25 = i(v.xu.xpass_bank.vregister_cf_fde30e2d2f4a090a)
let register_flow_26 = i(v.xu.xpass_bank.vregister_cf_3d469519e4ead358)
let register_flow_27 = i(VGND)
let register_flow_28 = i(VDD)
let register_flow_29 = i(VREF)
let register_flow_30 = i(VEN)
let register_flow_31 = i(VLOAD)
wrdata current-flow.dat register_flow_0 register_flow_1 register_flow_2 register_flow_3 register_flow_4 register_flow_5 register_flow_6 register_flow_7 register_flow_8 register_flow_9 register_flow_10 register_flow_11 register_flow_12 register_flow_13 register_flow_14 register_flow_15 register_flow_16 register_flow_17 register_flow_18 register_flow_19 register_flow_20 register_flow_21 register_flow_22 register_flow_23 register_flow_24 register_flow_25 register_flow_26 register_flow_27 register_flow_28 register_flow_29 register_flow_30 register_flow_31
let register_voltage_0 = v(BIAS)
let register_voltage_1 = v(VGND)
let register_voltage_2 = v(XU.ENB)
let register_voltage_3 = v(VPWR)
let register_voltage_4 = v(GATE)
let register_voltage_5 = v(XU.XCOMPENSATION.ZERO)
let register_voltage_6 = v(XU.EA_OUT)
let register_voltage_7 = v(OUT)
let register_voltage_8 = v(XU.XDECOUPLING.CAP)
let register_voltage_9 = v(EN)
let register_voltage_10 = v(XU.XERROR_AMP.MIR)
let register_voltage_11 = v(XU.XERROR_AMP.TAIL)
let register_voltage_12 = v(FB)
let register_voltage_13 = v(VREF)
let register_voltage_14 = 0*register_flow_0
let register_voltage_15 = v(LOADCTL)
wrdata node-voltages.dat register_voltage_0 register_voltage_1 register_voltage_2 register_voltage_3 register_voltage_4 register_voltage_5 register_voltage_6 register_voltage_7 register_voltage_8 register_voltage_9 register_voltage_10 register_voltage_11 register_voltage_12 register_voltage_13 register_voltage_14 register_voltage_15
quit
.endc
.end

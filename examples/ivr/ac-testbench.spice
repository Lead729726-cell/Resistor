Resistor actual SKY130 integrated linear IVR
.include "D:/Coldbrew/Resistor/.runtime/ivr/native-xLgP2f/.runtime/eda/runs/08e0ae0114ff4bb5ae8d356013e8bb87/supported-tt.spice"
.include "D:/Coldbrew/Resistor/.runtime/ivr/native-xLgP2f/.runtime/eda/runs/08e0ae0114ff4bb5ae8d356013e8bb87/reference.spice"
.options method=gear maxord=2
.temp 27.0
VGND VGND 0 0
RLOAD OUT VGND 60000
RSTEP OUT LOADSTEP 6666.66666666667
SLOAD LOADSTEP VGND LOADCTL VGND LOADSW
.model LOADSW SW(Ron=0.1 Roff=1e12 Vt=0.9 Vh=0.01)
VDD VPWR VGND DC 1.8 AC 1
VREF VREF VGND 0.6
VEN EN VGND 1.8
VLOAD LOADCTL VGND 0
XU VREF EN OUT FB GATE BIAS VPWR VGND soc_ivr_ldo
.control
set num_threads=1
set numdgt=17
set wr_singlescale
set wr_vecnames
set noaskquit
ac dec 80 10 1e8
let mos_wave_0 = mag(v(OUT))
let mos_wave_1 = 180/pi*ph(v(OUT))
wrdata waveform.dat mos_wave_0 mos_wave_1
write waveform.raw all
quit
.endc
.end

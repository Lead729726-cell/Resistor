.subckt osc_ring5 OUT VPWR VGND
CC_STAGE0 Q0 VGND 2e-12
CC_STAGE1 Q1 VGND 2e-12
CC_STAGE2 Q2 VGND 2e-12
CC_STAGE3 Q3 VGND 2e-12
CC_STAGE4 OUT VGND 2e-12
XINV0N Q0 OUT VGND VGND sky130_fd_pr__nfet_01v8 w=4 l=0.15 nf=1 m=1
XINV0P Q0 OUT VPWR VPWR sky130_fd_pr__pfet_01v8_hvt w=8 l=0.15 nf=1 m=1
XINV1N Q1 Q0 VGND VGND sky130_fd_pr__nfet_01v8 w=4 l=0.15 nf=1 m=1
XINV1P Q1 Q0 VPWR VPWR sky130_fd_pr__pfet_01v8_hvt w=8 l=0.15 nf=1 m=1
XINV2N Q2 Q1 VGND VGND sky130_fd_pr__nfet_01v8 w=4 l=0.15 nf=1 m=1
XINV2P Q2 Q1 VPWR VPWR sky130_fd_pr__pfet_01v8_hvt w=8 l=0.15 nf=1 m=1
XINV3N Q3 Q2 VGND VGND sky130_fd_pr__nfet_01v8 w=4 l=0.15 nf=1 m=1
XINV3P Q3 Q2 VPWR VPWR sky130_fd_pr__pfet_01v8_hvt w=8 l=0.15 nf=1 m=1
XINV4N OUT Q3 VGND VGND sky130_fd_pr__nfet_01v8 w=4 l=0.15 nf=1 m=1
XINV4P OUT Q3 VPWR VPWR sky130_fd_pr__pfet_01v8_hvt w=8 l=0.15 nf=1 m=1
.ends osc_ring5

* NGSPICE file created from cell_nand2.ext - technology: sky130A

.subckt cell_nand2 A0 A1 VGND VPWR Y
X0 Y.t1 A0.t0 VPWR.t1 VPWR.t0 sky130_fd_pr__pfet_01v8_hvt ad=0.1885 pd=1.88 as=0.1885 ps=1.88 w=0.65 l=0.15
X1 N1.t0 A1.t0 VGND.t1 VGND.t0 sky130_fd_pr__nfet_01v8 ad=0.1885 pd=1.88 as=0.1885 ps=1.88 w=0.65 l=0.15
X2 Y.t0 A0.t1 N1.t1 VGND.t2 sky130_fd_pr__nfet_01v8 ad=0.1885 pd=1.88 as=0.1885 ps=1.88 w=0.65 l=0.15
X3 Y.t2 A1.t1 VPWR.t3 VPWR.t2 sky130_fd_pr__pfet_01v8_hvt ad=0.1885 pd=1.88 as=0.1885 ps=1.88 w=0.65 l=0.15
C0 A0 N1 0.7039f
C1 Y A1 0.12228f
C2 Y N1 1.94216f
C3 A1 N1 2.6595f
C4 A0 VPWR 0.43986f
C5 Y VPWR 0.52747f
C6 A1 VPWR 0.42007f
C7 VPWR N1 0.02126f
C8 Y A0 1.71746f
C9 A1 A0 0.0325f
R0 A0 A0.t0 330.341
R1 A0 A0.t1 315.88
R2 A0.n0 A0 29.9353
R3 A0.n0 A0 29.3671
R4 A0 A0.n0 5.17104
R5 VPWR.n17 VPWR.n5 832.942
R6 VPWR.n32 VPWR.n6 832.942
R7 VPWR.n25 VPWR.n14 832.942
R8 VPWR.n29 VPWR.n7 832.942
R9 VPWR.n53 VPWR.n41 832.942
R10 VPWR.n68 VPWR.n42 832.942
R11 VPWR.n61 VPWR.n50 832.942
R12 VPWR.n65 VPWR.n43 832.942
R13 VPWR.t3 VPWR.n0 700.484
R14 VPWR.n1 VPWR.t3 700.484
R15 VPWR.t1 VPWR.n35 700.484
R16 VPWR.n36 VPWR.t1 700.484
R17 VPWR.n32 VPWR.n5 240
R18 VPWR.n21 VPWR.n16 240
R19 VPWR.n25 VPWR.n7 240
R20 VPWR.n10 VPWR.n6 240
R21 VPWR.n29 VPWR.n9 240
R22 VPWR.n68 VPWR.n41 240
R23 VPWR.n57 VPWR.n52 240
R24 VPWR.n61 VPWR.n43 240
R25 VPWR.n46 VPWR.n42 240
R26 VPWR.n65 VPWR.n45 240
R27 VPWR.n24 VPWR.n23 207.394
R28 VPWR.n31 VPWR.n30 207.394
R29 VPWR.n60 VPWR.n59 207.394
R30 VPWR.n67 VPWR.n66 207.394
R31 VPWR.n6 VPWR.n4 185
R32 VPWR.n30 VPWR.n6 185
R33 VPWR.n11 VPWR.n10 185
R34 VPWR.n12 VPWR.n9 185
R35 VPWR.n29 VPWR.n28 185
R36 VPWR.n30 VPWR.n29 185
R37 VPWR.n27 VPWR.n7 185
R38 VPWR.n31 VPWR.n7 185
R39 VPWR.n26 VPWR.n25 185
R40 VPWR.n25 VPWR.n24 185
R41 VPWR.n14 VPWR.n13 185
R42 VPWR.n21 VPWR.n20 185
R43 VPWR.n19 VPWR.n16 185
R44 VPWR.n18 VPWR.n17 185
R45 VPWR.n5 VPWR.n3 185
R46 VPWR.n24 VPWR.n5 185
R47 VPWR.n33 VPWR.n32 185
R48 VPWR.n32 VPWR.n31 185
R49 VPWR.n42 VPWR.n40 185
R50 VPWR.n66 VPWR.n42 185
R51 VPWR.n47 VPWR.n46 185
R52 VPWR.n48 VPWR.n45 185
R53 VPWR.n65 VPWR.n64 185
R54 VPWR.n66 VPWR.n65 185
R55 VPWR.n63 VPWR.n43 185
R56 VPWR.n67 VPWR.n43 185
R57 VPWR.n62 VPWR.n61 185
R58 VPWR.n61 VPWR.n60 185
R59 VPWR.n50 VPWR.n49 185
R60 VPWR.n57 VPWR.n56 185
R61 VPWR.n55 VPWR.n52 185
R62 VPWR.n54 VPWR.n53 185
R63 VPWR.n41 VPWR.n39 185
R64 VPWR.n60 VPWR.n41 185
R65 VPWR.n69 VPWR.n68 185
R66 VPWR.n68 VPWR.n67 185
R67 VPWR.n33 VPWR.n4 88.8476
R68 VPWR.n28 VPWR.n27 88.8476
R69 VPWR.n26 VPWR.n13 88.8476
R70 VPWR.n18 VPWR.n3 88.8476
R71 VPWR.n69 VPWR.n40 88.8476
R72 VPWR.n64 VPWR.n63 88.8476
R73 VPWR.n62 VPWR.n49 88.8476
R74 VPWR.n54 VPWR.n39 88.8476
R75 VPWR.n16 VPWR.n15 72.7879
R76 VPWR.n22 VPWR.n14 72.7879
R77 VPWR.n10 VPWR.n8 72.7879
R78 VPWR.n9 VPWR.n8 72.7879
R79 VPWR.n22 VPWR.n21 72.7879
R80 VPWR.n17 VPWR.n15 72.7879
R81 VPWR.n52 VPWR.n51 72.7879
R82 VPWR.n58 VPWR.n50 72.7879
R83 VPWR.n46 VPWR.n44 72.7879
R84 VPWR.n45 VPWR.n44 72.7879
R85 VPWR.n58 VPWR.n57 72.7879
R86 VPWR.n53 VPWR.n51 72.7879
R87 VPWR.n24 VPWR.t2 56.8667
R88 VPWR.n31 VPWR.t2 56.8667
R89 VPWR.n60 VPWR.t0 56.8667
R90 VPWR.n67 VPWR.t0 56.8667
R91 VPWR.n30 VPWR.n8 56.1076
R92 VPWR.n23 VPWR.n22 56.1076
R93 VPWR.n23 VPWR.n15 56.1076
R94 VPWR.n66 VPWR.n44 56.1076
R95 VPWR.n59 VPWR.n58 56.1076
R96 VPWR.n59 VPWR.n51 56.1076
R97 VPWR.n11 VPWR.n4 25.6005
R98 VPWR.n12 VPWR.n11 25.6005
R99 VPWR.n28 VPWR.n12 25.6005
R100 VPWR.n27 VPWR.n26 25.6005
R101 VPWR.n19 VPWR.n18 25.6005
R102 VPWR.n20 VPWR.n19 25.6005
R103 VPWR.n20 VPWR.n13 25.6005
R104 VPWR.n47 VPWR.n40 25.6005
R105 VPWR.n48 VPWR.n47 25.6005
R106 VPWR.n64 VPWR.n48 25.6005
R107 VPWR.n63 VPWR.n62 25.6005
R108 VPWR.n55 VPWR.n54 25.6005
R109 VPWR.n56 VPWR.n55 25.6005
R110 VPWR.n56 VPWR.n49 25.6005
R111 VPWR.n34 VPWR 18.865
R112 VPWR.n70 VPWR 18.865
R113 VPWR VPWR.n3 12.8005
R114 VPWR VPWR.n33 12.8005
R115 VPWR VPWR.n35 12.8005
R116 VPWR.n36 VPWR 12.8005
R117 VPWR VPWR.n39 12.8005
R118 VPWR VPWR.n69 12.8005
R119 VPWR VPWR.n0 12.8005
R120 VPWR.n1 VPWR 12.8005
R121 VPWR.n34 VPWR.n2 10.6503
R122 VPWR.n38 VPWR.n37 10.5563
R123 VPWR.n37 VPWR.n35 10.1513
R124 VPWR.n37 VPWR.n36 10.1513
R125 VPWR.n2 VPWR.n0 10.1513
R126 VPWR.n2 VPWR.n1 10.1513
R127 VPWR VPWR.n70 4.46447
R128 VPWR.n38 VPWR.n34 1.01178
R129 VPWR.n70 VPWR.n38 0.0945
R130 Y.t2 Y.n0 700.484
R131 Y.n1 Y.t2 700.484
R132 Y.t1 Y.n7 700.484
R133 Y.n8 Y.t1 700.484
R134 Y.t0 Y.n3 255.345
R135 Y.n4 Y.t0 255.345
R136 Y Y.n3 12.8005
R137 Y.n4 Y 12.8005
R138 Y Y.n7 12.8005
R139 Y.n8 Y 12.8005
R140 Y Y.n0 12.8005
R141 Y.n1 Y 12.8005
R142 Y.n6 Y.n2 11.0047
R143 Y.n6 Y.n5 10.4521
R144 Y.n10 Y.n9 10.4521
R145 Y.n5 Y.n3 10.1513
R146 Y.n5 Y.n4 10.1513
R147 Y.n9 Y.n7 10.1513
R148 Y.n9 Y.n8 10.1513
R149 Y.n2 Y.n0 10.1513
R150 Y.n2 Y.n1 10.1513
R151 Y Y.n10 4.22948
R152 Y.n10 Y.n6 0.553142
R153 A1 A1.t1 330.341
R154 A1 A1.t0 315.88
R155 A1.n0 A1 31.1853
R156 A1.n0 A1 30.6171
R157 A1 A1.n0 6.13533
R158 VGND.n63 VGND.n62 3946.74
R159 VGND.n60 VGND.n34 1315.26
R160 VGND.n56 VGND.n35 1315.26
R161 VGND.n45 VGND.n33 1315.26
R162 VGND.n48 VGND.n40 1315.26
R163 VGND.n18 VGND.n6 1315.26
R164 VGND.n65 VGND.n7 1315.26
R165 VGND.n26 VGND.n15 1315.26
R166 VGND.n30 VGND.n8 1315.26
R167 VGND.n57 VGND.n56 585
R168 VGND.n38 VGND.n37 585
R169 VGND.n52 VGND.n51 585
R170 VGND.n50 VGND.n40 585
R171 VGND.n49 VGND.n48 585
R172 VGND.n48 VGND.n39 585
R173 VGND.n47 VGND.n33 585
R174 VGND.n61 VGND.n33 585
R175 VGND.n46 VGND.n45 585
R176 VGND.n44 VGND.n43 585
R177 VGND.n42 VGND.n41 585
R178 VGND.n36 VGND.n34 585
R179 VGND.n60 VGND.n59 585
R180 VGND.n61 VGND.n60 585
R181 VGND.n58 VGND.n35 585
R182 VGND.n39 VGND.n35 585
R183 VGND.n7 VGND.n5 585
R184 VGND.n63 VGND.n7 585
R185 VGND.n12 VGND.n11 585
R186 VGND.n13 VGND.n10 585
R187 VGND.n30 VGND.n29 585
R188 VGND.n63 VGND.n30 585
R189 VGND.n28 VGND.n8 585
R190 VGND.n64 VGND.n8 585
R191 VGND.n27 VGND.n26 585
R192 VGND.n26 VGND.n25 585
R193 VGND.n15 VGND.n14 585
R194 VGND.n22 VGND.n21 585
R195 VGND.n20 VGND.n17 585
R196 VGND.n19 VGND.n18 585
R197 VGND.n6 VGND.n4 585
R198 VGND.n25 VGND.n6 585
R199 VGND.n66 VGND.n65 585
R200 VGND.n65 VGND.n64 585
R201 VGND.n60 VGND.n35 394
R202 VGND.n43 VGND.n42 394
R203 VGND.n48 VGND.n33 394
R204 VGND.n52 VGND.n38 394
R205 VGND.n65 VGND.n6 394
R206 VGND.n22 VGND.n17 394
R207 VGND.n26 VGND.n8 394
R208 VGND.n11 VGND.n7 394
R209 VGND.n30 VGND.n10 394
R210 VGND.t1 VGND.n0 255.345
R211 VGND.n1 VGND.t1 255.345
R212 VGND.n55 VGND.n54 218.815
R213 VGND.n54 VGND.n53 218.815
R214 VGND.n62 VGND.n32 218.815
R215 VGND.n62 VGND.n31 218.815
R216 VGND.n63 VGND.n9 218.815
R217 VGND.n24 VGND.n23 218.815
R218 VGND.n24 VGND.n16 218.815
R219 VGND.n62 VGND.n61 187.62
R220 VGND.n54 VGND.n39 187.62
R221 VGND.n25 VGND.n24 187.62
R222 VGND.n64 VGND.n63 187.62
R223 VGND.n42 VGND.n31 147.374
R224 VGND.n45 VGND.n32 147.374
R225 VGND.n56 VGND.n55 147.374
R226 VGND.n53 VGND.n40 147.374
R227 VGND.n55 VGND.n38 147.374
R228 VGND.n53 VGND.n52 147.374
R229 VGND.n43 VGND.n32 147.374
R230 VGND.n34 VGND.n31 147.374
R231 VGND.n17 VGND.n16 147.374
R232 VGND.n23 VGND.n15 147.374
R233 VGND.n11 VGND.n9 147.374
R234 VGND.n10 VGND.n9 147.374
R235 VGND.n23 VGND.n22 147.374
R236 VGND.n18 VGND.n16 147.374
R237 VGND.n59 VGND.n36 85.4593
R238 VGND.n58 VGND.n57 85.4593
R239 VGND.n47 VGND.n46 85.4593
R240 VGND.n50 VGND.n49 85.4593
R241 VGND.n66 VGND.n5 85.4593
R242 VGND.n29 VGND.n28 85.4593
R243 VGND.n27 VGND.n14 85.4593
R244 VGND.n19 VGND.n4 85.4593
R245 VGND.n61 VGND.t0 51.4448
R246 VGND.n39 VGND.t0 51.4448
R247 VGND.n25 VGND.t2 51.4448
R248 VGND.n64 VGND.t2 51.4448
R249 VGND.n41 VGND.n36 25.6005
R250 VGND.n44 VGND.n41 25.6005
R251 VGND.n46 VGND.n44 25.6005
R252 VGND.n49 VGND.n47 25.6005
R253 VGND.n57 VGND.n37 25.6005
R254 VGND.n51 VGND.n37 25.6005
R255 VGND.n51 VGND.n50 25.6005
R256 VGND.n12 VGND.n5 25.6005
R257 VGND.n13 VGND.n12 25.6005
R258 VGND.n29 VGND.n13 25.6005
R259 VGND.n28 VGND.n27 25.6005
R260 VGND.n20 VGND.n19 25.6005
R261 VGND.n21 VGND.n20 25.6005
R262 VGND.n21 VGND.n14 25.6005
R263 VGND.n67 VGND 18.3598
R264 VGND VGND.n3 18.3598
R265 VGND.n59 VGND 12.8005
R266 VGND VGND.n58 12.8005
R267 VGND VGND.n4 12.8005
R268 VGND VGND.n66 12.8005
R269 VGND VGND.n0 12.8005
R270 VGND.n1 VGND 12.8005
R271 VGND.n2 VGND.n0 10.1513
R272 VGND.n2 VGND.n1 10.1513
R273 VGND.n3 VGND.n2 10.1294
R274 VGND VGND.n67 5.15812
R275 VGND.n67 VGND.n3 1.10578
R276 N1.t1 N1.n1 255.345
R277 N1.n2 N1.t1 255.345
R278 N1.t0 N1.n0 255.345
R279 N1.n5 N1.t0 255.345
R280 N1.n4 N1.n3 22.6543
R281 N1 N1.n1 12.8005
R282 N1.n2 N1 12.8005
R283 N1 N1.n0 12.8005
R284 N1 N1.n5 12.8005
R285 N1.n3 N1.n1 10.1513
R286 N1.n3 N1.n2 10.1513
R287 N1.n4 N1.n0 10.1513
R288 N1.n5 N1.n4 10.1513
C10 A0 VGND 2.46062f
C11 Y VGND 1.962f
C12 A1 VGND 4.38974f
C13 VPWR VGND 6.78517f
C14 N1 VGND 2.04611f $ **FLOATING
C15 N1.n0 VGND 0.00702f $ **FLOATING
C16 N1.n1 VGND 0.00702f $ **FLOATING
C17 N1.t1 VGND 0.01708f $ **FLOATING
C18 N1.n2 VGND 0.00702f $ **FLOATING
C19 N1.n3 VGND 1.33891f $ **FLOATING
C20 N1.n4 VGND 1.29227f $ **FLOATING
C21 N1.t0 VGND 0.01708f $ **FLOATING
C22 N1.n5 VGND 0.00702f $ **FLOATING
C23 A1.t0 VGND 0.02194f $ **FLOATING
C24 A1.t1 VGND 0.0228f $ **FLOATING
C25 A1.n0 VGND 2.18323f $ **FLOATING
.ends

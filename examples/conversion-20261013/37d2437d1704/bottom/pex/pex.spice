* NGSPICE file created from cell_inv.ext - technology: sky130A

.subckt cell_inv A VPWR VGND Y
X0 VGND.t1 A.t0 Y.t0 VGND.t0 sky130_fd_pr__nfet_01v8 ad=0.1885 pd=1.88 as=0.1885 ps=1.88 w=0.65 l=0.15
X1 VPWR.t1 A.t1 Y.t1 VPWR.t0 sky130_fd_pr__pfet_01v8_hvt ad=0.1885 pd=1.88 as=0.1885 ps=1.88 w=0.65 l=0.15
C0 A VPWR 0.42022f
C1 Y VPWR 0.28701f
C2 Y A 1.41228f
R0 A A.t1 330.341
R1 A A.t0 315.88
R2 A.n0 A 33.455
R3 A.n0 A 32.8868
R4 A A.n0 4.88904
R5 Y.t1 Y.n3 700.484
R6 Y.n4 Y.t1 700.484
R7 Y.t0 Y.n0 255.345
R8 Y.n1 Y.t0 255.345
R9 Y Y.n0 12.8005
R10 Y.n1 Y 12.8005
R11 Y Y.n3 12.8005
R12 Y.n4 Y 12.8005
R13 Y.n6 Y.n2 10.5881
R14 Y.n2 Y.n0 10.1513
R15 Y.n2 Y.n1 10.1513
R16 Y.n5 Y.n3 10.1513
R17 Y.n5 Y.n4 10.1513
R18 Y.n6 Y.n5 10.0354
R19 Y Y.n6 4.22948
R20 VGND.n23 VGND.n7 9718.68
R21 VGND.n21 VGND.n12 1315.26
R22 VGND.n15 VGND.n14 1315.26
R23 VGND.n33 VGND.n32 1315.26
R24 VGND.n30 VGND.n9 1315.26
R25 VGND.n30 VGND.n29 585
R26 VGND.n31 VGND.n30 585
R27 VGND.n28 VGND.n10 585
R28 VGND.n10 VGND.n8 585
R29 VGND.n27 VGND.n26 585
R30 VGND.n26 VGND.n25 585
R31 VGND.n12 VGND.n11 585
R32 VGND.n24 VGND.n12 585
R33 VGND.n21 VGND.n20 585
R34 VGND.n19 VGND.n15 585
R35 VGND.n18 VGND.n14 585
R36 VGND.n24 VGND.n14 585
R37 VGND.n17 VGND.n13 585
R38 VGND.n25 VGND.n13 585
R39 VGND.n16 VGND.n6 585
R40 VGND.n8 VGND.n6 585
R41 VGND.n32 VGND.n4 585
R42 VGND.n32 VGND.n31 585
R43 VGND.n34 VGND.n33 585
R44 VGND.n9 VGND.n3 585
R45 VGND.n32 VGND.n6 394
R46 VGND.n13 VGND.n6 394
R47 VGND.n14 VGND.n13 394
R48 VGND.n30 VGND.n10 394
R49 VGND.n26 VGND.n10 394
R50 VGND.n26 VGND.n12 394
R51 VGND.n31 VGND.n7 325.123
R52 VGND.n24 VGND.n23 325.123
R53 VGND.t1 VGND.n0 255.345
R54 VGND.n1 VGND.t1 255.345
R55 VGND.n23 VGND.n22 218.815
R56 VGND.n7 VGND.n5 218.815
R57 VGND.n31 VGND.n8 184.237
R58 VGND.n25 VGND.n24 184.237
R59 VGND.n22 VGND.n21 147.374
R60 VGND.n33 VGND.n5 147.374
R61 VGND.n22 VGND.n15 147.374
R62 VGND.n9 VGND.n5 147.374
R63 VGND.t0 VGND.n8 92.1187
R64 VGND.n25 VGND.t0 92.1187
R65 VGND.n29 VGND.n3 85.4593
R66 VGND.n20 VGND.n11 85.4593
R67 VGND.n19 VGND.n18 85.4593
R68 VGND.n34 VGND.n4 85.4593
R69 VGND.n29 VGND.n28 25.6005
R70 VGND.n28 VGND.n27 25.6005
R71 VGND.n27 VGND.n11 25.6005
R72 VGND.n20 VGND.n19 25.6005
R73 VGND.n16 VGND.n4 25.6005
R74 VGND.n17 VGND.n16 25.6005
R75 VGND.n18 VGND.n17 25.6005
R76 VGND.n35 VGND 18.3598
R77 VGND VGND.n0 12.8005
R78 VGND.n1 VGND 12.8005
R79 VGND VGND.n3 12.8005
R80 VGND VGND.n34 12.8005
R81 VGND.n2 VGND.n0 10.1513
R82 VGND.n2 VGND.n1 10.1513
R83 VGND.n35 VGND.n2 10.1294
R84 VGND VGND.n35 5.15812
R85 VPWR.n20 VPWR.n11 832.942
R86 VPWR.n14 VPWR.n13 832.942
R87 VPWR.n31 VPWR.n30 832.942
R88 VPWR.n28 VPWR.n8 832.942
R89 VPWR.t1 VPWR.n0 700.484
R90 VPWR.n1 VPWR.t1 700.484
R91 VPWR.n22 VPWR.n21 346.51
R92 VPWR.n29 VPWR.n5 346.51
R93 VPWR.n30 VPWR.n6 240
R94 VPWR.n12 VPWR.n6 240
R95 VPWR.n13 VPWR.n12 240
R96 VPWR.n28 VPWR.n9 240
R97 VPWR.n24 VPWR.n9 240
R98 VPWR.n24 VPWR.n11 240
R99 VPWR.n28 VPWR.n27 185
R100 VPWR.n29 VPWR.n28 185
R101 VPWR.n26 VPWR.n9 185
R102 VPWR.n9 VPWR.n7 185
R103 VPWR.n25 VPWR.n24 185
R104 VPWR.n24 VPWR.n23 185
R105 VPWR.n11 VPWR.n10 185
R106 VPWR.n22 VPWR.n11 185
R107 VPWR.n20 VPWR.n19 185
R108 VPWR.n18 VPWR.n14 185
R109 VPWR.n17 VPWR.n13 185
R110 VPWR.n22 VPWR.n13 185
R111 VPWR.n16 VPWR.n12 185
R112 VPWR.n23 VPWR.n12 185
R113 VPWR.n15 VPWR.n6 185
R114 VPWR.n7 VPWR.n6 185
R115 VPWR.n30 VPWR.n4 185
R116 VPWR.n30 VPWR.n29 185
R117 VPWR.n32 VPWR.n31 185
R118 VPWR.n8 VPWR.n3 185
R119 VPWR.n29 VPWR.n7 153.082
R120 VPWR.n23 VPWR.n22 153.082
R121 VPWR.n27 VPWR.n3 88.8476
R122 VPWR.n19 VPWR.n10 88.8476
R123 VPWR.n18 VPWR.n17 88.8476
R124 VPWR.n32 VPWR.n4 88.8476
R125 VPWR.t0 VPWR.n7 76.5408
R126 VPWR.n23 VPWR.t0 76.5408
R127 VPWR.n21 VPWR.n20 72.7879
R128 VPWR.n31 VPWR.n5 72.7879
R129 VPWR.n21 VPWR.n14 72.7879
R130 VPWR.n8 VPWR.n5 72.7879
R131 VPWR.n27 VPWR.n26 25.6005
R132 VPWR.n26 VPWR.n25 25.6005
R133 VPWR.n25 VPWR.n10 25.6005
R134 VPWR.n19 VPWR.n18 25.6005
R135 VPWR.n15 VPWR.n4 25.6005
R136 VPWR.n16 VPWR.n15 25.6005
R137 VPWR.n17 VPWR.n16 25.6005
R138 VPWR.n33 VPWR 18.865
R139 VPWR VPWR.n0 12.8005
R140 VPWR.n1 VPWR 12.8005
R141 VPWR VPWR.n3 12.8005
R142 VPWR VPWR.n32 12.8005
R143 VPWR.n33 VPWR.n2 10.6503
R144 VPWR.n2 VPWR.n0 10.1513
R145 VPWR.n2 VPWR.n1 10.1513
R146 VPWR VPWR.n33 4.46447
C3 Y VGND 1.84472f
C4 A VGND 2.9654f
C5 VPWR VGND 3.30035f
.ends

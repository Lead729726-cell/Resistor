* NGSPICE file created from cell_inv.ext - technology: sky130A

.subckt cell_inv A VPWR VGND Y
X0 VGND A Y VGND sky130_fd_pr__nfet_01v8 ad=0.1885 pd=1.88 as=0.1885 ps=1.88 w=0.65 l=0.15
X1 VPWR A Y VPWR sky130_fd_pr__pfet_01v8_hvt ad=0.1885 pd=1.88 as=0.1885 ps=1.88 w=0.65 l=0.15
.ends

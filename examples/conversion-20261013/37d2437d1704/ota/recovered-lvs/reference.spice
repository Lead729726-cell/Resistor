.subckt soc_miller_ota VPWR VGND INP INN OUT BIAS
XE_10 VGND BIAS FIRST__TAIL VGND sky130_fd_pr__nfet_01v8 w=2 l=1 nf=1 m=1
XE_11 PRE COMP sky130_fd_pr__cap_mim_m3_1 w=28.68 l=28.68
XE_12 FIRST__TAIL INP PRE VGND sky130_fd_pr__nfet_01v8 w=5 l=1 nf=1 m=1
XE_13 VPWR PRE OUT VPWR sky130_fd_pr__pfet_01v8_hvt w=40 l=1 nf=1 m=1
XE_14 VPWR FIRST__MIR FIRST__MIR VPWR sky130_fd_pr__pfet_01v8_hvt w=20 l=1 nf=1 m=1
XE_15 PRE COMP sky130_fd_pr__cap_mim_m3_1 w=28.68 l=28.68
XE_16 FIRST__TAIL INP PRE VGND sky130_fd_pr__nfet_01v8 w=5 l=1 nf=1 m=1
XE_4 COMP OUT VGND sky130_fd_pr__res_xhigh_po_1p41 l=3.36
XE_5 FIRST__TAIL INN FIRST__MIR VGND sky130_fd_pr__nfet_01v8 w=5 l=1 nf=1 m=1
XE_6 VPWR FIRST__MIR PRE VPWR sky130_fd_pr__pfet_01v8_hvt w=20 l=1 nf=1 m=1
XE_7 VGND BIAS OUT VGND sky130_fd_pr__nfet_01v8 w=2 l=1 nf=1 m=1
XE_8 PRE COMP sky130_fd_pr__cap_mim_m3_1 w=28.68 l=28.68
XE_9 FIRST__TAIL INN FIRST__MIR VGND sky130_fd_pr__nfet_01v8 w=5 l=1 nf=1 m=1
.ends soc_miller_ota

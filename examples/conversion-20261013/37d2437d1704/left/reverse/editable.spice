.subckt cell_inv Y VPWR VGND A
XE_4 VPWR A Y VPWR sky130_fd_pr__pfet_01v8_hvt w=0.65 l=0.15 nf=1 m=1
XE_5 VGND A Y VGND sky130_fd_pr__nfet_01v8 w=0.65 l=0.15 nf=1 m=1
.ends cell_inv

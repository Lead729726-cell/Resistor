* NGSPICE file created from cell_mux2.ext - technology: sky130A

.subckt cell_mux2 A VGND B S VPWR Y
X0 SB.t1 S.t0 VPWR.t3 VPWR.t2 sky130_fd_pr__pfet_01v8_hvt ad=0.1885 pd=1.88 as=0.1885 ps=1.88 w=0.65 l=0.15
X1 Y.t1 S.t1 B.t0 VGND.t2 sky130_fd_pr__nfet_01v8 ad=0.1885 pd=1.88 as=0.1885 ps=1.88 w=0.65 l=0.15
X2 SB.t0 S.t2 VGND.t1 VGND.t0 sky130_fd_pr__nfet_01v8 ad=0.1885 pd=1.88 as=0.1885 ps=1.88 w=0.65 l=0.15
X3 Y.t3 SB.t2 A.t1 VGND.t3 sky130_fd_pr__nfet_01v8 ad=0.1885 pd=1.88 as=0.1885 ps=1.88 w=0.65 l=0.15
X4 Y.t0 S.t3 A.t0 VPWR.t1 sky130_fd_pr__pfet_01v8_hvt ad=0.1885 pd=1.88 as=0.1885 ps=1.88 w=0.65 l=0.15
X5 Y.t2 SB.t3 B.t1 VPWR.t0 sky130_fd_pr__pfet_01v8_hvt ad=0.1885 pd=1.88 as=0.1885 ps=1.88 w=0.65 l=0.15
C0 A Y 0.65913f
C1 A VPWR 0.16738f
C2 B SB 4.66001f
C3 A S 3.29812f
C4 B Y 3.79436f
C5 Y SB 0.47962f
C6 B VPWR 0.13687f
C7 VPWR SB 0.59148f
C8 VPWR Y 0.28278f
C9 B S 0.85053f
C10 S SB 0.59599f
C11 Y S 3.4163f
C12 VPWR S 0.74422f
C13 B A 0.0263f
C14 A SB 0.79994f
R0 S S.t0 330.341
R1 S S.t3 330.341
R2 S S.t2 315.88
R3 S S.t1 315.88
R4 S.n0 S 33.455
R5 S.n1 S 32.9024
R6 S.n0 S 32.8868
R7 S.n2 S 32.8868
R8 S S.n2 5.03004
R9 S.n1 S.n0 1.10147
R10 S.n2 S.n1 0.553142
R11 VPWR.n56 VPWR.n55 832.942
R12 VPWR.n58 VPWR.n32 832.942
R13 VPWR.n44 VPWR.n43 832.942
R14 VPWR.n41 VPWR.n36 832.942
R15 VPWR.n26 VPWR.n25 832.942
R16 VPWR.n28 VPWR.n2 832.942
R17 VPWR.n14 VPWR.n13 832.942
R18 VPWR.n11 VPWR.n6 832.942
R19 VPWR.n91 VPWR.n90 832.942
R20 VPWR.n93 VPWR.n67 832.942
R21 VPWR.n79 VPWR.n78 832.942
R22 VPWR.n76 VPWR.n71 832.942
R23 VPWR.t3 VPWR.n61 700.484
R24 VPWR.n62 VPWR.t3 700.484
R25 VPWR.n57 VPWR.n33 346.51
R26 VPWR.n42 VPWR.n37 346.51
R27 VPWR.n27 VPWR.n3 346.51
R28 VPWR.n12 VPWR.n7 346.51
R29 VPWR.n92 VPWR.n68 346.51
R30 VPWR.n77 VPWR.n72 346.51
R31 VPWR.n44 VPWR.n38 240
R32 VPWR.n48 VPWR.n38 240
R33 VPWR.n48 VPWR.n32 240
R34 VPWR.n51 VPWR.n36 240
R35 VPWR.n51 VPWR.n34 240
R36 VPWR.n55 VPWR.n34 240
R37 VPWR.n14 VPWR.n8 240
R38 VPWR.n18 VPWR.n8 240
R39 VPWR.n18 VPWR.n2 240
R40 VPWR.n21 VPWR.n6 240
R41 VPWR.n21 VPWR.n4 240
R42 VPWR.n25 VPWR.n4 240
R43 VPWR.n79 VPWR.n73 240
R44 VPWR.n83 VPWR.n73 240
R45 VPWR.n83 VPWR.n67 240
R46 VPWR.n86 VPWR.n71 240
R47 VPWR.n86 VPWR.n69 240
R48 VPWR.n90 VPWR.n69 240
R49 VPWR.n36 VPWR.n35 185
R50 VPWR.n37 VPWR.n36 185
R51 VPWR.n52 VPWR.n51 185
R52 VPWR.n51 VPWR.n50 185
R53 VPWR.n53 VPWR.n34 185
R54 VPWR.n49 VPWR.n34 185
R55 VPWR.n55 VPWR.n54 185
R56 VPWR.n55 VPWR.n33 185
R57 VPWR.n43 VPWR.n39 185
R58 VPWR.n41 VPWR.n40 185
R59 VPWR.n32 VPWR.n31 185
R60 VPWR.n33 VPWR.n32 185
R61 VPWR.n48 VPWR.n47 185
R62 VPWR.n49 VPWR.n48 185
R63 VPWR.n46 VPWR.n38 185
R64 VPWR.n50 VPWR.n38 185
R65 VPWR.n45 VPWR.n44 185
R66 VPWR.n44 VPWR.n37 185
R67 VPWR.n56 VPWR.n30 185
R68 VPWR.n59 VPWR.n58 185
R69 VPWR.n6 VPWR.n5 185
R70 VPWR.n7 VPWR.n6 185
R71 VPWR.n22 VPWR.n21 185
R72 VPWR.n21 VPWR.n20 185
R73 VPWR.n23 VPWR.n4 185
R74 VPWR.n19 VPWR.n4 185
R75 VPWR.n25 VPWR.n24 185
R76 VPWR.n25 VPWR.n3 185
R77 VPWR.n13 VPWR.n9 185
R78 VPWR.n11 VPWR.n10 185
R79 VPWR.n2 VPWR.n1 185
R80 VPWR.n3 VPWR.n2 185
R81 VPWR.n18 VPWR.n17 185
R82 VPWR.n19 VPWR.n18 185
R83 VPWR.n16 VPWR.n8 185
R84 VPWR.n20 VPWR.n8 185
R85 VPWR.n15 VPWR.n14 185
R86 VPWR.n14 VPWR.n7 185
R87 VPWR.n26 VPWR.n0 185
R88 VPWR.n29 VPWR.n28 185
R89 VPWR.n71 VPWR.n70 185
R90 VPWR.n72 VPWR.n71 185
R91 VPWR.n87 VPWR.n86 185
R92 VPWR.n86 VPWR.n85 185
R93 VPWR.n88 VPWR.n69 185
R94 VPWR.n84 VPWR.n69 185
R95 VPWR.n90 VPWR.n89 185
R96 VPWR.n90 VPWR.n68 185
R97 VPWR.n78 VPWR.n74 185
R98 VPWR.n76 VPWR.n75 185
R99 VPWR.n67 VPWR.n66 185
R100 VPWR.n68 VPWR.n67 185
R101 VPWR.n83 VPWR.n82 185
R102 VPWR.n84 VPWR.n83 185
R103 VPWR.n81 VPWR.n73 185
R104 VPWR.n85 VPWR.n73 185
R105 VPWR.n80 VPWR.n79 185
R106 VPWR.n79 VPWR.n72 185
R107 VPWR.n91 VPWR.n65 185
R108 VPWR.n94 VPWR.n93 185
R109 VPWR.n50 VPWR.n37 153.082
R110 VPWR.n49 VPWR.n33 153.082
R111 VPWR.n20 VPWR.n7 153.082
R112 VPWR.n19 VPWR.n3 153.082
R113 VPWR.n85 VPWR.n72 153.082
R114 VPWR.n84 VPWR.n68 153.082
R115 VPWR.n40 VPWR.n35 88.8476
R116 VPWR.n54 VPWR.n30 88.8476
R117 VPWR.n45 VPWR.n39 88.8476
R118 VPWR.n59 VPWR.n31 88.8476
R119 VPWR.n10 VPWR.n5 88.8476
R120 VPWR.n24 VPWR.n0 88.8476
R121 VPWR.n15 VPWR.n9 88.8476
R122 VPWR.n29 VPWR.n1 88.8476
R123 VPWR.n75 VPWR.n70 88.8476
R124 VPWR.n89 VPWR.n65 88.8476
R125 VPWR.n80 VPWR.n74 88.8476
R126 VPWR.n94 VPWR.n66 88.8476
R127 VPWR.n50 VPWR.t1 76.5408
R128 VPWR.t1 VPWR.n49 76.5408
R129 VPWR.n20 VPWR.t0 76.5408
R130 VPWR.t0 VPWR.n19 76.5408
R131 VPWR.n85 VPWR.t2 76.5408
R132 VPWR.t2 VPWR.n84 76.5408
R133 VPWR.n57 VPWR.n56 72.7879
R134 VPWR.n43 VPWR.n42 72.7879
R135 VPWR.n42 VPWR.n41 72.7879
R136 VPWR.n58 VPWR.n57 72.7879
R137 VPWR.n27 VPWR.n26 72.7879
R138 VPWR.n13 VPWR.n12 72.7879
R139 VPWR.n12 VPWR.n11 72.7879
R140 VPWR.n28 VPWR.n27 72.7879
R141 VPWR.n92 VPWR.n91 72.7879
R142 VPWR.n78 VPWR.n77 72.7879
R143 VPWR.n77 VPWR.n76 72.7879
R144 VPWR.n93 VPWR.n92 72.7879
R145 VPWR.n52 VPWR.n35 25.6005
R146 VPWR.n53 VPWR.n52 25.6005
R147 VPWR.n54 VPWR.n53 25.6005
R148 VPWR.n40 VPWR.n39 25.6005
R149 VPWR.n46 VPWR.n45 25.6005
R150 VPWR.n47 VPWR.n46 25.6005
R151 VPWR.n47 VPWR.n31 25.6005
R152 VPWR.n22 VPWR.n5 25.6005
R153 VPWR.n23 VPWR.n22 25.6005
R154 VPWR.n24 VPWR.n23 25.6005
R155 VPWR.n10 VPWR.n9 25.6005
R156 VPWR.n16 VPWR.n15 25.6005
R157 VPWR.n17 VPWR.n16 25.6005
R158 VPWR.n17 VPWR.n1 25.6005
R159 VPWR.n87 VPWR.n70 25.6005
R160 VPWR.n88 VPWR.n87 25.6005
R161 VPWR.n89 VPWR.n88 25.6005
R162 VPWR.n75 VPWR.n74 25.6005
R163 VPWR.n81 VPWR.n80 25.6005
R164 VPWR.n82 VPWR.n81 25.6005
R165 VPWR.n82 VPWR.n66 25.6005
R166 VPWR.n60 VPWR 19.9703
R167 VPWR.n60 VPWR 18.865
R168 VPWR.n95 VPWR 18.865
R169 VPWR VPWR.n61 12.8005
R170 VPWR.n62 VPWR 12.8005
R171 VPWR VPWR.n30 12.8005
R172 VPWR VPWR.n59 12.8005
R173 VPWR VPWR.n0 12.8005
R174 VPWR VPWR.n29 12.8005
R175 VPWR VPWR.n65 12.8005
R176 VPWR VPWR.n94 12.8005
R177 VPWR.n64 VPWR.n63 10.5563
R178 VPWR.n63 VPWR.n61 10.1513
R179 VPWR.n63 VPWR.n62 10.1513
R180 VPWR VPWR.n95 4.46447
R181 VPWR.n64 VPWR.n60 1.56012
R182 VPWR.n95 VPWR.n64 0.0945
R183 SB.t1 SB.n1 700.484
R184 SB.n2 SB.t1 700.484
R185 SB SB.t3 330.341
R186 SB SB.t2 315.88
R187 SB.t0 SB.n0 255.345
R188 SB.n7 SB.t0 255.345
R189 SB.n4 SB 35.7947
R190 SB.n4 SB 34.1524
R191 SB SB.n1 12.8005
R192 SB.n2 SB 12.8005
R193 SB SB.n0 12.8005
R194 SB SB.n7 12.8005
R195 SB.n5 SB.n3 12.2547
R196 SB.n6 SB.n5 11.7021
R197 SB.n3 SB.n1 10.1513
R198 SB.n3 SB.n2 10.1513
R199 SB.n6 SB.n0 10.1513
R200 SB.n7 SB.n6 10.1513
R201 SB.n5 SB.n4 0.7854
R202 B.t1 B.n0 700.484
R203 B.n1 B.t1 700.484
R204 B.t0 B.n3 255.345
R205 B.n4 B.t0 255.345
R206 B B.n0 12.8005
R207 B.n1 B 12.8005
R208 B B.n3 12.8005
R209 B.n4 B 12.8005
R210 B.n6 B.n2 11.8381
R211 B.n6 B.n5 11.2854
R212 B.n2 B.n0 10.1513
R213 B.n2 B.n1 10.1513
R214 B.n5 B.n3 10.1513
R215 B.n5 B.n4 10.1513
R216 B B.n6 7.32873
R217 Y.t0 Y.n7 700.484
R218 Y.n8 Y.t0 700.484
R219 Y.t2 Y.n0 700.484
R220 Y.n1 Y.t2 700.484
R221 Y.t3 Y.n11 255.345
R222 Y.n12 Y.t3 255.345
R223 Y.t1 Y.n3 255.345
R224 Y.n4 Y.t1 255.345
R225 Y Y.n7 12.8005
R226 Y.n8 Y 12.8005
R227 Y Y.n3 12.8005
R228 Y.n4 Y 12.8005
R229 Y Y.n0 12.8005
R230 Y.n1 Y 12.8005
R231 Y Y.n11 12.8005
R232 Y.n12 Y 12.8005
R233 Y.n6 Y.n2 11.4214
R234 Y.n10 Y.n9 10.8688
R235 Y.n6 Y.n5 10.8688
R236 Y.n14 Y.n13 10.8688
R237 Y.n9 Y.n7 10.1513
R238 Y.n9 Y.n8 10.1513
R239 Y.n5 Y.n3 10.1513
R240 Y.n5 Y.n4 10.1513
R241 Y.n2 Y.n0 10.1513
R242 Y.n2 Y.n1 10.1513
R243 Y.n13 Y.n11 10.1513
R244 Y.n13 Y.n12 10.1513
R245 Y Y.n14 5.33045
R246 Y.n14 Y.n10 0.553142
R247 Y.n10 Y.n6 0.553142
R248 VGND.n49 VGND.n16 2667.1
R249 VGND.n49 VGND.n48 2590.33
R250 VGND.n50 VGND.n49 1553.43
R251 VGND.n74 VGND.n73 1515.12
R252 VGND.n87 VGND.n75 1315.26
R253 VGND.n79 VGND.n6 1315.26
R254 VGND.n98 VGND.n76 1315.26
R255 VGND.n100 VGND.n7 1315.26
R256 VGND.n71 VGND.n11 1315.26
R257 VGND.n65 VGND.n64 1315.26
R258 VGND.n61 VGND.n51 1315.26
R259 VGND.n63 VGND.n14 1315.26
R260 VGND.n34 VGND.n24 1315.26
R261 VGND.n39 VGND.n26 1315.26
R262 VGND.n27 VGND.n18 1315.26
R263 VGND.n46 VGND.n20 1315.26
R264 VGND.n64 VGND.n13 585
R265 VGND.n64 VGND.n9 585
R266 VGND.n63 VGND.n15 585
R267 VGND.n63 VGND.n62 585
R268 VGND.n52 VGND.n14 585
R269 VGND.n56 VGND.n53 585
R270 VGND.n58 VGND.n57 585
R271 VGND.n59 VGND.n51 585
R272 VGND.n61 VGND.n60 585
R273 VGND.n62 VGND.n61 585
R274 VGND.n12 VGND.n11 585
R275 VGND.n11 VGND.n9 585
R276 VGND.n71 VGND.n70 585
R277 VGND.n69 VGND.n10 585
R278 VGND.n68 VGND.n67 585
R279 VGND.n66 VGND.n65 585
R280 VGND.n6 VGND.n4 585
R281 VGND.n84 VGND.n6 585
R282 VGND.n101 VGND.n100 585
R283 VGND.n100 VGND.n99 585
R284 VGND.n7 VGND.n5 585
R285 VGND.n93 VGND.n90 585
R286 VGND.n95 VGND.n94 585
R287 VGND.n96 VGND.n76 585
R288 VGND.n98 VGND.n97 585
R289 VGND.n99 VGND.n98 585
R290 VGND.n89 VGND.n75 585
R291 VGND.n84 VGND.n75 585
R292 VGND.n88 VGND.n87 585
R293 VGND.n78 VGND.n77 585
R294 VGND.n82 VGND.n81 585
R295 VGND.n80 VGND.n79 585
R296 VGND.n46 VGND.n45 585
R297 VGND.n47 VGND.n46 585
R298 VGND.n44 VGND.n21 585
R299 VGND.n21 VGND.n19 585
R300 VGND.n43 VGND.n42 585
R301 VGND.n42 VGND.n41 585
R302 VGND.n24 VGND.n23 585
R303 VGND.n40 VGND.n24 585
R304 VGND.n28 VGND.n27 585
R305 VGND.n22 VGND.n20 585
R306 VGND.n39 VGND.n38 585
R307 VGND.n40 VGND.n39 585
R308 VGND.n32 VGND.n25 585
R309 VGND.n41 VGND.n25 585
R310 VGND.n31 VGND.n30 585
R311 VGND.n30 VGND.n19 585
R312 VGND.n29 VGND.n18 585
R313 VGND.n47 VGND.n18 585
R314 VGND.n35 VGND.n34 585
R315 VGND.n37 VGND.n26 585
R316 VGND.n82 VGND.n78 394
R317 VGND.n98 VGND.n75 394
R318 VGND.n94 VGND.n93 394
R319 VGND.n100 VGND.n6 394
R320 VGND.n67 VGND.n10 394
R321 VGND.n61 VGND.n11 394
R322 VGND.n57 VGND.n56 394
R323 VGND.n64 VGND.n63 394
R324 VGND.n30 VGND.n18 394
R325 VGND.n30 VGND.n25 394
R326 VGND.n39 VGND.n25 394
R327 VGND.n46 VGND.n21 394
R328 VGND.n42 VGND.n21 394
R329 VGND.n42 VGND.n24 394
R330 VGND.t1 VGND.n0 255.345
R331 VGND.n1 VGND.t1 255.345
R332 VGND.n48 VGND.n47 220
R333 VGND.n40 VGND.n16 220
R334 VGND.n55 VGND.n50 218.815
R335 VGND.n54 VGND.n50 218.815
R336 VGND.n73 VGND.n72 218.815
R337 VGND.n73 VGND.n8 218.815
R338 VGND.n92 VGND.n74 218.815
R339 VGND.n91 VGND.n74 218.815
R340 VGND.n86 VGND.n85 218.815
R341 VGND.n85 VGND.n83 218.815
R342 VGND.n48 VGND.n17 218.815
R343 VGND.n33 VGND.n16 218.815
R344 VGND.n85 VGND.n84 173.316
R345 VGND.n99 VGND.n74 173.316
R346 VGND.n73 VGND.n9 173.316
R347 VGND.n62 VGND.n50 173.316
R348 VGND.n87 VGND.n86 147.374
R349 VGND.n83 VGND.n79 147.374
R350 VGND.n94 VGND.n91 147.374
R351 VGND.n92 VGND.n7 147.374
R352 VGND.n72 VGND.n71 147.374
R353 VGND.n65 VGND.n8 147.374
R354 VGND.n57 VGND.n54 147.374
R355 VGND.n55 VGND.n14 147.374
R356 VGND.n56 VGND.n55 147.374
R357 VGND.n54 VGND.n51 147.374
R358 VGND.n72 VGND.n10 147.374
R359 VGND.n67 VGND.n8 147.374
R360 VGND.n93 VGND.n92 147.374
R361 VGND.n91 VGND.n76 147.374
R362 VGND.n86 VGND.n78 147.374
R363 VGND.n83 VGND.n82 147.374
R364 VGND.n34 VGND.n33 147.374
R365 VGND.n27 VGND.n17 147.374
R366 VGND.n20 VGND.n17 147.374
R367 VGND.n33 VGND.n26 147.374
R368 VGND.n47 VGND.n19 124.668
R369 VGND.n41 VGND.n40 124.668
R370 VGND.n89 VGND.n88 85.4593
R371 VGND.n80 VGND.n4 85.4593
R372 VGND.n97 VGND.n96 85.4593
R373 VGND.n101 VGND.n5 85.4593
R374 VGND.n70 VGND.n12 85.4593
R375 VGND.n66 VGND.n13 85.4593
R376 VGND.n60 VGND.n59 85.4593
R377 VGND.n52 VGND.n15 85.4593
R378 VGND.n45 VGND.n22 85.4593
R379 VGND.n35 VGND.n23 85.4593
R380 VGND.n29 VGND.n28 85.4593
R381 VGND.n38 VGND.n37 85.4593
R382 VGND.t2 VGND.n19 62.3338
R383 VGND.n41 VGND.t2 62.3338
R384 VGND.n84 VGND.t0 47.5227
R385 VGND.n99 VGND.t0 47.5227
R386 VGND.t3 VGND.n9 47.5227
R387 VGND.n62 VGND.t3 47.5227
R388 VGND.n88 VGND.n77 25.6005
R389 VGND.n81 VGND.n77 25.6005
R390 VGND.n81 VGND.n80 25.6005
R391 VGND.n97 VGND.n89 25.6005
R392 VGND.n96 VGND.n95 25.6005
R393 VGND.n95 VGND.n90 25.6005
R394 VGND.n90 VGND.n5 25.6005
R395 VGND.n70 VGND.n69 25.6005
R396 VGND.n69 VGND.n68 25.6005
R397 VGND.n68 VGND.n66 25.6005
R398 VGND.n60 VGND.n12 25.6005
R399 VGND.n59 VGND.n58 25.6005
R400 VGND.n58 VGND.n53 25.6005
R401 VGND.n53 VGND.n52 25.6005
R402 VGND.n45 VGND.n44 25.6005
R403 VGND.n44 VGND.n43 25.6005
R404 VGND.n43 VGND.n23 25.6005
R405 VGND.n28 VGND.n22 25.6005
R406 VGND.n31 VGND.n29 25.6005
R407 VGND.n32 VGND.n31 25.6005
R408 VGND.n38 VGND.n32 25.6005
R409 VGND VGND.n36 19.4651
R410 VGND.n102 VGND 18.3598
R411 VGND.n36 VGND 18.3598
R412 VGND VGND.n4 12.8005
R413 VGND VGND.n101 12.8005
R414 VGND VGND.n13 12.8005
R415 VGND VGND.n15 12.8005
R416 VGND VGND.n35 12.8005
R417 VGND.n37 VGND 12.8005
R418 VGND VGND.n0 12.8005
R419 VGND.n1 VGND 12.8005
R420 VGND.n2 VGND.n0 10.1513
R421 VGND.n2 VGND.n1 10.1513
R422 VGND.n3 VGND.n2 10.0354
R423 VGND VGND.n102 5.15812
R424 VGND.n36 VGND.n3 0.454833
R425 VGND.n102 VGND.n3 0.0945
R426 A.t0 A.n0 700.484
R427 A.n1 A.t0 700.484
R428 A.t1 A.n3 255.345
R429 A.n4 A.t1 255.345
R430 A A.n0 12.8005
R431 A.n1 A 12.8005
R432 A A.n3 12.8005
R433 A.n4 A 12.8005
R434 A.n6 A.n2 10.5881
R435 A.n2 A.n0 10.1513
R436 A.n2 A.n1 10.1513
R437 A.n5 A.n3 10.1513
R438 A.n5 A.n4 10.1513
R439 A.n6 A.n5 10.0354
R440 A A.n6 6.36445
C15 B VGND 3.29926f
C16 A VGND 3.02041f
C17 Y VGND 3.29159f
C18 S VGND 4.11819f
C19 VPWR VGND 10.0234f
C20 SB VGND 6.21061f $ **FLOATING
C21 A.n0 VGND 0.00697f $ **FLOATING
C22 A.t0 VGND 0.02134f $ **FLOATING
C23 A.n1 VGND 0.00697f $ **FLOATING
C24 A.n2 VGND 0.15225f $ **FLOATING
C25 A.n3 VGND 0.00796f $ **FLOATING
C26 A.t1 VGND 0.01935f $ **FLOATING
C27 A.n4 VGND 0.00796f $ **FLOATING
C28 A.n5 VGND 0.13043f $ **FLOATING
C29 A.n6 VGND 2.49289f $ **FLOATING
C30 Y.n0 VGND 0.01031f $ **FLOATING
C31 Y.t2 VGND 0.03159f $ **FLOATING
C32 Y.n1 VGND 0.01031f $ **FLOATING
C33 Y.n2 VGND 0.29874f $ **FLOATING
C34 Y.n3 VGND 0.01178f $ **FLOATING
C35 Y.t1 VGND 0.02865f $ **FLOATING
C36 Y.n4 VGND 0.01178f $ **FLOATING
C37 Y.n5 VGND 0.26425f $ **FLOATING
C38 Y.n6 VGND 1.76082f $ **FLOATING
C39 Y.n7 VGND 0.01031f $ **FLOATING
C40 Y.t0 VGND 0.03159f $ **FLOATING
C41 Y.n8 VGND 0.01031f $ **FLOATING
C42 Y.n9 VGND 0.26425f $ **FLOATING
C43 Y.n10 VGND 1.08241f $ **FLOATING
C44 Y.n11 VGND 0.01178f $ **FLOATING
C45 Y.t3 VGND 0.02865f $ **FLOATING
C46 Y.n12 VGND 0.01178f $ **FLOATING
C47 Y.n13 VGND 0.26425f $ **FLOATING
C48 Y.n14 VGND 2.61141f $ **FLOATING
C49 B.n0 VGND 0.0127f $ **FLOATING
C50 B.t1 VGND 0.03889f $ **FLOATING
C51 B.n1 VGND 0.0127f $ **FLOATING
C52 B.n2 VGND 0.41352f $ **FLOATING
C53 B.n3 VGND 0.01451f $ **FLOATING
C54 B.t0 VGND 0.03527f $ **FLOATING
C55 B.n4 VGND 0.01451f $ **FLOATING
C56 B.n5 VGND 0.36989f $ **FLOATING
C57 B.n6 VGND 6.19126f $ **FLOATING
C58 SB.n0 VGND 0.00668f $ **FLOATING
C59 SB.n1 VGND 0.00584f $ **FLOATING
C60 SB.t1 VGND 0.0179f $ **FLOATING
C61 SB.n2 VGND 0.00584f $ **FLOATING
C62 SB.n3 VGND 0.23321f $ **FLOATING
C63 SB.t3 VGND 0.02509f $ **FLOATING
C64 SB.t2 VGND 0.02414f $ **FLOATING
C65 SB.n4 VGND 2.30803f $ **FLOATING
C66 SB.n5 VGND 1.6568f $ **FLOATING
C67 SB.n6 VGND 0.19093f $ **FLOATING
C68 SB.t0 VGND 0.01623f $ **FLOATING
C69 SB.n7 VGND 0.00668f $ **FLOATING
C70 S.t1 VGND 0.04274f $ **FLOATING
C71 S.t3 VGND 0.04441f $ **FLOATING
C72 S.n0 VGND 2.3559f $ **FLOATING
C73 S.t2 VGND 0.04274f $ **FLOATING
C74 S.n1 VGND 1.57207f $ **FLOATING
C75 S.t0 VGND 0.04441f $ **FLOATING
C76 S.n2 VGND 1.96319f $ **FLOATING
.ends

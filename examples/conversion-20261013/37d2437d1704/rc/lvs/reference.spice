.subckt rc_lowpass IN OUT VGND
XC1_P0 OUT VGND sky130_fd_pr__cap_mim_m3_1 w=22.17 l=22.17
XR1_P0 IN OUT VGND sky130_fd_pr__res_xhigh_po_1p41 l=6.885
.ends rc_lowpass

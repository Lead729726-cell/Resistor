* NGSPICE file created from rc_lowpass.ext - technology: sky130A

.subckt rc_lowpass VGND OUT IN
X0 OUT VGND sky130_fd_pr__cap_mim_m3_1 l=22.17 w=22.17
X1 IN OUT VGND sky130_fd_pr__res_xhigh_po_1p41 l=6.89
.ends

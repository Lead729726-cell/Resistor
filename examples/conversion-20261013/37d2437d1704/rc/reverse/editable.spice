.subckt rc_lowpass VGND OUT IN
XE_4 OUT VGND sky130_fd_pr__cap_mim_m3_1 w=22.17 l=22.17
XE_5 IN OUT VGND sky130_fd_pr__res_xhigh_po_1p41 l=6.89
.ends rc_lowpass

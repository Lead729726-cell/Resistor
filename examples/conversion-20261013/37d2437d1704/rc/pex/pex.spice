* NGSPICE file created from rc_lowpass.ext - technology: sky130A

.subckt rc_lowpass IN OUT VGND
X0 OUT VGND.t0 sky130_fd_pr__cap_mim_m3_1 l=22.17 w=22.17
X1 IN OUT VGND.t1 sky130_fd_pr__res_xhigh_po_1p41 l=6.89
C0 OUT IN 0.71444f
R0 VGND.n85 VGND.n73 1141.44
R1 VGND.n78 VGND.n71 1141.44
R2 VGND.n191 VGND.n190 1141.44
R3 VGND.n188 VGND.n10 1141.44
R4 VGND.n188 VGND.n187 585
R5 VGND.n189 VGND.n188 585
R6 VGND.n185 VGND.n7 585
R7 VGND.n7 VGND.n6 585
R8 VGND.n184 VGND.n183 585
R9 VGND.n183 VGND.n182 585
R10 VGND.n12 VGND.n11 585
R11 VGND.n13 VGND.n12 585
R12 VGND.n174 VGND.n173 585
R13 VGND.n175 VGND.n174 585
R14 VGND.n172 VGND.n18 585
R15 VGND.n18 VGND.n17 585
R16 VGND.n171 VGND.n170 585
R17 VGND.n170 VGND.n169 585
R18 VGND.n20 VGND.n19 585
R19 VGND.n21 VGND.n20 585
R20 VGND.n162 VGND.n161 585
R21 VGND.n163 VGND.n162 585
R22 VGND.n160 VGND.n26 585
R23 VGND.n26 VGND.n25 585
R24 VGND.n159 VGND.n158 585
R25 VGND.n158 VGND.n157 585
R26 VGND.n28 VGND.n27 585
R27 VGND.n29 VGND.n28 585
R28 VGND.n150 VGND.n149 585
R29 VGND.n151 VGND.n150 585
R30 VGND.n148 VGND.n34 585
R31 VGND.n34 VGND.n33 585
R32 VGND.n147 VGND.n146 585
R33 VGND.n146 VGND.n145 585
R34 VGND.n36 VGND.n35 585
R35 VGND.n37 VGND.n36 585
R36 VGND.n138 VGND.n137 585
R37 VGND.n139 VGND.n138 585
R38 VGND.n136 VGND.n41 585
R39 VGND.n132 VGND.n41 585
R40 VGND.n135 VGND.n134 585
R41 VGND.n134 VGND.n133 585
R42 VGND.n43 VGND.n42 585
R43 VGND.n44 VGND.n43 585
R44 VGND.n125 VGND.n124 585
R45 VGND.n126 VGND.n125 585
R46 VGND.n123 VGND.n49 585
R47 VGND.n49 VGND.n48 585
R48 VGND.n122 VGND.n121 585
R49 VGND.n121 VGND.n120 585
R50 VGND.n51 VGND.n50 585
R51 VGND.n52 VGND.n51 585
R52 VGND.n113 VGND.n112 585
R53 VGND.n114 VGND.n113 585
R54 VGND.n111 VGND.n57 585
R55 VGND.n57 VGND.n56 585
R56 VGND.n110 VGND.n109 585
R57 VGND.n109 VGND.n108 585
R58 VGND.n59 VGND.n58 585
R59 VGND.n60 VGND.n59 585
R60 VGND.n101 VGND.n100 585
R61 VGND.n102 VGND.n101 585
R62 VGND.n99 VGND.n65 585
R63 VGND.n65 VGND.n64 585
R64 VGND.n98 VGND.n97 585
R65 VGND.n97 VGND.n96 585
R66 VGND.n67 VGND.n66 585
R67 VGND.n68 VGND.n67 585
R68 VGND.n89 VGND.n88 585
R69 VGND.n90 VGND.n89 585
R70 VGND.n87 VGND.n73 585
R71 VGND.n73 VGND.n72 585
R72 VGND.n86 VGND.n85 585
R73 VGND.n75 VGND.n74 585
R74 VGND.n82 VGND.n81 585
R75 VGND.n83 VGND.n82 585
R76 VGND.n80 VGND.n77 585
R77 VGND.n79 VGND.n78 585
R78 VGND.n71 VGND.n70 585
R79 VGND.n72 VGND.n71 585
R80 VGND.n92 VGND.n91 585
R81 VGND.n91 VGND.n90 585
R82 VGND.n93 VGND.n69 585
R83 VGND.n69 VGND.n68 585
R84 VGND.n95 VGND.n94 585
R85 VGND.n96 VGND.n95 585
R86 VGND.n63 VGND.n62 585
R87 VGND.n64 VGND.n63 585
R88 VGND.n104 VGND.n103 585
R89 VGND.n103 VGND.n102 585
R90 VGND.n105 VGND.n61 585
R91 VGND.n61 VGND.n60 585
R92 VGND.n107 VGND.n106 585
R93 VGND.n108 VGND.n107 585
R94 VGND.n55 VGND.n54 585
R95 VGND.n56 VGND.n55 585
R96 VGND.n116 VGND.n115 585
R97 VGND.n115 VGND.n114 585
R98 VGND.n117 VGND.n53 585
R99 VGND.n53 VGND.n52 585
R100 VGND.n119 VGND.n118 585
R101 VGND.n120 VGND.n119 585
R102 VGND.n47 VGND.n46 585
R103 VGND.n48 VGND.n47 585
R104 VGND.n128 VGND.n127 585
R105 VGND.n127 VGND.n126 585
R106 VGND.n129 VGND.n45 585
R107 VGND.n45 VGND.n44 585
R108 VGND.n131 VGND.n130 585
R109 VGND.n133 VGND.n131 585
R110 VGND.n40 VGND.n39 585
R111 VGND.n132 VGND.n40 585
R112 VGND.n141 VGND.n140 585
R113 VGND.n140 VGND.n139 585
R114 VGND.n142 VGND.n38 585
R115 VGND.n38 VGND.n37 585
R116 VGND.n144 VGND.n143 585
R117 VGND.n145 VGND.n144 585
R118 VGND.n32 VGND.n31 585
R119 VGND.n33 VGND.n32 585
R120 VGND.n153 VGND.n152 585
R121 VGND.n152 VGND.n151 585
R122 VGND.n154 VGND.n30 585
R123 VGND.n30 VGND.n29 585
R124 VGND.n156 VGND.n155 585
R125 VGND.n157 VGND.n156 585
R126 VGND.n24 VGND.n23 585
R127 VGND.n25 VGND.n24 585
R128 VGND.n165 VGND.n164 585
R129 VGND.n164 VGND.n163 585
R130 VGND.n166 VGND.n22 585
R131 VGND.n22 VGND.n21 585
R132 VGND.n168 VGND.n167 585
R133 VGND.n169 VGND.n168 585
R134 VGND.n16 VGND.n15 585
R135 VGND.n17 VGND.n16 585
R136 VGND.n177 VGND.n176 585
R137 VGND.n176 VGND.n175 585
R138 VGND.n178 VGND.n14 585
R139 VGND.n14 VGND.n13 585
R140 VGND.n181 VGND.n180 585
R141 VGND.n182 VGND.n181 585
R142 VGND.n179 VGND.n4 585
R143 VGND.n6 VGND.n4 585
R144 VGND.n190 VGND.n5 585
R145 VGND.n190 VGND.n189 585
R146 VGND.n191 VGND.n2 585
R147 VGND.n194 VGND.n193 585
R148 VGND VGND.n1 585
R149 VGND.n9 VGND.n0 585
R150 VGND.n186 VGND.n10 585
R151 VGND.n10 VGND.n3 585
R152 VGND.n82 VGND.n75 394
R153 VGND.n82 VGND.n77 394
R154 VGND.n91 VGND.n71 394
R155 VGND.n91 VGND.n69 394
R156 VGND.n95 VGND.n69 394
R157 VGND.n95 VGND.n63 394
R158 VGND.n103 VGND.n63 394
R159 VGND.n103 VGND.n61 394
R160 VGND.n107 VGND.n61 394
R161 VGND.n107 VGND.n55 394
R162 VGND.n115 VGND.n55 394
R163 VGND.n115 VGND.n53 394
R164 VGND.n119 VGND.n53 394
R165 VGND.n119 VGND.n47 394
R166 VGND.n127 VGND.n47 394
R167 VGND.n127 VGND.n45 394
R168 VGND.n131 VGND.n45 394
R169 VGND.n131 VGND.n40 394
R170 VGND.n140 VGND.n40 394
R171 VGND.n140 VGND.n38 394
R172 VGND.n144 VGND.n38 394
R173 VGND.n144 VGND.n32 394
R174 VGND.n152 VGND.n32 394
R175 VGND.n152 VGND.n30 394
R176 VGND.n156 VGND.n30 394
R177 VGND.n156 VGND.n24 394
R178 VGND.n164 VGND.n24 394
R179 VGND.n164 VGND.n22 394
R180 VGND.n168 VGND.n22 394
R181 VGND.n168 VGND.n16 394
R182 VGND.n176 VGND.n16 394
R183 VGND.n176 VGND.n14 394
R184 VGND.n181 VGND.n14 394
R185 VGND.n181 VGND.n4 394
R186 VGND.n190 VGND.n4 394
R187 VGND.n10 VGND.n9 394
R188 VGND.n193 VGND.n1 394
R189 VGND.n89 VGND.n73 394
R190 VGND.n89 VGND.n67 394
R191 VGND.n97 VGND.n67 394
R192 VGND.n97 VGND.n65 394
R193 VGND.n101 VGND.n65 394
R194 VGND.n101 VGND.n59 394
R195 VGND.n109 VGND.n59 394
R196 VGND.n109 VGND.n57 394
R197 VGND.n113 VGND.n57 394
R198 VGND.n113 VGND.n51 394
R199 VGND.n121 VGND.n51 394
R200 VGND.n121 VGND.n49 394
R201 VGND.n125 VGND.n49 394
R202 VGND.n125 VGND.n43 394
R203 VGND.n134 VGND.n43 394
R204 VGND.n134 VGND.n41 394
R205 VGND.n138 VGND.n41 394
R206 VGND.n138 VGND.n36 394
R207 VGND.n146 VGND.n36 394
R208 VGND.n146 VGND.n34 394
R209 VGND.n150 VGND.n34 394
R210 VGND.n150 VGND.n28 394
R211 VGND.n158 VGND.n28 394
R212 VGND.n158 VGND.n26 394
R213 VGND.n162 VGND.n26 394
R214 VGND.n162 VGND.n20 394
R215 VGND.n170 VGND.n20 394
R216 VGND.n170 VGND.n18 394
R217 VGND.n174 VGND.n18 394
R218 VGND.n174 VGND.n12 394
R219 VGND.n183 VGND.n12 394
R220 VGND.n183 VGND.n7 394
R221 VGND.n188 VGND.n7 394
R222 VGND.n84 VGND.n83 218.815
R223 VGND.n83 VGND.n76 218.815
R224 VGND.n192 VGND.n3 218.815
R225 VGND.n8 VGND.n3 218.815
R226 VGND.n85 VGND.n84 147.374
R227 VGND.n77 VGND.n76 147.374
R228 VGND.n8 VGND.n1 147.374
R229 VGND.n192 VGND.n191 147.374
R230 VGND.n84 VGND.n75 147.374
R231 VGND.n78 VGND.n76 147.374
R232 VGND.n193 VGND.n192 147.374
R233 VGND.n9 VGND.n8 147.374
R234 VGND.n87 VGND.n86 74.1652
R235 VGND.n187 VGND.n186 74.1652
R236 VGND.n79 VGND.n70 74.1652
R237 VGND.n5 VGND.n2 74.1652
R238 VGND.n83 VGND.n72 49.8942
R239 VGND.n189 VGND.n3 49.8942
R240 VGND.n90 VGND.n72 35.3419
R241 VGND.n90 VGND.n68 35.3419
R242 VGND.n96 VGND.n68 35.3419
R243 VGND.n96 VGND.n64 35.3419
R244 VGND.n102 VGND.n64 35.3419
R245 VGND.n102 VGND.n60 35.3419
R246 VGND.n108 VGND.n60 35.3419
R247 VGND.n108 VGND.n56 35.3419
R248 VGND.n114 VGND.n56 35.3419
R249 VGND.n114 VGND.n52 35.3419
R250 VGND.n120 VGND.n52 35.3419
R251 VGND.n120 VGND.n48 35.3419
R252 VGND.n126 VGND.n48 35.3419
R253 VGND.n126 VGND.n44 35.3419
R254 VGND.n133 VGND.n44 35.3419
R255 VGND.n133 VGND.n132 35.3419
R256 VGND.n139 VGND.n37 35.3419
R257 VGND.n145 VGND.n37 35.3419
R258 VGND.n145 VGND.n33 35.3419
R259 VGND.n151 VGND.n33 35.3419
R260 VGND.n151 VGND.n29 35.3419
R261 VGND.n157 VGND.n29 35.3419
R262 VGND.n157 VGND.n25 35.3419
R263 VGND.n163 VGND.n25 35.3419
R264 VGND.n163 VGND.n21 35.3419
R265 VGND.n169 VGND.n21 35.3419
R266 VGND.n169 VGND.n17 35.3419
R267 VGND.n175 VGND.n17 35.3419
R268 VGND.n175 VGND.n13 35.3419
R269 VGND.n182 VGND.n13 35.3419
R270 VGND.n182 VGND.n6 35.3419
R271 VGND.n189 VGND.n6 35.3419
R272 VGND.n88 VGND.n87 25.6005
R273 VGND.n88 VGND.n66 25.6005
R274 VGND.n98 VGND.n66 25.6005
R275 VGND.n99 VGND.n98 25.6005
R276 VGND.n100 VGND.n99 25.6005
R277 VGND.n100 VGND.n58 25.6005
R278 VGND.n110 VGND.n58 25.6005
R279 VGND.n111 VGND.n110 25.6005
R280 VGND.n112 VGND.n111 25.6005
R281 VGND.n112 VGND.n50 25.6005
R282 VGND.n122 VGND.n50 25.6005
R283 VGND.n123 VGND.n122 25.6005
R284 VGND.n124 VGND.n123 25.6005
R285 VGND.n124 VGND.n42 25.6005
R286 VGND.n135 VGND.n42 25.6005
R287 VGND.n136 VGND.n135 25.6005
R288 VGND.n137 VGND.n136 25.6005
R289 VGND.n137 VGND.n35 25.6005
R290 VGND.n147 VGND.n35 25.6005
R291 VGND.n148 VGND.n147 25.6005
R292 VGND.n149 VGND.n148 25.6005
R293 VGND.n149 VGND.n27 25.6005
R294 VGND.n159 VGND.n27 25.6005
R295 VGND.n160 VGND.n159 25.6005
R296 VGND.n161 VGND.n160 25.6005
R297 VGND.n161 VGND.n19 25.6005
R298 VGND.n171 VGND.n19 25.6005
R299 VGND.n172 VGND.n171 25.6005
R300 VGND.n173 VGND.n172 25.6005
R301 VGND.n173 VGND.n11 25.6005
R302 VGND.n184 VGND.n11 25.6005
R303 VGND.n185 VGND.n184 25.6005
R304 VGND.n187 VGND.n185 25.6005
R305 VGND.n86 VGND.n74 25.6005
R306 VGND.n81 VGND.n74 25.6005
R307 VGND.n81 VGND.n80 25.6005
R308 VGND.n80 VGND.n79 25.6005
R309 VGND.n92 VGND.n70 25.6005
R310 VGND.n93 VGND.n92 25.6005
R311 VGND.n94 VGND.n93 25.6005
R312 VGND.n94 VGND.n62 25.6005
R313 VGND.n104 VGND.n62 25.6005
R314 VGND.n105 VGND.n104 25.6005
R315 VGND.n106 VGND.n105 25.6005
R316 VGND.n106 VGND.n54 25.6005
R317 VGND.n116 VGND.n54 25.6005
R318 VGND.n117 VGND.n116 25.6005
R319 VGND.n118 VGND.n117 25.6005
R320 VGND.n118 VGND.n46 25.6005
R321 VGND.n128 VGND.n46 25.6005
R322 VGND.n129 VGND.n128 25.6005
R323 VGND.n130 VGND.n129 25.6005
R324 VGND.n130 VGND.n39 25.6005
R325 VGND.n141 VGND.n39 25.6005
R326 VGND.n142 VGND.n141 25.6005
R327 VGND.n143 VGND.n142 25.6005
R328 VGND.n143 VGND.n31 25.6005
R329 VGND.n153 VGND.n31 25.6005
R330 VGND.n154 VGND.n153 25.6005
R331 VGND.n155 VGND.n154 25.6005
R332 VGND.n155 VGND.n23 25.6005
R333 VGND.n165 VGND.n23 25.6005
R334 VGND.n166 VGND.n165 25.6005
R335 VGND.n167 VGND.n166 25.6005
R336 VGND.n167 VGND.n15 25.6005
R337 VGND.n177 VGND.n15 25.6005
R338 VGND.n178 VGND.n177 25.6005
R339 VGND.n180 VGND.n178 25.6005
R340 VGND.n180 VGND.n179 25.6005
R341 VGND.n179 VGND.n5 25.6005
R342 VGND.n186 VGND.n0 25.6005
R343 VGND VGND.n0 25.6005
R344 VGND VGND.n194 25.6005
R345 VGND.n194 VGND.n2 25.6005
R346 VGND.n195 VGND 25.1185
R347 VGND.n132 VGND.t1 17.6712
R348 VGND.n139 VGND.t1 17.6712
R349 VGND.n195 VGND.t0 6.70738
R350 VGND VGND.n195 4.35677
C1 OUT VGND 53.0949f
C2 IN VGND 2.90019f
.ends

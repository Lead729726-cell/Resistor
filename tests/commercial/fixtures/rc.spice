Synthetic parser fixture RC deck
R1 IN OUT 100
C1 IN 0 1f
C2 OUT 0 1f
.end

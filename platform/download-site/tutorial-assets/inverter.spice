.subckt inverter A VGND VPWR Y
XMN1 Y A VGND VGND sky130_fd_pr__nfet_01v8 w=0.65 l=0.15 nf=1 m=1
XMP1 Y A VPWR VPWR sky130_fd_pr__pfet_01v8_hvt w=1 l=0.15 nf=1 m=1
.ends inverter

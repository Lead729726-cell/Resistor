; Register direct native DB query, IC6/IC23 candidate. Site validation required.
; This script reads only an immutable copied library. It never dbSave/dbCreate.
; Globals are fixed data bindings generated by the existing operator runner.
procedure(RDBstr(f v)
 let((ch code)
  unless(stringp(v) v="") fprintf(f "\"")
  for(i 1 strlen(v)
   ch=substring(v i 1) code=charToInt(ch)
   cond((ch=="\"" fprintf(f "\\\"")) (ch=="\\" fprintf(f "\\\\"))
        (code<32 fprintf(f "\\u%04x" code)) (t fprintf(f "%s" ch))))
  fprintf(f "\"")))
procedure(RDBnum(f v) fprintf(f "%d" round(v*RDBdbu)))
procedure(RDBpoint(f p) fprintf(f "[") fprintf(f "\"%d\",\"%d\"" round(xCoord(p)*RDBdbu) round(yCoord(p)*RDBdbu)) fprintf(f "]"))
procedure(RDBpoints(f ps) let((first) first=t fprintf(f "[") foreach(p ps unless(first fprintf(f ",")) RDBpoint(f p) first=nil) fprintf(f "]")))
procedure(RDBdiag(v) RDBdiagnostics=cons(v RDBdiagnostics))
procedure(RDBorient(v)
  case(v
    ("R0" list(0 nil)) ("R90" list(90 nil)) ("R180" list(180 nil)) ("R270" list(270 nil))
    ("MX" list(0 t)) ("MY" list(180 t)) ("MXR90" list(90 t)) ("MYR90" list(270 t))
    (t RDBdiag(strcat("Unsupported orientation: " v)) list(0 nil))))
procedure(RDBshape(f s pinName)
 let((ty pts orient)
  ty=s~>objType
  unless(member(ty '("rect" "polygon" "path" "label")) RDBdiag(strcat("Unsupported native object: " ty)))
  fprintf(f "{\"id\":") RDBstr(f sprintf(nil "%L" s))
  fprintf(f ",\"kind\":") RDBstr(f case(ty ("rect" "box") (t ty)))
  fprintf(f ",\"layer\":{\"name\":") RDBstr(f s~>layerName) fprintf(f ",\"purpose\":") RDBstr(f s~>purpose) fprintf(f "}")
  when(s~>net fprintf(f ",\"net\":") RDBstr(f s~>net~>name))
  when(pinName fprintf(f ",\"pin\":") RDBstr(f pinName))
  case(ty
   ("rect" fprintf(f ",\"box\":[\"%d\",\"%d\",\"%d\",\"%d\"]" round(xCoord(car(s~>bBox))*RDBdbu) round(yCoord(car(s~>bBox))*RDBdbu) round(xCoord(cadr(s~>bBox))*RDBdbu) round(yCoord(cadr(s~>bBox))*RDBdbu))
   ("polygon" fprintf(f ",\"points\":") RDBpoints(f s~>points))
   ("path" unless(s~>pathStyle=="truncate" RDBdiag("Non-truncated path ends are unsupported; no bbox approximation emitted.")) fprintf(f ",\"points\":") RDBpoints(f s~>points) fprintf(f ",\"width\":\"%d\"" round(s~>width*RDBdbu)))
   ("label" orient=RDBorient(s~>orient) fprintf(f ",\"text\":") RDBstr(f s~>theLabel) fprintf(f ",\"position\":") RDBpoint(f s~>xy) fprintf(f ",\"rotation\":%d,\"mirror\":%s" car(orient) if(cadr(orient) "true" "false"))))
  fprintf(f "}")))
procedure(RDBcell(f cv)
 let((first pinName pinTable orient)
  unless(cv~>userUnits=="micron" && cv~>DBUPerUU==RDBdbu RDBdiag("Mixed/unknown native user units or DBU unsupported."))
  when(cv~>mosaics RDBdiag("Native mosaics require explicit array adapter; no geometry approximation emitted."))
  pinTable=makeTable('RDBpins nil)
  foreach(term cv~>terminals foreach(pin term~>pins foreach(fig pin~>figs pinTable[fig]=term~>name)))
  fprintf(f "{\"name\":") RDBstr(f cv~>cellName) fprintf(f ",\"source_library\":") RDBstr(f cv~>libName) fprintf(f ",\"source_view\":") RDBstr(f cv~>viewName)
  fprintf(f ",\"shapes\":[") first=t
  foreach(s cv~>shapes RDBcount=RDBcount+1 when(RDBcount>100000 error("REGISTER_NATIVE_DB_LIMIT")) unless(first fprintf(f ",")) RDBshape(f s pinTable[s]) first=nil)
  fprintf(f "],\"instances\":[") first=t
  foreach(inst cv~>instances
   RDBcount=RDBcount+1 when(RDBcount>100000 error("REGISTER_NATIVE_DB_LIMIT"))
   unless(first fprintf(f ",")) orient=RDBorient(inst~>orient)
   unless(inst~>master~>libName==REGISTER_parameter_library RDBdiag("External library master is outside the immutable single-library resource closure."))
   when(caddr(inst~>transform)!=1.0 RDBdiag("Native instance magnification is unsupported."))
   fprintf(f "{\"id\":") RDBstr(f sprintf(nil "%L" inst)) fprintf(f ",\"name\":") RDBstr(f inst~>name) fprintf(f ",\"cell\":") RDBstr(f inst~>master~>cellName)
   fprintf(f ",\"position\":") RDBpoint(f inst~>xy) fprintf(f ",\"rotation\":%d,\"mirror\":%s}" car(orient) if(cadr(orient) "true" "false")) first=nil)
  fprintf(f "],\"pins\":[],\"nets\":[") first=t foreach(n cv~>nets unless(first fprintf(f ",")) RDBstr(f n~>name) first=nil) fprintf(f "]}")))
procedure(RDBmain()
let((cds f lib cv queue visited first mode)
 RDBdiagnostics=nil RDBcount=0 mode=REGISTER_parameter_mode
 cds=outfile("cds.lib" "w") fprintf(cds "DEFINE %s %s\n" REGISTER_parameter_library REGISTER_resource_native_db) close(cds)
 ddSetForcedLib("cds.lib") ddUpdateLibList()
 lib=ddGetObj(REGISTER_parameter_library) unless(lib error("REGISTER_LIBRARY_NOT_FOUND"))
 f=outfile("native-database.json" "w") unless(f error("REGISTER_OUTPUT_FAILED"))
 if(mode=="read" then
  cv=dbOpenCellViewByType(REGISTER_parameter_library REGISTER_top_cell REGISTER_parameter_view "maskLayout" "r") unless(cv error("REGISTER_CELLVIEW_NOT_FOUND"))
  unless(cv~>userUnits=="micron" && numberp(cv~>DBUPerUU) && cv~>DBUPerUU>0 error("REGISTER_UNKNOWN_NATIVE_UNITS"))
  RDBdbu=cv~>DBUPerUU
  fprintf(f "{\"schema_version\":1,\"dbu_um\":%.12g,\"top_cell\":" 1.0/RDBdbu) RDBstr(f REGISTER_top_cell)
  fprintf(f ",\"reader\":{\"adapter\":\"cadence-skill\",\"tool\":\"virtuoso\",\"api\":\"dbOpenCellViewByType-r\",\"version\":") RDBstr(f getVersion(t)) fprintf(f "},\"cells\":[")
  queue=list(cv) visited=nil first=t
  while(queue cv=car(queue) queue=cdr(queue)
   unless(member(cv visited)
    visited=cons(cv visited) unless(first fprintf(f ",")) RDBcell(f cv) first=nil
    foreach(master cv~>instanceMasters when(master~>libName==REGISTER_parameter_library queue=cons(master queue)))))
  fprintf(f "],\"complete\":%s,\"diagnostics\":[" if(RDBdiagnostics "false" "true")) first=t foreach(v reverse(RDBdiagnostics) unless(first fprintf(f ",")) RDBstr(f v) first=nil) fprintf(f "]}")
  foreach(opened visited dbClose(opened))
 else
  fprintf(f "{\"schema_version\":1,\"mode\":") RDBstr(f mode) fprintf(f ",\"version\":") RDBstr(f getVersion(t)) fprintf(f ",\"cells\":[") first=t
  foreach(cell lib~>cells foreach(view cell~>views
   RDBcount=RDBcount+1 when(RDBcount>100000 error("REGISTER_NATIVE_DB_LIMIT")) unless(first fprintf(f ","))
   fprintf(f "{\"library\":") RDBstr(f REGISTER_parameter_library) fprintf(f ",\"cell\":") RDBstr(f cell~>name) fprintf(f ",\"view\":") RDBstr(f view~>name) fprintf(f "}") first=nil))
  fprintf(f "],\"diagnostics\":[]}"))
 close(f)
))
; Cadence -replay can otherwise exit zero after SKILL errors. Explicitly bind
; the real query outcome to the process exit status; no saved DB operations.
if(errset(RDBmain() t) then exit(0) else exit(1))
